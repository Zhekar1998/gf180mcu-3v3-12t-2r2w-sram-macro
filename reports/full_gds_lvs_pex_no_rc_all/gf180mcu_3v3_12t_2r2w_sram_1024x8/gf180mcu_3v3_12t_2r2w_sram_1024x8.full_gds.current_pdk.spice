* NGSPICE file created from gf180mcu_3v3_12t_2r2w_sram_1024x8.ext - technology: gf180mcuD

.subckt detronyx_12t_write_driver_rc1 VDD VSS din wen wbl0 wbr0 a_240_2348#
X0 VDD a_240_2348# a_326_9670# VDD pfet_03v3 ad=0.1232p pd=1u as=0.1232p ps=1u w=0.56u l=0.28u
X1 VSS wen a_988_2348# VSS nfet_03v3 ad=0.4642p pd=2.99u as=0.4642p ps=2.99u w=1.055u l=0.28u
X2 VDD wen a_326_9670# VDD pfet_03v3 ad=0.1232p pd=1u as=0.1232p ps=1u w=0.56u l=0.28u
X3 VSS a_844_5266# a_328_6681# VSS nfet_03v3 ad=0.4642p pd=2.99u as=0.4642p ps=2.99u w=1.055u l=0.28u
X4 VSS wen a_240_3807# VSS nfet_03v3 ad=0.4642p pd=2.99u as=0.4642p ps=2.99u w=1.055u l=0.28u
X5 VDD wen a_326_11114# VDD pfet_03v3 ad=0.1232p pd=1u as=0.1232p ps=1u w=0.56u l=0.28u
X6 VDD wen a_844_2348# VDD pfet_03v3 ad=0.1232p pd=1u as=0.1232p ps=1u w=0.56u l=0.28u
X7 a_240_3807# a_240_2348# a_326_9670# VSS nfet_03v3 ad=0.4642p pd=2.99u as=0.4642p ps=2.99u w=1.055u l=0.28u
X8 VDD din a_844_5266# VDD pfet_03v3 ad=0.1232p pd=1u as=0.1232p ps=1u w=0.56u l=0.28u
X9 VDD wen a_844_5266# VDD pfet_03v3 ad=0.1232p pd=1u as=0.1232p ps=1u w=0.56u l=0.28u
X10 VDD a_240_2348# a_326_11114# VDD pfet_03v3 ad=0.1232p pd=1u as=0.1232p ps=1u w=0.56u l=0.28u
X11 VDD a_844_2348# wbl0 VDD pfet_03v3 ad=0.1232p pd=1u as=0.1232p ps=1u w=0.56u l=0.28u
X12 VDD a_844_5266# a_328_6681# VDD pfet_03v3 ad=0.1232p pd=1u as=0.1232p ps=1u w=0.56u l=0.28u
X13 VSS a_844_3807# wbl0 VSS nfet_03v3 ad=0.4642p pd=2.99u as=0.4642p ps=2.99u w=1.055u l=0.28u
X14 VDD din a_844_2348# VDD pfet_03v3 ad=0.1232p pd=1u as=0.1232p ps=1u w=0.56u l=0.28u
X15 a_988_5266# din a_844_5266# VSS nfet_03v3 ad=0.4642p pd=2.99u as=0.4642p ps=2.99u w=1.055u l=0.28u
X16 a_240_5266# a_240_2348# a_326_11114# VSS nfet_03v3 ad=0.4642p pd=2.99u as=0.4642p ps=2.99u w=1.055u l=0.28u
X17 VDD a_326_9670# a_844_3807# VDD pfet_03v3 ad=0.1232p pd=1u as=0.1232p ps=1u w=0.56u l=0.28u
X18 a_988_2348# din a_844_2348# VSS nfet_03v3 ad=0.4642p pd=2.99u as=0.4642p ps=2.99u w=1.055u l=0.28u
X19 VSS wen a_240_5266# VSS nfet_03v3 ad=0.4642p pd=2.99u as=0.4642p ps=2.99u w=1.055u l=0.28u
X20 VSS din a_240_2348# VSS nfet_03v3 ad=0.4642p pd=2.99u as=0.4642p ps=2.99u w=1.055u l=0.28u
X21 VSS a_326_9670# a_844_3807# VSS nfet_03v3 ad=0.4642p pd=2.99u as=0.4642p ps=2.99u w=1.055u l=0.28u
X22 VDD din a_240_2348# VDD pfet_03v3 ad=0.1232p pd=1u as=0.1232p ps=1u w=0.56u l=0.28u
X23 VSS wen a_988_5266# VSS nfet_03v3 ad=0.4642p pd=2.99u as=0.4642p ps=2.99u w=1.055u l=0.28u
X24 VDD a_326_11114# wbr0 VDD pfet_03v3 ad=0.1232p pd=1u as=0.1232p ps=1u w=0.56u l=0.28u
X25 VSS a_328_6681# wbr0 VSS nfet_03v3 ad=0.4642p pd=2.99u as=0.4642p ps=2.99u w=1.055u l=0.28u
.ends

.subckt detronyx_12t_precharge_sense_rc1 VDD VSS pchgb ren rbl0 dout a_672_2172# a_240_2172#
X0 VDD rbl0 a_240_2172# VDD pfet_03v3 ad=0.1232p pd=1u as=0.1232p ps=1u w=0.56u l=0.28u
X1 VSS a_240_2172# a_672_2172# VSS nfet_03v3 ad=0.4642p pd=2.99u as=0.4642p ps=2.99u w=1.055u l=0.28u
X2 VSS rbl0 a_240_2172# VSS nfet_03v3 ad=0.4642p pd=2.99u as=0.4642p ps=2.99u w=1.055u l=0.28u
X3 VDD pchgb rbl0 VDD pfet_03v3 ad=0.1232p pd=1u as=0.1232p ps=1u w=0.56u l=0.28u
X4 VDD a_672_2172# dout VDD pfet_03v3 ad=0.1232p pd=1u as=0.1232p ps=1u w=0.56u l=0.28u
X5 VSS a_672_2172# dout VSS nfet_03v3 ad=0.4642p pd=2.99u as=0.4642p ps=2.99u w=1.055u l=0.28u
X6 VDD a_240_2172# a_672_2172# VDD pfet_03v3 ad=0.1232p pd=1u as=0.1232p ps=1u w=0.56u l=0.28u
.ends

.subckt gf180mcu_as_sc_mcu7t3v3__inv_2 VDD VSS Y A VNW VPW
X0 VDD A Y VNW pfet_03v3 ad=0.6072p pd=3.64u as=0.3588p ps=1.9u w=1.38u l=0.28u
X1 Y A VSS VPW nfet_03v3 ad=0.26p pd=1.52u as=0.44p ps=2.88u w=1u l=0.28u
X2 Y A VDD VNW pfet_03v3 ad=0.3588p pd=1.9u as=0.6072p ps=3.64u w=1.38u l=0.28u
X3 VSS A Y VPW nfet_03v3 ad=0.44p pd=2.88u as=0.26p ps=1.52u w=1u l=0.28u
.ends

.subckt gf180mcu_as_sc_mcu7t3v3__nand4_2 VDD VSS A B C D Y VNW VPW
X0 VDD A Y VNW pfet_03v3 ad=0.3588p pd=1.9u as=0.3588p ps=1.9u w=1.38u l=0.28u
X1 Y D a_796_68# VPW nfet_03v3 ad=0.26p pd=1.52u as=0.26p ps=1.52u w=1u l=0.28u
X2 VSS A a_28_68# VPW nfet_03v3 ad=0.26p pd=1.52u as=0.44p ps=2.88u w=1u l=0.28u
X3 VDD C Y VNW pfet_03v3 ad=0.3588p pd=1.9u as=0.3588p ps=1.9u w=1.38u l=0.28u
X4 a_796_68# C a_492_68# VPW nfet_03v3 ad=0.26p pd=1.52u as=0.26p ps=1.52u w=1u l=0.28u
X5 Y B VDD VNW pfet_03v3 ad=0.3588p pd=1.9u as=0.3588p ps=1.9u w=1.38u l=0.28u
X6 a_28_68# B a_492_68# VPW nfet_03v3 ad=0.44p pd=2.88u as=0.26p ps=1.52u w=1u l=0.28u
X7 Y D VDD VNW pfet_03v3 ad=0.3588p pd=1.9u as=0.3588p ps=1.9u w=1.38u l=0.28u
X8 VDD B Y VNW pfet_03v3 ad=0.8004p pd=2.54u as=0.3588p ps=1.9u w=1.38u l=0.28u
X9 Y C VDD VNW pfet_03v3 ad=0.3588p pd=1.9u as=0.8004p ps=2.54u w=1.38u l=0.28u
X10 a_492_68# C a_796_68# VPW nfet_03v3 ad=0.26p pd=1.52u as=0.44p ps=2.88u w=1u l=0.28u
X11 a_492_68# B a_28_68# VPW nfet_03v3 ad=0.26p pd=1.52u as=0.26p ps=1.52u w=1u l=0.28u
X12 VDD D Y VNW pfet_03v3 ad=0.6348p pd=3.68u as=0.3588p ps=1.9u w=1.38u l=0.28u
X13 Y A VDD VNW pfet_03v3 ad=0.3588p pd=1.9u as=0.6072p ps=3.64u w=1.38u l=0.28u
X14 a_796_68# D Y VPW nfet_03v3 ad=0.46p pd=2.92u as=0.26p ps=1.52u w=1u l=0.28u
X15 a_28_68# A VSS VPW nfet_03v3 ad=0.26p pd=1.52u as=0.26p ps=1.52u w=1u l=0.28u
.ends

.subckt detronyx_12t_2w2r_rc4_4x4_routed_5layer_direct c0_w0_bl c0_w0_br c0_w1_bl
+ c0_w1_br c0_r0_rbl c0_r1_rbl c1_w0_bl c1_w0_br c1_w1_bl c1_w1_br c1_r0_rbl c1_r1_rbl
+ c2_w0_bl c2_w0_br c2_w1_bl c2_w1_br c2_r0_rbl c2_r1_rbl c3_w0_bl c3_w0_br c3_w1_bl
+ c3_w1_br c3_r0_rbl c3_r1_rbl r0_w0_wl r0_w1_wl r0_r0_rwl r0_r1_rwl r1_w0_wl r1_w1_wl
+ r1_r0_rwl r1_r1_rwl r2_w0_wl r2_w1_wl r2_r0_rwl r2_r1_rwl r3_w0_wl r3_w1_wl r3_r0_rwl
+ r3_r1_rwl VDD VSS m2_717_1265# m2_603_2031# m2_1290_336# m2_2000_2037# m2_791_2909#
+ m2_7_2126# m2_2154_2081# m2_1795_2037# m2_871_303# m2_431_438# m2_1290_2898# m2_1714_1210#
+ m2_431_1982# m2_512_1265# m2_2573_2126# m2_603_1259# m2_2074_2909# m2_7_336# m2_717_2037#
+ m2_1886_2031# m2_2573_336# m2_7_2898# m2_2000_1265# m2_512_2037# m2_1795_1265# m2_1714_1982#
+ m2_1886_1259# m2_1290_2126# m2_1714_438# m2_431_1210# m2_2573_2898# m2_2154_303#
+ m2_871_2081# VSUBS
X0 a_684_1814# a_484_1742# a_680_1660# VSUBS nfet_03v3 ad=0.1288p pd=1.48u as=0.1208p ps=1.42u w=0.28u l=0.36u
X1 a_1365_936# a_1283_888# a_1421_1243# w_1283_1162# pfet_03v3 ad=0.1238p pd=1.44u as=0.3061p ps=2.445u w=0.28u l=0.28u
X2 a_2215_1938# a_2159_1894# a_2071_1938# VSUBS nfet_03v3 ad=0.1378p pd=1.05u as=0.2332p ps=1.94u w=0.53u l=0.28u
X3 a_82_1708# a_484_2028# a_532_1946# VSUBS nfet_03v3 ad=0.1288p pd=1.48u as=0.1208p ps=1.42u w=0.28u l=0.36u
X4 a_2648_1708# a_2566_1660# a_2704_1752# VSUBS nfet_03v3 ad=0.3133p pd=2.64u as=0.342p ps=2.21u w=0.45u l=0.28u
X5 a_3658_932# a_3602_888# a_3498_932# VSUBS nfet_03v3 ad=0.23585p pd=1.95u as=0.1378p ps=1.05u w=0.53u l=0.28u
X6 a_932_1938# a_876_1894# a_788_1938# VSUBS nfet_03v3 ad=0.1378p pd=1.05u as=0.2332p ps=1.94u w=0.53u l=0.28u
X7 a_3250_2100# a_3050_2028# a_3246_1946# VSUBS nfet_03v3 ad=0.1288p pd=1.48u as=0.1208p ps=1.42u w=0.28u l=0.36u
X8 a_2375_160# a_2319_116# a_2215_160# VSUBS nfet_03v3 ad=0.23585p pd=1.95u as=0.1378p ps=1.05u w=0.53u l=0.28u
X9 a_1365_936# a_1283_888# a_1421_980# VSUBS nfet_03v3 ad=0.3133p pd=2.64u as=0.342p ps=2.21u w=0.45u l=0.28u
X10 a_4533_2100# a_4333_2028# a_4529_1946# VSUBS nfet_03v3 ad=0.1288p pd=1.48u as=0.1208p ps=1.42u w=0.28u l=0.36u
X11 a_82_164# a_0_116# a_138_471# w_0_390# pfet_03v3 ad=0.1238p pd=1.44u as=0.3061p ps=2.445u w=0.28u l=0.28u
X12 a_82_936# a_484_970# a_532_888# VSUBS nfet_03v3 ad=0.1288p pd=1.48u as=0.1208p ps=1.42u w=0.28u l=0.36u
X13 a_3931_1708# a_3849_1660# a_3987_2015# w_3849_1934# pfet_03v3 ad=0.1238p pd=1.44u as=0.3061p ps=2.445u w=0.28u l=0.28u
X14 a_1967_1042# a_1767_970# a_1963_888# VSUBS nfet_03v3 ad=0.1288p pd=1.48u as=0.1208p ps=1.42u w=0.28u l=0.36u
X15 a_1421_2787# a_1365_2480# a_1283_2432# w_1283_2706# pfet_03v3 ad=0.3061p pd=2.445u as=0.1238p ps=1.44u w=0.28u l=0.28u
X16 a_1365_2480# a_1767_2514# a_1815_2432# VSUBS nfet_03v3 ad=0.1288p pd=1.48u as=0.1208p ps=1.42u w=0.28u l=0.36u
X17 a_2704_2787# a_2648_2480# a_2566_2432# w_2566_2706# pfet_03v3 ad=0.3061p pd=2.445u as=0.1238p ps=1.44u w=0.28u l=0.28u
X18 a_138_2787# a_82_2480# a_0_2432# w_0_2706# pfet_03v3 ad=0.3061p pd=2.445u as=0.1238p ps=1.44u w=0.28u l=0.28u
X19 a_2648_936# a_3050_1256# a_3098_1174# VSUBS nfet_03v3 ad=0.1288p pd=1.48u as=0.1208p ps=1.42u w=0.28u l=0.36u
X20 a_1365_2480# a_1767_2800# a_1815_2718# VSUBS nfet_03v3 ad=0.1288p pd=1.48u as=0.1208p ps=1.42u w=0.28u l=0.36u
X21 a_2704_980# a_2648_936# a_2566_888# VSUBS nfet_03v3 ad=0.342p pd=2.21u as=0.3133p ps=2.64u w=0.45u l=0.28u
X22 a_82_1708# a_0_1660# a_138_1752# VSUBS nfet_03v3 ad=0.3133p pd=2.64u as=0.342p ps=2.21u w=0.45u l=0.28u
X23 a_3931_164# a_4333_198# a_4381_116# VSUBS nfet_03v3 ad=0.1288p pd=1.48u as=0.1208p ps=1.42u w=0.28u l=0.36u
X24 a_1092_160# a_1036_116# a_932_160# VSUBS nfet_03v3 ad=0.23585p pd=1.95u as=0.1378p ps=1.05u w=0.53u l=0.28u
X25 a_82_164# a_0_116# a_138_208# VSUBS nfet_03v3 ad=0.3133p pd=2.64u as=0.342p ps=2.21u w=0.45u l=0.28u
X26 a_4941_932# a_4885_1122# a_4781_1166# VSUBS nfet_03v3 ad=0.23585p pd=1.95u as=0.1378p ps=1.05u w=0.53u l=0.28u
X27 a_3931_164# a_4333_484# a_4381_402# VSUBS nfet_03v3 ad=0.1288p pd=1.48u as=0.1208p ps=1.42u w=0.28u l=0.36u
X28 a_2648_164# a_2566_116# a_2704_471# w_2566_390# pfet_03v3 ad=0.1238p pd=1.44u as=0.3061p ps=2.445u w=0.28u l=0.28u
X29 a_3498_1166# a_3442_1122# a_3354_1166# VSUBS nfet_03v3 ad=0.1378p pd=1.05u as=0.2332p ps=1.94u w=0.53u l=0.28u
X30 a_4533_270# a_4333_198# a_4529_116# VSUBS nfet_03v3 ad=0.1288p pd=1.48u as=0.1208p ps=1.42u w=0.28u l=0.36u
X31 a_2375_932# a_2319_888# a_2215_932# VSUBS nfet_03v3 ad=0.23585p pd=1.95u as=0.1378p ps=1.05u w=0.53u l=0.28u
X32 a_4781_1166# a_4725_1122# a_4637_1166# VSUBS nfet_03v3 ad=0.1378p pd=1.05u as=0.2332p ps=1.94u w=0.53u l=0.28u
X33 a_3658_1704# a_3602_1660# a_3498_1704# VSUBS nfet_03v3 ad=0.23585p pd=1.95u as=0.1378p ps=1.05u w=0.53u l=0.28u
X34 a_684_2586# a_484_2514# a_680_2432# VSUBS nfet_03v3 ad=0.1288p pd=1.48u as=0.1208p ps=1.42u w=0.28u l=0.36u
X35 a_1365_1708# a_1283_1660# a_1421_2015# w_1283_1934# pfet_03v3 ad=0.1238p pd=1.44u as=0.3061p ps=2.445u w=0.28u l=0.28u
X36 a_4533_556# a_4333_484# a_4529_402# VSUBS nfet_03v3 ad=0.1288p pd=1.48u as=0.1208p ps=1.42u w=0.28u l=0.36u
X37 a_1092_2476# a_1036_2666# a_932_2710# VSUBS nfet_03v3 ad=0.23585p pd=1.95u as=0.1378p ps=1.05u w=0.53u l=0.28u
X38 a_2215_1704# a_2159_1660# a_2071_1704# VSUBS nfet_03v3 ad=0.1378p pd=1.05u as=0.2332p ps=1.94u w=0.53u l=0.28u
X39 a_3987_471# a_3931_164# a_3849_116# w_3849_390# pfet_03v3 ad=0.3061p pd=2.445u as=0.1238p ps=1.44u w=0.28u l=0.28u
X40 a_4781_394# a_4725_350# a_4637_394# VSUBS nfet_03v3 ad=0.1378p pd=1.05u as=0.2332p ps=1.94u w=0.53u l=0.28u
X41 a_1421_980# a_1365_936# a_1283_888# VSUBS nfet_03v3 ad=0.342p pd=2.21u as=0.3133p ps=2.64u w=0.45u l=0.28u
X42 a_684_2872# a_484_2800# a_680_2718# VSUBS nfet_03v3 ad=0.1288p pd=1.48u as=0.1208p ps=1.42u w=0.28u l=0.36u
X43 a_2375_2476# a_2319_2666# a_2215_2710# VSUBS nfet_03v3 ad=0.23585p pd=1.95u as=0.1378p ps=1.05u w=0.53u l=0.28u
X44 a_2648_2480# a_2566_2432# a_2704_2524# VSUBS nfet_03v3 ad=0.3133p pd=2.64u as=0.342p ps=2.21u w=0.45u l=0.28u
X45 a_932_1704# a_876_1660# a_788_1704# VSUBS nfet_03v3 ad=0.1378p pd=1.05u as=0.2332p ps=1.94u w=0.53u l=0.28u
X46 a_2648_164# a_2566_116# a_2704_208# VSUBS nfet_03v3 ad=0.3133p pd=2.64u as=0.342p ps=2.21u w=0.45u l=0.28u
X47 a_1967_1328# a_1767_1256# a_1963_1174# VSUBS nfet_03v3 ad=0.1288p pd=1.48u as=0.1208p ps=1.42u w=0.28u l=0.36u
X48 a_82_1708# a_484_1742# a_532_1660# VSUBS nfet_03v3 ad=0.1288p pd=1.48u as=0.1208p ps=1.42u w=0.28u l=0.36u
X49 a_3250_1814# a_3050_1742# a_3246_1660# VSUBS nfet_03v3 ad=0.1288p pd=1.48u as=0.1208p ps=1.42u w=0.28u l=0.36u
X50 a_3250_270# a_3050_198# a_3246_116# VSUBS nfet_03v3 ad=0.1288p pd=1.48u as=0.1208p ps=1.42u w=0.28u l=0.36u
X51 a_2648_164# a_3050_198# a_3098_116# VSUBS nfet_03v3 ad=0.1288p pd=1.48u as=0.1208p ps=1.42u w=0.28u l=0.36u
X52 a_1092_932# a_1036_888# a_932_932# VSUBS nfet_03v3 ad=0.23585p pd=1.95u as=0.1378p ps=1.05u w=0.53u l=0.28u
X53 a_4941_1704# a_4885_1894# a_4781_1938# VSUBS nfet_03v3 ad=0.23585p pd=1.95u as=0.1378p ps=1.05u w=0.53u l=0.28u
X54 a_4533_1814# a_4333_1742# a_4529_1660# VSUBS nfet_03v3 ad=0.1288p pd=1.48u as=0.1208p ps=1.42u w=0.28u l=0.36u
X55 a_2648_1708# a_3050_2028# a_3098_1946# VSUBS nfet_03v3 ad=0.1288p pd=1.48u as=0.1208p ps=1.42u w=0.28u l=0.36u
X56 a_3250_556# a_3050_484# a_3246_402# VSUBS nfet_03v3 ad=0.1288p pd=1.48u as=0.1208p ps=1.42u w=0.28u l=0.36u
X57 a_2648_164# a_3050_484# a_3098_402# VSUBS nfet_03v3 ad=0.1288p pd=1.48u as=0.1208p ps=1.42u w=0.28u l=0.36u
X58 a_2648_936# a_2566_888# a_2704_1243# w_2566_1162# pfet_03v3 ad=0.1238p pd=1.44u as=0.3061p ps=2.445u w=0.28u l=0.28u
X59 a_3498_1938# a_3442_1894# a_3354_1938# VSUBS nfet_03v3 ad=0.1378p pd=1.05u as=0.2332p ps=1.94u w=0.53u l=0.28u
X60 a_1365_164# a_1283_116# a_1421_471# w_1283_390# pfet_03v3 ad=0.1238p pd=1.44u as=0.3061p ps=2.445u w=0.28u l=0.28u
X61 a_82_2480# a_0_2432# a_138_2524# VSUBS nfet_03v3 ad=0.3133p pd=2.64u as=0.342p ps=2.21u w=0.45u l=0.28u
X62 a_4781_1938# a_4725_1894# a_4637_1938# VSUBS nfet_03v3 ad=0.1378p pd=1.05u as=0.2332p ps=1.94u w=0.53u l=0.28u
X63 a_3498_394# a_3442_350# a_3354_394# VSUBS nfet_03v3 ad=0.1378p pd=1.05u as=0.2332p ps=1.94u w=0.53u l=0.28u
X64 a_1365_936# a_1767_970# a_1815_888# VSUBS nfet_03v3 ad=0.1288p pd=1.48u as=0.1208p ps=1.42u w=0.28u l=0.36u
X65 a_3987_208# a_3931_164# a_3849_116# VSUBS nfet_03v3 ad=0.342p pd=2.21u as=0.3133p ps=2.64u w=0.45u l=0.28u
X66 a_3931_936# a_3849_888# a_3987_980# VSUBS nfet_03v3 ad=0.3133p pd=2.64u as=0.342p ps=2.21u w=0.45u l=0.28u
X67 a_1421_1752# a_1365_1708# a_1283_1660# VSUBS nfet_03v3 ad=0.342p pd=2.21u as=0.3133p ps=2.64u w=0.45u l=0.28u
X68 a_1092_2476# a_1036_2432# a_932_2476# VSUBS nfet_03v3 ad=0.23585p pd=1.95u as=0.1378p ps=1.05u w=0.53u l=0.28u
X69 a_138_980# a_82_936# a_0_888# VSUBS nfet_03v3 ad=0.342p pd=2.21u as=0.3133p ps=2.64u w=0.45u l=0.28u
X70 a_2375_2476# a_2319_2432# a_2215_2476# VSUBS nfet_03v3 ad=0.23585p pd=1.95u as=0.1378p ps=1.05u w=0.53u l=0.28u
X71 a_2704_1752# a_2648_1708# a_2566_1660# VSUBS nfet_03v3 ad=0.342p pd=2.21u as=0.3133p ps=2.64u w=0.45u l=0.28u
X72 a_2704_471# a_2648_164# a_2566_116# w_2566_390# pfet_03v3 ad=0.3061p pd=2.445u as=0.1238p ps=1.44u w=0.28u l=0.28u
X73 a_138_1752# a_82_1708# a_0_1660# VSUBS nfet_03v3 ad=0.342p pd=2.21u as=0.3133p ps=2.64u w=0.45u l=0.28u
X74 a_3987_2787# a_3931_2480# a_3849_2432# w_3849_2706# pfet_03v3 ad=0.3061p pd=2.445u as=0.1238p ps=1.44u w=0.28u l=0.28u
X75 a_4941_160# a_4885_350# a_4781_394# VSUBS nfet_03v3 ad=0.23585p pd=1.95u as=0.1378p ps=1.05u w=0.53u l=0.28u
X76 a_3931_936# a_4333_1256# a_4381_1174# VSUBS nfet_03v3 ad=0.1288p pd=1.48u as=0.1208p ps=1.42u w=0.28u l=0.36u
X77 a_82_936# a_0_888# a_138_1243# w_0_1162# pfet_03v3 ad=0.1238p pd=1.44u as=0.3061p ps=2.445u w=0.28u l=0.28u
X78 a_1365_164# a_1283_116# a_1421_208# VSUBS nfet_03v3 ad=0.3133p pd=2.64u as=0.342p ps=2.21u w=0.45u l=0.28u
X79 a_4781_160# a_4725_116# a_4637_160# VSUBS nfet_03v3 ad=0.1378p pd=1.05u as=0.2332p ps=1.94u w=0.53u l=0.28u
X80 a_684_270# a_484_198# a_680_116# VSUBS nfet_03v3 ad=0.1288p pd=1.48u as=0.1208p ps=1.42u w=0.28u l=0.36u
X81 a_1421_471# a_1365_164# a_1283_116# w_1283_390# pfet_03v3 ad=0.3061p pd=2.445u as=0.1238p ps=1.44u w=0.28u l=0.28u
X82 a_684_556# a_484_484# a_680_402# VSUBS nfet_03v3 ad=0.1288p pd=1.48u as=0.1208p ps=1.42u w=0.28u l=0.36u
X83 a_3931_2480# a_3849_2432# a_3987_2787# w_3849_2706# pfet_03v3 ad=0.1238p pd=1.44u as=0.3061p ps=2.445u w=0.28u l=0.28u
X84 a_1967_2100# a_1767_2028# a_1963_1946# VSUBS nfet_03v3 ad=0.1288p pd=1.48u as=0.1208p ps=1.42u w=0.28u l=0.36u
X85 a_2215_394# a_2159_350# a_2071_394# VSUBS nfet_03v3 ad=0.1378p pd=1.05u as=0.2332p ps=1.94u w=0.53u l=0.28u
X86 a_82_2480# a_484_2514# a_532_2432# VSUBS nfet_03v3 ad=0.1288p pd=1.48u as=0.1208p ps=1.42u w=0.28u l=0.36u
X87 a_2704_208# a_2648_164# a_2566_116# VSUBS nfet_03v3 ad=0.342p pd=2.21u as=0.3133p ps=2.64u w=0.45u l=0.28u
X88 a_932_394# a_876_350# a_788_394# VSUBS nfet_03v3 ad=0.1378p pd=1.05u as=0.2332p ps=1.94u w=0.53u l=0.28u
X89 a_3250_2586# a_3050_2514# a_3246_2432# VSUBS nfet_03v3 ad=0.1288p pd=1.48u as=0.1208p ps=1.42u w=0.28u l=0.36u
X90 a_4941_1704# a_4885_1660# a_4781_1704# VSUBS nfet_03v3 ad=0.23585p pd=1.95u as=0.1378p ps=1.05u w=0.53u l=0.28u
X91 a_4533_2586# a_4333_2514# a_4529_2432# VSUBS nfet_03v3 ad=0.1288p pd=1.48u as=0.1208p ps=1.42u w=0.28u l=0.36u
X92 a_82_2480# a_484_2800# a_532_2718# VSUBS nfet_03v3 ad=0.1288p pd=1.48u as=0.1208p ps=1.42u w=0.28u l=0.36u
X93 a_2648_1708# a_2566_1660# a_2704_2015# w_2566_1934# pfet_03v3 ad=0.1238p pd=1.44u as=0.3061p ps=2.445u w=0.28u l=0.28u
X94 a_3250_2872# a_3050_2800# a_3246_2718# VSUBS nfet_03v3 ad=0.1288p pd=1.48u as=0.1208p ps=1.42u w=0.28u l=0.36u
X95 a_3498_1704# a_3442_1660# a_3354_1704# VSUBS nfet_03v3 ad=0.1378p pd=1.05u as=0.2332p ps=1.94u w=0.53u l=0.28u
X96 a_3658_2476# a_3602_2666# a_3498_2710# VSUBS nfet_03v3 ad=0.23585p pd=1.95u as=0.1378p ps=1.05u w=0.53u l=0.28u
X97 a_4533_2872# a_4333_2800# a_4529_2718# VSUBS nfet_03v3 ad=0.1288p pd=1.48u as=0.1208p ps=1.42u w=0.28u l=0.36u
X98 a_4781_1704# a_4725_1660# a_4637_1704# VSUBS nfet_03v3 ad=0.1378p pd=1.05u as=0.2332p ps=1.94u w=0.53u l=0.28u
X99 a_3498_160# a_3442_116# a_3354_160# VSUBS nfet_03v3 ad=0.1378p pd=1.05u as=0.2332p ps=1.94u w=0.53u l=0.28u
X100 a_1421_2524# a_1365_2480# a_1283_2432# VSUBS nfet_03v3 ad=0.342p pd=2.21u as=0.3133p ps=2.64u w=0.45u l=0.28u
X101 a_2215_2710# a_2159_2666# a_2071_2710# VSUBS nfet_03v3 ad=0.1378p pd=1.05u as=0.2332p ps=1.94u w=0.53u l=0.28u
X102 a_2648_1708# a_3050_1742# a_3098_1660# VSUBS nfet_03v3 ad=0.1288p pd=1.48u as=0.1208p ps=1.42u w=0.28u l=0.36u
X103 a_1365_936# a_1767_1256# a_1815_1174# VSUBS nfet_03v3 ad=0.1288p pd=1.48u as=0.1208p ps=1.42u w=0.28u l=0.36u
X104 a_2704_2524# a_2648_2480# a_2566_2432# VSUBS nfet_03v3 ad=0.342p pd=2.21u as=0.3133p ps=2.64u w=0.45u l=0.28u
X105 a_932_2710# a_876_2666# a_788_2710# VSUBS nfet_03v3 ad=0.1378p pd=1.05u as=0.2332p ps=1.94u w=0.53u l=0.28u
X106 a_138_2524# a_82_2480# a_0_2432# VSUBS nfet_03v3 ad=0.342p pd=2.21u as=0.3133p ps=2.64u w=0.45u l=0.28u
X107 a_4781_932# a_4725_888# a_4637_932# VSUBS nfet_03v3 ad=0.1378p pd=1.05u as=0.2332p ps=1.94u w=0.53u l=0.28u
X108 a_1421_208# a_1365_164# a_1283_116# VSUBS nfet_03v3 ad=0.342p pd=2.21u as=0.3133p ps=2.64u w=0.45u l=0.28u
X109 a_1421_1243# a_1365_936# a_1283_888# w_1283_1162# pfet_03v3 ad=0.3061p pd=2.445u as=0.1238p ps=1.44u w=0.28u l=0.28u
X110 a_138_471# a_82_164# a_0_116# w_0_390# pfet_03v3 ad=0.3061p pd=2.445u as=0.1238p ps=1.44u w=0.28u l=0.28u
X111 a_2704_1243# a_2648_936# a_2566_888# w_2566_1162# pfet_03v3 ad=0.3061p pd=2.445u as=0.1238p ps=1.44u w=0.28u l=0.28u
X112 a_82_1708# a_0_1660# a_138_2015# w_0_1934# pfet_03v3 ad=0.1238p pd=1.44u as=0.3061p ps=2.445u w=0.28u l=0.28u
X113 a_3931_1708# a_4333_2028# a_4381_1946# VSUBS nfet_03v3 ad=0.1288p pd=1.48u as=0.1208p ps=1.42u w=0.28u l=0.36u
X114 a_4941_160# a_4885_116# a_4781_160# VSUBS nfet_03v3 ad=0.23585p pd=1.95u as=0.1378p ps=1.05u w=0.53u l=0.28u
X115 a_138_1243# a_82_936# a_0_888# w_0_1162# pfet_03v3 ad=0.3061p pd=2.445u as=0.1238p ps=1.44u w=0.28u l=0.28u
X116 a_3931_164# a_3849_116# a_3987_471# w_3849_390# pfet_03v3 ad=0.1238p pd=1.44u as=0.3061p ps=2.445u w=0.28u l=0.28u
X117 a_3931_936# a_4333_970# a_4381_888# VSUBS nfet_03v3 ad=0.1288p pd=1.48u as=0.1208p ps=1.42u w=0.28u l=0.36u
X118 a_1365_2480# a_1283_2432# a_1421_2787# w_1283_2706# pfet_03v3 ad=0.1238p pd=1.44u as=0.3061p ps=2.445u w=0.28u l=0.28u
X119 a_1092_932# a_1036_1122# a_932_1166# VSUBS nfet_03v3 ad=0.23585p pd=1.95u as=0.1378p ps=1.05u w=0.53u l=0.28u
X120 a_3987_1752# a_3931_1708# a_3849_1660# VSUBS nfet_03v3 ad=0.342p pd=2.21u as=0.3133p ps=2.64u w=0.45u l=0.28u
X121 a_4533_1042# a_4333_970# a_4529_888# VSUBS nfet_03v3 ad=0.1288p pd=1.48u as=0.1208p ps=1.42u w=0.28u l=0.36u
X122 a_3658_2476# a_3602_2432# a_3498_2476# VSUBS nfet_03v3 ad=0.23585p pd=1.95u as=0.1378p ps=1.05u w=0.53u l=0.28u
X123 a_2375_932# a_2319_1122# a_2215_1166# VSUBS nfet_03v3 ad=0.23585p pd=1.95u as=0.1378p ps=1.05u w=0.53u l=0.28u
X124 a_684_1328# a_484_1256# a_680_1174# VSUBS nfet_03v3 ad=0.1288p pd=1.48u as=0.1208p ps=1.42u w=0.28u l=0.36u
X125 a_2215_160# a_2159_116# a_2071_160# VSUBS nfet_03v3 ad=0.1378p pd=1.05u as=0.2332p ps=1.94u w=0.53u l=0.28u
X126 a_3498_932# a_3442_888# a_3354_932# VSUBS nfet_03v3 ad=0.1378p pd=1.05u as=0.2332p ps=1.94u w=0.53u l=0.28u
X127 a_2215_2476# a_2159_2432# a_2071_2476# VSUBS nfet_03v3 ad=0.1378p pd=1.05u as=0.2332p ps=1.94u w=0.53u l=0.28u
X128 a_932_160# a_876_116# a_788_160# VSUBS nfet_03v3 ad=0.1378p pd=1.05u as=0.2332p ps=1.94u w=0.53u l=0.28u
X129 a_82_164# a_484_198# a_532_116# VSUBS nfet_03v3 ad=0.1288p pd=1.48u as=0.1208p ps=1.42u w=0.28u l=0.36u
X130 a_932_2476# a_876_2432# a_788_2476# VSUBS nfet_03v3 ad=0.1378p pd=1.05u as=0.2332p ps=1.94u w=0.53u l=0.28u
X131 a_3931_1708# a_3849_1660# a_3987_1752# VSUBS nfet_03v3 ad=0.3133p pd=2.64u as=0.342p ps=2.21u w=0.45u l=0.28u
X132 a_3931_164# a_3849_116# a_3987_208# VSUBS nfet_03v3 ad=0.3133p pd=2.64u as=0.342p ps=2.21u w=0.45u l=0.28u
X133 a_1967_270# a_1767_198# a_1963_116# VSUBS nfet_03v3 ad=0.1288p pd=1.48u as=0.1208p ps=1.42u w=0.28u l=0.36u
X134 a_1967_1814# a_1767_1742# a_1963_1660# VSUBS nfet_03v3 ad=0.1288p pd=1.48u as=0.1208p ps=1.42u w=0.28u l=0.36u
X135 a_82_164# a_484_484# a_532_402# VSUBS nfet_03v3 ad=0.1288p pd=1.48u as=0.1208p ps=1.42u w=0.28u l=0.36u
X136 a_138_208# a_82_164# a_0_116# VSUBS nfet_03v3 ad=0.342p pd=2.21u as=0.3133p ps=2.64u w=0.45u l=0.28u
X137 a_1967_556# a_1767_484# a_1963_402# VSUBS nfet_03v3 ad=0.1288p pd=1.48u as=0.1208p ps=1.42u w=0.28u l=0.36u
X138 a_1365_1708# a_1767_2028# a_1815_1946# VSUBS nfet_03v3 ad=0.1288p pd=1.48u as=0.1208p ps=1.42u w=0.28u l=0.36u
X139 a_4941_932# a_4885_888# a_4781_932# VSUBS nfet_03v3 ad=0.23585p pd=1.95u as=0.1378p ps=1.05u w=0.53u l=0.28u
X140 a_2648_2480# a_3050_2514# a_3098_2432# VSUBS nfet_03v3 ad=0.1288p pd=1.48u as=0.1208p ps=1.42u w=0.28u l=0.36u
X141 a_3250_1042# a_3050_970# a_3246_888# VSUBS nfet_03v3 ad=0.1288p pd=1.48u as=0.1208p ps=1.42u w=0.28u l=0.36u
X142 a_2648_936# a_3050_970# a_3098_888# VSUBS nfet_03v3 ad=0.1288p pd=1.48u as=0.1208p ps=1.42u w=0.28u l=0.36u
X143 a_2648_2480# a_3050_2800# a_3098_2718# VSUBS nfet_03v3 ad=0.1288p pd=1.48u as=0.1208p ps=1.42u w=0.28u l=0.36u
X144 a_1421_2015# a_1365_1708# a_1283_1660# w_1283_1934# pfet_03v3 ad=0.3061p pd=2.445u as=0.1238p ps=1.44u w=0.28u l=0.28u
X145 a_1092_1704# a_1036_1894# a_932_1938# VSUBS nfet_03v3 ad=0.23585p pd=1.95u as=0.1378p ps=1.05u w=0.53u l=0.28u
X146 a_3658_160# a_3602_350# a_3498_394# VSUBS nfet_03v3 ad=0.23585p pd=1.95u as=0.1378p ps=1.05u w=0.53u l=0.28u
X147 a_2375_1704# a_2319_1894# a_2215_1938# VSUBS nfet_03v3 ad=0.23585p pd=1.95u as=0.1378p ps=1.05u w=0.53u l=0.28u
X148 a_2704_2015# a_2648_1708# a_2566_1660# w_2566_1934# pfet_03v3 ad=0.3061p pd=2.445u as=0.1238p ps=1.44u w=0.28u l=0.28u
X149 a_138_2015# a_82_1708# a_0_1660# w_0_1934# pfet_03v3 ad=0.3061p pd=2.445u as=0.1238p ps=1.44u w=0.28u l=0.28u
X150 a_4941_2476# a_4885_2666# a_4781_2710# VSUBS nfet_03v3 ad=0.23585p pd=1.95u as=0.1378p ps=1.05u w=0.53u l=0.28u
X151 a_2215_932# a_2159_888# a_2071_932# VSUBS nfet_03v3 ad=0.1378p pd=1.05u as=0.2332p ps=1.94u w=0.53u l=0.28u
X152 a_932_932# a_876_888# a_788_932# VSUBS nfet_03v3 ad=0.1378p pd=1.05u as=0.2332p ps=1.94u w=0.53u l=0.28u
X153 a_1365_1708# a_1283_1660# a_1421_1752# VSUBS nfet_03v3 ad=0.3133p pd=2.64u as=0.342p ps=2.21u w=0.45u l=0.28u
X154 a_3498_2710# a_3442_2666# a_3354_2710# VSUBS nfet_03v3 ad=0.1378p pd=1.05u as=0.2332p ps=1.94u w=0.53u l=0.28u
X155 a_3987_2524# a_3931_2480# a_3849_2432# VSUBS nfet_03v3 ad=0.342p pd=2.21u as=0.3133p ps=2.64u w=0.45u l=0.28u
X156 a_3931_1708# a_4333_1742# a_4381_1660# VSUBS nfet_03v3 ad=0.1288p pd=1.48u as=0.1208p ps=1.42u w=0.28u l=0.36u
X157 a_4781_2710# a_4725_2666# a_4637_2710# VSUBS nfet_03v3 ad=0.1378p pd=1.05u as=0.2332p ps=1.94u w=0.53u l=0.28u
X158 a_684_2100# a_484_2028# a_680_1946# VSUBS nfet_03v3 ad=0.1288p pd=1.48u as=0.1208p ps=1.42u w=0.28u l=0.36u
X159 a_82_936# a_0_888# a_138_980# VSUBS nfet_03v3 ad=0.3133p pd=2.64u as=0.342p ps=2.21u w=0.45u l=0.28u
X160 a_3931_2480# a_3849_2432# a_3987_2524# VSUBS nfet_03v3 ad=0.3133p pd=2.64u as=0.342p ps=2.21u w=0.45u l=0.28u
X161 a_3987_1243# a_3931_936# a_3849_888# w_3849_1162# pfet_03v3 ad=0.3061p pd=2.445u as=0.1238p ps=1.44u w=0.28u l=0.28u
X162 a_2648_2480# a_2566_2432# a_2704_2787# w_2566_2706# pfet_03v3 ad=0.1238p pd=1.44u as=0.3061p ps=2.445u w=0.28u l=0.28u
X163 a_684_1042# a_484_970# a_680_888# VSUBS nfet_03v3 ad=0.1288p pd=1.48u as=0.1208p ps=1.42u w=0.28u l=0.36u
X164 a_1967_2586# a_1767_2514# a_1963_2432# VSUBS nfet_03v3 ad=0.1288p pd=1.48u as=0.1208p ps=1.42u w=0.28u l=0.36u
X165 a_3250_1328# a_3050_1256# a_3246_1174# VSUBS nfet_03v3 ad=0.1288p pd=1.48u as=0.1208p ps=1.42u w=0.28u l=0.36u
X166 a_82_936# a_484_1256# a_532_1174# VSUBS nfet_03v3 ad=0.1288p pd=1.48u as=0.1208p ps=1.42u w=0.28u l=0.36u
X167 a_1967_2872# a_1767_2800# a_1963_2718# VSUBS nfet_03v3 ad=0.1288p pd=1.48u as=0.1208p ps=1.42u w=0.28u l=0.36u
X168 a_4941_2476# a_4885_2432# a_4781_2476# VSUBS nfet_03v3 ad=0.23585p pd=1.95u as=0.1378p ps=1.05u w=0.53u l=0.28u
X169 a_2375_160# a_2319_350# a_2215_394# VSUBS nfet_03v3 ad=0.23585p pd=1.95u as=0.1378p ps=1.05u w=0.53u l=0.28u
X170 a_1365_164# a_1767_198# a_1815_116# VSUBS nfet_03v3 ad=0.1288p pd=1.48u as=0.1208p ps=1.42u w=0.28u l=0.36u
X171 a_4533_1328# a_4333_1256# a_4529_1174# VSUBS nfet_03v3 ad=0.1288p pd=1.48u as=0.1208p ps=1.42u w=0.28u l=0.36u
X172 a_3658_932# a_3602_1122# a_3498_1166# VSUBS nfet_03v3 ad=0.23585p pd=1.95u as=0.1378p ps=1.05u w=0.53u l=0.28u
X173 a_3931_936# a_3849_888# a_3987_1243# w_3849_1162# pfet_03v3 ad=0.1238p pd=1.44u as=0.3061p ps=2.445u w=0.28u l=0.28u
X174 a_3498_2476# a_3442_2432# a_3354_2476# VSUBS nfet_03v3 ad=0.1378p pd=1.05u as=0.2332p ps=1.94u w=0.53u l=0.28u
X175 a_1365_164# a_1767_484# a_1815_402# VSUBS nfet_03v3 ad=0.1288p pd=1.48u as=0.1208p ps=1.42u w=0.28u l=0.36u
X176 a_2215_1166# a_2159_1122# a_2071_1166# VSUBS nfet_03v3 ad=0.1378p pd=1.05u as=0.2332p ps=1.94u w=0.53u l=0.28u
X177 a_4781_2476# a_4725_2432# a_4637_2476# VSUBS nfet_03v3 ad=0.1378p pd=1.05u as=0.2332p ps=1.94u w=0.53u l=0.28u
X178 a_1092_1704# a_1036_1660# a_932_1704# VSUBS nfet_03v3 ad=0.23585p pd=1.95u as=0.1378p ps=1.05u w=0.53u l=0.28u
X179 a_3658_160# a_3602_116# a_3498_160# VSUBS nfet_03v3 ad=0.23585p pd=1.95u as=0.1378p ps=1.05u w=0.53u l=0.28u
X180 a_1365_1708# a_1767_1742# a_1815_1660# VSUBS nfet_03v3 ad=0.1288p pd=1.48u as=0.1208p ps=1.42u w=0.28u l=0.36u
X181 a_2375_1704# a_2319_1660# a_2215_1704# VSUBS nfet_03v3 ad=0.23585p pd=1.95u as=0.1378p ps=1.05u w=0.53u l=0.28u
X182 a_2648_936# a_2566_888# a_2704_980# VSUBS nfet_03v3 ad=0.3133p pd=2.64u as=0.342p ps=2.21u w=0.45u l=0.28u
X183 a_932_1166# a_876_1122# a_788_1166# VSUBS nfet_03v3 ad=0.1378p pd=1.05u as=0.2332p ps=1.94u w=0.53u l=0.28u
X184 a_82_2480# a_0_2432# a_138_2787# w_0_2706# pfet_03v3 ad=0.1238p pd=1.44u as=0.3061p ps=2.445u w=0.28u l=0.28u
X185 a_1365_2480# a_1283_2432# a_1421_2524# VSUBS nfet_03v3 ad=0.3133p pd=2.64u as=0.342p ps=2.21u w=0.45u l=0.28u
X186 a_3931_2480# a_4333_2514# a_4381_2432# VSUBS nfet_03v3 ad=0.1288p pd=1.48u as=0.1208p ps=1.42u w=0.28u l=0.36u
X187 a_1092_160# a_1036_350# a_932_394# VSUBS nfet_03v3 ad=0.23585p pd=1.95u as=0.1378p ps=1.05u w=0.53u l=0.28u
X188 a_3931_2480# a_4333_2800# a_4381_2718# VSUBS nfet_03v3 ad=0.1288p pd=1.48u as=0.1208p ps=1.42u w=0.28u l=0.36u
X189 a_3987_980# a_3931_936# a_3849_888# VSUBS nfet_03v3 ad=0.342p pd=2.21u as=0.3133p ps=2.64u w=0.45u l=0.28u
X190 a_3987_2015# a_3931_1708# a_3849_1660# w_3849_1934# pfet_03v3 ad=0.3061p pd=2.445u as=0.1238p ps=1.44u w=0.28u l=0.28u
X191 a_3658_1704# a_3602_1894# a_3498_1938# VSUBS nfet_03v3 ad=0.23585p pd=1.95u as=0.1378p ps=1.05u w=0.53u l=0.28u
.ends

.subckt gf180mcu_as_sc_mcu7t3v3__nand2_2 VDD VSS Y B A VNW VPW
X0 VDD A Y VNW pfet_03v3 ad=0.3588p pd=1.9u as=0.3588p ps=1.9u w=1.38u l=0.28u
X1 VSS A a_28_68# VPW nfet_03v3 ad=0.26p pd=1.52u as=0.44p ps=2.88u w=1u l=0.28u
X2 Y B VDD VNW pfet_03v3 ad=0.3588p pd=1.9u as=0.3588p ps=1.9u w=1.38u l=0.28u
X3 a_28_68# B Y VPW nfet_03v3 ad=0.515p pd=3.03u as=0.26p ps=1.52u w=1u l=0.28u
X4 VDD B Y VNW pfet_03v3 ad=0.7176p pd=3.8u as=0.3588p ps=1.9u w=1.38u l=0.28u
X5 Y B a_28_68# VPW nfet_03v3 ad=0.26p pd=1.52u as=0.26p ps=1.52u w=1u l=0.28u
X6 Y A VDD VNW pfet_03v3 ad=0.3588p pd=1.9u as=0.6072p ps=3.64u w=1.38u l=0.28u
X7 a_28_68# A VSS VPW nfet_03v3 ad=0.26p pd=1.52u as=0.26p ps=1.52u w=1u l=0.28u
.ends

.subckt gf180mcu_as_sc_mcu7t3v3__nor2_2 VDD VSS Y B A VNW VPW
X0 a_28_440# A VDD VNW pfet_03v3 ad=0.3588p pd=1.9u as=0.3588p ps=1.9u w=1.38u l=0.28u
X1 Y A VSS VPW nfet_03v3 ad=0.26p pd=1.52u as=0.44p ps=2.88u w=1u l=0.28u
X2 Y B a_28_440# VNW pfet_03v3 ad=0.3588p pd=1.9u as=0.3588p ps=1.9u w=1.38u l=0.28u
X3 VSS B Y VPW nfet_03v3 ad=0.515p pd=3.03u as=0.26p ps=1.52u w=1u l=0.28u
X4 a_28_440# B Y VNW pfet_03v3 ad=0.7176p pd=3.8u as=0.3588p ps=1.9u w=1.38u l=0.28u
X5 Y B VSS VPW nfet_03v3 ad=0.26p pd=1.52u as=0.26p ps=1.52u w=1u l=0.28u
X6 VDD A a_28_440# VNW pfet_03v3 ad=0.3588p pd=1.9u as=0.6072p ps=3.64u w=1.38u l=0.28u
X7 VSS A Y VPW nfet_03v3 ad=0.26p pd=1.52u as=0.26p ps=1.52u w=1u l=0.28u
.ends

.subckt gf180mcu_as_sc_mcu7t3v3__nand3_2 VDD VSS A B C Y VNW VPW
X0 VDD A Y VNW pfet_03v3 ad=0.3588p pd=1.9u as=0.3588p ps=1.9u w=1.38u l=0.28u
X1 VSS A a_28_68# VPW nfet_03v3 ad=0.26p pd=1.52u as=0.44p ps=2.88u w=1u l=0.28u
X2 VDD C Y VNW pfet_03v3 ad=0.621p pd=3.66u as=0.3588p ps=1.9u w=1.38u l=0.28u
X3 a_492_68# C Y VPW nfet_03v3 ad=0.45p pd=2.9u as=0.26p ps=1.52u w=1u l=0.28u
X4 Y B VDD VNW pfet_03v3 ad=0.3588p pd=1.9u as=0.3588p ps=1.9u w=1.38u l=0.28u
X5 a_28_68# B a_492_68# VPW nfet_03v3 ad=0.44p pd=2.88u as=0.26p ps=1.52u w=1u l=0.28u
X6 VDD B Y VNW pfet_03v3 ad=0.8004p pd=2.54u as=0.3588p ps=1.9u w=1.38u l=0.28u
X7 Y C VDD VNW pfet_03v3 ad=0.3588p pd=1.9u as=0.8004p ps=2.54u w=1.38u l=0.28u
X8 Y C a_492_68# VPW nfet_03v3 ad=0.26p pd=1.52u as=0.44p ps=2.88u w=1u l=0.28u
X9 a_492_68# B a_28_68# VPW nfet_03v3 ad=0.26p pd=1.52u as=0.26p ps=1.52u w=1u l=0.28u
X10 Y A VDD VNW pfet_03v3 ad=0.3588p pd=1.9u as=0.6072p ps=3.64u w=1.38u l=0.28u
X11 a_28_68# A VSS VPW nfet_03v3 ad=0.26p pd=1.52u as=0.26p ps=1.52u w=1u l=0.28u
.ends

.subckt gf180mcu_3v3_12t_2r2w_sram_1024x8_array_control_core clk VSS w0_data[0] w0_data[1]
+ w0_data[2] w0_data[3] w0_data[4] w0_data[5] w0_data[6] w0_data[7] w1_data[0] w1_data[1]
+ w1_data[2] w1_data[3] w1_data[4] w1_data[5] w1_data[6] w1_data[7] r0_data[0] r0_data[1]
+ r0_data[2] r0_data[3] r0_data[4] r0_data[5] r0_data[6] r0_data[7] r1_data[0] r1_data[1]
+ r1_data[2] r1_data[3] r1_data[4] r1_data[5] r1_data[6] r1_data[7] u_t000_013/c3_w1_br
+ u_t001_006/c1_r0_rbl u_t023_011/c2_w0_bl u_t000_013/r1_w1_wl u_t000_007/c2_r1_rbl
+ u_t003_009/c0_w1_bl u_t001_010/r3_r1_rwl u_t000_009/c3_r0_rbl u_t001_012/c3_w0_bl
+ u_t001_011/c2_r1_rbl u_t026_005/c2_w1_bl u_t000_012/c2_w0_br u_t001_013/c3_r0_rbl
+ u_t005_009/c2_w0_bl u_t021_013/c2_w0_bl u_t002_005/c0_w1_bl u_t019_013/c2_w0_bl
+ u_t003_006/c2_w1_br u_t003_001/c0_r1_rbl u_t000_015/r3_w0_wl u_t003_003/c1_r0_rbl
+ u_t006_001/r3_w1_wl u_t024_007/c2_w1_bl u_t002_004/c2_r1_rbl u_t030_015/r0_w0_wl
+ u_t006_010/c2_w1_bl u_t002_006/c3_r0_rbl u_t003_005/c1_w0_br u_t000_007/c0_w1_bl
+ u_t003_002/c3_w1_bl u_t017_015/c2_w0_bl u_t001_008/c2_w1_br u_t028_015/r0_w0_wl
+ u_t001_001/c0_w1_bl u_t002_002/c2_w1_br u_t003_010/c3_r0_rbl u_t022_009/c2_w1_bl
+ u_t023_003/c2_w1_bl u_t002_007/c2_w0_bl u_t001_007/c1_w0_br u_t003_001/c2_w0_bl
+ u_t001_004/c3_w1_bl u_t003_012/c1_w1_br u_t002_001/c1_w0_br u_t000_004/c2_w1_br
+ u_t016_011/c2_w0_bl u_t021_005/c2_w1_bl u_t000_009/c2_w0_bl u_t001_003/c2_w0_bl
+ u_t003_011/c0_w0_br u_t001_014/c1_w1_br u_t019_005/c2_w1_bl u_t002_004/r2_w0_wl
+ u_t000_003/c1_w0_br u_t000_000/c3_w1_bl u_t014_013/c2_w0_bl u_t001_015/c0_r0_rbl
+ u_t001_000/c0_r1_rbl u_t001_001/r3_w1_wl u_t001_002/c1_r0_rbl u_t003_014/c3_w0_br
+ u_t003_014/r1_w0_wl u_t031_001/r0_w1_wl u_t001_013/c0_w0_br u_t000_003/c2_r1_rbl
+ u_t001_010/c2_w1_bl u_t017_007/c2_w1_bl u_t000_005/c3_r0_rbl u_t000_010/c1_w1_br
+ u_t012_015/c2_w0_bl u_t029_001/r0_w1_wl u_t023_015/r0_w0_wl u_t000_015/c1_w0_bl
+ u_t015_009/c2_w1_bl u_t001_009/c1_r1_rbl u_t003_012/c0_r0_rbl u_t016_003/c2_w1_bl
+ u_t003_009/c1_w1_bl u_t011_011/c2_w0_bl u_t027_008/c2_w0_bl u_t002_000/c2_r1_rbl
+ u_t003_003/c0_w1_br u_t000_012/c3_w0_br u_t002_002/c3_r0_rbl u_t009_011/c2_w0_bl
+ u_t003_008/c0_w0_bl u_t014_005/c2_w1_bl u_t002_005/c1_w1_bl u_t003_006/c3_w1_br
+ u_t001_005/c0_w1_br u_t003_006/c1_r1_rbl u_t007_013/c2_w0_bl u_t003_008/c2_r0_rbl
+ u_t003_015/c0_w1_bl u_t012_007/c2_w1_bl u_t030_015/r1_w0_wl u_t002_004/c0_w0_bl
+ u_t000_007/c1_w1_bl u_t003_005/c2_w0_br u_t024_001/r0_w1_wl u_t001_008/c3_w1_br
+ u_t028_015/r1_w0_wl u_t001_001/c1_w1_bl u_t002_002/c3_w1_br u_t003_013/c3_r1_rbl
+ u_t005_015/c2_w0_bl u_t000_001/c0_w1_br u_t000_007/c0_r0_rbl u_t016_015/r0_w0_wl
+ u_t010_009/c2_w1_bl u_t000_006/c0_w0_bl u_t011_003/c2_w1_bl u_t001_007/c2_w0_br
+ u_t001_011/c0_r0_rbl u_t003_001/c3_w0_bl u_t003_012/c2_w1_br u_t001_007/r0_w0_wl
+ u_t008_009/c2_w1_bl u_t002_001/c2_w0_br u_t022_008/c2_w0_bl u_t000_012/c1_r1_rbl
+ u_t000_004/c3_w1_br u_t009_003/c2_w1_bl u_t000_014/c2_r0_rbl u_t000_004/r1_w1_wl
+ u_t000_009/c3_w0_bl u_t004_011/c2_w0_bl u_t000_001/c3_r0_rbl u_t000_013/c0_w1_bl
+ u_t001_003/c3_w0_bl u_t003_011/c1_w0_br u_t001_014/c2_w1_br u_t000_003/c2_w0_br
+ u_t002_004/c0_r0_rbl u_t007_005/c2_w1_bl u_t001_005/c1_r1_rbl u_t002_013/c2_w0_bl
+ u_t001_007/c2_r0_rbl u_t031_001/r1_w1_wl u_t001_013/c1_w0_br u_t001_010/c3_w1_bl
+ u_t000_008/c3_r1_rbl u_t000_010/c2_w1_br u_t005_007/c2_w1_bl u_t029_001/r1_w1_wl
+ u_t023_015/r1_w0_wl u_t000_015/c2_w0_bl u_t001_012/c3_r1_rbl u_t017_001/r0_w1_wl
+ u_t011_015/r0_w0_wl u_t003_015/c0_r1_rbl u_t009_015/r0_w0_wl u_t003_009/c2_w1_bl
+ u_t003_002/c1_r1_rbl u_t004_003/c2_w1_bl u_t003_004/c2_r0_rbl u_t003_003/c1_w1_br
+ u_t015_008/c2_w0_bl u_t002_005/c3_r1_rbl u_t031_012/c2_w0_bl u_t003_008/c1_w0_bl
+ u_t029_012/c2_w0_bl u_t002_005/c2_w1_bl u_t000_003/c0_r0_rbl u_t003_002/c0_w0_br
+ u_t001_005/c1_w1_br u_t003_015/c1_w1_bl u_t030_015/r2_w0_wl u_t002_004/c1_w0_bl
+ u_t027_014/c2_w0_bl u_t000_007/c2_w1_bl u_t003_005/c3_w0_br u_t024_001/r1_w1_wl
+ u_t000_010/c2_r0_rbl u_t000_009/r1_r1_rwl u_t001_004/c0_w0_br u_t003_005/r1_w0_wl
+ u_t028_015/r2_w0_wl u_t001_001/c2_w1_bl u_t012_001/r0_w1_wl u_t000_001/c1_w1_br
+ u_t002_002/r2_w1_wl u_t016_015/r1_w0_wl u_t003_014/c0_w0_bl u_t000_006/c1_w0_bl
+ u_t004_015/r0_w0_wl u_t001_007/c3_w0_br u_t001_014/c0_r1_rbl u_t002_000/c0_r0_rbl
+ u_t003_012/c3_w1_br u_t026_010/c2_w0_bl u_t001_011/c0_w1_br u_t002_001/c3_w0_br
+ u_t001_001/c1_r1_rbl u_t000_000/c0_w0_br u_t001_003/c2_r0_rbl u_t031_004/c2_w1_bl
+ u_t010_008/c2_w0_bl u_t000_004/c3_r1_rbl u_t029_004/c2_w1_bl u_t000_013/c1_w1_bl
+ u_t003_011/c2_w0_br u_t008_008/c2_w0_bl u_t001_014/c3_w1_br u_t024_012/c2_w0_bl
+ u_t000_003/c3_w0_br u_t002_007/c0_r1_rbl u_t001_009/r3_r1_rwl u_t000_012/c0_w0_bl
+ u_t003_011/c0_r1_rbl u_t027_006/c2_w1_bl u_t031_001/r2_w1_wl u_t001_013/c2_w0_br
+ u_t003_013/c1_r0_rbl u_t022_014/c2_w0_bl u_t000_010/c3_w1_br u_t003_000/c2_r0_rbl
+ u_t029_001/r2_w1_wl u_t000_010/r1_w1_wl u_t023_015/r2_w0_wl u_t003_006/c0_w1_bl
+ u_t002_001/c3_r1_rbl u_t017_001/r1_w1_wl u_t011_015/r1_w0_wl u_t025_008/c2_w1_bl
+ u_t005_001/r0_w1_wl u_t026_002/c2_w1_bl u_t009_015/r1_w0_wl u_t003_009/c3_w1_bl
+ u_t021_010/c2_w0_bl u_t001_008/c0_w1_bl u_t002_002/c0_w1_bl u_t003_007/c2_r1_rbl
+ u_t003_003/c2_w1_br u_t003_009/c3_r0_rbl u_t019_010/c2_w0_bl u_t001_004/r0_r0_rwl
+ u_t024_004/c2_w1_bl u_t003_008/c2_w0_bl u_t000_005/r1_r1_rwl u_t002_005/c3_w1_bl
+ u_t000_004/c0_w1_bl u_t000_006/c0_r1_rbl u_t003_002/c1_w0_br u_t000_008/c1_r0_rbl
+ u_t001_005/c2_w1_br u_t017_012/c2_w0_bl u_t001_005/r0_w1_wl u_t022_006/c2_w1_bl
+ u_t001_010/c0_r1_rbl u_t001_012/c1_r0_rbl u_t030_015/r3_w0_wl u_t002_004/c2_w0_bl
+ u_t000_007/c3_w1_bl u_t024_001/r2_w1_wl u_t000_013/c2_r1_rbl u_t001_004/c1_w0_br
+ u_t028_015/r3_w0_wl u_t001_001/c3_w1_bl u_t001_008/r3_w1_wl u_t015_014/c2_w0_bl
+ u_t012_001/r1_w1_wl u_t000_000/c3_r1_rbl u_t000_001/c2_w1_br u_t016_015/r2_w0_wl
+ u_t020_008/c2_w1_bl u_t003_014/c1_w0_bl u_t000_001/r0_w1_wl u_t002_004/r2_r0_rwl
+ u_t021_002/c2_w1_bl u_t004_015/r1_w0_wl u_t000_006/c2_w0_bl u_t002_003/c0_r1_rbl
+ u_t018_008/c2_w1_bl u_t001_005/r3_r1_rwl u_t001_000/c2_w0_bl u_t002_005/c1_r0_rbl
+ u_t019_002/c2_w1_bl u_t001_011/c1_w1_br u_t002_001/r2_w0_wl u_t001_006/c2_r1_rbl
+ u_t014_010/c2_w0_bl u_t001_008/c3_r0_rbl u_t000_013/c2_w1_bl u_t003_011/c3_w0_br
+ u_t003_011/r1_w0_wl u_t030_009/c2_w0_bl u_t001_010/c0_w0_br u_t017_004/c2_w1_bl
+ u_t012_012/c2_w0_bl u_t028_009/c2_w0_bl u_t000_012/c1_w0_bl u_t031_001/r3_w1_wl
+ u_t001_013/c3_w0_br u_t015_006/c2_w1_bl u_t003_003/c2_r1_rbl u_t029_001/r3_w1_wl
+ u_t031_010/c2_w1_bl u_t023_015/r3_w0_wl u_t003_005/c3_r0_rbl u_t003_006/c1_w1_bl
+ u_t010_014/c2_w0_bl u_t011_015/r2_w0_wl u_t017_001/r2_w1_wl u_t029_010/c2_w1_bl
+ u_t000_001/r1_r1_rwl u_t002_006/c0_w1_br u_t008_014/c2_w0_bl u_t003_000/c0_w1_br
+ u_t005_001/r1_w1_wl u_t009_015/r2_w0_wl u_t013_008/c2_w1_bl u_t000_002/c0_r1_rbl
+ u_t000_004/c1_r0_rbl u_t003_005/c0_w0_bl u_t014_002/c2_w1_bl u_t001_008/c1_w1_bl
+ u_t002_002/c1_w1_bl u_t000_008/c0_w1_br u_t003_003/c3_w1_br u_t001_002/c0_w1_br
+ u_t003_008/c3_w0_bl u_t007_010/c2_w0_bl u_t000_011/c3_r0_rbl u_t001_007/c0_w0_bl
+ u_t012_004/c2_w1_bl u_t003_012/c0_w1_bl u_t002_001/c0_w0_bl u_t023_009/c2_w0_bl
+ u_t000_004/c1_w1_bl u_t003_002/c2_w0_br u_t001_005/c3_w1_br u_t005_012/c2_w0_bl
+ u_t001_001/r3_r1_rwl u_t002_001/c1_r0_rbl u_t001_015/c1_r1_rbl u_t010_006/c2_w1_bl
+ u_t001_014/c0_w1_bl u_t002_004/c3_w0_bl u_t024_001/r3_w1_wl u_t000_003/c0_w0_bl
+ u_t001_002/c2_r1_rbl u_t001_004/c2_w0_br u_t001_004/r0_w0_wl u_t001_004/c3_r0_rbl
+ u_t008_006/c2_w1_bl u_t012_001/r2_w1_wl u_t016_015/r3_w0_wl u_t024_010/c2_w1_bl
+ u_t000_001/c3_w1_br u_t000_001/r1_w1_wl u_t003_014/c2_w0_bl u_t003_007/c0_r0_rbl
+ u_t004_015/r2_w0_wl u_t000_006/c3_w0_bl u_t000_010/c0_w1_bl u_t001_000/c3_w0_bl
+ u_t001_011/c2_w1_br u_t006_008/c2_w1_bl u_t000_000/c2_w0_br u_t007_002/c2_w1_bl
+ u_t003_012/c1_r1_rbl u_t002_010/c2_w0_bl u_t003_014/c2_r0_rbl u_t000_013/c3_w1_bl
+ u_t003_001/c3_r0_rbl u_t001_010/c1_w0_br u_t001_014/r3_w1_wl u_t005_004/c2_w1_bl
+ u_t000_013/c0_r0_rbl u_t016_009/c2_w0_bl u_t000_012/c2_w0_bl u_t003_009/c0_w0_br
+ u_t003_006/c2_w1_bl u_t003_008/c3_r1_rbl u_t011_015/r3_w0_wl u_t017_001/r3_w1_wl
+ u_t002_006/c1_w1_br u_t005_001/r2_w1_wl u_t030_015/c2_w0_bl u_t001_006/c0_r0_rbl
+ u_t009_015/r3_w0_wl u_t017_010/c2_w1_bl u_t003_005/c1_w0_bl u_t028_015/c2_w0_bl
+ u_t000_007/c1_r1_rbl u_t001_008/c2_w1_bl u_t000_009/c2_r0_rbl u_t002_005/c0_w0_br
+ u_t000_008/c1_w1_br u_t002_002/c2_w1_bl u_t001_011/c1_r1_rbl u_t001_002/c1_w1_br
+ u_t001_013/c2_r0_rbl u_t000_014/c3_r1_rbl u_t001_000/c3_r0_rbl u_t001_007/c1_w0_bl
+ u_t003_012/c1_w1_bl u_t000_007/c0_w0_br u_t002_001/c1_w0_bl u_t027_011/c2_w0_bl
+ u_t000_004/c2_w1_bl u_t003_002/c3_w0_br u_t003_002/r1_w0_wl u_t001_001/c0_w0_br
+ u_t003_003/c0_r0_rbl u_t011_009/c2_w0_bl u_t002_004/c1_r1_rbl u_t003_011/c0_w0_bl
+ u_t001_014/c1_w1_bl u_t002_006/c2_r0_rbl u_t009_009/c2_w0_bl u_t000_003/c1_w0_bl
+ u_t025_013/c2_w0_bl u_t000_014/c0_w1_br u_t001_004/c3_w0_br u_t001_007/c3_r1_rbl
+ u_t012_001/r3_w1_wl u_t003_010/c2_r0_rbl u_t030_007/c2_w1_bl u_t000_001/r2_w1_wl
+ u_t003_014/c3_w0_bl u_t001_013/c0_w0_bl u_t004_015/r3_w0_wl u_t012_010/c2_w1_bl
+ u_t028_007/c2_w1_bl u_t023_015/c2_w0_bl u_t000_010/c1_w1_bl u_t001_011/c3_w1_br
+ u_t000_000/c3_w0_br u_t026_009/c2_w1_bl u_t027_003/c2_w1_bl u_t003_004/c3_r1_rbl
+ u_t001_010/c2_w0_br u_t000_015/r1_r1_rwl u_t022_011/c2_w0_bl u_t001_002/c0_r0_rbl
+ u_t003_003/c0_w1_bl u_t000_012/c3_w0_bl u_t000_003/c1_r1_rbl u_t025_005/c2_w1_bl
+ u_t004_009/c2_w0_bl u_t000_005/c2_r0_rbl u_t020_013/c2_w0_bl u_t003_009/c1_w0_br
+ u_t003_006/c3_w1_bl u_t001_005/c0_w1_bl u_t002_006/c2_w1_br u_t018_013/c2_w0_bl
+ u_t005_001/r3_w1_wl u_t000_010/c3_r1_rbl u_t003_000/c2_w1_br u_t023_007/c2_w1_bl
+ u_t001_009/c0_r1_rbl u_t003_005/c2_w0_bl u_t001_008/c3_w1_bl u_t005_010/c2_w1_bl
+ u_t001_015/r3_r1_rwl u_t002_005/c1_w0_br u_t000_008/c2_w1_br u_t002_002/c3_w1_bl
+ u_t016_015/c2_w0_bl u_t027_015/r0_w0_wl u_t000_001/c0_w1_bl u_t001_002/c2_w1_br
+ u_t002_002/c2_r0_rbl u_t021_009/c2_w1_bl u_t001_002/r0_w1_wl u_t022_003/c2_w1_bl
+ u_t001_003/c3_r1_rbl u_t001_007/c2_w0_bl u_t003_015/c0_w0_br u_t003_012/c2_w1_bl
+ u_t019_009/c2_w1_bl u_t000_007/c1_w0_br u_t002_001/c2_w0_bl u_t000_004/c3_w1_bl
+ u_t001_001/c1_w0_br u_t001_005/r3_w1_wl u_t003_006/c0_r1_rbl u_t015_011/c2_w0_bl
+ u_t003_008/c1_r0_rbl u_t020_005/c2_w1_bl u_t003_011/c1_w0_bl u_t001_014/c2_w1_bl
+ u_t000_003/c2_w0_bl u_t018_005/c2_w1_bl u_t000_014/c1_w1_br u_t003_013/c2_r1_rbl
+ u_t013_013/c2_w0_bl u_t000_001/r3_w1_wl u_t003_000/c3_r1_rbl u_t001_013/c1_w0_bl
+ u_t000_011/r1_r1_rwl u_t030_001/r0_w1_wl u_t000_013/c0_w0_br u_t016_007/c2_w1_bl
+ u_t000_010/c2_w1_bl u_t000_012/c0_r1_rbl u_t011_015/c2_w0_bl u_t028_001/r0_w1_wl
+ u_t000_014/c1_r0_rbl u_t022_015/r0_w0_wl u_t000_001/c2_r0_rbl u_t003_007/c0_w1_br
+ u_t009_015/c2_w0_bl u_t001_010/c3_w0_br u_t014_009/c2_w1_bl u_t015_003/c2_w1_bl
+ u_t026_008/c2_w0_bl u_t003_003/c1_w1_bl u_t010_011/c2_w0_bl u_t001_005/c0_r1_rbl
+ u_t001_009/c0_w1_br u_t001_007/c1_r0_rbl u_t002_003/c0_w1_br u_t008_011/c2_w0_bl
+ u_t000_008/c2_r1_rbl u_t001_011/r3_r1_rwl u_t013_005/c2_w1_bl u_t003_009/c2_w0_br
+ u_t003_002/c0_w0_bl u_t001_005/c1_w1_bl u_t001_012/c2_r1_rbl u_t002_006/c3_w1_br
+ u_t001_014/c3_r0_rbl u_t000_005/c0_w1_br u_t003_000/c3_w1_br u_t006_013/c2_w0_bl
+ u_t011_007/c2_w1_bl u_t003_005/c3_w0_bl u_t001_004/c0_w0_bl u_t003_002/c0_r1_rbl
+ u_t002_005/c2_w0_br u_t023_001/r0_w1_wl u_t000_008/c3_w1_br u_t003_004/c1_r0_rbl
+ u_t009_007/c2_w1_bl u_t027_015/r1_w0_wl u_t000_001/c1_w1_bl u_t000_008/r1_w1_wl
+ u_t001_002/c3_w1_br u_t002_005/c2_r1_rbl u_t004_015/c2_w0_bl u_t015_015/r0_w0_wl
+ u_t001_007/c3_w0_bl u_t003_015/c1_w0_br u_t003_012/c3_w1_bl u_t002_001/c3_w0_bl
+ u_t010_003/c2_w1_bl u_t000_007/c2_w0_br u_t001_011/c0_w1_bl u_t003_011/c3_r0_rbl
+ u_t007_009/c2_w1_bl u_t021_008/c2_w0_bl u_t001_001/c2_w0_br u_t001_001/r0_w0_wl
+ u_t008_003/c2_w1_bl u_t003_011/c2_w0_bl u_t019_008/c2_w0_bl u_t001_014/c3_w1_bl
+ u_t000_003/c3_w0_bl u_t000_010/c1_r0_rbl u_t000_014/c2_w1_br u_t006_005/c2_w1_bl
+ u_t001_013/c2_w0_bl u_t030_001/r1_w1_wl u_t000_013/c1_w0_br u_t000_010/c3_w1_bl
+ u_t001_001/c0_r1_rbl u_t001_011/r3_w1_wl u_t004_007/c2_w1_bl u_t028_001/r1_w1_wl
+ u_t001_003/c1_r0_rbl u_t022_015/r1_w0_wl u_t003_007/c1_w1_br u_t000_004/c2_r1_rbl
+ u_t010_015/r0_w0_wl u_t016_001/r0_w1_wl u_t000_006/c3_r0_rbl u_t008_015/r0_w0_wl
+ u_t002_009/c2_w1_bl u_t001_010/c3_r0_rbl u_t003_006/c0_w0_br u_t001_009/c1_w1_br
+ u_t003_003/c2_w1_bl u_t002_003/c1_w1_br u_t014_008/c2_w0_bl u_t003_013/c0_r0_rbl
+ u_t030_012/c2_w0_bl u_t003_009/c3_w0_br u_t001_008/c0_w0_br u_t003_002/c1_w0_bl
+ u_t003_009/r1_w0_wl u_t028_012/c2_w0_bl u_t001_005/c2_w1_bl u_t002_001/c2_r1_rbl
+ u_t003_013/c0_w1_br u_t002_002/c0_w0_br u_t002_003/c3_r0_rbl u_t000_005/c1_w1_br
+ u_t002_006/r2_w1_wl u_t001_004/c1_w0_bl u_t026_014/c2_w0_bl u_t001_015/c0_w1_br
+ u_t002_005/c3_w0_br u_t023_001/r1_w1_wl u_t003_007/c1_r1_rbl u_t000_004/c0_w0_br
+ u_t027_015/r2_w0_wl u_t031_008/c2_w1_bl u_t000_001/c2_w1_bl u_t003_009/c2_r0_rbl
+ u_t011_001/r0_w1_wl u_t015_015/r1_w0_wl u_t029_008/c2_w1_bl u_t003_015/r0_w0_wl
+ u_t009_001/r0_w1_wl u_t000_007/c3_w0_br u_t001_011/c1_w1_bl u_t003_014/c3_r1_rbl
+ u_t000_008/c0_r0_rbl u_t025_010/c2_w0_bl u_t000_011/c0_w1_br u_t001_001/c3_w0_br
+ u_t030_004/c2_w1_bl u_t003_011/c3_w0_bl u_t001_012/c0_r0_rbl u_t001_010/c0_w0_bl
+ u_t028_004/c2_w1_bl u_t000_013/c1_r1_rbl u_t007_008/c2_w0_bl u_t000_014/c3_w1_br
+ u_t000_014/r1_w1_wl u_t023_012/c2_w0_bl u_t000_000/c2_r1_rbl u_t000_002/c3_r0_rbl
+ u_t001_013/c3_w0_bl u_t026_006/c2_w1_bl u_t030_001/r2_w1_wl u_t000_013/c2_w0_br
+ u_t002_005/c0_r0_rbl u_t021_014/c2_w0_bl u_t022_015/r2_w0_wl u_t028_001/r2_w1_wl
+ u_t001_006/c1_r1_rbl u_t001_008/c2_r0_rbl u_t002_006/c0_w1_bl u_t003_007/c2_w1_br
+ u_t019_014/c2_w0_bl u_t010_015/r1_w0_wl u_t016_001/r1_w1_wl u_t000_009/c3_r1_rbl
+ u_t024_008/c2_w1_bl u_t004_001/r0_w1_wl u_t025_002/c2_w1_bl u_t008_015/r1_w0_wl
+ u_t001_013/c3_r1_rbl u_t020_010/c2_w0_bl u_t000_008/c0_w1_bl u_t003_006/c1_w0_br
+ u_t001_009/c2_w1_br u_t003_003/c3_w1_bl u_t001_002/c0_w1_bl u_t002_003/c2_w1_br
+ u_t018_010/c2_w0_bl u_t023_004/c2_w1_bl u_t002_008/c2_w0_bl u_t003_003/c1_r1_rbl
+ u_t003_005/c2_r0_rbl u_t001_008/c1_w0_br u_t003_002/c2_w0_bl u_t001_005/c3_w1_bl
+ u_t003_013/c1_w1_br u_t002_002/c1_w0_br u_t002_006/c3_r1_rbl u_t000_005/c2_w1_br
+ u_t016_012/c2_w0_bl u_t021_006/c2_w1_bl u_t003_010/c3_r1_rbl u_t000_004/c0_r0_rbl
+ u_t001_004/c2_w0_bl u_t003_012/c0_w0_br u_t019_006/c2_w1_bl u_t001_015/c1_w1_br
+ u_t023_001/r2_w1_wl u_t002_005/r2_w0_wl u_t027_015/r3_w0_wl u_t000_004/c1_w0_br
+ u_t000_001/c3_w1_bl u_t011_001/r1_w1_wl u_t014_014/c2_w0_bl u_t001_002/r3_w1_wl
+ u_t015_015/r2_w0_wl u_t000_011/c2_r0_rbl u_t009_001/r1_w1_wl u_t020_002/c2_w1_bl
+ u_t003_015/r1_w0_wl u_t001_014/c0_w0_br u_t017_008/c2_w1_bl u_t001_011/c2_w1_bl
+ u_t000_000/c2_w0_bl u_t018_002/c2_w1_bl u_t000_011/c1_w1_br u_t013_010/c2_w0_bl
+ u_t002_001/c0_r0_rbl u_t001_015/c0_r1_rbl u_t001_010/c1_w0_bl u_t001_002/c1_r1_rbl
+ u_t000_010/c0_w0_br u_t001_004/c2_r0_rbl u_t016_004/c2_w1_bl u_t027_009/c2_w0_bl
+ u_t000_005/c3_r1_rbl u_t011_012/c2_w0_bl u_t003_004/c0_w1_br u_t000_013/c3_w0_br
+ u_t030_001/r3_w1_wl u_t009_012/c2_w0_bl u_t003_009/c0_w0_bl u_t014_006/c2_w1_bl
+ u_t022_015/r3_w0_wl u_t028_001/r3_w1_wl u_t030_010/c2_w1_bl u_t002_006/c1_w1_bl
+ u_t003_007/c3_w1_br u_t003_012/c0_r1_rbl u_t016_001/r2_w1_wl u_t003_014/c1_r0_rbl
+ u_t010_015/r2_w0_wl u_t001_006/c0_w1_br u_t028_010/c2_w1_bl u_t003_001/c2_r0_rbl
+ u_t004_001/r1_w1_wl u_t007_014/c2_w0_bl u_t002_000/c0_w1_br u_t008_015/r2_w0_wl
+ u_t012_008/c2_w1_bl u_t002_002/c3_r1_rbl u_t002_005/c0_w0_bl u_t013_002/c2_w1_bl
+ u_t000_008/c1_w1_bl u_t003_006/c2_w0_br u_t001_009/c3_w1_br u_t001_002/c1_w1_bl
+ u_t002_003/c3_w1_br u_t000_000/c0_r0_rbl u_t000_002/c0_w1_br u_t006_010/c2_w0_bl
+ u_t000_007/c0_w0_bl u_t003_002/c3_w0_bl u_t003_008/c2_r1_rbl u_t011_004/c2_w1_bl
+ u_t001_008/c2_w0_br u_t003_013/c2_w1_br u_t001_001/c0_w0_bl u_t001_005/r0_r0_rwl
+ u_t022_009/c2_w0_bl u_t002_002/c2_w0_br u_t000_005/c3_w1_br u_t009_004/c2_w1_bl
+ u_t000_005/r1_w1_wl u_t000_006/r1_r1_rwl u_t004_012/c2_w0_bl u_t000_007/c0_r1_rbl
+ u_t000_014/c0_w1_bl u_t001_004/c3_w0_bl u_t003_012/c1_w0_br u_t023_001/r3_w1_wl
+ u_t000_009/c1_r0_rbl u_t000_004/c2_w0_br u_t001_011/c0_r1_rbl u_t007_006/c2_w1_bl
+ u_t011_001/r2_w1_wl u_t001_013/c1_r0_rbl u_t015_015/r3_w0_wl u_t023_010/c2_w1_bl
+ u_t002_014/c2_w0_bl u_t001_000/c2_r0_rbl u_t009_001/r2_w1_wl u_t000_014/c2_r1_rbl
+ u_t003_015/r2_w0_wl u_t001_014/c1_w0_br u_t001_011/c3_w1_bl u_t000_000/c3_w0_bl
+ u_t000_001/c3_r1_rbl u_t000_011/c2_w1_br u_t005_008/c2_w1_bl u_t002_005/r2_r0_rwl
+ u_t006_002/c2_w1_bl u_t002_004/c0_r1_rbl u_t001_010/c2_w0_bl u_t001_006/r3_r1_rwl
+ u_t002_006/c1_r0_rbl u_t000_010/c1_w0_br u_t001_007/c2_r1_rbl u_t003_010/c1_r0_rbl
+ u_t001_009/c3_r0_rbl u_t004_004/c2_w1_bl u_t003_004/c1_w1_br u_t015_009/c2_w0_bl
+ u_t031_013/c2_w0_bl u_t003_009/c1_w0_bl u_t029_013/c2_w0_bl u_t002_006/c2_w1_bl
+ u_t016_001/r3_w1_wl u_t003_003/c0_w0_br u_t010_015/r3_w0_wl u_t001_006/c1_w1_br
+ u_t003_000/c2_w1_bl u_t004_001/r2_w1_wl u_t003_004/c2_r1_rbl u_t003_006/c3_r0_rbl
+ u_t008_015/r3_w0_wl u_t016_010/c2_w1_bl u_t001_001/r0_r0_rwl u_t002_005/c1_w0_bl
+ u_t027_015/c2_w0_bl u_t000_008/c2_w1_bl u_t003_006/c3_w0_br u_t000_002/r1_r1_rwl
+ u_t003_006/r1_w0_wl u_t001_005/c0_w0_br u_t001_002/c2_w1_bl u_t003_010/c0_w1_br
+ u_t002_003/r2_w1_wl u_t000_002/c1_w1_br u_t000_003/c0_r1_rbl u_t000_005/c1_r0_rbl
+ u_t003_015/c0_w0_bl u_t000_007/c1_w0_bl u_t001_008/c3_w0_br u_t001_001/c1_w0_bl
+ u_t003_013/c3_w1_br u_t026_011/c2_w0_bl u_t001_012/c0_w1_br u_t002_002/c3_w0_br
+ u_t031_005/c2_w1_bl u_t000_001/c0_w0_br u_t000_010/c2_r1_rbl u_t010_009/c2_w0_bl
+ u_t000_012/c3_r0_rbl u_t029_005/c2_w1_bl u_t000_014/c1_w1_bl u_t003_012/c2_w0_br
+ u_t008_009/c2_w0_bl u_t002_001/r2_r0_rwl u_t024_013/c2_w0_bl u_t000_004/c3_w0_br
+ u_t002_000/c0_r1_rbl u_t011_001/r3_w1_wl u_t001_002/r3_r1_rwl u_t002_002/c1_r0_rbl
+ u_t009_001/r3_w1_wl u_t027_007/c2_w1_bl u_t000_013/c0_w0_bl u_t001_003/c2_r1_rbl
+ u_t003_015/r3_w0_wl u_t011_010/c2_w1_bl u_t001_005/c3_r0_rbl u_t001_014/c2_w0_br
+ u_t022_015/c2_w0_bl u_t000_011/c3_w1_br u_t009_010/c2_w1_bl u_t000_011/r1_w1_wl
+ u_t003_007/c0_w1_bl u_t003_008/c0_r0_rbl u_t001_010/c3_w0_bl u_t025_009/c2_w1_bl
+ u_t026_003/c2_w1_bl u_t000_010/c2_w0_br u_t003_013/c1_r1_rbl u_t021_011/c2_w0_bl
+ u_t001_009/c0_w1_bl u_t003_000/c2_r1_rbl u_t002_003/c0_w1_bl u_t003_002/c3_r0_rbl
+ u_t003_004/c2_w1_br u_t019_011/c2_w0_bl u_t024_005/c2_w1_bl u_t003_009/c2_w0_bl
+ u_t000_014/c0_r0_rbl u_t002_006/c3_w1_bl u_t000_001/c1_r0_rbl u_t000_005/c0_w1_bl
+ u_t003_003/c1_w0_br u_t001_006/c2_w1_br u_t003_000/c3_w1_bl u_t017_013/c2_w0_bl
+ u_t001_006/r0_w1_wl u_t004_001/r3_w1_wl u_t022_007/c2_w1_bl u_t002_000/c2_w1_br
+ u_t003_009/c3_r1_rbl u_t002_005/c2_w0_bl u_t000_008/c3_w1_bl u_t004_010/c2_w1_bl
+ u_t001_005/c1_w0_br u_t001_002/c3_w1_bl u_t001_009/r3_w1_wl u_t003_010/c1_w1_br
+ u_t015_015/c2_w0_bl u_t001_007/c0_r0_rbl u_t026_015/r0_w0_wl u_t020_009/c2_w1_bl
+ u_t000_002/c2_w1_br u_t000_008/c1_r1_rbl u_t003_015/c1_w0_bl u_t021_003/c2_w1_bl
+ u_t000_007/c2_w0_bl u_t018_009/c2_w1_bl u_t001_001/c2_w0_bl u_t001_012/c1_r1_rbl
+ u_t019_003/c2_w1_bl u_t001_012/c1_w1_br u_t001_014/c2_r0_rbl u_t002_002/r2_w0_wl
+ u_t000_001/c1_w0_br u_t014_011/c2_w0_bl u_t001_001/c3_r0_rbl u_t003_012/c3_w0_br
+ u_t000_014/c2_w1_bl u_t003_012/r1_w0_wl u_t001_011/c0_w0_br u_t003_004/c0_r0_rbl
+ u_t017_005/c2_w1_bl u_t002_005/c1_r1_rbl u_t012_013/c2_w0_bl u_t000_013/c1_w0_bl
+ u_t001_014/c3_w0_br u_t001_008/c3_r1_rbl u_t003_011/c2_r0_rbl u_t015_007/c2_w1_bl
+ u_t003_007/c1_w1_bl u_t010_015/c2_w0_bl u_t021_015/r0_w0_wl u_t027_001/r0_w1_wl
+ u_t002_007/c0_w1_br u_t008_015/c2_w0_bl u_t019_015/r0_w0_wl u_t000_010/c0_r0_rbl
+ u_t003_001/c0_w1_br u_t000_010/c3_w0_br u_t013_009/c2_w1_bl u_t003_006/c0_w0_bl
+ u_t014_003/c2_w1_bl u_t001_009/c1_w1_bl u_t025_008/c2_w0_bl u_t000_009/c0_w1_br
+ u_t002_003/c1_w1_bl u_t003_004/c3_w1_br u_t003_005/c3_r1_rbl u_t001_003/c0_w1_br
+ u_t007_011/c2_w0_bl u_t003_009/c3_w0_bl u_t001_008/c0_w0_bl u_t012_005/c2_w1_bl
+ u_t001_003/c0_r0_rbl u_t003_013/c0_w1_bl u_t002_002/c0_w0_bl u_t000_005/c1_w1_bl
+ u_t003_003/c2_w0_br u_t000_004/c1_r1_rbl u_t001_006/c3_w1_br u_t000_006/c2_r0_rbl
+ u_t002_000/c3_w1_br u_t005_013/c2_w0_bl u_t010_007/c2_w1_bl u_t001_010/c2_r0_rbl
+ u_t001_015/c0_w1_bl u_t002_005/c3_w0_bl u_t000_004/c0_w0_bl u_t000_011/c3_r1_rbl
+ u_t001_005/c2_w0_br u_t022_001/r0_w1_wl u_t001_005/r0_w0_wl u_t003_010/c2_w1_br
+ u_t008_007/c2_w1_bl u_t026_015/r1_w0_wl u_t000_002/c3_w1_br u_t000_002/r1_w1_wl
+ u_t003_015/c2_w0_bl u_t014_015/r0_w0_wl u_t003_000/c0_r0_rbl u_t000_007/c3_w0_bl
+ u_t001_001/c3_w0_bl u_t002_001/c1_r1_rbl u_t000_011/c0_w1_bl u_t001_012/c2_w1_br
+ u_t002_003/c2_r0_rbl u_t006_009/c2_w1_bl u_t000_001/c2_w0_br u_t020_008/c2_w0_bl
+ u_t000_001/r0_w0_wl u_t007_003/c2_w1_bl u_t001_004/c3_r1_rbl u_t002_011/c2_w0_bl
+ u_t018_008/c2_w0_bl u_t000_014/c3_w1_bl u_t001_011/c1_w0_br u_t001_015/r3_w1_wl
+ u_t003_007/c0_r1_rbl u_t003_009/c1_r0_rbl u_t005_005/c2_w1_bl u_t000_013/c2_w0_bl
+ u_t003_014/c2_r1_rbl u_t003_001/c3_r1_rbl u_t003_007/c2_w1_bl u_t021_015/r1_w0_wl
+ u_t027_001/r1_w1_wl u_t000_012/r1_r1_rwl u_t002_007/c1_w1_br u_t015_001/r0_w1_wl
+ u_t019_015/r1_w0_wl u_t003_001/c1_w1_br u_t000_013/c0_r1_rbl u_t000_015/c1_r0_rbl
+ u_t031_010/c2_w0_bl u_t007_015/r0_w0_wl u_t003_006/c1_w0_bl u_t001_009/c2_w1_bl
+ u_t000_002/c2_r0_rbl u_t002_006/c0_w0_br u_t029_010/c2_w0_bl u_t000_009/c1_w1_br
+ u_t002_003/c2_w1_bl u_t003_000/c0_w0_br u_t001_003/c1_w1_br u_t013_008/c2_w0_bl
+ u_t001_008/c1_w0_bl u_t001_006/c0_r1_rbl u_t003_013/c1_w1_bl u_t002_002/c1_w0_bl
+ u_t000_008/c0_w0_br u_t001_008/c1_r0_rbl u_t027_012/c2_w0_bl u_t000_005/c2_w1_bl
+ u_t003_003/c3_w0_br u_t003_003/r1_w0_wl u_t001_002/c0_w0_br u_t000_009/c2_r1_rbl
+ u_t001_012/r3_r1_rwl u_t003_012/c0_w0_bl u_t001_013/c2_r1_rbl u_t001_015/c1_w1_bl
+ u_t000_004/c1_w0_bl u_t022_001/r1_w1_wl u_t025_014/c2_w0_bl u_t000_015/c0_w1_br
+ u_t001_000/c3_r1_rbl u_t001_005/c3_w0_br u_t003_010/c3_w1_br u_t026_015/r2_w0_wl
+ u_t030_008/c2_w1_bl u_t010_001/r0_w1_wl u_t031_002/c2_w1_bl u_t014_015/r1_w0_wl
+ u_t028_008/c2_w1_bl u_t001_014/c0_w0_bl u_t003_003/c0_r1_rbl u_t003_005/c1_r0_rbl
+ u_t008_001/r0_w1_wl u_t002_015/r0_w0_wl u_t029_002/c2_w1_bl u_t000_011/c1_w1_bl
+ u_t001_012/c3_w1_br u_t002_006/c2_r1_rbl u_t000_001/c3_w0_br u_t024_010/c2_w0_bl
+ u_t000_001/r1_w0_wl u_t003_010/c2_r1_rbl u_t003_012/c3_r0_rbl u_t000_010/c0_w0_bl
+ u_t027_004/c2_w1_bl u_t001_011/c2_w0_br u_t006_008/c2_w0_bl u_t022_012/c2_w0_bl
+ u_t003_004/c0_w1_bl u_t000_013/c3_w0_bl u_t000_011/c1_r0_rbl u_t025_006/c2_w1_bl
+ u_t020_014/c2_w0_bl u_t027_001/r2_w1_wl u_t003_007/c3_w1_bl u_t021_015/r2_w0_wl
+ u_t001_006/c0_w1_bl u_t015_001/r1_w1_wl u_t018_014/c2_w0_bl u_t019_015/r2_w0_wl
+ u_t023_008/c2_w1_bl u_t003_001/c2_w1_br u_t001_002/c0_r1_rbl u_t003_001/r0_w1_wl
+ u_t001_004/c1_r0_rbl u_t024_002/c2_w1_bl u_t007_015/r1_w0_wl u_t003_006/c2_w0_bl
+ u_t001_009/c3_w1_bl u_t000_005/c2_r1_rbl u_t002_006/c1_w0_br u_t000_007/c3_r0_rbl
+ u_t000_009/c2_w1_br u_t002_003/c3_w1_bl u_t000_002/c0_w1_bl u_t017_010/c2_w0_bl
+ u_t001_003/c2_w1_br u_t001_003/r0_w1_wl u_t001_011/c3_r0_rbl u_t022_004/c2_w1_bl
+ u_t001_008/c2_w0_bl u_t003_013/c2_w1_bl u_t002_002/c2_w0_bl u_t000_008/c1_w0_br
+ u_t000_005/c3_w1_bl u_t003_014/c0_r0_rbl u_t001_002/c1_w0_br u_t001_006/r3_w1_wl
+ u_t015_012/c2_w0_bl u_t003_001/c1_r0_rbl u_t020_006/c2_w1_bl u_t003_012/c1_w0_bl
+ u_t002_002/c2_r1_rbl u_t000_004/c2_w0_bl u_t002_004/c3_r0_rbl u_t018_006/c2_w1_bl
+ u_t022_001/r2_w1_wl u_t000_015/c1_w1_br u_t026_015/r3_w0_wl u_t010_001/r1_w1_wl
+ u_t013_014/c2_w0_bl u_t014_015/r2_w0_wl u_t001_014/c1_w0_bl u_t008_001/r1_w1_wl
+ u_t002_015/r1_w0_wl u_t003_008/c1_r1_rbl u_t000_011/c2_w1_bl u_t000_014/c0_w0_br
+ u_t016_008/c2_w1_bl u_t017_002/c2_w1_bl u_t012_010/c2_w0_bl u_t003_008/c0_w1_br
+ u_t000_010/c1_w0_bl u_t000_009/c0_r0_rbl u_t001_011/c3_w0_br u_t015_004/c2_w1_bl
+ u_t001_013/c0_r0_rbl u_t010_012/c2_w0_bl u_t026_009/c2_w0_bl u_t003_004/c1_w1_bl
+ u_t000_014/c1_r1_rbl u_t002_004/c0_w1_br u_t008_012/c2_w0_bl u_t000_001/c2_r1_rbl
+ u_t000_003/c3_r0_rbl u_t013_006/c2_w1_bl u_t027_001/r3_w1_wl u_t021_015/r3_w0_wl
+ u_t003_003/c0_w0_bl u_t001_006/c1_w1_bl u_t015_001/r2_w1_wl u_t000_006/c0_w1_br
+ u_t002_006/c0_r0_rbl u_t019_015/r3_w0_wl u_t027_010/c2_w1_bl u_t003_001/c3_w1_br
+ u_t006_014/c2_w0_bl u_t003_001/r1_w1_wl u_t001_000/c0_w1_br u_t001_007/c1_r1_rbl
+ u_t007_015/r2_w0_wl u_t011_008/c2_w1_bl u_t001_009/c2_r0_rbl u_t003_006/c3_w0_bl
+ u_t003_010/c0_r0_rbl u_t001_005/c0_w0_bl u_t012_002/c2_w1_bl u_t002_006/c2_w0_br
+ u_t003_010/c0_w1_bl u_t000_009/c3_w1_br u_t009_008/c2_w1_bl u_t003_000/c2_w0_br
+ u_t000_002/c1_w1_bl u_t000_009/r1_w1_wl u_t001_003/c3_w1_br u_t001_014/c3_r1_rbl
+ u_t002_000/c3_r0_rbl u_t005_010/c2_w0_bl u_t001_008/c3_w0_bl u_t003_013/c3_w1_bl
+ u_t002_002/c3_w0_bl u_t010_004/c2_w1_bl u_t000_008/c2_w0_br u_t001_012/c0_w1_bl
+ u_t000_001/c0_w0_bl u_t001_002/c2_w0_br u_t021_009/c2_w0_bl u_t001_002/r0_w0_wl
+ u_t008_004/c2_w1_bl u_t003_004/c1_r1_rbl u_t003_006/c2_r0_rbl u_t003_012/c2_w0_bl
+ u_t019_009/c2_w0_bl u_t000_004/c3_w0_bl u_t022_001/r3_w1_wl u_t006_006/c2_w1_bl
+ u_t010_001/r2_w1_wl u_t003_011/c3_r1_rbl u_t000_005/c0_r0_rbl u_t014_015/r3_w0_wl
+ u_t022_010/c2_w1_bl u_t001_014/c2_w0_bl u_t008_001/r2_w1_wl u_t000_014/c1_w0_br
+ u_t002_015/r2_w0_wl u_t000_011/c3_w1_bl u_t001_012/r3_w1_wl u_t004_008/c2_w1_bl
+ u_t000_010/c1_r1_rbl u_t000_012/c2_r0_rbl u_t003_008/c1_w1_br u_t005_002/c2_w1_bl
+ u_t000_010/c2_w0_bl u_t002_002/c0_r0_rbl u_t003_007/c0_w0_br u_t003_004/c2_w1_bl
+ u_t001_003/c1_r1_rbl u_t002_004/c1_w1_br u_t014_009/c2_w0_bl u_t001_005/c2_r0_rbl
+ u_t030_013/c2_w0_bl u_t000_006/c3_r1_rbl u_t003_003/c1_w0_bl u_t001_009/c0_w0_br
+ u_t028_013/c2_w0_bl u_t001_006/c2_w1_bl u_t003_014/c0_w1_br u_t015_001/r3_w1_wl
+ u_t001_010/c3_r1_rbl u_t002_000/c2_w1_bl u_t002_003/c0_w0_br u_t002_007/r2_w1_wl
+ u_t000_006/c1_w1_br u_t003_001/r2_w1_wl u_t007_015/r3_w0_wl u_t015_010/c2_w1_bl
+ u_t003_013/c0_r1_rbl u_t001_005/c1_w0_bl u_t003_010/c1_w1_bl u_t003_015/c1_r0_rbl
+ u_t026_015/c2_w0_bl u_t002_006/c3_w0_br u_t031_009/c2_w1_bl u_t000_005/c0_w0_br
+ u_t003_000/c3_w0_br u_t003_002/c2_r0_rbl u_t000_002/c2_w1_bl u_t002_003/c3_r1_rbl
+ u_t029_009/c2_w1_bl u_t000_008/c3_w0_br u_t001_012/c1_w1_bl u_t000_001/c1_w0_bl
+ u_t025_011/c2_w0_bl u_t000_001/c0_r0_rbl u_t001_002/c3_w0_br u_t000_012/c0_w1_br
+ u_t030_005/c2_w1_bl u_t003_009/c2_r1_rbl u_t003_012/c3_w0_bl u_t001_006/r0_r0_rwl
+ u_t001_011/c0_w0_bl u_t028_005/c2_w1_bl u_t007_009/c2_w0_bl u_t000_007/r1_r1_rwl
+ u_t000_015/r1_w1_wl u_t023_013/c2_w0_bl u_t010_001/r3_w1_wl u_t000_008/c0_r1_rbl
+ u_t001_014/c3_w0_bl u_t008_001/r3_w1_wl u_t010_010/c2_w1_bl u_t026_007/c2_w1_bl
+ u_t000_014/c2_w0_br u_t002_015/r3_w0_wl u_t001_012/c0_r1_rbl u_t021_015/c2_w0_bl
+ u_t001_014/c1_r0_rbl u_t008_010/c2_w1_bl u_t001_001/c2_r0_rbl u_t002_007/c0_w1_bl
+ u_t003_008/c2_w1_br u_t019_015/c2_w0_bl u_t003_001/c0_w1_bl u_t024_009/c2_w1_bl
+ u_t000_002/c3_r1_rbl u_t000_010/c3_w0_bl u_t025_003/c2_w1_bl u_t002_006/r2_r0_rwl
+ u_t020_011/c2_w0_bl u_t002_005/c0_r1_rbl u_t000_009/c0_w1_bl u_t001_007/r3_r1_rwl
+ u_t003_007/c1_w0_br u_t002_007/c1_r0_rbl u_t003_004/c3_w1_bl u_t001_003/c0_w1_bl
+ u_t018_011/c2_w0_bl u_t002_004/c2_w1_br u_t001_008/c2_r1_rbl u_t003_011/c1_r0_rbl
+ u_t023_005/c2_w1_bl u_t002_009/c2_w0_bl u_t003_003/c2_w0_bl u_t001_009/c1_w0_br
+ u_t001_006/c3_w1_bl u_t003_014/c1_w1_br u_t002_000/c3_w1_bl u_t002_003/c1_w0_br
+ u_t016_013/c2_w0_bl u_t000_006/c2_w1_br u_t003_001/r3_w1_wl u_t021_007/c2_w1_bl
+ u_t001_000/c2_w1_br u_t001_005/c2_w0_bl u_t003_013/c0_w0_br u_t003_010/c2_w1_bl
+ u_t019_007/c2_w1_bl u_t002_006/r2_w0_wl u_t000_002/c3_w1_bl u_t000_005/c1_w0_br
+ u_t003_005/c2_r1_rbl u_t014_015/c2_w0_bl u_t025_015/r0_w0_wl u_t003_007/c3_r0_rbl
+ u_t001_002/r0_r0_rwl u_t001_003/r3_w1_wl u_t020_003/c2_w1_bl u_t000_003/r1_r1_rwl
+ u_t001_012/c2_w1_bl u_t001_015/c0_w0_br u_t017_009/c2_w1_bl u_t031_008/c2_w0_bl
+ u_t000_001/c2_w0_bl u_t000_004/c0_r1_rbl u_t018_003/c2_w1_bl u_t000_012/c1_w1_br
+ u_t000_006/c1_r0_rbl u_t013_011/c2_w0_bl u_t029_008/c2_w0_bl u_t001_010/c1_r0_rbl
+ u_t001_011/c1_w0_bl u_t000_011/c0_w0_br u_t000_011/c2_r1_rbl u_t016_005/c2_w1_bl
+ u_t000_013/c3_r0_rbl u_t011_013/c2_w0_bl u_t002_002/r2_r0_rwl u_t003_005/c0_w1_br
+ u_t000_014/c3_w0_br u_t009_013/c2_w0_bl u_t002_001/c0_r1_rbl u_t001_003/r3_r1_rwl
+ u_t002_003/c1_r0_rbl u_t014_007/c2_w1_bl u_t026_001/r0_w1_wl u_t001_004/c2_r1_rbl
+ u_t002_007/c1_w1_bl u_t020_015/r0_w0_wl u_t003_008/c3_w1_br u_t001_006/c3_r0_rbl
+ u_t001_007/c0_w1_br u_t003_001/c1_w1_bl u_t007_015/c2_w0_bl u_t018_015/r0_w0_wl
+ u_t002_001/c0_w1_br u_t012_009/c2_w1_bl u_t003_009/c0_r0_rbl u_t002_006/c0_w0_bl
+ u_t013_003/c2_w1_bl u_t000_009/c1_w1_bl u_t003_007/c2_w0_br u_t024_008/c2_w0_bl
+ u_t001_003/c1_w1_bl u_t002_004/c3_w1_br u_t000_003/c0_w1_br u_t003_014/c1_r1_rbl
+ u_t006_011/c2_w0_bl u_t000_008/c0_w0_bl u_t003_001/c2_r1_rbl u_t003_003/c3_w0_bl
+ u_t011_005/c2_w1_bl u_t001_009/c2_w0_br u_t003_003/c3_r0_rbl u_t001_002/c0_w0_bl
+ u_t003_014/c2_w1_br u_t002_003/c2_w0_br u_t000_006/c3_w1_br u_t009_005/c2_w1_bl
+ u_t000_006/r1_w1_wl u_t001_000/c3_w1_br u_t004_013/c2_w0_bl u_t000_015/c0_r0_rbl
+ u_t000_000/c0_r1_rbl u_t001_005/c3_w0_bl u_t003_013/c1_w0_br u_t000_002/c1_r0_rbl
+ u_t000_015/c0_w1_bl u_t003_010/c3_w1_bl u_t000_005/c2_w0_br u_t021_001/r0_w1_wl
+ u_t007_007/c2_w1_bl u_t025_015/r1_w0_wl u_t002_015/c2_w0_bl u_t019_001/r0_w1_wl
+ u_t013_015/r0_w0_wl u_t001_015/c1_w0_br u_t001_012/c3_w1_bl u_t001_008/c0_r0_rbl
+ u_t000_001/c3_w0_bl u_t000_012/c2_w1_br u_t005_009/c2_w1_bl u_t000_009/c1_r1_rbl
+ u_t006_003/c2_w1_bl u_t001_011/c2_w0_bl u_t001_013/c1_r1_rbl u_t017_008/c2_w0_bl
+ u_t000_011/c1_w0_br u_t001_000/c2_r1_rbl u_t001_002/c3_r0_rbl u_t004_005/c2_w1_bl
+ u_t003_005/c1_w1_br u_t003_005/c0_r0_rbl u_t031_014/c2_w0_bl u_t002_006/c1_r1_rbl
+ u_t026_001/r1_w1_wl u_t029_014/c2_w0_bl u_t002_007/c2_w1_bl u_t020_015/r1_w0_wl
+ u_t001_009/c3_r1_rbl u_t003_001/c2_w1_bl u_t003_004/c0_w0_br u_t003_010/c1_r1_rbl
+ u_t001_007/c1_w1_br u_t003_012/c2_r0_rbl u_t014_001/r0_w1_wl u_t018_015/r1_w0_wl
+ u_t002_001/c1_w1_br u_t030_010/c2_w0_bl u_t006_015/r0_w0_wl u_t002_006/c1_w0_bl
+ u_t000_009/c2_w1_bl u_t003_007/c3_w0_br u_t003_007/r1_w0_wl u_t028_010/c2_w0_bl
+ u_t001_006/c0_w0_br u_t000_011/c0_r0_rbl u_t001_003/c2_w1_bl u_t003_011/c0_w1_br
+ u_t002_000/c0_w0_br u_t002_004/r2_w1_wl u_t000_003/c1_w1_br u_t012_008/c2_w0_bl
+ u_t000_008/c1_w0_bl u_t001_009/c3_w0_br u_t001_002/c1_w0_bl u_t003_006/c3_r1_rbl
+ u_t003_014/c3_w1_br u_t026_012/c2_w0_bl u_t002_003/c3_w0_br u_t001_013/c0_w1_br
+ u_t000_002/c0_w0_br u_t031_006/c2_w1_bl u_t001_004/c0_r0_rbl u_t029_006/c2_w1_bl
+ u_t003_013/c2_w0_br u_t000_005/c1_r1_rbl u_t000_015/c1_w1_bl u_t000_005/c3_w0_br
+ u_t000_007/c2_r0_rbl u_t021_001/r1_w1_wl u_t024_014/c2_w0_bl u_t025_015/r2_w0_wl
+ u_t001_011/c2_r0_rbl u_t019_001/r1_w1_wl u_t030_002/c2_w1_bl u_t013_015/r1_w0_wl
+ u_t000_014/c0_w0_bl u_t027_008/c2_w1_bl u_t000_012/c3_r1_rbl u_t007_001/r0_w1_wl
+ u_t001_015/r0_w0_wl u_t028_002/c2_w1_bl u_t000_012/c3_w1_br u_t023_010/c2_w0_bl
+ u_t000_012/r1_w1_wl u_t003_001/c0_r0_rbl u_t003_008/c0_w1_bl u_t001_011/c3_w0_bl
+ u_t002_002/c1_r1_rbl u_t002_004/c2_r0_rbl u_t026_004/c2_w1_bl u_t000_011/c2_w0_br
+ u_t005_008/c2_w0_bl u_t021_012/c2_w0_bl u_t001_005/c3_r1_rbl u_t002_004/c0_w1_bl
+ u_t019_012/c2_w0_bl u_t003_005/c2_w1_br u_t003_008/c0_r1_rbl u_t024_006/c2_w1_bl
+ u_t026_001/r2_w1_wl u_t020_015/r2_w0_wl u_t003_004/c1_w0_br u_t000_006/c0_w1_bl
+ u_t003_001/c3_w1_bl u_t017_014/c2_w0_bl u_t001_007/c2_w1_br u_t014_001/r1_w1_wl
+ u_t001_007/r0_w1_wl u_t002_001/c2_w1_br u_t018_015/r2_w0_wl u_t022_008/c2_w1_bl
+ u_t002_001/r0_w1_wl u_t003_002/c3_r1_rbl u_t023_002/c2_w1_bl u_t002_006/c2_w0_bl
+ u_t006_015/r1_w0_wl u_t000_013/r1_r1_rwl u_t000_009/c3_w1_bl u_t003_000/c2_w0_bl
+ u_t001_003/c3_w1_bl u_t001_006/c1_w0_br u_t003_011/c1_w1_br u_t000_014/c0_r1_rbl
+ u_t001_000/c0_r0_rbl u_t016_010/c2_w0_bl u_t000_003/c2_w1_br u_t000_001/c1_r1_rbl
+ u_t000_003/c2_r0_rbl u_t021_004/c2_w1_bl u_t000_008/c2_w0_bl u_t001_002/c2_w0_bl
+ u_t003_010/c0_w0_br u_t019_004/c2_w1_bl u_t001_013/c1_w1_br u_t000_002/c1_w0_br
+ u_t002_003/r2_w0_wl u_t014_012/c2_w0_bl u_t001_007/c0_r1_rbl u_t001_009/c1_r0_rbl
+ u_t003_013/c3_w0_br u_t001_012/c0_w0_br u_t003_013/r1_w0_wl u_t017_006/c2_w1_bl
+ u_t021_001/r2_w1_wl u_t001_013/r3_r1_rwl u_t025_015/r3_w0_wl u_t012_014/c2_w0_bl
+ u_t002_000/c2_r0_rbl u_t019_001/r2_w1_wl u_t001_014/c2_r1_rbl u_t013_015/r2_w0_wl
+ u_t000_014/c1_w0_bl u_t001_001/c3_r1_rbl u_t007_001/r1_w1_wl u_t001_015/r1_w0_wl
+ u_t015_008/c2_w1_bl u_t016_002/c2_w1_bl u_t003_008/c1_w1_bl u_t003_004/c0_r1_rbl
+ u_t003_006/c1_r0_rbl u_t011_010/c2_w0_bl u_t003_002/c0_w1_br u_t000_011/c3_w0_br
+ u_t009_010/c2_w0_bl u_t003_007/c0_w0_bl u_t014_004/c2_w1_bl u_t003_011/c2_r1_rbl
+ u_t003_013/c3_r0_rbl u_t025_009/c2_w0_bl u_t002_004/c1_w1_bl u_t003_005/c3_w1_br
+ u_t001_004/c0_w1_br u_t007_012/c2_w0_bl u_t001_009/c0_w0_bl u_t012_006/c2_w1_bl
+ u_t000_010/c0_r1_rbl u_t003_014/c0_w1_bl u_t026_001/r3_w1_wl u_t000_012/c1_r0_rbl
+ u_t002_003/c0_w0_bl u_t020_015/r3_w0_wl u_t003_004/c2_w0_br u_t000_006/c1_w1_bl
+ u_t001_007/c3_w1_br u_t014_001/r2_w1_wl u_t002_001/c3_w1_br u_t018_015/r3_w0_wl
+ u_t026_010/c2_w1_bl u_t005_014/c2_w0_bl u_t000_000/c0_w1_br u_t002_001/r1_w1_wl
+ u_t002_006/c3_w0_bl u_t006_015/r2_w0_wl u_t010_008/c2_w1_bl u_t000_005/c0_w0_bl
+ u_t001_006/c2_w0_br u_t003_000/c3_w0_bl u_t011_002/c2_w1_bl u_t003_011/c2_w1_br
+ u_t001_003/c0_r1_rbl u_t001_006/r0_w0_wl u_t008_008/c2_w1_bl u_t002_000/c2_w0_br
+ u_t000_003/c3_w1_br u_t001_005/c1_r0_rbl u_t009_002/c2_w1_bl u_t000_003/r1_w1_wl
+ u_t000_006/c2_r1_rbl u_t000_008/c3_w0_bl u_t004_010/c2_w0_bl u_t000_008/c3_r0_rbl
+ u_t000_012/c0_w1_bl u_t001_002/c3_w0_bl u_t003_010/c1_w0_br u_t001_013/c2_w1_br
+ u_t001_010/c2_r1_rbl u_t000_002/c2_w0_br u_t001_012/c3_r0_rbl u_t020_009/c2_w0_bl
+ u_t007_004/c2_w1_bl u_t002_012/c2_w0_bl u_t018_009/c2_w0_bl u_t003_015/c0_r0_rbl
+ u_t001_012/c1_w0_br u_t003_000/c0_r1_rbl u_t021_001/r3_w1_wl u_t003_002/c1_r0_rbl
+ u_t005_006/c2_w1_bl u_t002_003/c2_r1_rbl u_t019_001/r3_w1_wl u_t021_010/c2_w1_bl
+ u_t013_015/r3_w0_wl u_t000_014/c2_w0_bl u_t002_005/c3_r0_rbl u_t007_001/r2_w1_wl
+ u_t001_015/r2_w0_wl u_t019_010/c2_w1_bl u_t003_008/c2_w1_bl u_t003_009/c1_r1_rbl
+ u_t004_002/c2_w1_bl u_t003_002/c1_w1_br u_t031_011/c2_w0_bl u_t003_007/c1_w0_bl
+ u_t029_011/c2_w0_bl u_t002_007/c0_w0_br u_t002_004/c2_w1_bl u_t003_001/c0_w0_br
+ u_t001_004/c1_w1_br u_t013_009/c2_w0_bl u_t001_014/c0_r0_rbl u_t001_009/c1_w0_bl
+ u_t003_014/c1_w1_bl u_t001_001/c1_r0_rbl u_t002_003/c1_w0_bl u_t027_013/c2_w0_bl
+ u_t000_015/c1_r1_rbl u_t000_009/c0_w0_br u_t003_004/c3_w0_br u_t000_006/c2_w1_bl
+ u_t001_003/c0_w0_br u_t003_004/r1_w0_wl u_t014_001/r3_w1_wl u_t000_002/c2_r1_rbl
+ u_t001_000/c2_w1_bl u_t000_004/c3_r0_rbl u_t002_001/r2_w1_wl u_t003_013/c0_w0_bl
+ u_t014_010/c2_w1_bl u_t006_015/r3_w0_wl u_t000_005/c1_w0_bl u_t001_006/c3_w0_br
+ u_t002_007/c0_r0_rbl u_t025_015/c2_w0_bl u_t003_011/c3_w1_br u_t030_009/c2_w1_bl
+ u_t001_010/c0_w1_br u_t002_000/c3_w0_br u_t001_008/c1_r1_rbl u_t003_011/c0_r0_rbl
+ u_t031_003/c2_w1_bl u_t001_015/c0_w0_bl u_t028_009/c2_w1_bl u_t029_003/c2_w1_bl
+ u_t000_012/c1_w1_bl u_t003_010/c2_w0_br u_t001_013/c3_w1_br u_t024_011/c2_w0_bl
+ u_t000_002/c3_w0_br u_t002_001/c3_r0_rbl u_t000_011/c0_w0_bl u_t027_005/c2_w1_bl
+ u_t001_012/c2_w0_br u_t006_009/c2_w0_bl u_t022_013/c2_w0_bl u_t003_005/c1_r1_rbl
+ u_t003_007/c2_r0_rbl u_t003_005/c0_w1_bl u_t000_014/c3_w0_bl u_t007_001/r3_w1_wl
+ u_t025_007/c2_w1_bl u_t001_015/r3_w0_wl u_t003_012/c3_r1_rbl u_t020_015/c2_w0_bl
+ u_t031_015/r0_w0_wl u_t000_006/c0_r0_rbl u_t007_010/c2_w1_bl u_t003_008/c3_w1_bl
+ u_t001_007/c0_w1_bl u_t018_015/c2_w0_bl u_t029_015/r0_w0_wl u_t001_010/c0_r0_rbl
+ u_t002_001/c0_w1_bl u_t003_002/c2_w1_br u_t023_009/c2_w1_bl u_t000_011/c1_r1_rbl
+ u_t024_003/c2_w1_bl u_t003_007/c2_w0_bl u_t000_013/c2_r0_rbl u_t000_000/c3_r0_rbl
+ u_t002_004/c3_w1_bl u_t002_007/c1_w0_br u_t003_001/c1_w0_br u_t000_003/c0_w1_bl
+ u_t017_011/c2_w0_bl u_t001_004/c2_w1_br u_t001_004/r0_w1_wl u_t022_005/c2_w1_bl
+ u_t001_009/c2_w0_bl u_t002_003/c0_r0_rbl u_t003_014/c2_w1_bl u_t002_003/c2_w0_bl
+ u_t000_006/c3_w1_bl u_t000_009/c1_w0_br u_t001_004/c1_r1_rbl u_t001_006/c2_r0_rbl
+ u_t001_003/c1_w0_br u_t001_000/c3_w1_bl u_t001_007/r3_w1_wl u_t015_013/c2_w0_bl
+ u_t000_007/c3_r1_rbl u_t000_000/c2_w1_br u_t002_001/r3_w1_wl u_t020_007/c2_w1_bl
+ u_t003_013/c1_w0_bl u_t000_005/c2_w0_bl u_t001_011/c3_r1_rbl u_t002_010/c2_w1_bl
+ u_t018_007/c2_w1_bl u_t001_010/c1_w1_br u_t013_015/c2_w0_bl u_t024_015/r0_w0_wl
+ u_t003_014/c0_r1_rbl u_t001_015/c1_w0_bl u_t003_001/c1_r1_rbl u_t000_015/c0_w0_br
+ u_t000_012/c2_w1_bl u_t003_003/c2_r0_rbl u_t003_010/c3_w0_br u_t016_009/c2_w1_bl
+ u_t003_010/r1_w0_wl u_t030_008/c2_w0_bl u_t017_003/c2_w1_bl u_t002_004/c3_r1_rbl
+ u_t012_011/c2_w0_bl u_t028_008/c2_w0_bl u_t003_009/c0_w1_br u_t000_002/c0_r0_rbl
+ u_t000_011/c1_w0_bl u_t001_012/c3_w0_br u_t015_005/c2_w1_bl u_t010_013/c2_w0_bl
+ u_t001_007/r0_r0_rwl u_t003_005/c1_w1_bl u_t002_005/c0_w1_br u_t000_008/r1_r1_rwl
+ u_t008_013/c2_w0_bl u_t013_007/c2_w1_bl u_t031_015/r1_w0_wl u_t000_009/c0_r1_rbl
+ u_t003_004/c0_w0_bl u_t025_001/r0_w1_wl u_t001_007/c1_w1_bl u_t029_015/r1_w0_wl
+ u_t002_001/c1_w1_bl u_t000_007/c0_w1_br u_t001_013/c0_r1_rbl u_t003_002/c3_w1_br
+ u_t001_015/c1_r0_rbl u_t006_015/c2_w0_bl u_t001_001/c0_w1_br u_t017_015/r0_w0_wl
+ u_t003_007/c3_w0_bl u_t011_009/c2_w1_bl u_t001_002/c2_r0_rbl u_t001_006/c0_w0_bl
+ u_t003_011/c0_w1_bl u_t012_003/c2_w1_bl u_t000_003/c3_r1_rbl u_t009_009/c2_w1_bl
+ u_t000_003/c1_w1_bl u_t003_001/c2_w0_br u_t023_008/c2_w0_bl u_t001_004/c3_w1_br
+ u_t002_007/r2_r0_rwl u_t001_009/c3_w0_bl u_t002_006/c0_r1_rbl u_t005_011/c2_w0_bl
+ u_t001_008/r3_r1_rwl u_t003_014/c3_w1_bl u_t001_013/c0_w1_bl u_t002_003/c3_w0_bl
+ u_t010_005/c2_w1_bl u_t000_009/c2_w0_br u_t000_002/c0_w0_bl u_t003_010/c0_r1_rbl
+ u_t001_003/c2_w0_br u_t001_009/c2_r1_rbl u_t003_012/c1_r0_rbl u_t001_003/r0_w0_wl
+ u_t008_005/c2_w1_bl u_t000_000/c3_w1_br u_t003_013/c2_w0_bl u_t000_005/c3_w0_bl
+ u_t002_000/c3_r1_rbl u_t020_001/r0_w1_wl u_t001_010/c2_w1_br u_t006_007/c2_w1_bl
+ u_t024_015/r1_w0_wl u_t001_015/c2_w0_bl u_t018_001/r0_w1_wl u_t012_015/r0_w0_wl
+ u_t000_015/c1_w0_br u_t000_012/c3_w1_bl u_t003_006/c2_r1_rbl u_t003_008/c3_r0_rbl
+ u_t001_003/r0_r0_rwl u_t001_013/r3_w1_wl u_t004_009/c2_w1_bl u_t000_004/r1_r1_rwl
+ u_t005_003/c2_w1_bl u_t003_009/c1_w1_br u_t000_011/c2_w0_bl u_t016_008/c2_w0_bl
+ u_t000_005/c0_r1_rbl u_t000_007/c1_r0_rbl u_t003_005/c2_w1_bl u_t003_008/c0_w0_br
+ u_t001_011/c1_r0_rbl u_t000_012/c2_r1_rbl u_t002_005/c1_w1_br u_t030_014/c2_w0_bl
+ u_t000_014/c3_r0_rbl u_t031_015/r2_w0_wl u_t003_004/c1_w0_bl u_t028_014/c2_w0_bl
+ u_t025_001/r1_w1_wl u_t001_007/c2_w1_bl u_t002_003/r2_r0_rwl u_t003_015/c0_w1_br
+ u_t002_004/c0_w0_br u_t029_015/r2_w0_wl u_t002_001/c2_w1_bl u_t002_002/c0_r1_rbl
+ u_t000_007/c1_w1_br u_t001_004/r3_r1_rwl u_t013_001/r0_w1_wl u_t002_004/c1_r0_rbl
+ u_t001_001/c1_w1_br u_t017_015/r1_w0_wl u_t001_005/c2_r1_rbl u_t001_006/c1_w0_bl
+ u_t001_007/c3_r0_rbl u_t005_015/r0_w0_wl u_t003_011/c1_w1_bl u_t000_006/c0_w0_br
+ u_t027_010/c2_w0_bl u_t000_003/c2_w1_bl u_t003_001/c3_w0_br u_t001_000/c0_w0_br
+ u_t003_001/r1_w0_wl u_t011_008/c2_w0_bl u_t003_010/c0_w0_bl u_t000_009/c3_w0_br
+ u_t001_013/c1_w1_bl u_t009_008/c2_w0_bl u_t000_002/c1_w0_bl u_t025_012/c2_w0_bl
+ u_t000_013/c0_w1_br u_t001_003/c3_w0_br u_t003_015/c1_r1_rbl u_t030_006/c2_w1_bl
+ u_t003_002/c2_r1_rbl u_t003_013/c3_w0_bl u_t003_004/c3_r0_rbl u_t001_012/c0_w0_bl
+ u_t028_006/c2_w1_bl u_t023_014/c2_w0_bl u_t020_001/r1_w1_wl u_t001_010/c3_w1_br
+ u_t024_015/r2_w0_wl u_t000_001/c0_r1_rbl u_t018_001/r1_w1_wl u_t000_003/c1_r0_rbl
+ u_t012_015/r1_w0_wl u_t026_008/c2_w1_bl u_t006_001/r0_w1_wl u_t000_015/r0_w0_wl
+ u_t027_002/c2_w1_bl u_t022_010/c2_w0_bl u_t000_010/c3_r0_rbl u_t003_009/c2_w1_br
+ u_t003_002/c0_w1_bl u_t001_009/c0_r0_rbl u_t000_011/c3_w0_bl u_t025_004/c2_w1_bl
+ u_t004_008/c2_w0_bl u_t020_012/c2_w0_bl u_t003_005/c3_w1_bl u_t003_008/c1_w0_br
+ u_t001_014/c1_r1_rbl u_t001_004/c0_w1_bl u_t018_012/c2_w0_bl u_t001_001/c2_r1_rbl
+ u_t002_005/c2_w1_br u_t001_003/c3_r0_rbl u_t023_006/c2_w1_bl u_t031_015/r3_w0_wl
+ u_t003_004/c2_w0_bl u_t001_007/c3_w1_bl u_t025_001/r2_w1_wl u_t003_006/c0_r0_rbl
+ u_t003_015/c1_w1_br u_t002_004/c1_w0_br u_t029_015/r3_w0_wl u_t002_001/c3_w1_bl
+ u_t016_014/c2_w0_bl u_t000_007/c2_w1_br u_t013_001/r1_w1_wl u_t002_007/c1_r1_rbl
+ u_t001_001/c2_w1_br u_t017_015/r2_w0_wl u_t021_008/c2_w1_bl u_t001_001/r0_w1_wl
+ u_t022_002/c2_w1_bl u_t001_006/c2_w0_bl u_t003_014/c0_w0_br u_t005_015/r1_w0_wl
+ u_t003_011/c1_r1_rbl u_t003_011/c2_w1_bl u_t019_008/c2_w1_bl u_t003_013/c2_r0_rbl
+ u_t000_006/c1_w0_br u_t002_000/c2_w0_bl u_t002_007/r2_w0_wl u_t000_003/c3_w1_bl
+ u_t003_000/c3_r0_rbl u_t001_004/r3_w1_wl u_t015_010/c2_w0_bl u_t020_004/c2_w1_bl
+ u_t003_010/c1_w0_bl u_t001_013/c2_w1_bl u_t000_012/c0_r0_rbl u_t031_009/c2_w0_bl
+ u_t000_002/c2_w0_bl u_t000_013/c1_w1_br u_t018_004/c2_w1_bl u_t013_012/c2_w0_bl
+ u_t029_009/c2_w0_bl u_t003_007/c3_r1_rbl u_t001_012/c1_w0_bl u_t000_012/c0_w0_br
+ u_t016_006/c2_w1_bl u_t020_001/r2_w1_wl u_t001_005/c0_r0_rbl u_t024_015/r3_w0_wl
+ u_t011_014/c2_w0_bl u_t018_001/r2_w1_wl u_t000_006/c1_r1_rbl u_t012_015/r2_w0_wl
+ u_t003_006/c0_w1_br u_t000_008/c2_r0_rbl u_t009_014/c2_w0_bl u_t006_001/r1_w1_wl
+ u_t000_015/r1_w0_wl u_t001_010/c1_r1_rbl u_t014_008/c2_w1_bl u_t001_012/c2_r0_rbl
+ u_t015_002/c2_w1_bl u_t003_009/c3_w1_br u_t000_013/c3_r1_rbl u_t003_002/c1_w1_bl
+ u_t010_010/c2_w0_bl u_t001_008/c0_w1_br u_t002_002/c0_w1_br u_t008_010/c2_w0_bl
+ u_t003_002/c0_r0_rbl u_t002_007/c0_w0_bl u_t003_008/c2_w0_br u_t013_004/c2_w1_bl
+ u_t002_003/c1_r1_rbl u_t003_001/c0_w0_bl u_t001_004/c1_w1_bl u_t002_005/c2_r0_rbl
+ u_t024_009/c2_w0_bl u_t002_005/c3_w1_br u_t000_004/c0_w1_br u_t001_006/c3_r1_rbl
+ u_t006_012/c2_w0_bl u_t000_009/c0_w0_bl u_t003_004/c3_w0_bl u_t011_006/c2_w1_bl
+ u_t025_001/r3_w1_wl u_t001_003/c0_w0_bl u_t002_004/c2_w0_br u_t003_009/c0_r1_rbl
+ u_t000_007/c3_w1_br u_t009_006/c2_w1_bl u_t013_001/r2_w1_wl u_t000_007/r1_w1_wl
+ u_t025_010/c2_w1_bl u_t001_001/c3_w1_br u_t017_015/r3_w0_wl u_t004_014/c2_w0_bl
+ u_t001_001/r1_w1_wl u_t001_006/c3_w0_bl u_t003_014/c1_w0_br u_t005_015/r2_w0_wl
+ u_t003_011/c3_w1_bl u_t010_002/c2_w1_bl u_t000_006/c2_w0_br u_t001_010/c0_w1_bl
+ u_t002_000/c3_w0_bl u_t007_008/c2_w1_bl u_t001_000/c2_w0_br u_t003_003/c3_r1_rbl
+ u_t008_002/c2_w1_bl u_t000_014/r1_r1_rwl u_t003_010/c2_w0_bl u_t001_013/c3_w1_bl
+ u_t000_015/c0_r1_rbl u_t001_001/c0_r0_rbl u_t000_002/c3_w0_bl u_t000_013/c2_w1_br
+ u_t000_002/c1_r1_rbl u_t000_004/c2_r0_rbl u_t006_004/c2_w1_bl u_t001_012/c2_w0_bl
+ u_t017_009/c2_w0_bl u_t000_012/c1_w0_br u_t020_001/r3_w1_wl u_t001_010/r3_w1_wl
+ u_t001_008/c0_r1_rbl u_t004_006/c2_w1_bl u_t018_001/r3_w1_wl u_t020_010/c2_w1_bl
+ u_t012_015/r3_w0_wl u_t003_006/c1_w1_br u_t031_015/c2_w0_bl u_t000_015/r2_w0_wl
+ u_t001_014/r3_r1_rwl u_t006_001/r2_w1_wl u_t018_010/c2_w1_bl u_t002_001/c2_r0_rbl
+ u_t029_015/c2_w0_bl u_t002_008/c2_w1_bl u_t003_005/c0_w0_br u_t001_002/c3_r1_rbl
+ u_t003_002/c2_w1_bl u_t001_008/c1_w1_br u_t002_002/c1_w1_br u_t030_011/c2_w0_bl
+ u_t003_005/c0_r1_rbl u_t002_007/c1_w0_bl u_t003_007/c1_r0_rbl u_t003_008/c3_w0_br
+ u_t001_007/c0_w0_br u_t003_001/c1_w0_bl u_t003_008/r1_w0_wl u_t028_011/c2_w0_bl
+ u_t001_004/c2_w1_bl u_t003_012/c0_w1_br u_t002_001/c0_w0_br u_t000_004/c1_w1_br
+ u_t002_005/r2_w1_wl u_t012_009/c2_w0_bl u_t003_012/c2_r1_rbl u_t000_009/c1_w0_bl
+ u_t003_014/c3_r0_rbl u_t001_003/c1_w0_bl u_t026_013/c2_w0_bl VSUBS u_t001_014/c0_w1_br
+ u_t002_004/c3_w0_br u_t000_010/r1_r1_rwl u_t000_003/c0_w0_br u_t013_001/r3_w1_wl
+ u_t031_007/c2_w1_bl u_t000_000/c2_w1_bl u_t000_011/c0_r1_rbl u_t001_001/r2_w1_wl
+ u_t000_013/c1_r0_rbl u_t005_015/r3_w0_wl u_t013_010/c2_w1_bl u_t029_007/c2_w1_bl
+ u_t003_014/c2_w0_br u_t000_000/c2_r0_rbl u_t024_015/c2_w0_bl u_t000_006/c3_w0_br
+ u_t001_010/c1_w1_bl u_t000_010/c0_w1_br u_t001_000/c3_w0_br u_t030_003/c2_w1_bl
+ u_t000_015/c0_w0_bl u_t027_009/c2_w1_bl u_t003_010/c3_w0_bl u_t001_004/c0_r1_rbl
+ u_t028_003/c2_w1_bl
Xgf180mcu_as_sc_mcu7t3v3__inv_2_1588 VSS VSS VSS gf180mcu_as_sc_mcu7t3v3__inv_2_1588/A
+ gf180mcu_as_sc_mcu7t3v3__inv_2_1588/VNW VSUBS gf180mcu_as_sc_mcu7t3v3__inv_2
Xgf180mcu_as_sc_mcu7t3v3__inv_2_1566 VSS VSS gf180mcu_as_sc_mcu7t3v3__inv_2_1588/A
+ gf180mcu_as_sc_mcu7t3v3__inv_2_1567/Y gf180mcu_as_sc_mcu7t3v3__inv_2_1588/VNW VSUBS
+ gf180mcu_as_sc_mcu7t3v3__inv_2
Xgf180mcu_as_sc_mcu7t3v3__inv_2_1577 VSS VSS VSS gf180mcu_as_sc_mcu7t3v3__inv_2_1578/Y
+ gf180mcu_as_sc_mcu7t3v3__inv_2_1579/VNW VSUBS gf180mcu_as_sc_mcu7t3v3__inv_2
Xgf180mcu_as_sc_mcu7t3v3__inv_2_1599 VSS VSS VSS gf180mcu_as_sc_mcu7t3v3__inv_2_1600/Y
+ gf180mcu_as_sc_mcu7t3v3__inv_2_1601/VNW VSUBS gf180mcu_as_sc_mcu7t3v3__inv_2
Xgf180mcu_as_sc_mcu7t3v3__inv_2_1555 VSS VSS gf180mcu_as_sc_mcu7t3v3__inv_2_1555/Y
+ gf180mcu_as_sc_mcu7t3v3__inv_2_1556/Y gf180mcu_as_sc_mcu7t3v3__inv_2_1556/VNW VSUBS
+ gf180mcu_as_sc_mcu7t3v3__inv_2
Xgf180mcu_as_sc_mcu7t3v3__nand4_2_338 VSS VSS VSS VSS VSS VSS gf180mcu_as_sc_mcu7t3v3__inv_2_1139/A
+ gf180mcu_as_sc_mcu7t3v3__inv_2_1139/VNW VSUBS gf180mcu_as_sc_mcu7t3v3__nand4_2
Xgf180mcu_as_sc_mcu7t3v3__nand4_2_349 VSS VSS VSS VSS VSS VSS gf180mcu_as_sc_mcu7t3v3__inv_2_1157/A
+ gf180mcu_as_sc_mcu7t3v3__inv_2_1290/VNW VSUBS gf180mcu_as_sc_mcu7t3v3__nand4_2
Xgf180mcu_as_sc_mcu7t3v3__nand4_2_327 VSS VSS VSS VSS VSS VSS gf180mcu_as_sc_mcu7t3v3__inv_2_1103/A
+ gf180mcu_as_sc_mcu7t3v3__inv_2_1103/VNW VSUBS gf180mcu_as_sc_mcu7t3v3__nand4_2
Xgf180mcu_as_sc_mcu7t3v3__nand4_2_316 VSS VSS VSS VSS VSS VSS gf180mcu_as_sc_mcu7t3v3__inv_2_1021/A
+ gf180mcu_as_sc_mcu7t3v3__inv_2_1057/VNW VSUBS gf180mcu_as_sc_mcu7t3v3__nand4_2
Xgf180mcu_as_sc_mcu7t3v3__nand4_2_305 VSS VSS VSS VSS VSS VSS gf180mcu_as_sc_mcu7t3v3__inv_2_1044/A
+ gf180mcu_as_sc_mcu7t3v3__inv_2_1044/VNW VSUBS gf180mcu_as_sc_mcu7t3v3__nand4_2
Xu_t029_015 u_t029_015/c0_w0_bl u_t029_015/c0_w0_br u_t029_015/c0_w1_bl u_t029_015/c0_w1_br
+ u_t029_015/c0_r0_rbl u_t029_015/c0_r1_rbl u_t029_015/c1_w0_bl u_t029_015/c1_w0_br
+ u_t029_015/c1_w1_bl u_t029_015/c1_w1_br u_t029_015/c1_r0_rbl u_t029_015/c1_r1_rbl
+ u_t029_015/c2_w0_bl u_t029_015/c2_w0_br u_t029_015/c2_w1_bl u_t029_015/c2_w1_br
+ u_t029_015/c2_r0_rbl u_t029_015/c2_r1_rbl u_t029_015/c3_w0_bl u_t029_015/c3_w0_br
+ u_t029_015/c3_w1_bl u_t029_015/c3_w1_br u_t029_015/c3_r0_rbl u_t029_015/c3_r1_rbl
+ u_t029_015/r0_w0_wl u_t029_015/r0_w1_wl u_t029_015/r0_r0_rwl u_t029_015/r0_r1_rwl
+ u_t029_015/r1_w0_wl u_t029_015/r1_w1_wl u_t029_015/r1_r0_rwl u_t029_015/r1_r1_rwl
+ u_t029_015/r2_w0_wl u_t029_015/r2_w1_wl u_t029_015/r2_r0_rwl u_t029_015/r2_r1_rwl
+ u_t029_015/r3_w0_wl u_t029_015/r3_w1_wl u_t029_015/r3_r0_rwl u_t029_015/r3_r1_rwl
+ VSS VSS u_t029_015/m2_717_1265# u_t029_015/m2_603_2031# u_t029_015/m2_1290_336#
+ u_t029_015/m2_2000_2037# u_t029_015/m2_791_2909# u_t029_015/m2_7_2126# u_t029_015/m2_2154_2081#
+ u_t029_015/m2_1795_2037# u_t029_015/m2_871_303# u_t029_015/m2_431_438# u_t029_015/m2_1290_2898#
+ u_t029_015/m2_1714_1210# u_t029_015/m2_431_1982# u_t029_015/m2_512_1265# u_t029_015/m2_2573_2126#
+ u_t029_015/m2_603_1259# u_t029_015/m2_2074_2909# u_t029_015/m2_7_336# u_t029_015/m2_717_2037#
+ u_t029_015/m2_1886_2031# u_t029_015/m2_2573_336# u_t029_015/m2_7_2898# u_t029_015/m2_2000_1265#
+ u_t029_015/m2_512_2037# u_t029_015/m2_1795_1265# u_t029_015/m2_1714_1982# u_t029_015/m2_1886_1259#
+ u_t029_015/m2_1290_2126# u_t029_015/m2_1714_438# u_t029_015/m2_431_1210# u_t029_015/m2_2573_2898#
+ u_t029_015/m2_2154_303# u_t029_015/m2_871_2081# VSUBS detronyx_12t_2w2r_rc4_4x4_routed_5layer_direct
Xu_t029_004 u_t029_004/c0_w0_bl u_t029_004/c0_w0_br u_t029_004/c0_w1_bl u_t029_004/c0_w1_br
+ u_t029_004/c0_r0_rbl u_t029_004/c0_r1_rbl u_t029_004/c1_w0_bl u_t029_004/c1_w0_br
+ u_t029_004/c1_w1_bl u_t029_004/c1_w1_br u_t029_004/c1_r0_rbl u_t029_004/c1_r1_rbl
+ u_t029_004/c2_w0_bl u_t029_004/c2_w0_br u_t029_004/c2_w1_bl u_t029_004/c2_w1_br
+ u_t029_004/c2_r0_rbl u_t029_004/c2_r1_rbl u_t029_004/c3_w0_bl u_t029_004/c3_w0_br
+ u_t029_004/c3_w1_bl u_t029_004/c3_w1_br u_t029_004/c3_r0_rbl u_t029_004/c3_r1_rbl
+ u_t029_004/r0_w0_wl u_t029_004/r0_w1_wl u_t029_004/r0_r0_rwl u_t029_004/r0_r1_rwl
+ u_t029_004/r1_w0_wl u_t029_004/r1_w1_wl u_t029_004/r1_r0_rwl u_t029_004/r1_r1_rwl
+ u_t029_004/r2_w0_wl u_t029_004/r2_w1_wl u_t029_004/r2_r0_rwl u_t029_004/r2_r1_rwl
+ u_t029_004/r3_w0_wl u_t029_004/r3_w1_wl u_t029_004/r3_r0_rwl u_t029_004/r3_r1_rwl
+ VSS VSS u_t029_004/m2_717_1265# u_t029_004/m2_603_2031# u_t029_004/m2_1290_336#
+ u_t029_004/m2_2000_2037# u_t029_004/m2_791_2909# u_t029_004/m2_7_2126# u_t029_004/m2_2154_2081#
+ u_t029_004/m2_1795_2037# u_t029_004/m2_871_303# u_t029_004/m2_431_438# u_t029_004/m2_1290_2898#
+ u_t029_004/m2_1714_1210# u_t029_004/m2_431_1982# u_t029_004/m2_512_1265# u_t029_004/m2_2573_2126#
+ u_t029_004/m2_603_1259# u_t029_004/m2_2074_2909# u_t029_004/m2_7_336# u_t029_004/m2_717_2037#
+ u_t029_004/m2_1886_2031# u_t029_004/m2_2573_336# u_t029_004/m2_7_2898# u_t029_004/m2_2000_1265#
+ u_t029_004/m2_512_2037# u_t029_004/m2_1795_1265# u_t029_004/m2_1714_1982# u_t029_004/m2_1886_1259#
+ u_t029_004/m2_1290_2126# u_t029_004/m2_1714_438# u_t029_004/m2_431_1210# u_t029_004/m2_2573_2898#
+ u_t029_004/m2_2154_303# u_t029_004/m2_871_2081# VSUBS detronyx_12t_2w2r_rc4_4x4_routed_5layer_direct
Xgf180mcu_as_sc_mcu7t3v3__inv_2_1374 VSS VSS gf180mcu_as_sc_mcu7t3v3__inv_2_1374/Y
+ gf180mcu_as_sc_mcu7t3v3__inv_2_1374/A gf180mcu_as_sc_mcu7t3v3__inv_2_1374/VNW VSUBS
+ gf180mcu_as_sc_mcu7t3v3__inv_2
Xgf180mcu_as_sc_mcu7t3v3__inv_2_1385 VSS VSS gf180mcu_as_sc_mcu7t3v3__inv_2_1385/Y
+ gf180mcu_as_sc_mcu7t3v3__inv_2_1386/Y gf180mcu_as_sc_mcu7t3v3__inv_2_1386/VNW VSUBS
+ gf180mcu_as_sc_mcu7t3v3__inv_2
Xgf180mcu_as_sc_mcu7t3v3__inv_2_1396 VSS VSS VSS gf180mcu_as_sc_mcu7t3v3__inv_2_1397/Y
+ gf180mcu_as_sc_mcu7t3v3__inv_2_1398/VNW VSUBS gf180mcu_as_sc_mcu7t3v3__inv_2
Xgf180mcu_as_sc_mcu7t3v3__inv_2_1363 VSS VSS gf180mcu_as_sc_mcu7t3v3__inv_2_1403/A
+ gf180mcu_as_sc_mcu7t3v3__inv_2_1363/A gf180mcu_as_sc_mcu7t3v3__inv_2_1403/VNW VSUBS
+ gf180mcu_as_sc_mcu7t3v3__inv_2
Xgf180mcu_as_sc_mcu7t3v3__inv_2_1341 VSS VSS VSS gf180mcu_as_sc_mcu7t3v3__inv_2_1345/Y
+ gf180mcu_as_sc_mcu7t3v3__inv_2_1349/VNW VSUBS gf180mcu_as_sc_mcu7t3v3__inv_2
Xgf180mcu_as_sc_mcu7t3v3__inv_2_1352 VSS VSS gf180mcu_as_sc_mcu7t3v3__inv_2_1352/Y
+ gf180mcu_as_sc_mcu7t3v3__inv_2_1352/A gf180mcu_as_sc_mcu7t3v3__inv_2_1352/VNW VSUBS
+ gf180mcu_as_sc_mcu7t3v3__inv_2
Xgf180mcu_as_sc_mcu7t3v3__inv_2_1330 VSS VSS VSS gf180mcu_as_sc_mcu7t3v3__inv_2_1331/Y
+ gf180mcu_as_sc_mcu7t3v3__inv_2_1332/VNW VSUBS gf180mcu_as_sc_mcu7t3v3__inv_2
Xgf180mcu_as_sc_mcu7t3v3__inv_2_825 VSS VSS VSS gf180mcu_as_sc_mcu7t3v3__inv_2_825/A
+ gf180mcu_as_sc_mcu7t3v3__inv_2_825/VNW VSUBS gf180mcu_as_sc_mcu7t3v3__inv_2
Xgf180mcu_as_sc_mcu7t3v3__inv_2_836 VSS VSS VSS gf180mcu_as_sc_mcu7t3v3__inv_2_836/A
+ gf180mcu_as_sc_mcu7t3v3__inv_2_836/VNW VSUBS gf180mcu_as_sc_mcu7t3v3__inv_2
Xgf180mcu_as_sc_mcu7t3v3__inv_2_814 VSS VSS gf180mcu_as_sc_mcu7t3v3__inv_2_814/Y gf180mcu_as_sc_mcu7t3v3__inv_2_814/A
+ gf180mcu_as_sc_mcu7t3v3__inv_2_841/VNW VSUBS gf180mcu_as_sc_mcu7t3v3__inv_2
Xgf180mcu_as_sc_mcu7t3v3__inv_2_803 VSS VSS gf180mcu_as_sc_mcu7t3v3__inv_2_803/Y gf180mcu_as_sc_mcu7t3v3__inv_2_803/A
+ gf180mcu_as_sc_mcu7t3v3__inv_2_837/VNW VSUBS gf180mcu_as_sc_mcu7t3v3__inv_2
Xgf180mcu_as_sc_mcu7t3v3__inv_2_847 VSS VSS VSS gf180mcu_as_sc_mcu7t3v3__inv_2_847/A
+ gf180mcu_as_sc_mcu7t3v3__inv_2_847/VNW VSUBS gf180mcu_as_sc_mcu7t3v3__inv_2
Xgf180mcu_as_sc_mcu7t3v3__inv_2_869 VSS VSS gf180mcu_as_sc_mcu7t3v3__inv_2_940/A gf180mcu_as_sc_mcu7t3v3__inv_2_872/Y
+ gf180mcu_as_sc_mcu7t3v3__inv_2_940/VNW VSUBS gf180mcu_as_sc_mcu7t3v3__inv_2
Xgf180mcu_as_sc_mcu7t3v3__inv_2_858 VSS VSS gf180mcu_as_sc_mcu7t3v3__inv_2_889/A gf180mcu_as_sc_mcu7t3v3__inv_2_858/A
+ gf180mcu_as_sc_mcu7t3v3__inv_2_936/VNW VSUBS gf180mcu_as_sc_mcu7t3v3__inv_2
Xgf180mcu_as_sc_mcu7t3v3__nand4_2_146 VSS VSS VSS VSS VSS VSS gf180mcu_as_sc_mcu7t3v3__inv_2_514/A
+ gf180mcu_as_sc_mcu7t3v3__inv_2_558/VNW VSUBS gf180mcu_as_sc_mcu7t3v3__nand4_2
Xgf180mcu_as_sc_mcu7t3v3__nand4_2_157 VSS VSS VSS VSS VSS VSS gf180mcu_as_sc_mcu7t3v3__inv_2_570/A
+ gf180mcu_as_sc_mcu7t3v3__inv_2_570/VNW VSUBS gf180mcu_as_sc_mcu7t3v3__nand4_2
Xgf180mcu_as_sc_mcu7t3v3__nand4_2_124 VSS VSS VSS VSS VSS VSS gf180mcu_as_sc_mcu7t3v3__inv_2_440/A
+ gf180mcu_as_sc_mcu7t3v3__inv_2_551/VNW VSUBS gf180mcu_as_sc_mcu7t3v3__nand4_2
Xgf180mcu_as_sc_mcu7t3v3__nand4_2_168 VSS VSS VSS VSS VSS VSS gf180mcu_as_sc_mcu7t3v3__inv_2_594/A
+ gf180mcu_as_sc_mcu7t3v3__inv_2_638/VNW VSUBS gf180mcu_as_sc_mcu7t3v3__nand4_2
Xgf180mcu_as_sc_mcu7t3v3__nand4_2_135 VSS VSS VSS VSS VSS VSS gf180mcu_as_sc_mcu7t3v3__inv_2_518/A
+ gf180mcu_as_sc_mcu7t3v3__inv_2_562/VNW VSUBS gf180mcu_as_sc_mcu7t3v3__nand4_2
Xgf180mcu_as_sc_mcu7t3v3__nand4_2_179 VSS VSS VSS VSS VSS VSS gf180mcu_as_sc_mcu7t3v3__inv_2_646/A
+ gf180mcu_as_sc_mcu7t3v3__inv_2_646/VNW VSUBS gf180mcu_as_sc_mcu7t3v3__nand4_2
Xgf180mcu_as_sc_mcu7t3v3__nand4_2_113 VSS VSS VSS VSS VSS VSS gf180mcu_as_sc_mcu7t3v3__inv_2_274/A
+ gf180mcu_as_sc_mcu7t3v3__inv_2_274/VNW VSUBS gf180mcu_as_sc_mcu7t3v3__nand4_2
Xgf180mcu_as_sc_mcu7t3v3__nand4_2_102 VSS VSS VSS VSS VSS VSS gf180mcu_as_sc_mcu7t3v3__inv_2_359/A
+ gf180mcu_as_sc_mcu7t3v3__inv_2_359/VNW VSUBS gf180mcu_as_sc_mcu7t3v3__nand4_2
Xu_t026_007 u_t026_007/c0_w0_bl u_t026_007/c0_w0_br u_t026_007/c0_w1_bl u_t026_007/c0_w1_br
+ u_t026_007/c0_r0_rbl u_t026_007/c0_r1_rbl u_t026_007/c1_w0_bl u_t026_007/c1_w0_br
+ u_t026_007/c1_w1_bl u_t026_007/c1_w1_br u_t026_007/c1_r0_rbl u_t026_007/c1_r1_rbl
+ u_t026_007/c2_w0_bl u_t026_007/c2_w0_br u_t026_007/c2_w1_bl u_t026_007/c2_w1_br
+ u_t026_007/c2_r0_rbl u_t026_007/c2_r1_rbl u_t026_007/c3_w0_bl u_t026_007/c3_w0_br
+ u_t026_007/c3_w1_bl u_t026_007/c3_w1_br u_t026_007/c3_r0_rbl u_t026_007/c3_r1_rbl
+ u_t026_007/r0_w0_wl u_t026_007/r0_w1_wl u_t026_007/r0_r0_rwl u_t026_007/r0_r1_rwl
+ u_t026_007/r1_w0_wl u_t026_007/r1_w1_wl u_t026_007/r1_r0_rwl u_t026_007/r1_r1_rwl
+ u_t026_007/r2_w0_wl u_t026_007/r2_w1_wl u_t026_007/r2_r0_rwl u_t026_007/r2_r1_rwl
+ u_t026_007/r3_w0_wl u_t026_007/r3_w1_wl u_t026_007/r3_r0_rwl u_t026_007/r3_r1_rwl
+ VSS VSS u_t026_007/m2_717_1265# u_t026_007/m2_603_2031# u_t026_007/m2_1290_336#
+ u_t026_007/m2_2000_2037# u_t026_007/m2_791_2909# u_t026_007/m2_7_2126# u_t026_007/m2_2154_2081#
+ u_t026_007/m2_1795_2037# u_t026_007/m2_871_303# u_t026_007/m2_431_438# u_t026_007/m2_1290_2898#
+ u_t026_007/m2_1714_1210# u_t026_007/m2_431_1982# u_t026_007/m2_512_1265# u_t026_007/m2_2573_2126#
+ u_t026_007/m2_603_1259# u_t026_007/m2_2074_2909# u_t026_007/m2_7_336# u_t026_007/m2_717_2037#
+ u_t026_007/m2_1886_2031# u_t026_007/m2_2573_336# u_t026_007/m2_7_2898# u_t026_007/m2_2000_1265#
+ u_t026_007/m2_512_2037# u_t026_007/m2_1795_1265# u_t026_007/m2_1714_1982# u_t026_007/m2_1886_1259#
+ u_t026_007/m2_1290_2126# u_t026_007/m2_1714_438# u_t026_007/m2_431_1210# u_t026_007/m2_2573_2898#
+ u_t026_007/m2_2154_303# u_t026_007/m2_871_2081# VSUBS detronyx_12t_2w2r_rc4_4x4_routed_5layer_direct
Xgf180mcu_as_sc_mcu7t3v3__nand4_2_63 VSS VSS VSS VSS VSS VSS gf180mcu_as_sc_mcu7t3v3__inv_2_8/A
+ gf180mcu_as_sc_mcu7t3v3__inv_2_8/VNW VSUBS gf180mcu_as_sc_mcu7t3v3__nand4_2
Xgf180mcu_as_sc_mcu7t3v3__nand4_2_85 VSS VSS VSS VSS VSS VSS gf180mcu_as_sc_mcu7t3v3__inv_2_73/A
+ gf180mcu_as_sc_mcu7t3v3__inv_2_73/VNW VSUBS gf180mcu_as_sc_mcu7t3v3__nand4_2
Xgf180mcu_as_sc_mcu7t3v3__nand4_2_30 VSS VSS VSS VSS VSS VSS gf180mcu_as_sc_mcu7t3v3__inv_2_171/A
+ gf180mcu_as_sc_mcu7t3v3__inv_2_171/VNW VSUBS gf180mcu_as_sc_mcu7t3v3__nand4_2
Xgf180mcu_as_sc_mcu7t3v3__nand4_2_41 VSS VSS VSS VSS VSS VSS gf180mcu_as_sc_mcu7t3v3__inv_2_203/A
+ gf180mcu_as_sc_mcu7t3v3__inv_2_203/VNW VSUBS gf180mcu_as_sc_mcu7t3v3__nand4_2
Xgf180mcu_as_sc_mcu7t3v3__nand4_2_96 VSS VSS VSS VSS VSS VSS gf180mcu_as_sc_mcu7t3v3__inv_2_341/A
+ gf180mcu_as_sc_mcu7t3v3__inv_2_341/VNW VSUBS gf180mcu_as_sc_mcu7t3v3__nand4_2
Xgf180mcu_as_sc_mcu7t3v3__nand4_2_74 VSS VSS VSS VSS VSS VSS gf180mcu_as_sc_mcu7t3v3__inv_2_326/A
+ gf180mcu_as_sc_mcu7t3v3__inv_2_326/VNW VSUBS gf180mcu_as_sc_mcu7t3v3__nand4_2
Xgf180mcu_as_sc_mcu7t3v3__nand4_2_52 VSS VSS VSS VSS VSS VSS gf180mcu_as_sc_mcu7t3v3__inv_2_236/A
+ gf180mcu_as_sc_mcu7t3v3__inv_2_236/VNW VSUBS gf180mcu_as_sc_mcu7t3v3__nand4_2
Xu_t017_007 u_t017_007/c0_w0_bl u_t017_007/c0_w0_br u_t017_007/c0_w1_bl u_t017_007/c0_w1_br
+ u_t017_007/c0_r0_rbl u_t017_007/c0_r1_rbl u_t017_007/c1_w0_bl u_t017_007/c1_w0_br
+ u_t017_007/c1_w1_bl u_t017_007/c1_w1_br u_t017_007/c1_r0_rbl u_t017_007/c1_r1_rbl
+ u_t017_007/c2_w0_bl u_t017_007/c2_w0_br u_t017_007/c2_w1_bl u_t017_007/c2_w1_br
+ u_t017_007/c2_r0_rbl u_t017_007/c2_r1_rbl u_t017_007/c3_w0_bl u_t017_007/c3_w0_br
+ u_t017_007/c3_w1_bl u_t017_007/c3_w1_br u_t017_007/c3_r0_rbl u_t017_007/c3_r1_rbl
+ u_t017_007/r0_w0_wl u_t017_007/r0_w1_wl u_t017_007/r0_r0_rwl u_t017_007/r0_r1_rwl
+ u_t017_007/r1_w0_wl u_t017_007/r1_w1_wl u_t017_007/r1_r0_rwl u_t017_007/r1_r1_rwl
+ u_t017_007/r2_w0_wl u_t017_007/r2_w1_wl u_t017_007/r2_r0_rwl u_t017_007/r2_r1_rwl
+ u_t017_007/r3_w0_wl u_t017_007/r3_w1_wl u_t017_007/r3_r0_rwl u_t017_007/r3_r1_rwl
+ VSS VSS u_t017_007/m2_717_1265# u_t017_007/m2_603_2031# u_t017_007/m2_1290_336#
+ u_t017_007/m2_2000_2037# u_t017_007/m2_791_2909# u_t017_007/m2_7_2126# u_t017_007/m2_2154_2081#
+ u_t017_007/m2_1795_2037# u_t017_007/m2_871_303# u_t017_007/m2_431_438# u_t017_007/m2_1290_2898#
+ u_t017_007/m2_1714_1210# u_t017_007/m2_431_1982# u_t017_007/m2_512_1265# u_t017_007/m2_2573_2126#
+ u_t017_007/m2_603_1259# u_t017_007/m2_2074_2909# u_t017_007/m2_7_336# u_t017_007/m2_717_2037#
+ u_t017_007/m2_1886_2031# u_t017_007/m2_2573_336# u_t017_007/m2_7_2898# u_t017_007/m2_2000_1265#
+ u_t017_007/m2_512_2037# u_t017_007/m2_1795_1265# u_t017_007/m2_1714_1982# u_t017_007/m2_1886_1259#
+ u_t017_007/m2_1290_2126# u_t017_007/m2_1714_438# u_t017_007/m2_431_1210# u_t017_007/m2_2573_2898#
+ u_t017_007/m2_2154_303# u_t017_007/m2_871_2081# VSUBS detronyx_12t_2w2r_rc4_4x4_routed_5layer_direct
Xgf180mcu_as_sc_mcu7t3v3__inv_2_1193 gf180mcu_as_sc_mcu7t3v3__nor2_2_9/VDD gf180mcu_as_sc_mcu7t3v3__nand3_2_63/VSS
+ VSS VSS gf180mcu_as_sc_mcu7t3v3__nor2_2_9/VNW VSUBS gf180mcu_as_sc_mcu7t3v3__inv_2
Xgf180mcu_as_sc_mcu7t3v3__inv_2_1160 VSS VSS gf180mcu_as_sc_mcu7t3v3__inv_2_1292/A
+ gf180mcu_as_sc_mcu7t3v3__inv_2_1161/Y gf180mcu_as_sc_mcu7t3v3__inv_2_1292/VNW VSUBS
+ gf180mcu_as_sc_mcu7t3v3__inv_2
Xgf180mcu_as_sc_mcu7t3v3__inv_2_1182 VSS VSS gf180mcu_as_sc_mcu7t3v3__inv_2_1182/Y
+ gf180mcu_as_sc_mcu7t3v3__inv_2_1182/A gf180mcu_as_sc_mcu7t3v3__inv_2_1297/VNW VSUBS
+ gf180mcu_as_sc_mcu7t3v3__inv_2
Xgf180mcu_as_sc_mcu7t3v3__inv_2_1171 VSS VSS gf180mcu_as_sc_mcu7t3v3__inv_2_1171/Y
+ gf180mcu_as_sc_mcu7t3v3__inv_2_1171/A gf180mcu_as_sc_mcu7t3v3__inv_2_1271/VNW VSUBS
+ gf180mcu_as_sc_mcu7t3v3__inv_2
Xu_t031_010 u_t031_010/c0_w0_bl u_t031_010/c0_w0_br u_t031_010/c0_w1_bl u_t031_010/c0_w1_br
+ u_t031_010/c0_r0_rbl u_t031_010/c0_r1_rbl u_t031_010/c1_w0_bl u_t031_010/c1_w0_br
+ u_t031_010/c1_w1_bl u_t031_010/c1_w1_br u_t031_010/c1_r0_rbl u_t031_010/c1_r1_rbl
+ u_t031_010/c2_w0_bl u_t031_010/c2_w0_br u_t031_010/c2_w1_bl u_t031_010/c2_w1_br
+ u_t031_010/c2_r0_rbl u_t031_010/c2_r1_rbl u_t031_010/c3_w0_bl u_t031_010/c3_w0_br
+ u_t031_010/c3_w1_bl u_t031_010/c3_w1_br u_t031_010/c3_r0_rbl u_t031_010/c3_r1_rbl
+ u_t031_010/r0_w0_wl u_t031_010/r0_w1_wl u_t031_010/r0_r0_rwl u_t031_010/r0_r1_rwl
+ u_t031_010/r1_w0_wl u_t031_010/r1_w1_wl u_t031_010/r1_r0_rwl u_t031_010/r1_r1_rwl
+ u_t031_010/r2_w0_wl u_t031_010/r2_w1_wl u_t031_010/r2_r0_rwl u_t031_010/r2_r1_rwl
+ u_t031_010/r3_w0_wl u_t031_010/r3_w1_wl u_t031_010/r3_r0_rwl u_t031_010/r3_r1_rwl
+ VSS VSS u_t031_010/m2_717_1265# u_t031_010/m2_603_2031# u_t031_010/m2_1290_336#
+ u_t031_010/m2_2000_2037# u_t031_010/m2_791_2909# u_t031_010/m2_7_2126# u_t031_010/m2_2154_2081#
+ u_t031_010/m2_1795_2037# u_t031_010/m2_871_303# u_t031_010/m2_431_438# u_t031_010/m2_1290_2898#
+ u_t031_010/m2_1714_1210# u_t031_010/m2_431_1982# u_t031_010/m2_512_1265# u_t031_010/m2_2573_2126#
+ u_t031_010/m2_603_1259# u_t031_010/m2_2074_2909# u_t031_010/m2_7_336# u_t031_010/m2_717_2037#
+ u_t031_010/m2_1886_2031# u_t031_010/m2_2573_336# u_t031_010/m2_7_2898# u_t031_010/m2_2000_1265#
+ u_t031_010/m2_512_2037# u_t031_010/m2_1795_1265# u_t031_010/m2_1714_1982# u_t031_010/m2_1886_1259#
+ u_t031_010/m2_1290_2126# u_t031_010/m2_1714_438# u_t031_010/m2_431_1210# u_t031_010/m2_2573_2898#
+ u_t031_010/m2_2154_303# u_t031_010/m2_871_2081# VSUBS detronyx_12t_2w2r_rc4_4x4_routed_5layer_direct
Xu_t008_007 u_t008_007/c0_w0_bl u_t008_007/c0_w0_br u_t008_007/c0_w1_bl u_t008_007/c0_w1_br
+ u_t008_007/c0_r0_rbl u_t008_007/c0_r1_rbl u_t008_007/c1_w0_bl u_t008_007/c1_w0_br
+ u_t008_007/c1_w1_bl u_t008_007/c1_w1_br u_t008_007/c1_r0_rbl u_t008_007/c1_r1_rbl
+ u_t008_007/c2_w0_bl u_t008_007/c2_w0_br u_t008_007/c2_w1_bl u_t008_007/c2_w1_br
+ u_t008_007/c2_r0_rbl u_t008_007/c2_r1_rbl u_t008_007/c3_w0_bl u_t008_007/c3_w0_br
+ u_t008_007/c3_w1_bl u_t008_007/c3_w1_br u_t008_007/c3_r0_rbl u_t008_007/c3_r1_rbl
+ u_t008_007/r0_w0_wl u_t008_007/r0_w1_wl u_t008_007/r0_r0_rwl u_t008_007/r0_r1_rwl
+ u_t008_007/r1_w0_wl u_t008_007/r1_w1_wl u_t008_007/r1_r0_rwl u_t008_007/r1_r1_rwl
+ u_t008_007/r2_w0_wl u_t008_007/r2_w1_wl u_t008_007/r2_r0_rwl u_t008_007/r2_r1_rwl
+ u_t008_007/r3_w0_wl u_t008_007/r3_w1_wl u_t008_007/r3_r0_rwl u_t008_007/r3_r1_rwl
+ VSS VSS u_t008_007/m2_717_1265# u_t008_007/m2_603_2031# u_t008_007/m2_1290_336#
+ u_t008_007/m2_2000_2037# u_t008_007/m2_791_2909# u_t008_007/m2_7_2126# u_t008_007/m2_2154_2081#
+ u_t008_007/m2_1795_2037# u_t008_007/m2_871_303# u_t008_007/m2_431_438# u_t008_007/m2_1290_2898#
+ u_t008_007/m2_1714_1210# u_t008_007/m2_431_1982# u_t008_007/m2_512_1265# u_t008_007/m2_2573_2126#
+ u_t008_007/m2_603_1259# u_t008_007/m2_2074_2909# u_t008_007/m2_7_336# u_t008_007/m2_717_2037#
+ u_t008_007/m2_1886_2031# u_t008_007/m2_2573_336# u_t008_007/m2_7_2898# u_t008_007/m2_2000_1265#
+ u_t008_007/m2_512_2037# u_t008_007/m2_1795_1265# u_t008_007/m2_1714_1982# u_t008_007/m2_1886_1259#
+ u_t008_007/m2_1290_2126# u_t008_007/m2_1714_438# u_t008_007/m2_431_1210# u_t008_007/m2_2573_2898#
+ u_t008_007/m2_2154_303# u_t008_007/m2_871_2081# VSUBS detronyx_12t_2w2r_rc4_4x4_routed_5layer_direct
Xgf180mcu_as_sc_mcu7t3v3__inv_2_611 VSS VSS VSS gf180mcu_as_sc_mcu7t3v3__inv_2_621/Y
+ gf180mcu_as_sc_mcu7t3v3__inv_2_637/VNW VSUBS gf180mcu_as_sc_mcu7t3v3__inv_2
Xgf180mcu_as_sc_mcu7t3v3__inv_2_633 VSS VSS gf180mcu_as_sc_mcu7t3v3__inv_2_633/Y gf180mcu_as_sc_mcu7t3v3__inv_2_633/A
+ gf180mcu_as_sc_mcu7t3v3__inv_2_633/VNW VSUBS gf180mcu_as_sc_mcu7t3v3__inv_2
Xgf180mcu_as_sc_mcu7t3v3__inv_2_600 VSS VSS VSS gf180mcu_as_sc_mcu7t3v3__inv_2_601/Y
+ gf180mcu_as_sc_mcu7t3v3__inv_2_602/VNW VSUBS gf180mcu_as_sc_mcu7t3v3__inv_2
Xgf180mcu_as_sc_mcu7t3v3__inv_2_622 VSS VSS VSS gf180mcu_as_sc_mcu7t3v3__inv_2_623/Y
+ gf180mcu_as_sc_mcu7t3v3__inv_2_624/VNW VSUBS gf180mcu_as_sc_mcu7t3v3__inv_2
Xgf180mcu_as_sc_mcu7t3v3__inv_2_655 VSS VSS gf180mcu_as_sc_mcu7t3v3__inv_2_655/Y gf180mcu_as_sc_mcu7t3v3__inv_2_656/Y
+ gf180mcu_as_sc_mcu7t3v3__inv_2_656/VNW VSUBS gf180mcu_as_sc_mcu7t3v3__inv_2
Xgf180mcu_as_sc_mcu7t3v3__inv_2_688 VSS VSS gf180mcu_as_sc_mcu7t3v3__inv_2_688/Y gf180mcu_as_sc_mcu7t3v3__inv_2_688/A
+ gf180mcu_as_sc_mcu7t3v3__inv_2_688/VNW VSUBS gf180mcu_as_sc_mcu7t3v3__inv_2
Xgf180mcu_as_sc_mcu7t3v3__inv_2_666 VSS VSS VSS gf180mcu_as_sc_mcu7t3v3__inv_2_667/Y
+ gf180mcu_as_sc_mcu7t3v3__inv_2_680/VNW VSUBS gf180mcu_as_sc_mcu7t3v3__inv_2
Xgf180mcu_as_sc_mcu7t3v3__inv_2_644 VSS VSS VSS gf180mcu_as_sc_mcu7t3v3__inv_2_645/Y
+ gf180mcu_as_sc_mcu7t3v3__inv_2_646/VNW VSUBS gf180mcu_as_sc_mcu7t3v3__inv_2
Xgf180mcu_as_sc_mcu7t3v3__inv_2_677 VSS VSS gf180mcu_as_sc_mcu7t3v3__inv_2_677/Y gf180mcu_as_sc_mcu7t3v3__inv_2_678/Y
+ gf180mcu_as_sc_mcu7t3v3__inv_2_678/VNW VSUBS gf180mcu_as_sc_mcu7t3v3__inv_2
Xgf180mcu_as_sc_mcu7t3v3__inv_2_699 VSS VSS gf180mcu_as_sc_mcu7t3v3__inv_2_699/Y gf180mcu_as_sc_mcu7t3v3__inv_2_708/Y
+ gf180mcu_as_sc_mcu7t3v3__inv_2_708/VNW VSUBS gf180mcu_as_sc_mcu7t3v3__inv_2
Xu_t022_010 u_t022_010/c0_w0_bl u_t022_010/c0_w0_br u_t022_010/c0_w1_bl u_t022_010/c0_w1_br
+ u_t022_010/c0_r0_rbl u_t022_010/c0_r1_rbl u_t022_010/c1_w0_bl u_t022_010/c1_w0_br
+ u_t022_010/c1_w1_bl u_t022_010/c1_w1_br u_t022_010/c1_r0_rbl u_t022_010/c1_r1_rbl
+ u_t022_010/c2_w0_bl u_t022_010/c2_w0_br u_t022_010/c2_w1_bl u_t022_010/c2_w1_br
+ u_t022_010/c2_r0_rbl u_t022_010/c2_r1_rbl u_t022_010/c3_w0_bl u_t022_010/c3_w0_br
+ u_t022_010/c3_w1_bl u_t022_010/c3_w1_br u_t022_010/c3_r0_rbl u_t022_010/c3_r1_rbl
+ u_t022_010/r0_w0_wl u_t022_010/r0_w1_wl u_t022_010/r0_r0_rwl u_t022_010/r0_r1_rwl
+ u_t022_010/r1_w0_wl u_t022_010/r1_w1_wl u_t022_010/r1_r0_rwl u_t022_010/r1_r1_rwl
+ u_t022_010/r2_w0_wl u_t022_010/r2_w1_wl u_t022_010/r2_r0_rwl u_t022_010/r2_r1_rwl
+ u_t022_010/r3_w0_wl u_t022_010/r3_w1_wl u_t022_010/r3_r0_rwl u_t022_010/r3_r1_rwl
+ VSS VSS u_t022_010/m2_717_1265# u_t022_010/m2_603_2031# u_t022_010/m2_1290_336#
+ u_t022_010/m2_2000_2037# u_t022_010/m2_791_2909# u_t022_010/m2_7_2126# u_t022_010/m2_2154_2081#
+ u_t022_010/m2_1795_2037# u_t022_010/m2_871_303# u_t022_010/m2_431_438# u_t022_010/m2_1290_2898#
+ u_t022_010/m2_1714_1210# u_t022_010/m2_431_1982# u_t022_010/m2_512_1265# u_t022_010/m2_2573_2126#
+ u_t022_010/m2_603_1259# u_t022_010/m2_2074_2909# u_t022_010/m2_7_336# u_t022_010/m2_717_2037#
+ u_t022_010/m2_1886_2031# u_t022_010/m2_2573_336# u_t022_010/m2_7_2898# u_t022_010/m2_2000_1265#
+ u_t022_010/m2_512_2037# u_t022_010/m2_1795_1265# u_t022_010/m2_1714_1982# u_t022_010/m2_1886_1259#
+ u_t022_010/m2_1290_2126# u_t022_010/m2_1714_438# u_t022_010/m2_431_1210# u_t022_010/m2_2573_2898#
+ u_t022_010/m2_2154_303# u_t022_010/m2_871_2081# VSUBS detronyx_12t_2w2r_rc4_4x4_routed_5layer_direct
Xu_t013_010 u_t013_010/c0_w0_bl u_t013_010/c0_w0_br u_t013_010/c0_w1_bl u_t013_010/c0_w1_br
+ u_t013_010/c0_r0_rbl u_t013_010/c0_r1_rbl u_t013_010/c1_w0_bl u_t013_010/c1_w0_br
+ u_t013_010/c1_w1_bl u_t013_010/c1_w1_br u_t013_010/c1_r0_rbl u_t013_010/c1_r1_rbl
+ u_t013_010/c2_w0_bl u_t013_010/c2_w0_br u_t013_010/c2_w1_bl u_t013_010/c2_w1_br
+ u_t013_010/c2_r0_rbl u_t013_010/c2_r1_rbl u_t013_010/c3_w0_bl u_t013_010/c3_w0_br
+ u_t013_010/c3_w1_bl u_t013_010/c3_w1_br u_t013_010/c3_r0_rbl u_t013_010/c3_r1_rbl
+ u_t013_010/r0_w0_wl u_t013_010/r0_w1_wl u_t013_010/r0_r0_rwl u_t013_010/r0_r1_rwl
+ u_t013_010/r1_w0_wl u_t013_010/r1_w1_wl u_t013_010/r1_r0_rwl u_t013_010/r1_r1_rwl
+ u_t013_010/r2_w0_wl u_t013_010/r2_w1_wl u_t013_010/r2_r0_rwl u_t013_010/r2_r1_rwl
+ u_t013_010/r3_w0_wl u_t013_010/r3_w1_wl u_t013_010/r3_r0_rwl u_t013_010/r3_r1_rwl
+ VSS VSS u_t013_010/m2_717_1265# u_t013_010/m2_603_2031# u_t013_010/m2_1290_336#
+ u_t013_010/m2_2000_2037# u_t013_010/m2_791_2909# u_t013_010/m2_7_2126# u_t013_010/m2_2154_2081#
+ u_t013_010/m2_1795_2037# u_t013_010/m2_871_303# u_t013_010/m2_431_438# u_t013_010/m2_1290_2898#
+ u_t013_010/m2_1714_1210# u_t013_010/m2_431_1982# u_t013_010/m2_512_1265# u_t013_010/m2_2573_2126#
+ u_t013_010/m2_603_1259# u_t013_010/m2_2074_2909# u_t013_010/m2_7_336# u_t013_010/m2_717_2037#
+ u_t013_010/m2_1886_2031# u_t013_010/m2_2573_336# u_t013_010/m2_7_2898# u_t013_010/m2_2000_1265#
+ u_t013_010/m2_512_2037# u_t013_010/m2_1795_1265# u_t013_010/m2_1714_1982# u_t013_010/m2_1886_1259#
+ u_t013_010/m2_1290_2126# u_t013_010/m2_1714_438# u_t013_010/m2_431_1210# u_t013_010/m2_2573_2898#
+ u_t013_010/m2_2154_303# u_t013_010/m2_871_2081# VSUBS detronyx_12t_2w2r_rc4_4x4_routed_5layer_direct
Xu_t004_010 u_t004_010/c0_w0_bl u_t004_010/c0_w0_br u_t004_010/c0_w1_bl u_t004_010/c0_w1_br
+ u_t004_010/c0_r0_rbl u_t004_010/c0_r1_rbl u_t004_010/c1_w0_bl u_t004_010/c1_w0_br
+ u_t004_010/c1_w1_bl u_t004_010/c1_w1_br u_t004_010/c1_r0_rbl u_t004_010/c1_r1_rbl
+ u_t004_010/c2_w0_bl u_t004_010/c2_w0_br u_t004_010/c2_w1_bl u_t004_010/c2_w1_br
+ u_t004_010/c2_r0_rbl u_t004_010/c2_r1_rbl u_t004_010/c3_w0_bl u_t004_010/c3_w0_br
+ u_t004_010/c3_w1_bl u_t004_010/c3_w1_br u_t004_010/c3_r0_rbl u_t004_010/c3_r1_rbl
+ u_t004_010/r0_w0_wl u_t004_010/r0_w1_wl u_t004_010/r0_r0_rwl u_t004_010/r0_r1_rwl
+ u_t004_010/r1_w0_wl u_t004_010/r1_w1_wl u_t004_010/r1_r0_rwl u_t004_010/r1_r1_rwl
+ u_t004_010/r2_w0_wl u_t004_010/r2_w1_wl u_t004_010/r2_r0_rwl u_t004_010/r2_r1_rwl
+ u_t004_010/r3_w0_wl u_t004_010/r3_w1_wl u_t004_010/r3_r0_rwl u_t004_010/r3_r1_rwl
+ VSS VSS u_t004_010/m2_717_1265# u_t004_010/m2_603_2031# u_t004_010/m2_1290_336#
+ u_t004_010/m2_2000_2037# u_t004_010/m2_791_2909# u_t004_010/m2_7_2126# u_t004_010/m2_2154_2081#
+ u_t004_010/m2_1795_2037# u_t004_010/m2_871_303# u_t004_010/m2_431_438# u_t004_010/m2_1290_2898#
+ u_t004_010/m2_1714_1210# u_t004_010/m2_431_1982# u_t004_010/m2_512_1265# u_t004_010/m2_2573_2126#
+ u_t004_010/m2_603_1259# u_t004_010/m2_2074_2909# u_t004_010/m2_7_336# u_t004_010/m2_717_2037#
+ u_t004_010/m2_1886_2031# u_t004_010/m2_2573_336# u_t004_010/m2_7_2898# u_t004_010/m2_2000_1265#
+ u_t004_010/m2_512_2037# u_t004_010/m2_1795_1265# u_t004_010/m2_1714_1982# u_t004_010/m2_1886_1259#
+ u_t004_010/m2_1290_2126# u_t004_010/m2_1714_438# u_t004_010/m2_431_1210# u_t004_010/m2_2573_2898#
+ u_t004_010/m2_2154_303# u_t004_010/m2_871_2081# VSUBS detronyx_12t_2w2r_rc4_4x4_routed_5layer_direct
Xgf180mcu_as_sc_mcu7t3v3__inv_2_441 VSS VSS gf180mcu_as_sc_mcu7t3v3__inv_2_543/A gf180mcu_as_sc_mcu7t3v3__inv_2_442/Y
+ gf180mcu_as_sc_mcu7t3v3__inv_2_543/VNW VSUBS gf180mcu_as_sc_mcu7t3v3__inv_2
Xgf180mcu_as_sc_mcu7t3v3__inv_2_485 VSS VSS gf180mcu_as_sc_mcu7t3v3__inv_2_485/Y gf180mcu_as_sc_mcu7t3v3__inv_2_485/A
+ gf180mcu_as_sc_mcu7t3v3__inv_2_548/VNW VSUBS gf180mcu_as_sc_mcu7t3v3__inv_2
Xgf180mcu_as_sc_mcu7t3v3__inv_2_463 gf180mcu_as_sc_mcu7t3v3__nor2_2_7/VDD gf180mcu_as_sc_mcu7t3v3__nor2_2_7/VSS
+ gf180mcu_as_sc_mcu7t3v3__inv_2_463/Y VSS gf180mcu_as_sc_mcu7t3v3__nor2_2_7/VNW VSUBS
+ gf180mcu_as_sc_mcu7t3v3__inv_2
Xgf180mcu_as_sc_mcu7t3v3__inv_2_452 gf180mcu_as_sc_mcu7t3v3__nor2_2_4/VDD gf180mcu_as_sc_mcu7t3v3__nand2_2_3/VSS
+ VSS VSS gf180mcu_as_sc_mcu7t3v3__nor2_2_4/VNW VSUBS gf180mcu_as_sc_mcu7t3v3__inv_2
Xgf180mcu_as_sc_mcu7t3v3__inv_2_474 gf180mcu_as_sc_mcu7t3v3__nor2_2_4/VDD gf180mcu_as_sc_mcu7t3v3__nand2_2_3/VSS
+ VSS VSS gf180mcu_as_sc_mcu7t3v3__nor2_2_4/VNW VSUBS gf180mcu_as_sc_mcu7t3v3__inv_2
Xgf180mcu_as_sc_mcu7t3v3__inv_2_430 gf180mcu_as_sc_mcu7t3v3__nor2_2_4/VDD gf180mcu_as_sc_mcu7t3v3__nor2_2_4/VSS
+ gf180mcu_as_sc_mcu7t3v3__inv_2_430/Y VSS gf180mcu_as_sc_mcu7t3v3__nor2_2_4/VNW VSUBS
+ gf180mcu_as_sc_mcu7t3v3__inv_2
Xgf180mcu_as_sc_mcu7t3v3__inv_2_496 VSS VSS gf180mcu_as_sc_mcu7t3v3__inv_2_555/A gf180mcu_as_sc_mcu7t3v3__inv_2_497/Y
+ gf180mcu_as_sc_mcu7t3v3__inv_2_555/VNW VSUBS gf180mcu_as_sc_mcu7t3v3__inv_2
Xu_t010_013 u_t010_013/c0_w0_bl u_t010_013/c0_w0_br u_t010_013/c0_w1_bl u_t010_013/c0_w1_br
+ u_t010_013/c0_r0_rbl u_t010_013/c0_r1_rbl u_t010_013/c1_w0_bl u_t010_013/c1_w0_br
+ u_t010_013/c1_w1_bl u_t010_013/c1_w1_br u_t010_013/c1_r0_rbl u_t010_013/c1_r1_rbl
+ u_t010_013/c2_w0_bl u_t010_013/c2_w0_br u_t010_013/c2_w1_bl u_t010_013/c2_w1_br
+ u_t010_013/c2_r0_rbl u_t010_013/c2_r1_rbl u_t010_013/c3_w0_bl u_t010_013/c3_w0_br
+ u_t010_013/c3_w1_bl u_t010_013/c3_w1_br u_t010_013/c3_r0_rbl u_t010_013/c3_r1_rbl
+ u_t010_013/r0_w0_wl u_t010_013/r0_w1_wl u_t010_013/r0_r0_rwl u_t010_013/r0_r1_rwl
+ u_t010_013/r1_w0_wl u_t010_013/r1_w1_wl u_t010_013/r1_r0_rwl u_t010_013/r1_r1_rwl
+ u_t010_013/r2_w0_wl u_t010_013/r2_w1_wl u_t010_013/r2_r0_rwl u_t010_013/r2_r1_rwl
+ u_t010_013/r3_w0_wl u_t010_013/r3_w1_wl u_t010_013/r3_r0_rwl u_t010_013/r3_r1_rwl
+ VSS VSS u_t010_013/m2_717_1265# u_t010_013/m2_603_2031# u_t010_013/m2_1290_336#
+ u_t010_013/m2_2000_2037# u_t010_013/m2_791_2909# u_t010_013/m2_7_2126# u_t010_013/m2_2154_2081#
+ u_t010_013/m2_1795_2037# u_t010_013/m2_871_303# u_t010_013/m2_431_438# u_t010_013/m2_1290_2898#
+ u_t010_013/m2_1714_1210# u_t010_013/m2_431_1982# u_t010_013/m2_512_1265# u_t010_013/m2_2573_2126#
+ u_t010_013/m2_603_1259# u_t010_013/m2_2074_2909# u_t010_013/m2_7_336# u_t010_013/m2_717_2037#
+ u_t010_013/m2_1886_2031# u_t010_013/m2_2573_336# u_t010_013/m2_7_2898# u_t010_013/m2_2000_1265#
+ u_t010_013/m2_512_2037# u_t010_013/m2_1795_1265# u_t010_013/m2_1714_1982# u_t010_013/m2_1886_1259#
+ u_t010_013/m2_1290_2126# u_t010_013/m2_1714_438# u_t010_013/m2_431_1210# u_t010_013/m2_2573_2898#
+ u_t010_013/m2_2154_303# u_t010_013/m2_871_2081# VSUBS detronyx_12t_2w2r_rc4_4x4_routed_5layer_direct
Xu_t010_002 u_t010_002/c0_w0_bl u_t010_002/c0_w0_br u_t010_002/c0_w1_bl u_t010_002/c0_w1_br
+ u_t010_002/c0_r0_rbl u_t010_002/c0_r1_rbl u_t010_002/c1_w0_bl u_t010_002/c1_w0_br
+ u_t010_002/c1_w1_bl u_t010_002/c1_w1_br u_t010_002/c1_r0_rbl u_t010_002/c1_r1_rbl
+ u_t010_002/c2_w0_bl u_t010_002/c2_w0_br u_t010_002/c2_w1_bl u_t010_002/c2_w1_br
+ u_t010_002/c2_r0_rbl u_t010_002/c2_r1_rbl u_t010_002/c3_w0_bl u_t010_002/c3_w0_br
+ u_t010_002/c3_w1_bl u_t010_002/c3_w1_br u_t010_002/c3_r0_rbl u_t010_002/c3_r1_rbl
+ u_t010_002/r0_w0_wl u_t010_002/r0_w1_wl u_t010_002/r0_r0_rwl u_t010_002/r0_r1_rwl
+ u_t010_002/r1_w0_wl u_t010_002/r1_w1_wl u_t010_002/r1_r0_rwl u_t010_002/r1_r1_rwl
+ u_t010_002/r2_w0_wl u_t010_002/r2_w1_wl u_t010_002/r2_r0_rwl u_t010_002/r2_r1_rwl
+ u_t010_002/r3_w0_wl u_t010_002/r3_w1_wl u_t010_002/r3_r0_rwl u_t010_002/r3_r1_rwl
+ VSS VSS u_t010_002/m2_717_1265# u_t010_002/m2_603_2031# u_t010_002/m2_1290_336#
+ u_t010_002/m2_2000_2037# u_t010_002/m2_791_2909# u_t010_002/m2_7_2126# u_t010_002/m2_2154_2081#
+ u_t010_002/m2_1795_2037# u_t010_002/m2_871_303# u_t010_002/m2_431_438# u_t010_002/m2_1290_2898#
+ u_t010_002/m2_1714_1210# u_t010_002/m2_431_1982# u_t010_002/m2_512_1265# u_t010_002/m2_2573_2126#
+ u_t010_002/m2_603_1259# u_t010_002/m2_2074_2909# u_t010_002/m2_7_336# u_t010_002/m2_717_2037#
+ u_t010_002/m2_1886_2031# u_t010_002/m2_2573_336# u_t010_002/m2_7_2898# u_t010_002/m2_2000_1265#
+ u_t010_002/m2_512_2037# u_t010_002/m2_1795_1265# u_t010_002/m2_1714_1982# u_t010_002/m2_1886_1259#
+ u_t010_002/m2_1290_2126# u_t010_002/m2_1714_438# u_t010_002/m2_431_1210# u_t010_002/m2_2573_2898#
+ u_t010_002/m2_2154_303# u_t010_002/m2_871_2081# VSUBS detronyx_12t_2w2r_rc4_4x4_routed_5layer_direct
Xu_t001_013 u_t001_013/c0_w0_bl u_t001_013/c0_w0_br u_t001_013/c0_w1_bl u_t001_013/c0_w1_br
+ u_t001_013/c0_r0_rbl u_t001_013/c0_r1_rbl u_t001_013/c1_w0_bl u_t001_013/c1_w0_br
+ u_t001_013/c1_w1_bl u_t001_013/c1_w1_br u_t001_013/c1_r0_rbl u_t001_013/c1_r1_rbl
+ u_t001_013/c2_w0_bl u_t001_013/c2_w0_br u_t001_013/c2_w1_bl u_t001_013/c2_w1_br
+ u_t001_013/c2_r0_rbl u_t001_013/c2_r1_rbl u_t001_013/c3_w0_bl u_t001_013/c3_w0_br
+ u_t001_013/c3_w1_bl u_t001_013/c3_w1_br u_t001_013/c3_r0_rbl u_t001_013/c3_r1_rbl
+ u_t001_013/r0_w0_wl u_t001_013/r0_w1_wl u_t001_013/r0_r0_rwl u_t001_013/r0_r1_rwl
+ u_t001_013/r1_w0_wl u_t001_013/r1_w1_wl u_t001_013/r1_r0_rwl u_t001_013/r1_r1_rwl
+ u_t001_013/r2_w0_wl u_t001_013/r2_w1_wl u_t001_013/r2_r0_rwl u_t001_013/r2_r1_rwl
+ u_t001_013/r3_w0_wl u_t001_013/r3_w1_wl u_t001_013/r3_r0_rwl u_t001_013/r3_r1_rwl
+ VSS VSS u_t001_013/m2_717_1265# u_t001_013/m2_603_2031# u_t001_013/m2_1290_336#
+ u_t001_013/m2_2000_2037# u_t001_013/m2_791_2909# u_t001_013/m2_7_2126# u_t001_013/m2_2154_2081#
+ u_t001_013/m2_1795_2037# u_t001_013/m2_871_303# u_t001_013/m2_431_438# u_t001_013/m2_1290_2898#
+ u_t001_013/m2_1714_1210# u_t001_013/m2_431_1982# u_t001_013/m2_512_1265# u_t001_013/m2_2573_2126#
+ u_t001_013/m2_603_1259# u_t001_013/m2_2074_2909# u_t001_013/m2_7_336# u_t001_013/m2_717_2037#
+ u_t001_013/m2_1886_2031# u_t001_013/m2_2573_336# u_t001_013/m2_7_2898# u_t001_013/m2_2000_1265#
+ u_t001_013/m2_512_2037# u_t001_013/m2_1795_1265# u_t001_013/m2_1714_1982# u_t001_013/m2_1886_1259#
+ u_t001_013/m2_1290_2126# u_t001_013/m2_1714_438# u_t001_013/m2_431_1210# u_t001_013/m2_2573_2898#
+ u_t001_013/m2_2154_303# u_t001_013/m2_871_2081# VSUBS detronyx_12t_2w2r_rc4_4x4_routed_5layer_direct
Xu_t001_002 u_t001_002/c0_w0_bl u_t001_002/c0_w0_br u_t001_002/c0_w1_bl u_t001_002/c0_w1_br
+ u_t001_002/c0_r0_rbl u_t001_002/c0_r1_rbl u_t001_002/c1_w0_bl u_t001_002/c1_w0_br
+ u_t001_002/c1_w1_bl u_t001_002/c1_w1_br u_t001_002/c1_r0_rbl u_t001_002/c1_r1_rbl
+ u_t001_002/c2_w0_bl u_t001_002/c2_w0_br u_t001_002/c2_w1_bl u_t001_002/c2_w1_br
+ u_t001_002/c2_r0_rbl u_t001_002/c2_r1_rbl u_t001_002/c3_w0_bl u_t001_002/c3_w0_br
+ u_t001_002/c3_w1_bl u_t001_002/c3_w1_br u_t001_002/c3_r0_rbl u_t001_002/c3_r1_rbl
+ u_t001_002/r0_w0_wl u_t001_002/r0_w1_wl u_t001_002/r0_r0_rwl u_t001_002/r0_r1_rwl
+ u_t001_002/r1_w0_wl u_t001_002/r1_w1_wl u_t001_002/r1_r0_rwl u_t001_002/r1_r1_rwl
+ u_t001_002/r2_w0_wl u_t001_002/r2_w1_wl u_t001_002/r2_r0_rwl u_t001_002/r2_r1_rwl
+ u_t001_002/r3_w0_wl u_t001_002/r3_w1_wl u_t001_002/r3_r0_rwl u_t001_002/r3_r1_rwl
+ VSS VSS u_t001_002/m2_717_1265# u_t001_002/m2_603_2031# u_t001_002/m2_1290_336#
+ u_t001_002/m2_2000_2037# u_t001_002/m2_791_2909# u_t001_002/m2_7_2126# u_t001_002/m2_2154_2081#
+ u_t001_002/m2_1795_2037# u_t001_002/m2_871_303# u_t001_002/m2_431_438# u_t001_002/m2_1290_2898#
+ u_t001_002/m2_1714_1210# u_t001_002/m2_431_1982# u_t001_002/m2_512_1265# u_t001_002/m2_2573_2126#
+ u_t001_002/m2_603_1259# u_t001_002/m2_2074_2909# u_t001_002/m2_7_336# u_t001_002/m2_717_2037#
+ u_t001_002/m2_1886_2031# u_t001_002/m2_2573_336# u_t001_002/m2_7_2898# u_t001_002/m2_2000_1265#
+ u_t001_002/m2_512_2037# u_t001_002/m2_1795_1265# u_t001_002/m2_1714_1982# u_t001_002/m2_1886_1259#
+ u_t001_002/m2_1290_2126# u_t001_002/m2_1714_438# u_t001_002/m2_431_1210# u_t001_002/m2_2573_2898#
+ u_t001_002/m2_2154_303# u_t001_002/m2_871_2081# VSUBS detronyx_12t_2w2r_rc4_4x4_routed_5layer_direct
Xgf180mcu_as_sc_mcu7t3v3__inv_2_1704 gf180mcu_as_sc_mcu7t3v3__nand3_2_9/VDD gf180mcu_as_sc_mcu7t3v3__nor2_2_4/VSS
+ VSS VSS gf180mcu_as_sc_mcu7t3v3__nand3_2_9/VNW VSUBS gf180mcu_as_sc_mcu7t3v3__inv_2
Xgf180mcu_as_sc_mcu7t3v3__inv_2_282 VSS VSS VSS gf180mcu_as_sc_mcu7t3v3__inv_2_283/Y
+ gf180mcu_as_sc_mcu7t3v3__inv_2_288/VNW VSUBS gf180mcu_as_sc_mcu7t3v3__inv_2
Xgf180mcu_as_sc_mcu7t3v3__inv_2_271 VSS VSS VSS gf180mcu_as_sc_mcu7t3v3__inv_2_272/Y
+ gf180mcu_as_sc_mcu7t3v3__inv_2_274/VNW VSUBS gf180mcu_as_sc_mcu7t3v3__inv_2
Xgf180mcu_as_sc_mcu7t3v3__inv_2_293 VSS VSS gf180mcu_as_sc_mcu7t3v3__inv_2_293/Y gf180mcu_as_sc_mcu7t3v3__inv_2_297/Y
+ gf180mcu_as_sc_mcu7t3v3__inv_2_297/VNW VSUBS gf180mcu_as_sc_mcu7t3v3__inv_2
Xgf180mcu_as_sc_mcu7t3v3__inv_2_260 VSS VSS gf180mcu_as_sc_mcu7t3v3__inv_2_260/Y gf180mcu_as_sc_mcu7t3v3__inv_2_260/A
+ gf180mcu_as_sc_mcu7t3v3__inv_2_260/VNW VSUBS gf180mcu_as_sc_mcu7t3v3__inv_2
Xgf180mcu_as_sc_mcu7t3v3__inv_2_1726 VSS VSS gf180mcu_as_sc_mcu7t3v3__inv_2_1726/Y
+ gf180mcu_as_sc_mcu7t3v3__inv_2_1726/A gf180mcu_as_sc_mcu7t3v3__inv_2_1726/VNW VSUBS
+ gf180mcu_as_sc_mcu7t3v3__inv_2
Xgf180mcu_as_sc_mcu7t3v3__inv_2_1715 VSS VSS VSS gf180mcu_as_sc_mcu7t3v3__inv_2_1716/Y
+ gf180mcu_as_sc_mcu7t3v3__inv_2_1717/VNW VSUBS gf180mcu_as_sc_mcu7t3v3__inv_2
Xgf180mcu_as_sc_mcu7t3v3__nand4_2_509 VSS VSS VSS VSS VSS VSS gf180mcu_as_sc_mcu7t3v3__inv_2_1628/A
+ gf180mcu_as_sc_mcu7t3v3__inv_2_1685/VNW VSUBS gf180mcu_as_sc_mcu7t3v3__nand4_2
Xgf180mcu_as_sc_mcu7t3v3__inv_2_19 VSS VSS gf180mcu_as_sc_mcu7t3v3__inv_2_19/Y gf180mcu_as_sc_mcu7t3v3__inv_2_20/Y
+ gf180mcu_as_sc_mcu7t3v3__inv_2_20/VNW VSUBS gf180mcu_as_sc_mcu7t3v3__inv_2
Xgf180mcu_as_sc_mcu7t3v3__inv_2_1567 VSS VSS gf180mcu_as_sc_mcu7t3v3__inv_2_1567/Y
+ gf180mcu_as_sc_mcu7t3v3__inv_2_1567/A gf180mcu_as_sc_mcu7t3v3__inv_2_1588/VNW VSUBS
+ gf180mcu_as_sc_mcu7t3v3__inv_2
Xgf180mcu_as_sc_mcu7t3v3__inv_2_1578 VSS VSS gf180mcu_as_sc_mcu7t3v3__inv_2_1578/Y
+ gf180mcu_as_sc_mcu7t3v3__inv_2_1579/Y gf180mcu_as_sc_mcu7t3v3__inv_2_1579/VNW VSUBS
+ gf180mcu_as_sc_mcu7t3v3__inv_2
Xgf180mcu_as_sc_mcu7t3v3__inv_2_1545 VSS VSS VSS gf180mcu_as_sc_mcu7t3v3__inv_2_1546/Y
+ gf180mcu_as_sc_mcu7t3v3__inv_2_1547/VNW VSUBS gf180mcu_as_sc_mcu7t3v3__inv_2
Xgf180mcu_as_sc_mcu7t3v3__inv_2_1556 VSS VSS gf180mcu_as_sc_mcu7t3v3__inv_2_1556/Y
+ gf180mcu_as_sc_mcu7t3v3__inv_2_1556/A gf180mcu_as_sc_mcu7t3v3__inv_2_1556/VNW VSUBS
+ gf180mcu_as_sc_mcu7t3v3__inv_2
Xgf180mcu_as_sc_mcu7t3v3__inv_2_1512 VSS VSS VSS gf180mcu_as_sc_mcu7t3v3__inv_2_1513/Y
+ gf180mcu_as_sc_mcu7t3v3__inv_2_1514/VNW VSUBS gf180mcu_as_sc_mcu7t3v3__inv_2
Xgf180mcu_as_sc_mcu7t3v3__inv_2_1523 VSS VSS gf180mcu_as_sc_mcu7t3v3__inv_2_1523/Y
+ gf180mcu_as_sc_mcu7t3v3__inv_2_1523/A gf180mcu_as_sc_mcu7t3v3__inv_2_1523/VNW VSUBS
+ gf180mcu_as_sc_mcu7t3v3__inv_2
Xgf180mcu_as_sc_mcu7t3v3__inv_2_1534 VSS VSS gf180mcu_as_sc_mcu7t3v3__inv_2_1534/Y
+ gf180mcu_as_sc_mcu7t3v3__inv_2_1535/Y gf180mcu_as_sc_mcu7t3v3__inv_2_1535/VNW VSUBS
+ gf180mcu_as_sc_mcu7t3v3__inv_2
Xgf180mcu_as_sc_mcu7t3v3__inv_2_1501 VSS VSS VSS gf180mcu_as_sc_mcu7t3v3__inv_2_1502/Y
+ gf180mcu_as_sc_mcu7t3v3__inv_2_1503/VNW VSUBS gf180mcu_as_sc_mcu7t3v3__inv_2
Xgf180mcu_as_sc_mcu7t3v3__inv_2_1589 VSS VSS VSS gf180mcu_as_sc_mcu7t3v3__inv_2_1590/Y
+ gf180mcu_as_sc_mcu7t3v3__inv_2_1591/VNW VSUBS gf180mcu_as_sc_mcu7t3v3__inv_2
Xgf180mcu_as_sc_mcu7t3v3__nand4_2_339 VSS VSS VSS VSS VSS VSS gf180mcu_as_sc_mcu7t3v3__inv_2_1142/A
+ gf180mcu_as_sc_mcu7t3v3__inv_2_1142/VNW VSUBS gf180mcu_as_sc_mcu7t3v3__nand4_2
Xgf180mcu_as_sc_mcu7t3v3__nand4_2_328 VSS VSS VSS VSS VSS VSS gf180mcu_as_sc_mcu7t3v3__inv_2_1107/A
+ gf180mcu_as_sc_mcu7t3v3__inv_2_1107/VNW VSUBS gf180mcu_as_sc_mcu7t3v3__nand4_2
Xgf180mcu_as_sc_mcu7t3v3__nand4_2_317 VSS VSS VSS VSS VSS VSS gf180mcu_as_sc_mcu7t3v3__inv_2_1037/A
+ gf180mcu_as_sc_mcu7t3v3__inv_2_1037/VNW VSUBS gf180mcu_as_sc_mcu7t3v3__nand4_2
Xgf180mcu_as_sc_mcu7t3v3__nand4_2_306 VSS VSS VSS VSS VSS VSS gf180mcu_as_sc_mcu7t3v3__inv_2_1048/A
+ gf180mcu_as_sc_mcu7t3v3__inv_2_1048/VNW VSUBS gf180mcu_as_sc_mcu7t3v3__nand4_2
Xgf180mcu_as_sc_mcu7t3v3__nand2_2_0 gf180mcu_as_sc_mcu7t3v3__nor2_2_4/VDD gf180mcu_as_sc_mcu7t3v3__nand2_2_3/VSS
+ VSS VSS VSS gf180mcu_as_sc_mcu7t3v3__nor2_2_4/VNW VSUBS gf180mcu_as_sc_mcu7t3v3__nand2_2
Xu_t029_005 u_t029_005/c0_w0_bl u_t029_005/c0_w0_br u_t029_005/c0_w1_bl u_t029_005/c0_w1_br
+ u_t029_005/c0_r0_rbl u_t029_005/c0_r1_rbl u_t029_005/c1_w0_bl u_t029_005/c1_w0_br
+ u_t029_005/c1_w1_bl u_t029_005/c1_w1_br u_t029_005/c1_r0_rbl u_t029_005/c1_r1_rbl
+ u_t029_005/c2_w0_bl u_t029_005/c2_w0_br u_t029_005/c2_w1_bl u_t029_005/c2_w1_br
+ u_t029_005/c2_r0_rbl u_t029_005/c2_r1_rbl u_t029_005/c3_w0_bl u_t029_005/c3_w0_br
+ u_t029_005/c3_w1_bl u_t029_005/c3_w1_br u_t029_005/c3_r0_rbl u_t029_005/c3_r1_rbl
+ u_t029_005/r0_w0_wl u_t029_005/r0_w1_wl u_t029_005/r0_r0_rwl u_t029_005/r0_r1_rwl
+ u_t029_005/r1_w0_wl u_t029_005/r1_w1_wl u_t029_005/r1_r0_rwl u_t029_005/r1_r1_rwl
+ u_t029_005/r2_w0_wl u_t029_005/r2_w1_wl u_t029_005/r2_r0_rwl u_t029_005/r2_r1_rwl
+ u_t029_005/r3_w0_wl u_t029_005/r3_w1_wl u_t029_005/r3_r0_rwl u_t029_005/r3_r1_rwl
+ VSS VSS u_t029_005/m2_717_1265# u_t029_005/m2_603_2031# u_t029_005/m2_1290_336#
+ u_t029_005/m2_2000_2037# u_t029_005/m2_791_2909# u_t029_005/m2_7_2126# u_t029_005/m2_2154_2081#
+ u_t029_005/m2_1795_2037# u_t029_005/m2_871_303# u_t029_005/m2_431_438# u_t029_005/m2_1290_2898#
+ u_t029_005/m2_1714_1210# u_t029_005/m2_431_1982# u_t029_005/m2_512_1265# u_t029_005/m2_2573_2126#
+ u_t029_005/m2_603_1259# u_t029_005/m2_2074_2909# u_t029_005/m2_7_336# u_t029_005/m2_717_2037#
+ u_t029_005/m2_1886_2031# u_t029_005/m2_2573_336# u_t029_005/m2_7_2898# u_t029_005/m2_2000_1265#
+ u_t029_005/m2_512_2037# u_t029_005/m2_1795_1265# u_t029_005/m2_1714_1982# u_t029_005/m2_1886_1259#
+ u_t029_005/m2_1290_2126# u_t029_005/m2_1714_438# u_t029_005/m2_431_1210# u_t029_005/m2_2573_2898#
+ u_t029_005/m2_2154_303# u_t029_005/m2_871_2081# VSUBS detronyx_12t_2w2r_rc4_4x4_routed_5layer_direct
Xgf180mcu_as_sc_mcu7t3v3__inv_2_1364 VSS VSS VSS gf180mcu_as_sc_mcu7t3v3__inv_2_1365/Y
+ gf180mcu_as_sc_mcu7t3v3__inv_2_1366/VNW VSUBS gf180mcu_as_sc_mcu7t3v3__inv_2
Xgf180mcu_as_sc_mcu7t3v3__inv_2_1386 VSS VSS gf180mcu_as_sc_mcu7t3v3__inv_2_1386/Y
+ gf180mcu_as_sc_mcu7t3v3__inv_2_1386/A gf180mcu_as_sc_mcu7t3v3__inv_2_1386/VNW VSUBS
+ gf180mcu_as_sc_mcu7t3v3__inv_2
Xgf180mcu_as_sc_mcu7t3v3__inv_2_1397 VSS VSS gf180mcu_as_sc_mcu7t3v3__inv_2_1397/Y
+ gf180mcu_as_sc_mcu7t3v3__inv_2_1398/Y gf180mcu_as_sc_mcu7t3v3__inv_2_1398/VNW VSUBS
+ gf180mcu_as_sc_mcu7t3v3__inv_2
Xgf180mcu_as_sc_mcu7t3v3__inv_2_1375 VSS VSS gf180mcu_as_sc_mcu7t3v3__inv_2_1375/Y
+ gf180mcu_as_sc_mcu7t3v3__inv_2_1375/A gf180mcu_as_sc_mcu7t3v3__inv_2_1375/VNW VSUBS
+ gf180mcu_as_sc_mcu7t3v3__inv_2
Xgf180mcu_as_sc_mcu7t3v3__inv_2_1353 VSS VSS gf180mcu_as_sc_mcu7t3v3__inv_2_1353/Y
+ gf180mcu_as_sc_mcu7t3v3__inv_2_1353/A gf180mcu_as_sc_mcu7t3v3__inv_2_1353/VNW VSUBS
+ gf180mcu_as_sc_mcu7t3v3__inv_2
Xgf180mcu_as_sc_mcu7t3v3__inv_2_1320 VSS VSS gf180mcu_as_sc_mcu7t3v3__inv_2_1320/Y
+ gf180mcu_as_sc_mcu7t3v3__inv_2_1320/A gf180mcu_as_sc_mcu7t3v3__inv_2_1320/VNW VSUBS
+ gf180mcu_as_sc_mcu7t3v3__inv_2
Xgf180mcu_as_sc_mcu7t3v3__inv_2_1342 VSS VSS VSS gf180mcu_as_sc_mcu7t3v3__inv_2_1343/Y
+ gf180mcu_as_sc_mcu7t3v3__inv_2_1344/VNW VSUBS gf180mcu_as_sc_mcu7t3v3__inv_2
Xgf180mcu_as_sc_mcu7t3v3__inv_2_1331 VSS VSS gf180mcu_as_sc_mcu7t3v3__inv_2_1331/Y
+ gf180mcu_as_sc_mcu7t3v3__inv_2_1332/Y gf180mcu_as_sc_mcu7t3v3__inv_2_1332/VNW VSUBS
+ gf180mcu_as_sc_mcu7t3v3__inv_2
Xgf180mcu_as_sc_mcu7t3v3__inv_2_826 VSS VSS VSS gf180mcu_as_sc_mcu7t3v3__inv_2_826/A
+ gf180mcu_as_sc_mcu7t3v3__inv_2_826/VNW VSUBS gf180mcu_as_sc_mcu7t3v3__inv_2
Xgf180mcu_as_sc_mcu7t3v3__inv_2_815 VSS VSS VSS gf180mcu_as_sc_mcu7t3v3__inv_2_815/A
+ gf180mcu_as_sc_mcu7t3v3__inv_2_815/VNW VSUBS gf180mcu_as_sc_mcu7t3v3__inv_2
Xgf180mcu_as_sc_mcu7t3v3__inv_2_804 VSS VSS gf180mcu_as_sc_mcu7t3v3__inv_2_804/Y gf180mcu_as_sc_mcu7t3v3__inv_2_804/A
+ gf180mcu_as_sc_mcu7t3v3__inv_2_850/VNW VSUBS gf180mcu_as_sc_mcu7t3v3__inv_2
Xgf180mcu_as_sc_mcu7t3v3__inv_2_848 VSS VSS VSS gf180mcu_as_sc_mcu7t3v3__inv_2_848/A
+ gf180mcu_as_sc_mcu7t3v3__inv_2_848/VNW VSUBS gf180mcu_as_sc_mcu7t3v3__inv_2
Xgf180mcu_as_sc_mcu7t3v3__inv_2_837 VSS VSS VSS gf180mcu_as_sc_mcu7t3v3__inv_2_837/A
+ gf180mcu_as_sc_mcu7t3v3__inv_2_837/VNW VSUBS gf180mcu_as_sc_mcu7t3v3__inv_2
Xgf180mcu_as_sc_mcu7t3v3__inv_2_859 VSS VSS gf180mcu_as_sc_mcu7t3v3__inv_2_942/A gf180mcu_as_sc_mcu7t3v3__inv_2_862/Y
+ gf180mcu_as_sc_mcu7t3v3__inv_2_942/VNW VSUBS gf180mcu_as_sc_mcu7t3v3__inv_2
Xu_t026_008 u_t026_008/c0_w0_bl u_t026_008/c0_w0_br u_t026_008/c0_w1_bl u_t026_008/c0_w1_br
+ u_t026_008/c0_r0_rbl u_t026_008/c0_r1_rbl u_t026_008/c1_w0_bl u_t026_008/c1_w0_br
+ u_t026_008/c1_w1_bl u_t026_008/c1_w1_br u_t026_008/c1_r0_rbl u_t026_008/c1_r1_rbl
+ u_t026_008/c2_w0_bl u_t026_008/c2_w0_br u_t026_008/c2_w1_bl u_t026_008/c2_w1_br
+ u_t026_008/c2_r0_rbl u_t026_008/c2_r1_rbl u_t026_008/c3_w0_bl u_t026_008/c3_w0_br
+ u_t026_008/c3_w1_bl u_t026_008/c3_w1_br u_t026_008/c3_r0_rbl u_t026_008/c3_r1_rbl
+ u_t026_008/r0_w0_wl u_t026_008/r0_w1_wl u_t026_008/r0_r0_rwl u_t026_008/r0_r1_rwl
+ u_t026_008/r1_w0_wl u_t026_008/r1_w1_wl u_t026_008/r1_r0_rwl u_t026_008/r1_r1_rwl
+ u_t026_008/r2_w0_wl u_t026_008/r2_w1_wl u_t026_008/r2_r0_rwl u_t026_008/r2_r1_rwl
+ u_t026_008/r3_w0_wl u_t026_008/r3_w1_wl u_t026_008/r3_r0_rwl u_t026_008/r3_r1_rwl
+ VSS VSS u_t026_008/m2_717_1265# u_t026_008/m2_603_2031# u_t026_008/m2_1290_336#
+ u_t026_008/m2_2000_2037# u_t026_008/m2_791_2909# u_t026_008/m2_7_2126# u_t026_008/m2_2154_2081#
+ u_t026_008/m2_1795_2037# u_t026_008/m2_871_303# u_t026_008/m2_431_438# u_t026_008/m2_1290_2898#
+ u_t026_008/m2_1714_1210# u_t026_008/m2_431_1982# u_t026_008/m2_512_1265# u_t026_008/m2_2573_2126#
+ u_t026_008/m2_603_1259# u_t026_008/m2_2074_2909# u_t026_008/m2_7_336# u_t026_008/m2_717_2037#
+ u_t026_008/m2_1886_2031# u_t026_008/m2_2573_336# u_t026_008/m2_7_2898# u_t026_008/m2_2000_1265#
+ u_t026_008/m2_512_2037# u_t026_008/m2_1795_1265# u_t026_008/m2_1714_1982# u_t026_008/m2_1886_1259#
+ u_t026_008/m2_1290_2126# u_t026_008/m2_1714_438# u_t026_008/m2_431_1210# u_t026_008/m2_2573_2898#
+ u_t026_008/m2_2154_303# u_t026_008/m2_871_2081# VSUBS detronyx_12t_2w2r_rc4_4x4_routed_5layer_direct
Xgf180mcu_as_sc_mcu7t3v3__nand4_2_125 VSS VSS VSS VSS VSS VSS gf180mcu_as_sc_mcu7t3v3__inv_2_442/A
+ gf180mcu_as_sc_mcu7t3v3__inv_2_543/VNW VSUBS gf180mcu_as_sc_mcu7t3v3__nand4_2
Xgf180mcu_as_sc_mcu7t3v3__nand4_2_158 VSS VSS VSS VSS VSS VSS gf180mcu_as_sc_mcu7t3v3__inv_2_573/A
+ gf180mcu_as_sc_mcu7t3v3__inv_2_573/VNW VSUBS gf180mcu_as_sc_mcu7t3v3__nand4_2
Xgf180mcu_as_sc_mcu7t3v3__nand4_2_136 VSS VSS VSS VSS VSS VSS gf180mcu_as_sc_mcu7t3v3__inv_2_494/A
+ gf180mcu_as_sc_mcu7t3v3__inv_2_554/VNW VSUBS gf180mcu_as_sc_mcu7t3v3__nand4_2
Xgf180mcu_as_sc_mcu7t3v3__nand4_2_20 VSS VSS VSS VSS VSS VSS gf180mcu_as_sc_mcu7t3v3__inv_2_140/A
+ gf180mcu_as_sc_mcu7t3v3__inv_2_140/VNW VSUBS gf180mcu_as_sc_mcu7t3v3__nand4_2
Xgf180mcu_as_sc_mcu7t3v3__nand4_2_169 VSS VSS VSS VSS VSS VSS gf180mcu_as_sc_mcu7t3v3__inv_2_598/A
+ gf180mcu_as_sc_mcu7t3v3__inv_2_598/VNW VSUBS gf180mcu_as_sc_mcu7t3v3__nand4_2
Xgf180mcu_as_sc_mcu7t3v3__nand4_2_147 VSS VSS VSS VSS VSS VSS gf180mcu_as_sc_mcu7t3v3__inv_2_489/A
+ gf180mcu_as_sc_mcu7t3v3__inv_2_552/VNW VSUBS gf180mcu_as_sc_mcu7t3v3__nand4_2
Xgf180mcu_as_sc_mcu7t3v3__nand4_2_31 VSS VSS VSS VSS VSS VSS gf180mcu_as_sc_mcu7t3v3__inv_2_174/A
+ gf180mcu_as_sc_mcu7t3v3__inv_2_174/VNW VSUBS gf180mcu_as_sc_mcu7t3v3__nand4_2
Xgf180mcu_as_sc_mcu7t3v3__nand4_2_114 VSS VSS VSS VSS VSS VSS gf180mcu_as_sc_mcu7t3v3__inv_2_279/A
+ gf180mcu_as_sc_mcu7t3v3__inv_2_279/VNW VSUBS gf180mcu_as_sc_mcu7t3v3__nand4_2
Xgf180mcu_as_sc_mcu7t3v3__nand4_2_42 VSS VSS VSS VSS VSS VSS gf180mcu_as_sc_mcu7t3v3__inv_2_206/A
+ gf180mcu_as_sc_mcu7t3v3__inv_2_206/VNW VSUBS gf180mcu_as_sc_mcu7t3v3__nand4_2
Xgf180mcu_as_sc_mcu7t3v3__nand4_2_103 VSS VSS VSS VSS VSS VSS gf180mcu_as_sc_mcu7t3v3__inv_2_362/A
+ gf180mcu_as_sc_mcu7t3v3__inv_2_362/VNW VSUBS gf180mcu_as_sc_mcu7t3v3__nand4_2
Xgf180mcu_as_sc_mcu7t3v3__nand4_2_53 VSS VSS VSS VSS VSS VSS gf180mcu_as_sc_mcu7t3v3__inv_2_239/A
+ gf180mcu_as_sc_mcu7t3v3__inv_2_239/VNW VSUBS gf180mcu_as_sc_mcu7t3v3__nand4_2
Xgf180mcu_as_sc_mcu7t3v3__nand4_2_64 VSS VSS VSS VSS VSS VSS gf180mcu_as_sc_mcu7t3v3__inv_2_12/A
+ gf180mcu_as_sc_mcu7t3v3__inv_2_12/VNW VSUBS gf180mcu_as_sc_mcu7t3v3__nand4_2
Xgf180mcu_as_sc_mcu7t3v3__nand4_2_86 VSS VSS VSS VSS VSS VSS gf180mcu_as_sc_mcu7t3v3__inv_2_77/A
+ gf180mcu_as_sc_mcu7t3v3__inv_2_77/VNW VSUBS gf180mcu_as_sc_mcu7t3v3__nand4_2
Xgf180mcu_as_sc_mcu7t3v3__nand4_2_97 VSS VSS VSS VSS VSS VSS gf180mcu_as_sc_mcu7t3v3__inv_2_344/A
+ gf180mcu_as_sc_mcu7t3v3__inv_2_344/VNW VSUBS gf180mcu_as_sc_mcu7t3v3__nand4_2
Xgf180mcu_as_sc_mcu7t3v3__nand4_2_75 VSS VSS VSS VSS VSS VSS gf180mcu_as_sc_mcu7t3v3__inv_2_329/A
+ gf180mcu_as_sc_mcu7t3v3__inv_2_329/VNW VSUBS gf180mcu_as_sc_mcu7t3v3__nand4_2
Xu_t017_008 u_t017_008/c0_w0_bl u_t017_008/c0_w0_br u_t017_008/c0_w1_bl u_t017_008/c0_w1_br
+ u_t017_008/c0_r0_rbl u_t017_008/c0_r1_rbl u_t017_008/c1_w0_bl u_t017_008/c1_w0_br
+ u_t017_008/c1_w1_bl u_t017_008/c1_w1_br u_t017_008/c1_r0_rbl u_t017_008/c1_r1_rbl
+ u_t017_008/c2_w0_bl u_t017_008/c2_w0_br u_t017_008/c2_w1_bl u_t017_008/c2_w1_br
+ u_t017_008/c2_r0_rbl u_t017_008/c2_r1_rbl u_t017_008/c3_w0_bl u_t017_008/c3_w0_br
+ u_t017_008/c3_w1_bl u_t017_008/c3_w1_br u_t017_008/c3_r0_rbl u_t017_008/c3_r1_rbl
+ u_t017_008/r0_w0_wl u_t017_008/r0_w1_wl u_t017_008/r0_r0_rwl u_t017_008/r0_r1_rwl
+ u_t017_008/r1_w0_wl u_t017_008/r1_w1_wl u_t017_008/r1_r0_rwl u_t017_008/r1_r1_rwl
+ u_t017_008/r2_w0_wl u_t017_008/r2_w1_wl u_t017_008/r2_r0_rwl u_t017_008/r2_r1_rwl
+ u_t017_008/r3_w0_wl u_t017_008/r3_w1_wl u_t017_008/r3_r0_rwl u_t017_008/r3_r1_rwl
+ VSS VSS u_t017_008/m2_717_1265# u_t017_008/m2_603_2031# u_t017_008/m2_1290_336#
+ u_t017_008/m2_2000_2037# u_t017_008/m2_791_2909# u_t017_008/m2_7_2126# u_t017_008/m2_2154_2081#
+ u_t017_008/m2_1795_2037# u_t017_008/m2_871_303# u_t017_008/m2_431_438# u_t017_008/m2_1290_2898#
+ u_t017_008/m2_1714_1210# u_t017_008/m2_431_1982# u_t017_008/m2_512_1265# u_t017_008/m2_2573_2126#
+ u_t017_008/m2_603_1259# u_t017_008/m2_2074_2909# u_t017_008/m2_7_336# u_t017_008/m2_717_2037#
+ u_t017_008/m2_1886_2031# u_t017_008/m2_2573_336# u_t017_008/m2_7_2898# u_t017_008/m2_2000_1265#
+ u_t017_008/m2_512_2037# u_t017_008/m2_1795_1265# u_t017_008/m2_1714_1982# u_t017_008/m2_1886_1259#
+ u_t017_008/m2_1290_2126# u_t017_008/m2_1714_438# u_t017_008/m2_431_1210# u_t017_008/m2_2573_2898#
+ u_t017_008/m2_2154_303# u_t017_008/m2_871_2081# VSUBS detronyx_12t_2w2r_rc4_4x4_routed_5layer_direct
Xgf180mcu_as_sc_mcu7t3v3__inv_2_1194 gf180mcu_as_sc_mcu7t3v3__nor2_2_9/VDD gf180mcu_as_sc_mcu7t3v3__nor2_2_9/VSS
+ VSS VSS gf180mcu_as_sc_mcu7t3v3__nor2_2_9/VNW VSUBS gf180mcu_as_sc_mcu7t3v3__inv_2
Xgf180mcu_as_sc_mcu7t3v3__inv_2_1150 VSS VSS gf180mcu_as_sc_mcu7t3v3__inv_2_1150/Y
+ gf180mcu_as_sc_mcu7t3v3__inv_2_1151/Y gf180mcu_as_sc_mcu7t3v3__inv_2_1151/VNW VSUBS
+ gf180mcu_as_sc_mcu7t3v3__inv_2
Xgf180mcu_as_sc_mcu7t3v3__inv_2_1161 VSS VSS gf180mcu_as_sc_mcu7t3v3__inv_2_1161/Y
+ gf180mcu_as_sc_mcu7t3v3__inv_2_1161/A gf180mcu_as_sc_mcu7t3v3__inv_2_1292/VNW VSUBS
+ gf180mcu_as_sc_mcu7t3v3__inv_2
Xgf180mcu_as_sc_mcu7t3v3__inv_2_1172 VSS VSS gf180mcu_as_sc_mcu7t3v3__inv_2_1172/Y
+ gf180mcu_as_sc_mcu7t3v3__inv_2_1172/A gf180mcu_as_sc_mcu7t3v3__inv_2_1294/VNW VSUBS
+ gf180mcu_as_sc_mcu7t3v3__inv_2
Xgf180mcu_as_sc_mcu7t3v3__inv_2_1183 VSS VSS gf180mcu_as_sc_mcu7t3v3__inv_2_1183/Y
+ gf180mcu_as_sc_mcu7t3v3__inv_2_1183/A gf180mcu_as_sc_mcu7t3v3__inv_2_1300/VNW VSUBS
+ gf180mcu_as_sc_mcu7t3v3__inv_2
Xu_t008_008 u_t008_008/c0_w0_bl u_t008_008/c0_w0_br u_t008_008/c0_w1_bl u_t008_008/c0_w1_br
+ u_t008_008/c0_r0_rbl u_t008_008/c0_r1_rbl u_t008_008/c1_w0_bl u_t008_008/c1_w0_br
+ u_t008_008/c1_w1_bl u_t008_008/c1_w1_br u_t008_008/c1_r0_rbl u_t008_008/c1_r1_rbl
+ u_t008_008/c2_w0_bl u_t008_008/c2_w0_br u_t008_008/c2_w1_bl u_t008_008/c2_w1_br
+ u_t008_008/c2_r0_rbl u_t008_008/c2_r1_rbl u_t008_008/c3_w0_bl u_t008_008/c3_w0_br
+ u_t008_008/c3_w1_bl u_t008_008/c3_w1_br u_t008_008/c3_r0_rbl u_t008_008/c3_r1_rbl
+ u_t008_008/r0_w0_wl u_t008_008/r0_w1_wl u_t008_008/r0_r0_rwl u_t008_008/r0_r1_rwl
+ u_t008_008/r1_w0_wl u_t008_008/r1_w1_wl u_t008_008/r1_r0_rwl u_t008_008/r1_r1_rwl
+ u_t008_008/r2_w0_wl u_t008_008/r2_w1_wl u_t008_008/r2_r0_rwl u_t008_008/r2_r1_rwl
+ u_t008_008/r3_w0_wl u_t008_008/r3_w1_wl u_t008_008/r3_r0_rwl u_t008_008/r3_r1_rwl
+ VSS VSS u_t008_008/m2_717_1265# u_t008_008/m2_603_2031# u_t008_008/m2_1290_336#
+ u_t008_008/m2_2000_2037# u_t008_008/m2_791_2909# u_t008_008/m2_7_2126# u_t008_008/m2_2154_2081#
+ u_t008_008/m2_1795_2037# u_t008_008/m2_871_303# u_t008_008/m2_431_438# u_t008_008/m2_1290_2898#
+ u_t008_008/m2_1714_1210# u_t008_008/m2_431_1982# u_t008_008/m2_512_1265# u_t008_008/m2_2573_2126#
+ u_t008_008/m2_603_1259# u_t008_008/m2_2074_2909# u_t008_008/m2_7_336# u_t008_008/m2_717_2037#
+ u_t008_008/m2_1886_2031# u_t008_008/m2_2573_336# u_t008_008/m2_7_2898# u_t008_008/m2_2000_1265#
+ u_t008_008/m2_512_2037# u_t008_008/m2_1795_1265# u_t008_008/m2_1714_1982# u_t008_008/m2_1886_1259#
+ u_t008_008/m2_1290_2126# u_t008_008/m2_1714_438# u_t008_008/m2_431_1210# u_t008_008/m2_2573_2898#
+ u_t008_008/m2_2154_303# u_t008_008/m2_871_2081# VSUBS detronyx_12t_2w2r_rc4_4x4_routed_5layer_direct
Xu_t031_011 u_t031_011/c0_w0_bl u_t031_011/c0_w0_br u_t031_011/c0_w1_bl u_t031_011/c0_w1_br
+ u_t031_011/c0_r0_rbl u_t031_011/c0_r1_rbl u_t031_011/c1_w0_bl u_t031_011/c1_w0_br
+ u_t031_011/c1_w1_bl u_t031_011/c1_w1_br u_t031_011/c1_r0_rbl u_t031_011/c1_r1_rbl
+ u_t031_011/c2_w0_bl u_t031_011/c2_w0_br u_t031_011/c2_w1_bl u_t031_011/c2_w1_br
+ u_t031_011/c2_r0_rbl u_t031_011/c2_r1_rbl u_t031_011/c3_w0_bl u_t031_011/c3_w0_br
+ u_t031_011/c3_w1_bl u_t031_011/c3_w1_br u_t031_011/c3_r0_rbl u_t031_011/c3_r1_rbl
+ u_t031_011/r0_w0_wl u_t031_011/r0_w1_wl u_t031_011/r0_r0_rwl u_t031_011/r0_r1_rwl
+ u_t031_011/r1_w0_wl u_t031_011/r1_w1_wl u_t031_011/r1_r0_rwl u_t031_011/r1_r1_rwl
+ u_t031_011/r2_w0_wl u_t031_011/r2_w1_wl u_t031_011/r2_r0_rwl u_t031_011/r2_r1_rwl
+ u_t031_011/r3_w0_wl u_t031_011/r3_w1_wl u_t031_011/r3_r0_rwl u_t031_011/r3_r1_rwl
+ VSS VSS u_t031_011/m2_717_1265# u_t031_011/m2_603_2031# u_t031_011/m2_1290_336#
+ u_t031_011/m2_2000_2037# u_t031_011/m2_791_2909# u_t031_011/m2_7_2126# u_t031_011/m2_2154_2081#
+ u_t031_011/m2_1795_2037# u_t031_011/m2_871_303# u_t031_011/m2_431_438# u_t031_011/m2_1290_2898#
+ u_t031_011/m2_1714_1210# u_t031_011/m2_431_1982# u_t031_011/m2_512_1265# u_t031_011/m2_2573_2126#
+ u_t031_011/m2_603_1259# u_t031_011/m2_2074_2909# u_t031_011/m2_7_336# u_t031_011/m2_717_2037#
+ u_t031_011/m2_1886_2031# u_t031_011/m2_2573_336# u_t031_011/m2_7_2898# u_t031_011/m2_2000_1265#
+ u_t031_011/m2_512_2037# u_t031_011/m2_1795_1265# u_t031_011/m2_1714_1982# u_t031_011/m2_1886_1259#
+ u_t031_011/m2_1290_2126# u_t031_011/m2_1714_438# u_t031_011/m2_431_1210# u_t031_011/m2_2573_2898#
+ u_t031_011/m2_2154_303# u_t031_011/m2_871_2081# VSUBS detronyx_12t_2w2r_rc4_4x4_routed_5layer_direct
Xu_t031_000 VSS u_t031_000/c0_w0_br VSS u_t031_000/c0_w1_br u_t031_000/c0_r0_rbl u_t031_000/c0_r1_rbl
+ VSS VSS VSS VSS VSS VSS u_t031_000/c2_w0_bl u_t031_000/c2_w0_br u_t031_000/c2_w1_bl
+ u_t031_000/c2_w1_br u_t031_000/c2_r0_rbl u_t031_000/c2_r1_rbl u_t031_000/c3_w0_bl
+ u_t031_000/c3_w0_br u_t031_000/c3_w1_bl u_t031_000/c3_w1_br u_t031_000/c3_r0_rbl
+ u_t031_000/c3_r1_rbl VSS VSS VSS VSS VSS VSS VSS VSS VSS VSS VSS VSS VSS VSS VSS
+ VSS VSS VSS u_t031_000/m2_717_1265# VSS VSS VSS VSS u_t031_000/m2_7_2126# VSS VSS
+ VSS VSS VSS VSS VSS u_t031_000/m2_512_1265# VSS u_t031_000/m2_603_1259# VSS VSS
+ VSS VSS VSS VSS u_t031_000/m2_2000_1265# VSS u_t031_000/m2_1795_1265# VSS u_t031_000/m2_1886_1259#
+ u_t031_000/m2_1290_2126# VSS VSS VSS VSS VSS VSUBS detronyx_12t_2w2r_rc4_4x4_routed_5layer_direct
Xgf180mcu_as_sc_mcu7t3v3__inv_2_612 VSS VSS VSS gf180mcu_as_sc_mcu7t3v3__inv_2_613/Y
+ gf180mcu_as_sc_mcu7t3v3__inv_2_617/VNW VSUBS gf180mcu_as_sc_mcu7t3v3__inv_2
Xgf180mcu_as_sc_mcu7t3v3__inv_2_601 VSS VSS gf180mcu_as_sc_mcu7t3v3__inv_2_601/Y gf180mcu_as_sc_mcu7t3v3__inv_2_602/Y
+ gf180mcu_as_sc_mcu7t3v3__inv_2_602/VNW VSUBS gf180mcu_as_sc_mcu7t3v3__inv_2
Xgf180mcu_as_sc_mcu7t3v3__inv_2_634 VSS VSS VSS gf180mcu_as_sc_mcu7t3v3__inv_2_635/Y
+ gf180mcu_as_sc_mcu7t3v3__inv_2_636/VNW VSUBS gf180mcu_as_sc_mcu7t3v3__inv_2
Xgf180mcu_as_sc_mcu7t3v3__inv_2_623 VSS VSS gf180mcu_as_sc_mcu7t3v3__inv_2_623/Y gf180mcu_as_sc_mcu7t3v3__inv_2_624/Y
+ gf180mcu_as_sc_mcu7t3v3__inv_2_624/VNW VSUBS gf180mcu_as_sc_mcu7t3v3__inv_2
Xgf180mcu_as_sc_mcu7t3v3__inv_2_656 VSS VSS gf180mcu_as_sc_mcu7t3v3__inv_2_656/Y gf180mcu_as_sc_mcu7t3v3__inv_2_656/A
+ gf180mcu_as_sc_mcu7t3v3__inv_2_656/VNW VSUBS gf180mcu_as_sc_mcu7t3v3__inv_2
Xgf180mcu_as_sc_mcu7t3v3__inv_2_667 VSS VSS gf180mcu_as_sc_mcu7t3v3__inv_2_667/Y gf180mcu_as_sc_mcu7t3v3__inv_2_680/Y
+ gf180mcu_as_sc_mcu7t3v3__inv_2_680/VNW VSUBS gf180mcu_as_sc_mcu7t3v3__inv_2
Xgf180mcu_as_sc_mcu7t3v3__inv_2_645 VSS VSS gf180mcu_as_sc_mcu7t3v3__inv_2_645/Y gf180mcu_as_sc_mcu7t3v3__inv_2_646/Y
+ gf180mcu_as_sc_mcu7t3v3__inv_2_646/VNW VSUBS gf180mcu_as_sc_mcu7t3v3__inv_2
Xgf180mcu_as_sc_mcu7t3v3__inv_2_689 VSS VSS gf180mcu_as_sc_mcu7t3v3__inv_2_689/Y gf180mcu_as_sc_mcu7t3v3__inv_2_689/A
+ gf180mcu_as_sc_mcu7t3v3__inv_2_689/VNW VSUBS gf180mcu_as_sc_mcu7t3v3__inv_2
Xgf180mcu_as_sc_mcu7t3v3__inv_2_678 VSS VSS gf180mcu_as_sc_mcu7t3v3__inv_2_678/Y gf180mcu_as_sc_mcu7t3v3__inv_2_678/A
+ gf180mcu_as_sc_mcu7t3v3__inv_2_678/VNW VSUBS gf180mcu_as_sc_mcu7t3v3__inv_2
Xu_t022_011 u_t022_011/c0_w0_bl u_t022_011/c0_w0_br u_t022_011/c0_w1_bl u_t022_011/c0_w1_br
+ u_t022_011/c0_r0_rbl u_t022_011/c0_r1_rbl u_t022_011/c1_w0_bl u_t022_011/c1_w0_br
+ u_t022_011/c1_w1_bl u_t022_011/c1_w1_br u_t022_011/c1_r0_rbl u_t022_011/c1_r1_rbl
+ u_t022_011/c2_w0_bl u_t022_011/c2_w0_br u_t022_011/c2_w1_bl u_t022_011/c2_w1_br
+ u_t022_011/c2_r0_rbl u_t022_011/c2_r1_rbl u_t022_011/c3_w0_bl u_t022_011/c3_w0_br
+ u_t022_011/c3_w1_bl u_t022_011/c3_w1_br u_t022_011/c3_r0_rbl u_t022_011/c3_r1_rbl
+ u_t022_011/r0_w0_wl u_t022_011/r0_w1_wl u_t022_011/r0_r0_rwl u_t022_011/r0_r1_rwl
+ u_t022_011/r1_w0_wl u_t022_011/r1_w1_wl u_t022_011/r1_r0_rwl u_t022_011/r1_r1_rwl
+ u_t022_011/r2_w0_wl u_t022_011/r2_w1_wl u_t022_011/r2_r0_rwl u_t022_011/r2_r1_rwl
+ u_t022_011/r3_w0_wl u_t022_011/r3_w1_wl u_t022_011/r3_r0_rwl u_t022_011/r3_r1_rwl
+ VSS VSS u_t022_011/m2_717_1265# u_t022_011/m2_603_2031# u_t022_011/m2_1290_336#
+ u_t022_011/m2_2000_2037# u_t022_011/m2_791_2909# u_t022_011/m2_7_2126# u_t022_011/m2_2154_2081#
+ u_t022_011/m2_1795_2037# u_t022_011/m2_871_303# u_t022_011/m2_431_438# u_t022_011/m2_1290_2898#
+ u_t022_011/m2_1714_1210# u_t022_011/m2_431_1982# u_t022_011/m2_512_1265# u_t022_011/m2_2573_2126#
+ u_t022_011/m2_603_1259# u_t022_011/m2_2074_2909# u_t022_011/m2_7_336# u_t022_011/m2_717_2037#
+ u_t022_011/m2_1886_2031# u_t022_011/m2_2573_336# u_t022_011/m2_7_2898# u_t022_011/m2_2000_1265#
+ u_t022_011/m2_512_2037# u_t022_011/m2_1795_1265# u_t022_011/m2_1714_1982# u_t022_011/m2_1886_1259#
+ u_t022_011/m2_1290_2126# u_t022_011/m2_1714_438# u_t022_011/m2_431_1210# u_t022_011/m2_2573_2898#
+ u_t022_011/m2_2154_303# u_t022_011/m2_871_2081# VSUBS detronyx_12t_2w2r_rc4_4x4_routed_5layer_direct
Xu_t022_000 VSS u_t022_000/c0_w0_br VSS u_t022_000/c0_w1_br u_t022_000/c0_r0_rbl u_t022_000/c0_r1_rbl
+ VSS VSS VSS VSS VSS VSS u_t022_000/c2_w0_bl u_t022_000/c2_w0_br u_t022_000/c2_w1_bl
+ u_t022_000/c2_w1_br u_t022_000/c2_r0_rbl u_t022_000/c2_r1_rbl u_t022_000/c3_w0_bl
+ u_t022_000/c3_w0_br u_t022_000/c3_w1_bl u_t022_000/c3_w1_br u_t022_000/c3_r0_rbl
+ u_t022_000/c3_r1_rbl VSS VSS VSS VSS VSS VSS VSS VSS VSS VSS VSS VSS VSS VSS VSS
+ VSS VSS VSS u_t022_000/m2_717_1265# VSS VSS VSS VSS VSS VSS VSS VSS VSS VSS VSS
+ VSS u_t022_000/m2_512_1265# u_t022_000/m2_2573_2126# VSS VSS VSS VSS VSS u_t022_000/m2_2573_336#
+ VSS u_t022_000/m2_2000_1265# VSS u_t022_000/m2_1795_1265# VSS VSS VSS VSS VSS u_t022_000/m2_2573_2898#
+ VSS VSS VSUBS detronyx_12t_2w2r_rc4_4x4_routed_5layer_direct
Xu_t013_011 u_t013_011/c0_w0_bl u_t013_011/c0_w0_br u_t013_011/c0_w1_bl u_t013_011/c0_w1_br
+ u_t013_011/c0_r0_rbl u_t013_011/c0_r1_rbl u_t013_011/c1_w0_bl u_t013_011/c1_w0_br
+ u_t013_011/c1_w1_bl u_t013_011/c1_w1_br u_t013_011/c1_r0_rbl u_t013_011/c1_r1_rbl
+ u_t013_011/c2_w0_bl u_t013_011/c2_w0_br u_t013_011/c2_w1_bl u_t013_011/c2_w1_br
+ u_t013_011/c2_r0_rbl u_t013_011/c2_r1_rbl u_t013_011/c3_w0_bl u_t013_011/c3_w0_br
+ u_t013_011/c3_w1_bl u_t013_011/c3_w1_br u_t013_011/c3_r0_rbl u_t013_011/c3_r1_rbl
+ u_t013_011/r0_w0_wl u_t013_011/r0_w1_wl u_t013_011/r0_r0_rwl u_t013_011/r0_r1_rwl
+ u_t013_011/r1_w0_wl u_t013_011/r1_w1_wl u_t013_011/r1_r0_rwl u_t013_011/r1_r1_rwl
+ u_t013_011/r2_w0_wl u_t013_011/r2_w1_wl u_t013_011/r2_r0_rwl u_t013_011/r2_r1_rwl
+ u_t013_011/r3_w0_wl u_t013_011/r3_w1_wl u_t013_011/r3_r0_rwl u_t013_011/r3_r1_rwl
+ VSS VSS u_t013_011/m2_717_1265# u_t013_011/m2_603_2031# u_t013_011/m2_1290_336#
+ u_t013_011/m2_2000_2037# u_t013_011/m2_791_2909# u_t013_011/m2_7_2126# u_t013_011/m2_2154_2081#
+ u_t013_011/m2_1795_2037# u_t013_011/m2_871_303# u_t013_011/m2_431_438# u_t013_011/m2_1290_2898#
+ u_t013_011/m2_1714_1210# u_t013_011/m2_431_1982# u_t013_011/m2_512_1265# u_t013_011/m2_2573_2126#
+ u_t013_011/m2_603_1259# u_t013_011/m2_2074_2909# u_t013_011/m2_7_336# u_t013_011/m2_717_2037#
+ u_t013_011/m2_1886_2031# u_t013_011/m2_2573_336# u_t013_011/m2_7_2898# u_t013_011/m2_2000_1265#
+ u_t013_011/m2_512_2037# u_t013_011/m2_1795_1265# u_t013_011/m2_1714_1982# u_t013_011/m2_1886_1259#
+ u_t013_011/m2_1290_2126# u_t013_011/m2_1714_438# u_t013_011/m2_431_1210# u_t013_011/m2_2573_2898#
+ u_t013_011/m2_2154_303# u_t013_011/m2_871_2081# VSUBS detronyx_12t_2w2r_rc4_4x4_routed_5layer_direct
Xu_t013_000 VSS u_t013_000/c0_w0_br VSS u_t013_000/c0_w1_br u_t013_000/c0_r0_rbl u_t013_000/c0_r1_rbl
+ VSS VSS VSS VSS VSS VSS u_t013_000/c2_w0_bl u_t013_000/c2_w0_br u_t013_000/c2_w1_bl
+ u_t013_000/c2_w1_br u_t013_000/c2_r0_rbl u_t013_000/c2_r1_rbl u_t013_000/c3_w0_bl
+ u_t013_000/c3_w0_br u_t013_000/c3_w1_bl u_t013_000/c3_w1_br u_t013_000/c3_r0_rbl
+ u_t013_000/c3_r1_rbl VSS VSS VSS VSS VSS VSS VSS VSS VSS VSS VSS VSS VSS VSS VSS
+ VSS VSS VSS u_t013_000/m2_717_1265# u_t013_000/m2_603_2031# u_t013_000/m2_1290_336#
+ u_t013_000/m2_2000_2037# u_t013_000/m2_791_2909# u_t013_000/m2_7_2126# u_t013_000/m2_2154_2081#
+ u_t013_000/m2_1795_2037# u_t013_000/m2_871_303# u_t013_000/m2_431_438# u_t013_000/m2_1290_2898#
+ u_t013_000/m2_1714_1210# u_t013_000/m2_431_1982# u_t013_000/m2_512_1265# u_t013_000/m2_2573_2126#
+ u_t013_000/m2_603_1259# u_t013_000/m2_2074_2909# u_t013_000/m2_7_336# u_t013_000/m2_717_2037#
+ u_t013_000/m2_1886_2031# u_t013_000/m2_2573_336# u_t013_000/m2_7_2898# u_t013_000/m2_2000_1265#
+ u_t013_000/m2_512_2037# u_t013_000/m2_1795_1265# u_t013_000/m2_1714_1982# u_t013_000/m2_1886_1259#
+ u_t013_000/m2_1290_2126# u_t013_000/m2_1714_438# u_t013_000/m2_431_1210# u_t013_000/m2_2573_2898#
+ u_t013_000/m2_2154_303# u_t013_000/m2_871_2081# VSUBS detronyx_12t_2w2r_rc4_4x4_routed_5layer_direct
Xgf180mcu_as_sc_mcu7t3v3__inv_2_420 gf180mcu_as_sc_mcu7t3v3__nor2_2_6/VDD gf180mcu_as_sc_mcu7t3v3__nand3_2_4/VSS
+ gf180mcu_as_sc_mcu7t3v3__inv_2_420/Y VSS gf180mcu_as_sc_mcu7t3v3__nor2_2_6/VNW VSUBS
+ gf180mcu_as_sc_mcu7t3v3__inv_2
Xu_t004_011 u_t004_011/c0_w0_bl u_t004_011/c0_w0_br u_t004_011/c0_w1_bl u_t004_011/c0_w1_br
+ u_t004_011/c0_r0_rbl u_t004_011/c0_r1_rbl u_t004_011/c1_w0_bl u_t004_011/c1_w0_br
+ u_t004_011/c1_w1_bl u_t004_011/c1_w1_br u_t004_011/c1_r0_rbl u_t004_011/c1_r1_rbl
+ u_t004_011/c2_w0_bl u_t004_011/c2_w0_br u_t004_011/c2_w1_bl u_t004_011/c2_w1_br
+ u_t004_011/c2_r0_rbl u_t004_011/c2_r1_rbl u_t004_011/c3_w0_bl u_t004_011/c3_w0_br
+ u_t004_011/c3_w1_bl u_t004_011/c3_w1_br u_t004_011/c3_r0_rbl u_t004_011/c3_r1_rbl
+ u_t004_011/r0_w0_wl u_t004_011/r0_w1_wl u_t004_011/r0_r0_rwl u_t004_011/r0_r1_rwl
+ u_t004_011/r1_w0_wl u_t004_011/r1_w1_wl u_t004_011/r1_r0_rwl u_t004_011/r1_r1_rwl
+ u_t004_011/r2_w0_wl u_t004_011/r2_w1_wl u_t004_011/r2_r0_rwl u_t004_011/r2_r1_rwl
+ u_t004_011/r3_w0_wl u_t004_011/r3_w1_wl u_t004_011/r3_r0_rwl u_t004_011/r3_r1_rwl
+ VSS VSS u_t004_011/m2_717_1265# u_t004_011/m2_603_2031# u_t004_011/m2_1290_336#
+ u_t004_011/m2_2000_2037# u_t004_011/m2_791_2909# u_t004_011/m2_7_2126# u_t004_011/m2_2154_2081#
+ u_t004_011/m2_1795_2037# u_t004_011/m2_871_303# u_t004_011/m2_431_438# u_t004_011/m2_1290_2898#
+ u_t004_011/m2_1714_1210# u_t004_011/m2_431_1982# u_t004_011/m2_512_1265# u_t004_011/m2_2573_2126#
+ u_t004_011/m2_603_1259# u_t004_011/m2_2074_2909# u_t004_011/m2_7_336# u_t004_011/m2_717_2037#
+ u_t004_011/m2_1886_2031# u_t004_011/m2_2573_336# u_t004_011/m2_7_2898# u_t004_011/m2_2000_1265#
+ u_t004_011/m2_512_2037# u_t004_011/m2_1795_1265# u_t004_011/m2_1714_1982# u_t004_011/m2_1886_1259#
+ u_t004_011/m2_1290_2126# u_t004_011/m2_1714_438# u_t004_011/m2_431_1210# u_t004_011/m2_2573_2898#
+ u_t004_011/m2_2154_303# u_t004_011/m2_871_2081# VSUBS detronyx_12t_2w2r_rc4_4x4_routed_5layer_direct
Xgf180mcu_as_sc_mcu7t3v3__inv_2_442 VSS VSS gf180mcu_as_sc_mcu7t3v3__inv_2_442/Y gf180mcu_as_sc_mcu7t3v3__inv_2_442/A
+ gf180mcu_as_sc_mcu7t3v3__inv_2_543/VNW VSUBS gf180mcu_as_sc_mcu7t3v3__inv_2
Xgf180mcu_as_sc_mcu7t3v3__inv_2_453 VSS VSS gf180mcu_as_sc_mcu7t3v3__inv_2_453/Y gf180mcu_as_sc_mcu7t3v3__inv_2_453/A
+ gf180mcu_as_sc_mcu7t3v3__inv_2_546/VNW VSUBS gf180mcu_as_sc_mcu7t3v3__inv_2
Xgf180mcu_as_sc_mcu7t3v3__inv_2_486 VSS VSS gf180mcu_as_sc_mcu7t3v3__inv_2_550/A gf180mcu_as_sc_mcu7t3v3__inv_2_487/Y
+ gf180mcu_as_sc_mcu7t3v3__inv_2_550/VNW VSUBS gf180mcu_as_sc_mcu7t3v3__inv_2
Xgf180mcu_as_sc_mcu7t3v3__inv_2_475 gf180mcu_as_sc_mcu7t3v3__nor2_2_7/VDD gf180mcu_as_sc_mcu7t3v3__nand3_2_4/VSS
+ VSS VSS gf180mcu_as_sc_mcu7t3v3__nor2_2_7/VNW VSUBS gf180mcu_as_sc_mcu7t3v3__inv_2
Xgf180mcu_as_sc_mcu7t3v3__inv_2_431 gf180mcu_as_sc_mcu7t3v3__nor2_2_4/VDD gf180mcu_as_sc_mcu7t3v3__nand2_2_3/VSS
+ gf180mcu_as_sc_mcu7t3v3__inv_2_431/Y VSS gf180mcu_as_sc_mcu7t3v3__nor2_2_4/VNW VSUBS
+ gf180mcu_as_sc_mcu7t3v3__inv_2
Xgf180mcu_as_sc_mcu7t3v3__inv_2_464 gf180mcu_as_sc_mcu7t3v3__nand3_2_9/VDD gf180mcu_as_sc_mcu7t3v3__nor2_2_7/VSS
+ VSS VSS gf180mcu_as_sc_mcu7t3v3__nand3_2_9/VNW VSUBS gf180mcu_as_sc_mcu7t3v3__inv_2
Xgf180mcu_as_sc_mcu7t3v3__inv_2_497 VSS VSS gf180mcu_as_sc_mcu7t3v3__inv_2_497/Y gf180mcu_as_sc_mcu7t3v3__inv_2_497/A
+ gf180mcu_as_sc_mcu7t3v3__inv_2_555/VNW VSUBS gf180mcu_as_sc_mcu7t3v3__inv_2
Xu_t004_000 VSS u_t004_000/c0_w0_br VSS u_t004_000/c0_w1_br u_t004_000/c0_r0_rbl u_t004_000/c0_r1_rbl
+ VSS VSS VSS VSS VSS VSS u_t004_000/c2_w0_bl u_t004_000/c2_w0_br u_t004_000/c2_w1_bl
+ u_t004_000/c2_w1_br u_t004_000/c2_r0_rbl u_t004_000/c2_r1_rbl u_t004_000/c3_w0_bl
+ u_t004_000/c3_w0_br u_t004_000/c3_w1_bl u_t004_000/c3_w1_br u_t004_000/c3_r0_rbl
+ u_t004_000/c3_r1_rbl VSS VSS VSS VSS VSS VSS VSS VSS VSS VSS VSS VSS VSS VSS VSS
+ VSS VSS VSS u_t004_000/m2_717_1265# u_t004_000/m2_603_2031# u_t004_000/m2_1290_336#
+ u_t004_000/m2_2000_2037# u_t004_000/m2_791_2909# u_t004_000/m2_7_2126# u_t004_000/m2_2154_2081#
+ u_t004_000/m2_1795_2037# u_t004_000/m2_871_303# u_t004_000/m2_431_438# u_t004_000/m2_1290_2898#
+ u_t004_000/m2_1714_1210# u_t004_000/m2_431_1982# u_t004_000/m2_512_1265# u_t004_000/m2_2573_2126#
+ u_t004_000/m2_603_1259# u_t004_000/m2_2074_2909# u_t004_000/m2_7_336# u_t004_000/m2_717_2037#
+ u_t004_000/m2_1886_2031# u_t004_000/m2_2573_336# u_t004_000/m2_7_2898# u_t004_000/m2_2000_1265#
+ u_t004_000/m2_512_2037# u_t004_000/m2_1795_1265# u_t004_000/m2_1714_1982# u_t004_000/m2_1886_1259#
+ u_t004_000/m2_1290_2126# u_t004_000/m2_1714_438# u_t004_000/m2_431_1210# u_t004_000/m2_2573_2898#
+ u_t004_000/m2_2154_303# u_t004_000/m2_871_2081# VSUBS detronyx_12t_2w2r_rc4_4x4_routed_5layer_direct
Xu_t010_014 u_t010_014/c0_w0_bl u_t010_014/c0_w0_br u_t010_014/c0_w1_bl u_t010_014/c0_w1_br
+ u_t010_014/c0_r0_rbl u_t010_014/c0_r1_rbl u_t010_014/c1_w0_bl u_t010_014/c1_w0_br
+ u_t010_014/c1_w1_bl u_t010_014/c1_w1_br u_t010_014/c1_r0_rbl u_t010_014/c1_r1_rbl
+ u_t010_014/c2_w0_bl u_t010_014/c2_w0_br u_t010_014/c2_w1_bl u_t010_014/c2_w1_br
+ u_t010_014/c2_r0_rbl u_t010_014/c2_r1_rbl u_t010_014/c3_w0_bl u_t010_014/c3_w0_br
+ u_t010_014/c3_w1_bl u_t010_014/c3_w1_br u_t010_014/c3_r0_rbl u_t010_014/c3_r1_rbl
+ u_t010_014/r0_w0_wl u_t010_014/r0_w1_wl u_t010_014/r0_r0_rwl u_t010_014/r0_r1_rwl
+ u_t010_014/r1_w0_wl u_t010_014/r1_w1_wl u_t010_014/r1_r0_rwl u_t010_014/r1_r1_rwl
+ u_t010_014/r2_w0_wl u_t010_014/r2_w1_wl u_t010_014/r2_r0_rwl u_t010_014/r2_r1_rwl
+ u_t010_014/r3_w0_wl u_t010_014/r3_w1_wl u_t010_014/r3_r0_rwl u_t010_014/r3_r1_rwl
+ VSS VSS u_t010_014/m2_717_1265# u_t010_014/m2_603_2031# u_t010_014/m2_1290_336#
+ u_t010_014/m2_2000_2037# u_t010_014/m2_791_2909# u_t010_014/m2_7_2126# u_t010_014/m2_2154_2081#
+ u_t010_014/m2_1795_2037# u_t010_014/m2_871_303# u_t010_014/m2_431_438# u_t010_014/m2_1290_2898#
+ u_t010_014/m2_1714_1210# u_t010_014/m2_431_1982# u_t010_014/m2_512_1265# u_t010_014/m2_2573_2126#
+ u_t010_014/m2_603_1259# u_t010_014/m2_2074_2909# u_t010_014/m2_7_336# u_t010_014/m2_717_2037#
+ u_t010_014/m2_1886_2031# u_t010_014/m2_2573_336# u_t010_014/m2_7_2898# u_t010_014/m2_2000_1265#
+ u_t010_014/m2_512_2037# u_t010_014/m2_1795_1265# u_t010_014/m2_1714_1982# u_t010_014/m2_1886_1259#
+ u_t010_014/m2_1290_2126# u_t010_014/m2_1714_438# u_t010_014/m2_431_1210# u_t010_014/m2_2573_2898#
+ u_t010_014/m2_2154_303# u_t010_014/m2_871_2081# VSUBS detronyx_12t_2w2r_rc4_4x4_routed_5layer_direct
Xu_t010_003 u_t010_003/c0_w0_bl u_t010_003/c0_w0_br u_t010_003/c0_w1_bl u_t010_003/c0_w1_br
+ u_t010_003/c0_r0_rbl u_t010_003/c0_r1_rbl u_t010_003/c1_w0_bl u_t010_003/c1_w0_br
+ u_t010_003/c1_w1_bl u_t010_003/c1_w1_br u_t010_003/c1_r0_rbl u_t010_003/c1_r1_rbl
+ u_t010_003/c2_w0_bl u_t010_003/c2_w0_br u_t010_003/c2_w1_bl u_t010_003/c2_w1_br
+ u_t010_003/c2_r0_rbl u_t010_003/c2_r1_rbl u_t010_003/c3_w0_bl u_t010_003/c3_w0_br
+ u_t010_003/c3_w1_bl u_t010_003/c3_w1_br u_t010_003/c3_r0_rbl u_t010_003/c3_r1_rbl
+ u_t010_003/r0_w0_wl u_t010_003/r0_w1_wl u_t010_003/r0_r0_rwl u_t010_003/r0_r1_rwl
+ u_t010_003/r1_w0_wl u_t010_003/r1_w1_wl u_t010_003/r1_r0_rwl u_t010_003/r1_r1_rwl
+ u_t010_003/r2_w0_wl u_t010_003/r2_w1_wl u_t010_003/r2_r0_rwl u_t010_003/r2_r1_rwl
+ u_t010_003/r3_w0_wl u_t010_003/r3_w1_wl u_t010_003/r3_r0_rwl u_t010_003/r3_r1_rwl
+ VSS VSS u_t010_003/m2_717_1265# u_t010_003/m2_603_2031# u_t010_003/m2_1290_336#
+ u_t010_003/m2_2000_2037# u_t010_003/m2_791_2909# u_t010_003/m2_7_2126# u_t010_003/m2_2154_2081#
+ u_t010_003/m2_1795_2037# u_t010_003/m2_871_303# u_t010_003/m2_431_438# u_t010_003/m2_1290_2898#
+ u_t010_003/m2_1714_1210# u_t010_003/m2_431_1982# u_t010_003/m2_512_1265# u_t010_003/m2_2573_2126#
+ u_t010_003/m2_603_1259# u_t010_003/m2_2074_2909# u_t010_003/m2_7_336# u_t010_003/m2_717_2037#
+ u_t010_003/m2_1886_2031# u_t010_003/m2_2573_336# u_t010_003/m2_7_2898# u_t010_003/m2_2000_1265#
+ u_t010_003/m2_512_2037# u_t010_003/m2_1795_1265# u_t010_003/m2_1714_1982# u_t010_003/m2_1886_1259#
+ u_t010_003/m2_1290_2126# u_t010_003/m2_1714_438# u_t010_003/m2_431_1210# u_t010_003/m2_2573_2898#
+ u_t010_003/m2_2154_303# u_t010_003/m2_871_2081# VSUBS detronyx_12t_2w2r_rc4_4x4_routed_5layer_direct
Xu_t001_014 u_t001_014/c0_w0_bl u_t001_014/c0_w0_br u_t001_014/c0_w1_bl u_t001_014/c0_w1_br
+ u_t001_014/c0_r0_rbl u_t001_014/c0_r1_rbl u_t001_014/c1_w0_bl u_t001_014/c1_w0_br
+ u_t001_014/c1_w1_bl u_t001_014/c1_w1_br u_t001_014/c1_r0_rbl u_t001_014/c1_r1_rbl
+ u_t001_014/c2_w0_bl u_t001_014/c2_w0_br u_t001_014/c2_w1_bl u_t001_014/c2_w1_br
+ u_t001_014/c2_r0_rbl u_t001_014/c2_r1_rbl u_t001_014/c3_w0_bl u_t001_014/c3_w0_br
+ u_t001_014/c3_w1_bl u_t001_014/c3_w1_br u_t001_014/c3_r0_rbl u_t001_014/c3_r1_rbl
+ u_t001_014/r0_w0_wl u_t001_014/r0_w1_wl u_t001_014/r0_r0_rwl u_t001_014/r0_r1_rwl
+ u_t001_014/r1_w0_wl u_t001_014/r1_w1_wl u_t001_014/r1_r0_rwl u_t001_014/r1_r1_rwl
+ u_t001_014/r2_w0_wl u_t001_014/r2_w1_wl u_t001_014/r2_r0_rwl u_t001_014/r2_r1_rwl
+ u_t001_014/r3_w0_wl u_t001_014/r3_w1_wl u_t001_014/r3_r0_rwl u_t001_014/r3_r1_rwl
+ VSS VSS u_t001_014/m2_717_1265# u_t001_014/m2_603_2031# u_t001_014/m2_1290_336#
+ u_t001_014/m2_2000_2037# u_t001_014/m2_791_2909# u_t001_014/m2_7_2126# u_t001_014/m2_2154_2081#
+ u_t001_014/m2_1795_2037# u_t001_014/m2_871_303# u_t001_014/m2_431_438# u_t001_014/m2_1290_2898#
+ u_t001_014/m2_1714_1210# u_t001_014/m2_431_1982# u_t001_014/m2_512_1265# u_t001_014/m2_2573_2126#
+ u_t001_014/m2_603_1259# u_t001_014/m2_2074_2909# u_t001_014/m2_7_336# u_t001_014/m2_717_2037#
+ u_t001_014/m2_1886_2031# u_t001_014/m2_2573_336# u_t001_014/m2_7_2898# u_t001_014/m2_2000_1265#
+ u_t001_014/m2_512_2037# u_t001_014/m2_1795_1265# u_t001_014/m2_1714_1982# u_t001_014/m2_1886_1259#
+ u_t001_014/m2_1290_2126# u_t001_014/m2_1714_438# u_t001_014/m2_431_1210# u_t001_014/m2_2573_2898#
+ u_t001_014/m2_2154_303# u_t001_014/m2_871_2081# VSUBS detronyx_12t_2w2r_rc4_4x4_routed_5layer_direct
Xu_t001_003 u_t001_003/c0_w0_bl u_t001_003/c0_w0_br u_t001_003/c0_w1_bl u_t001_003/c0_w1_br
+ u_t001_003/c0_r0_rbl u_t001_003/c0_r1_rbl u_t001_003/c1_w0_bl u_t001_003/c1_w0_br
+ u_t001_003/c1_w1_bl u_t001_003/c1_w1_br u_t001_003/c1_r0_rbl u_t001_003/c1_r1_rbl
+ u_t001_003/c2_w0_bl u_t001_003/c2_w0_br u_t001_003/c2_w1_bl u_t001_003/c2_w1_br
+ u_t001_003/c2_r0_rbl u_t001_003/c2_r1_rbl u_t001_003/c3_w0_bl u_t001_003/c3_w0_br
+ u_t001_003/c3_w1_bl u_t001_003/c3_w1_br u_t001_003/c3_r0_rbl u_t001_003/c3_r1_rbl
+ u_t001_003/r0_w0_wl u_t001_003/r0_w1_wl u_t001_003/r0_r0_rwl u_t001_003/r0_r1_rwl
+ u_t001_003/r1_w0_wl u_t001_003/r1_w1_wl u_t001_003/r1_r0_rwl u_t001_003/r1_r1_rwl
+ u_t001_003/r2_w0_wl u_t001_003/r2_w1_wl u_t001_003/r2_r0_rwl u_t001_003/r2_r1_rwl
+ u_t001_003/r3_w0_wl u_t001_003/r3_w1_wl u_t001_003/r3_r0_rwl u_t001_003/r3_r1_rwl
+ VSS VSS u_t001_003/m2_717_1265# u_t001_003/m2_603_2031# u_t001_003/m2_1290_336#
+ u_t001_003/m2_2000_2037# u_t001_003/m2_791_2909# u_t001_003/m2_7_2126# u_t001_003/m2_2154_2081#
+ u_t001_003/m2_1795_2037# u_t001_003/m2_871_303# u_t001_003/m2_431_438# u_t001_003/m2_1290_2898#
+ u_t001_003/m2_1714_1210# u_t001_003/m2_431_1982# u_t001_003/m2_512_1265# u_t001_003/m2_2573_2126#
+ u_t001_003/m2_603_1259# u_t001_003/m2_2074_2909# u_t001_003/m2_7_336# u_t001_003/m2_717_2037#
+ u_t001_003/m2_1886_2031# u_t001_003/m2_2573_336# u_t001_003/m2_7_2898# u_t001_003/m2_2000_1265#
+ u_t001_003/m2_512_2037# u_t001_003/m2_1795_1265# u_t001_003/m2_1714_1982# u_t001_003/m2_1886_1259#
+ u_t001_003/m2_1290_2126# u_t001_003/m2_1714_438# u_t001_003/m2_431_1210# u_t001_003/m2_2573_2898#
+ u_t001_003/m2_2154_303# u_t001_003/m2_871_2081# VSUBS detronyx_12t_2w2r_rc4_4x4_routed_5layer_direct
Xgf180mcu_as_sc_mcu7t3v3__inv_2_261 VSS VSS gf180mcu_as_sc_mcu7t3v3__inv_2_298/A gf180mcu_as_sc_mcu7t3v3__inv_2_261/A
+ gf180mcu_as_sc_mcu7t3v3__inv_2_298/VNW VSUBS gf180mcu_as_sc_mcu7t3v3__inv_2
Xgf180mcu_as_sc_mcu7t3v3__inv_2_250 VSS VSS gf180mcu_as_sc_mcu7t3v3__inv_2_250/Y gf180mcu_as_sc_mcu7t3v3__inv_2_251/Y
+ gf180mcu_as_sc_mcu7t3v3__inv_2_251/VNW VSUBS gf180mcu_as_sc_mcu7t3v3__inv_2
Xgf180mcu_as_sc_mcu7t3v3__inv_2_1705 gf180mcu_as_sc_mcu7t3v3__nor2_2_4/VDD gf180mcu_as_sc_mcu7t3v3__nor2_2_4/VSS
+ VSS VSS gf180mcu_as_sc_mcu7t3v3__nor2_2_4/VNW VSUBS gf180mcu_as_sc_mcu7t3v3__inv_2
Xgf180mcu_as_sc_mcu7t3v3__inv_2_294 VSS VSS gf180mcu_as_sc_mcu7t3v3__inv_2_308/A gf180mcu_as_sc_mcu7t3v3__inv_2_294/A
+ gf180mcu_as_sc_mcu7t3v3__inv_2_308/VNW VSUBS gf180mcu_as_sc_mcu7t3v3__inv_2
Xgf180mcu_as_sc_mcu7t3v3__inv_2_283 VSS VSS gf180mcu_as_sc_mcu7t3v3__inv_2_283/Y gf180mcu_as_sc_mcu7t3v3__inv_2_288/Y
+ gf180mcu_as_sc_mcu7t3v3__inv_2_288/VNW VSUBS gf180mcu_as_sc_mcu7t3v3__inv_2
Xgf180mcu_as_sc_mcu7t3v3__inv_2_272 VSS VSS gf180mcu_as_sc_mcu7t3v3__inv_2_272/Y gf180mcu_as_sc_mcu7t3v3__inv_2_274/Y
+ gf180mcu_as_sc_mcu7t3v3__inv_2_274/VNW VSUBS gf180mcu_as_sc_mcu7t3v3__inv_2
Xgf180mcu_as_sc_mcu7t3v3__inv_2_1716 VSS VSS gf180mcu_as_sc_mcu7t3v3__inv_2_1716/Y
+ gf180mcu_as_sc_mcu7t3v3__inv_2_1717/Y gf180mcu_as_sc_mcu7t3v3__inv_2_1717/VNW VSUBS
+ gf180mcu_as_sc_mcu7t3v3__inv_2
Xgf180mcu_as_sc_mcu7t3v3__inv_2_1568 VSS VSS VSS gf180mcu_as_sc_mcu7t3v3__inv_2_1569/Y
+ gf180mcu_as_sc_mcu7t3v3__inv_2_1570/VNW VSUBS gf180mcu_as_sc_mcu7t3v3__inv_2
Xgf180mcu_as_sc_mcu7t3v3__inv_2_1579 VSS VSS gf180mcu_as_sc_mcu7t3v3__inv_2_1579/Y
+ gf180mcu_as_sc_mcu7t3v3__inv_2_1579/A gf180mcu_as_sc_mcu7t3v3__inv_2_1579/VNW VSUBS
+ gf180mcu_as_sc_mcu7t3v3__inv_2
Xgf180mcu_as_sc_mcu7t3v3__inv_2_1546 VSS VSS gf180mcu_as_sc_mcu7t3v3__inv_2_1546/Y
+ gf180mcu_as_sc_mcu7t3v3__inv_2_1547/Y gf180mcu_as_sc_mcu7t3v3__inv_2_1547/VNW VSUBS
+ gf180mcu_as_sc_mcu7t3v3__inv_2
Xgf180mcu_as_sc_mcu7t3v3__inv_2_1557 VSS VSS VSS gf180mcu_as_sc_mcu7t3v3__inv_2_1558/Y
+ gf180mcu_as_sc_mcu7t3v3__inv_2_1559/VNW VSUBS gf180mcu_as_sc_mcu7t3v3__inv_2
Xgf180mcu_as_sc_mcu7t3v3__inv_2_1513 VSS VSS gf180mcu_as_sc_mcu7t3v3__inv_2_1513/Y
+ gf180mcu_as_sc_mcu7t3v3__inv_2_1514/Y gf180mcu_as_sc_mcu7t3v3__inv_2_1514/VNW VSUBS
+ gf180mcu_as_sc_mcu7t3v3__inv_2
Xgf180mcu_as_sc_mcu7t3v3__inv_2_1524 VSS VSS VSS gf180mcu_as_sc_mcu7t3v3__inv_2_1525/Y
+ gf180mcu_as_sc_mcu7t3v3__inv_2_1526/VNW VSUBS gf180mcu_as_sc_mcu7t3v3__inv_2
Xgf180mcu_as_sc_mcu7t3v3__inv_2_1535 VSS VSS gf180mcu_as_sc_mcu7t3v3__inv_2_1535/Y
+ gf180mcu_as_sc_mcu7t3v3__inv_2_1535/A gf180mcu_as_sc_mcu7t3v3__inv_2_1535/VNW VSUBS
+ gf180mcu_as_sc_mcu7t3v3__inv_2
Xgf180mcu_as_sc_mcu7t3v3__inv_2_1502 VSS VSS gf180mcu_as_sc_mcu7t3v3__inv_2_1502/Y
+ gf180mcu_as_sc_mcu7t3v3__inv_2_1503/Y gf180mcu_as_sc_mcu7t3v3__inv_2_1503/VNW VSUBS
+ gf180mcu_as_sc_mcu7t3v3__inv_2
Xgf180mcu_as_sc_mcu7t3v3__nand4_2_318 VSS VSS VSS VSS VSS VSS gf180mcu_as_sc_mcu7t3v3__inv_2_1067/A
+ gf180mcu_as_sc_mcu7t3v3__inv_2_1067/VNW VSUBS gf180mcu_as_sc_mcu7t3v3__nand4_2
Xgf180mcu_as_sc_mcu7t3v3__nand4_2_329 VSS VSS VSS VSS VSS VSS gf180mcu_as_sc_mcu7t3v3__inv_2_1111/A
+ gf180mcu_as_sc_mcu7t3v3__inv_2_1111/VNW VSUBS gf180mcu_as_sc_mcu7t3v3__nand4_2
Xgf180mcu_as_sc_mcu7t3v3__nand4_2_307 VSS VSS VSS VSS VSS VSS gf180mcu_as_sc_mcu7t3v3__inv_2_1052/A
+ gf180mcu_as_sc_mcu7t3v3__inv_2_1052/VNW VSUBS gf180mcu_as_sc_mcu7t3v3__nand4_2
Xgf180mcu_as_sc_mcu7t3v3__nand2_2_1 gf180mcu_as_sc_mcu7t3v3__nor2_2_6/VDD gf180mcu_as_sc_mcu7t3v3__nand3_2_4/VSS
+ VSS VSS VSS gf180mcu_as_sc_mcu7t3v3__nor2_2_6/VNW VSUBS gf180mcu_as_sc_mcu7t3v3__nand2_2
Xu_t029_006 u_t029_006/c0_w0_bl u_t029_006/c0_w0_br u_t029_006/c0_w1_bl u_t029_006/c0_w1_br
+ u_t029_006/c0_r0_rbl u_t029_006/c0_r1_rbl u_t029_006/c1_w0_bl u_t029_006/c1_w0_br
+ u_t029_006/c1_w1_bl u_t029_006/c1_w1_br u_t029_006/c1_r0_rbl u_t029_006/c1_r1_rbl
+ u_t029_006/c2_w0_bl u_t029_006/c2_w0_br u_t029_006/c2_w1_bl u_t029_006/c2_w1_br
+ u_t029_006/c2_r0_rbl u_t029_006/c2_r1_rbl u_t029_006/c3_w0_bl u_t029_006/c3_w0_br
+ u_t029_006/c3_w1_bl u_t029_006/c3_w1_br u_t029_006/c3_r0_rbl u_t029_006/c3_r1_rbl
+ u_t029_006/r0_w0_wl u_t029_006/r0_w1_wl u_t029_006/r0_r0_rwl u_t029_006/r0_r1_rwl
+ u_t029_006/r1_w0_wl u_t029_006/r1_w1_wl u_t029_006/r1_r0_rwl u_t029_006/r1_r1_rwl
+ u_t029_006/r2_w0_wl u_t029_006/r2_w1_wl u_t029_006/r2_r0_rwl u_t029_006/r2_r1_rwl
+ u_t029_006/r3_w0_wl u_t029_006/r3_w1_wl u_t029_006/r3_r0_rwl u_t029_006/r3_r1_rwl
+ VSS VSS u_t029_006/m2_717_1265# u_t029_006/m2_603_2031# u_t029_006/m2_1290_336#
+ u_t029_006/m2_2000_2037# u_t029_006/m2_791_2909# u_t029_006/m2_7_2126# u_t029_006/m2_2154_2081#
+ u_t029_006/m2_1795_2037# u_t029_006/m2_871_303# u_t029_006/m2_431_438# u_t029_006/m2_1290_2898#
+ u_t029_006/m2_1714_1210# u_t029_006/m2_431_1982# u_t029_006/m2_512_1265# u_t029_006/m2_2573_2126#
+ u_t029_006/m2_603_1259# u_t029_006/m2_2074_2909# u_t029_006/m2_7_336# u_t029_006/m2_717_2037#
+ u_t029_006/m2_1886_2031# u_t029_006/m2_2573_336# u_t029_006/m2_7_2898# u_t029_006/m2_2000_1265#
+ u_t029_006/m2_512_2037# u_t029_006/m2_1795_1265# u_t029_006/m2_1714_1982# u_t029_006/m2_1886_1259#
+ u_t029_006/m2_1290_2126# u_t029_006/m2_1714_438# u_t029_006/m2_431_1210# u_t029_006/m2_2573_2898#
+ u_t029_006/m2_2154_303# u_t029_006/m2_871_2081# VSUBS detronyx_12t_2w2r_rc4_4x4_routed_5layer_direct
Xgf180mcu_as_sc_mcu7t3v3__inv_2_1310 VSS VSS VSS gf180mcu_as_sc_mcu7t3v3__inv_2_1311/Y
+ gf180mcu_as_sc_mcu7t3v3__inv_2_1312/VNW VSUBS gf180mcu_as_sc_mcu7t3v3__inv_2
Xgf180mcu_as_sc_mcu7t3v3__inv_2_1365 VSS VSS gf180mcu_as_sc_mcu7t3v3__inv_2_1365/Y
+ gf180mcu_as_sc_mcu7t3v3__inv_2_1366/Y gf180mcu_as_sc_mcu7t3v3__inv_2_1366/VNW VSUBS
+ gf180mcu_as_sc_mcu7t3v3__inv_2
Xgf180mcu_as_sc_mcu7t3v3__inv_2_1376 VSS VSS VSS gf180mcu_as_sc_mcu7t3v3__inv_2_1377/Y
+ gf180mcu_as_sc_mcu7t3v3__inv_2_1378/VNW VSUBS gf180mcu_as_sc_mcu7t3v3__inv_2
Xgf180mcu_as_sc_mcu7t3v3__inv_2_1398 VSS VSS gf180mcu_as_sc_mcu7t3v3__inv_2_1398/Y
+ gf180mcu_as_sc_mcu7t3v3__inv_2_1398/A gf180mcu_as_sc_mcu7t3v3__inv_2_1398/VNW VSUBS
+ gf180mcu_as_sc_mcu7t3v3__inv_2
Xgf180mcu_as_sc_mcu7t3v3__inv_2_1387 VSS VSS gf180mcu_as_sc_mcu7t3v3__inv_2_1387/Y
+ gf180mcu_as_sc_mcu7t3v3__inv_2_1391/Y gf180mcu_as_sc_mcu7t3v3__inv_2_1391/VNW VSUBS
+ gf180mcu_as_sc_mcu7t3v3__inv_2
Xgf180mcu_as_sc_mcu7t3v3__inv_2_1321 VSS VSS gf180mcu_as_sc_mcu7t3v3__inv_2_1353/A
+ gf180mcu_as_sc_mcu7t3v3__inv_2_1321/A gf180mcu_as_sc_mcu7t3v3__inv_2_1353/VNW VSUBS
+ gf180mcu_as_sc_mcu7t3v3__inv_2
Xgf180mcu_as_sc_mcu7t3v3__inv_2_1354 VSS VSS VSS gf180mcu_as_sc_mcu7t3v3__inv_2_1355/Y
+ gf180mcu_as_sc_mcu7t3v3__inv_2_1355/VNW VSUBS gf180mcu_as_sc_mcu7t3v3__inv_2
Xgf180mcu_as_sc_mcu7t3v3__inv_2_1343 VSS VSS gf180mcu_as_sc_mcu7t3v3__inv_2_1343/Y
+ gf180mcu_as_sc_mcu7t3v3__inv_2_1344/Y gf180mcu_as_sc_mcu7t3v3__inv_2_1344/VNW VSUBS
+ gf180mcu_as_sc_mcu7t3v3__inv_2
Xgf180mcu_as_sc_mcu7t3v3__inv_2_1332 VSS VSS gf180mcu_as_sc_mcu7t3v3__inv_2_1332/Y
+ gf180mcu_as_sc_mcu7t3v3__inv_2_1332/A gf180mcu_as_sc_mcu7t3v3__inv_2_1332/VNW VSUBS
+ gf180mcu_as_sc_mcu7t3v3__inv_2
Xgf180mcu_as_sc_mcu7t3v3__inv_2_827 VSS VSS VSS gf180mcu_as_sc_mcu7t3v3__inv_2_827/A
+ gf180mcu_as_sc_mcu7t3v3__inv_2_827/VNW VSUBS gf180mcu_as_sc_mcu7t3v3__inv_2
Xgf180mcu_as_sc_mcu7t3v3__inv_2_816 VSS VSS VSS gf180mcu_as_sc_mcu7t3v3__inv_2_816/A
+ gf180mcu_as_sc_mcu7t3v3__inv_2_816/VNW VSUBS gf180mcu_as_sc_mcu7t3v3__inv_2
Xgf180mcu_as_sc_mcu7t3v3__inv_2_849 VSS VSS VSS gf180mcu_as_sc_mcu7t3v3__inv_2_849/A
+ gf180mcu_as_sc_mcu7t3v3__inv_2_849/VNW VSUBS gf180mcu_as_sc_mcu7t3v3__inv_2
Xgf180mcu_as_sc_mcu7t3v3__inv_2_805 VSS VSS gf180mcu_as_sc_mcu7t3v3__inv_2_838/A gf180mcu_as_sc_mcu7t3v3__inv_2_806/Y
+ gf180mcu_as_sc_mcu7t3v3__inv_2_838/VNW VSUBS gf180mcu_as_sc_mcu7t3v3__inv_2
Xgf180mcu_as_sc_mcu7t3v3__inv_2_838 VSS VSS VSS gf180mcu_as_sc_mcu7t3v3__inv_2_838/A
+ gf180mcu_as_sc_mcu7t3v3__inv_2_838/VNW VSUBS gf180mcu_as_sc_mcu7t3v3__inv_2
Xgf180mcu_as_sc_mcu7t3v3__nand4_2_126 VSS VSS VSS VSS VSS VSS gf180mcu_as_sc_mcu7t3v3__inv_2_444/A
+ gf180mcu_as_sc_mcu7t3v3__inv_2_545/VNW VSUBS gf180mcu_as_sc_mcu7t3v3__nand4_2
Xgf180mcu_as_sc_mcu7t3v3__nand4_2_115 VSS VSS VSS VSS VSS VSS gf180mcu_as_sc_mcu7t3v3__inv_2_288/A
+ gf180mcu_as_sc_mcu7t3v3__inv_2_288/VNW VSUBS gf180mcu_as_sc_mcu7t3v3__nand4_2
Xgf180mcu_as_sc_mcu7t3v3__nand4_2_104 VSS VSS VSS VSS VSS VSS gf180mcu_as_sc_mcu7t3v3__inv_2_365/A
+ gf180mcu_as_sc_mcu7t3v3__inv_2_365/VNW VSUBS gf180mcu_as_sc_mcu7t3v3__nand4_2
Xu_t026_009 u_t026_009/c0_w0_bl u_t026_009/c0_w0_br u_t026_009/c0_w1_bl u_t026_009/c0_w1_br
+ u_t026_009/c0_r0_rbl u_t026_009/c0_r1_rbl u_t026_009/c1_w0_bl u_t026_009/c1_w0_br
+ u_t026_009/c1_w1_bl u_t026_009/c1_w1_br u_t026_009/c1_r0_rbl u_t026_009/c1_r1_rbl
+ u_t026_009/c2_w0_bl u_t026_009/c2_w0_br u_t026_009/c2_w1_bl u_t026_009/c2_w1_br
+ u_t026_009/c2_r0_rbl u_t026_009/c2_r1_rbl u_t026_009/c3_w0_bl u_t026_009/c3_w0_br
+ u_t026_009/c3_w1_bl u_t026_009/c3_w1_br u_t026_009/c3_r0_rbl u_t026_009/c3_r1_rbl
+ u_t026_009/r0_w0_wl u_t026_009/r0_w1_wl u_t026_009/r0_r0_rwl u_t026_009/r0_r1_rwl
+ u_t026_009/r1_w0_wl u_t026_009/r1_w1_wl u_t026_009/r1_r0_rwl u_t026_009/r1_r1_rwl
+ u_t026_009/r2_w0_wl u_t026_009/r2_w1_wl u_t026_009/r2_r0_rwl u_t026_009/r2_r1_rwl
+ u_t026_009/r3_w0_wl u_t026_009/r3_w1_wl u_t026_009/r3_r0_rwl u_t026_009/r3_r1_rwl
+ VSS VSS u_t026_009/m2_717_1265# u_t026_009/m2_603_2031# u_t026_009/m2_1290_336#
+ u_t026_009/m2_2000_2037# u_t026_009/m2_791_2909# u_t026_009/m2_7_2126# u_t026_009/m2_2154_2081#
+ u_t026_009/m2_1795_2037# u_t026_009/m2_871_303# u_t026_009/m2_431_438# u_t026_009/m2_1290_2898#
+ u_t026_009/m2_1714_1210# u_t026_009/m2_431_1982# u_t026_009/m2_512_1265# u_t026_009/m2_2573_2126#
+ u_t026_009/m2_603_1259# u_t026_009/m2_2074_2909# u_t026_009/m2_7_336# u_t026_009/m2_717_2037#
+ u_t026_009/m2_1886_2031# u_t026_009/m2_2573_336# u_t026_009/m2_7_2898# u_t026_009/m2_2000_1265#
+ u_t026_009/m2_512_2037# u_t026_009/m2_1795_1265# u_t026_009/m2_1714_1982# u_t026_009/m2_1886_1259#
+ u_t026_009/m2_1290_2126# u_t026_009/m2_1714_438# u_t026_009/m2_431_1210# u_t026_009/m2_2573_2898#
+ u_t026_009/m2_2154_303# u_t026_009/m2_871_2081# VSUBS detronyx_12t_2w2r_rc4_4x4_routed_5layer_direct
Xgf180mcu_as_sc_mcu7t3v3__nand4_2_65 VSS VSS VSS VSS VSS VSS gf180mcu_as_sc_mcu7t3v3__inv_2_16/A
+ gf180mcu_as_sc_mcu7t3v3__inv_2_16/VNW VSUBS gf180mcu_as_sc_mcu7t3v3__nand4_2
Xgf180mcu_as_sc_mcu7t3v3__nand4_2_159 VSS VSS VSS VSS VSS VSS gf180mcu_as_sc_mcu7t3v3__inv_2_576/A
+ gf180mcu_as_sc_mcu7t3v3__inv_2_576/VNW VSUBS gf180mcu_as_sc_mcu7t3v3__nand4_2
Xgf180mcu_as_sc_mcu7t3v3__nand4_2_137 VSS VSS VSS VSS VSS VSS gf180mcu_as_sc_mcu7t3v3__inv_2_497/A
+ gf180mcu_as_sc_mcu7t3v3__inv_2_555/VNW VSUBS gf180mcu_as_sc_mcu7t3v3__nand4_2
Xgf180mcu_as_sc_mcu7t3v3__nand4_2_21 VSS VSS VSS VSS VSS VSS gf180mcu_as_sc_mcu7t3v3__inv_2_143/A
+ gf180mcu_as_sc_mcu7t3v3__inv_2_143/VNW VSUBS gf180mcu_as_sc_mcu7t3v3__nand4_2
Xgf180mcu_as_sc_mcu7t3v3__nand4_2_148 VSS VSS VSS VSS VSS VSS gf180mcu_as_sc_mcu7t3v3__inv_2_517/A
+ gf180mcu_as_sc_mcu7t3v3__inv_2_559/VNW VSUBS gf180mcu_as_sc_mcu7t3v3__nand4_2
Xgf180mcu_as_sc_mcu7t3v3__nand4_2_10 VSS VSS VSS VSS VSS VSS gf180mcu_as_sc_mcu7t3v3__inv_2_110/A
+ gf180mcu_as_sc_mcu7t3v3__inv_2_110/VNW VSUBS gf180mcu_as_sc_mcu7t3v3__nand4_2
Xgf180mcu_as_sc_mcu7t3v3__nand4_2_32 VSS VSS VSS VSS VSS VSS gf180mcu_as_sc_mcu7t3v3__inv_2_175/A
+ gf180mcu_as_sc_mcu7t3v3__inv_2_182/VNW VSUBS gf180mcu_as_sc_mcu7t3v3__nand4_2
Xgf180mcu_as_sc_mcu7t3v3__nand4_2_43 VSS VSS VSS VSS VSS VSS gf180mcu_as_sc_mcu7t3v3__inv_2_209/A
+ gf180mcu_as_sc_mcu7t3v3__inv_2_209/VNW VSUBS gf180mcu_as_sc_mcu7t3v3__nand4_2
Xgf180mcu_as_sc_mcu7t3v3__nand4_2_54 VSS VSS VSS VSS VSS VSS gf180mcu_as_sc_mcu7t3v3__inv_2_242/A
+ gf180mcu_as_sc_mcu7t3v3__inv_2_242/VNW VSUBS gf180mcu_as_sc_mcu7t3v3__nand4_2
Xgf180mcu_as_sc_mcu7t3v3__nand4_2_76 VSS VSS VSS VSS VSS VSS gf180mcu_as_sc_mcu7t3v3__inv_2_332/A
+ gf180mcu_as_sc_mcu7t3v3__inv_2_332/VNW VSUBS gf180mcu_as_sc_mcu7t3v3__nand4_2
Xgf180mcu_as_sc_mcu7t3v3__nand4_2_87 VSS VSS VSS VSS VSS VSS gf180mcu_as_sc_mcu7t3v3__inv_2_9/A
+ gf180mcu_as_sc_mcu7t3v3__inv_2_9/VNW VSUBS gf180mcu_as_sc_mcu7t3v3__nand4_2
Xgf180mcu_as_sc_mcu7t3v3__nand4_2_98 VSS VSS VSS VSS VSS VSS gf180mcu_as_sc_mcu7t3v3__inv_2_347/A
+ gf180mcu_as_sc_mcu7t3v3__inv_2_347/VNW VSUBS gf180mcu_as_sc_mcu7t3v3__nand4_2
Xu_t017_009 u_t017_009/c0_w0_bl u_t017_009/c0_w0_br u_t017_009/c0_w1_bl u_t017_009/c0_w1_br
+ u_t017_009/c0_r0_rbl u_t017_009/c0_r1_rbl u_t017_009/c1_w0_bl u_t017_009/c1_w0_br
+ u_t017_009/c1_w1_bl u_t017_009/c1_w1_br u_t017_009/c1_r0_rbl u_t017_009/c1_r1_rbl
+ u_t017_009/c2_w0_bl u_t017_009/c2_w0_br u_t017_009/c2_w1_bl u_t017_009/c2_w1_br
+ u_t017_009/c2_r0_rbl u_t017_009/c2_r1_rbl u_t017_009/c3_w0_bl u_t017_009/c3_w0_br
+ u_t017_009/c3_w1_bl u_t017_009/c3_w1_br u_t017_009/c3_r0_rbl u_t017_009/c3_r1_rbl
+ u_t017_009/r0_w0_wl u_t017_009/r0_w1_wl u_t017_009/r0_r0_rwl u_t017_009/r0_r1_rwl
+ u_t017_009/r1_w0_wl u_t017_009/r1_w1_wl u_t017_009/r1_r0_rwl u_t017_009/r1_r1_rwl
+ u_t017_009/r2_w0_wl u_t017_009/r2_w1_wl u_t017_009/r2_r0_rwl u_t017_009/r2_r1_rwl
+ u_t017_009/r3_w0_wl u_t017_009/r3_w1_wl u_t017_009/r3_r0_rwl u_t017_009/r3_r1_rwl
+ VSS VSS u_t017_009/m2_717_1265# u_t017_009/m2_603_2031# u_t017_009/m2_1290_336#
+ u_t017_009/m2_2000_2037# u_t017_009/m2_791_2909# u_t017_009/m2_7_2126# u_t017_009/m2_2154_2081#
+ u_t017_009/m2_1795_2037# u_t017_009/m2_871_303# u_t017_009/m2_431_438# u_t017_009/m2_1290_2898#
+ u_t017_009/m2_1714_1210# u_t017_009/m2_431_1982# u_t017_009/m2_512_1265# u_t017_009/m2_2573_2126#
+ u_t017_009/m2_603_1259# u_t017_009/m2_2074_2909# u_t017_009/m2_7_336# u_t017_009/m2_717_2037#
+ u_t017_009/m2_1886_2031# u_t017_009/m2_2573_336# u_t017_009/m2_7_2898# u_t017_009/m2_2000_1265#
+ u_t017_009/m2_512_2037# u_t017_009/m2_1795_1265# u_t017_009/m2_1714_1982# u_t017_009/m2_1886_1259#
+ u_t017_009/m2_1290_2126# u_t017_009/m2_1714_438# u_t017_009/m2_431_1210# u_t017_009/m2_2573_2898#
+ u_t017_009/m2_2154_303# u_t017_009/m2_871_2081# VSUBS detronyx_12t_2w2r_rc4_4x4_routed_5layer_direct
Xgf180mcu_as_sc_mcu7t3v3__inv_2_1140 VSS VSS VSS gf180mcu_as_sc_mcu7t3v3__inv_2_1141/Y
+ gf180mcu_as_sc_mcu7t3v3__inv_2_1142/VNW VSUBS gf180mcu_as_sc_mcu7t3v3__inv_2
Xgf180mcu_as_sc_mcu7t3v3__inv_2_1151 VSS VSS gf180mcu_as_sc_mcu7t3v3__inv_2_1151/Y
+ gf180mcu_as_sc_mcu7t3v3__inv_2_1151/A gf180mcu_as_sc_mcu7t3v3__inv_2_1151/VNW VSUBS
+ gf180mcu_as_sc_mcu7t3v3__inv_2
Xgf180mcu_as_sc_mcu7t3v3__inv_2_1162 VSS VSS gf180mcu_as_sc_mcu7t3v3__inv_2_1299/A
+ gf180mcu_as_sc_mcu7t3v3__inv_2_1165/Y gf180mcu_as_sc_mcu7t3v3__inv_2_1299/VNW VSUBS
+ gf180mcu_as_sc_mcu7t3v3__inv_2
Xgf180mcu_as_sc_mcu7t3v3__inv_2_1195 VSS VSS gf180mcu_as_sc_mcu7t3v3__inv_2_1280/A
+ gf180mcu_as_sc_mcu7t3v3__inv_2_1198/Y gf180mcu_as_sc_mcu7t3v3__inv_2_1280/VNW VSUBS
+ gf180mcu_as_sc_mcu7t3v3__inv_2
Xgf180mcu_as_sc_mcu7t3v3__inv_2_1173 VSS VSS gf180mcu_as_sc_mcu7t3v3__inv_2_1295/A
+ gf180mcu_as_sc_mcu7t3v3__inv_2_1174/Y gf180mcu_as_sc_mcu7t3v3__inv_2_1295/VNW VSUBS
+ gf180mcu_as_sc_mcu7t3v3__inv_2
Xgf180mcu_as_sc_mcu7t3v3__inv_2_1184 VSS VSS gf180mcu_as_sc_mcu7t3v3__inv_2_1298/A
+ gf180mcu_as_sc_mcu7t3v3__inv_2_1184/A gf180mcu_as_sc_mcu7t3v3__inv_2_1298/VNW VSUBS
+ gf180mcu_as_sc_mcu7t3v3__inv_2
Xu_t008_009 u_t008_009/c0_w0_bl u_t008_009/c0_w0_br u_t008_009/c0_w1_bl u_t008_009/c0_w1_br
+ u_t008_009/c0_r0_rbl u_t008_009/c0_r1_rbl u_t008_009/c1_w0_bl u_t008_009/c1_w0_br
+ u_t008_009/c1_w1_bl u_t008_009/c1_w1_br u_t008_009/c1_r0_rbl u_t008_009/c1_r1_rbl
+ u_t008_009/c2_w0_bl u_t008_009/c2_w0_br u_t008_009/c2_w1_bl u_t008_009/c2_w1_br
+ u_t008_009/c2_r0_rbl u_t008_009/c2_r1_rbl u_t008_009/c3_w0_bl u_t008_009/c3_w0_br
+ u_t008_009/c3_w1_bl u_t008_009/c3_w1_br u_t008_009/c3_r0_rbl u_t008_009/c3_r1_rbl
+ u_t008_009/r0_w0_wl u_t008_009/r0_w1_wl u_t008_009/r0_r0_rwl u_t008_009/r0_r1_rwl
+ u_t008_009/r1_w0_wl u_t008_009/r1_w1_wl u_t008_009/r1_r0_rwl u_t008_009/r1_r1_rwl
+ u_t008_009/r2_w0_wl u_t008_009/r2_w1_wl u_t008_009/r2_r0_rwl u_t008_009/r2_r1_rwl
+ u_t008_009/r3_w0_wl u_t008_009/r3_w1_wl u_t008_009/r3_r0_rwl u_t008_009/r3_r1_rwl
+ VSS VSS u_t008_009/m2_717_1265# u_t008_009/m2_603_2031# u_t008_009/m2_1290_336#
+ u_t008_009/m2_2000_2037# u_t008_009/m2_791_2909# u_t008_009/m2_7_2126# u_t008_009/m2_2154_2081#
+ u_t008_009/m2_1795_2037# u_t008_009/m2_871_303# u_t008_009/m2_431_438# u_t008_009/m2_1290_2898#
+ u_t008_009/m2_1714_1210# u_t008_009/m2_431_1982# u_t008_009/m2_512_1265# u_t008_009/m2_2573_2126#
+ u_t008_009/m2_603_1259# u_t008_009/m2_2074_2909# u_t008_009/m2_7_336# u_t008_009/m2_717_2037#
+ u_t008_009/m2_1886_2031# u_t008_009/m2_2573_336# u_t008_009/m2_7_2898# u_t008_009/m2_2000_1265#
+ u_t008_009/m2_512_2037# u_t008_009/m2_1795_1265# u_t008_009/m2_1714_1982# u_t008_009/m2_1886_1259#
+ u_t008_009/m2_1290_2126# u_t008_009/m2_1714_438# u_t008_009/m2_431_1210# u_t008_009/m2_2573_2898#
+ u_t008_009/m2_2154_303# u_t008_009/m2_871_2081# VSUBS detronyx_12t_2w2r_rc4_4x4_routed_5layer_direct
Xgf180mcu_as_sc_mcu7t3v3__inv_2_602 VSS VSS gf180mcu_as_sc_mcu7t3v3__inv_2_602/Y gf180mcu_as_sc_mcu7t3v3__inv_2_602/A
+ gf180mcu_as_sc_mcu7t3v3__inv_2_602/VNW VSUBS gf180mcu_as_sc_mcu7t3v3__inv_2
Xu_t031_012 u_t031_012/c0_w0_bl u_t031_012/c0_w0_br u_t031_012/c0_w1_bl u_t031_012/c0_w1_br
+ u_t031_012/c0_r0_rbl u_t031_012/c0_r1_rbl u_t031_012/c1_w0_bl u_t031_012/c1_w0_br
+ u_t031_012/c1_w1_bl u_t031_012/c1_w1_br u_t031_012/c1_r0_rbl u_t031_012/c1_r1_rbl
+ u_t031_012/c2_w0_bl u_t031_012/c2_w0_br u_t031_012/c2_w1_bl u_t031_012/c2_w1_br
+ u_t031_012/c2_r0_rbl u_t031_012/c2_r1_rbl u_t031_012/c3_w0_bl u_t031_012/c3_w0_br
+ u_t031_012/c3_w1_bl u_t031_012/c3_w1_br u_t031_012/c3_r0_rbl u_t031_012/c3_r1_rbl
+ u_t031_012/r0_w0_wl u_t031_012/r0_w1_wl u_t031_012/r0_r0_rwl u_t031_012/r0_r1_rwl
+ u_t031_012/r1_w0_wl u_t031_012/r1_w1_wl u_t031_012/r1_r0_rwl u_t031_012/r1_r1_rwl
+ u_t031_012/r2_w0_wl u_t031_012/r2_w1_wl u_t031_012/r2_r0_rwl u_t031_012/r2_r1_rwl
+ u_t031_012/r3_w0_wl u_t031_012/r3_w1_wl u_t031_012/r3_r0_rwl u_t031_012/r3_r1_rwl
+ VSS VSS u_t031_012/m2_717_1265# u_t031_012/m2_603_2031# u_t031_012/m2_1290_336#
+ u_t031_012/m2_2000_2037# u_t031_012/m2_791_2909# u_t031_012/m2_7_2126# u_t031_012/m2_2154_2081#
+ u_t031_012/m2_1795_2037# u_t031_012/m2_871_303# u_t031_012/m2_431_438# u_t031_012/m2_1290_2898#
+ u_t031_012/m2_1714_1210# u_t031_012/m2_431_1982# u_t031_012/m2_512_1265# u_t031_012/m2_2573_2126#
+ u_t031_012/m2_603_1259# u_t031_012/m2_2074_2909# u_t031_012/m2_7_336# u_t031_012/m2_717_2037#
+ u_t031_012/m2_1886_2031# u_t031_012/m2_2573_336# u_t031_012/m2_7_2898# u_t031_012/m2_2000_1265#
+ u_t031_012/m2_512_2037# u_t031_012/m2_1795_1265# u_t031_012/m2_1714_1982# u_t031_012/m2_1886_1259#
+ u_t031_012/m2_1290_2126# u_t031_012/m2_1714_438# u_t031_012/m2_431_1210# u_t031_012/m2_2573_2898#
+ u_t031_012/m2_2154_303# u_t031_012/m2_871_2081# VSUBS detronyx_12t_2w2r_rc4_4x4_routed_5layer_direct
Xu_t031_001 u_t031_001/c0_w0_bl u_t031_001/c0_w0_br u_t031_001/c0_w1_bl u_t031_001/c0_w1_br
+ u_t031_001/c0_r0_rbl u_t031_001/c0_r1_rbl u_t031_001/c1_w0_bl u_t031_001/c1_w0_br
+ u_t031_001/c1_w1_bl u_t031_001/c1_w1_br u_t031_001/c1_r0_rbl u_t031_001/c1_r1_rbl
+ u_t031_001/c2_w0_bl u_t031_001/c2_w0_br u_t031_001/c2_w1_bl u_t031_001/c2_w1_br
+ u_t031_001/c2_r0_rbl u_t031_001/c2_r1_rbl u_t031_001/c3_w0_bl u_t031_001/c3_w0_br
+ u_t031_001/c3_w1_bl u_t031_001/c3_w1_br u_t031_001/c3_r0_rbl u_t031_001/c3_r1_rbl
+ u_t031_001/r0_w0_wl u_t031_001/r0_w1_wl u_t031_001/r0_r0_rwl u_t031_001/r0_r1_rwl
+ u_t031_001/r1_w0_wl u_t031_001/r1_w1_wl u_t031_001/r1_r0_rwl u_t031_001/r1_r1_rwl
+ u_t031_001/r2_w0_wl u_t031_001/r2_w1_wl u_t031_001/r2_r0_rwl u_t031_001/r2_r1_rwl
+ u_t031_001/r3_w0_wl u_t031_001/r3_w1_wl u_t031_001/r3_r0_rwl u_t031_001/r3_r1_rwl
+ VSS VSS u_t031_001/m2_717_1265# u_t031_001/m2_603_2031# u_t031_001/m2_1290_336#
+ u_t031_001/m2_2000_2037# u_t031_001/m2_791_2909# u_t031_001/m2_7_2126# u_t031_001/m2_2154_2081#
+ u_t031_001/m2_1795_2037# u_t031_001/m2_871_303# u_t031_001/m2_431_438# u_t031_001/m2_1290_2898#
+ u_t031_001/m2_1714_1210# u_t031_001/m2_431_1982# u_t031_001/m2_512_1265# u_t031_001/m2_2573_2126#
+ u_t031_001/m2_603_1259# u_t031_001/m2_2074_2909# u_t031_001/m2_7_336# u_t031_001/m2_717_2037#
+ u_t031_001/m2_1886_2031# u_t031_001/m2_2573_336# u_t031_001/m2_7_2898# u_t031_001/m2_2000_1265#
+ u_t031_001/m2_512_2037# u_t031_001/m2_1795_1265# u_t031_001/m2_1714_1982# u_t031_001/m2_1886_1259#
+ u_t031_001/m2_1290_2126# u_t031_001/m2_1714_438# u_t031_001/m2_431_1210# u_t031_001/m2_2573_2898#
+ u_t031_001/m2_2154_303# u_t031_001/m2_871_2081# VSUBS detronyx_12t_2w2r_rc4_4x4_routed_5layer_direct
Xgf180mcu_as_sc_mcu7t3v3__inv_2_613 VSS VSS gf180mcu_as_sc_mcu7t3v3__inv_2_613/Y gf180mcu_as_sc_mcu7t3v3__inv_2_617/Y
+ gf180mcu_as_sc_mcu7t3v3__inv_2_617/VNW VSUBS gf180mcu_as_sc_mcu7t3v3__inv_2
Xgf180mcu_as_sc_mcu7t3v3__inv_2_624 VSS VSS gf180mcu_as_sc_mcu7t3v3__inv_2_624/Y gf180mcu_as_sc_mcu7t3v3__inv_2_624/A
+ gf180mcu_as_sc_mcu7t3v3__inv_2_624/VNW VSUBS gf180mcu_as_sc_mcu7t3v3__inv_2
Xgf180mcu_as_sc_mcu7t3v3__inv_2_635 VSS VSS gf180mcu_as_sc_mcu7t3v3__inv_2_635/Y gf180mcu_as_sc_mcu7t3v3__inv_2_636/Y
+ gf180mcu_as_sc_mcu7t3v3__inv_2_636/VNW VSUBS gf180mcu_as_sc_mcu7t3v3__inv_2
Xgf180mcu_as_sc_mcu7t3v3__inv_2_679 VSS VSS gf180mcu_as_sc_mcu7t3v3__inv_2_679/Y gf180mcu_as_sc_mcu7t3v3__inv_2_679/A
+ gf180mcu_as_sc_mcu7t3v3__inv_2_679/VNW VSUBS gf180mcu_as_sc_mcu7t3v3__inv_2
Xgf180mcu_as_sc_mcu7t3v3__inv_2_646 VSS VSS gf180mcu_as_sc_mcu7t3v3__inv_2_646/Y gf180mcu_as_sc_mcu7t3v3__inv_2_646/A
+ gf180mcu_as_sc_mcu7t3v3__inv_2_646/VNW VSUBS gf180mcu_as_sc_mcu7t3v3__inv_2
Xgf180mcu_as_sc_mcu7t3v3__inv_2_657 VSS VSS gf180mcu_as_sc_mcu7t3v3__inv_2_657/Y gf180mcu_as_sc_mcu7t3v3__inv_2_661/Y
+ gf180mcu_as_sc_mcu7t3v3__inv_2_661/VNW VSUBS gf180mcu_as_sc_mcu7t3v3__inv_2
Xgf180mcu_as_sc_mcu7t3v3__inv_2_668 VSS VSS VSS gf180mcu_as_sc_mcu7t3v3__inv_2_669/Y
+ gf180mcu_as_sc_mcu7t3v3__inv_2_670/VNW VSUBS gf180mcu_as_sc_mcu7t3v3__inv_2
Xu_t022_001 u_t022_001/c0_w0_bl u_t022_001/c0_w0_br u_t022_001/c0_w1_bl u_t022_001/c0_w1_br
+ u_t022_001/c0_r0_rbl u_t022_001/c0_r1_rbl u_t022_001/c1_w0_bl u_t022_001/c1_w0_br
+ u_t022_001/c1_w1_bl u_t022_001/c1_w1_br u_t022_001/c1_r0_rbl u_t022_001/c1_r1_rbl
+ u_t022_001/c2_w0_bl u_t022_001/c2_w0_br u_t022_001/c2_w1_bl u_t022_001/c2_w1_br
+ u_t022_001/c2_r0_rbl u_t022_001/c2_r1_rbl u_t022_001/c3_w0_bl u_t022_001/c3_w0_br
+ u_t022_001/c3_w1_bl u_t022_001/c3_w1_br u_t022_001/c3_r0_rbl u_t022_001/c3_r1_rbl
+ u_t022_001/r0_w0_wl u_t022_001/r0_w1_wl u_t022_001/r0_r0_rwl u_t022_001/r0_r1_rwl
+ u_t022_001/r1_w0_wl u_t022_001/r1_w1_wl u_t022_001/r1_r0_rwl u_t022_001/r1_r1_rwl
+ u_t022_001/r2_w0_wl u_t022_001/r2_w1_wl u_t022_001/r2_r0_rwl u_t022_001/r2_r1_rwl
+ u_t022_001/r3_w0_wl u_t022_001/r3_w1_wl u_t022_001/r3_r0_rwl u_t022_001/r3_r1_rwl
+ VSS VSS u_t022_001/m2_717_1265# u_t022_001/m2_603_2031# u_t022_001/m2_1290_336#
+ u_t022_001/m2_2000_2037# u_t022_001/m2_791_2909# u_t022_001/m2_7_2126# u_t022_001/m2_2154_2081#
+ u_t022_001/m2_1795_2037# u_t022_001/m2_871_303# u_t022_001/m2_431_438# u_t022_001/m2_1290_2898#
+ u_t022_001/m2_1714_1210# u_t022_001/m2_431_1982# u_t022_001/m2_512_1265# u_t022_001/m2_2573_2126#
+ u_t022_001/m2_603_1259# u_t022_001/m2_2074_2909# u_t022_001/m2_7_336# u_t022_001/m2_717_2037#
+ u_t022_001/m2_1886_2031# u_t022_001/m2_2573_336# u_t022_001/m2_7_2898# u_t022_001/m2_2000_1265#
+ u_t022_001/m2_512_2037# u_t022_001/m2_1795_1265# u_t022_001/m2_1714_1982# u_t022_001/m2_1886_1259#
+ u_t022_001/m2_1290_2126# u_t022_001/m2_1714_438# u_t022_001/m2_431_1210# u_t022_001/m2_2573_2898#
+ u_t022_001/m2_2154_303# u_t022_001/m2_871_2081# VSUBS detronyx_12t_2w2r_rc4_4x4_routed_5layer_direct
Xu_t022_012 u_t022_012/c0_w0_bl u_t022_012/c0_w0_br u_t022_012/c0_w1_bl u_t022_012/c0_w1_br
+ u_t022_012/c0_r0_rbl u_t022_012/c0_r1_rbl u_t022_012/c1_w0_bl u_t022_012/c1_w0_br
+ u_t022_012/c1_w1_bl u_t022_012/c1_w1_br u_t022_012/c1_r0_rbl u_t022_012/c1_r1_rbl
+ u_t022_012/c2_w0_bl u_t022_012/c2_w0_br u_t022_012/c2_w1_bl u_t022_012/c2_w1_br
+ u_t022_012/c2_r0_rbl u_t022_012/c2_r1_rbl u_t022_012/c3_w0_bl u_t022_012/c3_w0_br
+ u_t022_012/c3_w1_bl u_t022_012/c3_w1_br u_t022_012/c3_r0_rbl u_t022_012/c3_r1_rbl
+ u_t022_012/r0_w0_wl u_t022_012/r0_w1_wl u_t022_012/r0_r0_rwl u_t022_012/r0_r1_rwl
+ u_t022_012/r1_w0_wl u_t022_012/r1_w1_wl u_t022_012/r1_r0_rwl u_t022_012/r1_r1_rwl
+ u_t022_012/r2_w0_wl u_t022_012/r2_w1_wl u_t022_012/r2_r0_rwl u_t022_012/r2_r1_rwl
+ u_t022_012/r3_w0_wl u_t022_012/r3_w1_wl u_t022_012/r3_r0_rwl u_t022_012/r3_r1_rwl
+ VSS VSS u_t022_012/m2_717_1265# u_t022_012/m2_603_2031# u_t022_012/m2_1290_336#
+ u_t022_012/m2_2000_2037# u_t022_012/m2_791_2909# u_t022_012/m2_7_2126# u_t022_012/m2_2154_2081#
+ u_t022_012/m2_1795_2037# u_t022_012/m2_871_303# u_t022_012/m2_431_438# u_t022_012/m2_1290_2898#
+ u_t022_012/m2_1714_1210# u_t022_012/m2_431_1982# u_t022_012/m2_512_1265# u_t022_012/m2_2573_2126#
+ u_t022_012/m2_603_1259# u_t022_012/m2_2074_2909# u_t022_012/m2_7_336# u_t022_012/m2_717_2037#
+ u_t022_012/m2_1886_2031# u_t022_012/m2_2573_336# u_t022_012/m2_7_2898# u_t022_012/m2_2000_1265#
+ u_t022_012/m2_512_2037# u_t022_012/m2_1795_1265# u_t022_012/m2_1714_1982# u_t022_012/m2_1886_1259#
+ u_t022_012/m2_1290_2126# u_t022_012/m2_1714_438# u_t022_012/m2_431_1210# u_t022_012/m2_2573_2898#
+ u_t022_012/m2_2154_303# u_t022_012/m2_871_2081# VSUBS detronyx_12t_2w2r_rc4_4x4_routed_5layer_direct
Xgf180mcu_as_sc_mcu7t3v3__nand4_2_490 VSS VSS VSS VSS VSS VSS gf180mcu_as_sc_mcu7t3v3__inv_2_1684/A
+ gf180mcu_as_sc_mcu7t3v3__inv_2_1684/VNW VSUBS gf180mcu_as_sc_mcu7t3v3__nand4_2
Xu_t013_012 u_t013_012/c0_w0_bl u_t013_012/c0_w0_br u_t013_012/c0_w1_bl u_t013_012/c0_w1_br
+ u_t013_012/c0_r0_rbl u_t013_012/c0_r1_rbl u_t013_012/c1_w0_bl u_t013_012/c1_w0_br
+ u_t013_012/c1_w1_bl u_t013_012/c1_w1_br u_t013_012/c1_r0_rbl u_t013_012/c1_r1_rbl
+ u_t013_012/c2_w0_bl u_t013_012/c2_w0_br u_t013_012/c2_w1_bl u_t013_012/c2_w1_br
+ u_t013_012/c2_r0_rbl u_t013_012/c2_r1_rbl u_t013_012/c3_w0_bl u_t013_012/c3_w0_br
+ u_t013_012/c3_w1_bl u_t013_012/c3_w1_br u_t013_012/c3_r0_rbl u_t013_012/c3_r1_rbl
+ u_t013_012/r0_w0_wl u_t013_012/r0_w1_wl u_t013_012/r0_r0_rwl u_t013_012/r0_r1_rwl
+ u_t013_012/r1_w0_wl u_t013_012/r1_w1_wl u_t013_012/r1_r0_rwl u_t013_012/r1_r1_rwl
+ u_t013_012/r2_w0_wl u_t013_012/r2_w1_wl u_t013_012/r2_r0_rwl u_t013_012/r2_r1_rwl
+ u_t013_012/r3_w0_wl u_t013_012/r3_w1_wl u_t013_012/r3_r0_rwl u_t013_012/r3_r1_rwl
+ VSS VSS u_t013_012/m2_717_1265# u_t013_012/m2_603_2031# u_t013_012/m2_1290_336#
+ u_t013_012/m2_2000_2037# u_t013_012/m2_791_2909# u_t013_012/m2_7_2126# u_t013_012/m2_2154_2081#
+ u_t013_012/m2_1795_2037# u_t013_012/m2_871_303# u_t013_012/m2_431_438# u_t013_012/m2_1290_2898#
+ u_t013_012/m2_1714_1210# u_t013_012/m2_431_1982# u_t013_012/m2_512_1265# u_t013_012/m2_2573_2126#
+ u_t013_012/m2_603_1259# u_t013_012/m2_2074_2909# u_t013_012/m2_7_336# u_t013_012/m2_717_2037#
+ u_t013_012/m2_1886_2031# u_t013_012/m2_2573_336# u_t013_012/m2_7_2898# u_t013_012/m2_2000_1265#
+ u_t013_012/m2_512_2037# u_t013_012/m2_1795_1265# u_t013_012/m2_1714_1982# u_t013_012/m2_1886_1259#
+ u_t013_012/m2_1290_2126# u_t013_012/m2_1714_438# u_t013_012/m2_431_1210# u_t013_012/m2_2573_2898#
+ u_t013_012/m2_2154_303# u_t013_012/m2_871_2081# VSUBS detronyx_12t_2w2r_rc4_4x4_routed_5layer_direct
Xu_t013_001 u_t013_001/c0_w0_bl u_t013_001/c0_w0_br u_t013_001/c0_w1_bl u_t013_001/c0_w1_br
+ u_t013_001/c0_r0_rbl u_t013_001/c0_r1_rbl u_t013_001/c1_w0_bl u_t013_001/c1_w0_br
+ u_t013_001/c1_w1_bl u_t013_001/c1_w1_br u_t013_001/c1_r0_rbl u_t013_001/c1_r1_rbl
+ u_t013_001/c2_w0_bl u_t013_001/c2_w0_br u_t013_001/c2_w1_bl u_t013_001/c2_w1_br
+ u_t013_001/c2_r0_rbl u_t013_001/c2_r1_rbl u_t013_001/c3_w0_bl u_t013_001/c3_w0_br
+ u_t013_001/c3_w1_bl u_t013_001/c3_w1_br u_t013_001/c3_r0_rbl u_t013_001/c3_r1_rbl
+ u_t013_001/r0_w0_wl u_t013_001/r0_w1_wl u_t013_001/r0_r0_rwl u_t013_001/r0_r1_rwl
+ u_t013_001/r1_w0_wl u_t013_001/r1_w1_wl u_t013_001/r1_r0_rwl u_t013_001/r1_r1_rwl
+ u_t013_001/r2_w0_wl u_t013_001/r2_w1_wl u_t013_001/r2_r0_rwl u_t013_001/r2_r1_rwl
+ u_t013_001/r3_w0_wl u_t013_001/r3_w1_wl u_t013_001/r3_r0_rwl u_t013_001/r3_r1_rwl
+ VSS VSS u_t013_001/m2_717_1265# u_t013_001/m2_603_2031# u_t013_001/m2_1290_336#
+ u_t013_001/m2_2000_2037# u_t013_001/m2_791_2909# u_t013_001/m2_7_2126# u_t013_001/m2_2154_2081#
+ u_t013_001/m2_1795_2037# u_t013_001/m2_871_303# u_t013_001/m2_431_438# u_t013_001/m2_1290_2898#
+ u_t013_001/m2_1714_1210# u_t013_001/m2_431_1982# u_t013_001/m2_512_1265# u_t013_001/m2_2573_2126#
+ u_t013_001/m2_603_1259# u_t013_001/m2_2074_2909# u_t013_001/m2_7_336# u_t013_001/m2_717_2037#
+ u_t013_001/m2_1886_2031# u_t013_001/m2_2573_336# u_t013_001/m2_7_2898# u_t013_001/m2_2000_1265#
+ u_t013_001/m2_512_2037# u_t013_001/m2_1795_1265# u_t013_001/m2_1714_1982# u_t013_001/m2_1886_1259#
+ u_t013_001/m2_1290_2126# u_t013_001/m2_1714_438# u_t013_001/m2_431_1210# u_t013_001/m2_2573_2898#
+ u_t013_001/m2_2154_303# u_t013_001/m2_871_2081# VSUBS detronyx_12t_2w2r_rc4_4x4_routed_5layer_direct
Xgf180mcu_as_sc_mcu7t3v3__inv_2_443 VSS VSS gf180mcu_as_sc_mcu7t3v3__inv_2_545/A gf180mcu_as_sc_mcu7t3v3__inv_2_444/Y
+ gf180mcu_as_sc_mcu7t3v3__inv_2_545/VNW VSUBS gf180mcu_as_sc_mcu7t3v3__inv_2
Xgf180mcu_as_sc_mcu7t3v3__inv_2_421 gf180mcu_as_sc_mcu7t3v3__nor2_2_7/VDD gf180mcu_as_sc_mcu7t3v3__nand3_2_4/VSS
+ gf180mcu_as_sc_mcu7t3v3__inv_2_421/Y VSS gf180mcu_as_sc_mcu7t3v3__nor2_2_7/VNW VSUBS
+ gf180mcu_as_sc_mcu7t3v3__inv_2
Xgf180mcu_as_sc_mcu7t3v3__inv_2_410 gf180mcu_as_sc_mcu7t3v3__nor2_2_4/VDD gf180mcu_as_sc_mcu7t3v3__nand2_2_3/VSS
+ VSS VSS gf180mcu_as_sc_mcu7t3v3__nor2_2_4/VNW VSUBS gf180mcu_as_sc_mcu7t3v3__inv_2
Xgf180mcu_as_sc_mcu7t3v3__inv_2_454 gf180mcu_as_sc_mcu7t3v3__nand3_2_9/VDD gf180mcu_as_sc_mcu7t3v3__nor2_2_7/VSS
+ VSS VSS gf180mcu_as_sc_mcu7t3v3__nand3_2_9/VNW VSUBS gf180mcu_as_sc_mcu7t3v3__inv_2
Xgf180mcu_as_sc_mcu7t3v3__inv_2_432 gf180mcu_as_sc_mcu7t3v3__nand3_2_9/VDD gf180mcu_as_sc_mcu7t3v3__nor2_2_7/VSS
+ VSS VSS gf180mcu_as_sc_mcu7t3v3__nand3_2_9/VNW VSUBS gf180mcu_as_sc_mcu7t3v3__inv_2
Xu_t004_012 u_t004_012/c0_w0_bl u_t004_012/c0_w0_br u_t004_012/c0_w1_bl u_t004_012/c0_w1_br
+ u_t004_012/c0_r0_rbl u_t004_012/c0_r1_rbl u_t004_012/c1_w0_bl u_t004_012/c1_w0_br
+ u_t004_012/c1_w1_bl u_t004_012/c1_w1_br u_t004_012/c1_r0_rbl u_t004_012/c1_r1_rbl
+ u_t004_012/c2_w0_bl u_t004_012/c2_w0_br u_t004_012/c2_w1_bl u_t004_012/c2_w1_br
+ u_t004_012/c2_r0_rbl u_t004_012/c2_r1_rbl u_t004_012/c3_w0_bl u_t004_012/c3_w0_br
+ u_t004_012/c3_w1_bl u_t004_012/c3_w1_br u_t004_012/c3_r0_rbl u_t004_012/c3_r1_rbl
+ u_t004_012/r0_w0_wl u_t004_012/r0_w1_wl u_t004_012/r0_r0_rwl u_t004_012/r0_r1_rwl
+ u_t004_012/r1_w0_wl u_t004_012/r1_w1_wl u_t004_012/r1_r0_rwl u_t004_012/r1_r1_rwl
+ u_t004_012/r2_w0_wl u_t004_012/r2_w1_wl u_t004_012/r2_r0_rwl u_t004_012/r2_r1_rwl
+ u_t004_012/r3_w0_wl u_t004_012/r3_w1_wl u_t004_012/r3_r0_rwl u_t004_012/r3_r1_rwl
+ VSS VSS u_t004_012/m2_717_1265# u_t004_012/m2_603_2031# u_t004_012/m2_1290_336#
+ u_t004_012/m2_2000_2037# u_t004_012/m2_791_2909# u_t004_012/m2_7_2126# u_t004_012/m2_2154_2081#
+ u_t004_012/m2_1795_2037# u_t004_012/m2_871_303# u_t004_012/m2_431_438# u_t004_012/m2_1290_2898#
+ u_t004_012/m2_1714_1210# u_t004_012/m2_431_1982# u_t004_012/m2_512_1265# u_t004_012/m2_2573_2126#
+ u_t004_012/m2_603_1259# u_t004_012/m2_2074_2909# u_t004_012/m2_7_336# u_t004_012/m2_717_2037#
+ u_t004_012/m2_1886_2031# u_t004_012/m2_2573_336# u_t004_012/m2_7_2898# u_t004_012/m2_2000_1265#
+ u_t004_012/m2_512_2037# u_t004_012/m2_1795_1265# u_t004_012/m2_1714_1982# u_t004_012/m2_1886_1259#
+ u_t004_012/m2_1290_2126# u_t004_012/m2_1714_438# u_t004_012/m2_431_1210# u_t004_012/m2_2573_2898#
+ u_t004_012/m2_2154_303# u_t004_012/m2_871_2081# VSUBS detronyx_12t_2w2r_rc4_4x4_routed_5layer_direct
Xu_t004_001 u_t004_001/c0_w0_bl u_t004_001/c0_w0_br u_t004_001/c0_w1_bl u_t004_001/c0_w1_br
+ u_t004_001/c0_r0_rbl u_t004_001/c0_r1_rbl u_t004_001/c1_w0_bl u_t004_001/c1_w0_br
+ u_t004_001/c1_w1_bl u_t004_001/c1_w1_br u_t004_001/c1_r0_rbl u_t004_001/c1_r1_rbl
+ u_t004_001/c2_w0_bl u_t004_001/c2_w0_br u_t004_001/c2_w1_bl u_t004_001/c2_w1_br
+ u_t004_001/c2_r0_rbl u_t004_001/c2_r1_rbl u_t004_001/c3_w0_bl u_t004_001/c3_w0_br
+ u_t004_001/c3_w1_bl u_t004_001/c3_w1_br u_t004_001/c3_r0_rbl u_t004_001/c3_r1_rbl
+ u_t004_001/r0_w0_wl u_t004_001/r0_w1_wl u_t004_001/r0_r0_rwl u_t004_001/r0_r1_rwl
+ u_t004_001/r1_w0_wl u_t004_001/r1_w1_wl u_t004_001/r1_r0_rwl u_t004_001/r1_r1_rwl
+ u_t004_001/r2_w0_wl u_t004_001/r2_w1_wl u_t004_001/r2_r0_rwl u_t004_001/r2_r1_rwl
+ u_t004_001/r3_w0_wl u_t004_001/r3_w1_wl u_t004_001/r3_r0_rwl u_t004_001/r3_r1_rwl
+ VSS VSS u_t004_001/m2_717_1265# u_t004_001/m2_603_2031# u_t004_001/m2_1290_336#
+ u_t004_001/m2_2000_2037# u_t004_001/m2_791_2909# u_t004_001/m2_7_2126# u_t004_001/m2_2154_2081#
+ u_t004_001/m2_1795_2037# u_t004_001/m2_871_303# u_t004_001/m2_431_438# u_t004_001/m2_1290_2898#
+ u_t004_001/m2_1714_1210# u_t004_001/m2_431_1982# u_t004_001/m2_512_1265# u_t004_001/m2_2573_2126#
+ u_t004_001/m2_603_1259# u_t004_001/m2_2074_2909# u_t004_001/m2_7_336# u_t004_001/m2_717_2037#
+ u_t004_001/m2_1886_2031# u_t004_001/m2_2573_336# u_t004_001/m2_7_2898# u_t004_001/m2_2000_1265#
+ u_t004_001/m2_512_2037# u_t004_001/m2_1795_1265# u_t004_001/m2_1714_1982# u_t004_001/m2_1886_1259#
+ u_t004_001/m2_1290_2126# u_t004_001/m2_1714_438# u_t004_001/m2_431_1210# u_t004_001/m2_2573_2898#
+ u_t004_001/m2_2154_303# u_t004_001/m2_871_2081# VSUBS detronyx_12t_2w2r_rc4_4x4_routed_5layer_direct
Xgf180mcu_as_sc_mcu7t3v3__inv_2_487 VSS VSS gf180mcu_as_sc_mcu7t3v3__inv_2_487/Y gf180mcu_as_sc_mcu7t3v3__inv_2_487/A
+ gf180mcu_as_sc_mcu7t3v3__inv_2_550/VNW VSUBS gf180mcu_as_sc_mcu7t3v3__inv_2
Xgf180mcu_as_sc_mcu7t3v3__inv_2_476 gf180mcu_as_sc_mcu7t3v3__nor2_2_7/VDD gf180mcu_as_sc_mcu7t3v3__nor2_2_7/VSS
+ VSS VSS gf180mcu_as_sc_mcu7t3v3__nor2_2_7/VNW VSUBS gf180mcu_as_sc_mcu7t3v3__inv_2
Xgf180mcu_as_sc_mcu7t3v3__inv_2_465 gf180mcu_as_sc_mcu7t3v3__nand3_2_9/VDD gf180mcu_as_sc_mcu7t3v3__nor2_2_4/VSS
+ VSS VSS gf180mcu_as_sc_mcu7t3v3__nand3_2_9/VNW VSUBS gf180mcu_as_sc_mcu7t3v3__inv_2
Xgf180mcu_as_sc_mcu7t3v3__inv_2_498 VSS VSS gf180mcu_as_sc_mcu7t3v3__inv_2_498/Y gf180mcu_as_sc_mcu7t3v3__inv_2_498/A
+ gf180mcu_as_sc_mcu7t3v3__inv_2_561/VNW VSUBS gf180mcu_as_sc_mcu7t3v3__inv_2
Xu_t010_015 u_t010_015/c0_w0_bl u_t010_015/c0_w0_br u_t010_015/c0_w1_bl u_t010_015/c0_w1_br
+ u_t010_015/c0_r0_rbl u_t010_015/c0_r1_rbl u_t010_015/c1_w0_bl u_t010_015/c1_w0_br
+ u_t010_015/c1_w1_bl u_t010_015/c1_w1_br u_t010_015/c1_r0_rbl u_t010_015/c1_r1_rbl
+ u_t010_015/c2_w0_bl u_t010_015/c2_w0_br u_t010_015/c2_w1_bl u_t010_015/c2_w1_br
+ u_t010_015/c2_r0_rbl u_t010_015/c2_r1_rbl u_t010_015/c3_w0_bl u_t010_015/c3_w0_br
+ u_t010_015/c3_w1_bl u_t010_015/c3_w1_br u_t010_015/c3_r0_rbl u_t010_015/c3_r1_rbl
+ u_t010_015/r0_w0_wl u_t010_015/r0_w1_wl u_t010_015/r0_r0_rwl u_t010_015/r0_r1_rwl
+ u_t010_015/r1_w0_wl u_t010_015/r1_w1_wl u_t010_015/r1_r0_rwl u_t010_015/r1_r1_rwl
+ u_t010_015/r2_w0_wl u_t010_015/r2_w1_wl u_t010_015/r2_r0_rwl u_t010_015/r2_r1_rwl
+ u_t010_015/r3_w0_wl u_t010_015/r3_w1_wl u_t010_015/r3_r0_rwl u_t010_015/r3_r1_rwl
+ VSS VSS u_t010_015/m2_717_1265# u_t010_015/m2_603_2031# u_t010_015/m2_1290_336#
+ u_t010_015/m2_2000_2037# u_t010_015/m2_791_2909# u_t010_015/m2_7_2126# u_t010_015/m2_2154_2081#
+ u_t010_015/m2_1795_2037# u_t010_015/m2_871_303# u_t010_015/m2_431_438# u_t010_015/m2_1290_2898#
+ u_t010_015/m2_1714_1210# u_t010_015/m2_431_1982# u_t010_015/m2_512_1265# u_t010_015/m2_2573_2126#
+ u_t010_015/m2_603_1259# u_t010_015/m2_2074_2909# u_t010_015/m2_7_336# u_t010_015/m2_717_2037#
+ u_t010_015/m2_1886_2031# u_t010_015/m2_2573_336# u_t010_015/m2_7_2898# u_t010_015/m2_2000_1265#
+ u_t010_015/m2_512_2037# u_t010_015/m2_1795_1265# u_t010_015/m2_1714_1982# u_t010_015/m2_1886_1259#
+ u_t010_015/m2_1290_2126# u_t010_015/m2_1714_438# u_t010_015/m2_431_1210# u_t010_015/m2_2573_2898#
+ u_t010_015/m2_2154_303# u_t010_015/m2_871_2081# VSUBS detronyx_12t_2w2r_rc4_4x4_routed_5layer_direct
Xu_t010_004 u_t010_004/c0_w0_bl u_t010_004/c0_w0_br u_t010_004/c0_w1_bl u_t010_004/c0_w1_br
+ u_t010_004/c0_r0_rbl u_t010_004/c0_r1_rbl u_t010_004/c1_w0_bl u_t010_004/c1_w0_br
+ u_t010_004/c1_w1_bl u_t010_004/c1_w1_br u_t010_004/c1_r0_rbl u_t010_004/c1_r1_rbl
+ u_t010_004/c2_w0_bl u_t010_004/c2_w0_br u_t010_004/c2_w1_bl u_t010_004/c2_w1_br
+ u_t010_004/c2_r0_rbl u_t010_004/c2_r1_rbl u_t010_004/c3_w0_bl u_t010_004/c3_w0_br
+ u_t010_004/c3_w1_bl u_t010_004/c3_w1_br u_t010_004/c3_r0_rbl u_t010_004/c3_r1_rbl
+ u_t010_004/r0_w0_wl u_t010_004/r0_w1_wl u_t010_004/r0_r0_rwl u_t010_004/r0_r1_rwl
+ u_t010_004/r1_w0_wl u_t010_004/r1_w1_wl u_t010_004/r1_r0_rwl u_t010_004/r1_r1_rwl
+ u_t010_004/r2_w0_wl u_t010_004/r2_w1_wl u_t010_004/r2_r0_rwl u_t010_004/r2_r1_rwl
+ u_t010_004/r3_w0_wl u_t010_004/r3_w1_wl u_t010_004/r3_r0_rwl u_t010_004/r3_r1_rwl
+ VSS VSS u_t010_004/m2_717_1265# u_t010_004/m2_603_2031# u_t010_004/m2_1290_336#
+ u_t010_004/m2_2000_2037# u_t010_004/m2_791_2909# u_t010_004/m2_7_2126# u_t010_004/m2_2154_2081#
+ u_t010_004/m2_1795_2037# u_t010_004/m2_871_303# u_t010_004/m2_431_438# u_t010_004/m2_1290_2898#
+ u_t010_004/m2_1714_1210# u_t010_004/m2_431_1982# u_t010_004/m2_512_1265# u_t010_004/m2_2573_2126#
+ u_t010_004/m2_603_1259# u_t010_004/m2_2074_2909# u_t010_004/m2_7_336# u_t010_004/m2_717_2037#
+ u_t010_004/m2_1886_2031# u_t010_004/m2_2573_336# u_t010_004/m2_7_2898# u_t010_004/m2_2000_1265#
+ u_t010_004/m2_512_2037# u_t010_004/m2_1795_1265# u_t010_004/m2_1714_1982# u_t010_004/m2_1886_1259#
+ u_t010_004/m2_1290_2126# u_t010_004/m2_1714_438# u_t010_004/m2_431_1210# u_t010_004/m2_2573_2898#
+ u_t010_004/m2_2154_303# u_t010_004/m2_871_2081# VSUBS detronyx_12t_2w2r_rc4_4x4_routed_5layer_direct
Xu_t001_015 u_t001_015/c0_w0_bl u_t001_015/c0_w0_br u_t001_015/c0_w1_bl u_t001_015/c0_w1_br
+ u_t001_015/c0_r0_rbl u_t001_015/c0_r1_rbl u_t001_015/c1_w0_bl u_t001_015/c1_w0_br
+ u_t001_015/c1_w1_bl u_t001_015/c1_w1_br u_t001_015/c1_r0_rbl u_t001_015/c1_r1_rbl
+ u_t001_015/c2_w0_bl u_t001_015/c2_w0_br u_t001_015/c2_w1_bl u_t001_015/c2_w1_br
+ u_t001_015/c2_r0_rbl u_t001_015/c2_r1_rbl u_t001_015/c3_w0_bl u_t001_015/c3_w0_br
+ u_t001_015/c3_w1_bl u_t001_015/c3_w1_br u_t001_015/c3_r0_rbl u_t001_015/c3_r1_rbl
+ u_t001_015/r0_w0_wl u_t001_015/r0_w1_wl u_t001_015/r0_r0_rwl u_t001_015/r0_r1_rwl
+ u_t001_015/r1_w0_wl u_t001_015/r1_w1_wl u_t001_015/r1_r0_rwl u_t001_015/r1_r1_rwl
+ u_t001_015/r2_w0_wl u_t001_015/r2_w1_wl u_t001_015/r2_r0_rwl u_t001_015/r2_r1_rwl
+ u_t001_015/r3_w0_wl u_t001_015/r3_w1_wl u_t001_015/r3_r0_rwl u_t001_015/r3_r1_rwl
+ VSS VSS u_t001_015/m2_717_1265# u_t001_015/m2_603_2031# u_t001_015/m2_1290_336#
+ u_t001_015/m2_2000_2037# u_t001_015/m2_791_2909# u_t001_015/m2_7_2126# u_t001_015/m2_2154_2081#
+ u_t001_015/m2_1795_2037# u_t001_015/m2_871_303# u_t001_015/m2_431_438# u_t001_015/m2_1290_2898#
+ u_t001_015/m2_1714_1210# u_t001_015/m2_431_1982# u_t001_015/m2_512_1265# u_t001_015/m2_2573_2126#
+ u_t001_015/m2_603_1259# u_t001_015/m2_2074_2909# u_t001_015/m2_7_336# u_t001_015/m2_717_2037#
+ u_t001_015/m2_1886_2031# u_t001_015/m2_2573_336# u_t001_015/m2_7_2898# u_t001_015/m2_2000_1265#
+ u_t001_015/m2_512_2037# u_t001_015/m2_1795_1265# u_t001_015/m2_1714_1982# u_t001_015/m2_1886_1259#
+ u_t001_015/m2_1290_2126# u_t001_015/m2_1714_438# u_t001_015/m2_431_1210# u_t001_015/m2_2573_2898#
+ u_t001_015/m2_2154_303# u_t001_015/m2_871_2081# VSUBS detronyx_12t_2w2r_rc4_4x4_routed_5layer_direct
Xu_t001_004 u_t001_004/c0_w0_bl u_t001_004/c0_w0_br u_t001_004/c0_w1_bl u_t001_004/c0_w1_br
+ u_t001_004/c0_r0_rbl u_t001_004/c0_r1_rbl u_t001_004/c1_w0_bl u_t001_004/c1_w0_br
+ u_t001_004/c1_w1_bl u_t001_004/c1_w1_br u_t001_004/c1_r0_rbl u_t001_004/c1_r1_rbl
+ u_t001_004/c2_w0_bl u_t001_004/c2_w0_br u_t001_004/c2_w1_bl u_t001_004/c2_w1_br
+ u_t001_004/c2_r0_rbl u_t001_004/c2_r1_rbl u_t001_004/c3_w0_bl u_t001_004/c3_w0_br
+ u_t001_004/c3_w1_bl u_t001_004/c3_w1_br u_t001_004/c3_r0_rbl u_t001_004/c3_r1_rbl
+ u_t001_004/r0_w0_wl u_t001_004/r0_w1_wl u_t001_004/r0_r0_rwl u_t001_004/r0_r1_rwl
+ u_t001_004/r1_w0_wl u_t001_004/r1_w1_wl u_t001_004/r1_r0_rwl u_t001_004/r1_r1_rwl
+ u_t001_004/r2_w0_wl u_t001_004/r2_w1_wl u_t001_004/r2_r0_rwl u_t001_004/r2_r1_rwl
+ u_t001_004/r3_w0_wl u_t001_004/r3_w1_wl u_t001_004/r3_r0_rwl u_t001_004/r3_r1_rwl
+ VSS VSS u_t001_004/m2_717_1265# u_t001_004/m2_603_2031# u_t001_004/m2_1290_336#
+ u_t001_004/m2_2000_2037# u_t001_004/m2_791_2909# u_t001_004/m2_7_2126# u_t001_004/m2_2154_2081#
+ u_t001_004/m2_1795_2037# u_t001_004/m2_871_303# u_t001_004/m2_431_438# u_t001_004/m2_1290_2898#
+ u_t001_004/m2_1714_1210# u_t001_004/m2_431_1982# u_t001_004/m2_512_1265# u_t001_004/m2_2573_2126#
+ u_t001_004/m2_603_1259# u_t001_004/m2_2074_2909# u_t001_004/m2_7_336# u_t001_004/m2_717_2037#
+ u_t001_004/m2_1886_2031# u_t001_004/m2_2573_336# u_t001_004/m2_7_2898# u_t001_004/m2_2000_1265#
+ u_t001_004/m2_512_2037# u_t001_004/m2_1795_1265# u_t001_004/m2_1714_1982# u_t001_004/m2_1886_1259#
+ u_t001_004/m2_1290_2126# u_t001_004/m2_1714_438# u_t001_004/m2_431_1210# u_t001_004/m2_2573_2898#
+ u_t001_004/m2_2154_303# u_t001_004/m2_871_2081# VSUBS detronyx_12t_2w2r_rc4_4x4_routed_5layer_direct
Xgf180mcu_as_sc_mcu7t3v3__inv_2_273 VSS VSS VSS gf180mcu_as_sc_mcu7t3v3__inv_2_277/Y
+ gf180mcu_as_sc_mcu7t3v3__inv_2_281/VNW VSUBS gf180mcu_as_sc_mcu7t3v3__inv_2
Xgf180mcu_as_sc_mcu7t3v3__inv_2_262 VSS VSS VSS gf180mcu_as_sc_mcu7t3v3__inv_2_263/Y
+ gf180mcu_as_sc_mcu7t3v3__inv_2_264/VNW VSUBS gf180mcu_as_sc_mcu7t3v3__inv_2
Xgf180mcu_as_sc_mcu7t3v3__inv_2_284 VSS VSS VSS gf180mcu_as_sc_mcu7t3v3__inv_2_286/Y
+ gf180mcu_as_sc_mcu7t3v3__inv_2_287/VNW VSUBS gf180mcu_as_sc_mcu7t3v3__inv_2
Xgf180mcu_as_sc_mcu7t3v3__inv_2_295 VSS VSS VSS gf180mcu_as_sc_mcu7t3v3__inv_2_298/Y
+ gf180mcu_as_sc_mcu7t3v3__inv_2_298/VNW VSUBS gf180mcu_as_sc_mcu7t3v3__inv_2
Xgf180mcu_as_sc_mcu7t3v3__inv_2_251 VSS VSS gf180mcu_as_sc_mcu7t3v3__inv_2_251/Y gf180mcu_as_sc_mcu7t3v3__inv_2_251/A
+ gf180mcu_as_sc_mcu7t3v3__inv_2_251/VNW VSUBS gf180mcu_as_sc_mcu7t3v3__inv_2
Xgf180mcu_as_sc_mcu7t3v3__inv_2_240 VSS VSS VSS gf180mcu_as_sc_mcu7t3v3__inv_2_241/Y
+ gf180mcu_as_sc_mcu7t3v3__inv_2_242/VNW VSUBS gf180mcu_as_sc_mcu7t3v3__inv_2
Xgf180mcu_as_sc_mcu7t3v3__inv_2_1706 gf180mcu_as_sc_mcu7t3v3__nor2_2_4/VDD gf180mcu_as_sc_mcu7t3v3__nand2_2_3/VSS
+ VSS VSS gf180mcu_as_sc_mcu7t3v3__nor2_2_4/VNW VSUBS gf180mcu_as_sc_mcu7t3v3__inv_2
Xgf180mcu_as_sc_mcu7t3v3__inv_2_1717 VSS VSS gf180mcu_as_sc_mcu7t3v3__inv_2_1717/Y
+ gf180mcu_as_sc_mcu7t3v3__inv_2_1717/A gf180mcu_as_sc_mcu7t3v3__inv_2_1717/VNW VSUBS
+ gf180mcu_as_sc_mcu7t3v3__inv_2
Xgf180mcu_as_sc_mcu7t3v3__inv_2_1569 VSS VSS gf180mcu_as_sc_mcu7t3v3__inv_2_1569/Y
+ gf180mcu_as_sc_mcu7t3v3__inv_2_1570/Y gf180mcu_as_sc_mcu7t3v3__inv_2_1570/VNW VSUBS
+ gf180mcu_as_sc_mcu7t3v3__inv_2
Xgf180mcu_as_sc_mcu7t3v3__inv_2_1547 VSS VSS gf180mcu_as_sc_mcu7t3v3__inv_2_1547/Y
+ gf180mcu_as_sc_mcu7t3v3__inv_2_1547/A gf180mcu_as_sc_mcu7t3v3__inv_2_1547/VNW VSUBS
+ gf180mcu_as_sc_mcu7t3v3__inv_2
Xgf180mcu_as_sc_mcu7t3v3__inv_2_1558 VSS VSS gf180mcu_as_sc_mcu7t3v3__inv_2_1558/Y
+ gf180mcu_as_sc_mcu7t3v3__inv_2_1559/Y gf180mcu_as_sc_mcu7t3v3__inv_2_1559/VNW VSUBS
+ gf180mcu_as_sc_mcu7t3v3__inv_2
Xgf180mcu_as_sc_mcu7t3v3__inv_2_1514 VSS VSS gf180mcu_as_sc_mcu7t3v3__inv_2_1514/Y
+ gf180mcu_as_sc_mcu7t3v3__inv_2_1514/A gf180mcu_as_sc_mcu7t3v3__inv_2_1514/VNW VSUBS
+ gf180mcu_as_sc_mcu7t3v3__inv_2
Xgf180mcu_as_sc_mcu7t3v3__inv_2_1525 VSS VSS gf180mcu_as_sc_mcu7t3v3__inv_2_1525/Y
+ gf180mcu_as_sc_mcu7t3v3__inv_2_1526/Y gf180mcu_as_sc_mcu7t3v3__inv_2_1526/VNW VSUBS
+ gf180mcu_as_sc_mcu7t3v3__inv_2
Xgf180mcu_as_sc_mcu7t3v3__inv_2_1536 VSS VSS VSS gf180mcu_as_sc_mcu7t3v3__inv_2_1537/Y
+ gf180mcu_as_sc_mcu7t3v3__inv_2_1538/VNW VSUBS gf180mcu_as_sc_mcu7t3v3__inv_2
Xgf180mcu_as_sc_mcu7t3v3__inv_2_1503 VSS VSS gf180mcu_as_sc_mcu7t3v3__inv_2_1503/Y
+ gf180mcu_as_sc_mcu7t3v3__inv_2_1503/A gf180mcu_as_sc_mcu7t3v3__inv_2_1503/VNW VSUBS
+ gf180mcu_as_sc_mcu7t3v3__inv_2
Xgf180mcu_as_sc_mcu7t3v3__nand4_2_308 VSS VSS VSS VSS VSS VSS gf180mcu_as_sc_mcu7t3v3__inv_2_1056/A
+ gf180mcu_as_sc_mcu7t3v3__inv_2_1056/VNW VSUBS gf180mcu_as_sc_mcu7t3v3__nand4_2
Xgf180mcu_as_sc_mcu7t3v3__nand4_2_319 VSS VSS VSS VSS VSS VSS gf180mcu_as_sc_mcu7t3v3__inv_2_1071/A
+ gf180mcu_as_sc_mcu7t3v3__inv_2_1071/VNW VSUBS gf180mcu_as_sc_mcu7t3v3__nand4_2
Xgf180mcu_as_sc_mcu7t3v3__nand2_2_2 gf180mcu_as_sc_mcu7t3v3__nor2_2_7/VDD gf180mcu_as_sc_mcu7t3v3__nand3_2_4/VSS
+ VSS VSS VSS gf180mcu_as_sc_mcu7t3v3__nor2_2_7/VNW VSUBS gf180mcu_as_sc_mcu7t3v3__nand2_2
Xu_t029_007 u_t029_007/c0_w0_bl u_t029_007/c0_w0_br u_t029_007/c0_w1_bl u_t029_007/c0_w1_br
+ u_t029_007/c0_r0_rbl u_t029_007/c0_r1_rbl u_t029_007/c1_w0_bl u_t029_007/c1_w0_br
+ u_t029_007/c1_w1_bl u_t029_007/c1_w1_br u_t029_007/c1_r0_rbl u_t029_007/c1_r1_rbl
+ u_t029_007/c2_w0_bl u_t029_007/c2_w0_br u_t029_007/c2_w1_bl u_t029_007/c2_w1_br
+ u_t029_007/c2_r0_rbl u_t029_007/c2_r1_rbl u_t029_007/c3_w0_bl u_t029_007/c3_w0_br
+ u_t029_007/c3_w1_bl u_t029_007/c3_w1_br u_t029_007/c3_r0_rbl u_t029_007/c3_r1_rbl
+ u_t029_007/r0_w0_wl u_t029_007/r0_w1_wl u_t029_007/r0_r0_rwl u_t029_007/r0_r1_rwl
+ u_t029_007/r1_w0_wl u_t029_007/r1_w1_wl u_t029_007/r1_r0_rwl u_t029_007/r1_r1_rwl
+ u_t029_007/r2_w0_wl u_t029_007/r2_w1_wl u_t029_007/r2_r0_rwl u_t029_007/r2_r1_rwl
+ u_t029_007/r3_w0_wl u_t029_007/r3_w1_wl u_t029_007/r3_r0_rwl u_t029_007/r3_r1_rwl
+ VSS VSS u_t029_007/m2_717_1265# u_t029_007/m2_603_2031# u_t029_007/m2_1290_336#
+ u_t029_007/m2_2000_2037# u_t029_007/m2_791_2909# u_t029_007/m2_7_2126# u_t029_007/m2_2154_2081#
+ u_t029_007/m2_1795_2037# u_t029_007/m2_871_303# u_t029_007/m2_431_438# u_t029_007/m2_1290_2898#
+ u_t029_007/m2_1714_1210# u_t029_007/m2_431_1982# u_t029_007/m2_512_1265# u_t029_007/m2_2573_2126#
+ u_t029_007/m2_603_1259# u_t029_007/m2_2074_2909# u_t029_007/m2_7_336# u_t029_007/m2_717_2037#
+ u_t029_007/m2_1886_2031# u_t029_007/m2_2573_336# u_t029_007/m2_7_2898# u_t029_007/m2_2000_1265#
+ u_t029_007/m2_512_2037# u_t029_007/m2_1795_1265# u_t029_007/m2_1714_1982# u_t029_007/m2_1886_1259#
+ u_t029_007/m2_1290_2126# u_t029_007/m2_1714_438# u_t029_007/m2_431_1210# u_t029_007/m2_2573_2898#
+ u_t029_007/m2_2154_303# u_t029_007/m2_871_2081# VSUBS detronyx_12t_2w2r_rc4_4x4_routed_5layer_direct
Xgf180mcu_as_sc_mcu7t3v3__inv_2_1300 VSS VSS VSS gf180mcu_as_sc_mcu7t3v3__inv_2_1300/A
+ gf180mcu_as_sc_mcu7t3v3__inv_2_1300/VNW VSUBS gf180mcu_as_sc_mcu7t3v3__inv_2
Xgf180mcu_as_sc_mcu7t3v3__inv_2_1322 VSS VSS VSS gf180mcu_as_sc_mcu7t3v3__inv_2_1323/Y
+ gf180mcu_as_sc_mcu7t3v3__inv_2_1324/VNW VSUBS gf180mcu_as_sc_mcu7t3v3__inv_2
Xgf180mcu_as_sc_mcu7t3v3__inv_2_1333 VSS VSS gf180mcu_as_sc_mcu7t3v3__inv_2_1333/Y
+ gf180mcu_as_sc_mcu7t3v3__inv_2_1333/A gf180mcu_as_sc_mcu7t3v3__inv_2_1333/VNW VSUBS
+ gf180mcu_as_sc_mcu7t3v3__inv_2
Xgf180mcu_as_sc_mcu7t3v3__inv_2_1311 VSS VSS gf180mcu_as_sc_mcu7t3v3__inv_2_1311/Y
+ gf180mcu_as_sc_mcu7t3v3__inv_2_1312/Y gf180mcu_as_sc_mcu7t3v3__inv_2_1312/VNW VSUBS
+ gf180mcu_as_sc_mcu7t3v3__inv_2
Xgf180mcu_as_sc_mcu7t3v3__inv_2_1344 VSS VSS gf180mcu_as_sc_mcu7t3v3__inv_2_1344/Y
+ gf180mcu_as_sc_mcu7t3v3__inv_2_1344/A gf180mcu_as_sc_mcu7t3v3__inv_2_1344/VNW VSUBS
+ gf180mcu_as_sc_mcu7t3v3__inv_2
Xgf180mcu_as_sc_mcu7t3v3__inv_2_1366 VSS VSS gf180mcu_as_sc_mcu7t3v3__inv_2_1366/Y
+ gf180mcu_as_sc_mcu7t3v3__inv_2_1366/A gf180mcu_as_sc_mcu7t3v3__inv_2_1366/VNW VSUBS
+ gf180mcu_as_sc_mcu7t3v3__inv_2
Xgf180mcu_as_sc_mcu7t3v3__inv_2_1377 VSS VSS gf180mcu_as_sc_mcu7t3v3__inv_2_1377/Y
+ gf180mcu_as_sc_mcu7t3v3__inv_2_1378/Y gf180mcu_as_sc_mcu7t3v3__inv_2_1378/VNW VSUBS
+ gf180mcu_as_sc_mcu7t3v3__inv_2
Xgf180mcu_as_sc_mcu7t3v3__inv_2_1388 VSS VSS VSS gf180mcu_as_sc_mcu7t3v3__inv_2_1389/Y
+ gf180mcu_as_sc_mcu7t3v3__inv_2_1390/VNW VSUBS gf180mcu_as_sc_mcu7t3v3__inv_2
Xgf180mcu_as_sc_mcu7t3v3__inv_2_1399 VSS VSS VSS gf180mcu_as_sc_mcu7t3v3__inv_2_1403/Y
+ gf180mcu_as_sc_mcu7t3v3__inv_2_1403/VNW VSUBS gf180mcu_as_sc_mcu7t3v3__inv_2
Xgf180mcu_as_sc_mcu7t3v3__inv_2_1355 VSS VSS gf180mcu_as_sc_mcu7t3v3__inv_2_1355/Y
+ gf180mcu_as_sc_mcu7t3v3__inv_2_1355/A gf180mcu_as_sc_mcu7t3v3__inv_2_1355/VNW VSUBS
+ gf180mcu_as_sc_mcu7t3v3__inv_2
Xgf180mcu_as_sc_mcu7t3v3__inv_2_828 VSS VSS VSS gf180mcu_as_sc_mcu7t3v3__inv_2_828/A
+ gf180mcu_as_sc_mcu7t3v3__inv_2_828/VNW VSUBS gf180mcu_as_sc_mcu7t3v3__inv_2
Xgf180mcu_as_sc_mcu7t3v3__inv_2_817 VSS VSS VSS gf180mcu_as_sc_mcu7t3v3__inv_2_818/Y
+ gf180mcu_as_sc_mcu7t3v3__inv_2_819/VNW VSUBS gf180mcu_as_sc_mcu7t3v3__inv_2
Xgf180mcu_as_sc_mcu7t3v3__inv_2_839 VSS VSS VSS gf180mcu_as_sc_mcu7t3v3__inv_2_839/A
+ gf180mcu_as_sc_mcu7t3v3__inv_2_839/VNW VSUBS gf180mcu_as_sc_mcu7t3v3__inv_2
Xgf180mcu_as_sc_mcu7t3v3__inv_2_806 VSS VSS gf180mcu_as_sc_mcu7t3v3__inv_2_806/Y gf180mcu_as_sc_mcu7t3v3__inv_2_806/A
+ gf180mcu_as_sc_mcu7t3v3__inv_2_838/VNW VSUBS gf180mcu_as_sc_mcu7t3v3__inv_2
Xgf180mcu_as_sc_mcu7t3v3__nand4_2_149 VSS VSS VSS VSS VSS VSS gf180mcu_as_sc_mcu7t3v3__inv_2_542/A
+ gf180mcu_as_sc_mcu7t3v3__inv_2_542/VNW VSUBS gf180mcu_as_sc_mcu7t3v3__nand4_2
Xgf180mcu_as_sc_mcu7t3v3__nand4_2_127 VSS VSS VSS VSS VSS VSS gf180mcu_as_sc_mcu7t3v3__inv_2_453/A
+ gf180mcu_as_sc_mcu7t3v3__inv_2_546/VNW VSUBS gf180mcu_as_sc_mcu7t3v3__nand4_2
Xgf180mcu_as_sc_mcu7t3v3__nand4_2_138 VSS VSS VSS VSS VSS VSS gf180mcu_as_sc_mcu7t3v3__inv_2_499/A
+ gf180mcu_as_sc_mcu7t3v3__inv_2_563/VNW VSUBS gf180mcu_as_sc_mcu7t3v3__nand4_2
Xgf180mcu_as_sc_mcu7t3v3__nand4_2_105 VSS VSS VSS VSS VSS VSS gf180mcu_as_sc_mcu7t3v3__inv_2_368/A
+ gf180mcu_as_sc_mcu7t3v3__inv_2_368/VNW VSUBS gf180mcu_as_sc_mcu7t3v3__nand4_2
Xgf180mcu_as_sc_mcu7t3v3__nand4_2_116 VSS VSS VSS VSS VSS VSS gf180mcu_as_sc_mcu7t3v3__inv_2_290/A
+ gf180mcu_as_sc_mcu7t3v3__inv_2_304/VNW VSUBS gf180mcu_as_sc_mcu7t3v3__nand4_2
Xgf180mcu_as_sc_mcu7t3v3__nand4_2_66 VSS VSS VSS VSS VSS VSS gf180mcu_as_sc_mcu7t3v3__inv_2_20/A
+ gf180mcu_as_sc_mcu7t3v3__inv_2_20/VNW VSUBS gf180mcu_as_sc_mcu7t3v3__nand4_2
Xgf180mcu_as_sc_mcu7t3v3__nand4_2_22 VSS VSS VSS VSS VSS VSS gf180mcu_as_sc_mcu7t3v3__inv_2_146/A
+ gf180mcu_as_sc_mcu7t3v3__inv_2_146/VNW VSUBS gf180mcu_as_sc_mcu7t3v3__nand4_2
Xgf180mcu_as_sc_mcu7t3v3__nand4_2_88 VSS VSS VSS VSS VSS VSS gf180mcu_as_sc_mcu7t3v3__inv_2_25/A
+ gf180mcu_as_sc_mcu7t3v3__inv_2_25/VNW VSUBS gf180mcu_as_sc_mcu7t3v3__nand4_2
Xgf180mcu_as_sc_mcu7t3v3__nand4_2_11 VSS VSS VSS VSS VSS VSS gf180mcu_as_sc_mcu7t3v3__inv_2_113/A
+ gf180mcu_as_sc_mcu7t3v3__inv_2_113/VNW VSUBS gf180mcu_as_sc_mcu7t3v3__nand4_2
Xgf180mcu_as_sc_mcu7t3v3__nand4_2_33 VSS VSS VSS VSS VSS VSS gf180mcu_as_sc_mcu7t3v3__inv_2_180/A
+ gf180mcu_as_sc_mcu7t3v3__inv_2_180/VNW VSUBS gf180mcu_as_sc_mcu7t3v3__nand4_2
Xgf180mcu_as_sc_mcu7t3v3__nand4_2_99 VSS VSS VSS VSS VSS VSS gf180mcu_as_sc_mcu7t3v3__inv_2_350/A
+ gf180mcu_as_sc_mcu7t3v3__inv_2_350/VNW VSUBS gf180mcu_as_sc_mcu7t3v3__nand4_2
Xgf180mcu_as_sc_mcu7t3v3__nand4_2_44 VSS VSS VSS VSS VSS VSS gf180mcu_as_sc_mcu7t3v3__inv_2_212/A
+ gf180mcu_as_sc_mcu7t3v3__inv_2_212/VNW VSUBS gf180mcu_as_sc_mcu7t3v3__nand4_2
Xgf180mcu_as_sc_mcu7t3v3__nand4_2_77 VSS VSS VSS VSS VSS VSS gf180mcu_as_sc_mcu7t3v3__inv_2_335/A
+ gf180mcu_as_sc_mcu7t3v3__inv_2_335/VNW VSUBS gf180mcu_as_sc_mcu7t3v3__nand4_2
Xgf180mcu_as_sc_mcu7t3v3__nand4_2_55 VSS VSS VSS VSS VSS VSS gf180mcu_as_sc_mcu7t3v3__inv_2_245/A
+ gf180mcu_as_sc_mcu7t3v3__inv_2_245/VNW VSUBS gf180mcu_as_sc_mcu7t3v3__nand4_2
Xu_t025_010 u_t025_010/c0_w0_bl u_t025_010/c0_w0_br u_t025_010/c0_w1_bl u_t025_010/c0_w1_br
+ u_t025_010/c0_r0_rbl u_t025_010/c0_r1_rbl u_t025_010/c1_w0_bl u_t025_010/c1_w0_br
+ u_t025_010/c1_w1_bl u_t025_010/c1_w1_br u_t025_010/c1_r0_rbl u_t025_010/c1_r1_rbl
+ u_t025_010/c2_w0_bl u_t025_010/c2_w0_br u_t025_010/c2_w1_bl u_t025_010/c2_w1_br
+ u_t025_010/c2_r0_rbl u_t025_010/c2_r1_rbl u_t025_010/c3_w0_bl u_t025_010/c3_w0_br
+ u_t025_010/c3_w1_bl u_t025_010/c3_w1_br u_t025_010/c3_r0_rbl u_t025_010/c3_r1_rbl
+ u_t025_010/r0_w0_wl u_t025_010/r0_w1_wl u_t025_010/r0_r0_rwl u_t025_010/r0_r1_rwl
+ u_t025_010/r1_w0_wl u_t025_010/r1_w1_wl u_t025_010/r1_r0_rwl u_t025_010/r1_r1_rwl
+ u_t025_010/r2_w0_wl u_t025_010/r2_w1_wl u_t025_010/r2_r0_rwl u_t025_010/r2_r1_rwl
+ u_t025_010/r3_w0_wl u_t025_010/r3_w1_wl u_t025_010/r3_r0_rwl u_t025_010/r3_r1_rwl
+ VSS VSS u_t025_010/m2_717_1265# u_t025_010/m2_603_2031# u_t025_010/m2_1290_336#
+ u_t025_010/m2_2000_2037# u_t025_010/m2_791_2909# u_t025_010/m2_7_2126# u_t025_010/m2_2154_2081#
+ u_t025_010/m2_1795_2037# u_t025_010/m2_871_303# u_t025_010/m2_431_438# u_t025_010/m2_1290_2898#
+ u_t025_010/m2_1714_1210# u_t025_010/m2_431_1982# u_t025_010/m2_512_1265# u_t025_010/m2_2573_2126#
+ u_t025_010/m2_603_1259# u_t025_010/m2_2074_2909# u_t025_010/m2_7_336# u_t025_010/m2_717_2037#
+ u_t025_010/m2_1886_2031# u_t025_010/m2_2573_336# u_t025_010/m2_7_2898# u_t025_010/m2_2000_1265#
+ u_t025_010/m2_512_2037# u_t025_010/m2_1795_1265# u_t025_010/m2_1714_1982# u_t025_010/m2_1886_1259#
+ u_t025_010/m2_1290_2126# u_t025_010/m2_1714_438# u_t025_010/m2_431_1210# u_t025_010/m2_2573_2898#
+ u_t025_010/m2_2154_303# u_t025_010/m2_871_2081# VSUBS detronyx_12t_2w2r_rc4_4x4_routed_5layer_direct
Xgf180mcu_as_sc_mcu7t3v3__inv_2_1141 VSS VSS gf180mcu_as_sc_mcu7t3v3__inv_2_1141/Y
+ gf180mcu_as_sc_mcu7t3v3__inv_2_1142/Y gf180mcu_as_sc_mcu7t3v3__inv_2_1142/VNW VSUBS
+ gf180mcu_as_sc_mcu7t3v3__inv_2
Xgf180mcu_as_sc_mcu7t3v3__inv_2_1130 VSS VSS gf180mcu_as_sc_mcu7t3v3__inv_2_1130/Y
+ gf180mcu_as_sc_mcu7t3v3__inv_2_1130/A gf180mcu_as_sc_mcu7t3v3__inv_2_1130/VNW VSUBS
+ gf180mcu_as_sc_mcu7t3v3__inv_2
Xgf180mcu_as_sc_mcu7t3v3__inv_2_1185 VSS VSS gf180mcu_as_sc_mcu7t3v3__inv_2_1289/A
+ gf180mcu_as_sc_mcu7t3v3__inv_2_1185/A gf180mcu_as_sc_mcu7t3v3__inv_2_1289/VNW VSUBS
+ gf180mcu_as_sc_mcu7t3v3__inv_2
Xgf180mcu_as_sc_mcu7t3v3__inv_2_1152 VSS VSS gf180mcu_as_sc_mcu7t3v3__inv_2_1185/A
+ gf180mcu_as_sc_mcu7t3v3__inv_2_1152/A gf180mcu_as_sc_mcu7t3v3__inv_2_1289/VNW VSUBS
+ gf180mcu_as_sc_mcu7t3v3__inv_2
Xgf180mcu_as_sc_mcu7t3v3__inv_2_1163 VSS VSS gf180mcu_as_sc_mcu7t3v3__inv_2_1293/A
+ gf180mcu_as_sc_mcu7t3v3__inv_2_1164/Y gf180mcu_as_sc_mcu7t3v3__inv_2_1293/VNW VSUBS
+ gf180mcu_as_sc_mcu7t3v3__inv_2
Xgf180mcu_as_sc_mcu7t3v3__inv_2_1174 VSS VSS gf180mcu_as_sc_mcu7t3v3__inv_2_1174/Y
+ gf180mcu_as_sc_mcu7t3v3__inv_2_1174/A gf180mcu_as_sc_mcu7t3v3__inv_2_1295/VNW VSUBS
+ gf180mcu_as_sc_mcu7t3v3__inv_2
Xgf180mcu_as_sc_mcu7t3v3__inv_2_1196 gf180mcu_as_sc_mcu7t3v3__nand3_2_65/VDD gf180mcu_as_sc_mcu7t3v3__nor2_2_9/VSS
+ gf180mcu_as_sc_mcu7t3v3__inv_2_1196/Y VSS gf180mcu_as_sc_mcu7t3v3__nand3_2_65/VNW
+ VSUBS gf180mcu_as_sc_mcu7t3v3__inv_2
Xu_t016_010 u_t016_010/c0_w0_bl u_t016_010/c0_w0_br u_t016_010/c0_w1_bl u_t016_010/c0_w1_br
+ u_t016_010/c0_r0_rbl u_t016_010/c0_r1_rbl u_t016_010/c1_w0_bl u_t016_010/c1_w0_br
+ u_t016_010/c1_w1_bl u_t016_010/c1_w1_br u_t016_010/c1_r0_rbl u_t016_010/c1_r1_rbl
+ u_t016_010/c2_w0_bl u_t016_010/c2_w0_br u_t016_010/c2_w1_bl u_t016_010/c2_w1_br
+ u_t016_010/c2_r0_rbl u_t016_010/c2_r1_rbl u_t016_010/c3_w0_bl u_t016_010/c3_w0_br
+ u_t016_010/c3_w1_bl u_t016_010/c3_w1_br u_t016_010/c3_r0_rbl u_t016_010/c3_r1_rbl
+ u_t016_010/r0_w0_wl u_t016_010/r0_w1_wl u_t016_010/r0_r0_rwl u_t016_010/r0_r1_rwl
+ u_t016_010/r1_w0_wl u_t016_010/r1_w1_wl u_t016_010/r1_r0_rwl u_t016_010/r1_r1_rwl
+ u_t016_010/r2_w0_wl u_t016_010/r2_w1_wl u_t016_010/r2_r0_rwl u_t016_010/r2_r1_rwl
+ u_t016_010/r3_w0_wl u_t016_010/r3_w1_wl u_t016_010/r3_r0_rwl u_t016_010/r3_r1_rwl
+ VSS VSS u_t016_010/m2_717_1265# u_t016_010/m2_603_2031# u_t016_010/m2_1290_336#
+ u_t016_010/m2_2000_2037# u_t016_010/m2_791_2909# u_t016_010/m2_7_2126# u_t016_010/m2_2154_2081#
+ u_t016_010/m2_1795_2037# u_t016_010/m2_871_303# u_t016_010/m2_431_438# u_t016_010/m2_1290_2898#
+ u_t016_010/m2_1714_1210# u_t016_010/m2_431_1982# u_t016_010/m2_512_1265# u_t016_010/m2_2573_2126#
+ u_t016_010/m2_603_1259# u_t016_010/m2_2074_2909# u_t016_010/m2_7_336# u_t016_010/m2_717_2037#
+ u_t016_010/m2_1886_2031# u_t016_010/m2_2573_336# u_t016_010/m2_7_2898# u_t016_010/m2_2000_1265#
+ u_t016_010/m2_512_2037# u_t016_010/m2_1795_1265# u_t016_010/m2_1714_1982# u_t016_010/m2_1886_1259#
+ u_t016_010/m2_1290_2126# u_t016_010/m2_1714_438# u_t016_010/m2_431_1210# u_t016_010/m2_2573_2898#
+ u_t016_010/m2_2154_303# u_t016_010/m2_871_2081# VSUBS detronyx_12t_2w2r_rc4_4x4_routed_5layer_direct
Xgf180mcu_as_sc_mcu7t3v3__inv_2_603 VSS VSS gf180mcu_as_sc_mcu7t3v3__inv_2_603/Y gf180mcu_as_sc_mcu7t3v3__inv_2_603/A
+ gf180mcu_as_sc_mcu7t3v3__inv_2_603/VNW VSUBS gf180mcu_as_sc_mcu7t3v3__inv_2
Xgf180mcu_as_sc_mcu7t3v3__inv_2_625 VSS VSS VSS gf180mcu_as_sc_mcu7t3v3__inv_2_629/Y
+ gf180mcu_as_sc_mcu7t3v3__inv_2_633/VNW VSUBS gf180mcu_as_sc_mcu7t3v3__inv_2
Xgf180mcu_as_sc_mcu7t3v3__inv_2_636 VSS VSS gf180mcu_as_sc_mcu7t3v3__inv_2_636/Y gf180mcu_as_sc_mcu7t3v3__inv_2_636/A
+ gf180mcu_as_sc_mcu7t3v3__inv_2_636/VNW VSUBS gf180mcu_as_sc_mcu7t3v3__inv_2
Xgf180mcu_as_sc_mcu7t3v3__inv_2_614 VSS VSS VSS gf180mcu_as_sc_mcu7t3v3__inv_2_615/Y
+ gf180mcu_as_sc_mcu7t3v3__inv_2_616/VNW VSUBS gf180mcu_as_sc_mcu7t3v3__inv_2
Xu_t031_013 u_t031_013/c0_w0_bl u_t031_013/c0_w0_br u_t031_013/c0_w1_bl u_t031_013/c0_w1_br
+ u_t031_013/c0_r0_rbl u_t031_013/c0_r1_rbl u_t031_013/c1_w0_bl u_t031_013/c1_w0_br
+ u_t031_013/c1_w1_bl u_t031_013/c1_w1_br u_t031_013/c1_r0_rbl u_t031_013/c1_r1_rbl
+ u_t031_013/c2_w0_bl u_t031_013/c2_w0_br u_t031_013/c2_w1_bl u_t031_013/c2_w1_br
+ u_t031_013/c2_r0_rbl u_t031_013/c2_r1_rbl u_t031_013/c3_w0_bl u_t031_013/c3_w0_br
+ u_t031_013/c3_w1_bl u_t031_013/c3_w1_br u_t031_013/c3_r0_rbl u_t031_013/c3_r1_rbl
+ u_t031_013/r0_w0_wl u_t031_013/r0_w1_wl u_t031_013/r0_r0_rwl u_t031_013/r0_r1_rwl
+ u_t031_013/r1_w0_wl u_t031_013/r1_w1_wl u_t031_013/r1_r0_rwl u_t031_013/r1_r1_rwl
+ u_t031_013/r2_w0_wl u_t031_013/r2_w1_wl u_t031_013/r2_r0_rwl u_t031_013/r2_r1_rwl
+ u_t031_013/r3_w0_wl u_t031_013/r3_w1_wl u_t031_013/r3_r0_rwl u_t031_013/r3_r1_rwl
+ VSS VSS u_t031_013/m2_717_1265# u_t031_013/m2_603_2031# u_t031_013/m2_1290_336#
+ u_t031_013/m2_2000_2037# u_t031_013/m2_791_2909# u_t031_013/m2_7_2126# u_t031_013/m2_2154_2081#
+ u_t031_013/m2_1795_2037# u_t031_013/m2_871_303# u_t031_013/m2_431_438# u_t031_013/m2_1290_2898#
+ u_t031_013/m2_1714_1210# u_t031_013/m2_431_1982# u_t031_013/m2_512_1265# u_t031_013/m2_2573_2126#
+ u_t031_013/m2_603_1259# u_t031_013/m2_2074_2909# u_t031_013/m2_7_336# u_t031_013/m2_717_2037#
+ u_t031_013/m2_1886_2031# u_t031_013/m2_2573_336# u_t031_013/m2_7_2898# u_t031_013/m2_2000_1265#
+ u_t031_013/m2_512_2037# u_t031_013/m2_1795_1265# u_t031_013/m2_1714_1982# u_t031_013/m2_1886_1259#
+ u_t031_013/m2_1290_2126# u_t031_013/m2_1714_438# u_t031_013/m2_431_1210# u_t031_013/m2_2573_2898#
+ u_t031_013/m2_2154_303# u_t031_013/m2_871_2081# VSUBS detronyx_12t_2w2r_rc4_4x4_routed_5layer_direct
Xu_t031_002 u_t031_002/c0_w0_bl u_t031_002/c0_w0_br u_t031_002/c0_w1_bl u_t031_002/c0_w1_br
+ u_t031_002/c0_r0_rbl u_t031_002/c0_r1_rbl u_t031_002/c1_w0_bl u_t031_002/c1_w0_br
+ u_t031_002/c1_w1_bl u_t031_002/c1_w1_br u_t031_002/c1_r0_rbl u_t031_002/c1_r1_rbl
+ u_t031_002/c2_w0_bl u_t031_002/c2_w0_br u_t031_002/c2_w1_bl u_t031_002/c2_w1_br
+ u_t031_002/c2_r0_rbl u_t031_002/c2_r1_rbl u_t031_002/c3_w0_bl u_t031_002/c3_w0_br
+ u_t031_002/c3_w1_bl u_t031_002/c3_w1_br u_t031_002/c3_r0_rbl u_t031_002/c3_r1_rbl
+ u_t031_002/r0_w0_wl u_t031_002/r0_w1_wl u_t031_002/r0_r0_rwl u_t031_002/r0_r1_rwl
+ u_t031_002/r1_w0_wl u_t031_002/r1_w1_wl u_t031_002/r1_r0_rwl u_t031_002/r1_r1_rwl
+ u_t031_002/r2_w0_wl u_t031_002/r2_w1_wl u_t031_002/r2_r0_rwl u_t031_002/r2_r1_rwl
+ u_t031_002/r3_w0_wl u_t031_002/r3_w1_wl u_t031_002/r3_r0_rwl u_t031_002/r3_r1_rwl
+ VSS VSS u_t031_002/m2_717_1265# u_t031_002/m2_603_2031# u_t031_002/m2_1290_336#
+ u_t031_002/m2_2000_2037# u_t031_002/m2_791_2909# u_t031_002/m2_7_2126# u_t031_002/m2_2154_2081#
+ u_t031_002/m2_1795_2037# u_t031_002/m2_871_303# u_t031_002/m2_431_438# u_t031_002/m2_1290_2898#
+ u_t031_002/m2_1714_1210# u_t031_002/m2_431_1982# u_t031_002/m2_512_1265# u_t031_002/m2_2573_2126#
+ u_t031_002/m2_603_1259# u_t031_002/m2_2074_2909# u_t031_002/m2_7_336# u_t031_002/m2_717_2037#
+ u_t031_002/m2_1886_2031# u_t031_002/m2_2573_336# u_t031_002/m2_7_2898# u_t031_002/m2_2000_1265#
+ u_t031_002/m2_512_2037# u_t031_002/m2_1795_1265# u_t031_002/m2_1714_1982# u_t031_002/m2_1886_1259#
+ u_t031_002/m2_1290_2126# u_t031_002/m2_1714_438# u_t031_002/m2_431_1210# u_t031_002/m2_2573_2898#
+ u_t031_002/m2_2154_303# u_t031_002/m2_871_2081# VSUBS detronyx_12t_2w2r_rc4_4x4_routed_5layer_direct
Xgf180mcu_as_sc_mcu7t3v3__inv_2_647 VSS VSS VSS gf180mcu_as_sc_mcu7t3v3__inv_2_651/Y
+ gf180mcu_as_sc_mcu7t3v3__inv_2_652/VNW VSUBS gf180mcu_as_sc_mcu7t3v3__inv_2
Xgf180mcu_as_sc_mcu7t3v3__inv_2_658 VSS VSS VSS gf180mcu_as_sc_mcu7t3v3__inv_2_659/Y
+ gf180mcu_as_sc_mcu7t3v3__inv_2_660/VNW VSUBS gf180mcu_as_sc_mcu7t3v3__inv_2
Xgf180mcu_as_sc_mcu7t3v3__inv_2_669 VSS VSS gf180mcu_as_sc_mcu7t3v3__inv_2_669/Y gf180mcu_as_sc_mcu7t3v3__inv_2_670/Y
+ gf180mcu_as_sc_mcu7t3v3__inv_2_670/VNW VSUBS gf180mcu_as_sc_mcu7t3v3__inv_2
Xu_t022_013 u_t022_013/c0_w0_bl u_t022_013/c0_w0_br u_t022_013/c0_w1_bl u_t022_013/c0_w1_br
+ u_t022_013/c0_r0_rbl u_t022_013/c0_r1_rbl u_t022_013/c1_w0_bl u_t022_013/c1_w0_br
+ u_t022_013/c1_w1_bl u_t022_013/c1_w1_br u_t022_013/c1_r0_rbl u_t022_013/c1_r1_rbl
+ u_t022_013/c2_w0_bl u_t022_013/c2_w0_br u_t022_013/c2_w1_bl u_t022_013/c2_w1_br
+ u_t022_013/c2_r0_rbl u_t022_013/c2_r1_rbl u_t022_013/c3_w0_bl u_t022_013/c3_w0_br
+ u_t022_013/c3_w1_bl u_t022_013/c3_w1_br u_t022_013/c3_r0_rbl u_t022_013/c3_r1_rbl
+ u_t022_013/r0_w0_wl u_t022_013/r0_w1_wl u_t022_013/r0_r0_rwl u_t022_013/r0_r1_rwl
+ u_t022_013/r1_w0_wl u_t022_013/r1_w1_wl u_t022_013/r1_r0_rwl u_t022_013/r1_r1_rwl
+ u_t022_013/r2_w0_wl u_t022_013/r2_w1_wl u_t022_013/r2_r0_rwl u_t022_013/r2_r1_rwl
+ u_t022_013/r3_w0_wl u_t022_013/r3_w1_wl u_t022_013/r3_r0_rwl u_t022_013/r3_r1_rwl
+ VSS VSS u_t022_013/m2_717_1265# u_t022_013/m2_603_2031# u_t022_013/m2_1290_336#
+ u_t022_013/m2_2000_2037# u_t022_013/m2_791_2909# u_t022_013/m2_7_2126# u_t022_013/m2_2154_2081#
+ u_t022_013/m2_1795_2037# u_t022_013/m2_871_303# u_t022_013/m2_431_438# u_t022_013/m2_1290_2898#
+ u_t022_013/m2_1714_1210# u_t022_013/m2_431_1982# u_t022_013/m2_512_1265# u_t022_013/m2_2573_2126#
+ u_t022_013/m2_603_1259# u_t022_013/m2_2074_2909# u_t022_013/m2_7_336# u_t022_013/m2_717_2037#
+ u_t022_013/m2_1886_2031# u_t022_013/m2_2573_336# u_t022_013/m2_7_2898# u_t022_013/m2_2000_1265#
+ u_t022_013/m2_512_2037# u_t022_013/m2_1795_1265# u_t022_013/m2_1714_1982# u_t022_013/m2_1886_1259#
+ u_t022_013/m2_1290_2126# u_t022_013/m2_1714_438# u_t022_013/m2_431_1210# u_t022_013/m2_2573_2898#
+ u_t022_013/m2_2154_303# u_t022_013/m2_871_2081# VSUBS detronyx_12t_2w2r_rc4_4x4_routed_5layer_direct
Xu_t007_010 u_t007_010/c0_w0_bl u_t007_010/c0_w0_br u_t007_010/c0_w1_bl u_t007_010/c0_w1_br
+ u_t007_010/c0_r0_rbl u_t007_010/c0_r1_rbl u_t007_010/c1_w0_bl u_t007_010/c1_w0_br
+ u_t007_010/c1_w1_bl u_t007_010/c1_w1_br u_t007_010/c1_r0_rbl u_t007_010/c1_r1_rbl
+ u_t007_010/c2_w0_bl u_t007_010/c2_w0_br u_t007_010/c2_w1_bl u_t007_010/c2_w1_br
+ u_t007_010/c2_r0_rbl u_t007_010/c2_r1_rbl u_t007_010/c3_w0_bl u_t007_010/c3_w0_br
+ u_t007_010/c3_w1_bl u_t007_010/c3_w1_br u_t007_010/c3_r0_rbl u_t007_010/c3_r1_rbl
+ u_t007_010/r0_w0_wl u_t007_010/r0_w1_wl u_t007_010/r0_r0_rwl u_t007_010/r0_r1_rwl
+ u_t007_010/r1_w0_wl u_t007_010/r1_w1_wl u_t007_010/r1_r0_rwl u_t007_010/r1_r1_rwl
+ u_t007_010/r2_w0_wl u_t007_010/r2_w1_wl u_t007_010/r2_r0_rwl u_t007_010/r2_r1_rwl
+ u_t007_010/r3_w0_wl u_t007_010/r3_w1_wl u_t007_010/r3_r0_rwl u_t007_010/r3_r1_rwl
+ VSS VSS u_t007_010/m2_717_1265# u_t007_010/m2_603_2031# u_t007_010/m2_1290_336#
+ u_t007_010/m2_2000_2037# u_t007_010/m2_791_2909# u_t007_010/m2_7_2126# u_t007_010/m2_2154_2081#
+ u_t007_010/m2_1795_2037# u_t007_010/m2_871_303# u_t007_010/m2_431_438# u_t007_010/m2_1290_2898#
+ u_t007_010/m2_1714_1210# u_t007_010/m2_431_1982# u_t007_010/m2_512_1265# u_t007_010/m2_2573_2126#
+ u_t007_010/m2_603_1259# u_t007_010/m2_2074_2909# u_t007_010/m2_7_336# u_t007_010/m2_717_2037#
+ u_t007_010/m2_1886_2031# u_t007_010/m2_2573_336# u_t007_010/m2_7_2898# u_t007_010/m2_2000_1265#
+ u_t007_010/m2_512_2037# u_t007_010/m2_1795_1265# u_t007_010/m2_1714_1982# u_t007_010/m2_1886_1259#
+ u_t007_010/m2_1290_2126# u_t007_010/m2_1714_438# u_t007_010/m2_431_1210# u_t007_010/m2_2573_2898#
+ u_t007_010/m2_2154_303# u_t007_010/m2_871_2081# VSUBS detronyx_12t_2w2r_rc4_4x4_routed_5layer_direct
Xu_t022_002 u_t022_002/c0_w0_bl u_t022_002/c0_w0_br u_t022_002/c0_w1_bl u_t022_002/c0_w1_br
+ u_t022_002/c0_r0_rbl u_t022_002/c0_r1_rbl u_t022_002/c1_w0_bl u_t022_002/c1_w0_br
+ u_t022_002/c1_w1_bl u_t022_002/c1_w1_br u_t022_002/c1_r0_rbl u_t022_002/c1_r1_rbl
+ u_t022_002/c2_w0_bl u_t022_002/c2_w0_br u_t022_002/c2_w1_bl u_t022_002/c2_w1_br
+ u_t022_002/c2_r0_rbl u_t022_002/c2_r1_rbl u_t022_002/c3_w0_bl u_t022_002/c3_w0_br
+ u_t022_002/c3_w1_bl u_t022_002/c3_w1_br u_t022_002/c3_r0_rbl u_t022_002/c3_r1_rbl
+ u_t022_002/r0_w0_wl u_t022_002/r0_w1_wl u_t022_002/r0_r0_rwl u_t022_002/r0_r1_rwl
+ u_t022_002/r1_w0_wl u_t022_002/r1_w1_wl u_t022_002/r1_r0_rwl u_t022_002/r1_r1_rwl
+ u_t022_002/r2_w0_wl u_t022_002/r2_w1_wl u_t022_002/r2_r0_rwl u_t022_002/r2_r1_rwl
+ u_t022_002/r3_w0_wl u_t022_002/r3_w1_wl u_t022_002/r3_r0_rwl u_t022_002/r3_r1_rwl
+ VSS VSS u_t022_002/m2_717_1265# u_t022_002/m2_603_2031# u_t022_002/m2_1290_336#
+ u_t022_002/m2_2000_2037# u_t022_002/m2_791_2909# u_t022_002/m2_7_2126# u_t022_002/m2_2154_2081#
+ u_t022_002/m2_1795_2037# u_t022_002/m2_871_303# u_t022_002/m2_431_438# u_t022_002/m2_1290_2898#
+ u_t022_002/m2_1714_1210# u_t022_002/m2_431_1982# u_t022_002/m2_512_1265# u_t022_002/m2_2573_2126#
+ u_t022_002/m2_603_1259# u_t022_002/m2_2074_2909# u_t022_002/m2_7_336# u_t022_002/m2_717_2037#
+ u_t022_002/m2_1886_2031# u_t022_002/m2_2573_336# u_t022_002/m2_7_2898# u_t022_002/m2_2000_1265#
+ u_t022_002/m2_512_2037# u_t022_002/m2_1795_1265# u_t022_002/m2_1714_1982# u_t022_002/m2_1886_1259#
+ u_t022_002/m2_1290_2126# u_t022_002/m2_1714_438# u_t022_002/m2_431_1210# u_t022_002/m2_2573_2898#
+ u_t022_002/m2_2154_303# u_t022_002/m2_871_2081# VSUBS detronyx_12t_2w2r_rc4_4x4_routed_5layer_direct
Xgf180mcu_as_sc_mcu7t3v3__nand4_2_491 VSS VSS VSS VSS VSS VSS gf180mcu_as_sc_mcu7t3v3__inv_2_1688/A
+ gf180mcu_as_sc_mcu7t3v3__inv_2_1688/VNW VSUBS gf180mcu_as_sc_mcu7t3v3__nand4_2
Xgf180mcu_as_sc_mcu7t3v3__nand4_2_480 VSS VSS VSS VSS VSS VSS gf180mcu_as_sc_mcu7t3v3__inv_2_1408/A
+ gf180mcu_as_sc_mcu7t3v3__inv_2_1409/VNW VSUBS gf180mcu_as_sc_mcu7t3v3__nand4_2
Xu_t013_013 u_t013_013/c0_w0_bl u_t013_013/c0_w0_br u_t013_013/c0_w1_bl u_t013_013/c0_w1_br
+ u_t013_013/c0_r0_rbl u_t013_013/c0_r1_rbl u_t013_013/c1_w0_bl u_t013_013/c1_w0_br
+ u_t013_013/c1_w1_bl u_t013_013/c1_w1_br u_t013_013/c1_r0_rbl u_t013_013/c1_r1_rbl
+ u_t013_013/c2_w0_bl u_t013_013/c2_w0_br u_t013_013/c2_w1_bl u_t013_013/c2_w1_br
+ u_t013_013/c2_r0_rbl u_t013_013/c2_r1_rbl u_t013_013/c3_w0_bl u_t013_013/c3_w0_br
+ u_t013_013/c3_w1_bl u_t013_013/c3_w1_br u_t013_013/c3_r0_rbl u_t013_013/c3_r1_rbl
+ u_t013_013/r0_w0_wl u_t013_013/r0_w1_wl u_t013_013/r0_r0_rwl u_t013_013/r0_r1_rwl
+ u_t013_013/r1_w0_wl u_t013_013/r1_w1_wl u_t013_013/r1_r0_rwl u_t013_013/r1_r1_rwl
+ u_t013_013/r2_w0_wl u_t013_013/r2_w1_wl u_t013_013/r2_r0_rwl u_t013_013/r2_r1_rwl
+ u_t013_013/r3_w0_wl u_t013_013/r3_w1_wl u_t013_013/r3_r0_rwl u_t013_013/r3_r1_rwl
+ VSS VSS u_t013_013/m2_717_1265# u_t013_013/m2_603_2031# u_t013_013/m2_1290_336#
+ u_t013_013/m2_2000_2037# u_t013_013/m2_791_2909# u_t013_013/m2_7_2126# u_t013_013/m2_2154_2081#
+ u_t013_013/m2_1795_2037# u_t013_013/m2_871_303# u_t013_013/m2_431_438# u_t013_013/m2_1290_2898#
+ u_t013_013/m2_1714_1210# u_t013_013/m2_431_1982# u_t013_013/m2_512_1265# u_t013_013/m2_2573_2126#
+ u_t013_013/m2_603_1259# u_t013_013/m2_2074_2909# u_t013_013/m2_7_336# u_t013_013/m2_717_2037#
+ u_t013_013/m2_1886_2031# u_t013_013/m2_2573_336# u_t013_013/m2_7_2898# u_t013_013/m2_2000_1265#
+ u_t013_013/m2_512_2037# u_t013_013/m2_1795_1265# u_t013_013/m2_1714_1982# u_t013_013/m2_1886_1259#
+ u_t013_013/m2_1290_2126# u_t013_013/m2_1714_438# u_t013_013/m2_431_1210# u_t013_013/m2_2573_2898#
+ u_t013_013/m2_2154_303# u_t013_013/m2_871_2081# VSUBS detronyx_12t_2w2r_rc4_4x4_routed_5layer_direct
Xu_t013_002 u_t013_002/c0_w0_bl u_t013_002/c0_w0_br u_t013_002/c0_w1_bl u_t013_002/c0_w1_br
+ u_t013_002/c0_r0_rbl u_t013_002/c0_r1_rbl u_t013_002/c1_w0_bl u_t013_002/c1_w0_br
+ u_t013_002/c1_w1_bl u_t013_002/c1_w1_br u_t013_002/c1_r0_rbl u_t013_002/c1_r1_rbl
+ u_t013_002/c2_w0_bl u_t013_002/c2_w0_br u_t013_002/c2_w1_bl u_t013_002/c2_w1_br
+ u_t013_002/c2_r0_rbl u_t013_002/c2_r1_rbl u_t013_002/c3_w0_bl u_t013_002/c3_w0_br
+ u_t013_002/c3_w1_bl u_t013_002/c3_w1_br u_t013_002/c3_r0_rbl u_t013_002/c3_r1_rbl
+ u_t013_002/r0_w0_wl u_t013_002/r0_w1_wl u_t013_002/r0_r0_rwl u_t013_002/r0_r1_rwl
+ u_t013_002/r1_w0_wl u_t013_002/r1_w1_wl u_t013_002/r1_r0_rwl u_t013_002/r1_r1_rwl
+ u_t013_002/r2_w0_wl u_t013_002/r2_w1_wl u_t013_002/r2_r0_rwl u_t013_002/r2_r1_rwl
+ u_t013_002/r3_w0_wl u_t013_002/r3_w1_wl u_t013_002/r3_r0_rwl u_t013_002/r3_r1_rwl
+ VSS VSS u_t013_002/m2_717_1265# u_t013_002/m2_603_2031# u_t013_002/m2_1290_336#
+ u_t013_002/m2_2000_2037# u_t013_002/m2_791_2909# u_t013_002/m2_7_2126# u_t013_002/m2_2154_2081#
+ u_t013_002/m2_1795_2037# u_t013_002/m2_871_303# u_t013_002/m2_431_438# u_t013_002/m2_1290_2898#
+ u_t013_002/m2_1714_1210# u_t013_002/m2_431_1982# u_t013_002/m2_512_1265# u_t013_002/m2_2573_2126#
+ u_t013_002/m2_603_1259# u_t013_002/m2_2074_2909# u_t013_002/m2_7_336# u_t013_002/m2_717_2037#
+ u_t013_002/m2_1886_2031# u_t013_002/m2_2573_336# u_t013_002/m2_7_2898# u_t013_002/m2_2000_1265#
+ u_t013_002/m2_512_2037# u_t013_002/m2_1795_1265# u_t013_002/m2_1714_1982# u_t013_002/m2_1886_1259#
+ u_t013_002/m2_1290_2126# u_t013_002/m2_1714_438# u_t013_002/m2_431_1210# u_t013_002/m2_2573_2898#
+ u_t013_002/m2_2154_303# u_t013_002/m2_871_2081# VSUBS detronyx_12t_2w2r_rc4_4x4_routed_5layer_direct
Xu_t004_013 u_t004_013/c0_w0_bl u_t004_013/c0_w0_br u_t004_013/c0_w1_bl u_t004_013/c0_w1_br
+ u_t004_013/c0_r0_rbl u_t004_013/c0_r1_rbl u_t004_013/c1_w0_bl u_t004_013/c1_w0_br
+ u_t004_013/c1_w1_bl u_t004_013/c1_w1_br u_t004_013/c1_r0_rbl u_t004_013/c1_r1_rbl
+ u_t004_013/c2_w0_bl u_t004_013/c2_w0_br u_t004_013/c2_w1_bl u_t004_013/c2_w1_br
+ u_t004_013/c2_r0_rbl u_t004_013/c2_r1_rbl u_t004_013/c3_w0_bl u_t004_013/c3_w0_br
+ u_t004_013/c3_w1_bl u_t004_013/c3_w1_br u_t004_013/c3_r0_rbl u_t004_013/c3_r1_rbl
+ u_t004_013/r0_w0_wl u_t004_013/r0_w1_wl u_t004_013/r0_r0_rwl u_t004_013/r0_r1_rwl
+ u_t004_013/r1_w0_wl u_t004_013/r1_w1_wl u_t004_013/r1_r0_rwl u_t004_013/r1_r1_rwl
+ u_t004_013/r2_w0_wl u_t004_013/r2_w1_wl u_t004_013/r2_r0_rwl u_t004_013/r2_r1_rwl
+ u_t004_013/r3_w0_wl u_t004_013/r3_w1_wl u_t004_013/r3_r0_rwl u_t004_013/r3_r1_rwl
+ VSS VSS u_t004_013/m2_717_1265# u_t004_013/m2_603_2031# u_t004_013/m2_1290_336#
+ u_t004_013/m2_2000_2037# u_t004_013/m2_791_2909# u_t004_013/m2_7_2126# u_t004_013/m2_2154_2081#
+ u_t004_013/m2_1795_2037# u_t004_013/m2_871_303# u_t004_013/m2_431_438# u_t004_013/m2_1290_2898#
+ u_t004_013/m2_1714_1210# u_t004_013/m2_431_1982# u_t004_013/m2_512_1265# u_t004_013/m2_2573_2126#
+ u_t004_013/m2_603_1259# u_t004_013/m2_2074_2909# u_t004_013/m2_7_336# u_t004_013/m2_717_2037#
+ u_t004_013/m2_1886_2031# u_t004_013/m2_2573_336# u_t004_013/m2_7_2898# u_t004_013/m2_2000_1265#
+ u_t004_013/m2_512_2037# u_t004_013/m2_1795_1265# u_t004_013/m2_1714_1982# u_t004_013/m2_1886_1259#
+ u_t004_013/m2_1290_2126# u_t004_013/m2_1714_438# u_t004_013/m2_431_1210# u_t004_013/m2_2573_2898#
+ u_t004_013/m2_2154_303# u_t004_013/m2_871_2081# VSUBS detronyx_12t_2w2r_rc4_4x4_routed_5layer_direct
Xu_t004_002 u_t004_002/c0_w0_bl u_t004_002/c0_w0_br u_t004_002/c0_w1_bl u_t004_002/c0_w1_br
+ u_t004_002/c0_r0_rbl u_t004_002/c0_r1_rbl u_t004_002/c1_w0_bl u_t004_002/c1_w0_br
+ u_t004_002/c1_w1_bl u_t004_002/c1_w1_br u_t004_002/c1_r0_rbl u_t004_002/c1_r1_rbl
+ u_t004_002/c2_w0_bl u_t004_002/c2_w0_br u_t004_002/c2_w1_bl u_t004_002/c2_w1_br
+ u_t004_002/c2_r0_rbl u_t004_002/c2_r1_rbl u_t004_002/c3_w0_bl u_t004_002/c3_w0_br
+ u_t004_002/c3_w1_bl u_t004_002/c3_w1_br u_t004_002/c3_r0_rbl u_t004_002/c3_r1_rbl
+ u_t004_002/r0_w0_wl u_t004_002/r0_w1_wl u_t004_002/r0_r0_rwl u_t004_002/r0_r1_rwl
+ u_t004_002/r1_w0_wl u_t004_002/r1_w1_wl u_t004_002/r1_r0_rwl u_t004_002/r1_r1_rwl
+ u_t004_002/r2_w0_wl u_t004_002/r2_w1_wl u_t004_002/r2_r0_rwl u_t004_002/r2_r1_rwl
+ u_t004_002/r3_w0_wl u_t004_002/r3_w1_wl u_t004_002/r3_r0_rwl u_t004_002/r3_r1_rwl
+ VSS VSS u_t004_002/m2_717_1265# u_t004_002/m2_603_2031# u_t004_002/m2_1290_336#
+ u_t004_002/m2_2000_2037# u_t004_002/m2_791_2909# u_t004_002/m2_7_2126# u_t004_002/m2_2154_2081#
+ u_t004_002/m2_1795_2037# u_t004_002/m2_871_303# u_t004_002/m2_431_438# u_t004_002/m2_1290_2898#
+ u_t004_002/m2_1714_1210# u_t004_002/m2_431_1982# u_t004_002/m2_512_1265# u_t004_002/m2_2573_2126#
+ u_t004_002/m2_603_1259# u_t004_002/m2_2074_2909# u_t004_002/m2_7_336# u_t004_002/m2_717_2037#
+ u_t004_002/m2_1886_2031# u_t004_002/m2_2573_336# u_t004_002/m2_7_2898# u_t004_002/m2_2000_1265#
+ u_t004_002/m2_512_2037# u_t004_002/m2_1795_1265# u_t004_002/m2_1714_1982# u_t004_002/m2_1886_1259#
+ u_t004_002/m2_1290_2126# u_t004_002/m2_1714_438# u_t004_002/m2_431_1210# u_t004_002/m2_2573_2898#
+ u_t004_002/m2_2154_303# u_t004_002/m2_871_2081# VSUBS detronyx_12t_2w2r_rc4_4x4_routed_5layer_direct
Xgf180mcu_as_sc_mcu7t3v3__inv_2_444 VSS VSS gf180mcu_as_sc_mcu7t3v3__inv_2_444/Y gf180mcu_as_sc_mcu7t3v3__inv_2_444/A
+ gf180mcu_as_sc_mcu7t3v3__inv_2_545/VNW VSUBS gf180mcu_as_sc_mcu7t3v3__inv_2
Xgf180mcu_as_sc_mcu7t3v3__inv_2_411 gf180mcu_as_sc_mcu7t3v3__nor2_2_6/VDD gf180mcu_as_sc_mcu7t3v3__nor2_2_6/VSS
+ VSS VSS gf180mcu_as_sc_mcu7t3v3__nor2_2_6/VNW VSUBS gf180mcu_as_sc_mcu7t3v3__inv_2
Xgf180mcu_as_sc_mcu7t3v3__inv_2_455 gf180mcu_as_sc_mcu7t3v3__nor2_2_6/VDD gf180mcu_as_sc_mcu7t3v3__nor2_2_6/VSS
+ VSS VSS gf180mcu_as_sc_mcu7t3v3__nor2_2_6/VNW VSUBS gf180mcu_as_sc_mcu7t3v3__inv_2
Xgf180mcu_as_sc_mcu7t3v3__inv_2_422 gf180mcu_as_sc_mcu7t3v3__nor2_2_7/VDD gf180mcu_as_sc_mcu7t3v3__nor2_2_7/VSS
+ gf180mcu_as_sc_mcu7t3v3__inv_2_422/Y VSS gf180mcu_as_sc_mcu7t3v3__nor2_2_7/VNW VSUBS
+ gf180mcu_as_sc_mcu7t3v3__inv_2
Xgf180mcu_as_sc_mcu7t3v3__inv_2_477 gf180mcu_as_sc_mcu7t3v3__nor2_2_4/VDD gf180mcu_as_sc_mcu7t3v3__nor2_2_4/VSS
+ gf180mcu_as_sc_mcu7t3v3__inv_2_477/Y VSS gf180mcu_as_sc_mcu7t3v3__nor2_2_4/VNW VSUBS
+ gf180mcu_as_sc_mcu7t3v3__inv_2
Xgf180mcu_as_sc_mcu7t3v3__inv_2_466 gf180mcu_as_sc_mcu7t3v3__nor2_2_4/VDD gf180mcu_as_sc_mcu7t3v3__nor2_2_4/VSS
+ VSS VSS gf180mcu_as_sc_mcu7t3v3__nor2_2_4/VNW VSUBS gf180mcu_as_sc_mcu7t3v3__inv_2
Xgf180mcu_as_sc_mcu7t3v3__inv_2_400 gf180mcu_as_sc_mcu7t3v3__nor2_2_4/VDD gf180mcu_as_sc_mcu7t3v3__nand2_2_3/VSS
+ VSS VSS gf180mcu_as_sc_mcu7t3v3__nor2_2_4/VNW VSUBS gf180mcu_as_sc_mcu7t3v3__inv_2
Xgf180mcu_as_sc_mcu7t3v3__inv_2_433 gf180mcu_as_sc_mcu7t3v3__nand3_2_9/VDD gf180mcu_as_sc_mcu7t3v3__nor2_2_4/VSS
+ VSS VSS gf180mcu_as_sc_mcu7t3v3__nand3_2_9/VNW VSUBS gf180mcu_as_sc_mcu7t3v3__inv_2
Xgf180mcu_as_sc_mcu7t3v3__inv_2_488 VSS VSS gf180mcu_as_sc_mcu7t3v3__inv_2_552/A gf180mcu_as_sc_mcu7t3v3__inv_2_489/Y
+ gf180mcu_as_sc_mcu7t3v3__inv_2_552/VNW VSUBS gf180mcu_as_sc_mcu7t3v3__inv_2
Xgf180mcu_as_sc_mcu7t3v3__inv_2_499 VSS VSS gf180mcu_as_sc_mcu7t3v3__inv_2_512/A gf180mcu_as_sc_mcu7t3v3__inv_2_499/A
+ gf180mcu_as_sc_mcu7t3v3__inv_2_563/VNW VSUBS gf180mcu_as_sc_mcu7t3v3__inv_2
Xu_t010_005 u_t010_005/c0_w0_bl u_t010_005/c0_w0_br u_t010_005/c0_w1_bl u_t010_005/c0_w1_br
+ u_t010_005/c0_r0_rbl u_t010_005/c0_r1_rbl u_t010_005/c1_w0_bl u_t010_005/c1_w0_br
+ u_t010_005/c1_w1_bl u_t010_005/c1_w1_br u_t010_005/c1_r0_rbl u_t010_005/c1_r1_rbl
+ u_t010_005/c2_w0_bl u_t010_005/c2_w0_br u_t010_005/c2_w1_bl u_t010_005/c2_w1_br
+ u_t010_005/c2_r0_rbl u_t010_005/c2_r1_rbl u_t010_005/c3_w0_bl u_t010_005/c3_w0_br
+ u_t010_005/c3_w1_bl u_t010_005/c3_w1_br u_t010_005/c3_r0_rbl u_t010_005/c3_r1_rbl
+ u_t010_005/r0_w0_wl u_t010_005/r0_w1_wl u_t010_005/r0_r0_rwl u_t010_005/r0_r1_rwl
+ u_t010_005/r1_w0_wl u_t010_005/r1_w1_wl u_t010_005/r1_r0_rwl u_t010_005/r1_r1_rwl
+ u_t010_005/r2_w0_wl u_t010_005/r2_w1_wl u_t010_005/r2_r0_rwl u_t010_005/r2_r1_rwl
+ u_t010_005/r3_w0_wl u_t010_005/r3_w1_wl u_t010_005/r3_r0_rwl u_t010_005/r3_r1_rwl
+ VSS VSS u_t010_005/m2_717_1265# u_t010_005/m2_603_2031# u_t010_005/m2_1290_336#
+ u_t010_005/m2_2000_2037# u_t010_005/m2_791_2909# u_t010_005/m2_7_2126# u_t010_005/m2_2154_2081#
+ u_t010_005/m2_1795_2037# u_t010_005/m2_871_303# u_t010_005/m2_431_438# u_t010_005/m2_1290_2898#
+ u_t010_005/m2_1714_1210# u_t010_005/m2_431_1982# u_t010_005/m2_512_1265# u_t010_005/m2_2573_2126#
+ u_t010_005/m2_603_1259# u_t010_005/m2_2074_2909# u_t010_005/m2_7_336# u_t010_005/m2_717_2037#
+ u_t010_005/m2_1886_2031# u_t010_005/m2_2573_336# u_t010_005/m2_7_2898# u_t010_005/m2_2000_1265#
+ u_t010_005/m2_512_2037# u_t010_005/m2_1795_1265# u_t010_005/m2_1714_1982# u_t010_005/m2_1886_1259#
+ u_t010_005/m2_1290_2126# u_t010_005/m2_1714_438# u_t010_005/m2_431_1210# u_t010_005/m2_2573_2898#
+ u_t010_005/m2_2154_303# u_t010_005/m2_871_2081# VSUBS detronyx_12t_2w2r_rc4_4x4_routed_5layer_direct
Xu_t001_005 u_t001_005/c0_w0_bl u_t001_005/c0_w0_br u_t001_005/c0_w1_bl u_t001_005/c0_w1_br
+ u_t001_005/c0_r0_rbl u_t001_005/c0_r1_rbl u_t001_005/c1_w0_bl u_t001_005/c1_w0_br
+ u_t001_005/c1_w1_bl u_t001_005/c1_w1_br u_t001_005/c1_r0_rbl u_t001_005/c1_r1_rbl
+ u_t001_005/c2_w0_bl u_t001_005/c2_w0_br u_t001_005/c2_w1_bl u_t001_005/c2_w1_br
+ u_t001_005/c2_r0_rbl u_t001_005/c2_r1_rbl u_t001_005/c3_w0_bl u_t001_005/c3_w0_br
+ u_t001_005/c3_w1_bl u_t001_005/c3_w1_br u_t001_005/c3_r0_rbl u_t001_005/c3_r1_rbl
+ u_t001_005/r0_w0_wl u_t001_005/r0_w1_wl u_t001_005/r0_r0_rwl u_t001_005/r0_r1_rwl
+ u_t001_005/r1_w0_wl u_t001_005/r1_w1_wl u_t001_005/r1_r0_rwl u_t001_005/r1_r1_rwl
+ u_t001_005/r2_w0_wl u_t001_005/r2_w1_wl u_t001_005/r2_r0_rwl u_t001_005/r2_r1_rwl
+ u_t001_005/r3_w0_wl u_t001_005/r3_w1_wl u_t001_005/r3_r0_rwl u_t001_005/r3_r1_rwl
+ VSS VSS u_t001_005/m2_717_1265# u_t001_005/m2_603_2031# u_t001_005/m2_1290_336#
+ u_t001_005/m2_2000_2037# u_t001_005/m2_791_2909# u_t001_005/m2_7_2126# u_t001_005/m2_2154_2081#
+ u_t001_005/m2_1795_2037# u_t001_005/m2_871_303# u_t001_005/m2_431_438# u_t001_005/m2_1290_2898#
+ u_t001_005/m2_1714_1210# u_t001_005/m2_431_1982# u_t001_005/m2_512_1265# u_t001_005/m2_2573_2126#
+ u_t001_005/m2_603_1259# u_t001_005/m2_2074_2909# u_t001_005/m2_7_336# u_t001_005/m2_717_2037#
+ u_t001_005/m2_1886_2031# u_t001_005/m2_2573_336# u_t001_005/m2_7_2898# u_t001_005/m2_2000_1265#
+ u_t001_005/m2_512_2037# u_t001_005/m2_1795_1265# u_t001_005/m2_1714_1982# u_t001_005/m2_1886_1259#
+ u_t001_005/m2_1290_2126# u_t001_005/m2_1714_438# u_t001_005/m2_431_1210# u_t001_005/m2_2573_2898#
+ u_t001_005/m2_2154_303# u_t001_005/m2_871_2081# VSUBS detronyx_12t_2w2r_rc4_4x4_routed_5layer_direct
Xgf180mcu_as_sc_mcu7t3v3__inv_2_263 VSS VSS gf180mcu_as_sc_mcu7t3v3__inv_2_263/Y gf180mcu_as_sc_mcu7t3v3__inv_2_264/Y
+ gf180mcu_as_sc_mcu7t3v3__inv_2_264/VNW VSUBS gf180mcu_as_sc_mcu7t3v3__inv_2
Xgf180mcu_as_sc_mcu7t3v3__inv_2_296 VSS VSS VSS gf180mcu_as_sc_mcu7t3v3__inv_2_302/Y
+ gf180mcu_as_sc_mcu7t3v3__inv_2_302/VNW VSUBS gf180mcu_as_sc_mcu7t3v3__inv_2
Xgf180mcu_as_sc_mcu7t3v3__inv_2_285 VSS VSS gf180mcu_as_sc_mcu7t3v3__inv_2_285/Y gf180mcu_as_sc_mcu7t3v3__inv_2_301/Y
+ gf180mcu_as_sc_mcu7t3v3__inv_2_301/VNW VSUBS gf180mcu_as_sc_mcu7t3v3__inv_2
Xgf180mcu_as_sc_mcu7t3v3__inv_2_274 VSS VSS gf180mcu_as_sc_mcu7t3v3__inv_2_274/Y gf180mcu_as_sc_mcu7t3v3__inv_2_274/A
+ gf180mcu_as_sc_mcu7t3v3__inv_2_274/VNW VSUBS gf180mcu_as_sc_mcu7t3v3__inv_2
Xgf180mcu_as_sc_mcu7t3v3__inv_2_230 VSS VSS gf180mcu_as_sc_mcu7t3v3__inv_2_230/Y gf180mcu_as_sc_mcu7t3v3__inv_2_230/A
+ gf180mcu_as_sc_mcu7t3v3__inv_2_230/VNW VSUBS gf180mcu_as_sc_mcu7t3v3__inv_2
Xgf180mcu_as_sc_mcu7t3v3__inv_2_252 VSS VSS VSS gf180mcu_as_sc_mcu7t3v3__inv_2_253/Y
+ gf180mcu_as_sc_mcu7t3v3__inv_2_254/VNW VSUBS gf180mcu_as_sc_mcu7t3v3__inv_2
Xgf180mcu_as_sc_mcu7t3v3__inv_2_241 VSS VSS gf180mcu_as_sc_mcu7t3v3__inv_2_241/Y gf180mcu_as_sc_mcu7t3v3__inv_2_242/Y
+ gf180mcu_as_sc_mcu7t3v3__inv_2_242/VNW VSUBS gf180mcu_as_sc_mcu7t3v3__inv_2
Xgf180mcu_as_sc_mcu7t3v3__inv_2_1707 gf180mcu_as_sc_mcu7t3v3__nor2_2_6/VDD gf180mcu_as_sc_mcu7t3v3__nor2_2_6/VSS
+ VSS VSS gf180mcu_as_sc_mcu7t3v3__nor2_2_6/VNW VSUBS gf180mcu_as_sc_mcu7t3v3__inv_2
Xgf180mcu_as_sc_mcu7t3v3__inv_2_1718 VSS VSS VSS gf180mcu_as_sc_mcu7t3v3__inv_2_1719/Y
+ gf180mcu_as_sc_mcu7t3v3__inv_2_1720/VNW VSUBS gf180mcu_as_sc_mcu7t3v3__inv_2
Xgf180mcu_as_sc_mcu7t3v3__inv_2_1515 VSS VSS VSS gf180mcu_as_sc_mcu7t3v3__inv_2_1516/Y
+ gf180mcu_as_sc_mcu7t3v3__inv_2_1520/VNW VSUBS gf180mcu_as_sc_mcu7t3v3__inv_2
Xgf180mcu_as_sc_mcu7t3v3__inv_2_1526 VSS VSS gf180mcu_as_sc_mcu7t3v3__inv_2_1526/Y
+ gf180mcu_as_sc_mcu7t3v3__inv_2_1526/A gf180mcu_as_sc_mcu7t3v3__inv_2_1526/VNW VSUBS
+ gf180mcu_as_sc_mcu7t3v3__inv_2
Xgf180mcu_as_sc_mcu7t3v3__inv_2_1504 VSS VSS VSS gf180mcu_as_sc_mcu7t3v3__inv_2_1505/Y
+ gf180mcu_as_sc_mcu7t3v3__inv_2_1506/VNW VSUBS gf180mcu_as_sc_mcu7t3v3__inv_2
Xgf180mcu_as_sc_mcu7t3v3__inv_2_1548 VSS VSS VSS gf180mcu_as_sc_mcu7t3v3__inv_2_1549/Y
+ gf180mcu_as_sc_mcu7t3v3__inv_2_1550/VNW VSUBS gf180mcu_as_sc_mcu7t3v3__inv_2
Xgf180mcu_as_sc_mcu7t3v3__inv_2_1559 VSS VSS gf180mcu_as_sc_mcu7t3v3__inv_2_1559/Y
+ gf180mcu_as_sc_mcu7t3v3__inv_2_1559/A gf180mcu_as_sc_mcu7t3v3__inv_2_1559/VNW VSUBS
+ gf180mcu_as_sc_mcu7t3v3__inv_2
Xgf180mcu_as_sc_mcu7t3v3__inv_2_1537 VSS VSS gf180mcu_as_sc_mcu7t3v3__inv_2_1537/Y
+ gf180mcu_as_sc_mcu7t3v3__inv_2_1538/Y gf180mcu_as_sc_mcu7t3v3__inv_2_1538/VNW VSUBS
+ gf180mcu_as_sc_mcu7t3v3__inv_2
Xgf180mcu_as_sc_mcu7t3v3__nand4_2_309 VSS VSS VSS VSS VSS VSS gf180mcu_as_sc_mcu7t3v3__inv_2_1013/A
+ gf180mcu_as_sc_mcu7t3v3__inv_2_1058/VNW VSUBS gf180mcu_as_sc_mcu7t3v3__nand4_2
Xgf180mcu_as_sc_mcu7t3v3__nand2_2_3 gf180mcu_as_sc_mcu7t3v3__nor2_2_4/VDD gf180mcu_as_sc_mcu7t3v3__nand2_2_3/VSS
+ VSS VSS VSS gf180mcu_as_sc_mcu7t3v3__nor2_2_4/VNW VSUBS gf180mcu_as_sc_mcu7t3v3__nand2_2
Xu_t029_008 u_t029_008/c0_w0_bl u_t029_008/c0_w0_br u_t029_008/c0_w1_bl u_t029_008/c0_w1_br
+ u_t029_008/c0_r0_rbl u_t029_008/c0_r1_rbl u_t029_008/c1_w0_bl u_t029_008/c1_w0_br
+ u_t029_008/c1_w1_bl u_t029_008/c1_w1_br u_t029_008/c1_r0_rbl u_t029_008/c1_r1_rbl
+ u_t029_008/c2_w0_bl u_t029_008/c2_w0_br u_t029_008/c2_w1_bl u_t029_008/c2_w1_br
+ u_t029_008/c2_r0_rbl u_t029_008/c2_r1_rbl u_t029_008/c3_w0_bl u_t029_008/c3_w0_br
+ u_t029_008/c3_w1_bl u_t029_008/c3_w1_br u_t029_008/c3_r0_rbl u_t029_008/c3_r1_rbl
+ u_t029_008/r0_w0_wl u_t029_008/r0_w1_wl u_t029_008/r0_r0_rwl u_t029_008/r0_r1_rwl
+ u_t029_008/r1_w0_wl u_t029_008/r1_w1_wl u_t029_008/r1_r0_rwl u_t029_008/r1_r1_rwl
+ u_t029_008/r2_w0_wl u_t029_008/r2_w1_wl u_t029_008/r2_r0_rwl u_t029_008/r2_r1_rwl
+ u_t029_008/r3_w0_wl u_t029_008/r3_w1_wl u_t029_008/r3_r0_rwl u_t029_008/r3_r1_rwl
+ VSS VSS u_t029_008/m2_717_1265# u_t029_008/m2_603_2031# u_t029_008/m2_1290_336#
+ u_t029_008/m2_2000_2037# u_t029_008/m2_791_2909# u_t029_008/m2_7_2126# u_t029_008/m2_2154_2081#
+ u_t029_008/m2_1795_2037# u_t029_008/m2_871_303# u_t029_008/m2_431_438# u_t029_008/m2_1290_2898#
+ u_t029_008/m2_1714_1210# u_t029_008/m2_431_1982# u_t029_008/m2_512_1265# u_t029_008/m2_2573_2126#
+ u_t029_008/m2_603_1259# u_t029_008/m2_2074_2909# u_t029_008/m2_7_336# u_t029_008/m2_717_2037#
+ u_t029_008/m2_1886_2031# u_t029_008/m2_2573_336# u_t029_008/m2_7_2898# u_t029_008/m2_2000_1265#
+ u_t029_008/m2_512_2037# u_t029_008/m2_1795_1265# u_t029_008/m2_1714_1982# u_t029_008/m2_1886_1259#
+ u_t029_008/m2_1290_2126# u_t029_008/m2_1714_438# u_t029_008/m2_431_1210# u_t029_008/m2_2573_2898#
+ u_t029_008/m2_2154_303# u_t029_008/m2_871_2081# VSUBS detronyx_12t_2w2r_rc4_4x4_routed_5layer_direct
Xgf180mcu_as_sc_mcu7t3v3__inv_2_1301 VSS VSS VSS gf180mcu_as_sc_mcu7t3v3__inv_2_1301/A
+ gf180mcu_as_sc_mcu7t3v3__inv_2_1301/VNW VSUBS gf180mcu_as_sc_mcu7t3v3__inv_2
Xgf180mcu_as_sc_mcu7t3v3__inv_2_1378 VSS VSS gf180mcu_as_sc_mcu7t3v3__inv_2_1378/Y
+ gf180mcu_as_sc_mcu7t3v3__inv_2_1378/A gf180mcu_as_sc_mcu7t3v3__inv_2_1378/VNW VSUBS
+ gf180mcu_as_sc_mcu7t3v3__inv_2
Xgf180mcu_as_sc_mcu7t3v3__inv_2_1367 VSS VSS VSS gf180mcu_as_sc_mcu7t3v3__inv_2_1371/Y
+ gf180mcu_as_sc_mcu7t3v3__inv_2_1375/VNW VSUBS gf180mcu_as_sc_mcu7t3v3__inv_2
Xgf180mcu_as_sc_mcu7t3v3__inv_2_1356 VSS VSS VSS gf180mcu_as_sc_mcu7t3v3__inv_2_1357/Y
+ gf180mcu_as_sc_mcu7t3v3__inv_2_1358/VNW VSUBS gf180mcu_as_sc_mcu7t3v3__inv_2
Xgf180mcu_as_sc_mcu7t3v3__inv_2_1323 VSS VSS gf180mcu_as_sc_mcu7t3v3__inv_2_1323/Y
+ gf180mcu_as_sc_mcu7t3v3__inv_2_1324/Y gf180mcu_as_sc_mcu7t3v3__inv_2_1324/VNW VSUBS
+ gf180mcu_as_sc_mcu7t3v3__inv_2
Xgf180mcu_as_sc_mcu7t3v3__inv_2_1345 VSS VSS gf180mcu_as_sc_mcu7t3v3__inv_2_1345/Y
+ gf180mcu_as_sc_mcu7t3v3__inv_2_1349/Y gf180mcu_as_sc_mcu7t3v3__inv_2_1349/VNW VSUBS
+ gf180mcu_as_sc_mcu7t3v3__inv_2
Xgf180mcu_as_sc_mcu7t3v3__inv_2_1312 VSS VSS gf180mcu_as_sc_mcu7t3v3__inv_2_1312/Y
+ gf180mcu_as_sc_mcu7t3v3__inv_2_1312/A gf180mcu_as_sc_mcu7t3v3__inv_2_1312/VNW VSUBS
+ gf180mcu_as_sc_mcu7t3v3__inv_2
Xgf180mcu_as_sc_mcu7t3v3__inv_2_1334 VSS VSS VSS gf180mcu_as_sc_mcu7t3v3__inv_2_1335/Y
+ gf180mcu_as_sc_mcu7t3v3__inv_2_1336/VNW VSUBS gf180mcu_as_sc_mcu7t3v3__inv_2
Xgf180mcu_as_sc_mcu7t3v3__inv_2_1389 VSS VSS gf180mcu_as_sc_mcu7t3v3__inv_2_1389/Y
+ gf180mcu_as_sc_mcu7t3v3__inv_2_1390/Y gf180mcu_as_sc_mcu7t3v3__inv_2_1390/VNW VSUBS
+ gf180mcu_as_sc_mcu7t3v3__inv_2
Xgf180mcu_as_sc_mcu7t3v3__inv_2_818 VSS VSS gf180mcu_as_sc_mcu7t3v3__inv_2_818/Y gf180mcu_as_sc_mcu7t3v3__inv_2_819/Y
+ gf180mcu_as_sc_mcu7t3v3__inv_2_819/VNW VSUBS gf180mcu_as_sc_mcu7t3v3__inv_2
Xgf180mcu_as_sc_mcu7t3v3__inv_2_807 VSS VSS gf180mcu_as_sc_mcu7t3v3__inv_2_848/A gf180mcu_as_sc_mcu7t3v3__inv_2_810/Y
+ gf180mcu_as_sc_mcu7t3v3__inv_2_848/VNW VSUBS gf180mcu_as_sc_mcu7t3v3__inv_2
Xgf180mcu_as_sc_mcu7t3v3__inv_2_829 VSS VSS VSS gf180mcu_as_sc_mcu7t3v3__inv_2_829/A
+ gf180mcu_as_sc_mcu7t3v3__inv_2_829/VNW VSUBS gf180mcu_as_sc_mcu7t3v3__inv_2
Xgf180mcu_as_sc_mcu7t3v3__nand4_2_128 VSS VSS VSS VSS VSS VSS gf180mcu_as_sc_mcu7t3v3__inv_2_482/A
+ gf180mcu_as_sc_mcu7t3v3__inv_2_547/VNW VSUBS gf180mcu_as_sc_mcu7t3v3__nand4_2
Xgf180mcu_as_sc_mcu7t3v3__nand4_2_139 VSS VSS VSS VSS VSS VSS gf180mcu_as_sc_mcu7t3v3__inv_2_502/A
+ gf180mcu_as_sc_mcu7t3v3__inv_2_536/VNW VSUBS gf180mcu_as_sc_mcu7t3v3__nand4_2
Xgf180mcu_as_sc_mcu7t3v3__nand4_2_106 VSS VSS VSS VSS VSS VSS gf180mcu_as_sc_mcu7t3v3__inv_2_371/A
+ gf180mcu_as_sc_mcu7t3v3__inv_2_371/VNW VSUBS gf180mcu_as_sc_mcu7t3v3__nand4_2
Xgf180mcu_as_sc_mcu7t3v3__nand4_2_117 VSS VSS VSS VSS VSS VSS gf180mcu_as_sc_mcu7t3v3__inv_2_300/A
+ gf180mcu_as_sc_mcu7t3v3__inv_2_303/VNW VSUBS gf180mcu_as_sc_mcu7t3v3__nand4_2
Xgf180mcu_as_sc_mcu7t3v3__nand4_2_67 VSS VSS VSS VSS VSS VSS gf180mcu_as_sc_mcu7t3v3__inv_2_24/A
+ gf180mcu_as_sc_mcu7t3v3__inv_2_24/VNW VSUBS gf180mcu_as_sc_mcu7t3v3__nand4_2
Xgf180mcu_as_sc_mcu7t3v3__nand4_2_23 VSS VSS VSS VSS VSS VSS gf180mcu_as_sc_mcu7t3v3__inv_2_149/A
+ gf180mcu_as_sc_mcu7t3v3__inv_2_149/VNW VSUBS gf180mcu_as_sc_mcu7t3v3__nand4_2
Xgf180mcu_as_sc_mcu7t3v3__nand4_2_89 VSS VSS VSS VSS VSS VSS gf180mcu_as_sc_mcu7t3v3__inv_2_38/A
+ gf180mcu_as_sc_mcu7t3v3__inv_2_38/VNW VSUBS gf180mcu_as_sc_mcu7t3v3__nand4_2
Xgf180mcu_as_sc_mcu7t3v3__nand4_2_12 VSS VSS VSS VSS VSS VSS gf180mcu_as_sc_mcu7t3v3__inv_2_116/A
+ gf180mcu_as_sc_mcu7t3v3__inv_2_116/VNW VSUBS gf180mcu_as_sc_mcu7t3v3__nand4_2
Xgf180mcu_as_sc_mcu7t3v3__nand4_2_34 VSS VSS VSS VSS VSS VSS gf180mcu_as_sc_mcu7t3v3__inv_2_163/A
+ gf180mcu_as_sc_mcu7t3v3__inv_2_163/VNW VSUBS gf180mcu_as_sc_mcu7t3v3__nand4_2
Xgf180mcu_as_sc_mcu7t3v3__nand4_2_45 VSS VSS VSS VSS VSS VSS gf180mcu_as_sc_mcu7t3v3__inv_2_215/A
+ gf180mcu_as_sc_mcu7t3v3__inv_2_215/VNW VSUBS gf180mcu_as_sc_mcu7t3v3__nand4_2
Xgf180mcu_as_sc_mcu7t3v3__nand4_2_78 VSS VSS VSS VSS VSS VSS gf180mcu_as_sc_mcu7t3v3__inv_2_338/A
+ gf180mcu_as_sc_mcu7t3v3__inv_2_338/VNW VSUBS gf180mcu_as_sc_mcu7t3v3__nand4_2
Xgf180mcu_as_sc_mcu7t3v3__nand4_2_56 VSS VSS VSS VSS VSS VSS gf180mcu_as_sc_mcu7t3v3__inv_2_248/A
+ gf180mcu_as_sc_mcu7t3v3__inv_2_248/VNW VSUBS gf180mcu_as_sc_mcu7t3v3__nand4_2
Xu_t025_000 VSS u_t025_000/c0_w0_br VSS u_t025_000/c0_w1_br u_t025_000/c0_r0_rbl u_t025_000/c0_r1_rbl
+ VSS VSS VSS VSS VSS VSS u_t025_000/c2_w0_bl u_t025_000/c2_w0_br u_t025_000/c2_w1_bl
+ u_t025_000/c2_w1_br u_t025_000/c2_r0_rbl u_t025_000/c2_r1_rbl u_t025_000/c3_w0_bl
+ u_t025_000/c3_w0_br u_t025_000/c3_w1_bl u_t025_000/c3_w1_br u_t025_000/c3_r0_rbl
+ u_t025_000/c3_r1_rbl VSS VSS VSS VSS VSS VSS VSS VSS VSS VSS VSS VSS VSS VSS VSS
+ VSS VSS VSS u_t025_000/m2_717_1265# VSS VSS VSS VSS u_t025_000/m2_7_2126# VSS VSS
+ VSS VSS VSS VSS VSS u_t025_000/m2_512_1265# u_t025_000/m2_2573_2126# VSS VSS VSS
+ VSS VSS u_t025_000/m2_2573_336# VSS u_t025_000/m2_2000_1265# VSS u_t025_000/m2_1795_1265#
+ VSS VSS u_t025_000/m2_1290_2126# VSS VSS u_t025_000/m2_2573_2898# VSS VSS VSUBS
+ detronyx_12t_2w2r_rc4_4x4_routed_5layer_direct
Xu_t025_011 u_t025_011/c0_w0_bl u_t025_011/c0_w0_br u_t025_011/c0_w1_bl u_t025_011/c0_w1_br
+ u_t025_011/c0_r0_rbl u_t025_011/c0_r1_rbl u_t025_011/c1_w0_bl u_t025_011/c1_w0_br
+ u_t025_011/c1_w1_bl u_t025_011/c1_w1_br u_t025_011/c1_r0_rbl u_t025_011/c1_r1_rbl
+ u_t025_011/c2_w0_bl u_t025_011/c2_w0_br u_t025_011/c2_w1_bl u_t025_011/c2_w1_br
+ u_t025_011/c2_r0_rbl u_t025_011/c2_r1_rbl u_t025_011/c3_w0_bl u_t025_011/c3_w0_br
+ u_t025_011/c3_w1_bl u_t025_011/c3_w1_br u_t025_011/c3_r0_rbl u_t025_011/c3_r1_rbl
+ u_t025_011/r0_w0_wl u_t025_011/r0_w1_wl u_t025_011/r0_r0_rwl u_t025_011/r0_r1_rwl
+ u_t025_011/r1_w0_wl u_t025_011/r1_w1_wl u_t025_011/r1_r0_rwl u_t025_011/r1_r1_rwl
+ u_t025_011/r2_w0_wl u_t025_011/r2_w1_wl u_t025_011/r2_r0_rwl u_t025_011/r2_r1_rwl
+ u_t025_011/r3_w0_wl u_t025_011/r3_w1_wl u_t025_011/r3_r0_rwl u_t025_011/r3_r1_rwl
+ VSS VSS u_t025_011/m2_717_1265# u_t025_011/m2_603_2031# u_t025_011/m2_1290_336#
+ u_t025_011/m2_2000_2037# u_t025_011/m2_791_2909# u_t025_011/m2_7_2126# u_t025_011/m2_2154_2081#
+ u_t025_011/m2_1795_2037# u_t025_011/m2_871_303# u_t025_011/m2_431_438# u_t025_011/m2_1290_2898#
+ u_t025_011/m2_1714_1210# u_t025_011/m2_431_1982# u_t025_011/m2_512_1265# u_t025_011/m2_2573_2126#
+ u_t025_011/m2_603_1259# u_t025_011/m2_2074_2909# u_t025_011/m2_7_336# u_t025_011/m2_717_2037#
+ u_t025_011/m2_1886_2031# u_t025_011/m2_2573_336# u_t025_011/m2_7_2898# u_t025_011/m2_2000_1265#
+ u_t025_011/m2_512_2037# u_t025_011/m2_1795_1265# u_t025_011/m2_1714_1982# u_t025_011/m2_1886_1259#
+ u_t025_011/m2_1290_2126# u_t025_011/m2_1714_438# u_t025_011/m2_431_1210# u_t025_011/m2_2573_2898#
+ u_t025_011/m2_2154_303# u_t025_011/m2_871_2081# VSUBS detronyx_12t_2w2r_rc4_4x4_routed_5layer_direct
Xgf180mcu_as_sc_mcu7t3v3__inv_2_1197 gf180mcu_as_sc_mcu7t3v3__nor2_2_9/VDD gf180mcu_as_sc_mcu7t3v3__nand3_2_63/VSS
+ gf180mcu_as_sc_mcu7t3v3__inv_2_1197/Y VSS gf180mcu_as_sc_mcu7t3v3__nor2_2_9/VNW
+ VSUBS gf180mcu_as_sc_mcu7t3v3__inv_2
Xgf180mcu_as_sc_mcu7t3v3__inv_2_1131 VSS VSS VSS gf180mcu_as_sc_mcu7t3v3__inv_2_1132/Y
+ gf180mcu_as_sc_mcu7t3v3__inv_2_1133/VNW VSUBS gf180mcu_as_sc_mcu7t3v3__inv_2
Xgf180mcu_as_sc_mcu7t3v3__inv_2_1186 VSS VSS gf180mcu_as_sc_mcu7t3v3__inv_2_1229/A
+ gf180mcu_as_sc_mcu7t3v3__inv_2_1186/A gf180mcu_as_sc_mcu7t3v3__inv_2_1278/VNW VSUBS
+ gf180mcu_as_sc_mcu7t3v3__inv_2
Xgf180mcu_as_sc_mcu7t3v3__inv_2_1142 VSS VSS gf180mcu_as_sc_mcu7t3v3__inv_2_1142/Y
+ gf180mcu_as_sc_mcu7t3v3__inv_2_1142/A gf180mcu_as_sc_mcu7t3v3__inv_2_1142/VNW VSUBS
+ gf180mcu_as_sc_mcu7t3v3__inv_2
Xgf180mcu_as_sc_mcu7t3v3__inv_2_1120 VSS VSS gf180mcu_as_sc_mcu7t3v3__inv_2_1120/Y
+ gf180mcu_as_sc_mcu7t3v3__inv_2_1121/Y gf180mcu_as_sc_mcu7t3v3__inv_2_1121/VNW VSUBS
+ gf180mcu_as_sc_mcu7t3v3__inv_2
Xgf180mcu_as_sc_mcu7t3v3__inv_2_1153 VSS VSS gf180mcu_as_sc_mcu7t3v3__inv_2_1263/A
+ gf180mcu_as_sc_mcu7t3v3__inv_2_1154/Y gf180mcu_as_sc_mcu7t3v3__inv_2_1263/VNW VSUBS
+ gf180mcu_as_sc_mcu7t3v3__inv_2
Xgf180mcu_as_sc_mcu7t3v3__inv_2_1164 VSS VSS gf180mcu_as_sc_mcu7t3v3__inv_2_1164/Y
+ gf180mcu_as_sc_mcu7t3v3__inv_2_1164/A gf180mcu_as_sc_mcu7t3v3__inv_2_1293/VNW VSUBS
+ gf180mcu_as_sc_mcu7t3v3__inv_2
Xgf180mcu_as_sc_mcu7t3v3__inv_2_1175 VSS VSS gf180mcu_as_sc_mcu7t3v3__inv_2_1301/A
+ gf180mcu_as_sc_mcu7t3v3__inv_2_1175/A gf180mcu_as_sc_mcu7t3v3__inv_2_1301/VNW VSUBS
+ gf180mcu_as_sc_mcu7t3v3__inv_2
Xu_t016_011 u_t016_011/c0_w0_bl u_t016_011/c0_w0_br u_t016_011/c0_w1_bl u_t016_011/c0_w1_br
+ u_t016_011/c0_r0_rbl u_t016_011/c0_r1_rbl u_t016_011/c1_w0_bl u_t016_011/c1_w0_br
+ u_t016_011/c1_w1_bl u_t016_011/c1_w1_br u_t016_011/c1_r0_rbl u_t016_011/c1_r1_rbl
+ u_t016_011/c2_w0_bl u_t016_011/c2_w0_br u_t016_011/c2_w1_bl u_t016_011/c2_w1_br
+ u_t016_011/c2_r0_rbl u_t016_011/c2_r1_rbl u_t016_011/c3_w0_bl u_t016_011/c3_w0_br
+ u_t016_011/c3_w1_bl u_t016_011/c3_w1_br u_t016_011/c3_r0_rbl u_t016_011/c3_r1_rbl
+ u_t016_011/r0_w0_wl u_t016_011/r0_w1_wl u_t016_011/r0_r0_rwl u_t016_011/r0_r1_rwl
+ u_t016_011/r1_w0_wl u_t016_011/r1_w1_wl u_t016_011/r1_r0_rwl u_t016_011/r1_r1_rwl
+ u_t016_011/r2_w0_wl u_t016_011/r2_w1_wl u_t016_011/r2_r0_rwl u_t016_011/r2_r1_rwl
+ u_t016_011/r3_w0_wl u_t016_011/r3_w1_wl u_t016_011/r3_r0_rwl u_t016_011/r3_r1_rwl
+ VSS VSS u_t016_011/m2_717_1265# u_t016_011/m2_603_2031# u_t016_011/m2_1290_336#
+ u_t016_011/m2_2000_2037# u_t016_011/m2_791_2909# u_t016_011/m2_7_2126# u_t016_011/m2_2154_2081#
+ u_t016_011/m2_1795_2037# u_t016_011/m2_871_303# u_t016_011/m2_431_438# u_t016_011/m2_1290_2898#
+ u_t016_011/m2_1714_1210# u_t016_011/m2_431_1982# u_t016_011/m2_512_1265# u_t016_011/m2_2573_2126#
+ u_t016_011/m2_603_1259# u_t016_011/m2_2074_2909# u_t016_011/m2_7_336# u_t016_011/m2_717_2037#
+ u_t016_011/m2_1886_2031# u_t016_011/m2_2573_336# u_t016_011/m2_7_2898# u_t016_011/m2_2000_1265#
+ u_t016_011/m2_512_2037# u_t016_011/m2_1795_1265# u_t016_011/m2_1714_1982# u_t016_011/m2_1886_1259#
+ u_t016_011/m2_1290_2126# u_t016_011/m2_1714_438# u_t016_011/m2_431_1210# u_t016_011/m2_2573_2898#
+ u_t016_011/m2_2154_303# u_t016_011/m2_871_2081# VSUBS detronyx_12t_2w2r_rc4_4x4_routed_5layer_direct
Xgf180mcu_as_sc_mcu7t3v3__inv_2_637 VSS VSS gf180mcu_as_sc_mcu7t3v3__inv_2_637/Y gf180mcu_as_sc_mcu7t3v3__inv_2_637/A
+ gf180mcu_as_sc_mcu7t3v3__inv_2_637/VNW VSUBS gf180mcu_as_sc_mcu7t3v3__inv_2
Xgf180mcu_as_sc_mcu7t3v3__inv_2_604 VSS VSS VSS gf180mcu_as_sc_mcu7t3v3__inv_2_605/Y
+ gf180mcu_as_sc_mcu7t3v3__inv_2_606/VNW VSUBS gf180mcu_as_sc_mcu7t3v3__inv_2
Xgf180mcu_as_sc_mcu7t3v3__inv_2_626 VSS VSS VSS gf180mcu_as_sc_mcu7t3v3__inv_2_627/Y
+ gf180mcu_as_sc_mcu7t3v3__inv_2_628/VNW VSUBS gf180mcu_as_sc_mcu7t3v3__inv_2
Xgf180mcu_as_sc_mcu7t3v3__inv_2_615 VSS VSS gf180mcu_as_sc_mcu7t3v3__inv_2_615/Y gf180mcu_as_sc_mcu7t3v3__inv_2_616/Y
+ gf180mcu_as_sc_mcu7t3v3__inv_2_616/VNW VSUBS gf180mcu_as_sc_mcu7t3v3__inv_2
Xgf180mcu_as_sc_mcu7t3v3__inv_2_659 VSS VSS gf180mcu_as_sc_mcu7t3v3__inv_2_659/Y gf180mcu_as_sc_mcu7t3v3__inv_2_660/Y
+ gf180mcu_as_sc_mcu7t3v3__inv_2_660/VNW VSUBS gf180mcu_as_sc_mcu7t3v3__inv_2
Xgf180mcu_as_sc_mcu7t3v3__inv_2_648 VSS VSS VSS gf180mcu_as_sc_mcu7t3v3__inv_2_649/Y
+ gf180mcu_as_sc_mcu7t3v3__inv_2_650/VNW VSUBS gf180mcu_as_sc_mcu7t3v3__inv_2
Xu_t016_000 VSS u_t016_000/c0_w0_br VSS u_t016_000/c0_w1_br u_t016_000/c0_r0_rbl u_t016_000/c0_r1_rbl
+ VSS VSS VSS VSS VSS VSS u_t016_000/c2_w0_bl u_t016_000/c2_w0_br u_t016_000/c2_w1_bl
+ u_t016_000/c2_w1_br u_t016_000/c2_r0_rbl u_t016_000/c2_r1_rbl u_t016_000/c3_w0_bl
+ u_t016_000/c3_w0_br u_t016_000/c3_w1_bl u_t016_000/c3_w1_br u_t016_000/c3_r0_rbl
+ u_t016_000/c3_r1_rbl VSS VSS VSS VSS VSS VSS VSS VSS VSS VSS VSS VSS VSS VSS VSS
+ VSS VSS VSS VSS VSS VSS VSS VSS VSS VSS VSS VSS VSS u_t016_000/m2_1290_2898# VSS
+ VSS VSS u_t016_000/m2_2573_2126# VSS VSS VSS VSS VSS u_t016_000/m2_2573_336# u_t016_000/m2_7_2898#
+ VSS VSS VSS u_t016_000/m2_1714_1982# VSS VSS u_t016_000/m2_1714_438# VSS u_t016_000/m2_2573_2898#
+ VSS VSS VSUBS detronyx_12t_2w2r_rc4_4x4_routed_5layer_direct
Xu_t031_014 u_t031_014/c0_w0_bl u_t031_014/c0_w0_br u_t031_014/c0_w1_bl u_t031_014/c0_w1_br
+ u_t031_014/c0_r0_rbl u_t031_014/c0_r1_rbl u_t031_014/c1_w0_bl u_t031_014/c1_w0_br
+ u_t031_014/c1_w1_bl u_t031_014/c1_w1_br u_t031_014/c1_r0_rbl u_t031_014/c1_r1_rbl
+ u_t031_014/c2_w0_bl u_t031_014/c2_w0_br u_t031_014/c2_w1_bl u_t031_014/c2_w1_br
+ u_t031_014/c2_r0_rbl u_t031_014/c2_r1_rbl u_t031_014/c3_w0_bl u_t031_014/c3_w0_br
+ u_t031_014/c3_w1_bl u_t031_014/c3_w1_br u_t031_014/c3_r0_rbl u_t031_014/c3_r1_rbl
+ u_t031_014/r0_w0_wl u_t031_014/r0_w1_wl u_t031_014/r0_r0_rwl u_t031_014/r0_r1_rwl
+ u_t031_014/r1_w0_wl u_t031_014/r1_w1_wl u_t031_014/r1_r0_rwl u_t031_014/r1_r1_rwl
+ u_t031_014/r2_w0_wl u_t031_014/r2_w1_wl u_t031_014/r2_r0_rwl u_t031_014/r2_r1_rwl
+ u_t031_014/r3_w0_wl u_t031_014/r3_w1_wl u_t031_014/r3_r0_rwl u_t031_014/r3_r1_rwl
+ VSS VSS u_t031_014/m2_717_1265# u_t031_014/m2_603_2031# u_t031_014/m2_1290_336#
+ u_t031_014/m2_2000_2037# u_t031_014/m2_791_2909# u_t031_014/m2_7_2126# u_t031_014/m2_2154_2081#
+ u_t031_014/m2_1795_2037# u_t031_014/m2_871_303# u_t031_014/m2_431_438# u_t031_014/m2_1290_2898#
+ u_t031_014/m2_1714_1210# u_t031_014/m2_431_1982# u_t031_014/m2_512_1265# u_t031_014/m2_2573_2126#
+ u_t031_014/m2_603_1259# u_t031_014/m2_2074_2909# u_t031_014/m2_7_336# u_t031_014/m2_717_2037#
+ u_t031_014/m2_1886_2031# u_t031_014/m2_2573_336# u_t031_014/m2_7_2898# u_t031_014/m2_2000_1265#
+ u_t031_014/m2_512_2037# u_t031_014/m2_1795_1265# u_t031_014/m2_1714_1982# u_t031_014/m2_1886_1259#
+ u_t031_014/m2_1290_2126# u_t031_014/m2_1714_438# u_t031_014/m2_431_1210# u_t031_014/m2_2573_2898#
+ u_t031_014/m2_2154_303# u_t031_014/m2_871_2081# VSUBS detronyx_12t_2w2r_rc4_4x4_routed_5layer_direct
Xu_t031_003 u_t031_003/c0_w0_bl u_t031_003/c0_w0_br u_t031_003/c0_w1_bl u_t031_003/c0_w1_br
+ u_t031_003/c0_r0_rbl u_t031_003/c0_r1_rbl u_t031_003/c1_w0_bl u_t031_003/c1_w0_br
+ u_t031_003/c1_w1_bl u_t031_003/c1_w1_br u_t031_003/c1_r0_rbl u_t031_003/c1_r1_rbl
+ u_t031_003/c2_w0_bl u_t031_003/c2_w0_br u_t031_003/c2_w1_bl u_t031_003/c2_w1_br
+ u_t031_003/c2_r0_rbl u_t031_003/c2_r1_rbl u_t031_003/c3_w0_bl u_t031_003/c3_w0_br
+ u_t031_003/c3_w1_bl u_t031_003/c3_w1_br u_t031_003/c3_r0_rbl u_t031_003/c3_r1_rbl
+ u_t031_003/r0_w0_wl u_t031_003/r0_w1_wl u_t031_003/r0_r0_rwl u_t031_003/r0_r1_rwl
+ u_t031_003/r1_w0_wl u_t031_003/r1_w1_wl u_t031_003/r1_r0_rwl u_t031_003/r1_r1_rwl
+ u_t031_003/r2_w0_wl u_t031_003/r2_w1_wl u_t031_003/r2_r0_rwl u_t031_003/r2_r1_rwl
+ u_t031_003/r3_w0_wl u_t031_003/r3_w1_wl u_t031_003/r3_r0_rwl u_t031_003/r3_r1_rwl
+ VSS VSS u_t031_003/m2_717_1265# u_t031_003/m2_603_2031# u_t031_003/m2_1290_336#
+ u_t031_003/m2_2000_2037# u_t031_003/m2_791_2909# u_t031_003/m2_7_2126# u_t031_003/m2_2154_2081#
+ u_t031_003/m2_1795_2037# u_t031_003/m2_871_303# u_t031_003/m2_431_438# u_t031_003/m2_1290_2898#
+ u_t031_003/m2_1714_1210# u_t031_003/m2_431_1982# u_t031_003/m2_512_1265# u_t031_003/m2_2573_2126#
+ u_t031_003/m2_603_1259# u_t031_003/m2_2074_2909# u_t031_003/m2_7_336# u_t031_003/m2_717_2037#
+ u_t031_003/m2_1886_2031# u_t031_003/m2_2573_336# u_t031_003/m2_7_2898# u_t031_003/m2_2000_1265#
+ u_t031_003/m2_512_2037# u_t031_003/m2_1795_1265# u_t031_003/m2_1714_1982# u_t031_003/m2_1886_1259#
+ u_t031_003/m2_1290_2126# u_t031_003/m2_1714_438# u_t031_003/m2_431_1210# u_t031_003/m2_2573_2898#
+ u_t031_003/m2_2154_303# u_t031_003/m2_871_2081# VSUBS detronyx_12t_2w2r_rc4_4x4_routed_5layer_direct
Xu_t007_000 VSS u_t007_000/c0_w0_br VSS u_t007_000/c0_w1_br u_t007_000/c0_r0_rbl u_t007_000/c0_r1_rbl
+ VSS VSS VSS VSS VSS VSS u_t007_000/c2_w0_bl u_t007_000/c2_w0_br u_t007_000/c2_w1_bl
+ u_t007_000/c2_w1_br u_t007_000/c2_r0_rbl u_t007_000/c2_r1_rbl u_t007_000/c3_w0_bl
+ u_t007_000/c3_w0_br u_t007_000/c3_w1_bl u_t007_000/c3_w1_br u_t007_000/c3_r0_rbl
+ u_t007_000/c3_r1_rbl VSS VSS VSS VSS VSS VSS VSS VSS VSS VSS VSS VSS VSS VSS VSS
+ VSS VSS VSS u_t007_000/m2_717_1265# u_t007_000/m2_603_2031# u_t007_000/m2_1290_336#
+ u_t007_000/m2_2000_2037# u_t007_000/m2_791_2909# u_t007_000/m2_7_2126# u_t007_000/m2_2154_2081#
+ u_t007_000/m2_1795_2037# u_t007_000/m2_871_303# u_t007_000/m2_431_438# u_t007_000/m2_1290_2898#
+ u_t007_000/m2_1714_1210# u_t007_000/m2_431_1982# u_t007_000/m2_512_1265# u_t007_000/m2_2573_2126#
+ u_t007_000/m2_603_1259# u_t007_000/m2_2074_2909# u_t007_000/m2_7_336# u_t007_000/m2_717_2037#
+ u_t007_000/m2_1886_2031# u_t007_000/m2_2573_336# u_t007_000/m2_7_2898# u_t007_000/m2_2000_1265#
+ u_t007_000/m2_512_2037# u_t007_000/m2_1795_1265# u_t007_000/m2_1714_1982# u_t007_000/m2_1886_1259#
+ u_t007_000/m2_1290_2126# u_t007_000/m2_1714_438# u_t007_000/m2_431_1210# u_t007_000/m2_2573_2898#
+ u_t007_000/m2_2154_303# u_t007_000/m2_871_2081# VSUBS detronyx_12t_2w2r_rc4_4x4_routed_5layer_direct
Xu_t022_014 u_t022_014/c0_w0_bl u_t022_014/c0_w0_br u_t022_014/c0_w1_bl u_t022_014/c0_w1_br
+ u_t022_014/c0_r0_rbl u_t022_014/c0_r1_rbl u_t022_014/c1_w0_bl u_t022_014/c1_w0_br
+ u_t022_014/c1_w1_bl u_t022_014/c1_w1_br u_t022_014/c1_r0_rbl u_t022_014/c1_r1_rbl
+ u_t022_014/c2_w0_bl u_t022_014/c2_w0_br u_t022_014/c2_w1_bl u_t022_014/c2_w1_br
+ u_t022_014/c2_r0_rbl u_t022_014/c2_r1_rbl u_t022_014/c3_w0_bl u_t022_014/c3_w0_br
+ u_t022_014/c3_w1_bl u_t022_014/c3_w1_br u_t022_014/c3_r0_rbl u_t022_014/c3_r1_rbl
+ u_t022_014/r0_w0_wl u_t022_014/r0_w1_wl u_t022_014/r0_r0_rwl u_t022_014/r0_r1_rwl
+ u_t022_014/r1_w0_wl u_t022_014/r1_w1_wl u_t022_014/r1_r0_rwl u_t022_014/r1_r1_rwl
+ u_t022_014/r2_w0_wl u_t022_014/r2_w1_wl u_t022_014/r2_r0_rwl u_t022_014/r2_r1_rwl
+ u_t022_014/r3_w0_wl u_t022_014/r3_w1_wl u_t022_014/r3_r0_rwl u_t022_014/r3_r1_rwl
+ VSS VSS u_t022_014/m2_717_1265# u_t022_014/m2_603_2031# u_t022_014/m2_1290_336#
+ u_t022_014/m2_2000_2037# u_t022_014/m2_791_2909# u_t022_014/m2_7_2126# u_t022_014/m2_2154_2081#
+ u_t022_014/m2_1795_2037# u_t022_014/m2_871_303# u_t022_014/m2_431_438# u_t022_014/m2_1290_2898#
+ u_t022_014/m2_1714_1210# u_t022_014/m2_431_1982# u_t022_014/m2_512_1265# u_t022_014/m2_2573_2126#
+ u_t022_014/m2_603_1259# u_t022_014/m2_2074_2909# u_t022_014/m2_7_336# u_t022_014/m2_717_2037#
+ u_t022_014/m2_1886_2031# u_t022_014/m2_2573_336# u_t022_014/m2_7_2898# u_t022_014/m2_2000_1265#
+ u_t022_014/m2_512_2037# u_t022_014/m2_1795_1265# u_t022_014/m2_1714_1982# u_t022_014/m2_1886_1259#
+ u_t022_014/m2_1290_2126# u_t022_014/m2_1714_438# u_t022_014/m2_431_1210# u_t022_014/m2_2573_2898#
+ u_t022_014/m2_2154_303# u_t022_014/m2_871_2081# VSUBS detronyx_12t_2w2r_rc4_4x4_routed_5layer_direct
Xu_t007_011 u_t007_011/c0_w0_bl u_t007_011/c0_w0_br u_t007_011/c0_w1_bl u_t007_011/c0_w1_br
+ u_t007_011/c0_r0_rbl u_t007_011/c0_r1_rbl u_t007_011/c1_w0_bl u_t007_011/c1_w0_br
+ u_t007_011/c1_w1_bl u_t007_011/c1_w1_br u_t007_011/c1_r0_rbl u_t007_011/c1_r1_rbl
+ u_t007_011/c2_w0_bl u_t007_011/c2_w0_br u_t007_011/c2_w1_bl u_t007_011/c2_w1_br
+ u_t007_011/c2_r0_rbl u_t007_011/c2_r1_rbl u_t007_011/c3_w0_bl u_t007_011/c3_w0_br
+ u_t007_011/c3_w1_bl u_t007_011/c3_w1_br u_t007_011/c3_r0_rbl u_t007_011/c3_r1_rbl
+ u_t007_011/r0_w0_wl u_t007_011/r0_w1_wl u_t007_011/r0_r0_rwl u_t007_011/r0_r1_rwl
+ u_t007_011/r1_w0_wl u_t007_011/r1_w1_wl u_t007_011/r1_r0_rwl u_t007_011/r1_r1_rwl
+ u_t007_011/r2_w0_wl u_t007_011/r2_w1_wl u_t007_011/r2_r0_rwl u_t007_011/r2_r1_rwl
+ u_t007_011/r3_w0_wl u_t007_011/r3_w1_wl u_t007_011/r3_r0_rwl u_t007_011/r3_r1_rwl
+ VSS VSS u_t007_011/m2_717_1265# u_t007_011/m2_603_2031# u_t007_011/m2_1290_336#
+ u_t007_011/m2_2000_2037# u_t007_011/m2_791_2909# u_t007_011/m2_7_2126# u_t007_011/m2_2154_2081#
+ u_t007_011/m2_1795_2037# u_t007_011/m2_871_303# u_t007_011/m2_431_438# u_t007_011/m2_1290_2898#
+ u_t007_011/m2_1714_1210# u_t007_011/m2_431_1982# u_t007_011/m2_512_1265# u_t007_011/m2_2573_2126#
+ u_t007_011/m2_603_1259# u_t007_011/m2_2074_2909# u_t007_011/m2_7_336# u_t007_011/m2_717_2037#
+ u_t007_011/m2_1886_2031# u_t007_011/m2_2573_336# u_t007_011/m2_7_2898# u_t007_011/m2_2000_1265#
+ u_t007_011/m2_512_2037# u_t007_011/m2_1795_1265# u_t007_011/m2_1714_1982# u_t007_011/m2_1886_1259#
+ u_t007_011/m2_1290_2126# u_t007_011/m2_1714_438# u_t007_011/m2_431_1210# u_t007_011/m2_2573_2898#
+ u_t007_011/m2_2154_303# u_t007_011/m2_871_2081# VSUBS detronyx_12t_2w2r_rc4_4x4_routed_5layer_direct
Xu_t022_003 u_t022_003/c0_w0_bl u_t022_003/c0_w0_br u_t022_003/c0_w1_bl u_t022_003/c0_w1_br
+ u_t022_003/c0_r0_rbl u_t022_003/c0_r1_rbl u_t022_003/c1_w0_bl u_t022_003/c1_w0_br
+ u_t022_003/c1_w1_bl u_t022_003/c1_w1_br u_t022_003/c1_r0_rbl u_t022_003/c1_r1_rbl
+ u_t022_003/c2_w0_bl u_t022_003/c2_w0_br u_t022_003/c2_w1_bl u_t022_003/c2_w1_br
+ u_t022_003/c2_r0_rbl u_t022_003/c2_r1_rbl u_t022_003/c3_w0_bl u_t022_003/c3_w0_br
+ u_t022_003/c3_w1_bl u_t022_003/c3_w1_br u_t022_003/c3_r0_rbl u_t022_003/c3_r1_rbl
+ u_t022_003/r0_w0_wl u_t022_003/r0_w1_wl u_t022_003/r0_r0_rwl u_t022_003/r0_r1_rwl
+ u_t022_003/r1_w0_wl u_t022_003/r1_w1_wl u_t022_003/r1_r0_rwl u_t022_003/r1_r1_rwl
+ u_t022_003/r2_w0_wl u_t022_003/r2_w1_wl u_t022_003/r2_r0_rwl u_t022_003/r2_r1_rwl
+ u_t022_003/r3_w0_wl u_t022_003/r3_w1_wl u_t022_003/r3_r0_rwl u_t022_003/r3_r1_rwl
+ VSS VSS u_t022_003/m2_717_1265# u_t022_003/m2_603_2031# u_t022_003/m2_1290_336#
+ u_t022_003/m2_2000_2037# u_t022_003/m2_791_2909# u_t022_003/m2_7_2126# u_t022_003/m2_2154_2081#
+ u_t022_003/m2_1795_2037# u_t022_003/m2_871_303# u_t022_003/m2_431_438# u_t022_003/m2_1290_2898#
+ u_t022_003/m2_1714_1210# u_t022_003/m2_431_1982# u_t022_003/m2_512_1265# u_t022_003/m2_2573_2126#
+ u_t022_003/m2_603_1259# u_t022_003/m2_2074_2909# u_t022_003/m2_7_336# u_t022_003/m2_717_2037#
+ u_t022_003/m2_1886_2031# u_t022_003/m2_2573_336# u_t022_003/m2_7_2898# u_t022_003/m2_2000_1265#
+ u_t022_003/m2_512_2037# u_t022_003/m2_1795_1265# u_t022_003/m2_1714_1982# u_t022_003/m2_1886_1259#
+ u_t022_003/m2_1290_2126# u_t022_003/m2_1714_438# u_t022_003/m2_431_1210# u_t022_003/m2_2573_2898#
+ u_t022_003/m2_2154_303# u_t022_003/m2_871_2081# VSUBS detronyx_12t_2w2r_rc4_4x4_routed_5layer_direct
Xgf180mcu_as_sc_mcu7t3v3__nand4_2_481 VSS VSS VSS VSS VSS VSS gf180mcu_as_sc_mcu7t3v3__inv_2_1648/A
+ gf180mcu_as_sc_mcu7t3v3__inv_2_1648/VNW VSUBS gf180mcu_as_sc_mcu7t3v3__nand4_2
Xgf180mcu_as_sc_mcu7t3v3__nand4_2_492 VSS VSS VSS VSS VSS VSS gf180mcu_as_sc_mcu7t3v3__inv_2_1603/A
+ gf180mcu_as_sc_mcu7t3v3__inv_2_1691/VNW VSUBS gf180mcu_as_sc_mcu7t3v3__nand4_2
Xgf180mcu_as_sc_mcu7t3v3__nand4_2_470 VSS VSS VSS VSS VSS VSS gf180mcu_as_sc_mcu7t3v3__inv_2_1386/A
+ gf180mcu_as_sc_mcu7t3v3__inv_2_1386/VNW VSUBS gf180mcu_as_sc_mcu7t3v3__nand4_2
Xu_t013_014 u_t013_014/c0_w0_bl u_t013_014/c0_w0_br u_t013_014/c0_w1_bl u_t013_014/c0_w1_br
+ u_t013_014/c0_r0_rbl u_t013_014/c0_r1_rbl u_t013_014/c1_w0_bl u_t013_014/c1_w0_br
+ u_t013_014/c1_w1_bl u_t013_014/c1_w1_br u_t013_014/c1_r0_rbl u_t013_014/c1_r1_rbl
+ u_t013_014/c2_w0_bl u_t013_014/c2_w0_br u_t013_014/c2_w1_bl u_t013_014/c2_w1_br
+ u_t013_014/c2_r0_rbl u_t013_014/c2_r1_rbl u_t013_014/c3_w0_bl u_t013_014/c3_w0_br
+ u_t013_014/c3_w1_bl u_t013_014/c3_w1_br u_t013_014/c3_r0_rbl u_t013_014/c3_r1_rbl
+ u_t013_014/r0_w0_wl u_t013_014/r0_w1_wl u_t013_014/r0_r0_rwl u_t013_014/r0_r1_rwl
+ u_t013_014/r1_w0_wl u_t013_014/r1_w1_wl u_t013_014/r1_r0_rwl u_t013_014/r1_r1_rwl
+ u_t013_014/r2_w0_wl u_t013_014/r2_w1_wl u_t013_014/r2_r0_rwl u_t013_014/r2_r1_rwl
+ u_t013_014/r3_w0_wl u_t013_014/r3_w1_wl u_t013_014/r3_r0_rwl u_t013_014/r3_r1_rwl
+ VSS VSS u_t013_014/m2_717_1265# u_t013_014/m2_603_2031# u_t013_014/m2_1290_336#
+ u_t013_014/m2_2000_2037# u_t013_014/m2_791_2909# u_t013_014/m2_7_2126# u_t013_014/m2_2154_2081#
+ u_t013_014/m2_1795_2037# u_t013_014/m2_871_303# u_t013_014/m2_431_438# u_t013_014/m2_1290_2898#
+ u_t013_014/m2_1714_1210# u_t013_014/m2_431_1982# u_t013_014/m2_512_1265# u_t013_014/m2_2573_2126#
+ u_t013_014/m2_603_1259# u_t013_014/m2_2074_2909# u_t013_014/m2_7_336# u_t013_014/m2_717_2037#
+ u_t013_014/m2_1886_2031# u_t013_014/m2_2573_336# u_t013_014/m2_7_2898# u_t013_014/m2_2000_1265#
+ u_t013_014/m2_512_2037# u_t013_014/m2_1795_1265# u_t013_014/m2_1714_1982# u_t013_014/m2_1886_1259#
+ u_t013_014/m2_1290_2126# u_t013_014/m2_1714_438# u_t013_014/m2_431_1210# u_t013_014/m2_2573_2898#
+ u_t013_014/m2_2154_303# u_t013_014/m2_871_2081# VSUBS detronyx_12t_2w2r_rc4_4x4_routed_5layer_direct
Xu_t013_003 u_t013_003/c0_w0_bl u_t013_003/c0_w0_br u_t013_003/c0_w1_bl u_t013_003/c0_w1_br
+ u_t013_003/c0_r0_rbl u_t013_003/c0_r1_rbl u_t013_003/c1_w0_bl u_t013_003/c1_w0_br
+ u_t013_003/c1_w1_bl u_t013_003/c1_w1_br u_t013_003/c1_r0_rbl u_t013_003/c1_r1_rbl
+ u_t013_003/c2_w0_bl u_t013_003/c2_w0_br u_t013_003/c2_w1_bl u_t013_003/c2_w1_br
+ u_t013_003/c2_r0_rbl u_t013_003/c2_r1_rbl u_t013_003/c3_w0_bl u_t013_003/c3_w0_br
+ u_t013_003/c3_w1_bl u_t013_003/c3_w1_br u_t013_003/c3_r0_rbl u_t013_003/c3_r1_rbl
+ u_t013_003/r0_w0_wl u_t013_003/r0_w1_wl u_t013_003/r0_r0_rwl u_t013_003/r0_r1_rwl
+ u_t013_003/r1_w0_wl u_t013_003/r1_w1_wl u_t013_003/r1_r0_rwl u_t013_003/r1_r1_rwl
+ u_t013_003/r2_w0_wl u_t013_003/r2_w1_wl u_t013_003/r2_r0_rwl u_t013_003/r2_r1_rwl
+ u_t013_003/r3_w0_wl u_t013_003/r3_w1_wl u_t013_003/r3_r0_rwl u_t013_003/r3_r1_rwl
+ VSS VSS u_t013_003/m2_717_1265# u_t013_003/m2_603_2031# u_t013_003/m2_1290_336#
+ u_t013_003/m2_2000_2037# u_t013_003/m2_791_2909# u_t013_003/m2_7_2126# u_t013_003/m2_2154_2081#
+ u_t013_003/m2_1795_2037# u_t013_003/m2_871_303# u_t013_003/m2_431_438# u_t013_003/m2_1290_2898#
+ u_t013_003/m2_1714_1210# u_t013_003/m2_431_1982# u_t013_003/m2_512_1265# u_t013_003/m2_2573_2126#
+ u_t013_003/m2_603_1259# u_t013_003/m2_2074_2909# u_t013_003/m2_7_336# u_t013_003/m2_717_2037#
+ u_t013_003/m2_1886_2031# u_t013_003/m2_2573_336# u_t013_003/m2_7_2898# u_t013_003/m2_2000_1265#
+ u_t013_003/m2_512_2037# u_t013_003/m2_1795_1265# u_t013_003/m2_1714_1982# u_t013_003/m2_1886_1259#
+ u_t013_003/m2_1290_2126# u_t013_003/m2_1714_438# u_t013_003/m2_431_1210# u_t013_003/m2_2573_2898#
+ u_t013_003/m2_2154_303# u_t013_003/m2_871_2081# VSUBS detronyx_12t_2w2r_rc4_4x4_routed_5layer_direct
Xu_t004_014 u_t004_014/c0_w0_bl u_t004_014/c0_w0_br u_t004_014/c0_w1_bl u_t004_014/c0_w1_br
+ u_t004_014/c0_r0_rbl u_t004_014/c0_r1_rbl u_t004_014/c1_w0_bl u_t004_014/c1_w0_br
+ u_t004_014/c1_w1_bl u_t004_014/c1_w1_br u_t004_014/c1_r0_rbl u_t004_014/c1_r1_rbl
+ u_t004_014/c2_w0_bl u_t004_014/c2_w0_br u_t004_014/c2_w1_bl u_t004_014/c2_w1_br
+ u_t004_014/c2_r0_rbl u_t004_014/c2_r1_rbl u_t004_014/c3_w0_bl u_t004_014/c3_w0_br
+ u_t004_014/c3_w1_bl u_t004_014/c3_w1_br u_t004_014/c3_r0_rbl u_t004_014/c3_r1_rbl
+ u_t004_014/r0_w0_wl u_t004_014/r0_w1_wl u_t004_014/r0_r0_rwl u_t004_014/r0_r1_rwl
+ u_t004_014/r1_w0_wl u_t004_014/r1_w1_wl u_t004_014/r1_r0_rwl u_t004_014/r1_r1_rwl
+ u_t004_014/r2_w0_wl u_t004_014/r2_w1_wl u_t004_014/r2_r0_rwl u_t004_014/r2_r1_rwl
+ u_t004_014/r3_w0_wl u_t004_014/r3_w1_wl u_t004_014/r3_r0_rwl u_t004_014/r3_r1_rwl
+ VSS VSS u_t004_014/m2_717_1265# u_t004_014/m2_603_2031# u_t004_014/m2_1290_336#
+ u_t004_014/m2_2000_2037# u_t004_014/m2_791_2909# u_t004_014/m2_7_2126# u_t004_014/m2_2154_2081#
+ u_t004_014/m2_1795_2037# u_t004_014/m2_871_303# u_t004_014/m2_431_438# u_t004_014/m2_1290_2898#
+ u_t004_014/m2_1714_1210# u_t004_014/m2_431_1982# u_t004_014/m2_512_1265# u_t004_014/m2_2573_2126#
+ u_t004_014/m2_603_1259# u_t004_014/m2_2074_2909# u_t004_014/m2_7_336# u_t004_014/m2_717_2037#
+ u_t004_014/m2_1886_2031# u_t004_014/m2_2573_336# u_t004_014/m2_7_2898# u_t004_014/m2_2000_1265#
+ u_t004_014/m2_512_2037# u_t004_014/m2_1795_1265# u_t004_014/m2_1714_1982# u_t004_014/m2_1886_1259#
+ u_t004_014/m2_1290_2126# u_t004_014/m2_1714_438# u_t004_014/m2_431_1210# u_t004_014/m2_2573_2898#
+ u_t004_014/m2_2154_303# u_t004_014/m2_871_2081# VSUBS detronyx_12t_2w2r_rc4_4x4_routed_5layer_direct
Xu_t004_003 u_t004_003/c0_w0_bl u_t004_003/c0_w0_br u_t004_003/c0_w1_bl u_t004_003/c0_w1_br
+ u_t004_003/c0_r0_rbl u_t004_003/c0_r1_rbl u_t004_003/c1_w0_bl u_t004_003/c1_w0_br
+ u_t004_003/c1_w1_bl u_t004_003/c1_w1_br u_t004_003/c1_r0_rbl u_t004_003/c1_r1_rbl
+ u_t004_003/c2_w0_bl u_t004_003/c2_w0_br u_t004_003/c2_w1_bl u_t004_003/c2_w1_br
+ u_t004_003/c2_r0_rbl u_t004_003/c2_r1_rbl u_t004_003/c3_w0_bl u_t004_003/c3_w0_br
+ u_t004_003/c3_w1_bl u_t004_003/c3_w1_br u_t004_003/c3_r0_rbl u_t004_003/c3_r1_rbl
+ u_t004_003/r0_w0_wl u_t004_003/r0_w1_wl u_t004_003/r0_r0_rwl u_t004_003/r0_r1_rwl
+ u_t004_003/r1_w0_wl u_t004_003/r1_w1_wl u_t004_003/r1_r0_rwl u_t004_003/r1_r1_rwl
+ u_t004_003/r2_w0_wl u_t004_003/r2_w1_wl u_t004_003/r2_r0_rwl u_t004_003/r2_r1_rwl
+ u_t004_003/r3_w0_wl u_t004_003/r3_w1_wl u_t004_003/r3_r0_rwl u_t004_003/r3_r1_rwl
+ VSS VSS u_t004_003/m2_717_1265# u_t004_003/m2_603_2031# u_t004_003/m2_1290_336#
+ u_t004_003/m2_2000_2037# u_t004_003/m2_791_2909# u_t004_003/m2_7_2126# u_t004_003/m2_2154_2081#
+ u_t004_003/m2_1795_2037# u_t004_003/m2_871_303# u_t004_003/m2_431_438# u_t004_003/m2_1290_2898#
+ u_t004_003/m2_1714_1210# u_t004_003/m2_431_1982# u_t004_003/m2_512_1265# u_t004_003/m2_2573_2126#
+ u_t004_003/m2_603_1259# u_t004_003/m2_2074_2909# u_t004_003/m2_7_336# u_t004_003/m2_717_2037#
+ u_t004_003/m2_1886_2031# u_t004_003/m2_2573_336# u_t004_003/m2_7_2898# u_t004_003/m2_2000_1265#
+ u_t004_003/m2_512_2037# u_t004_003/m2_1795_1265# u_t004_003/m2_1714_1982# u_t004_003/m2_1886_1259#
+ u_t004_003/m2_1290_2126# u_t004_003/m2_1714_438# u_t004_003/m2_431_1210# u_t004_003/m2_2573_2898#
+ u_t004_003/m2_2154_303# u_t004_003/m2_871_2081# VSUBS detronyx_12t_2w2r_rc4_4x4_routed_5layer_direct
Xgf180mcu_as_sc_mcu7t3v3__inv_2_445 VSS VSS gf180mcu_as_sc_mcu7t3v3__inv_2_544/A gf180mcu_as_sc_mcu7t3v3__inv_2_459/Y
+ gf180mcu_as_sc_mcu7t3v3__inv_2_544/VNW VSUBS gf180mcu_as_sc_mcu7t3v3__inv_2
Xgf180mcu_as_sc_mcu7t3v3__inv_2_401 gf180mcu_as_sc_mcu7t3v3__nor2_2_6/VDD gf180mcu_as_sc_mcu7t3v3__nor2_2_6/VSS
+ VSS VSS gf180mcu_as_sc_mcu7t3v3__nor2_2_6/VNW VSUBS gf180mcu_as_sc_mcu7t3v3__inv_2
Xgf180mcu_as_sc_mcu7t3v3__inv_2_412 gf180mcu_as_sc_mcu7t3v3__nor2_2_6/VDD gf180mcu_as_sc_mcu7t3v3__nand3_2_4/VSS
+ VSS VSS gf180mcu_as_sc_mcu7t3v3__nor2_2_6/VNW VSUBS gf180mcu_as_sc_mcu7t3v3__inv_2
Xgf180mcu_as_sc_mcu7t3v3__inv_2_456 gf180mcu_as_sc_mcu7t3v3__nor2_2_6/VDD gf180mcu_as_sc_mcu7t3v3__nand3_2_4/VSS
+ VSS VSS gf180mcu_as_sc_mcu7t3v3__nor2_2_6/VNW VSUBS gf180mcu_as_sc_mcu7t3v3__inv_2
Xgf180mcu_as_sc_mcu7t3v3__inv_2_478 gf180mcu_as_sc_mcu7t3v3__nor2_2_4/VDD gf180mcu_as_sc_mcu7t3v3__nand2_2_3/VSS
+ gf180mcu_as_sc_mcu7t3v3__inv_2_478/Y VSS gf180mcu_as_sc_mcu7t3v3__nor2_2_4/VNW VSUBS
+ gf180mcu_as_sc_mcu7t3v3__inv_2
Xgf180mcu_as_sc_mcu7t3v3__inv_2_467 gf180mcu_as_sc_mcu7t3v3__nor2_2_4/VDD gf180mcu_as_sc_mcu7t3v3__nand2_2_3/VSS
+ VSS VSS gf180mcu_as_sc_mcu7t3v3__nor2_2_4/VNW VSUBS gf180mcu_as_sc_mcu7t3v3__inv_2
Xgf180mcu_as_sc_mcu7t3v3__inv_2_434 gf180mcu_as_sc_mcu7t3v3__nor2_2_4/VDD gf180mcu_as_sc_mcu7t3v3__nor2_2_4/VSS
+ VSS VSS gf180mcu_as_sc_mcu7t3v3__nor2_2_4/VNW VSUBS gf180mcu_as_sc_mcu7t3v3__inv_2
Xgf180mcu_as_sc_mcu7t3v3__inv_2_423 gf180mcu_as_sc_mcu7t3v3__nand3_2_9/VDD gf180mcu_as_sc_mcu7t3v3__nor2_2_4/VSS
+ gf180mcu_as_sc_mcu7t3v3__inv_2_423/Y VSS gf180mcu_as_sc_mcu7t3v3__nand3_2_9/VNW
+ VSUBS gf180mcu_as_sc_mcu7t3v3__inv_2
Xgf180mcu_as_sc_mcu7t3v3__inv_2_489 VSS VSS gf180mcu_as_sc_mcu7t3v3__inv_2_489/Y gf180mcu_as_sc_mcu7t3v3__inv_2_489/A
+ gf180mcu_as_sc_mcu7t3v3__inv_2_552/VNW VSUBS gf180mcu_as_sc_mcu7t3v3__inv_2
Xu_t010_006 u_t010_006/c0_w0_bl u_t010_006/c0_w0_br u_t010_006/c0_w1_bl u_t010_006/c0_w1_br
+ u_t010_006/c0_r0_rbl u_t010_006/c0_r1_rbl u_t010_006/c1_w0_bl u_t010_006/c1_w0_br
+ u_t010_006/c1_w1_bl u_t010_006/c1_w1_br u_t010_006/c1_r0_rbl u_t010_006/c1_r1_rbl
+ u_t010_006/c2_w0_bl u_t010_006/c2_w0_br u_t010_006/c2_w1_bl u_t010_006/c2_w1_br
+ u_t010_006/c2_r0_rbl u_t010_006/c2_r1_rbl u_t010_006/c3_w0_bl u_t010_006/c3_w0_br
+ u_t010_006/c3_w1_bl u_t010_006/c3_w1_br u_t010_006/c3_r0_rbl u_t010_006/c3_r1_rbl
+ u_t010_006/r0_w0_wl u_t010_006/r0_w1_wl u_t010_006/r0_r0_rwl u_t010_006/r0_r1_rwl
+ u_t010_006/r1_w0_wl u_t010_006/r1_w1_wl u_t010_006/r1_r0_rwl u_t010_006/r1_r1_rwl
+ u_t010_006/r2_w0_wl u_t010_006/r2_w1_wl u_t010_006/r2_r0_rwl u_t010_006/r2_r1_rwl
+ u_t010_006/r3_w0_wl u_t010_006/r3_w1_wl u_t010_006/r3_r0_rwl u_t010_006/r3_r1_rwl
+ VSS VSS u_t010_006/m2_717_1265# u_t010_006/m2_603_2031# u_t010_006/m2_1290_336#
+ u_t010_006/m2_2000_2037# u_t010_006/m2_791_2909# u_t010_006/m2_7_2126# u_t010_006/m2_2154_2081#
+ u_t010_006/m2_1795_2037# u_t010_006/m2_871_303# u_t010_006/m2_431_438# u_t010_006/m2_1290_2898#
+ u_t010_006/m2_1714_1210# u_t010_006/m2_431_1982# u_t010_006/m2_512_1265# u_t010_006/m2_2573_2126#
+ u_t010_006/m2_603_1259# u_t010_006/m2_2074_2909# u_t010_006/m2_7_336# u_t010_006/m2_717_2037#
+ u_t010_006/m2_1886_2031# u_t010_006/m2_2573_336# u_t010_006/m2_7_2898# u_t010_006/m2_2000_1265#
+ u_t010_006/m2_512_2037# u_t010_006/m2_1795_1265# u_t010_006/m2_1714_1982# u_t010_006/m2_1886_1259#
+ u_t010_006/m2_1290_2126# u_t010_006/m2_1714_438# u_t010_006/m2_431_1210# u_t010_006/m2_2573_2898#
+ u_t010_006/m2_2154_303# u_t010_006/m2_871_2081# VSUBS detronyx_12t_2w2r_rc4_4x4_routed_5layer_direct
Xgf180mcu_as_sc_mcu7t3v3__inv_2_990 VSS VSS VSS gf180mcu_as_sc_mcu7t3v3__inv_2_991/Y
+ gf180mcu_as_sc_mcu7t3v3__inv_2_992/VNW VSUBS gf180mcu_as_sc_mcu7t3v3__inv_2
Xu_t001_006 u_t001_006/c0_w0_bl u_t001_006/c0_w0_br u_t001_006/c0_w1_bl u_t001_006/c0_w1_br
+ u_t001_006/c0_r0_rbl u_t001_006/c0_r1_rbl u_t001_006/c1_w0_bl u_t001_006/c1_w0_br
+ u_t001_006/c1_w1_bl u_t001_006/c1_w1_br u_t001_006/c1_r0_rbl u_t001_006/c1_r1_rbl
+ u_t001_006/c2_w0_bl u_t001_006/c2_w0_br u_t001_006/c2_w1_bl u_t001_006/c2_w1_br
+ u_t001_006/c2_r0_rbl u_t001_006/c2_r1_rbl u_t001_006/c3_w0_bl u_t001_006/c3_w0_br
+ u_t001_006/c3_w1_bl u_t001_006/c3_w1_br u_t001_006/c3_r0_rbl u_t001_006/c3_r1_rbl
+ u_t001_006/r0_w0_wl u_t001_006/r0_w1_wl u_t001_006/r0_r0_rwl u_t001_006/r0_r1_rwl
+ u_t001_006/r1_w0_wl u_t001_006/r1_w1_wl u_t001_006/r1_r0_rwl u_t001_006/r1_r1_rwl
+ u_t001_006/r2_w0_wl u_t001_006/r2_w1_wl u_t001_006/r2_r0_rwl u_t001_006/r2_r1_rwl
+ u_t001_006/r3_w0_wl u_t001_006/r3_w1_wl u_t001_006/r3_r0_rwl u_t001_006/r3_r1_rwl
+ VSS VSS u_t001_006/m2_717_1265# u_t001_006/m2_603_2031# u_t001_006/m2_1290_336#
+ u_t001_006/m2_2000_2037# u_t001_006/m2_791_2909# u_t001_006/m2_7_2126# u_t001_006/m2_2154_2081#
+ u_t001_006/m2_1795_2037# u_t001_006/m2_871_303# u_t001_006/m2_431_438# u_t001_006/m2_1290_2898#
+ u_t001_006/m2_1714_1210# u_t001_006/m2_431_1982# u_t001_006/m2_512_1265# u_t001_006/m2_2573_2126#
+ u_t001_006/m2_603_1259# u_t001_006/m2_2074_2909# u_t001_006/m2_7_336# u_t001_006/m2_717_2037#
+ u_t001_006/m2_1886_2031# u_t001_006/m2_2573_336# u_t001_006/m2_7_2898# u_t001_006/m2_2000_1265#
+ u_t001_006/m2_512_2037# u_t001_006/m2_1795_1265# u_t001_006/m2_1714_1982# u_t001_006/m2_1886_1259#
+ u_t001_006/m2_1290_2126# u_t001_006/m2_1714_438# u_t001_006/m2_431_1210# u_t001_006/m2_2573_2898#
+ u_t001_006/m2_2154_303# u_t001_006/m2_871_2081# VSUBS detronyx_12t_2w2r_rc4_4x4_routed_5layer_direct
Xgf180mcu_as_sc_mcu7t3v3__inv_2_1708 gf180mcu_as_sc_mcu7t3v3__nor2_2_6/VDD gf180mcu_as_sc_mcu7t3v3__nand3_2_4/VSS
+ VSS VSS gf180mcu_as_sc_mcu7t3v3__nor2_2_6/VNW VSUBS gf180mcu_as_sc_mcu7t3v3__inv_2
Xgf180mcu_as_sc_mcu7t3v3__inv_2_264 VSS VSS gf180mcu_as_sc_mcu7t3v3__inv_2_264/Y gf180mcu_as_sc_mcu7t3v3__inv_2_264/A
+ gf180mcu_as_sc_mcu7t3v3__inv_2_264/VNW VSUBS gf180mcu_as_sc_mcu7t3v3__inv_2
Xgf180mcu_as_sc_mcu7t3v3__inv_2_275 VSS VSS gf180mcu_as_sc_mcu7t3v3__inv_2_275/Y gf180mcu_as_sc_mcu7t3v3__inv_2_280/Y
+ gf180mcu_as_sc_mcu7t3v3__inv_2_280/VNW VSUBS gf180mcu_as_sc_mcu7t3v3__inv_2
Xgf180mcu_as_sc_mcu7t3v3__inv_2_286 VSS VSS gf180mcu_as_sc_mcu7t3v3__inv_2_286/Y gf180mcu_as_sc_mcu7t3v3__inv_2_287/Y
+ gf180mcu_as_sc_mcu7t3v3__inv_2_287/VNW VSUBS gf180mcu_as_sc_mcu7t3v3__inv_2
Xgf180mcu_as_sc_mcu7t3v3__inv_2_297 VSS VSS gf180mcu_as_sc_mcu7t3v3__inv_2_297/Y gf180mcu_as_sc_mcu7t3v3__inv_2_297/A
+ gf180mcu_as_sc_mcu7t3v3__inv_2_297/VNW VSUBS gf180mcu_as_sc_mcu7t3v3__inv_2
Xgf180mcu_as_sc_mcu7t3v3__inv_2_220 VSS VSS gf180mcu_as_sc_mcu7t3v3__inv_2_220/Y gf180mcu_as_sc_mcu7t3v3__inv_2_221/Y
+ gf180mcu_as_sc_mcu7t3v3__inv_2_221/VNW VSUBS gf180mcu_as_sc_mcu7t3v3__inv_2
Xgf180mcu_as_sc_mcu7t3v3__inv_2_253 VSS VSS gf180mcu_as_sc_mcu7t3v3__inv_2_253/Y gf180mcu_as_sc_mcu7t3v3__inv_2_254/Y
+ gf180mcu_as_sc_mcu7t3v3__inv_2_254/VNW VSUBS gf180mcu_as_sc_mcu7t3v3__inv_2
Xgf180mcu_as_sc_mcu7t3v3__inv_2_242 VSS VSS gf180mcu_as_sc_mcu7t3v3__inv_2_242/Y gf180mcu_as_sc_mcu7t3v3__inv_2_242/A
+ gf180mcu_as_sc_mcu7t3v3__inv_2_242/VNW VSUBS gf180mcu_as_sc_mcu7t3v3__inv_2
Xgf180mcu_as_sc_mcu7t3v3__inv_2_1719 VSS VSS gf180mcu_as_sc_mcu7t3v3__inv_2_1719/Y
+ gf180mcu_as_sc_mcu7t3v3__inv_2_1720/Y gf180mcu_as_sc_mcu7t3v3__inv_2_1720/VNW VSUBS
+ gf180mcu_as_sc_mcu7t3v3__inv_2
Xgf180mcu_as_sc_mcu7t3v3__inv_2_231 VSS VSS VSS gf180mcu_as_sc_mcu7t3v3__inv_2_232/Y
+ gf180mcu_as_sc_mcu7t3v3__inv_2_233/VNW VSUBS gf180mcu_as_sc_mcu7t3v3__inv_2
Xgf180mcu_as_sc_mcu7t3v3__inv_2_1549 VSS VSS gf180mcu_as_sc_mcu7t3v3__inv_2_1549/Y
+ gf180mcu_as_sc_mcu7t3v3__inv_2_1550/Y gf180mcu_as_sc_mcu7t3v3__inv_2_1550/VNW VSUBS
+ gf180mcu_as_sc_mcu7t3v3__inv_2
Xgf180mcu_as_sc_mcu7t3v3__inv_2_1527 VSS VSS VSS gf180mcu_as_sc_mcu7t3v3__inv_2_1528/Y
+ gf180mcu_as_sc_mcu7t3v3__inv_2_1529/VNW VSUBS gf180mcu_as_sc_mcu7t3v3__inv_2
Xgf180mcu_as_sc_mcu7t3v3__inv_2_1516 VSS VSS gf180mcu_as_sc_mcu7t3v3__inv_2_1516/Y
+ gf180mcu_as_sc_mcu7t3v3__inv_2_1520/Y gf180mcu_as_sc_mcu7t3v3__inv_2_1520/VNW VSUBS
+ gf180mcu_as_sc_mcu7t3v3__inv_2
Xgf180mcu_as_sc_mcu7t3v3__inv_2_1538 VSS VSS gf180mcu_as_sc_mcu7t3v3__inv_2_1538/Y
+ gf180mcu_as_sc_mcu7t3v3__inv_2_1538/A gf180mcu_as_sc_mcu7t3v3__inv_2_1538/VNW VSUBS
+ gf180mcu_as_sc_mcu7t3v3__inv_2
Xgf180mcu_as_sc_mcu7t3v3__inv_2_1505 VSS VSS gf180mcu_as_sc_mcu7t3v3__inv_2_1505/Y
+ gf180mcu_as_sc_mcu7t3v3__inv_2_1506/Y gf180mcu_as_sc_mcu7t3v3__inv_2_1506/VNW VSUBS
+ gf180mcu_as_sc_mcu7t3v3__inv_2
Xgf180mcu_as_sc_mcu7t3v3__nand2_2_4 gf180mcu_as_sc_mcu7t3v3__nor2_2_6/VDD gf180mcu_as_sc_mcu7t3v3__nand3_2_4/VSS
+ VSS VSS VSS gf180mcu_as_sc_mcu7t3v3__nor2_2_6/VNW VSUBS gf180mcu_as_sc_mcu7t3v3__nand2_2
Xu_t029_009 u_t029_009/c0_w0_bl u_t029_009/c0_w0_br u_t029_009/c0_w1_bl u_t029_009/c0_w1_br
+ u_t029_009/c0_r0_rbl u_t029_009/c0_r1_rbl u_t029_009/c1_w0_bl u_t029_009/c1_w0_br
+ u_t029_009/c1_w1_bl u_t029_009/c1_w1_br u_t029_009/c1_r0_rbl u_t029_009/c1_r1_rbl
+ u_t029_009/c2_w0_bl u_t029_009/c2_w0_br u_t029_009/c2_w1_bl u_t029_009/c2_w1_br
+ u_t029_009/c2_r0_rbl u_t029_009/c2_r1_rbl u_t029_009/c3_w0_bl u_t029_009/c3_w0_br
+ u_t029_009/c3_w1_bl u_t029_009/c3_w1_br u_t029_009/c3_r0_rbl u_t029_009/c3_r1_rbl
+ u_t029_009/r0_w0_wl u_t029_009/r0_w1_wl u_t029_009/r0_r0_rwl u_t029_009/r0_r1_rwl
+ u_t029_009/r1_w0_wl u_t029_009/r1_w1_wl u_t029_009/r1_r0_rwl u_t029_009/r1_r1_rwl
+ u_t029_009/r2_w0_wl u_t029_009/r2_w1_wl u_t029_009/r2_r0_rwl u_t029_009/r2_r1_rwl
+ u_t029_009/r3_w0_wl u_t029_009/r3_w1_wl u_t029_009/r3_r0_rwl u_t029_009/r3_r1_rwl
+ VSS VSS u_t029_009/m2_717_1265# u_t029_009/m2_603_2031# u_t029_009/m2_1290_336#
+ u_t029_009/m2_2000_2037# u_t029_009/m2_791_2909# u_t029_009/m2_7_2126# u_t029_009/m2_2154_2081#
+ u_t029_009/m2_1795_2037# u_t029_009/m2_871_303# u_t029_009/m2_431_438# u_t029_009/m2_1290_2898#
+ u_t029_009/m2_1714_1210# u_t029_009/m2_431_1982# u_t029_009/m2_512_1265# u_t029_009/m2_2573_2126#
+ u_t029_009/m2_603_1259# u_t029_009/m2_2074_2909# u_t029_009/m2_7_336# u_t029_009/m2_717_2037#
+ u_t029_009/m2_1886_2031# u_t029_009/m2_2573_336# u_t029_009/m2_7_2898# u_t029_009/m2_2000_1265#
+ u_t029_009/m2_512_2037# u_t029_009/m2_1795_1265# u_t029_009/m2_1714_1982# u_t029_009/m2_1886_1259#
+ u_t029_009/m2_1290_2126# u_t029_009/m2_1714_438# u_t029_009/m2_431_1210# u_t029_009/m2_2573_2898#
+ u_t029_009/m2_2154_303# u_t029_009/m2_871_2081# VSUBS detronyx_12t_2w2r_rc4_4x4_routed_5layer_direct
Xgf180mcu_as_sc_mcu7t3v3__inv_2_1368 VSS VSS VSS gf180mcu_as_sc_mcu7t3v3__inv_2_1369/Y
+ gf180mcu_as_sc_mcu7t3v3__inv_2_1370/VNW VSUBS gf180mcu_as_sc_mcu7t3v3__inv_2
Xgf180mcu_as_sc_mcu7t3v3__inv_2_1302 VSS VSS VSS gf180mcu_as_sc_mcu7t3v3__inv_2_1303/Y
+ gf180mcu_as_sc_mcu7t3v3__inv_2_1304/VNW VSUBS gf180mcu_as_sc_mcu7t3v3__inv_2
Xgf180mcu_as_sc_mcu7t3v3__inv_2_1379 VSS VSS VSS gf180mcu_as_sc_mcu7t3v3__inv_2_1395/Y
+ gf180mcu_as_sc_mcu7t3v3__inv_2_1395/VNW VSUBS gf180mcu_as_sc_mcu7t3v3__inv_2
Xgf180mcu_as_sc_mcu7t3v3__inv_2_1357 VSS VSS gf180mcu_as_sc_mcu7t3v3__inv_2_1357/Y
+ gf180mcu_as_sc_mcu7t3v3__inv_2_1358/Y gf180mcu_as_sc_mcu7t3v3__inv_2_1358/VNW VSUBS
+ gf180mcu_as_sc_mcu7t3v3__inv_2
Xgf180mcu_as_sc_mcu7t3v3__inv_2_1324 VSS VSS gf180mcu_as_sc_mcu7t3v3__inv_2_1324/Y
+ gf180mcu_as_sc_mcu7t3v3__inv_2_1324/A gf180mcu_as_sc_mcu7t3v3__inv_2_1324/VNW VSUBS
+ gf180mcu_as_sc_mcu7t3v3__inv_2
Xgf180mcu_as_sc_mcu7t3v3__inv_2_1313 VSS VSS gf180mcu_as_sc_mcu7t3v3__inv_2_1313/Y
+ gf180mcu_as_sc_mcu7t3v3__inv_2_1317/Y gf180mcu_as_sc_mcu7t3v3__inv_2_1317/VNW VSUBS
+ gf180mcu_as_sc_mcu7t3v3__inv_2
Xgf180mcu_as_sc_mcu7t3v3__inv_2_1346 VSS VSS VSS gf180mcu_as_sc_mcu7t3v3__inv_2_1347/Y
+ gf180mcu_as_sc_mcu7t3v3__inv_2_1348/VNW VSUBS gf180mcu_as_sc_mcu7t3v3__inv_2
Xgf180mcu_as_sc_mcu7t3v3__inv_2_1335 VSS VSS gf180mcu_as_sc_mcu7t3v3__inv_2_1335/Y
+ gf180mcu_as_sc_mcu7t3v3__inv_2_1336/Y gf180mcu_as_sc_mcu7t3v3__inv_2_1336/VNW VSUBS
+ gf180mcu_as_sc_mcu7t3v3__inv_2
Xgf180mcu_as_sc_mcu7t3v3__inv_2_819 VSS VSS gf180mcu_as_sc_mcu7t3v3__inv_2_819/Y gf180mcu_as_sc_mcu7t3v3__inv_2_819/A
+ gf180mcu_as_sc_mcu7t3v3__inv_2_819/VNW VSUBS gf180mcu_as_sc_mcu7t3v3__inv_2
Xgf180mcu_as_sc_mcu7t3v3__inv_2_808 VSS VSS gf180mcu_as_sc_mcu7t3v3__inv_2_839/A gf180mcu_as_sc_mcu7t3v3__inv_2_809/Y
+ gf180mcu_as_sc_mcu7t3v3__inv_2_839/VNW VSUBS gf180mcu_as_sc_mcu7t3v3__inv_2
Xgf180mcu_as_sc_mcu7t3v3__nand4_2_129 VSS VSS VSS VSS VSS VSS gf180mcu_as_sc_mcu7t3v3__inv_2_485/A
+ gf180mcu_as_sc_mcu7t3v3__inv_2_548/VNW VSUBS gf180mcu_as_sc_mcu7t3v3__nand4_2
Xgf180mcu_as_sc_mcu7t3v3__nand4_2_24 VSS VSS VSS VSS VSS VSS gf180mcu_as_sc_mcu7t3v3__inv_2_152/A
+ gf180mcu_as_sc_mcu7t3v3__inv_2_152/VNW VSUBS gf180mcu_as_sc_mcu7t3v3__nand4_2
Xgf180mcu_as_sc_mcu7t3v3__nand4_2_13 VSS VSS VSS VSS VSS VSS gf180mcu_as_sc_mcu7t3v3__inv_2_119/A
+ gf180mcu_as_sc_mcu7t3v3__inv_2_119/VNW VSUBS gf180mcu_as_sc_mcu7t3v3__nand4_2
Xgf180mcu_as_sc_mcu7t3v3__nand4_2_107 VSS VSS VSS VSS VSS VSS gf180mcu_as_sc_mcu7t3v3__inv_2_264/A
+ gf180mcu_as_sc_mcu7t3v3__inv_2_264/VNW VSUBS gf180mcu_as_sc_mcu7t3v3__nand4_2
Xgf180mcu_as_sc_mcu7t3v3__nand4_2_118 VSS VSS VSS VSS VSS VSS gf180mcu_as_sc_mcu7t3v3__inv_2_287/A
+ gf180mcu_as_sc_mcu7t3v3__inv_2_287/VNW VSUBS gf180mcu_as_sc_mcu7t3v3__nand4_2
Xgf180mcu_as_sc_mcu7t3v3__nand4_2_35 VSS VSS VSS VSS VSS VSS gf180mcu_as_sc_mcu7t3v3__inv_2_187/A
+ gf180mcu_as_sc_mcu7t3v3__inv_2_187/VNW VSUBS gf180mcu_as_sc_mcu7t3v3__nand4_2
Xgf180mcu_as_sc_mcu7t3v3__nand4_2_79 VSS VSS VSS VSS VSS VSS gf180mcu_as_sc_mcu7t3v3__inv_2_49/A
+ gf180mcu_as_sc_mcu7t3v3__inv_2_49/VNW VSUBS gf180mcu_as_sc_mcu7t3v3__nand4_2
Xgf180mcu_as_sc_mcu7t3v3__nand4_2_68 VSS VSS VSS VSS VSS VSS gf180mcu_as_sc_mcu7t3v3__inv_2_28/A
+ gf180mcu_as_sc_mcu7t3v3__inv_2_28/VNW VSUBS gf180mcu_as_sc_mcu7t3v3__nand4_2
Xgf180mcu_as_sc_mcu7t3v3__nand4_2_46 VSS VSS VSS VSS VSS VSS gf180mcu_as_sc_mcu7t3v3__inv_2_218/A
+ gf180mcu_as_sc_mcu7t3v3__inv_2_218/VNW VSUBS gf180mcu_as_sc_mcu7t3v3__nand4_2
Xgf180mcu_as_sc_mcu7t3v3__nand4_2_57 VSS VSS VSS VSS VSS VSS gf180mcu_as_sc_mcu7t3v3__inv_2_251/A
+ gf180mcu_as_sc_mcu7t3v3__inv_2_251/VNW VSUBS gf180mcu_as_sc_mcu7t3v3__nand4_2
Xu_t025_012 u_t025_012/c0_w0_bl u_t025_012/c0_w0_br u_t025_012/c0_w1_bl u_t025_012/c0_w1_br
+ u_t025_012/c0_r0_rbl u_t025_012/c0_r1_rbl u_t025_012/c1_w0_bl u_t025_012/c1_w0_br
+ u_t025_012/c1_w1_bl u_t025_012/c1_w1_br u_t025_012/c1_r0_rbl u_t025_012/c1_r1_rbl
+ u_t025_012/c2_w0_bl u_t025_012/c2_w0_br u_t025_012/c2_w1_bl u_t025_012/c2_w1_br
+ u_t025_012/c2_r0_rbl u_t025_012/c2_r1_rbl u_t025_012/c3_w0_bl u_t025_012/c3_w0_br
+ u_t025_012/c3_w1_bl u_t025_012/c3_w1_br u_t025_012/c3_r0_rbl u_t025_012/c3_r1_rbl
+ u_t025_012/r0_w0_wl u_t025_012/r0_w1_wl u_t025_012/r0_r0_rwl u_t025_012/r0_r1_rwl
+ u_t025_012/r1_w0_wl u_t025_012/r1_w1_wl u_t025_012/r1_r0_rwl u_t025_012/r1_r1_rwl
+ u_t025_012/r2_w0_wl u_t025_012/r2_w1_wl u_t025_012/r2_r0_rwl u_t025_012/r2_r1_rwl
+ u_t025_012/r3_w0_wl u_t025_012/r3_w1_wl u_t025_012/r3_r0_rwl u_t025_012/r3_r1_rwl
+ VSS VSS u_t025_012/m2_717_1265# u_t025_012/m2_603_2031# u_t025_012/m2_1290_336#
+ u_t025_012/m2_2000_2037# u_t025_012/m2_791_2909# u_t025_012/m2_7_2126# u_t025_012/m2_2154_2081#
+ u_t025_012/m2_1795_2037# u_t025_012/m2_871_303# u_t025_012/m2_431_438# u_t025_012/m2_1290_2898#
+ u_t025_012/m2_1714_1210# u_t025_012/m2_431_1982# u_t025_012/m2_512_1265# u_t025_012/m2_2573_2126#
+ u_t025_012/m2_603_1259# u_t025_012/m2_2074_2909# u_t025_012/m2_7_336# u_t025_012/m2_717_2037#
+ u_t025_012/m2_1886_2031# u_t025_012/m2_2573_336# u_t025_012/m2_7_2898# u_t025_012/m2_2000_1265#
+ u_t025_012/m2_512_2037# u_t025_012/m2_1795_1265# u_t025_012/m2_1714_1982# u_t025_012/m2_1886_1259#
+ u_t025_012/m2_1290_2126# u_t025_012/m2_1714_438# u_t025_012/m2_431_1210# u_t025_012/m2_2573_2898#
+ u_t025_012/m2_2154_303# u_t025_012/m2_871_2081# VSUBS detronyx_12t_2w2r_rc4_4x4_routed_5layer_direct
Xu_t025_001 u_t025_001/c0_w0_bl u_t025_001/c0_w0_br u_t025_001/c0_w1_bl u_t025_001/c0_w1_br
+ u_t025_001/c0_r0_rbl u_t025_001/c0_r1_rbl u_t025_001/c1_w0_bl u_t025_001/c1_w0_br
+ u_t025_001/c1_w1_bl u_t025_001/c1_w1_br u_t025_001/c1_r0_rbl u_t025_001/c1_r1_rbl
+ u_t025_001/c2_w0_bl u_t025_001/c2_w0_br u_t025_001/c2_w1_bl u_t025_001/c2_w1_br
+ u_t025_001/c2_r0_rbl u_t025_001/c2_r1_rbl u_t025_001/c3_w0_bl u_t025_001/c3_w0_br
+ u_t025_001/c3_w1_bl u_t025_001/c3_w1_br u_t025_001/c3_r0_rbl u_t025_001/c3_r1_rbl
+ u_t025_001/r0_w0_wl u_t025_001/r0_w1_wl u_t025_001/r0_r0_rwl u_t025_001/r0_r1_rwl
+ u_t025_001/r1_w0_wl u_t025_001/r1_w1_wl u_t025_001/r1_r0_rwl u_t025_001/r1_r1_rwl
+ u_t025_001/r2_w0_wl u_t025_001/r2_w1_wl u_t025_001/r2_r0_rwl u_t025_001/r2_r1_rwl
+ u_t025_001/r3_w0_wl u_t025_001/r3_w1_wl u_t025_001/r3_r0_rwl u_t025_001/r3_r1_rwl
+ VSS VSS u_t025_001/m2_717_1265# u_t025_001/m2_603_2031# u_t025_001/m2_1290_336#
+ u_t025_001/m2_2000_2037# u_t025_001/m2_791_2909# u_t025_001/m2_7_2126# u_t025_001/m2_2154_2081#
+ u_t025_001/m2_1795_2037# u_t025_001/m2_871_303# u_t025_001/m2_431_438# u_t025_001/m2_1290_2898#
+ u_t025_001/m2_1714_1210# u_t025_001/m2_431_1982# u_t025_001/m2_512_1265# u_t025_001/m2_2573_2126#
+ u_t025_001/m2_603_1259# u_t025_001/m2_2074_2909# u_t025_001/m2_7_336# u_t025_001/m2_717_2037#
+ u_t025_001/m2_1886_2031# u_t025_001/m2_2573_336# u_t025_001/m2_7_2898# u_t025_001/m2_2000_1265#
+ u_t025_001/m2_512_2037# u_t025_001/m2_1795_1265# u_t025_001/m2_1714_1982# u_t025_001/m2_1886_1259#
+ u_t025_001/m2_1290_2126# u_t025_001/m2_1714_438# u_t025_001/m2_431_1210# u_t025_001/m2_2573_2898#
+ u_t025_001/m2_2154_303# u_t025_001/m2_871_2081# VSUBS detronyx_12t_2w2r_rc4_4x4_routed_5layer_direct
Xgf180mcu_as_sc_mcu7t3v3__inv_2_1110 VSS VSS gf180mcu_as_sc_mcu7t3v3__inv_2_1110/Y
+ gf180mcu_as_sc_mcu7t3v3__inv_2_1111/Y gf180mcu_as_sc_mcu7t3v3__inv_2_1111/VNW VSUBS
+ gf180mcu_as_sc_mcu7t3v3__inv_2
Xgf180mcu_as_sc_mcu7t3v3__inv_2_1132 VSS VSS gf180mcu_as_sc_mcu7t3v3__inv_2_1132/Y
+ gf180mcu_as_sc_mcu7t3v3__inv_2_1133/Y gf180mcu_as_sc_mcu7t3v3__inv_2_1133/VNW VSUBS
+ gf180mcu_as_sc_mcu7t3v3__inv_2
Xgf180mcu_as_sc_mcu7t3v3__inv_2_1187 VSS VSS gf180mcu_as_sc_mcu7t3v3__inv_2_1279/A
+ gf180mcu_as_sc_mcu7t3v3__inv_2_1188/Y gf180mcu_as_sc_mcu7t3v3__inv_2_1279/VNW VSUBS
+ gf180mcu_as_sc_mcu7t3v3__inv_2
Xgf180mcu_as_sc_mcu7t3v3__inv_2_1143 VSS VSS VSS gf180mcu_as_sc_mcu7t3v3__inv_2_1144/Y
+ gf180mcu_as_sc_mcu7t3v3__inv_2_1145/VNW VSUBS gf180mcu_as_sc_mcu7t3v3__inv_2
Xgf180mcu_as_sc_mcu7t3v3__inv_2_1198 VSS VSS gf180mcu_as_sc_mcu7t3v3__inv_2_1198/Y
+ gf180mcu_as_sc_mcu7t3v3__inv_2_1198/A gf180mcu_as_sc_mcu7t3v3__inv_2_1280/VNW VSUBS
+ gf180mcu_as_sc_mcu7t3v3__inv_2
Xgf180mcu_as_sc_mcu7t3v3__inv_2_1121 VSS VSS gf180mcu_as_sc_mcu7t3v3__inv_2_1121/Y
+ gf180mcu_as_sc_mcu7t3v3__inv_2_1121/A gf180mcu_as_sc_mcu7t3v3__inv_2_1121/VNW VSUBS
+ gf180mcu_as_sc_mcu7t3v3__inv_2
Xgf180mcu_as_sc_mcu7t3v3__inv_2_1154 VSS VSS gf180mcu_as_sc_mcu7t3v3__inv_2_1154/Y
+ gf180mcu_as_sc_mcu7t3v3__inv_2_1154/A gf180mcu_as_sc_mcu7t3v3__inv_2_1263/VNW VSUBS
+ gf180mcu_as_sc_mcu7t3v3__inv_2
Xgf180mcu_as_sc_mcu7t3v3__inv_2_1176 VSS VSS gf180mcu_as_sc_mcu7t3v3__inv_2_1296/A
+ gf180mcu_as_sc_mcu7t3v3__inv_2_1177/Y gf180mcu_as_sc_mcu7t3v3__inv_2_1296/VNW VSUBS
+ gf180mcu_as_sc_mcu7t3v3__inv_2
Xgf180mcu_as_sc_mcu7t3v3__inv_2_1165 VSS VSS gf180mcu_as_sc_mcu7t3v3__inv_2_1165/Y
+ gf180mcu_as_sc_mcu7t3v3__inv_2_1165/A gf180mcu_as_sc_mcu7t3v3__inv_2_1299/VNW VSUBS
+ gf180mcu_as_sc_mcu7t3v3__inv_2
Xu_t031_015 u_t031_015/c0_w0_bl u_t031_015/c0_w0_br u_t031_015/c0_w1_bl u_t031_015/c0_w1_br
+ u_t031_015/c0_r0_rbl u_t031_015/c0_r1_rbl u_t031_015/c1_w0_bl u_t031_015/c1_w0_br
+ u_t031_015/c1_w1_bl u_t031_015/c1_w1_br u_t031_015/c1_r0_rbl u_t031_015/c1_r1_rbl
+ u_t031_015/c2_w0_bl u_t031_015/c2_w0_br u_t031_015/c2_w1_bl u_t031_015/c2_w1_br
+ u_t031_015/c2_r0_rbl u_t031_015/c2_r1_rbl u_t031_015/c3_w0_bl u_t031_015/c3_w0_br
+ u_t031_015/c3_w1_bl u_t031_015/c3_w1_br u_t031_015/c3_r0_rbl u_t031_015/c3_r1_rbl
+ u_t031_015/r0_w0_wl u_t031_015/r0_w1_wl u_t031_015/r0_r0_rwl u_t031_015/r0_r1_rwl
+ u_t031_015/r1_w0_wl u_t031_015/r1_w1_wl u_t031_015/r1_r0_rwl u_t031_015/r1_r1_rwl
+ u_t031_015/r2_w0_wl u_t031_015/r2_w1_wl u_t031_015/r2_r0_rwl u_t031_015/r2_r1_rwl
+ u_t031_015/r3_w0_wl u_t031_015/r3_w1_wl u_t031_015/r3_r0_rwl u_t031_015/r3_r1_rwl
+ VSS VSS u_t031_015/m2_717_1265# u_t031_015/m2_603_2031# u_t031_015/m2_1290_336#
+ u_t031_015/m2_2000_2037# u_t031_015/m2_791_2909# u_t031_015/m2_7_2126# u_t031_015/m2_2154_2081#
+ u_t031_015/m2_1795_2037# u_t031_015/m2_871_303# u_t031_015/m2_431_438# u_t031_015/m2_1290_2898#
+ u_t031_015/m2_1714_1210# u_t031_015/m2_431_1982# u_t031_015/m2_512_1265# u_t031_015/m2_2573_2126#
+ u_t031_015/m2_603_1259# u_t031_015/m2_2074_2909# u_t031_015/m2_7_336# u_t031_015/m2_717_2037#
+ u_t031_015/m2_1886_2031# u_t031_015/m2_2573_336# u_t031_015/m2_7_2898# u_t031_015/m2_2000_1265#
+ u_t031_015/m2_512_2037# u_t031_015/m2_1795_1265# u_t031_015/m2_1714_1982# u_t031_015/m2_1886_1259#
+ u_t031_015/m2_1290_2126# u_t031_015/m2_1714_438# u_t031_015/m2_431_1210# u_t031_015/m2_2573_2898#
+ u_t031_015/m2_2154_303# u_t031_015/m2_871_2081# VSUBS detronyx_12t_2w2r_rc4_4x4_routed_5layer_direct
Xu_t016_012 u_t016_012/c0_w0_bl u_t016_012/c0_w0_br u_t016_012/c0_w1_bl u_t016_012/c0_w1_br
+ u_t016_012/c0_r0_rbl u_t016_012/c0_r1_rbl u_t016_012/c1_w0_bl u_t016_012/c1_w0_br
+ u_t016_012/c1_w1_bl u_t016_012/c1_w1_br u_t016_012/c1_r0_rbl u_t016_012/c1_r1_rbl
+ u_t016_012/c2_w0_bl u_t016_012/c2_w0_br u_t016_012/c2_w1_bl u_t016_012/c2_w1_br
+ u_t016_012/c2_r0_rbl u_t016_012/c2_r1_rbl u_t016_012/c3_w0_bl u_t016_012/c3_w0_br
+ u_t016_012/c3_w1_bl u_t016_012/c3_w1_br u_t016_012/c3_r0_rbl u_t016_012/c3_r1_rbl
+ u_t016_012/r0_w0_wl u_t016_012/r0_w1_wl u_t016_012/r0_r0_rwl u_t016_012/r0_r1_rwl
+ u_t016_012/r1_w0_wl u_t016_012/r1_w1_wl u_t016_012/r1_r0_rwl u_t016_012/r1_r1_rwl
+ u_t016_012/r2_w0_wl u_t016_012/r2_w1_wl u_t016_012/r2_r0_rwl u_t016_012/r2_r1_rwl
+ u_t016_012/r3_w0_wl u_t016_012/r3_w1_wl u_t016_012/r3_r0_rwl u_t016_012/r3_r1_rwl
+ VSS VSS u_t016_012/m2_717_1265# u_t016_012/m2_603_2031# u_t016_012/m2_1290_336#
+ u_t016_012/m2_2000_2037# u_t016_012/m2_791_2909# u_t016_012/m2_7_2126# u_t016_012/m2_2154_2081#
+ u_t016_012/m2_1795_2037# u_t016_012/m2_871_303# u_t016_012/m2_431_438# u_t016_012/m2_1290_2898#
+ u_t016_012/m2_1714_1210# u_t016_012/m2_431_1982# u_t016_012/m2_512_1265# u_t016_012/m2_2573_2126#
+ u_t016_012/m2_603_1259# u_t016_012/m2_2074_2909# u_t016_012/m2_7_336# u_t016_012/m2_717_2037#
+ u_t016_012/m2_1886_2031# u_t016_012/m2_2573_336# u_t016_012/m2_7_2898# u_t016_012/m2_2000_1265#
+ u_t016_012/m2_512_2037# u_t016_012/m2_1795_1265# u_t016_012/m2_1714_1982# u_t016_012/m2_1886_1259#
+ u_t016_012/m2_1290_2126# u_t016_012/m2_1714_438# u_t016_012/m2_431_1210# u_t016_012/m2_2573_2898#
+ u_t016_012/m2_2154_303# u_t016_012/m2_871_2081# VSUBS detronyx_12t_2w2r_rc4_4x4_routed_5layer_direct
Xu_t031_004 u_t031_004/c0_w0_bl u_t031_004/c0_w0_br u_t031_004/c0_w1_bl u_t031_004/c0_w1_br
+ u_t031_004/c0_r0_rbl u_t031_004/c0_r1_rbl u_t031_004/c1_w0_bl u_t031_004/c1_w0_br
+ u_t031_004/c1_w1_bl u_t031_004/c1_w1_br u_t031_004/c1_r0_rbl u_t031_004/c1_r1_rbl
+ u_t031_004/c2_w0_bl u_t031_004/c2_w0_br u_t031_004/c2_w1_bl u_t031_004/c2_w1_br
+ u_t031_004/c2_r0_rbl u_t031_004/c2_r1_rbl u_t031_004/c3_w0_bl u_t031_004/c3_w0_br
+ u_t031_004/c3_w1_bl u_t031_004/c3_w1_br u_t031_004/c3_r0_rbl u_t031_004/c3_r1_rbl
+ u_t031_004/r0_w0_wl u_t031_004/r0_w1_wl u_t031_004/r0_r0_rwl u_t031_004/r0_r1_rwl
+ u_t031_004/r1_w0_wl u_t031_004/r1_w1_wl u_t031_004/r1_r0_rwl u_t031_004/r1_r1_rwl
+ u_t031_004/r2_w0_wl u_t031_004/r2_w1_wl u_t031_004/r2_r0_rwl u_t031_004/r2_r1_rwl
+ u_t031_004/r3_w0_wl u_t031_004/r3_w1_wl u_t031_004/r3_r0_rwl u_t031_004/r3_r1_rwl
+ VSS VSS u_t031_004/m2_717_1265# u_t031_004/m2_603_2031# u_t031_004/m2_1290_336#
+ u_t031_004/m2_2000_2037# u_t031_004/m2_791_2909# u_t031_004/m2_7_2126# u_t031_004/m2_2154_2081#
+ u_t031_004/m2_1795_2037# u_t031_004/m2_871_303# u_t031_004/m2_431_438# u_t031_004/m2_1290_2898#
+ u_t031_004/m2_1714_1210# u_t031_004/m2_431_1982# u_t031_004/m2_512_1265# u_t031_004/m2_2573_2126#
+ u_t031_004/m2_603_1259# u_t031_004/m2_2074_2909# u_t031_004/m2_7_336# u_t031_004/m2_717_2037#
+ u_t031_004/m2_1886_2031# u_t031_004/m2_2573_336# u_t031_004/m2_7_2898# u_t031_004/m2_2000_1265#
+ u_t031_004/m2_512_2037# u_t031_004/m2_1795_1265# u_t031_004/m2_1714_1982# u_t031_004/m2_1886_1259#
+ u_t031_004/m2_1290_2126# u_t031_004/m2_1714_438# u_t031_004/m2_431_1210# u_t031_004/m2_2573_2898#
+ u_t031_004/m2_2154_303# u_t031_004/m2_871_2081# VSUBS detronyx_12t_2w2r_rc4_4x4_routed_5layer_direct
Xu_t016_001 u_t016_001/c0_w0_bl u_t016_001/c0_w0_br u_t016_001/c0_w1_bl u_t016_001/c0_w1_br
+ u_t016_001/c0_r0_rbl u_t016_001/c0_r1_rbl u_t016_001/c1_w0_bl u_t016_001/c1_w0_br
+ u_t016_001/c1_w1_bl u_t016_001/c1_w1_br u_t016_001/c1_r0_rbl u_t016_001/c1_r1_rbl
+ u_t016_001/c2_w0_bl u_t016_001/c2_w0_br u_t016_001/c2_w1_bl u_t016_001/c2_w1_br
+ u_t016_001/c2_r0_rbl u_t016_001/c2_r1_rbl u_t016_001/c3_w0_bl u_t016_001/c3_w0_br
+ u_t016_001/c3_w1_bl u_t016_001/c3_w1_br u_t016_001/c3_r0_rbl u_t016_001/c3_r1_rbl
+ u_t016_001/r0_w0_wl u_t016_001/r0_w1_wl u_t016_001/r0_r0_rwl u_t016_001/r0_r1_rwl
+ u_t016_001/r1_w0_wl u_t016_001/r1_w1_wl u_t016_001/r1_r0_rwl u_t016_001/r1_r1_rwl
+ u_t016_001/r2_w0_wl u_t016_001/r2_w1_wl u_t016_001/r2_r0_rwl u_t016_001/r2_r1_rwl
+ u_t016_001/r3_w0_wl u_t016_001/r3_w1_wl u_t016_001/r3_r0_rwl u_t016_001/r3_r1_rwl
+ VSS VSS u_t016_001/m2_717_1265# u_t016_001/m2_603_2031# u_t016_001/m2_1290_336#
+ u_t016_001/m2_2000_2037# u_t016_001/m2_791_2909# u_t016_001/m2_7_2126# u_t016_001/m2_2154_2081#
+ u_t016_001/m2_1795_2037# u_t016_001/m2_871_303# u_t016_001/m2_431_438# u_t016_001/m2_1290_2898#
+ u_t016_001/m2_1714_1210# u_t016_001/m2_431_1982# u_t016_001/m2_512_1265# u_t016_001/m2_2573_2126#
+ u_t016_001/m2_603_1259# u_t016_001/m2_2074_2909# u_t016_001/m2_7_336# u_t016_001/m2_717_2037#
+ u_t016_001/m2_1886_2031# u_t016_001/m2_2573_336# u_t016_001/m2_7_2898# u_t016_001/m2_2000_1265#
+ u_t016_001/m2_512_2037# u_t016_001/m2_1795_1265# u_t016_001/m2_1714_1982# u_t016_001/m2_1886_1259#
+ u_t016_001/m2_1290_2126# u_t016_001/m2_1714_438# u_t016_001/m2_431_1210# u_t016_001/m2_2573_2898#
+ u_t016_001/m2_2154_303# u_t016_001/m2_871_2081# VSUBS detronyx_12t_2w2r_rc4_4x4_routed_5layer_direct
Xgf180mcu_as_sc_mcu7t3v3__inv_2_638 VSS VSS VSS gf180mcu_as_sc_mcu7t3v3__inv_2_638/A
+ gf180mcu_as_sc_mcu7t3v3__inv_2_638/VNW VSUBS gf180mcu_as_sc_mcu7t3v3__inv_2
Xgf180mcu_as_sc_mcu7t3v3__inv_2_605 VSS VSS gf180mcu_as_sc_mcu7t3v3__inv_2_605/Y gf180mcu_as_sc_mcu7t3v3__inv_2_606/Y
+ gf180mcu_as_sc_mcu7t3v3__inv_2_606/VNW VSUBS gf180mcu_as_sc_mcu7t3v3__inv_2
Xgf180mcu_as_sc_mcu7t3v3__inv_2_627 VSS VSS gf180mcu_as_sc_mcu7t3v3__inv_2_627/Y gf180mcu_as_sc_mcu7t3v3__inv_2_628/Y
+ gf180mcu_as_sc_mcu7t3v3__inv_2_628/VNW VSUBS gf180mcu_as_sc_mcu7t3v3__inv_2
Xgf180mcu_as_sc_mcu7t3v3__inv_2_616 VSS VSS gf180mcu_as_sc_mcu7t3v3__inv_2_616/Y gf180mcu_as_sc_mcu7t3v3__inv_2_616/A
+ gf180mcu_as_sc_mcu7t3v3__inv_2_616/VNW VSUBS gf180mcu_as_sc_mcu7t3v3__inv_2
Xgf180mcu_as_sc_mcu7t3v3__inv_2_649 VSS VSS gf180mcu_as_sc_mcu7t3v3__inv_2_649/Y gf180mcu_as_sc_mcu7t3v3__inv_2_650/Y
+ gf180mcu_as_sc_mcu7t3v3__inv_2_650/VNW VSUBS gf180mcu_as_sc_mcu7t3v3__inv_2
Xu_t007_012 u_t007_012/c0_w0_bl u_t007_012/c0_w0_br u_t007_012/c0_w1_bl u_t007_012/c0_w1_br
+ u_t007_012/c0_r0_rbl u_t007_012/c0_r1_rbl u_t007_012/c1_w0_bl u_t007_012/c1_w0_br
+ u_t007_012/c1_w1_bl u_t007_012/c1_w1_br u_t007_012/c1_r0_rbl u_t007_012/c1_r1_rbl
+ u_t007_012/c2_w0_bl u_t007_012/c2_w0_br u_t007_012/c2_w1_bl u_t007_012/c2_w1_br
+ u_t007_012/c2_r0_rbl u_t007_012/c2_r1_rbl u_t007_012/c3_w0_bl u_t007_012/c3_w0_br
+ u_t007_012/c3_w1_bl u_t007_012/c3_w1_br u_t007_012/c3_r0_rbl u_t007_012/c3_r1_rbl
+ u_t007_012/r0_w0_wl u_t007_012/r0_w1_wl u_t007_012/r0_r0_rwl u_t007_012/r0_r1_rwl
+ u_t007_012/r1_w0_wl u_t007_012/r1_w1_wl u_t007_012/r1_r0_rwl u_t007_012/r1_r1_rwl
+ u_t007_012/r2_w0_wl u_t007_012/r2_w1_wl u_t007_012/r2_r0_rwl u_t007_012/r2_r1_rwl
+ u_t007_012/r3_w0_wl u_t007_012/r3_w1_wl u_t007_012/r3_r0_rwl u_t007_012/r3_r1_rwl
+ VSS VSS u_t007_012/m2_717_1265# u_t007_012/m2_603_2031# u_t007_012/m2_1290_336#
+ u_t007_012/m2_2000_2037# u_t007_012/m2_791_2909# u_t007_012/m2_7_2126# u_t007_012/m2_2154_2081#
+ u_t007_012/m2_1795_2037# u_t007_012/m2_871_303# u_t007_012/m2_431_438# u_t007_012/m2_1290_2898#
+ u_t007_012/m2_1714_1210# u_t007_012/m2_431_1982# u_t007_012/m2_512_1265# u_t007_012/m2_2573_2126#
+ u_t007_012/m2_603_1259# u_t007_012/m2_2074_2909# u_t007_012/m2_7_336# u_t007_012/m2_717_2037#
+ u_t007_012/m2_1886_2031# u_t007_012/m2_2573_336# u_t007_012/m2_7_2898# u_t007_012/m2_2000_1265#
+ u_t007_012/m2_512_2037# u_t007_012/m2_1795_1265# u_t007_012/m2_1714_1982# u_t007_012/m2_1886_1259#
+ u_t007_012/m2_1290_2126# u_t007_012/m2_1714_438# u_t007_012/m2_431_1210# u_t007_012/m2_2573_2898#
+ u_t007_012/m2_2154_303# u_t007_012/m2_871_2081# VSUBS detronyx_12t_2w2r_rc4_4x4_routed_5layer_direct
Xu_t007_001 u_t007_001/c0_w0_bl u_t007_001/c0_w0_br u_t007_001/c0_w1_bl u_t007_001/c0_w1_br
+ u_t007_001/c0_r0_rbl u_t007_001/c0_r1_rbl u_t007_001/c1_w0_bl u_t007_001/c1_w0_br
+ u_t007_001/c1_w1_bl u_t007_001/c1_w1_br u_t007_001/c1_r0_rbl u_t007_001/c1_r1_rbl
+ u_t007_001/c2_w0_bl u_t007_001/c2_w0_br u_t007_001/c2_w1_bl u_t007_001/c2_w1_br
+ u_t007_001/c2_r0_rbl u_t007_001/c2_r1_rbl u_t007_001/c3_w0_bl u_t007_001/c3_w0_br
+ u_t007_001/c3_w1_bl u_t007_001/c3_w1_br u_t007_001/c3_r0_rbl u_t007_001/c3_r1_rbl
+ u_t007_001/r0_w0_wl u_t007_001/r0_w1_wl u_t007_001/r0_r0_rwl u_t007_001/r0_r1_rwl
+ u_t007_001/r1_w0_wl u_t007_001/r1_w1_wl u_t007_001/r1_r0_rwl u_t007_001/r1_r1_rwl
+ u_t007_001/r2_w0_wl u_t007_001/r2_w1_wl u_t007_001/r2_r0_rwl u_t007_001/r2_r1_rwl
+ u_t007_001/r3_w0_wl u_t007_001/r3_w1_wl u_t007_001/r3_r0_rwl u_t007_001/r3_r1_rwl
+ VSS VSS u_t007_001/m2_717_1265# u_t007_001/m2_603_2031# u_t007_001/m2_1290_336#
+ u_t007_001/m2_2000_2037# u_t007_001/m2_791_2909# u_t007_001/m2_7_2126# u_t007_001/m2_2154_2081#
+ u_t007_001/m2_1795_2037# u_t007_001/m2_871_303# u_t007_001/m2_431_438# u_t007_001/m2_1290_2898#
+ u_t007_001/m2_1714_1210# u_t007_001/m2_431_1982# u_t007_001/m2_512_1265# u_t007_001/m2_2573_2126#
+ u_t007_001/m2_603_1259# u_t007_001/m2_2074_2909# u_t007_001/m2_7_336# u_t007_001/m2_717_2037#
+ u_t007_001/m2_1886_2031# u_t007_001/m2_2573_336# u_t007_001/m2_7_2898# u_t007_001/m2_2000_1265#
+ u_t007_001/m2_512_2037# u_t007_001/m2_1795_1265# u_t007_001/m2_1714_1982# u_t007_001/m2_1886_1259#
+ u_t007_001/m2_1290_2126# u_t007_001/m2_1714_438# u_t007_001/m2_431_1210# u_t007_001/m2_2573_2898#
+ u_t007_001/m2_2154_303# u_t007_001/m2_871_2081# VSUBS detronyx_12t_2w2r_rc4_4x4_routed_5layer_direct
Xu_t022_015 u_t022_015/c0_w0_bl u_t022_015/c0_w0_br u_t022_015/c0_w1_bl u_t022_015/c0_w1_br
+ u_t022_015/c0_r0_rbl u_t022_015/c0_r1_rbl u_t022_015/c1_w0_bl u_t022_015/c1_w0_br
+ u_t022_015/c1_w1_bl u_t022_015/c1_w1_br u_t022_015/c1_r0_rbl u_t022_015/c1_r1_rbl
+ u_t022_015/c2_w0_bl u_t022_015/c2_w0_br u_t022_015/c2_w1_bl u_t022_015/c2_w1_br
+ u_t022_015/c2_r0_rbl u_t022_015/c2_r1_rbl u_t022_015/c3_w0_bl u_t022_015/c3_w0_br
+ u_t022_015/c3_w1_bl u_t022_015/c3_w1_br u_t022_015/c3_r0_rbl u_t022_015/c3_r1_rbl
+ u_t022_015/r0_w0_wl u_t022_015/r0_w1_wl u_t022_015/r0_r0_rwl u_t022_015/r0_r1_rwl
+ u_t022_015/r1_w0_wl u_t022_015/r1_w1_wl u_t022_015/r1_r0_rwl u_t022_015/r1_r1_rwl
+ u_t022_015/r2_w0_wl u_t022_015/r2_w1_wl u_t022_015/r2_r0_rwl u_t022_015/r2_r1_rwl
+ u_t022_015/r3_w0_wl u_t022_015/r3_w1_wl u_t022_015/r3_r0_rwl u_t022_015/r3_r1_rwl
+ VSS VSS u_t022_015/m2_717_1265# u_t022_015/m2_603_2031# u_t022_015/m2_1290_336#
+ u_t022_015/m2_2000_2037# u_t022_015/m2_791_2909# u_t022_015/m2_7_2126# u_t022_015/m2_2154_2081#
+ u_t022_015/m2_1795_2037# u_t022_015/m2_871_303# u_t022_015/m2_431_438# u_t022_015/m2_1290_2898#
+ u_t022_015/m2_1714_1210# u_t022_015/m2_431_1982# u_t022_015/m2_512_1265# u_t022_015/m2_2573_2126#
+ u_t022_015/m2_603_1259# u_t022_015/m2_2074_2909# u_t022_015/m2_7_336# u_t022_015/m2_717_2037#
+ u_t022_015/m2_1886_2031# u_t022_015/m2_2573_336# u_t022_015/m2_7_2898# u_t022_015/m2_2000_1265#
+ u_t022_015/m2_512_2037# u_t022_015/m2_1795_1265# u_t022_015/m2_1714_1982# u_t022_015/m2_1886_1259#
+ u_t022_015/m2_1290_2126# u_t022_015/m2_1714_438# u_t022_015/m2_431_1210# u_t022_015/m2_2573_2898#
+ u_t022_015/m2_2154_303# u_t022_015/m2_871_2081# VSUBS detronyx_12t_2w2r_rc4_4x4_routed_5layer_direct
Xu_t022_004 u_t022_004/c0_w0_bl u_t022_004/c0_w0_br u_t022_004/c0_w1_bl u_t022_004/c0_w1_br
+ u_t022_004/c0_r0_rbl u_t022_004/c0_r1_rbl u_t022_004/c1_w0_bl u_t022_004/c1_w0_br
+ u_t022_004/c1_w1_bl u_t022_004/c1_w1_br u_t022_004/c1_r0_rbl u_t022_004/c1_r1_rbl
+ u_t022_004/c2_w0_bl u_t022_004/c2_w0_br u_t022_004/c2_w1_bl u_t022_004/c2_w1_br
+ u_t022_004/c2_r0_rbl u_t022_004/c2_r1_rbl u_t022_004/c3_w0_bl u_t022_004/c3_w0_br
+ u_t022_004/c3_w1_bl u_t022_004/c3_w1_br u_t022_004/c3_r0_rbl u_t022_004/c3_r1_rbl
+ u_t022_004/r0_w0_wl u_t022_004/r0_w1_wl u_t022_004/r0_r0_rwl u_t022_004/r0_r1_rwl
+ u_t022_004/r1_w0_wl u_t022_004/r1_w1_wl u_t022_004/r1_r0_rwl u_t022_004/r1_r1_rwl
+ u_t022_004/r2_w0_wl u_t022_004/r2_w1_wl u_t022_004/r2_r0_rwl u_t022_004/r2_r1_rwl
+ u_t022_004/r3_w0_wl u_t022_004/r3_w1_wl u_t022_004/r3_r0_rwl u_t022_004/r3_r1_rwl
+ VSS VSS u_t022_004/m2_717_1265# u_t022_004/m2_603_2031# u_t022_004/m2_1290_336#
+ u_t022_004/m2_2000_2037# u_t022_004/m2_791_2909# u_t022_004/m2_7_2126# u_t022_004/m2_2154_2081#
+ u_t022_004/m2_1795_2037# u_t022_004/m2_871_303# u_t022_004/m2_431_438# u_t022_004/m2_1290_2898#
+ u_t022_004/m2_1714_1210# u_t022_004/m2_431_1982# u_t022_004/m2_512_1265# u_t022_004/m2_2573_2126#
+ u_t022_004/m2_603_1259# u_t022_004/m2_2074_2909# u_t022_004/m2_7_336# u_t022_004/m2_717_2037#
+ u_t022_004/m2_1886_2031# u_t022_004/m2_2573_336# u_t022_004/m2_7_2898# u_t022_004/m2_2000_1265#
+ u_t022_004/m2_512_2037# u_t022_004/m2_1795_1265# u_t022_004/m2_1714_1982# u_t022_004/m2_1886_1259#
+ u_t022_004/m2_1290_2126# u_t022_004/m2_1714_438# u_t022_004/m2_431_1210# u_t022_004/m2_2573_2898#
+ u_t022_004/m2_2154_303# u_t022_004/m2_871_2081# VSUBS detronyx_12t_2w2r_rc4_4x4_routed_5layer_direct
Xgf180mcu_as_sc_mcu7t3v3__nand4_2_471 VSS VSS VSS VSS VSS VSS gf180mcu_as_sc_mcu7t3v3__inv_2_1390/A
+ gf180mcu_as_sc_mcu7t3v3__inv_2_1390/VNW VSUBS gf180mcu_as_sc_mcu7t3v3__nand4_2
Xgf180mcu_as_sc_mcu7t3v3__nand4_2_460 VSS VSS VSS VSS VSS VSS gf180mcu_as_sc_mcu7t3v3__inv_2_1349/A
+ gf180mcu_as_sc_mcu7t3v3__inv_2_1349/VNW VSUBS gf180mcu_as_sc_mcu7t3v3__nand4_2
Xu_t013_015 u_t013_015/c0_w0_bl u_t013_015/c0_w0_br u_t013_015/c0_w1_bl u_t013_015/c0_w1_br
+ u_t013_015/c0_r0_rbl u_t013_015/c0_r1_rbl u_t013_015/c1_w0_bl u_t013_015/c1_w0_br
+ u_t013_015/c1_w1_bl u_t013_015/c1_w1_br u_t013_015/c1_r0_rbl u_t013_015/c1_r1_rbl
+ u_t013_015/c2_w0_bl u_t013_015/c2_w0_br u_t013_015/c2_w1_bl u_t013_015/c2_w1_br
+ u_t013_015/c2_r0_rbl u_t013_015/c2_r1_rbl u_t013_015/c3_w0_bl u_t013_015/c3_w0_br
+ u_t013_015/c3_w1_bl u_t013_015/c3_w1_br u_t013_015/c3_r0_rbl u_t013_015/c3_r1_rbl
+ u_t013_015/r0_w0_wl u_t013_015/r0_w1_wl u_t013_015/r0_r0_rwl u_t013_015/r0_r1_rwl
+ u_t013_015/r1_w0_wl u_t013_015/r1_w1_wl u_t013_015/r1_r0_rwl u_t013_015/r1_r1_rwl
+ u_t013_015/r2_w0_wl u_t013_015/r2_w1_wl u_t013_015/r2_r0_rwl u_t013_015/r2_r1_rwl
+ u_t013_015/r3_w0_wl u_t013_015/r3_w1_wl u_t013_015/r3_r0_rwl u_t013_015/r3_r1_rwl
+ VSS VSS u_t013_015/m2_717_1265# u_t013_015/m2_603_2031# u_t013_015/m2_1290_336#
+ u_t013_015/m2_2000_2037# u_t013_015/m2_791_2909# u_t013_015/m2_7_2126# u_t013_015/m2_2154_2081#
+ u_t013_015/m2_1795_2037# u_t013_015/m2_871_303# u_t013_015/m2_431_438# u_t013_015/m2_1290_2898#
+ u_t013_015/m2_1714_1210# u_t013_015/m2_431_1982# u_t013_015/m2_512_1265# u_t013_015/m2_2573_2126#
+ u_t013_015/m2_603_1259# u_t013_015/m2_2074_2909# u_t013_015/m2_7_336# u_t013_015/m2_717_2037#
+ u_t013_015/m2_1886_2031# u_t013_015/m2_2573_336# u_t013_015/m2_7_2898# u_t013_015/m2_2000_1265#
+ u_t013_015/m2_512_2037# u_t013_015/m2_1795_1265# u_t013_015/m2_1714_1982# u_t013_015/m2_1886_1259#
+ u_t013_015/m2_1290_2126# u_t013_015/m2_1714_438# u_t013_015/m2_431_1210# u_t013_015/m2_2573_2898#
+ u_t013_015/m2_2154_303# u_t013_015/m2_871_2081# VSUBS detronyx_12t_2w2r_rc4_4x4_routed_5layer_direct
Xu_t013_004 u_t013_004/c0_w0_bl u_t013_004/c0_w0_br u_t013_004/c0_w1_bl u_t013_004/c0_w1_br
+ u_t013_004/c0_r0_rbl u_t013_004/c0_r1_rbl u_t013_004/c1_w0_bl u_t013_004/c1_w0_br
+ u_t013_004/c1_w1_bl u_t013_004/c1_w1_br u_t013_004/c1_r0_rbl u_t013_004/c1_r1_rbl
+ u_t013_004/c2_w0_bl u_t013_004/c2_w0_br u_t013_004/c2_w1_bl u_t013_004/c2_w1_br
+ u_t013_004/c2_r0_rbl u_t013_004/c2_r1_rbl u_t013_004/c3_w0_bl u_t013_004/c3_w0_br
+ u_t013_004/c3_w1_bl u_t013_004/c3_w1_br u_t013_004/c3_r0_rbl u_t013_004/c3_r1_rbl
+ u_t013_004/r0_w0_wl u_t013_004/r0_w1_wl u_t013_004/r0_r0_rwl u_t013_004/r0_r1_rwl
+ u_t013_004/r1_w0_wl u_t013_004/r1_w1_wl u_t013_004/r1_r0_rwl u_t013_004/r1_r1_rwl
+ u_t013_004/r2_w0_wl u_t013_004/r2_w1_wl u_t013_004/r2_r0_rwl u_t013_004/r2_r1_rwl
+ u_t013_004/r3_w0_wl u_t013_004/r3_w1_wl u_t013_004/r3_r0_rwl u_t013_004/r3_r1_rwl
+ VSS VSS u_t013_004/m2_717_1265# u_t013_004/m2_603_2031# u_t013_004/m2_1290_336#
+ u_t013_004/m2_2000_2037# u_t013_004/m2_791_2909# u_t013_004/m2_7_2126# u_t013_004/m2_2154_2081#
+ u_t013_004/m2_1795_2037# u_t013_004/m2_871_303# u_t013_004/m2_431_438# u_t013_004/m2_1290_2898#
+ u_t013_004/m2_1714_1210# u_t013_004/m2_431_1982# u_t013_004/m2_512_1265# u_t013_004/m2_2573_2126#
+ u_t013_004/m2_603_1259# u_t013_004/m2_2074_2909# u_t013_004/m2_7_336# u_t013_004/m2_717_2037#
+ u_t013_004/m2_1886_2031# u_t013_004/m2_2573_336# u_t013_004/m2_7_2898# u_t013_004/m2_2000_1265#
+ u_t013_004/m2_512_2037# u_t013_004/m2_1795_1265# u_t013_004/m2_1714_1982# u_t013_004/m2_1886_1259#
+ u_t013_004/m2_1290_2126# u_t013_004/m2_1714_438# u_t013_004/m2_431_1210# u_t013_004/m2_2573_2898#
+ u_t013_004/m2_2154_303# u_t013_004/m2_871_2081# VSUBS detronyx_12t_2w2r_rc4_4x4_routed_5layer_direct
Xgf180mcu_as_sc_mcu7t3v3__nand4_2_482 VSS VSS VSS VSS VSS VSS gf180mcu_as_sc_mcu7t3v3__inv_2_1652/A
+ gf180mcu_as_sc_mcu7t3v3__inv_2_1652/VNW VSUBS gf180mcu_as_sc_mcu7t3v3__nand4_2
Xgf180mcu_as_sc_mcu7t3v3__nand4_2_493 VSS VSS VSS VSS VSS VSS gf180mcu_as_sc_mcu7t3v3__inv_2_1610/A
+ gf180mcu_as_sc_mcu7t3v3__inv_2_1610/VNW VSUBS gf180mcu_as_sc_mcu7t3v3__nand4_2
Xgf180mcu_as_sc_mcu7t3v3__inv_2_402 gf180mcu_as_sc_mcu7t3v3__nor2_2_6/VDD gf180mcu_as_sc_mcu7t3v3__nand3_2_4/VSS
+ VSS VSS gf180mcu_as_sc_mcu7t3v3__nor2_2_6/VNW VSUBS gf180mcu_as_sc_mcu7t3v3__inv_2
Xu_t004_015 u_t004_015/c0_w0_bl u_t004_015/c0_w0_br u_t004_015/c0_w1_bl u_t004_015/c0_w1_br
+ u_t004_015/c0_r0_rbl u_t004_015/c0_r1_rbl u_t004_015/c1_w0_bl u_t004_015/c1_w0_br
+ u_t004_015/c1_w1_bl u_t004_015/c1_w1_br u_t004_015/c1_r0_rbl u_t004_015/c1_r1_rbl
+ u_t004_015/c2_w0_bl u_t004_015/c2_w0_br u_t004_015/c2_w1_bl u_t004_015/c2_w1_br
+ u_t004_015/c2_r0_rbl u_t004_015/c2_r1_rbl u_t004_015/c3_w0_bl u_t004_015/c3_w0_br
+ u_t004_015/c3_w1_bl u_t004_015/c3_w1_br u_t004_015/c3_r0_rbl u_t004_015/c3_r1_rbl
+ u_t004_015/r0_w0_wl u_t004_015/r0_w1_wl u_t004_015/r0_r0_rwl u_t004_015/r0_r1_rwl
+ u_t004_015/r1_w0_wl u_t004_015/r1_w1_wl u_t004_015/r1_r0_rwl u_t004_015/r1_r1_rwl
+ u_t004_015/r2_w0_wl u_t004_015/r2_w1_wl u_t004_015/r2_r0_rwl u_t004_015/r2_r1_rwl
+ u_t004_015/r3_w0_wl u_t004_015/r3_w1_wl u_t004_015/r3_r0_rwl u_t004_015/r3_r1_rwl
+ VSS VSS u_t004_015/m2_717_1265# u_t004_015/m2_603_2031# u_t004_015/m2_1290_336#
+ u_t004_015/m2_2000_2037# u_t004_015/m2_791_2909# u_t004_015/m2_7_2126# u_t004_015/m2_2154_2081#
+ u_t004_015/m2_1795_2037# u_t004_015/m2_871_303# u_t004_015/m2_431_438# u_t004_015/m2_1290_2898#
+ u_t004_015/m2_1714_1210# u_t004_015/m2_431_1982# u_t004_015/m2_512_1265# u_t004_015/m2_2573_2126#
+ u_t004_015/m2_603_1259# u_t004_015/m2_2074_2909# u_t004_015/m2_7_336# u_t004_015/m2_717_2037#
+ u_t004_015/m2_1886_2031# u_t004_015/m2_2573_336# u_t004_015/m2_7_2898# u_t004_015/m2_2000_1265#
+ u_t004_015/m2_512_2037# u_t004_015/m2_1795_1265# u_t004_015/m2_1714_1982# u_t004_015/m2_1886_1259#
+ u_t004_015/m2_1290_2126# u_t004_015/m2_1714_438# u_t004_015/m2_431_1210# u_t004_015/m2_2573_2898#
+ u_t004_015/m2_2154_303# u_t004_015/m2_871_2081# VSUBS detronyx_12t_2w2r_rc4_4x4_routed_5layer_direct
Xu_t004_004 u_t004_004/c0_w0_bl u_t004_004/c0_w0_br u_t004_004/c0_w1_bl u_t004_004/c0_w1_br
+ u_t004_004/c0_r0_rbl u_t004_004/c0_r1_rbl u_t004_004/c1_w0_bl u_t004_004/c1_w0_br
+ u_t004_004/c1_w1_bl u_t004_004/c1_w1_br u_t004_004/c1_r0_rbl u_t004_004/c1_r1_rbl
+ u_t004_004/c2_w0_bl u_t004_004/c2_w0_br u_t004_004/c2_w1_bl u_t004_004/c2_w1_br
+ u_t004_004/c2_r0_rbl u_t004_004/c2_r1_rbl u_t004_004/c3_w0_bl u_t004_004/c3_w0_br
+ u_t004_004/c3_w1_bl u_t004_004/c3_w1_br u_t004_004/c3_r0_rbl u_t004_004/c3_r1_rbl
+ u_t004_004/r0_w0_wl u_t004_004/r0_w1_wl u_t004_004/r0_r0_rwl u_t004_004/r0_r1_rwl
+ u_t004_004/r1_w0_wl u_t004_004/r1_w1_wl u_t004_004/r1_r0_rwl u_t004_004/r1_r1_rwl
+ u_t004_004/r2_w0_wl u_t004_004/r2_w1_wl u_t004_004/r2_r0_rwl u_t004_004/r2_r1_rwl
+ u_t004_004/r3_w0_wl u_t004_004/r3_w1_wl u_t004_004/r3_r0_rwl u_t004_004/r3_r1_rwl
+ VSS VSS u_t004_004/m2_717_1265# u_t004_004/m2_603_2031# u_t004_004/m2_1290_336#
+ u_t004_004/m2_2000_2037# u_t004_004/m2_791_2909# u_t004_004/m2_7_2126# u_t004_004/m2_2154_2081#
+ u_t004_004/m2_1795_2037# u_t004_004/m2_871_303# u_t004_004/m2_431_438# u_t004_004/m2_1290_2898#
+ u_t004_004/m2_1714_1210# u_t004_004/m2_431_1982# u_t004_004/m2_512_1265# u_t004_004/m2_2573_2126#
+ u_t004_004/m2_603_1259# u_t004_004/m2_2074_2909# u_t004_004/m2_7_336# u_t004_004/m2_717_2037#
+ u_t004_004/m2_1886_2031# u_t004_004/m2_2573_336# u_t004_004/m2_7_2898# u_t004_004/m2_2000_1265#
+ u_t004_004/m2_512_2037# u_t004_004/m2_1795_1265# u_t004_004/m2_1714_1982# u_t004_004/m2_1886_1259#
+ u_t004_004/m2_1290_2126# u_t004_004/m2_1714_438# u_t004_004/m2_431_1210# u_t004_004/m2_2573_2898#
+ u_t004_004/m2_2154_303# u_t004_004/m2_871_2081# VSUBS detronyx_12t_2w2r_rc4_4x4_routed_5layer_direct
Xgf180mcu_as_sc_mcu7t3v3__inv_2_413 gf180mcu_as_sc_mcu7t3v3__nor2_2_7/VDD gf180mcu_as_sc_mcu7t3v3__nand3_2_4/VSS
+ VSS VSS gf180mcu_as_sc_mcu7t3v3__nor2_2_7/VNW VSUBS gf180mcu_as_sc_mcu7t3v3__inv_2
Xgf180mcu_as_sc_mcu7t3v3__inv_2_424 gf180mcu_as_sc_mcu7t3v3__nor2_2_6/VDD gf180mcu_as_sc_mcu7t3v3__nor2_2_6/VSS
+ gf180mcu_as_sc_mcu7t3v3__inv_2_424/Y VSS gf180mcu_as_sc_mcu7t3v3__nor2_2_6/VNW VSUBS
+ gf180mcu_as_sc_mcu7t3v3__inv_2
Xgf180mcu_as_sc_mcu7t3v3__inv_2_479 gf180mcu_as_sc_mcu7t3v3__nor2_2_6/VDD gf180mcu_as_sc_mcu7t3v3__nor2_2_6/VSS
+ gf180mcu_as_sc_mcu7t3v3__inv_2_479/Y VSS gf180mcu_as_sc_mcu7t3v3__nor2_2_6/VNW VSUBS
+ gf180mcu_as_sc_mcu7t3v3__inv_2
Xgf180mcu_as_sc_mcu7t3v3__inv_2_457 gf180mcu_as_sc_mcu7t3v3__nor2_2_7/VDD gf180mcu_as_sc_mcu7t3v3__nand3_2_4/VSS
+ VSS VSS gf180mcu_as_sc_mcu7t3v3__nor2_2_7/VNW VSUBS gf180mcu_as_sc_mcu7t3v3__inv_2
Xgf180mcu_as_sc_mcu7t3v3__inv_2_446 gf180mcu_as_sc_mcu7t3v3__nor2_2_7/VDD gf180mcu_as_sc_mcu7t3v3__nand3_2_4/VSS
+ VSS VSS gf180mcu_as_sc_mcu7t3v3__nor2_2_7/VNW VSUBS gf180mcu_as_sc_mcu7t3v3__inv_2
Xgf180mcu_as_sc_mcu7t3v3__inv_2_435 gf180mcu_as_sc_mcu7t3v3__nor2_2_4/VDD gf180mcu_as_sc_mcu7t3v3__nand2_2_3/VSS
+ VSS VSS gf180mcu_as_sc_mcu7t3v3__nor2_2_4/VNW VSUBS gf180mcu_as_sc_mcu7t3v3__inv_2
Xgf180mcu_as_sc_mcu7t3v3__inv_2_468 gf180mcu_as_sc_mcu7t3v3__nand3_2_9/VDD gf180mcu_as_sc_mcu7t3v3__nor2_2_7/VSS
+ VSS VSS gf180mcu_as_sc_mcu7t3v3__nand3_2_9/VNW VSUBS gf180mcu_as_sc_mcu7t3v3__inv_2
Xu_t010_007 u_t010_007/c0_w0_bl u_t010_007/c0_w0_br u_t010_007/c0_w1_bl u_t010_007/c0_w1_br
+ u_t010_007/c0_r0_rbl u_t010_007/c0_r1_rbl u_t010_007/c1_w0_bl u_t010_007/c1_w0_br
+ u_t010_007/c1_w1_bl u_t010_007/c1_w1_br u_t010_007/c1_r0_rbl u_t010_007/c1_r1_rbl
+ u_t010_007/c2_w0_bl u_t010_007/c2_w0_br u_t010_007/c2_w1_bl u_t010_007/c2_w1_br
+ u_t010_007/c2_r0_rbl u_t010_007/c2_r1_rbl u_t010_007/c3_w0_bl u_t010_007/c3_w0_br
+ u_t010_007/c3_w1_bl u_t010_007/c3_w1_br u_t010_007/c3_r0_rbl u_t010_007/c3_r1_rbl
+ u_t010_007/r0_w0_wl u_t010_007/r0_w1_wl u_t010_007/r0_r0_rwl u_t010_007/r0_r1_rwl
+ u_t010_007/r1_w0_wl u_t010_007/r1_w1_wl u_t010_007/r1_r0_rwl u_t010_007/r1_r1_rwl
+ u_t010_007/r2_w0_wl u_t010_007/r2_w1_wl u_t010_007/r2_r0_rwl u_t010_007/r2_r1_rwl
+ u_t010_007/r3_w0_wl u_t010_007/r3_w1_wl u_t010_007/r3_r0_rwl u_t010_007/r3_r1_rwl
+ VSS VSS u_t010_007/m2_717_1265# u_t010_007/m2_603_2031# u_t010_007/m2_1290_336#
+ u_t010_007/m2_2000_2037# u_t010_007/m2_791_2909# u_t010_007/m2_7_2126# u_t010_007/m2_2154_2081#
+ u_t010_007/m2_1795_2037# u_t010_007/m2_871_303# u_t010_007/m2_431_438# u_t010_007/m2_1290_2898#
+ u_t010_007/m2_1714_1210# u_t010_007/m2_431_1982# u_t010_007/m2_512_1265# u_t010_007/m2_2573_2126#
+ u_t010_007/m2_603_1259# u_t010_007/m2_2074_2909# u_t010_007/m2_7_336# u_t010_007/m2_717_2037#
+ u_t010_007/m2_1886_2031# u_t010_007/m2_2573_336# u_t010_007/m2_7_2898# u_t010_007/m2_2000_1265#
+ u_t010_007/m2_512_2037# u_t010_007/m2_1795_1265# u_t010_007/m2_1714_1982# u_t010_007/m2_1886_1259#
+ u_t010_007/m2_1290_2126# u_t010_007/m2_1714_438# u_t010_007/m2_431_1210# u_t010_007/m2_2573_2898#
+ u_t010_007/m2_2154_303# u_t010_007/m2_871_2081# VSUBS detronyx_12t_2w2r_rc4_4x4_routed_5layer_direct
Xgf180mcu_as_sc_mcu7t3v3__inv_2_980 VSS VSS gf180mcu_as_sc_mcu7t3v3__inv_2_980/Y gf180mcu_as_sc_mcu7t3v3__inv_2_980/A
+ gf180mcu_as_sc_mcu7t3v3__inv_2_980/VNW VSUBS gf180mcu_as_sc_mcu7t3v3__inv_2
Xgf180mcu_as_sc_mcu7t3v3__inv_2_991 VSS VSS gf180mcu_as_sc_mcu7t3v3__inv_2_991/Y gf180mcu_as_sc_mcu7t3v3__inv_2_992/Y
+ gf180mcu_as_sc_mcu7t3v3__inv_2_992/VNW VSUBS gf180mcu_as_sc_mcu7t3v3__inv_2
Xgf180mcu_as_sc_mcu7t3v3__nand4_2_290 VSS VSS VSS VSS VSS VSS gf180mcu_as_sc_mcu7t3v3__inv_2_984/A
+ gf180mcu_as_sc_mcu7t3v3__inv_2_984/VNW VSUBS gf180mcu_as_sc_mcu7t3v3__nand4_2
Xu_t001_007 u_t001_007/c0_w0_bl u_t001_007/c0_w0_br u_t001_007/c0_w1_bl u_t001_007/c0_w1_br
+ u_t001_007/c0_r0_rbl u_t001_007/c0_r1_rbl u_t001_007/c1_w0_bl u_t001_007/c1_w0_br
+ u_t001_007/c1_w1_bl u_t001_007/c1_w1_br u_t001_007/c1_r0_rbl u_t001_007/c1_r1_rbl
+ u_t001_007/c2_w0_bl u_t001_007/c2_w0_br u_t001_007/c2_w1_bl u_t001_007/c2_w1_br
+ u_t001_007/c2_r0_rbl u_t001_007/c2_r1_rbl u_t001_007/c3_w0_bl u_t001_007/c3_w0_br
+ u_t001_007/c3_w1_bl u_t001_007/c3_w1_br u_t001_007/c3_r0_rbl u_t001_007/c3_r1_rbl
+ u_t001_007/r0_w0_wl u_t001_007/r0_w1_wl u_t001_007/r0_r0_rwl u_t001_007/r0_r1_rwl
+ u_t001_007/r1_w0_wl u_t001_007/r1_w1_wl u_t001_007/r1_r0_rwl u_t001_007/r1_r1_rwl
+ u_t001_007/r2_w0_wl u_t001_007/r2_w1_wl u_t001_007/r2_r0_rwl u_t001_007/r2_r1_rwl
+ u_t001_007/r3_w0_wl u_t001_007/r3_w1_wl u_t001_007/r3_r0_rwl u_t001_007/r3_r1_rwl
+ VSS VSS u_t001_007/m2_717_1265# u_t001_007/m2_603_2031# u_t001_007/m2_1290_336#
+ u_t001_007/m2_2000_2037# u_t001_007/m2_791_2909# u_t001_007/m2_7_2126# u_t001_007/m2_2154_2081#
+ u_t001_007/m2_1795_2037# u_t001_007/m2_871_303# u_t001_007/m2_431_438# u_t001_007/m2_1290_2898#
+ u_t001_007/m2_1714_1210# u_t001_007/m2_431_1982# u_t001_007/m2_512_1265# u_t001_007/m2_2573_2126#
+ u_t001_007/m2_603_1259# u_t001_007/m2_2074_2909# u_t001_007/m2_7_336# u_t001_007/m2_717_2037#
+ u_t001_007/m2_1886_2031# u_t001_007/m2_2573_336# u_t001_007/m2_7_2898# u_t001_007/m2_2000_1265#
+ u_t001_007/m2_512_2037# u_t001_007/m2_1795_1265# u_t001_007/m2_1714_1982# u_t001_007/m2_1886_1259#
+ u_t001_007/m2_1290_2126# u_t001_007/m2_1714_438# u_t001_007/m2_431_1210# u_t001_007/m2_2573_2898#
+ u_t001_007/m2_2154_303# u_t001_007/m2_871_2081# VSUBS detronyx_12t_2w2r_rc4_4x4_routed_5layer_direct
Xgf180mcu_as_sc_mcu7t3v3__inv_2_221 VSS VSS gf180mcu_as_sc_mcu7t3v3__inv_2_221/Y gf180mcu_as_sc_mcu7t3v3__inv_2_221/A
+ gf180mcu_as_sc_mcu7t3v3__inv_2_221/VNW VSUBS gf180mcu_as_sc_mcu7t3v3__inv_2
Xgf180mcu_as_sc_mcu7t3v3__inv_2_210 VSS VSS VSS gf180mcu_as_sc_mcu7t3v3__inv_2_211/Y
+ gf180mcu_as_sc_mcu7t3v3__inv_2_212/VNW VSUBS gf180mcu_as_sc_mcu7t3v3__inv_2
Xgf180mcu_as_sc_mcu7t3v3__inv_2_243 VSS VSS VSS gf180mcu_as_sc_mcu7t3v3__inv_2_244/Y
+ gf180mcu_as_sc_mcu7t3v3__inv_2_245/VNW VSUBS gf180mcu_as_sc_mcu7t3v3__inv_2
Xgf180mcu_as_sc_mcu7t3v3__inv_2_232 VSS VSS gf180mcu_as_sc_mcu7t3v3__inv_2_232/Y gf180mcu_as_sc_mcu7t3v3__inv_2_233/Y
+ gf180mcu_as_sc_mcu7t3v3__inv_2_233/VNW VSUBS gf180mcu_as_sc_mcu7t3v3__inv_2
Xgf180mcu_as_sc_mcu7t3v3__inv_2_1709 gf180mcu_as_sc_mcu7t3v3__nor2_2_7/VDD gf180mcu_as_sc_mcu7t3v3__nand3_2_4/VSS
+ VSS VSS gf180mcu_as_sc_mcu7t3v3__nor2_2_7/VNW VSUBS gf180mcu_as_sc_mcu7t3v3__inv_2
Xgf180mcu_as_sc_mcu7t3v3__inv_2_265 VSS VSS gf180mcu_as_sc_mcu7t3v3__inv_2_294/A gf180mcu_as_sc_mcu7t3v3__inv_2_265/A
+ gf180mcu_as_sc_mcu7t3v3__inv_2_308/VNW VSUBS gf180mcu_as_sc_mcu7t3v3__inv_2
Xgf180mcu_as_sc_mcu7t3v3__inv_2_287 VSS VSS gf180mcu_as_sc_mcu7t3v3__inv_2_287/Y gf180mcu_as_sc_mcu7t3v3__inv_2_287/A
+ gf180mcu_as_sc_mcu7t3v3__inv_2_287/VNW VSUBS gf180mcu_as_sc_mcu7t3v3__inv_2
Xgf180mcu_as_sc_mcu7t3v3__inv_2_298 VSS VSS gf180mcu_as_sc_mcu7t3v3__inv_2_298/Y gf180mcu_as_sc_mcu7t3v3__inv_2_298/A
+ gf180mcu_as_sc_mcu7t3v3__inv_2_298/VNW VSUBS gf180mcu_as_sc_mcu7t3v3__inv_2
Xgf180mcu_as_sc_mcu7t3v3__inv_2_276 VSS VSS VSS gf180mcu_as_sc_mcu7t3v3__inv_2_278/Y
+ gf180mcu_as_sc_mcu7t3v3__inv_2_279/VNW VSUBS gf180mcu_as_sc_mcu7t3v3__inv_2
Xgf180mcu_as_sc_mcu7t3v3__inv_2_254 VSS VSS gf180mcu_as_sc_mcu7t3v3__inv_2_254/Y gf180mcu_as_sc_mcu7t3v3__inv_2_254/A
+ gf180mcu_as_sc_mcu7t3v3__inv_2_254/VNW VSUBS gf180mcu_as_sc_mcu7t3v3__inv_2
Xgf180mcu_as_sc_mcu7t3v3__inv_2_1517 VSS VSS VSS gf180mcu_as_sc_mcu7t3v3__inv_2_1518/Y
+ gf180mcu_as_sc_mcu7t3v3__inv_2_1519/VNW VSUBS gf180mcu_as_sc_mcu7t3v3__inv_2
Xgf180mcu_as_sc_mcu7t3v3__inv_2_1528 VSS VSS gf180mcu_as_sc_mcu7t3v3__inv_2_1528/Y
+ gf180mcu_as_sc_mcu7t3v3__inv_2_1529/Y gf180mcu_as_sc_mcu7t3v3__inv_2_1529/VNW VSUBS
+ gf180mcu_as_sc_mcu7t3v3__inv_2
Xgf180mcu_as_sc_mcu7t3v3__inv_2_1539 VSS VSS VSS gf180mcu_as_sc_mcu7t3v3__inv_2_1540/Y
+ gf180mcu_as_sc_mcu7t3v3__inv_2_1541/VNW VSUBS gf180mcu_as_sc_mcu7t3v3__inv_2
Xgf180mcu_as_sc_mcu7t3v3__inv_2_1506 VSS VSS gf180mcu_as_sc_mcu7t3v3__inv_2_1506/Y
+ gf180mcu_as_sc_mcu7t3v3__inv_2_1506/A gf180mcu_as_sc_mcu7t3v3__inv_2_1506/VNW VSUBS
+ gf180mcu_as_sc_mcu7t3v3__inv_2
Xgf180mcu_as_sc_mcu7t3v3__nand2_2_5 gf180mcu_as_sc_mcu7t3v3__nor2_2_7/VDD gf180mcu_as_sc_mcu7t3v3__nand3_2_4/VSS
+ VSS VSS VSS gf180mcu_as_sc_mcu7t3v3__nor2_2_7/VNW VSUBS gf180mcu_as_sc_mcu7t3v3__nand2_2
Xgf180mcu_as_sc_mcu7t3v3__nor2_2_0 gf180mcu_as_sc_mcu7t3v3__nor2_2_4/VDD gf180mcu_as_sc_mcu7t3v3__nor2_2_4/VSS
+ VSS VSS VSS gf180mcu_as_sc_mcu7t3v3__nor2_2_4/VNW VSUBS gf180mcu_as_sc_mcu7t3v3__nor2_2
Xgf180mcu_as_sc_mcu7t3v3__inv_2_1369 VSS VSS gf180mcu_as_sc_mcu7t3v3__inv_2_1369/Y
+ gf180mcu_as_sc_mcu7t3v3__inv_2_1370/Y gf180mcu_as_sc_mcu7t3v3__inv_2_1370/VNW VSUBS
+ gf180mcu_as_sc_mcu7t3v3__inv_2
Xgf180mcu_as_sc_mcu7t3v3__inv_2_1303 VSS VSS gf180mcu_as_sc_mcu7t3v3__inv_2_1303/Y
+ gf180mcu_as_sc_mcu7t3v3__inv_2_1304/Y gf180mcu_as_sc_mcu7t3v3__inv_2_1304/VNW VSUBS
+ gf180mcu_as_sc_mcu7t3v3__inv_2
Xgf180mcu_as_sc_mcu7t3v3__inv_2_1358 VSS VSS gf180mcu_as_sc_mcu7t3v3__inv_2_1358/Y
+ gf180mcu_as_sc_mcu7t3v3__inv_2_1358/A gf180mcu_as_sc_mcu7t3v3__inv_2_1358/VNW VSUBS
+ gf180mcu_as_sc_mcu7t3v3__inv_2
Xgf180mcu_as_sc_mcu7t3v3__inv_2_1325 VSS VSS VSS gf180mcu_as_sc_mcu7t3v3__inv_2_1329/Y
+ gf180mcu_as_sc_mcu7t3v3__inv_2_1333/VNW VSUBS gf180mcu_as_sc_mcu7t3v3__inv_2
Xgf180mcu_as_sc_mcu7t3v3__inv_2_1314 VSS VSS VSS gf180mcu_as_sc_mcu7t3v3__inv_2_1315/Y
+ gf180mcu_as_sc_mcu7t3v3__inv_2_1316/VNW VSUBS gf180mcu_as_sc_mcu7t3v3__inv_2
Xgf180mcu_as_sc_mcu7t3v3__inv_2_1347 VSS VSS gf180mcu_as_sc_mcu7t3v3__inv_2_1347/Y
+ gf180mcu_as_sc_mcu7t3v3__inv_2_1348/Y gf180mcu_as_sc_mcu7t3v3__inv_2_1348/VNW VSUBS
+ gf180mcu_as_sc_mcu7t3v3__inv_2
Xgf180mcu_as_sc_mcu7t3v3__inv_2_1336 VSS VSS gf180mcu_as_sc_mcu7t3v3__inv_2_1336/Y
+ gf180mcu_as_sc_mcu7t3v3__inv_2_1336/A gf180mcu_as_sc_mcu7t3v3__inv_2_1336/VNW VSUBS
+ gf180mcu_as_sc_mcu7t3v3__inv_2
Xu_t028_010 u_t028_010/c0_w0_bl u_t028_010/c0_w0_br u_t028_010/c0_w1_bl u_t028_010/c0_w1_br
+ u_t028_010/c0_r0_rbl u_t028_010/c0_r1_rbl u_t028_010/c1_w0_bl u_t028_010/c1_w0_br
+ u_t028_010/c1_w1_bl u_t028_010/c1_w1_br u_t028_010/c1_r0_rbl u_t028_010/c1_r1_rbl
+ u_t028_010/c2_w0_bl u_t028_010/c2_w0_br u_t028_010/c2_w1_bl u_t028_010/c2_w1_br
+ u_t028_010/c2_r0_rbl u_t028_010/c2_r1_rbl u_t028_010/c3_w0_bl u_t028_010/c3_w0_br
+ u_t028_010/c3_w1_bl u_t028_010/c3_w1_br u_t028_010/c3_r0_rbl u_t028_010/c3_r1_rbl
+ u_t028_010/r0_w0_wl u_t028_010/r0_w1_wl u_t028_010/r0_r0_rwl u_t028_010/r0_r1_rwl
+ u_t028_010/r1_w0_wl u_t028_010/r1_w1_wl u_t028_010/r1_r0_rwl u_t028_010/r1_r1_rwl
+ u_t028_010/r2_w0_wl u_t028_010/r2_w1_wl u_t028_010/r2_r0_rwl u_t028_010/r2_r1_rwl
+ u_t028_010/r3_w0_wl u_t028_010/r3_w1_wl u_t028_010/r3_r0_rwl u_t028_010/r3_r1_rwl
+ VSS VSS u_t028_010/m2_717_1265# u_t028_010/m2_603_2031# u_t028_010/m2_1290_336#
+ u_t028_010/m2_2000_2037# u_t028_010/m2_791_2909# u_t028_010/m2_7_2126# u_t028_010/m2_2154_2081#
+ u_t028_010/m2_1795_2037# u_t028_010/m2_871_303# u_t028_010/m2_431_438# u_t028_010/m2_1290_2898#
+ u_t028_010/m2_1714_1210# u_t028_010/m2_431_1982# u_t028_010/m2_512_1265# u_t028_010/m2_2573_2126#
+ u_t028_010/m2_603_1259# u_t028_010/m2_2074_2909# u_t028_010/m2_7_336# u_t028_010/m2_717_2037#
+ u_t028_010/m2_1886_2031# u_t028_010/m2_2573_336# u_t028_010/m2_7_2898# u_t028_010/m2_2000_1265#
+ u_t028_010/m2_512_2037# u_t028_010/m2_1795_1265# u_t028_010/m2_1714_1982# u_t028_010/m2_1886_1259#
+ u_t028_010/m2_1290_2126# u_t028_010/m2_1714_438# u_t028_010/m2_431_1210# u_t028_010/m2_2573_2898#
+ u_t028_010/m2_2154_303# u_t028_010/m2_871_2081# VSUBS detronyx_12t_2w2r_rc4_4x4_routed_5layer_direct
Xgf180mcu_as_sc_mcu7t3v3__inv_2_809 VSS VSS gf180mcu_as_sc_mcu7t3v3__inv_2_809/Y gf180mcu_as_sc_mcu7t3v3__inv_2_809/A
+ gf180mcu_as_sc_mcu7t3v3__inv_2_839/VNW VSUBS gf180mcu_as_sc_mcu7t3v3__inv_2
Xgf180mcu_as_sc_mcu7t3v3__nand4_2_108 VSS VSS VSS VSS VSS VSS gf180mcu_as_sc_mcu7t3v3__inv_2_268/A
+ gf180mcu_as_sc_mcu7t3v3__inv_2_268/VNW VSUBS gf180mcu_as_sc_mcu7t3v3__nand4_2
Xu_t019_010 u_t019_010/c0_w0_bl u_t019_010/c0_w0_br u_t019_010/c0_w1_bl u_t019_010/c0_w1_br
+ u_t019_010/c0_r0_rbl u_t019_010/c0_r1_rbl u_t019_010/c1_w0_bl u_t019_010/c1_w0_br
+ u_t019_010/c1_w1_bl u_t019_010/c1_w1_br u_t019_010/c1_r0_rbl u_t019_010/c1_r1_rbl
+ u_t019_010/c2_w0_bl u_t019_010/c2_w0_br u_t019_010/c2_w1_bl u_t019_010/c2_w1_br
+ u_t019_010/c2_r0_rbl u_t019_010/c2_r1_rbl u_t019_010/c3_w0_bl u_t019_010/c3_w0_br
+ u_t019_010/c3_w1_bl u_t019_010/c3_w1_br u_t019_010/c3_r0_rbl u_t019_010/c3_r1_rbl
+ u_t019_010/r0_w0_wl u_t019_010/r0_w1_wl u_t019_010/r0_r0_rwl u_t019_010/r0_r1_rwl
+ u_t019_010/r1_w0_wl u_t019_010/r1_w1_wl u_t019_010/r1_r0_rwl u_t019_010/r1_r1_rwl
+ u_t019_010/r2_w0_wl u_t019_010/r2_w1_wl u_t019_010/r2_r0_rwl u_t019_010/r2_r1_rwl
+ u_t019_010/r3_w0_wl u_t019_010/r3_w1_wl u_t019_010/r3_r0_rwl u_t019_010/r3_r1_rwl
+ VSS VSS u_t019_010/m2_717_1265# u_t019_010/m2_603_2031# u_t019_010/m2_1290_336#
+ u_t019_010/m2_2000_2037# u_t019_010/m2_791_2909# u_t019_010/m2_7_2126# u_t019_010/m2_2154_2081#
+ u_t019_010/m2_1795_2037# u_t019_010/m2_871_303# u_t019_010/m2_431_438# u_t019_010/m2_1290_2898#
+ u_t019_010/m2_1714_1210# u_t019_010/m2_431_1982# u_t019_010/m2_512_1265# u_t019_010/m2_2573_2126#
+ u_t019_010/m2_603_1259# u_t019_010/m2_2074_2909# u_t019_010/m2_7_336# u_t019_010/m2_717_2037#
+ u_t019_010/m2_1886_2031# u_t019_010/m2_2573_336# u_t019_010/m2_7_2898# u_t019_010/m2_2000_1265#
+ u_t019_010/m2_512_2037# u_t019_010/m2_1795_1265# u_t019_010/m2_1714_1982# u_t019_010/m2_1886_1259#
+ u_t019_010/m2_1290_2126# u_t019_010/m2_1714_438# u_t019_010/m2_431_1210# u_t019_010/m2_2573_2898#
+ u_t019_010/m2_2154_303# u_t019_010/m2_871_2081# VSUBS detronyx_12t_2w2r_rc4_4x4_routed_5layer_direct
Xgf180mcu_as_sc_mcu7t3v3__nand4_2_25 VSS VSS VSS VSS VSS VSS gf180mcu_as_sc_mcu7t3v3__inv_2_155/A
+ gf180mcu_as_sc_mcu7t3v3__inv_2_155/VNW VSUBS gf180mcu_as_sc_mcu7t3v3__nand4_2
Xgf180mcu_as_sc_mcu7t3v3__nand4_2_14 VSS VSS VSS VSS VSS VSS gf180mcu_as_sc_mcu7t3v3__inv_2_122/A
+ gf180mcu_as_sc_mcu7t3v3__inv_2_122/VNW VSUBS gf180mcu_as_sc_mcu7t3v3__nand4_2
Xgf180mcu_as_sc_mcu7t3v3__nand4_2_119 VSS VSS VSS VSS VSS VSS gf180mcu_as_sc_mcu7t3v3__inv_2_261/A
+ gf180mcu_as_sc_mcu7t3v3__inv_2_298/VNW VSUBS gf180mcu_as_sc_mcu7t3v3__nand4_2
Xgf180mcu_as_sc_mcu7t3v3__nand4_2_36 VSS VSS VSS VSS VSS VSS gf180mcu_as_sc_mcu7t3v3__inv_2_190/A
+ gf180mcu_as_sc_mcu7t3v3__inv_2_190/VNW VSUBS gf180mcu_as_sc_mcu7t3v3__nand4_2
Xgf180mcu_as_sc_mcu7t3v3__nand4_2_47 VSS VSS VSS VSS VSS VSS gf180mcu_as_sc_mcu7t3v3__inv_2_221/A
+ gf180mcu_as_sc_mcu7t3v3__inv_2_221/VNW VSUBS gf180mcu_as_sc_mcu7t3v3__nand4_2
Xgf180mcu_as_sc_mcu7t3v3__nand4_2_58 VSS VSS VSS VSS VSS VSS gf180mcu_as_sc_mcu7t3v3__inv_2_254/A
+ gf180mcu_as_sc_mcu7t3v3__inv_2_254/VNW VSUBS gf180mcu_as_sc_mcu7t3v3__nand4_2
Xgf180mcu_as_sc_mcu7t3v3__nand4_2_69 VSS VSS VSS VSS VSS VSS gf180mcu_as_sc_mcu7t3v3__inv_2_32/A
+ gf180mcu_as_sc_mcu7t3v3__inv_2_32/VNW VSUBS gf180mcu_as_sc_mcu7t3v3__nand4_2
Xu_t025_013 u_t025_013/c0_w0_bl u_t025_013/c0_w0_br u_t025_013/c0_w1_bl u_t025_013/c0_w1_br
+ u_t025_013/c0_r0_rbl u_t025_013/c0_r1_rbl u_t025_013/c1_w0_bl u_t025_013/c1_w0_br
+ u_t025_013/c1_w1_bl u_t025_013/c1_w1_br u_t025_013/c1_r0_rbl u_t025_013/c1_r1_rbl
+ u_t025_013/c2_w0_bl u_t025_013/c2_w0_br u_t025_013/c2_w1_bl u_t025_013/c2_w1_br
+ u_t025_013/c2_r0_rbl u_t025_013/c2_r1_rbl u_t025_013/c3_w0_bl u_t025_013/c3_w0_br
+ u_t025_013/c3_w1_bl u_t025_013/c3_w1_br u_t025_013/c3_r0_rbl u_t025_013/c3_r1_rbl
+ u_t025_013/r0_w0_wl u_t025_013/r0_w1_wl u_t025_013/r0_r0_rwl u_t025_013/r0_r1_rwl
+ u_t025_013/r1_w0_wl u_t025_013/r1_w1_wl u_t025_013/r1_r0_rwl u_t025_013/r1_r1_rwl
+ u_t025_013/r2_w0_wl u_t025_013/r2_w1_wl u_t025_013/r2_r0_rwl u_t025_013/r2_r1_rwl
+ u_t025_013/r3_w0_wl u_t025_013/r3_w1_wl u_t025_013/r3_r0_rwl u_t025_013/r3_r1_rwl
+ VSS VSS u_t025_013/m2_717_1265# u_t025_013/m2_603_2031# u_t025_013/m2_1290_336#
+ u_t025_013/m2_2000_2037# u_t025_013/m2_791_2909# u_t025_013/m2_7_2126# u_t025_013/m2_2154_2081#
+ u_t025_013/m2_1795_2037# u_t025_013/m2_871_303# u_t025_013/m2_431_438# u_t025_013/m2_1290_2898#
+ u_t025_013/m2_1714_1210# u_t025_013/m2_431_1982# u_t025_013/m2_512_1265# u_t025_013/m2_2573_2126#
+ u_t025_013/m2_603_1259# u_t025_013/m2_2074_2909# u_t025_013/m2_7_336# u_t025_013/m2_717_2037#
+ u_t025_013/m2_1886_2031# u_t025_013/m2_2573_336# u_t025_013/m2_7_2898# u_t025_013/m2_2000_1265#
+ u_t025_013/m2_512_2037# u_t025_013/m2_1795_1265# u_t025_013/m2_1714_1982# u_t025_013/m2_1886_1259#
+ u_t025_013/m2_1290_2126# u_t025_013/m2_1714_438# u_t025_013/m2_431_1210# u_t025_013/m2_2573_2898#
+ u_t025_013/m2_2154_303# u_t025_013/m2_871_2081# VSUBS detronyx_12t_2w2r_rc4_4x4_routed_5layer_direct
Xu_t025_002 u_t025_002/c0_w0_bl u_t025_002/c0_w0_br u_t025_002/c0_w1_bl u_t025_002/c0_w1_br
+ u_t025_002/c0_r0_rbl u_t025_002/c0_r1_rbl u_t025_002/c1_w0_bl u_t025_002/c1_w0_br
+ u_t025_002/c1_w1_bl u_t025_002/c1_w1_br u_t025_002/c1_r0_rbl u_t025_002/c1_r1_rbl
+ u_t025_002/c2_w0_bl u_t025_002/c2_w0_br u_t025_002/c2_w1_bl u_t025_002/c2_w1_br
+ u_t025_002/c2_r0_rbl u_t025_002/c2_r1_rbl u_t025_002/c3_w0_bl u_t025_002/c3_w0_br
+ u_t025_002/c3_w1_bl u_t025_002/c3_w1_br u_t025_002/c3_r0_rbl u_t025_002/c3_r1_rbl
+ u_t025_002/r0_w0_wl u_t025_002/r0_w1_wl u_t025_002/r0_r0_rwl u_t025_002/r0_r1_rwl
+ u_t025_002/r1_w0_wl u_t025_002/r1_w1_wl u_t025_002/r1_r0_rwl u_t025_002/r1_r1_rwl
+ u_t025_002/r2_w0_wl u_t025_002/r2_w1_wl u_t025_002/r2_r0_rwl u_t025_002/r2_r1_rwl
+ u_t025_002/r3_w0_wl u_t025_002/r3_w1_wl u_t025_002/r3_r0_rwl u_t025_002/r3_r1_rwl
+ VSS VSS u_t025_002/m2_717_1265# u_t025_002/m2_603_2031# u_t025_002/m2_1290_336#
+ u_t025_002/m2_2000_2037# u_t025_002/m2_791_2909# u_t025_002/m2_7_2126# u_t025_002/m2_2154_2081#
+ u_t025_002/m2_1795_2037# u_t025_002/m2_871_303# u_t025_002/m2_431_438# u_t025_002/m2_1290_2898#
+ u_t025_002/m2_1714_1210# u_t025_002/m2_431_1982# u_t025_002/m2_512_1265# u_t025_002/m2_2573_2126#
+ u_t025_002/m2_603_1259# u_t025_002/m2_2074_2909# u_t025_002/m2_7_336# u_t025_002/m2_717_2037#
+ u_t025_002/m2_1886_2031# u_t025_002/m2_2573_336# u_t025_002/m2_7_2898# u_t025_002/m2_2000_1265#
+ u_t025_002/m2_512_2037# u_t025_002/m2_1795_1265# u_t025_002/m2_1714_1982# u_t025_002/m2_1886_1259#
+ u_t025_002/m2_1290_2126# u_t025_002/m2_1714_438# u_t025_002/m2_431_1210# u_t025_002/m2_2573_2898#
+ u_t025_002/m2_2154_303# u_t025_002/m2_871_2081# VSUBS detronyx_12t_2w2r_rc4_4x4_routed_5layer_direct
Xgf180mcu_as_sc_mcu7t3v3__inv_2_1133 VSS VSS gf180mcu_as_sc_mcu7t3v3__inv_2_1133/Y
+ gf180mcu_as_sc_mcu7t3v3__inv_2_1133/A gf180mcu_as_sc_mcu7t3v3__inv_2_1133/VNW VSUBS
+ gf180mcu_as_sc_mcu7t3v3__inv_2
Xgf180mcu_as_sc_mcu7t3v3__inv_2_1144 VSS VSS gf180mcu_as_sc_mcu7t3v3__inv_2_1144/Y
+ gf180mcu_as_sc_mcu7t3v3__inv_2_1145/Y gf180mcu_as_sc_mcu7t3v3__inv_2_1145/VNW VSUBS
+ gf180mcu_as_sc_mcu7t3v3__inv_2
Xgf180mcu_as_sc_mcu7t3v3__inv_2_1100 VSS VSS gf180mcu_as_sc_mcu7t3v3__inv_2_1100/Y
+ gf180mcu_as_sc_mcu7t3v3__inv_2_1100/A gf180mcu_as_sc_mcu7t3v3__inv_2_1100/VNW VSUBS
+ gf180mcu_as_sc_mcu7t3v3__inv_2
Xgf180mcu_as_sc_mcu7t3v3__inv_2_1122 VSS VSS VSS gf180mcu_as_sc_mcu7t3v3__inv_2_1123/Y
+ gf180mcu_as_sc_mcu7t3v3__inv_2_1124/VNW VSUBS gf180mcu_as_sc_mcu7t3v3__inv_2
Xgf180mcu_as_sc_mcu7t3v3__inv_2_1111 VSS VSS gf180mcu_as_sc_mcu7t3v3__inv_2_1111/Y
+ gf180mcu_as_sc_mcu7t3v3__inv_2_1111/A gf180mcu_as_sc_mcu7t3v3__inv_2_1111/VNW VSUBS
+ gf180mcu_as_sc_mcu7t3v3__inv_2
Xgf180mcu_as_sc_mcu7t3v3__inv_2_1188 VSS VSS gf180mcu_as_sc_mcu7t3v3__inv_2_1188/Y
+ gf180mcu_as_sc_mcu7t3v3__inv_2_1188/A gf180mcu_as_sc_mcu7t3v3__inv_2_1279/VNW VSUBS
+ gf180mcu_as_sc_mcu7t3v3__inv_2
Xgf180mcu_as_sc_mcu7t3v3__inv_2_1199 VSS VSS gf180mcu_as_sc_mcu7t3v3__inv_2_1272/A
+ gf180mcu_as_sc_mcu7t3v3__inv_2_1200/Y gf180mcu_as_sc_mcu7t3v3__inv_2_1272/VNW VSUBS
+ gf180mcu_as_sc_mcu7t3v3__inv_2
Xgf180mcu_as_sc_mcu7t3v3__inv_2_1166 VSS VSS gf180mcu_as_sc_mcu7t3v3__inv_2_1294/A
+ gf180mcu_as_sc_mcu7t3v3__inv_2_1172/Y gf180mcu_as_sc_mcu7t3v3__inv_2_1294/VNW VSUBS
+ gf180mcu_as_sc_mcu7t3v3__inv_2
Xgf180mcu_as_sc_mcu7t3v3__inv_2_1177 VSS VSS gf180mcu_as_sc_mcu7t3v3__inv_2_1177/Y
+ gf180mcu_as_sc_mcu7t3v3__inv_2_1177/A gf180mcu_as_sc_mcu7t3v3__inv_2_1296/VNW VSUBS
+ gf180mcu_as_sc_mcu7t3v3__inv_2
Xgf180mcu_as_sc_mcu7t3v3__inv_2_1155 VSS VSS gf180mcu_as_sc_mcu7t3v3__inv_2_1184/A
+ gf180mcu_as_sc_mcu7t3v3__inv_2_1155/A gf180mcu_as_sc_mcu7t3v3__inv_2_1298/VNW VSUBS
+ gf180mcu_as_sc_mcu7t3v3__inv_2
Xu_t016_013 u_t016_013/c0_w0_bl u_t016_013/c0_w0_br u_t016_013/c0_w1_bl u_t016_013/c0_w1_br
+ u_t016_013/c0_r0_rbl u_t016_013/c0_r1_rbl u_t016_013/c1_w0_bl u_t016_013/c1_w0_br
+ u_t016_013/c1_w1_bl u_t016_013/c1_w1_br u_t016_013/c1_r0_rbl u_t016_013/c1_r1_rbl
+ u_t016_013/c2_w0_bl u_t016_013/c2_w0_br u_t016_013/c2_w1_bl u_t016_013/c2_w1_br
+ u_t016_013/c2_r0_rbl u_t016_013/c2_r1_rbl u_t016_013/c3_w0_bl u_t016_013/c3_w0_br
+ u_t016_013/c3_w1_bl u_t016_013/c3_w1_br u_t016_013/c3_r0_rbl u_t016_013/c3_r1_rbl
+ u_t016_013/r0_w0_wl u_t016_013/r0_w1_wl u_t016_013/r0_r0_rwl u_t016_013/r0_r1_rwl
+ u_t016_013/r1_w0_wl u_t016_013/r1_w1_wl u_t016_013/r1_r0_rwl u_t016_013/r1_r1_rwl
+ u_t016_013/r2_w0_wl u_t016_013/r2_w1_wl u_t016_013/r2_r0_rwl u_t016_013/r2_r1_rwl
+ u_t016_013/r3_w0_wl u_t016_013/r3_w1_wl u_t016_013/r3_r0_rwl u_t016_013/r3_r1_rwl
+ VSS VSS u_t016_013/m2_717_1265# u_t016_013/m2_603_2031# u_t016_013/m2_1290_336#
+ u_t016_013/m2_2000_2037# u_t016_013/m2_791_2909# u_t016_013/m2_7_2126# u_t016_013/m2_2154_2081#
+ u_t016_013/m2_1795_2037# u_t016_013/m2_871_303# u_t016_013/m2_431_438# u_t016_013/m2_1290_2898#
+ u_t016_013/m2_1714_1210# u_t016_013/m2_431_1982# u_t016_013/m2_512_1265# u_t016_013/m2_2573_2126#
+ u_t016_013/m2_603_1259# u_t016_013/m2_2074_2909# u_t016_013/m2_7_336# u_t016_013/m2_717_2037#
+ u_t016_013/m2_1886_2031# u_t016_013/m2_2573_336# u_t016_013/m2_7_2898# u_t016_013/m2_2000_1265#
+ u_t016_013/m2_512_2037# u_t016_013/m2_1795_1265# u_t016_013/m2_1714_1982# u_t016_013/m2_1886_1259#
+ u_t016_013/m2_1290_2126# u_t016_013/m2_1714_438# u_t016_013/m2_431_1210# u_t016_013/m2_2573_2898#
+ u_t016_013/m2_2154_303# u_t016_013/m2_871_2081# VSUBS detronyx_12t_2w2r_rc4_4x4_routed_5layer_direct
Xu_t031_005 u_t031_005/c0_w0_bl u_t031_005/c0_w0_br u_t031_005/c0_w1_bl u_t031_005/c0_w1_br
+ u_t031_005/c0_r0_rbl u_t031_005/c0_r1_rbl u_t031_005/c1_w0_bl u_t031_005/c1_w0_br
+ u_t031_005/c1_w1_bl u_t031_005/c1_w1_br u_t031_005/c1_r0_rbl u_t031_005/c1_r1_rbl
+ u_t031_005/c2_w0_bl u_t031_005/c2_w0_br u_t031_005/c2_w1_bl u_t031_005/c2_w1_br
+ u_t031_005/c2_r0_rbl u_t031_005/c2_r1_rbl u_t031_005/c3_w0_bl u_t031_005/c3_w0_br
+ u_t031_005/c3_w1_bl u_t031_005/c3_w1_br u_t031_005/c3_r0_rbl u_t031_005/c3_r1_rbl
+ u_t031_005/r0_w0_wl u_t031_005/r0_w1_wl u_t031_005/r0_r0_rwl u_t031_005/r0_r1_rwl
+ u_t031_005/r1_w0_wl u_t031_005/r1_w1_wl u_t031_005/r1_r0_rwl u_t031_005/r1_r1_rwl
+ u_t031_005/r2_w0_wl u_t031_005/r2_w1_wl u_t031_005/r2_r0_rwl u_t031_005/r2_r1_rwl
+ u_t031_005/r3_w0_wl u_t031_005/r3_w1_wl u_t031_005/r3_r0_rwl u_t031_005/r3_r1_rwl
+ VSS VSS u_t031_005/m2_717_1265# u_t031_005/m2_603_2031# u_t031_005/m2_1290_336#
+ u_t031_005/m2_2000_2037# u_t031_005/m2_791_2909# u_t031_005/m2_7_2126# u_t031_005/m2_2154_2081#
+ u_t031_005/m2_1795_2037# u_t031_005/m2_871_303# u_t031_005/m2_431_438# u_t031_005/m2_1290_2898#
+ u_t031_005/m2_1714_1210# u_t031_005/m2_431_1982# u_t031_005/m2_512_1265# u_t031_005/m2_2573_2126#
+ u_t031_005/m2_603_1259# u_t031_005/m2_2074_2909# u_t031_005/m2_7_336# u_t031_005/m2_717_2037#
+ u_t031_005/m2_1886_2031# u_t031_005/m2_2573_336# u_t031_005/m2_7_2898# u_t031_005/m2_2000_1265#
+ u_t031_005/m2_512_2037# u_t031_005/m2_1795_1265# u_t031_005/m2_1714_1982# u_t031_005/m2_1886_1259#
+ u_t031_005/m2_1290_2126# u_t031_005/m2_1714_438# u_t031_005/m2_431_1210# u_t031_005/m2_2573_2898#
+ u_t031_005/m2_2154_303# u_t031_005/m2_871_2081# VSUBS detronyx_12t_2w2r_rc4_4x4_routed_5layer_direct
Xu_t016_002 u_t016_002/c0_w0_bl u_t016_002/c0_w0_br u_t016_002/c0_w1_bl u_t016_002/c0_w1_br
+ u_t016_002/c0_r0_rbl u_t016_002/c0_r1_rbl u_t016_002/c1_w0_bl u_t016_002/c1_w0_br
+ u_t016_002/c1_w1_bl u_t016_002/c1_w1_br u_t016_002/c1_r0_rbl u_t016_002/c1_r1_rbl
+ u_t016_002/c2_w0_bl u_t016_002/c2_w0_br u_t016_002/c2_w1_bl u_t016_002/c2_w1_br
+ u_t016_002/c2_r0_rbl u_t016_002/c2_r1_rbl u_t016_002/c3_w0_bl u_t016_002/c3_w0_br
+ u_t016_002/c3_w1_bl u_t016_002/c3_w1_br u_t016_002/c3_r0_rbl u_t016_002/c3_r1_rbl
+ u_t016_002/r0_w0_wl u_t016_002/r0_w1_wl u_t016_002/r0_r0_rwl u_t016_002/r0_r1_rwl
+ u_t016_002/r1_w0_wl u_t016_002/r1_w1_wl u_t016_002/r1_r0_rwl u_t016_002/r1_r1_rwl
+ u_t016_002/r2_w0_wl u_t016_002/r2_w1_wl u_t016_002/r2_r0_rwl u_t016_002/r2_r1_rwl
+ u_t016_002/r3_w0_wl u_t016_002/r3_w1_wl u_t016_002/r3_r0_rwl u_t016_002/r3_r1_rwl
+ VSS VSS u_t016_002/m2_717_1265# u_t016_002/m2_603_2031# u_t016_002/m2_1290_336#
+ u_t016_002/m2_2000_2037# u_t016_002/m2_791_2909# u_t016_002/m2_7_2126# u_t016_002/m2_2154_2081#
+ u_t016_002/m2_1795_2037# u_t016_002/m2_871_303# u_t016_002/m2_431_438# u_t016_002/m2_1290_2898#
+ u_t016_002/m2_1714_1210# u_t016_002/m2_431_1982# u_t016_002/m2_512_1265# u_t016_002/m2_2573_2126#
+ u_t016_002/m2_603_1259# u_t016_002/m2_2074_2909# u_t016_002/m2_7_336# u_t016_002/m2_717_2037#
+ u_t016_002/m2_1886_2031# u_t016_002/m2_2573_336# u_t016_002/m2_7_2898# u_t016_002/m2_2000_1265#
+ u_t016_002/m2_512_2037# u_t016_002/m2_1795_1265# u_t016_002/m2_1714_1982# u_t016_002/m2_1886_1259#
+ u_t016_002/m2_1290_2126# u_t016_002/m2_1714_438# u_t016_002/m2_431_1210# u_t016_002/m2_2573_2898#
+ u_t016_002/m2_2154_303# u_t016_002/m2_871_2081# VSUBS detronyx_12t_2w2r_rc4_4x4_routed_5layer_direct
Xgf180mcu_as_sc_mcu7t3v3__inv_2_639 VSS VSS VSS gf180mcu_as_sc_mcu7t3v3__inv_2_640/Y
+ gf180mcu_as_sc_mcu7t3v3__inv_2_641/VNW VSUBS gf180mcu_as_sc_mcu7t3v3__inv_2
Xgf180mcu_as_sc_mcu7t3v3__inv_2_617 VSS VSS gf180mcu_as_sc_mcu7t3v3__inv_2_617/Y gf180mcu_as_sc_mcu7t3v3__inv_2_617/A
+ gf180mcu_as_sc_mcu7t3v3__inv_2_617/VNW VSUBS gf180mcu_as_sc_mcu7t3v3__inv_2
Xgf180mcu_as_sc_mcu7t3v3__inv_2_606 VSS VSS gf180mcu_as_sc_mcu7t3v3__inv_2_606/Y gf180mcu_as_sc_mcu7t3v3__inv_2_606/A
+ gf180mcu_as_sc_mcu7t3v3__inv_2_606/VNW VSUBS gf180mcu_as_sc_mcu7t3v3__inv_2
Xgf180mcu_as_sc_mcu7t3v3__inv_2_628 VSS VSS gf180mcu_as_sc_mcu7t3v3__inv_2_628/Y gf180mcu_as_sc_mcu7t3v3__inv_2_628/A
+ gf180mcu_as_sc_mcu7t3v3__inv_2_628/VNW VSUBS gf180mcu_as_sc_mcu7t3v3__inv_2
Xu_t007_013 u_t007_013/c0_w0_bl u_t007_013/c0_w0_br u_t007_013/c0_w1_bl u_t007_013/c0_w1_br
+ u_t007_013/c0_r0_rbl u_t007_013/c0_r1_rbl u_t007_013/c1_w0_bl u_t007_013/c1_w0_br
+ u_t007_013/c1_w1_bl u_t007_013/c1_w1_br u_t007_013/c1_r0_rbl u_t007_013/c1_r1_rbl
+ u_t007_013/c2_w0_bl u_t007_013/c2_w0_br u_t007_013/c2_w1_bl u_t007_013/c2_w1_br
+ u_t007_013/c2_r0_rbl u_t007_013/c2_r1_rbl u_t007_013/c3_w0_bl u_t007_013/c3_w0_br
+ u_t007_013/c3_w1_bl u_t007_013/c3_w1_br u_t007_013/c3_r0_rbl u_t007_013/c3_r1_rbl
+ u_t007_013/r0_w0_wl u_t007_013/r0_w1_wl u_t007_013/r0_r0_rwl u_t007_013/r0_r1_rwl
+ u_t007_013/r1_w0_wl u_t007_013/r1_w1_wl u_t007_013/r1_r0_rwl u_t007_013/r1_r1_rwl
+ u_t007_013/r2_w0_wl u_t007_013/r2_w1_wl u_t007_013/r2_r0_rwl u_t007_013/r2_r1_rwl
+ u_t007_013/r3_w0_wl u_t007_013/r3_w1_wl u_t007_013/r3_r0_rwl u_t007_013/r3_r1_rwl
+ VSS VSS u_t007_013/m2_717_1265# u_t007_013/m2_603_2031# u_t007_013/m2_1290_336#
+ u_t007_013/m2_2000_2037# u_t007_013/m2_791_2909# u_t007_013/m2_7_2126# u_t007_013/m2_2154_2081#
+ u_t007_013/m2_1795_2037# u_t007_013/m2_871_303# u_t007_013/m2_431_438# u_t007_013/m2_1290_2898#
+ u_t007_013/m2_1714_1210# u_t007_013/m2_431_1982# u_t007_013/m2_512_1265# u_t007_013/m2_2573_2126#
+ u_t007_013/m2_603_1259# u_t007_013/m2_2074_2909# u_t007_013/m2_7_336# u_t007_013/m2_717_2037#
+ u_t007_013/m2_1886_2031# u_t007_013/m2_2573_336# u_t007_013/m2_7_2898# u_t007_013/m2_2000_1265#
+ u_t007_013/m2_512_2037# u_t007_013/m2_1795_1265# u_t007_013/m2_1714_1982# u_t007_013/m2_1886_1259#
+ u_t007_013/m2_1290_2126# u_t007_013/m2_1714_438# u_t007_013/m2_431_1210# u_t007_013/m2_2573_2898#
+ u_t007_013/m2_2154_303# u_t007_013/m2_871_2081# VSUBS detronyx_12t_2w2r_rc4_4x4_routed_5layer_direct
Xu_t007_002 u_t007_002/c0_w0_bl u_t007_002/c0_w0_br u_t007_002/c0_w1_bl u_t007_002/c0_w1_br
+ u_t007_002/c0_r0_rbl u_t007_002/c0_r1_rbl u_t007_002/c1_w0_bl u_t007_002/c1_w0_br
+ u_t007_002/c1_w1_bl u_t007_002/c1_w1_br u_t007_002/c1_r0_rbl u_t007_002/c1_r1_rbl
+ u_t007_002/c2_w0_bl u_t007_002/c2_w0_br u_t007_002/c2_w1_bl u_t007_002/c2_w1_br
+ u_t007_002/c2_r0_rbl u_t007_002/c2_r1_rbl u_t007_002/c3_w0_bl u_t007_002/c3_w0_br
+ u_t007_002/c3_w1_bl u_t007_002/c3_w1_br u_t007_002/c3_r0_rbl u_t007_002/c3_r1_rbl
+ u_t007_002/r0_w0_wl u_t007_002/r0_w1_wl u_t007_002/r0_r0_rwl u_t007_002/r0_r1_rwl
+ u_t007_002/r1_w0_wl u_t007_002/r1_w1_wl u_t007_002/r1_r0_rwl u_t007_002/r1_r1_rwl
+ u_t007_002/r2_w0_wl u_t007_002/r2_w1_wl u_t007_002/r2_r0_rwl u_t007_002/r2_r1_rwl
+ u_t007_002/r3_w0_wl u_t007_002/r3_w1_wl u_t007_002/r3_r0_rwl u_t007_002/r3_r1_rwl
+ VSS VSS u_t007_002/m2_717_1265# u_t007_002/m2_603_2031# u_t007_002/m2_1290_336#
+ u_t007_002/m2_2000_2037# u_t007_002/m2_791_2909# u_t007_002/m2_7_2126# u_t007_002/m2_2154_2081#
+ u_t007_002/m2_1795_2037# u_t007_002/m2_871_303# u_t007_002/m2_431_438# u_t007_002/m2_1290_2898#
+ u_t007_002/m2_1714_1210# u_t007_002/m2_431_1982# u_t007_002/m2_512_1265# u_t007_002/m2_2573_2126#
+ u_t007_002/m2_603_1259# u_t007_002/m2_2074_2909# u_t007_002/m2_7_336# u_t007_002/m2_717_2037#
+ u_t007_002/m2_1886_2031# u_t007_002/m2_2573_336# u_t007_002/m2_7_2898# u_t007_002/m2_2000_1265#
+ u_t007_002/m2_512_2037# u_t007_002/m2_1795_1265# u_t007_002/m2_1714_1982# u_t007_002/m2_1886_1259#
+ u_t007_002/m2_1290_2126# u_t007_002/m2_1714_438# u_t007_002/m2_431_1210# u_t007_002/m2_2573_2898#
+ u_t007_002/m2_2154_303# u_t007_002/m2_871_2081# VSUBS detronyx_12t_2w2r_rc4_4x4_routed_5layer_direct
Xu_t022_005 u_t022_005/c0_w0_bl u_t022_005/c0_w0_br u_t022_005/c0_w1_bl u_t022_005/c0_w1_br
+ u_t022_005/c0_r0_rbl u_t022_005/c0_r1_rbl u_t022_005/c1_w0_bl u_t022_005/c1_w0_br
+ u_t022_005/c1_w1_bl u_t022_005/c1_w1_br u_t022_005/c1_r0_rbl u_t022_005/c1_r1_rbl
+ u_t022_005/c2_w0_bl u_t022_005/c2_w0_br u_t022_005/c2_w1_bl u_t022_005/c2_w1_br
+ u_t022_005/c2_r0_rbl u_t022_005/c2_r1_rbl u_t022_005/c3_w0_bl u_t022_005/c3_w0_br
+ u_t022_005/c3_w1_bl u_t022_005/c3_w1_br u_t022_005/c3_r0_rbl u_t022_005/c3_r1_rbl
+ u_t022_005/r0_w0_wl u_t022_005/r0_w1_wl u_t022_005/r0_r0_rwl u_t022_005/r0_r1_rwl
+ u_t022_005/r1_w0_wl u_t022_005/r1_w1_wl u_t022_005/r1_r0_rwl u_t022_005/r1_r1_rwl
+ u_t022_005/r2_w0_wl u_t022_005/r2_w1_wl u_t022_005/r2_r0_rwl u_t022_005/r2_r1_rwl
+ u_t022_005/r3_w0_wl u_t022_005/r3_w1_wl u_t022_005/r3_r0_rwl u_t022_005/r3_r1_rwl
+ VSS VSS u_t022_005/m2_717_1265# u_t022_005/m2_603_2031# u_t022_005/m2_1290_336#
+ u_t022_005/m2_2000_2037# u_t022_005/m2_791_2909# u_t022_005/m2_7_2126# u_t022_005/m2_2154_2081#
+ u_t022_005/m2_1795_2037# u_t022_005/m2_871_303# u_t022_005/m2_431_438# u_t022_005/m2_1290_2898#
+ u_t022_005/m2_1714_1210# u_t022_005/m2_431_1982# u_t022_005/m2_512_1265# u_t022_005/m2_2573_2126#
+ u_t022_005/m2_603_1259# u_t022_005/m2_2074_2909# u_t022_005/m2_7_336# u_t022_005/m2_717_2037#
+ u_t022_005/m2_1886_2031# u_t022_005/m2_2573_336# u_t022_005/m2_7_2898# u_t022_005/m2_2000_1265#
+ u_t022_005/m2_512_2037# u_t022_005/m2_1795_1265# u_t022_005/m2_1714_1982# u_t022_005/m2_1886_1259#
+ u_t022_005/m2_1290_2126# u_t022_005/m2_1714_438# u_t022_005/m2_431_1210# u_t022_005/m2_2573_2898#
+ u_t022_005/m2_2154_303# u_t022_005/m2_871_2081# VSUBS detronyx_12t_2w2r_rc4_4x4_routed_5layer_direct
Xgf180mcu_as_sc_mcu7t3v3__nand4_2_494 VSS VSS VSS VSS VSS VSS gf180mcu_as_sc_mcu7t3v3__inv_2_1614/A
+ gf180mcu_as_sc_mcu7t3v3__inv_2_1614/VNW VSUBS gf180mcu_as_sc_mcu7t3v3__nand4_2
Xgf180mcu_as_sc_mcu7t3v3__nand4_2_483 VSS VSS VSS VSS VSS VSS gf180mcu_as_sc_mcu7t3v3__inv_2_1656/A
+ gf180mcu_as_sc_mcu7t3v3__inv_2_1656/VNW VSUBS gf180mcu_as_sc_mcu7t3v3__nand4_2
Xgf180mcu_as_sc_mcu7t3v3__nand4_2_472 VSS VSS VSS VSS VSS VSS gf180mcu_as_sc_mcu7t3v3__inv_2_1394/A
+ gf180mcu_as_sc_mcu7t3v3__inv_2_1394/VNW VSUBS gf180mcu_as_sc_mcu7t3v3__nand4_2
Xgf180mcu_as_sc_mcu7t3v3__nand4_2_461 VSS VSS VSS VSS VSS VSS gf180mcu_as_sc_mcu7t3v3__inv_2_1317/A
+ gf180mcu_as_sc_mcu7t3v3__inv_2_1317/VNW VSUBS gf180mcu_as_sc_mcu7t3v3__nand4_2
Xgf180mcu_as_sc_mcu7t3v3__nand4_2_450 VSS VSS VSS VSS VSS VSS gf180mcu_as_sc_mcu7t3v3__inv_2_1336/A
+ gf180mcu_as_sc_mcu7t3v3__inv_2_1336/VNW VSUBS gf180mcu_as_sc_mcu7t3v3__nand4_2
Xu_t013_005 u_t013_005/c0_w0_bl u_t013_005/c0_w0_br u_t013_005/c0_w1_bl u_t013_005/c0_w1_br
+ u_t013_005/c0_r0_rbl u_t013_005/c0_r1_rbl u_t013_005/c1_w0_bl u_t013_005/c1_w0_br
+ u_t013_005/c1_w1_bl u_t013_005/c1_w1_br u_t013_005/c1_r0_rbl u_t013_005/c1_r1_rbl
+ u_t013_005/c2_w0_bl u_t013_005/c2_w0_br u_t013_005/c2_w1_bl u_t013_005/c2_w1_br
+ u_t013_005/c2_r0_rbl u_t013_005/c2_r1_rbl u_t013_005/c3_w0_bl u_t013_005/c3_w0_br
+ u_t013_005/c3_w1_bl u_t013_005/c3_w1_br u_t013_005/c3_r0_rbl u_t013_005/c3_r1_rbl
+ u_t013_005/r0_w0_wl u_t013_005/r0_w1_wl u_t013_005/r0_r0_rwl u_t013_005/r0_r1_rwl
+ u_t013_005/r1_w0_wl u_t013_005/r1_w1_wl u_t013_005/r1_r0_rwl u_t013_005/r1_r1_rwl
+ u_t013_005/r2_w0_wl u_t013_005/r2_w1_wl u_t013_005/r2_r0_rwl u_t013_005/r2_r1_rwl
+ u_t013_005/r3_w0_wl u_t013_005/r3_w1_wl u_t013_005/r3_r0_rwl u_t013_005/r3_r1_rwl
+ VSS VSS u_t013_005/m2_717_1265# u_t013_005/m2_603_2031# u_t013_005/m2_1290_336#
+ u_t013_005/m2_2000_2037# u_t013_005/m2_791_2909# u_t013_005/m2_7_2126# u_t013_005/m2_2154_2081#
+ u_t013_005/m2_1795_2037# u_t013_005/m2_871_303# u_t013_005/m2_431_438# u_t013_005/m2_1290_2898#
+ u_t013_005/m2_1714_1210# u_t013_005/m2_431_1982# u_t013_005/m2_512_1265# u_t013_005/m2_2573_2126#
+ u_t013_005/m2_603_1259# u_t013_005/m2_2074_2909# u_t013_005/m2_7_336# u_t013_005/m2_717_2037#
+ u_t013_005/m2_1886_2031# u_t013_005/m2_2573_336# u_t013_005/m2_7_2898# u_t013_005/m2_2000_1265#
+ u_t013_005/m2_512_2037# u_t013_005/m2_1795_1265# u_t013_005/m2_1714_1982# u_t013_005/m2_1886_1259#
+ u_t013_005/m2_1290_2126# u_t013_005/m2_1714_438# u_t013_005/m2_431_1210# u_t013_005/m2_2573_2898#
+ u_t013_005/m2_2154_303# u_t013_005/m2_871_2081# VSUBS detronyx_12t_2w2r_rc4_4x4_routed_5layer_direct
Xgf180mcu_as_sc_mcu7t3v3__inv_2_403 gf180mcu_as_sc_mcu7t3v3__nor2_2_7/VDD gf180mcu_as_sc_mcu7t3v3__nand3_2_4/VSS
+ VSS VSS gf180mcu_as_sc_mcu7t3v3__nor2_2_7/VNW VSUBS gf180mcu_as_sc_mcu7t3v3__inv_2
Xgf180mcu_as_sc_mcu7t3v3__inv_2_425 gf180mcu_as_sc_mcu7t3v3__nor2_2_6/VDD gf180mcu_as_sc_mcu7t3v3__nand3_2_4/VSS
+ gf180mcu_as_sc_mcu7t3v3__inv_2_425/Y VSS gf180mcu_as_sc_mcu7t3v3__nor2_2_6/VNW VSUBS
+ gf180mcu_as_sc_mcu7t3v3__inv_2
Xgf180mcu_as_sc_mcu7t3v3__inv_2_414 gf180mcu_as_sc_mcu7t3v3__nor2_2_7/VDD gf180mcu_as_sc_mcu7t3v3__nor2_2_7/VSS
+ VSS VSS gf180mcu_as_sc_mcu7t3v3__nor2_2_7/VNW VSUBS gf180mcu_as_sc_mcu7t3v3__inv_2
Xgf180mcu_as_sc_mcu7t3v3__inv_2_436 gf180mcu_as_sc_mcu7t3v3__nor2_2_4/VDD gf180mcu_as_sc_mcu7t3v3__nand2_2_3/VSS
+ VSS VSS gf180mcu_as_sc_mcu7t3v3__nor2_2_4/VNW VSUBS gf180mcu_as_sc_mcu7t3v3__inv_2
Xu_t004_005 u_t004_005/c0_w0_bl u_t004_005/c0_w0_br u_t004_005/c0_w1_bl u_t004_005/c0_w1_br
+ u_t004_005/c0_r0_rbl u_t004_005/c0_r1_rbl u_t004_005/c1_w0_bl u_t004_005/c1_w0_br
+ u_t004_005/c1_w1_bl u_t004_005/c1_w1_br u_t004_005/c1_r0_rbl u_t004_005/c1_r1_rbl
+ u_t004_005/c2_w0_bl u_t004_005/c2_w0_br u_t004_005/c2_w1_bl u_t004_005/c2_w1_br
+ u_t004_005/c2_r0_rbl u_t004_005/c2_r1_rbl u_t004_005/c3_w0_bl u_t004_005/c3_w0_br
+ u_t004_005/c3_w1_bl u_t004_005/c3_w1_br u_t004_005/c3_r0_rbl u_t004_005/c3_r1_rbl
+ u_t004_005/r0_w0_wl u_t004_005/r0_w1_wl u_t004_005/r0_r0_rwl u_t004_005/r0_r1_rwl
+ u_t004_005/r1_w0_wl u_t004_005/r1_w1_wl u_t004_005/r1_r0_rwl u_t004_005/r1_r1_rwl
+ u_t004_005/r2_w0_wl u_t004_005/r2_w1_wl u_t004_005/r2_r0_rwl u_t004_005/r2_r1_rwl
+ u_t004_005/r3_w0_wl u_t004_005/r3_w1_wl u_t004_005/r3_r0_rwl u_t004_005/r3_r1_rwl
+ VSS VSS u_t004_005/m2_717_1265# u_t004_005/m2_603_2031# u_t004_005/m2_1290_336#
+ u_t004_005/m2_2000_2037# u_t004_005/m2_791_2909# u_t004_005/m2_7_2126# u_t004_005/m2_2154_2081#
+ u_t004_005/m2_1795_2037# u_t004_005/m2_871_303# u_t004_005/m2_431_438# u_t004_005/m2_1290_2898#
+ u_t004_005/m2_1714_1210# u_t004_005/m2_431_1982# u_t004_005/m2_512_1265# u_t004_005/m2_2573_2126#
+ u_t004_005/m2_603_1259# u_t004_005/m2_2074_2909# u_t004_005/m2_7_336# u_t004_005/m2_717_2037#
+ u_t004_005/m2_1886_2031# u_t004_005/m2_2573_336# u_t004_005/m2_7_2898# u_t004_005/m2_2000_1265#
+ u_t004_005/m2_512_2037# u_t004_005/m2_1795_1265# u_t004_005/m2_1714_1982# u_t004_005/m2_1886_1259#
+ u_t004_005/m2_1290_2126# u_t004_005/m2_1714_438# u_t004_005/m2_431_1210# u_t004_005/m2_2573_2898#
+ u_t004_005/m2_2154_303# u_t004_005/m2_871_2081# VSUBS detronyx_12t_2w2r_rc4_4x4_routed_5layer_direct
Xgf180mcu_as_sc_mcu7t3v3__inv_2_458 gf180mcu_as_sc_mcu7t3v3__nor2_2_7/VDD gf180mcu_as_sc_mcu7t3v3__nor2_2_7/VSS
+ VSS VSS gf180mcu_as_sc_mcu7t3v3__nor2_2_7/VNW VSUBS gf180mcu_as_sc_mcu7t3v3__inv_2
Xgf180mcu_as_sc_mcu7t3v3__inv_2_469 gf180mcu_as_sc_mcu7t3v3__nand3_2_9/VDD gf180mcu_as_sc_mcu7t3v3__nor2_2_4/VSS
+ VSS VSS gf180mcu_as_sc_mcu7t3v3__nand3_2_9/VNW VSUBS gf180mcu_as_sc_mcu7t3v3__inv_2
Xgf180mcu_as_sc_mcu7t3v3__inv_2_447 gf180mcu_as_sc_mcu7t3v3__nor2_2_7/VDD gf180mcu_as_sc_mcu7t3v3__nor2_2_7/VSS
+ VSS VSS gf180mcu_as_sc_mcu7t3v3__nor2_2_7/VNW VSUBS gf180mcu_as_sc_mcu7t3v3__inv_2
Xgf180mcu_as_sc_mcu7t3v3__inv_2_981 VSS VSS gf180mcu_as_sc_mcu7t3v3__inv_2_981/Y gf180mcu_as_sc_mcu7t3v3__inv_2_985/Y
+ gf180mcu_as_sc_mcu7t3v3__inv_2_985/VNW VSUBS gf180mcu_as_sc_mcu7t3v3__inv_2
Xgf180mcu_as_sc_mcu7t3v3__inv_2_970 VSS VSS VSS gf180mcu_as_sc_mcu7t3v3__inv_2_971/Y
+ gf180mcu_as_sc_mcu7t3v3__inv_2_972/VNW VSUBS gf180mcu_as_sc_mcu7t3v3__inv_2
Xu_t010_008 u_t010_008/c0_w0_bl u_t010_008/c0_w0_br u_t010_008/c0_w1_bl u_t010_008/c0_w1_br
+ u_t010_008/c0_r0_rbl u_t010_008/c0_r1_rbl u_t010_008/c1_w0_bl u_t010_008/c1_w0_br
+ u_t010_008/c1_w1_bl u_t010_008/c1_w1_br u_t010_008/c1_r0_rbl u_t010_008/c1_r1_rbl
+ u_t010_008/c2_w0_bl u_t010_008/c2_w0_br u_t010_008/c2_w1_bl u_t010_008/c2_w1_br
+ u_t010_008/c2_r0_rbl u_t010_008/c2_r1_rbl u_t010_008/c3_w0_bl u_t010_008/c3_w0_br
+ u_t010_008/c3_w1_bl u_t010_008/c3_w1_br u_t010_008/c3_r0_rbl u_t010_008/c3_r1_rbl
+ u_t010_008/r0_w0_wl u_t010_008/r0_w1_wl u_t010_008/r0_r0_rwl u_t010_008/r0_r1_rwl
+ u_t010_008/r1_w0_wl u_t010_008/r1_w1_wl u_t010_008/r1_r0_rwl u_t010_008/r1_r1_rwl
+ u_t010_008/r2_w0_wl u_t010_008/r2_w1_wl u_t010_008/r2_r0_rwl u_t010_008/r2_r1_rwl
+ u_t010_008/r3_w0_wl u_t010_008/r3_w1_wl u_t010_008/r3_r0_rwl u_t010_008/r3_r1_rwl
+ VSS VSS u_t010_008/m2_717_1265# u_t010_008/m2_603_2031# u_t010_008/m2_1290_336#
+ u_t010_008/m2_2000_2037# u_t010_008/m2_791_2909# u_t010_008/m2_7_2126# u_t010_008/m2_2154_2081#
+ u_t010_008/m2_1795_2037# u_t010_008/m2_871_303# u_t010_008/m2_431_438# u_t010_008/m2_1290_2898#
+ u_t010_008/m2_1714_1210# u_t010_008/m2_431_1982# u_t010_008/m2_512_1265# u_t010_008/m2_2573_2126#
+ u_t010_008/m2_603_1259# u_t010_008/m2_2074_2909# u_t010_008/m2_7_336# u_t010_008/m2_717_2037#
+ u_t010_008/m2_1886_2031# u_t010_008/m2_2573_336# u_t010_008/m2_7_2898# u_t010_008/m2_2000_1265#
+ u_t010_008/m2_512_2037# u_t010_008/m2_1795_1265# u_t010_008/m2_1714_1982# u_t010_008/m2_1886_1259#
+ u_t010_008/m2_1290_2126# u_t010_008/m2_1714_438# u_t010_008/m2_431_1210# u_t010_008/m2_2573_2898#
+ u_t010_008/m2_2154_303# u_t010_008/m2_871_2081# VSUBS detronyx_12t_2w2r_rc4_4x4_routed_5layer_direct
Xgf180mcu_as_sc_mcu7t3v3__inv_2_992 VSS VSS gf180mcu_as_sc_mcu7t3v3__inv_2_992/Y gf180mcu_as_sc_mcu7t3v3__inv_2_992/A
+ gf180mcu_as_sc_mcu7t3v3__inv_2_992/VNW VSUBS gf180mcu_as_sc_mcu7t3v3__inv_2
Xgf180mcu_as_sc_mcu7t3v3__nand4_2_280 VSS VSS VSS VSS VSS VSS gf180mcu_as_sc_mcu7t3v3__inv_2_920/A
+ gf180mcu_as_sc_mcu7t3v3__inv_2_947/VNW VSUBS gf180mcu_as_sc_mcu7t3v3__nand4_2
Xgf180mcu_as_sc_mcu7t3v3__nand4_2_291 VSS VSS VSS VSS VSS VSS gf180mcu_as_sc_mcu7t3v3__inv_2_988/A
+ gf180mcu_as_sc_mcu7t3v3__inv_2_988/VNW VSUBS gf180mcu_as_sc_mcu7t3v3__nand4_2
Xu_t001_008 u_t001_008/c0_w0_bl u_t001_008/c0_w0_br u_t001_008/c0_w1_bl u_t001_008/c0_w1_br
+ u_t001_008/c0_r0_rbl u_t001_008/c0_r1_rbl u_t001_008/c1_w0_bl u_t001_008/c1_w0_br
+ u_t001_008/c1_w1_bl u_t001_008/c1_w1_br u_t001_008/c1_r0_rbl u_t001_008/c1_r1_rbl
+ u_t001_008/c2_w0_bl u_t001_008/c2_w0_br u_t001_008/c2_w1_bl u_t001_008/c2_w1_br
+ u_t001_008/c2_r0_rbl u_t001_008/c2_r1_rbl u_t001_008/c3_w0_bl u_t001_008/c3_w0_br
+ u_t001_008/c3_w1_bl u_t001_008/c3_w1_br u_t001_008/c3_r0_rbl u_t001_008/c3_r1_rbl
+ u_t001_008/r0_w0_wl u_t001_008/r0_w1_wl u_t001_008/r0_r0_rwl u_t001_008/r0_r1_rwl
+ u_t001_008/r1_w0_wl u_t001_008/r1_w1_wl u_t001_008/r1_r0_rwl u_t001_008/r1_r1_rwl
+ u_t001_008/r2_w0_wl u_t001_008/r2_w1_wl u_t001_008/r2_r0_rwl u_t001_008/r2_r1_rwl
+ u_t001_008/r3_w0_wl u_t001_008/r3_w1_wl u_t001_008/r3_r0_rwl u_t001_008/r3_r1_rwl
+ VSS VSS u_t001_008/m2_717_1265# u_t001_008/m2_603_2031# u_t001_008/m2_1290_336#
+ u_t001_008/m2_2000_2037# u_t001_008/m2_791_2909# u_t001_008/m2_7_2126# u_t001_008/m2_2154_2081#
+ u_t001_008/m2_1795_2037# u_t001_008/m2_871_303# u_t001_008/m2_431_438# u_t001_008/m2_1290_2898#
+ u_t001_008/m2_1714_1210# u_t001_008/m2_431_1982# u_t001_008/m2_512_1265# u_t001_008/m2_2573_2126#
+ u_t001_008/m2_603_1259# u_t001_008/m2_2074_2909# u_t001_008/m2_7_336# u_t001_008/m2_717_2037#
+ u_t001_008/m2_1886_2031# u_t001_008/m2_2573_336# u_t001_008/m2_7_2898# u_t001_008/m2_2000_1265#
+ u_t001_008/m2_512_2037# u_t001_008/m2_1795_1265# u_t001_008/m2_1714_1982# u_t001_008/m2_1886_1259#
+ u_t001_008/m2_1290_2126# u_t001_008/m2_1714_438# u_t001_008/m2_431_1210# u_t001_008/m2_2573_2898#
+ u_t001_008/m2_2154_303# u_t001_008/m2_871_2081# VSUBS detronyx_12t_2w2r_rc4_4x4_routed_5layer_direct
Xgf180mcu_as_sc_mcu7t3v3__inv_2_277 VSS VSS gf180mcu_as_sc_mcu7t3v3__inv_2_277/Y gf180mcu_as_sc_mcu7t3v3__inv_2_281/Y
+ gf180mcu_as_sc_mcu7t3v3__inv_2_281/VNW VSUBS gf180mcu_as_sc_mcu7t3v3__inv_2
Xgf180mcu_as_sc_mcu7t3v3__inv_2_266 VSS VSS VSS gf180mcu_as_sc_mcu7t3v3__inv_2_267/Y
+ gf180mcu_as_sc_mcu7t3v3__inv_2_268/VNW VSUBS gf180mcu_as_sc_mcu7t3v3__inv_2
Xgf180mcu_as_sc_mcu7t3v3__inv_2_200 VSS VSS gf180mcu_as_sc_mcu7t3v3__inv_2_200/Y gf180mcu_as_sc_mcu7t3v3__inv_2_200/A
+ gf180mcu_as_sc_mcu7t3v3__inv_2_200/VNW VSUBS gf180mcu_as_sc_mcu7t3v3__inv_2
Xgf180mcu_as_sc_mcu7t3v3__inv_2_222 VSS VSS VSS gf180mcu_as_sc_mcu7t3v3__inv_2_223/Y
+ gf180mcu_as_sc_mcu7t3v3__inv_2_224/VNW VSUBS gf180mcu_as_sc_mcu7t3v3__inv_2
Xgf180mcu_as_sc_mcu7t3v3__inv_2_211 VSS VSS gf180mcu_as_sc_mcu7t3v3__inv_2_211/Y gf180mcu_as_sc_mcu7t3v3__inv_2_212/Y
+ gf180mcu_as_sc_mcu7t3v3__inv_2_212/VNW VSUBS gf180mcu_as_sc_mcu7t3v3__inv_2
Xgf180mcu_as_sc_mcu7t3v3__inv_2_255 VSS VSS VSS gf180mcu_as_sc_mcu7t3v3__inv_2_256/Y
+ gf180mcu_as_sc_mcu7t3v3__inv_2_257/VNW VSUBS gf180mcu_as_sc_mcu7t3v3__inv_2
Xgf180mcu_as_sc_mcu7t3v3__inv_2_244 VSS VSS gf180mcu_as_sc_mcu7t3v3__inv_2_244/Y gf180mcu_as_sc_mcu7t3v3__inv_2_245/Y
+ gf180mcu_as_sc_mcu7t3v3__inv_2_245/VNW VSUBS gf180mcu_as_sc_mcu7t3v3__inv_2
Xgf180mcu_as_sc_mcu7t3v3__inv_2_233 VSS VSS gf180mcu_as_sc_mcu7t3v3__inv_2_233/Y gf180mcu_as_sc_mcu7t3v3__inv_2_233/A
+ gf180mcu_as_sc_mcu7t3v3__inv_2_233/VNW VSUBS gf180mcu_as_sc_mcu7t3v3__inv_2
Xgf180mcu_as_sc_mcu7t3v3__inv_2_299 VSS VSS VSS gf180mcu_as_sc_mcu7t3v3__inv_2_304/Y
+ gf180mcu_as_sc_mcu7t3v3__inv_2_304/VNW VSUBS gf180mcu_as_sc_mcu7t3v3__inv_2
Xgf180mcu_as_sc_mcu7t3v3__inv_2_288 VSS VSS gf180mcu_as_sc_mcu7t3v3__inv_2_288/Y gf180mcu_as_sc_mcu7t3v3__inv_2_288/A
+ gf180mcu_as_sc_mcu7t3v3__inv_2_288/VNW VSUBS gf180mcu_as_sc_mcu7t3v3__inv_2
Xgf180mcu_as_sc_mcu7t3v3__inv_2_1518 VSS VSS gf180mcu_as_sc_mcu7t3v3__inv_2_1518/Y
+ gf180mcu_as_sc_mcu7t3v3__inv_2_1519/Y gf180mcu_as_sc_mcu7t3v3__inv_2_1519/VNW VSUBS
+ gf180mcu_as_sc_mcu7t3v3__inv_2
Xgf180mcu_as_sc_mcu7t3v3__inv_2_1529 VSS VSS gf180mcu_as_sc_mcu7t3v3__inv_2_1529/Y
+ gf180mcu_as_sc_mcu7t3v3__inv_2_1529/A gf180mcu_as_sc_mcu7t3v3__inv_2_1529/VNW VSUBS
+ gf180mcu_as_sc_mcu7t3v3__inv_2
Xgf180mcu_as_sc_mcu7t3v3__inv_2_1507 VSS VSS VSS gf180mcu_as_sc_mcu7t3v3__inv_2_1508/Y
+ gf180mcu_as_sc_mcu7t3v3__inv_2_1508/VNW VSUBS gf180mcu_as_sc_mcu7t3v3__inv_2
Xgf180mcu_as_sc_mcu7t3v3__nor2_2_1 gf180mcu_as_sc_mcu7t3v3__nor2_2_6/VDD gf180mcu_as_sc_mcu7t3v3__nor2_2_6/VSS
+ VSS VSS VSS gf180mcu_as_sc_mcu7t3v3__nor2_2_6/VNW VSUBS gf180mcu_as_sc_mcu7t3v3__nor2_2
Xgf180mcu_as_sc_mcu7t3v3__nand2_2_6 gf180mcu_as_sc_mcu7t3v3__nand3_2_9/VDD gf180mcu_as_sc_mcu7t3v3__nor2_2_7/VSS
+ VSS VSS VSS gf180mcu_as_sc_mcu7t3v3__nand3_2_9/VNW VSUBS gf180mcu_as_sc_mcu7t3v3__nand2_2
Xgf180mcu_as_sc_mcu7t3v3__inv_2_1304 VSS VSS gf180mcu_as_sc_mcu7t3v3__inv_2_1304/Y
+ gf180mcu_as_sc_mcu7t3v3__inv_2_1304/A gf180mcu_as_sc_mcu7t3v3__inv_2_1304/VNW VSUBS
+ gf180mcu_as_sc_mcu7t3v3__inv_2
Xgf180mcu_as_sc_mcu7t3v3__inv_2_1315 VSS VSS gf180mcu_as_sc_mcu7t3v3__inv_2_1315/Y
+ gf180mcu_as_sc_mcu7t3v3__inv_2_1316/Y gf180mcu_as_sc_mcu7t3v3__inv_2_1316/VNW VSUBS
+ gf180mcu_as_sc_mcu7t3v3__inv_2
Xgf180mcu_as_sc_mcu7t3v3__inv_2_1326 VSS VSS VSS gf180mcu_as_sc_mcu7t3v3__inv_2_1327/Y
+ gf180mcu_as_sc_mcu7t3v3__inv_2_1328/VNW VSUBS gf180mcu_as_sc_mcu7t3v3__inv_2
Xgf180mcu_as_sc_mcu7t3v3__inv_2_1359 VSS VSS gf180mcu_as_sc_mcu7t3v3__inv_2_1395/A
+ gf180mcu_as_sc_mcu7t3v3__inv_2_1359/A gf180mcu_as_sc_mcu7t3v3__inv_2_1395/VNW VSUBS
+ gf180mcu_as_sc_mcu7t3v3__inv_2
Xgf180mcu_as_sc_mcu7t3v3__inv_2_1337 VSS VSS VSS gf180mcu_as_sc_mcu7t3v3__inv_2_1353/Y
+ gf180mcu_as_sc_mcu7t3v3__inv_2_1353/VNW VSUBS gf180mcu_as_sc_mcu7t3v3__inv_2
Xgf180mcu_as_sc_mcu7t3v3__inv_2_1348 VSS VSS gf180mcu_as_sc_mcu7t3v3__inv_2_1348/Y
+ gf180mcu_as_sc_mcu7t3v3__inv_2_1348/A gf180mcu_as_sc_mcu7t3v3__inv_2_1348/VNW VSUBS
+ gf180mcu_as_sc_mcu7t3v3__inv_2
Xu_t028_011 u_t028_011/c0_w0_bl u_t028_011/c0_w0_br u_t028_011/c0_w1_bl u_t028_011/c0_w1_br
+ u_t028_011/c0_r0_rbl u_t028_011/c0_r1_rbl u_t028_011/c1_w0_bl u_t028_011/c1_w0_br
+ u_t028_011/c1_w1_bl u_t028_011/c1_w1_br u_t028_011/c1_r0_rbl u_t028_011/c1_r1_rbl
+ u_t028_011/c2_w0_bl u_t028_011/c2_w0_br u_t028_011/c2_w1_bl u_t028_011/c2_w1_br
+ u_t028_011/c2_r0_rbl u_t028_011/c2_r1_rbl u_t028_011/c3_w0_bl u_t028_011/c3_w0_br
+ u_t028_011/c3_w1_bl u_t028_011/c3_w1_br u_t028_011/c3_r0_rbl u_t028_011/c3_r1_rbl
+ u_t028_011/r0_w0_wl u_t028_011/r0_w1_wl u_t028_011/r0_r0_rwl u_t028_011/r0_r1_rwl
+ u_t028_011/r1_w0_wl u_t028_011/r1_w1_wl u_t028_011/r1_r0_rwl u_t028_011/r1_r1_rwl
+ u_t028_011/r2_w0_wl u_t028_011/r2_w1_wl u_t028_011/r2_r0_rwl u_t028_011/r2_r1_rwl
+ u_t028_011/r3_w0_wl u_t028_011/r3_w1_wl u_t028_011/r3_r0_rwl u_t028_011/r3_r1_rwl
+ VSS VSS u_t028_011/m2_717_1265# u_t028_011/m2_603_2031# u_t028_011/m2_1290_336#
+ u_t028_011/m2_2000_2037# u_t028_011/m2_791_2909# u_t028_011/m2_7_2126# u_t028_011/m2_2154_2081#
+ u_t028_011/m2_1795_2037# u_t028_011/m2_871_303# u_t028_011/m2_431_438# u_t028_011/m2_1290_2898#
+ u_t028_011/m2_1714_1210# u_t028_011/m2_431_1982# u_t028_011/m2_512_1265# u_t028_011/m2_2573_2126#
+ u_t028_011/m2_603_1259# u_t028_011/m2_2074_2909# u_t028_011/m2_7_336# u_t028_011/m2_717_2037#
+ u_t028_011/m2_1886_2031# u_t028_011/m2_2573_336# u_t028_011/m2_7_2898# u_t028_011/m2_2000_1265#
+ u_t028_011/m2_512_2037# u_t028_011/m2_1795_1265# u_t028_011/m2_1714_1982# u_t028_011/m2_1886_1259#
+ u_t028_011/m2_1290_2126# u_t028_011/m2_1714_438# u_t028_011/m2_431_1210# u_t028_011/m2_2573_2898#
+ u_t028_011/m2_2154_303# u_t028_011/m2_871_2081# VSUBS detronyx_12t_2w2r_rc4_4x4_routed_5layer_direct
Xu_t028_000 VSS u_t028_000/c0_w0_br VSS u_t028_000/c0_w1_br u_t028_000/c0_r0_rbl u_t028_000/c0_r1_rbl
+ VSS VSS VSS VSS VSS VSS u_t028_000/c2_w0_bl u_t028_000/c2_w0_br u_t028_000/c2_w1_bl
+ u_t028_000/c2_w1_br u_t028_000/c2_r0_rbl u_t028_000/c2_r1_rbl u_t028_000/c3_w0_bl
+ u_t028_000/c3_w0_br u_t028_000/c3_w1_bl u_t028_000/c3_w1_br u_t028_000/c3_r0_rbl
+ u_t028_000/c3_r1_rbl VSS VSS VSS VSS VSS VSS VSS VSS VSS VSS VSS VSS VSS VSS VSS
+ VSS VSS VSS u_t028_000/m2_717_1265# VSS VSS VSS VSS u_t028_000/m2_7_2126# VSS VSS
+ VSS VSS VSS VSS VSS u_t028_000/m2_512_1265# VSS u_t028_000/m2_603_1259# VSS VSS
+ VSS VSS VSS VSS u_t028_000/m2_2000_1265# VSS u_t028_000/m2_1795_1265# VSS u_t028_000/m2_1886_1259#
+ u_t028_000/m2_1290_2126# VSS VSS VSS VSS VSS VSUBS detronyx_12t_2w2r_rc4_4x4_routed_5layer_direct
Xgf180mcu_as_sc_mcu7t3v3__nand4_2_109 VSS VSS VSS VSS VSS VSS gf180mcu_as_sc_mcu7t3v3__inv_2_281/A
+ gf180mcu_as_sc_mcu7t3v3__inv_2_281/VNW VSUBS gf180mcu_as_sc_mcu7t3v3__nand4_2
Xu_t019_011 u_t019_011/c0_w0_bl u_t019_011/c0_w0_br u_t019_011/c0_w1_bl u_t019_011/c0_w1_br
+ u_t019_011/c0_r0_rbl u_t019_011/c0_r1_rbl u_t019_011/c1_w0_bl u_t019_011/c1_w0_br
+ u_t019_011/c1_w1_bl u_t019_011/c1_w1_br u_t019_011/c1_r0_rbl u_t019_011/c1_r1_rbl
+ u_t019_011/c2_w0_bl u_t019_011/c2_w0_br u_t019_011/c2_w1_bl u_t019_011/c2_w1_br
+ u_t019_011/c2_r0_rbl u_t019_011/c2_r1_rbl u_t019_011/c3_w0_bl u_t019_011/c3_w0_br
+ u_t019_011/c3_w1_bl u_t019_011/c3_w1_br u_t019_011/c3_r0_rbl u_t019_011/c3_r1_rbl
+ u_t019_011/r0_w0_wl u_t019_011/r0_w1_wl u_t019_011/r0_r0_rwl u_t019_011/r0_r1_rwl
+ u_t019_011/r1_w0_wl u_t019_011/r1_w1_wl u_t019_011/r1_r0_rwl u_t019_011/r1_r1_rwl
+ u_t019_011/r2_w0_wl u_t019_011/r2_w1_wl u_t019_011/r2_r0_rwl u_t019_011/r2_r1_rwl
+ u_t019_011/r3_w0_wl u_t019_011/r3_w1_wl u_t019_011/r3_r0_rwl u_t019_011/r3_r1_rwl
+ VSS VSS u_t019_011/m2_717_1265# u_t019_011/m2_603_2031# u_t019_011/m2_1290_336#
+ u_t019_011/m2_2000_2037# u_t019_011/m2_791_2909# u_t019_011/m2_7_2126# u_t019_011/m2_2154_2081#
+ u_t019_011/m2_1795_2037# u_t019_011/m2_871_303# u_t019_011/m2_431_438# u_t019_011/m2_1290_2898#
+ u_t019_011/m2_1714_1210# u_t019_011/m2_431_1982# u_t019_011/m2_512_1265# u_t019_011/m2_2573_2126#
+ u_t019_011/m2_603_1259# u_t019_011/m2_2074_2909# u_t019_011/m2_7_336# u_t019_011/m2_717_2037#
+ u_t019_011/m2_1886_2031# u_t019_011/m2_2573_336# u_t019_011/m2_7_2898# u_t019_011/m2_2000_1265#
+ u_t019_011/m2_512_2037# u_t019_011/m2_1795_1265# u_t019_011/m2_1714_1982# u_t019_011/m2_1886_1259#
+ u_t019_011/m2_1290_2126# u_t019_011/m2_1714_438# u_t019_011/m2_431_1210# u_t019_011/m2_2573_2898#
+ u_t019_011/m2_2154_303# u_t019_011/m2_871_2081# VSUBS detronyx_12t_2w2r_rc4_4x4_routed_5layer_direct
Xgf180mcu_as_sc_mcu7t3v3__nand4_2_15 VSS VSS VSS VSS VSS VSS gf180mcu_as_sc_mcu7t3v3__inv_2_125/A
+ gf180mcu_as_sc_mcu7t3v3__inv_2_125/VNW VSUBS gf180mcu_as_sc_mcu7t3v3__nand4_2
Xgf180mcu_as_sc_mcu7t3v3__nand4_2_37 VSS VSS VSS VSS VSS VSS gf180mcu_as_sc_mcu7t3v3__inv_2_193/A
+ gf180mcu_as_sc_mcu7t3v3__inv_2_193/VNW VSUBS gf180mcu_as_sc_mcu7t3v3__nand4_2
Xgf180mcu_as_sc_mcu7t3v3__nand4_2_26 VSS VSS VSS VSS VSS VSS gf180mcu_as_sc_mcu7t3v3__inv_2_157/A
+ gf180mcu_as_sc_mcu7t3v3__inv_2_177/VNW VSUBS gf180mcu_as_sc_mcu7t3v3__nand4_2
Xgf180mcu_as_sc_mcu7t3v3__nand4_2_48 VSS VSS VSS VSS VSS VSS gf180mcu_as_sc_mcu7t3v3__inv_2_224/A
+ gf180mcu_as_sc_mcu7t3v3__inv_2_224/VNW VSUBS gf180mcu_as_sc_mcu7t3v3__nand4_2
Xgf180mcu_as_sc_mcu7t3v3__nand4_2_59 VSS VSS VSS VSS VSS VSS gf180mcu_as_sc_mcu7t3v3__inv_2_257/A
+ gf180mcu_as_sc_mcu7t3v3__inv_2_257/VNW VSUBS gf180mcu_as_sc_mcu7t3v3__nand4_2
Xu_t019_000 VSS u_t019_000/c0_w0_br VSS u_t019_000/c0_w1_br u_t019_000/c0_r0_rbl u_t019_000/c0_r1_rbl
+ VSS VSS VSS VSS VSS VSS u_t019_000/c2_w0_bl u_t019_000/c2_w0_br u_t019_000/c2_w1_bl
+ u_t019_000/c2_w1_br u_t019_000/c2_r0_rbl u_t019_000/c2_r1_rbl u_t019_000/c3_w0_bl
+ u_t019_000/c3_w0_br u_t019_000/c3_w1_bl u_t019_000/c3_w1_br u_t019_000/c3_r0_rbl
+ u_t019_000/c3_r1_rbl VSS VSS VSS VSS VSS VSS VSS VSS VSS VSS VSS VSS VSS VSS VSS
+ VSS VSS VSS VSS VSS VSS VSS VSS VSS VSS VSS VSS VSS VSS VSS VSS VSS u_t019_000/m2_2573_2126#
+ VSS VSS VSS VSS VSS u_t019_000/m2_2573_336# VSS VSS VSS VSS u_t019_000/m2_1714_1982#
+ VSS VSS u_t019_000/m2_1714_438# VSS u_t019_000/m2_2573_2898# VSS VSS VSUBS detronyx_12t_2w2r_rc4_4x4_routed_5layer_direct
Xu_t025_014 u_t025_014/c0_w0_bl u_t025_014/c0_w0_br u_t025_014/c0_w1_bl u_t025_014/c0_w1_br
+ u_t025_014/c0_r0_rbl u_t025_014/c0_r1_rbl u_t025_014/c1_w0_bl u_t025_014/c1_w0_br
+ u_t025_014/c1_w1_bl u_t025_014/c1_w1_br u_t025_014/c1_r0_rbl u_t025_014/c1_r1_rbl
+ u_t025_014/c2_w0_bl u_t025_014/c2_w0_br u_t025_014/c2_w1_bl u_t025_014/c2_w1_br
+ u_t025_014/c2_r0_rbl u_t025_014/c2_r1_rbl u_t025_014/c3_w0_bl u_t025_014/c3_w0_br
+ u_t025_014/c3_w1_bl u_t025_014/c3_w1_br u_t025_014/c3_r0_rbl u_t025_014/c3_r1_rbl
+ u_t025_014/r0_w0_wl u_t025_014/r0_w1_wl u_t025_014/r0_r0_rwl u_t025_014/r0_r1_rwl
+ u_t025_014/r1_w0_wl u_t025_014/r1_w1_wl u_t025_014/r1_r0_rwl u_t025_014/r1_r1_rwl
+ u_t025_014/r2_w0_wl u_t025_014/r2_w1_wl u_t025_014/r2_r0_rwl u_t025_014/r2_r1_rwl
+ u_t025_014/r3_w0_wl u_t025_014/r3_w1_wl u_t025_014/r3_r0_rwl u_t025_014/r3_r1_rwl
+ VSS VSS u_t025_014/m2_717_1265# u_t025_014/m2_603_2031# u_t025_014/m2_1290_336#
+ u_t025_014/m2_2000_2037# u_t025_014/m2_791_2909# u_t025_014/m2_7_2126# u_t025_014/m2_2154_2081#
+ u_t025_014/m2_1795_2037# u_t025_014/m2_871_303# u_t025_014/m2_431_438# u_t025_014/m2_1290_2898#
+ u_t025_014/m2_1714_1210# u_t025_014/m2_431_1982# u_t025_014/m2_512_1265# u_t025_014/m2_2573_2126#
+ u_t025_014/m2_603_1259# u_t025_014/m2_2074_2909# u_t025_014/m2_7_336# u_t025_014/m2_717_2037#
+ u_t025_014/m2_1886_2031# u_t025_014/m2_2573_336# u_t025_014/m2_7_2898# u_t025_014/m2_2000_1265#
+ u_t025_014/m2_512_2037# u_t025_014/m2_1795_1265# u_t025_014/m2_1714_1982# u_t025_014/m2_1886_1259#
+ u_t025_014/m2_1290_2126# u_t025_014/m2_1714_438# u_t025_014/m2_431_1210# u_t025_014/m2_2573_2898#
+ u_t025_014/m2_2154_303# u_t025_014/m2_871_2081# VSUBS detronyx_12t_2w2r_rc4_4x4_routed_5layer_direct
Xu_t025_003 u_t025_003/c0_w0_bl u_t025_003/c0_w0_br u_t025_003/c0_w1_bl u_t025_003/c0_w1_br
+ u_t025_003/c0_r0_rbl u_t025_003/c0_r1_rbl u_t025_003/c1_w0_bl u_t025_003/c1_w0_br
+ u_t025_003/c1_w1_bl u_t025_003/c1_w1_br u_t025_003/c1_r0_rbl u_t025_003/c1_r1_rbl
+ u_t025_003/c2_w0_bl u_t025_003/c2_w0_br u_t025_003/c2_w1_bl u_t025_003/c2_w1_br
+ u_t025_003/c2_r0_rbl u_t025_003/c2_r1_rbl u_t025_003/c3_w0_bl u_t025_003/c3_w0_br
+ u_t025_003/c3_w1_bl u_t025_003/c3_w1_br u_t025_003/c3_r0_rbl u_t025_003/c3_r1_rbl
+ u_t025_003/r0_w0_wl u_t025_003/r0_w1_wl u_t025_003/r0_r0_rwl u_t025_003/r0_r1_rwl
+ u_t025_003/r1_w0_wl u_t025_003/r1_w1_wl u_t025_003/r1_r0_rwl u_t025_003/r1_r1_rwl
+ u_t025_003/r2_w0_wl u_t025_003/r2_w1_wl u_t025_003/r2_r0_rwl u_t025_003/r2_r1_rwl
+ u_t025_003/r3_w0_wl u_t025_003/r3_w1_wl u_t025_003/r3_r0_rwl u_t025_003/r3_r1_rwl
+ VSS VSS u_t025_003/m2_717_1265# u_t025_003/m2_603_2031# u_t025_003/m2_1290_336#
+ u_t025_003/m2_2000_2037# u_t025_003/m2_791_2909# u_t025_003/m2_7_2126# u_t025_003/m2_2154_2081#
+ u_t025_003/m2_1795_2037# u_t025_003/m2_871_303# u_t025_003/m2_431_438# u_t025_003/m2_1290_2898#
+ u_t025_003/m2_1714_1210# u_t025_003/m2_431_1982# u_t025_003/m2_512_1265# u_t025_003/m2_2573_2126#
+ u_t025_003/m2_603_1259# u_t025_003/m2_2074_2909# u_t025_003/m2_7_336# u_t025_003/m2_717_2037#
+ u_t025_003/m2_1886_2031# u_t025_003/m2_2573_336# u_t025_003/m2_7_2898# u_t025_003/m2_2000_1265#
+ u_t025_003/m2_512_2037# u_t025_003/m2_1795_1265# u_t025_003/m2_1714_1982# u_t025_003/m2_1886_1259#
+ u_t025_003/m2_1290_2126# u_t025_003/m2_1714_438# u_t025_003/m2_431_1210# u_t025_003/m2_2573_2898#
+ u_t025_003/m2_2154_303# u_t025_003/m2_871_2081# VSUBS detronyx_12t_2w2r_rc4_4x4_routed_5layer_direct
Xgf180mcu_as_sc_mcu7t3v3__inv_2_1134 VSS VSS VSS gf180mcu_as_sc_mcu7t3v3__inv_2_1135/Y
+ gf180mcu_as_sc_mcu7t3v3__inv_2_1136/VNW VSUBS gf180mcu_as_sc_mcu7t3v3__inv_2
Xgf180mcu_as_sc_mcu7t3v3__inv_2_1145 VSS VSS gf180mcu_as_sc_mcu7t3v3__inv_2_1145/Y
+ gf180mcu_as_sc_mcu7t3v3__inv_2_1145/A gf180mcu_as_sc_mcu7t3v3__inv_2_1145/VNW VSUBS
+ gf180mcu_as_sc_mcu7t3v3__inv_2
Xgf180mcu_as_sc_mcu7t3v3__inv_2_1123 VSS VSS gf180mcu_as_sc_mcu7t3v3__inv_2_1123/Y
+ gf180mcu_as_sc_mcu7t3v3__inv_2_1124/Y gf180mcu_as_sc_mcu7t3v3__inv_2_1124/VNW VSUBS
+ gf180mcu_as_sc_mcu7t3v3__inv_2
Xgf180mcu_as_sc_mcu7t3v3__inv_2_1156 VSS VSS gf180mcu_as_sc_mcu7t3v3__inv_2_1290/A
+ gf180mcu_as_sc_mcu7t3v3__inv_2_1157/Y gf180mcu_as_sc_mcu7t3v3__inv_2_1290/VNW VSUBS
+ gf180mcu_as_sc_mcu7t3v3__inv_2
Xgf180mcu_as_sc_mcu7t3v3__inv_2_1101 VSS VSS VSS gf180mcu_as_sc_mcu7t3v3__inv_2_1102/Y
+ gf180mcu_as_sc_mcu7t3v3__inv_2_1103/VNW VSUBS gf180mcu_as_sc_mcu7t3v3__inv_2
Xgf180mcu_as_sc_mcu7t3v3__inv_2_1167 VSS VSS gf180mcu_as_sc_mcu7t3v3__inv_2_1287/A
+ gf180mcu_as_sc_mcu7t3v3__inv_2_1169/Y gf180mcu_as_sc_mcu7t3v3__inv_2_1287/VNW VSUBS
+ gf180mcu_as_sc_mcu7t3v3__inv_2
Xgf180mcu_as_sc_mcu7t3v3__inv_2_1112 VSS VSS gf180mcu_as_sc_mcu7t3v3__inv_2_1112/Y
+ gf180mcu_as_sc_mcu7t3v3__inv_2_1112/A gf180mcu_as_sc_mcu7t3v3__inv_2_1112/VNW VSUBS
+ gf180mcu_as_sc_mcu7t3v3__inv_2
Xgf180mcu_as_sc_mcu7t3v3__inv_2_1189 VSS VSS gf180mcu_as_sc_mcu7t3v3__inv_2_1268/A
+ gf180mcu_as_sc_mcu7t3v3__inv_2_1190/Y gf180mcu_as_sc_mcu7t3v3__inv_2_1268/VNW VSUBS
+ gf180mcu_as_sc_mcu7t3v3__inv_2
Xgf180mcu_as_sc_mcu7t3v3__inv_2_1178 VSS VSS gf180mcu_as_sc_mcu7t3v3__inv_2_1288/A
+ gf180mcu_as_sc_mcu7t3v3__inv_2_1179/Y gf180mcu_as_sc_mcu7t3v3__inv_2_1288/VNW VSUBS
+ gf180mcu_as_sc_mcu7t3v3__inv_2
Xu_t016_014 u_t016_014/c0_w0_bl u_t016_014/c0_w0_br u_t016_014/c0_w1_bl u_t016_014/c0_w1_br
+ u_t016_014/c0_r0_rbl u_t016_014/c0_r1_rbl u_t016_014/c1_w0_bl u_t016_014/c1_w0_br
+ u_t016_014/c1_w1_bl u_t016_014/c1_w1_br u_t016_014/c1_r0_rbl u_t016_014/c1_r1_rbl
+ u_t016_014/c2_w0_bl u_t016_014/c2_w0_br u_t016_014/c2_w1_bl u_t016_014/c2_w1_br
+ u_t016_014/c2_r0_rbl u_t016_014/c2_r1_rbl u_t016_014/c3_w0_bl u_t016_014/c3_w0_br
+ u_t016_014/c3_w1_bl u_t016_014/c3_w1_br u_t016_014/c3_r0_rbl u_t016_014/c3_r1_rbl
+ u_t016_014/r0_w0_wl u_t016_014/r0_w1_wl u_t016_014/r0_r0_rwl u_t016_014/r0_r1_rwl
+ u_t016_014/r1_w0_wl u_t016_014/r1_w1_wl u_t016_014/r1_r0_rwl u_t016_014/r1_r1_rwl
+ u_t016_014/r2_w0_wl u_t016_014/r2_w1_wl u_t016_014/r2_r0_rwl u_t016_014/r2_r1_rwl
+ u_t016_014/r3_w0_wl u_t016_014/r3_w1_wl u_t016_014/r3_r0_rwl u_t016_014/r3_r1_rwl
+ VSS VSS u_t016_014/m2_717_1265# u_t016_014/m2_603_2031# u_t016_014/m2_1290_336#
+ u_t016_014/m2_2000_2037# u_t016_014/m2_791_2909# u_t016_014/m2_7_2126# u_t016_014/m2_2154_2081#
+ u_t016_014/m2_1795_2037# u_t016_014/m2_871_303# u_t016_014/m2_431_438# u_t016_014/m2_1290_2898#
+ u_t016_014/m2_1714_1210# u_t016_014/m2_431_1982# u_t016_014/m2_512_1265# u_t016_014/m2_2573_2126#
+ u_t016_014/m2_603_1259# u_t016_014/m2_2074_2909# u_t016_014/m2_7_336# u_t016_014/m2_717_2037#
+ u_t016_014/m2_1886_2031# u_t016_014/m2_2573_336# u_t016_014/m2_7_2898# u_t016_014/m2_2000_1265#
+ u_t016_014/m2_512_2037# u_t016_014/m2_1795_1265# u_t016_014/m2_1714_1982# u_t016_014/m2_1886_1259#
+ u_t016_014/m2_1290_2126# u_t016_014/m2_1714_438# u_t016_014/m2_431_1210# u_t016_014/m2_2573_2898#
+ u_t016_014/m2_2154_303# u_t016_014/m2_871_2081# VSUBS detronyx_12t_2w2r_rc4_4x4_routed_5layer_direct
Xu_t016_003 u_t016_003/c0_w0_bl u_t016_003/c0_w0_br u_t016_003/c0_w1_bl u_t016_003/c0_w1_br
+ u_t016_003/c0_r0_rbl u_t016_003/c0_r1_rbl u_t016_003/c1_w0_bl u_t016_003/c1_w0_br
+ u_t016_003/c1_w1_bl u_t016_003/c1_w1_br u_t016_003/c1_r0_rbl u_t016_003/c1_r1_rbl
+ u_t016_003/c2_w0_bl u_t016_003/c2_w0_br u_t016_003/c2_w1_bl u_t016_003/c2_w1_br
+ u_t016_003/c2_r0_rbl u_t016_003/c2_r1_rbl u_t016_003/c3_w0_bl u_t016_003/c3_w0_br
+ u_t016_003/c3_w1_bl u_t016_003/c3_w1_br u_t016_003/c3_r0_rbl u_t016_003/c3_r1_rbl
+ u_t016_003/r0_w0_wl u_t016_003/r0_w1_wl u_t016_003/r0_r0_rwl u_t016_003/r0_r1_rwl
+ u_t016_003/r1_w0_wl u_t016_003/r1_w1_wl u_t016_003/r1_r0_rwl u_t016_003/r1_r1_rwl
+ u_t016_003/r2_w0_wl u_t016_003/r2_w1_wl u_t016_003/r2_r0_rwl u_t016_003/r2_r1_rwl
+ u_t016_003/r3_w0_wl u_t016_003/r3_w1_wl u_t016_003/r3_r0_rwl u_t016_003/r3_r1_rwl
+ VSS VSS u_t016_003/m2_717_1265# u_t016_003/m2_603_2031# u_t016_003/m2_1290_336#
+ u_t016_003/m2_2000_2037# u_t016_003/m2_791_2909# u_t016_003/m2_7_2126# u_t016_003/m2_2154_2081#
+ u_t016_003/m2_1795_2037# u_t016_003/m2_871_303# u_t016_003/m2_431_438# u_t016_003/m2_1290_2898#
+ u_t016_003/m2_1714_1210# u_t016_003/m2_431_1982# u_t016_003/m2_512_1265# u_t016_003/m2_2573_2126#
+ u_t016_003/m2_603_1259# u_t016_003/m2_2074_2909# u_t016_003/m2_7_336# u_t016_003/m2_717_2037#
+ u_t016_003/m2_1886_2031# u_t016_003/m2_2573_336# u_t016_003/m2_7_2898# u_t016_003/m2_2000_1265#
+ u_t016_003/m2_512_2037# u_t016_003/m2_1795_1265# u_t016_003/m2_1714_1982# u_t016_003/m2_1886_1259#
+ u_t016_003/m2_1290_2126# u_t016_003/m2_1714_438# u_t016_003/m2_431_1210# u_t016_003/m2_2573_2898#
+ u_t016_003/m2_2154_303# u_t016_003/m2_871_2081# VSUBS detronyx_12t_2w2r_rc4_4x4_routed_5layer_direct
Xgf180mcu_as_sc_mcu7t3v3__inv_2_607 VSS VSS VSS gf180mcu_as_sc_mcu7t3v3__inv_2_607/A
+ gf180mcu_as_sc_mcu7t3v3__inv_2_607/VNW VSUBS gf180mcu_as_sc_mcu7t3v3__inv_2
Xgf180mcu_as_sc_mcu7t3v3__inv_2_618 VSS VSS VSS gf180mcu_as_sc_mcu7t3v3__inv_2_619/Y
+ gf180mcu_as_sc_mcu7t3v3__inv_2_620/VNW VSUBS gf180mcu_as_sc_mcu7t3v3__inv_2
Xu_t031_006 u_t031_006/c0_w0_bl u_t031_006/c0_w0_br u_t031_006/c0_w1_bl u_t031_006/c0_w1_br
+ u_t031_006/c0_r0_rbl u_t031_006/c0_r1_rbl u_t031_006/c1_w0_bl u_t031_006/c1_w0_br
+ u_t031_006/c1_w1_bl u_t031_006/c1_w1_br u_t031_006/c1_r0_rbl u_t031_006/c1_r1_rbl
+ u_t031_006/c2_w0_bl u_t031_006/c2_w0_br u_t031_006/c2_w1_bl u_t031_006/c2_w1_br
+ u_t031_006/c2_r0_rbl u_t031_006/c2_r1_rbl u_t031_006/c3_w0_bl u_t031_006/c3_w0_br
+ u_t031_006/c3_w1_bl u_t031_006/c3_w1_br u_t031_006/c3_r0_rbl u_t031_006/c3_r1_rbl
+ u_t031_006/r0_w0_wl u_t031_006/r0_w1_wl u_t031_006/r0_r0_rwl u_t031_006/r0_r1_rwl
+ u_t031_006/r1_w0_wl u_t031_006/r1_w1_wl u_t031_006/r1_r0_rwl u_t031_006/r1_r1_rwl
+ u_t031_006/r2_w0_wl u_t031_006/r2_w1_wl u_t031_006/r2_r0_rwl u_t031_006/r2_r1_rwl
+ u_t031_006/r3_w0_wl u_t031_006/r3_w1_wl u_t031_006/r3_r0_rwl u_t031_006/r3_r1_rwl
+ VSS VSS u_t031_006/m2_717_1265# u_t031_006/m2_603_2031# u_t031_006/m2_1290_336#
+ u_t031_006/m2_2000_2037# u_t031_006/m2_791_2909# u_t031_006/m2_7_2126# u_t031_006/m2_2154_2081#
+ u_t031_006/m2_1795_2037# u_t031_006/m2_871_303# u_t031_006/m2_431_438# u_t031_006/m2_1290_2898#
+ u_t031_006/m2_1714_1210# u_t031_006/m2_431_1982# u_t031_006/m2_512_1265# u_t031_006/m2_2573_2126#
+ u_t031_006/m2_603_1259# u_t031_006/m2_2074_2909# u_t031_006/m2_7_336# u_t031_006/m2_717_2037#
+ u_t031_006/m2_1886_2031# u_t031_006/m2_2573_336# u_t031_006/m2_7_2898# u_t031_006/m2_2000_1265#
+ u_t031_006/m2_512_2037# u_t031_006/m2_1795_1265# u_t031_006/m2_1714_1982# u_t031_006/m2_1886_1259#
+ u_t031_006/m2_1290_2126# u_t031_006/m2_1714_438# u_t031_006/m2_431_1210# u_t031_006/m2_2573_2898#
+ u_t031_006/m2_2154_303# u_t031_006/m2_871_2081# VSUBS detronyx_12t_2w2r_rc4_4x4_routed_5layer_direct
Xgf180mcu_as_sc_mcu7t3v3__inv_2_629 VSS VSS gf180mcu_as_sc_mcu7t3v3__inv_2_629/Y gf180mcu_as_sc_mcu7t3v3__inv_2_633/Y
+ gf180mcu_as_sc_mcu7t3v3__inv_2_633/VNW VSUBS gf180mcu_as_sc_mcu7t3v3__inv_2
Xgf180mcu_as_sc_mcu7t3v3__inv_2_1690 VSS VSS VSS gf180mcu_as_sc_mcu7t3v3__inv_2_1691/Y
+ gf180mcu_as_sc_mcu7t3v3__inv_2_1691/VNW VSUBS gf180mcu_as_sc_mcu7t3v3__inv_2
Xu_t007_014 u_t007_014/c0_w0_bl u_t007_014/c0_w0_br u_t007_014/c0_w1_bl u_t007_014/c0_w1_br
+ u_t007_014/c0_r0_rbl u_t007_014/c0_r1_rbl u_t007_014/c1_w0_bl u_t007_014/c1_w0_br
+ u_t007_014/c1_w1_bl u_t007_014/c1_w1_br u_t007_014/c1_r0_rbl u_t007_014/c1_r1_rbl
+ u_t007_014/c2_w0_bl u_t007_014/c2_w0_br u_t007_014/c2_w1_bl u_t007_014/c2_w1_br
+ u_t007_014/c2_r0_rbl u_t007_014/c2_r1_rbl u_t007_014/c3_w0_bl u_t007_014/c3_w0_br
+ u_t007_014/c3_w1_bl u_t007_014/c3_w1_br u_t007_014/c3_r0_rbl u_t007_014/c3_r1_rbl
+ u_t007_014/r0_w0_wl u_t007_014/r0_w1_wl u_t007_014/r0_r0_rwl u_t007_014/r0_r1_rwl
+ u_t007_014/r1_w0_wl u_t007_014/r1_w1_wl u_t007_014/r1_r0_rwl u_t007_014/r1_r1_rwl
+ u_t007_014/r2_w0_wl u_t007_014/r2_w1_wl u_t007_014/r2_r0_rwl u_t007_014/r2_r1_rwl
+ u_t007_014/r3_w0_wl u_t007_014/r3_w1_wl u_t007_014/r3_r0_rwl u_t007_014/r3_r1_rwl
+ VSS VSS u_t007_014/m2_717_1265# u_t007_014/m2_603_2031# u_t007_014/m2_1290_336#
+ u_t007_014/m2_2000_2037# u_t007_014/m2_791_2909# u_t007_014/m2_7_2126# u_t007_014/m2_2154_2081#
+ u_t007_014/m2_1795_2037# u_t007_014/m2_871_303# u_t007_014/m2_431_438# u_t007_014/m2_1290_2898#
+ u_t007_014/m2_1714_1210# u_t007_014/m2_431_1982# u_t007_014/m2_512_1265# u_t007_014/m2_2573_2126#
+ u_t007_014/m2_603_1259# u_t007_014/m2_2074_2909# u_t007_014/m2_7_336# u_t007_014/m2_717_2037#
+ u_t007_014/m2_1886_2031# u_t007_014/m2_2573_336# u_t007_014/m2_7_2898# u_t007_014/m2_2000_1265#
+ u_t007_014/m2_512_2037# u_t007_014/m2_1795_1265# u_t007_014/m2_1714_1982# u_t007_014/m2_1886_1259#
+ u_t007_014/m2_1290_2126# u_t007_014/m2_1714_438# u_t007_014/m2_431_1210# u_t007_014/m2_2573_2898#
+ u_t007_014/m2_2154_303# u_t007_014/m2_871_2081# VSUBS detronyx_12t_2w2r_rc4_4x4_routed_5layer_direct
Xu_t022_006 u_t022_006/c0_w0_bl u_t022_006/c0_w0_br u_t022_006/c0_w1_bl u_t022_006/c0_w1_br
+ u_t022_006/c0_r0_rbl u_t022_006/c0_r1_rbl u_t022_006/c1_w0_bl u_t022_006/c1_w0_br
+ u_t022_006/c1_w1_bl u_t022_006/c1_w1_br u_t022_006/c1_r0_rbl u_t022_006/c1_r1_rbl
+ u_t022_006/c2_w0_bl u_t022_006/c2_w0_br u_t022_006/c2_w1_bl u_t022_006/c2_w1_br
+ u_t022_006/c2_r0_rbl u_t022_006/c2_r1_rbl u_t022_006/c3_w0_bl u_t022_006/c3_w0_br
+ u_t022_006/c3_w1_bl u_t022_006/c3_w1_br u_t022_006/c3_r0_rbl u_t022_006/c3_r1_rbl
+ u_t022_006/r0_w0_wl u_t022_006/r0_w1_wl u_t022_006/r0_r0_rwl u_t022_006/r0_r1_rwl
+ u_t022_006/r1_w0_wl u_t022_006/r1_w1_wl u_t022_006/r1_r0_rwl u_t022_006/r1_r1_rwl
+ u_t022_006/r2_w0_wl u_t022_006/r2_w1_wl u_t022_006/r2_r0_rwl u_t022_006/r2_r1_rwl
+ u_t022_006/r3_w0_wl u_t022_006/r3_w1_wl u_t022_006/r3_r0_rwl u_t022_006/r3_r1_rwl
+ VSS VSS u_t022_006/m2_717_1265# u_t022_006/m2_603_2031# u_t022_006/m2_1290_336#
+ u_t022_006/m2_2000_2037# u_t022_006/m2_791_2909# u_t022_006/m2_7_2126# u_t022_006/m2_2154_2081#
+ u_t022_006/m2_1795_2037# u_t022_006/m2_871_303# u_t022_006/m2_431_438# u_t022_006/m2_1290_2898#
+ u_t022_006/m2_1714_1210# u_t022_006/m2_431_1982# u_t022_006/m2_512_1265# u_t022_006/m2_2573_2126#
+ u_t022_006/m2_603_1259# u_t022_006/m2_2074_2909# u_t022_006/m2_7_336# u_t022_006/m2_717_2037#
+ u_t022_006/m2_1886_2031# u_t022_006/m2_2573_336# u_t022_006/m2_7_2898# u_t022_006/m2_2000_1265#
+ u_t022_006/m2_512_2037# u_t022_006/m2_1795_1265# u_t022_006/m2_1714_1982# u_t022_006/m2_1886_1259#
+ u_t022_006/m2_1290_2126# u_t022_006/m2_1714_438# u_t022_006/m2_431_1210# u_t022_006/m2_2573_2898#
+ u_t022_006/m2_2154_303# u_t022_006/m2_871_2081# VSUBS detronyx_12t_2w2r_rc4_4x4_routed_5layer_direct
Xu_t007_003 u_t007_003/c0_w0_bl u_t007_003/c0_w0_br u_t007_003/c0_w1_bl u_t007_003/c0_w1_br
+ u_t007_003/c0_r0_rbl u_t007_003/c0_r1_rbl u_t007_003/c1_w0_bl u_t007_003/c1_w0_br
+ u_t007_003/c1_w1_bl u_t007_003/c1_w1_br u_t007_003/c1_r0_rbl u_t007_003/c1_r1_rbl
+ u_t007_003/c2_w0_bl u_t007_003/c2_w0_br u_t007_003/c2_w1_bl u_t007_003/c2_w1_br
+ u_t007_003/c2_r0_rbl u_t007_003/c2_r1_rbl u_t007_003/c3_w0_bl u_t007_003/c3_w0_br
+ u_t007_003/c3_w1_bl u_t007_003/c3_w1_br u_t007_003/c3_r0_rbl u_t007_003/c3_r1_rbl
+ u_t007_003/r0_w0_wl u_t007_003/r0_w1_wl u_t007_003/r0_r0_rwl u_t007_003/r0_r1_rwl
+ u_t007_003/r1_w0_wl u_t007_003/r1_w1_wl u_t007_003/r1_r0_rwl u_t007_003/r1_r1_rwl
+ u_t007_003/r2_w0_wl u_t007_003/r2_w1_wl u_t007_003/r2_r0_rwl u_t007_003/r2_r1_rwl
+ u_t007_003/r3_w0_wl u_t007_003/r3_w1_wl u_t007_003/r3_r0_rwl u_t007_003/r3_r1_rwl
+ VSS VSS u_t007_003/m2_717_1265# u_t007_003/m2_603_2031# u_t007_003/m2_1290_336#
+ u_t007_003/m2_2000_2037# u_t007_003/m2_791_2909# u_t007_003/m2_7_2126# u_t007_003/m2_2154_2081#
+ u_t007_003/m2_1795_2037# u_t007_003/m2_871_303# u_t007_003/m2_431_438# u_t007_003/m2_1290_2898#
+ u_t007_003/m2_1714_1210# u_t007_003/m2_431_1982# u_t007_003/m2_512_1265# u_t007_003/m2_2573_2126#
+ u_t007_003/m2_603_1259# u_t007_003/m2_2074_2909# u_t007_003/m2_7_336# u_t007_003/m2_717_2037#
+ u_t007_003/m2_1886_2031# u_t007_003/m2_2573_336# u_t007_003/m2_7_2898# u_t007_003/m2_2000_1265#
+ u_t007_003/m2_512_2037# u_t007_003/m2_1795_1265# u_t007_003/m2_1714_1982# u_t007_003/m2_1886_1259#
+ u_t007_003/m2_1290_2126# u_t007_003/m2_1714_438# u_t007_003/m2_431_1210# u_t007_003/m2_2573_2898#
+ u_t007_003/m2_2154_303# u_t007_003/m2_871_2081# VSUBS detronyx_12t_2w2r_rc4_4x4_routed_5layer_direct
Xgf180mcu_as_sc_mcu7t3v3__nand4_2_440 VSS VSS VSS VSS VSS VSS gf180mcu_as_sc_mcu7t3v3__inv_2_1591/A
+ gf180mcu_as_sc_mcu7t3v3__inv_2_1591/VNW VSUBS gf180mcu_as_sc_mcu7t3v3__nand4_2
Xgf180mcu_as_sc_mcu7t3v3__nand4_2_495 VSS VSS VSS VSS VSS VSS gf180mcu_as_sc_mcu7t3v3__inv_2_1618/A
+ gf180mcu_as_sc_mcu7t3v3__inv_2_1618/VNW VSUBS gf180mcu_as_sc_mcu7t3v3__nand4_2
Xgf180mcu_as_sc_mcu7t3v3__nand4_2_484 VSS VSS VSS VSS VSS VSS gf180mcu_as_sc_mcu7t3v3__inv_2_1660/A
+ gf180mcu_as_sc_mcu7t3v3__inv_2_1660/VNW VSUBS gf180mcu_as_sc_mcu7t3v3__nand4_2
Xgf180mcu_as_sc_mcu7t3v3__nand4_2_473 VSS VSS VSS VSS VSS VSS gf180mcu_as_sc_mcu7t3v3__inv_2_1398/A
+ gf180mcu_as_sc_mcu7t3v3__inv_2_1398/VNW VSUBS gf180mcu_as_sc_mcu7t3v3__nand4_2
Xgf180mcu_as_sc_mcu7t3v3__nand4_2_462 VSS VSS VSS VSS VSS VSS gf180mcu_as_sc_mcu7t3v3__inv_2_1321/A
+ gf180mcu_as_sc_mcu7t3v3__inv_2_1353/VNW VSUBS gf180mcu_as_sc_mcu7t3v3__nand4_2
Xgf180mcu_as_sc_mcu7t3v3__nand4_2_451 VSS VSS VSS VSS VSS VSS gf180mcu_as_sc_mcu7t3v3__inv_2_1340/A
+ gf180mcu_as_sc_mcu7t3v3__inv_2_1340/VNW VSUBS gf180mcu_as_sc_mcu7t3v3__nand4_2
Xu_t013_006 u_t013_006/c0_w0_bl u_t013_006/c0_w0_br u_t013_006/c0_w1_bl u_t013_006/c0_w1_br
+ u_t013_006/c0_r0_rbl u_t013_006/c0_r1_rbl u_t013_006/c1_w0_bl u_t013_006/c1_w0_br
+ u_t013_006/c1_w1_bl u_t013_006/c1_w1_br u_t013_006/c1_r0_rbl u_t013_006/c1_r1_rbl
+ u_t013_006/c2_w0_bl u_t013_006/c2_w0_br u_t013_006/c2_w1_bl u_t013_006/c2_w1_br
+ u_t013_006/c2_r0_rbl u_t013_006/c2_r1_rbl u_t013_006/c3_w0_bl u_t013_006/c3_w0_br
+ u_t013_006/c3_w1_bl u_t013_006/c3_w1_br u_t013_006/c3_r0_rbl u_t013_006/c3_r1_rbl
+ u_t013_006/r0_w0_wl u_t013_006/r0_w1_wl u_t013_006/r0_r0_rwl u_t013_006/r0_r1_rwl
+ u_t013_006/r1_w0_wl u_t013_006/r1_w1_wl u_t013_006/r1_r0_rwl u_t013_006/r1_r1_rwl
+ u_t013_006/r2_w0_wl u_t013_006/r2_w1_wl u_t013_006/r2_r0_rwl u_t013_006/r2_r1_rwl
+ u_t013_006/r3_w0_wl u_t013_006/r3_w1_wl u_t013_006/r3_r0_rwl u_t013_006/r3_r1_rwl
+ VSS VSS u_t013_006/m2_717_1265# u_t013_006/m2_603_2031# u_t013_006/m2_1290_336#
+ u_t013_006/m2_2000_2037# u_t013_006/m2_791_2909# u_t013_006/m2_7_2126# u_t013_006/m2_2154_2081#
+ u_t013_006/m2_1795_2037# u_t013_006/m2_871_303# u_t013_006/m2_431_438# u_t013_006/m2_1290_2898#
+ u_t013_006/m2_1714_1210# u_t013_006/m2_431_1982# u_t013_006/m2_512_1265# u_t013_006/m2_2573_2126#
+ u_t013_006/m2_603_1259# u_t013_006/m2_2074_2909# u_t013_006/m2_7_336# u_t013_006/m2_717_2037#
+ u_t013_006/m2_1886_2031# u_t013_006/m2_2573_336# u_t013_006/m2_7_2898# u_t013_006/m2_2000_1265#
+ u_t013_006/m2_512_2037# u_t013_006/m2_1795_1265# u_t013_006/m2_1714_1982# u_t013_006/m2_1886_1259#
+ u_t013_006/m2_1290_2126# u_t013_006/m2_1714_438# u_t013_006/m2_431_1210# u_t013_006/m2_2573_2898#
+ u_t013_006/m2_2154_303# u_t013_006/m2_871_2081# VSUBS detronyx_12t_2w2r_rc4_4x4_routed_5layer_direct
Xu_t004_006 u_t004_006/c0_w0_bl u_t004_006/c0_w0_br u_t004_006/c0_w1_bl u_t004_006/c0_w1_br
+ u_t004_006/c0_r0_rbl u_t004_006/c0_r1_rbl u_t004_006/c1_w0_bl u_t004_006/c1_w0_br
+ u_t004_006/c1_w1_bl u_t004_006/c1_w1_br u_t004_006/c1_r0_rbl u_t004_006/c1_r1_rbl
+ u_t004_006/c2_w0_bl u_t004_006/c2_w0_br u_t004_006/c2_w1_bl u_t004_006/c2_w1_br
+ u_t004_006/c2_r0_rbl u_t004_006/c2_r1_rbl u_t004_006/c3_w0_bl u_t004_006/c3_w0_br
+ u_t004_006/c3_w1_bl u_t004_006/c3_w1_br u_t004_006/c3_r0_rbl u_t004_006/c3_r1_rbl
+ u_t004_006/r0_w0_wl u_t004_006/r0_w1_wl u_t004_006/r0_r0_rwl u_t004_006/r0_r1_rwl
+ u_t004_006/r1_w0_wl u_t004_006/r1_w1_wl u_t004_006/r1_r0_rwl u_t004_006/r1_r1_rwl
+ u_t004_006/r2_w0_wl u_t004_006/r2_w1_wl u_t004_006/r2_r0_rwl u_t004_006/r2_r1_rwl
+ u_t004_006/r3_w0_wl u_t004_006/r3_w1_wl u_t004_006/r3_r0_rwl u_t004_006/r3_r1_rwl
+ VSS VSS u_t004_006/m2_717_1265# u_t004_006/m2_603_2031# u_t004_006/m2_1290_336#
+ u_t004_006/m2_2000_2037# u_t004_006/m2_791_2909# u_t004_006/m2_7_2126# u_t004_006/m2_2154_2081#
+ u_t004_006/m2_1795_2037# u_t004_006/m2_871_303# u_t004_006/m2_431_438# u_t004_006/m2_1290_2898#
+ u_t004_006/m2_1714_1210# u_t004_006/m2_431_1982# u_t004_006/m2_512_1265# u_t004_006/m2_2573_2126#
+ u_t004_006/m2_603_1259# u_t004_006/m2_2074_2909# u_t004_006/m2_7_336# u_t004_006/m2_717_2037#
+ u_t004_006/m2_1886_2031# u_t004_006/m2_2573_336# u_t004_006/m2_7_2898# u_t004_006/m2_2000_1265#
+ u_t004_006/m2_512_2037# u_t004_006/m2_1795_1265# u_t004_006/m2_1714_1982# u_t004_006/m2_1886_1259#
+ u_t004_006/m2_1290_2126# u_t004_006/m2_1714_438# u_t004_006/m2_431_1210# u_t004_006/m2_2573_2898#
+ u_t004_006/m2_2154_303# u_t004_006/m2_871_2081# VSUBS detronyx_12t_2w2r_rc4_4x4_routed_5layer_direct
Xgf180mcu_as_sc_mcu7t3v3__inv_2_448 VSS VSS gf180mcu_as_sc_mcu7t3v3__inv_2_546/A gf180mcu_as_sc_mcu7t3v3__inv_2_453/Y
+ gf180mcu_as_sc_mcu7t3v3__inv_2_546/VNW VSUBS gf180mcu_as_sc_mcu7t3v3__inv_2
Xgf180mcu_as_sc_mcu7t3v3__inv_2_459 VSS VSS gf180mcu_as_sc_mcu7t3v3__inv_2_459/Y gf180mcu_as_sc_mcu7t3v3__inv_2_459/A
+ gf180mcu_as_sc_mcu7t3v3__inv_2_544/VNW VSUBS gf180mcu_as_sc_mcu7t3v3__inv_2
Xgf180mcu_as_sc_mcu7t3v3__inv_2_426 gf180mcu_as_sc_mcu7t3v3__nor2_2_6/VDD gf180mcu_as_sc_mcu7t3v3__nor2_2_6/VSS
+ VSS VSS gf180mcu_as_sc_mcu7t3v3__nor2_2_6/VNW VSUBS gf180mcu_as_sc_mcu7t3v3__inv_2
Xgf180mcu_as_sc_mcu7t3v3__inv_2_404 gf180mcu_as_sc_mcu7t3v3__nor2_2_7/VDD gf180mcu_as_sc_mcu7t3v3__nor2_2_7/VSS
+ VSS VSS gf180mcu_as_sc_mcu7t3v3__nor2_2_7/VNW VSUBS gf180mcu_as_sc_mcu7t3v3__inv_2
Xgf180mcu_as_sc_mcu7t3v3__inv_2_415 gf180mcu_as_sc_mcu7t3v3__nand3_2_9/VDD gf180mcu_as_sc_mcu7t3v3__nor2_2_7/VSS
+ VSS VSS gf180mcu_as_sc_mcu7t3v3__nand3_2_9/VNW VSUBS gf180mcu_as_sc_mcu7t3v3__inv_2
Xgf180mcu_as_sc_mcu7t3v3__inv_2_437 gf180mcu_as_sc_mcu7t3v3__nor2_2_4/VDD gf180mcu_as_sc_mcu7t3v3__nor2_2_4/VSS
+ VSS VSS gf180mcu_as_sc_mcu7t3v3__nor2_2_4/VNW VSUBS gf180mcu_as_sc_mcu7t3v3__inv_2
Xgf180mcu_as_sc_mcu7t3v3__inv_2_960 VSS VSS gf180mcu_as_sc_mcu7t3v3__inv_2_960/Y gf180mcu_as_sc_mcu7t3v3__inv_2_960/A
+ gf180mcu_as_sc_mcu7t3v3__inv_2_960/VNW VSUBS gf180mcu_as_sc_mcu7t3v3__inv_2
Xgf180mcu_as_sc_mcu7t3v3__inv_2_982 VSS VSS VSS gf180mcu_as_sc_mcu7t3v3__inv_2_983/Y
+ gf180mcu_as_sc_mcu7t3v3__inv_2_984/VNW VSUBS gf180mcu_as_sc_mcu7t3v3__inv_2
Xgf180mcu_as_sc_mcu7t3v3__inv_2_993 VSS VSS VSS gf180mcu_as_sc_mcu7t3v3__inv_2_997/Y
+ gf180mcu_as_sc_mcu7t3v3__inv_2_997/VNW VSUBS gf180mcu_as_sc_mcu7t3v3__inv_2
Xgf180mcu_as_sc_mcu7t3v3__inv_2_971 VSS VSS gf180mcu_as_sc_mcu7t3v3__inv_2_971/Y gf180mcu_as_sc_mcu7t3v3__inv_2_972/Y
+ gf180mcu_as_sc_mcu7t3v3__inv_2_972/VNW VSUBS gf180mcu_as_sc_mcu7t3v3__inv_2
Xu_t010_009 u_t010_009/c0_w0_bl u_t010_009/c0_w0_br u_t010_009/c0_w1_bl u_t010_009/c0_w1_br
+ u_t010_009/c0_r0_rbl u_t010_009/c0_r1_rbl u_t010_009/c1_w0_bl u_t010_009/c1_w0_br
+ u_t010_009/c1_w1_bl u_t010_009/c1_w1_br u_t010_009/c1_r0_rbl u_t010_009/c1_r1_rbl
+ u_t010_009/c2_w0_bl u_t010_009/c2_w0_br u_t010_009/c2_w1_bl u_t010_009/c2_w1_br
+ u_t010_009/c2_r0_rbl u_t010_009/c2_r1_rbl u_t010_009/c3_w0_bl u_t010_009/c3_w0_br
+ u_t010_009/c3_w1_bl u_t010_009/c3_w1_br u_t010_009/c3_r0_rbl u_t010_009/c3_r1_rbl
+ u_t010_009/r0_w0_wl u_t010_009/r0_w1_wl u_t010_009/r0_r0_rwl u_t010_009/r0_r1_rwl
+ u_t010_009/r1_w0_wl u_t010_009/r1_w1_wl u_t010_009/r1_r0_rwl u_t010_009/r1_r1_rwl
+ u_t010_009/r2_w0_wl u_t010_009/r2_w1_wl u_t010_009/r2_r0_rwl u_t010_009/r2_r1_rwl
+ u_t010_009/r3_w0_wl u_t010_009/r3_w1_wl u_t010_009/r3_r0_rwl u_t010_009/r3_r1_rwl
+ VSS VSS u_t010_009/m2_717_1265# u_t010_009/m2_603_2031# u_t010_009/m2_1290_336#
+ u_t010_009/m2_2000_2037# u_t010_009/m2_791_2909# u_t010_009/m2_7_2126# u_t010_009/m2_2154_2081#
+ u_t010_009/m2_1795_2037# u_t010_009/m2_871_303# u_t010_009/m2_431_438# u_t010_009/m2_1290_2898#
+ u_t010_009/m2_1714_1210# u_t010_009/m2_431_1982# u_t010_009/m2_512_1265# u_t010_009/m2_2573_2126#
+ u_t010_009/m2_603_1259# u_t010_009/m2_2074_2909# u_t010_009/m2_7_336# u_t010_009/m2_717_2037#
+ u_t010_009/m2_1886_2031# u_t010_009/m2_2573_336# u_t010_009/m2_7_2898# u_t010_009/m2_2000_1265#
+ u_t010_009/m2_512_2037# u_t010_009/m2_1795_1265# u_t010_009/m2_1714_1982# u_t010_009/m2_1886_1259#
+ u_t010_009/m2_1290_2126# u_t010_009/m2_1714_438# u_t010_009/m2_431_1210# u_t010_009/m2_2573_2898#
+ u_t010_009/m2_2154_303# u_t010_009/m2_871_2081# VSUBS detronyx_12t_2w2r_rc4_4x4_routed_5layer_direct
Xgf180mcu_as_sc_mcu7t3v3__nand4_2_281 VSS VSS VSS VSS VSS VSS gf180mcu_as_sc_mcu7t3v3__inv_2_923/A
+ gf180mcu_as_sc_mcu7t3v3__inv_2_948/VNW VSUBS gf180mcu_as_sc_mcu7t3v3__nand4_2
Xgf180mcu_as_sc_mcu7t3v3__nand4_2_270 VSS VSS VSS VSS VSS VSS gf180mcu_as_sc_mcu7t3v3__inv_2_900/A
+ gf180mcu_as_sc_mcu7t3v3__inv_2_950/VNW VSUBS gf180mcu_as_sc_mcu7t3v3__nand4_2
Xgf180mcu_as_sc_mcu7t3v3__nand4_2_292 VSS VSS VSS VSS VSS VSS gf180mcu_as_sc_mcu7t3v3__inv_2_992/A
+ gf180mcu_as_sc_mcu7t3v3__inv_2_992/VNW VSUBS gf180mcu_as_sc_mcu7t3v3__nand4_2
Xu_t001_009 u_t001_009/c0_w0_bl u_t001_009/c0_w0_br u_t001_009/c0_w1_bl u_t001_009/c0_w1_br
+ u_t001_009/c0_r0_rbl u_t001_009/c0_r1_rbl u_t001_009/c1_w0_bl u_t001_009/c1_w0_br
+ u_t001_009/c1_w1_bl u_t001_009/c1_w1_br u_t001_009/c1_r0_rbl u_t001_009/c1_r1_rbl
+ u_t001_009/c2_w0_bl u_t001_009/c2_w0_br u_t001_009/c2_w1_bl u_t001_009/c2_w1_br
+ u_t001_009/c2_r0_rbl u_t001_009/c2_r1_rbl u_t001_009/c3_w0_bl u_t001_009/c3_w0_br
+ u_t001_009/c3_w1_bl u_t001_009/c3_w1_br u_t001_009/c3_r0_rbl u_t001_009/c3_r1_rbl
+ u_t001_009/r0_w0_wl u_t001_009/r0_w1_wl u_t001_009/r0_r0_rwl u_t001_009/r0_r1_rwl
+ u_t001_009/r1_w0_wl u_t001_009/r1_w1_wl u_t001_009/r1_r0_rwl u_t001_009/r1_r1_rwl
+ u_t001_009/r2_w0_wl u_t001_009/r2_w1_wl u_t001_009/r2_r0_rwl u_t001_009/r2_r1_rwl
+ u_t001_009/r3_w0_wl u_t001_009/r3_w1_wl u_t001_009/r3_r0_rwl u_t001_009/r3_r1_rwl
+ VSS VSS u_t001_009/m2_717_1265# u_t001_009/m2_603_2031# u_t001_009/m2_1290_336#
+ u_t001_009/m2_2000_2037# u_t001_009/m2_791_2909# u_t001_009/m2_7_2126# u_t001_009/m2_2154_2081#
+ u_t001_009/m2_1795_2037# u_t001_009/m2_871_303# u_t001_009/m2_431_438# u_t001_009/m2_1290_2898#
+ u_t001_009/m2_1714_1210# u_t001_009/m2_431_1982# u_t001_009/m2_512_1265# u_t001_009/m2_2573_2126#
+ u_t001_009/m2_603_1259# u_t001_009/m2_2074_2909# u_t001_009/m2_7_336# u_t001_009/m2_717_2037#
+ u_t001_009/m2_1886_2031# u_t001_009/m2_2573_336# u_t001_009/m2_7_2898# u_t001_009/m2_2000_1265#
+ u_t001_009/m2_512_2037# u_t001_009/m2_1795_1265# u_t001_009/m2_1714_1982# u_t001_009/m2_1886_1259#
+ u_t001_009/m2_1290_2126# u_t001_009/m2_1714_438# u_t001_009/m2_431_1210# u_t001_009/m2_2573_2898#
+ u_t001_009/m2_2154_303# u_t001_009/m2_871_2081# VSUBS detronyx_12t_2w2r_rc4_4x4_routed_5layer_direct
Xgf180mcu_as_sc_mcu7t3v3__inv_2_267 VSS VSS gf180mcu_as_sc_mcu7t3v3__inv_2_267/Y gf180mcu_as_sc_mcu7t3v3__inv_2_268/Y
+ gf180mcu_as_sc_mcu7t3v3__inv_2_268/VNW VSUBS gf180mcu_as_sc_mcu7t3v3__inv_2
Xgf180mcu_as_sc_mcu7t3v3__inv_2_201 VSS VSS VSS gf180mcu_as_sc_mcu7t3v3__inv_2_202/Y
+ gf180mcu_as_sc_mcu7t3v3__inv_2_203/VNW VSUBS gf180mcu_as_sc_mcu7t3v3__inv_2
Xgf180mcu_as_sc_mcu7t3v3__inv_2_278 VSS VSS gf180mcu_as_sc_mcu7t3v3__inv_2_278/Y gf180mcu_as_sc_mcu7t3v3__inv_2_279/Y
+ gf180mcu_as_sc_mcu7t3v3__inv_2_279/VNW VSUBS gf180mcu_as_sc_mcu7t3v3__inv_2
Xgf180mcu_as_sc_mcu7t3v3__inv_2_289 VSS VSS VSS gf180mcu_as_sc_mcu7t3v3__inv_2_293/Y
+ gf180mcu_as_sc_mcu7t3v3__inv_2_297/VNW VSUBS gf180mcu_as_sc_mcu7t3v3__inv_2
Xgf180mcu_as_sc_mcu7t3v3__inv_2_223 VSS VSS gf180mcu_as_sc_mcu7t3v3__inv_2_223/Y gf180mcu_as_sc_mcu7t3v3__inv_2_224/Y
+ gf180mcu_as_sc_mcu7t3v3__inv_2_224/VNW VSUBS gf180mcu_as_sc_mcu7t3v3__inv_2
Xgf180mcu_as_sc_mcu7t3v3__inv_2_212 VSS VSS gf180mcu_as_sc_mcu7t3v3__inv_2_212/Y gf180mcu_as_sc_mcu7t3v3__inv_2_212/A
+ gf180mcu_as_sc_mcu7t3v3__inv_2_212/VNW VSUBS gf180mcu_as_sc_mcu7t3v3__inv_2
Xgf180mcu_as_sc_mcu7t3v3__inv_2_256 VSS VSS gf180mcu_as_sc_mcu7t3v3__inv_2_256/Y gf180mcu_as_sc_mcu7t3v3__inv_2_257/Y
+ gf180mcu_as_sc_mcu7t3v3__inv_2_257/VNW VSUBS gf180mcu_as_sc_mcu7t3v3__inv_2
Xgf180mcu_as_sc_mcu7t3v3__inv_2_245 VSS VSS gf180mcu_as_sc_mcu7t3v3__inv_2_245/Y gf180mcu_as_sc_mcu7t3v3__inv_2_245/A
+ gf180mcu_as_sc_mcu7t3v3__inv_2_245/VNW VSUBS gf180mcu_as_sc_mcu7t3v3__inv_2
Xgf180mcu_as_sc_mcu7t3v3__inv_2_234 VSS VSS VSS gf180mcu_as_sc_mcu7t3v3__inv_2_235/Y
+ gf180mcu_as_sc_mcu7t3v3__inv_2_236/VNW VSUBS gf180mcu_as_sc_mcu7t3v3__inv_2
Xgf180mcu_as_sc_mcu7t3v3__inv_2_790 VSS VSS gf180mcu_as_sc_mcu7t3v3__inv_2_790/Y gf180mcu_as_sc_mcu7t3v3__inv_2_790/A
+ gf180mcu_as_sc_mcu7t3v3__inv_2_843/VNW VSUBS gf180mcu_as_sc_mcu7t3v3__inv_2
Xgf180mcu_as_sc_mcu7t3v3__inv_2_1508 VSS VSS gf180mcu_as_sc_mcu7t3v3__inv_2_1508/Y
+ gf180mcu_as_sc_mcu7t3v3__inv_2_1508/A gf180mcu_as_sc_mcu7t3v3__inv_2_1508/VNW VSUBS
+ gf180mcu_as_sc_mcu7t3v3__inv_2
Xgf180mcu_as_sc_mcu7t3v3__inv_2_1519 VSS VSS gf180mcu_as_sc_mcu7t3v3__inv_2_1519/Y
+ gf180mcu_as_sc_mcu7t3v3__inv_2_1519/A gf180mcu_as_sc_mcu7t3v3__inv_2_1519/VNW VSUBS
+ gf180mcu_as_sc_mcu7t3v3__inv_2
Xgf180mcu_as_sc_mcu7t3v3__nand2_2_7 gf180mcu_as_sc_mcu7t3v3__nand3_2_9/VDD gf180mcu_as_sc_mcu7t3v3__nor2_2_7/VSS
+ VSS VSS VSS gf180mcu_as_sc_mcu7t3v3__nand3_2_9/VNW VSUBS gf180mcu_as_sc_mcu7t3v3__nand2_2
Xgf180mcu_as_sc_mcu7t3v3__nor2_2_2 gf180mcu_as_sc_mcu7t3v3__nor2_2_7/VDD gf180mcu_as_sc_mcu7t3v3__nor2_2_7/VSS
+ VSS VSS VSS gf180mcu_as_sc_mcu7t3v3__nor2_2_7/VNW VSUBS gf180mcu_as_sc_mcu7t3v3__nor2_2
Xgf180mcu_as_sc_mcu7t3v3__inv_2_1305 VSS VSS VSS gf180mcu_as_sc_mcu7t3v3__inv_2_1306/Y
+ gf180mcu_as_sc_mcu7t3v3__inv_2_1307/VNW VSUBS gf180mcu_as_sc_mcu7t3v3__inv_2
Xgf180mcu_as_sc_mcu7t3v3__inv_2_1349 VSS VSS gf180mcu_as_sc_mcu7t3v3__inv_2_1349/Y
+ gf180mcu_as_sc_mcu7t3v3__inv_2_1349/A gf180mcu_as_sc_mcu7t3v3__inv_2_1349/VNW VSUBS
+ gf180mcu_as_sc_mcu7t3v3__inv_2
Xgf180mcu_as_sc_mcu7t3v3__inv_2_1316 VSS VSS gf180mcu_as_sc_mcu7t3v3__inv_2_1316/Y
+ gf180mcu_as_sc_mcu7t3v3__inv_2_1316/A gf180mcu_as_sc_mcu7t3v3__inv_2_1316/VNW VSUBS
+ gf180mcu_as_sc_mcu7t3v3__inv_2
Xgf180mcu_as_sc_mcu7t3v3__inv_2_1338 VSS VSS VSS gf180mcu_as_sc_mcu7t3v3__inv_2_1339/Y
+ gf180mcu_as_sc_mcu7t3v3__inv_2_1340/VNW VSUBS gf180mcu_as_sc_mcu7t3v3__inv_2
Xgf180mcu_as_sc_mcu7t3v3__inv_2_1327 VSS VSS gf180mcu_as_sc_mcu7t3v3__inv_2_1327/Y
+ gf180mcu_as_sc_mcu7t3v3__inv_2_1328/Y gf180mcu_as_sc_mcu7t3v3__inv_2_1328/VNW VSUBS
+ gf180mcu_as_sc_mcu7t3v3__inv_2
Xu_t028_012 u_t028_012/c0_w0_bl u_t028_012/c0_w0_br u_t028_012/c0_w1_bl u_t028_012/c0_w1_br
+ u_t028_012/c0_r0_rbl u_t028_012/c0_r1_rbl u_t028_012/c1_w0_bl u_t028_012/c1_w0_br
+ u_t028_012/c1_w1_bl u_t028_012/c1_w1_br u_t028_012/c1_r0_rbl u_t028_012/c1_r1_rbl
+ u_t028_012/c2_w0_bl u_t028_012/c2_w0_br u_t028_012/c2_w1_bl u_t028_012/c2_w1_br
+ u_t028_012/c2_r0_rbl u_t028_012/c2_r1_rbl u_t028_012/c3_w0_bl u_t028_012/c3_w0_br
+ u_t028_012/c3_w1_bl u_t028_012/c3_w1_br u_t028_012/c3_r0_rbl u_t028_012/c3_r1_rbl
+ u_t028_012/r0_w0_wl u_t028_012/r0_w1_wl u_t028_012/r0_r0_rwl u_t028_012/r0_r1_rwl
+ u_t028_012/r1_w0_wl u_t028_012/r1_w1_wl u_t028_012/r1_r0_rwl u_t028_012/r1_r1_rwl
+ u_t028_012/r2_w0_wl u_t028_012/r2_w1_wl u_t028_012/r2_r0_rwl u_t028_012/r2_r1_rwl
+ u_t028_012/r3_w0_wl u_t028_012/r3_w1_wl u_t028_012/r3_r0_rwl u_t028_012/r3_r1_rwl
+ VSS VSS u_t028_012/m2_717_1265# u_t028_012/m2_603_2031# u_t028_012/m2_1290_336#
+ u_t028_012/m2_2000_2037# u_t028_012/m2_791_2909# u_t028_012/m2_7_2126# u_t028_012/m2_2154_2081#
+ u_t028_012/m2_1795_2037# u_t028_012/m2_871_303# u_t028_012/m2_431_438# u_t028_012/m2_1290_2898#
+ u_t028_012/m2_1714_1210# u_t028_012/m2_431_1982# u_t028_012/m2_512_1265# u_t028_012/m2_2573_2126#
+ u_t028_012/m2_603_1259# u_t028_012/m2_2074_2909# u_t028_012/m2_7_336# u_t028_012/m2_717_2037#
+ u_t028_012/m2_1886_2031# u_t028_012/m2_2573_336# u_t028_012/m2_7_2898# u_t028_012/m2_2000_1265#
+ u_t028_012/m2_512_2037# u_t028_012/m2_1795_1265# u_t028_012/m2_1714_1982# u_t028_012/m2_1886_1259#
+ u_t028_012/m2_1290_2126# u_t028_012/m2_1714_438# u_t028_012/m2_431_1210# u_t028_012/m2_2573_2898#
+ u_t028_012/m2_2154_303# u_t028_012/m2_871_2081# VSUBS detronyx_12t_2w2r_rc4_4x4_routed_5layer_direct
Xu_t028_001 u_t028_001/c0_w0_bl u_t028_001/c0_w0_br u_t028_001/c0_w1_bl u_t028_001/c0_w1_br
+ u_t028_001/c0_r0_rbl u_t028_001/c0_r1_rbl u_t028_001/c1_w0_bl u_t028_001/c1_w0_br
+ u_t028_001/c1_w1_bl u_t028_001/c1_w1_br u_t028_001/c1_r0_rbl u_t028_001/c1_r1_rbl
+ u_t028_001/c2_w0_bl u_t028_001/c2_w0_br u_t028_001/c2_w1_bl u_t028_001/c2_w1_br
+ u_t028_001/c2_r0_rbl u_t028_001/c2_r1_rbl u_t028_001/c3_w0_bl u_t028_001/c3_w0_br
+ u_t028_001/c3_w1_bl u_t028_001/c3_w1_br u_t028_001/c3_r0_rbl u_t028_001/c3_r1_rbl
+ u_t028_001/r0_w0_wl u_t028_001/r0_w1_wl u_t028_001/r0_r0_rwl u_t028_001/r0_r1_rwl
+ u_t028_001/r1_w0_wl u_t028_001/r1_w1_wl u_t028_001/r1_r0_rwl u_t028_001/r1_r1_rwl
+ u_t028_001/r2_w0_wl u_t028_001/r2_w1_wl u_t028_001/r2_r0_rwl u_t028_001/r2_r1_rwl
+ u_t028_001/r3_w0_wl u_t028_001/r3_w1_wl u_t028_001/r3_r0_rwl u_t028_001/r3_r1_rwl
+ VSS VSS u_t028_001/m2_717_1265# u_t028_001/m2_603_2031# u_t028_001/m2_1290_336#
+ u_t028_001/m2_2000_2037# u_t028_001/m2_791_2909# u_t028_001/m2_7_2126# u_t028_001/m2_2154_2081#
+ u_t028_001/m2_1795_2037# u_t028_001/m2_871_303# u_t028_001/m2_431_438# u_t028_001/m2_1290_2898#
+ u_t028_001/m2_1714_1210# u_t028_001/m2_431_1982# u_t028_001/m2_512_1265# u_t028_001/m2_2573_2126#
+ u_t028_001/m2_603_1259# u_t028_001/m2_2074_2909# u_t028_001/m2_7_336# u_t028_001/m2_717_2037#
+ u_t028_001/m2_1886_2031# u_t028_001/m2_2573_336# u_t028_001/m2_7_2898# u_t028_001/m2_2000_1265#
+ u_t028_001/m2_512_2037# u_t028_001/m2_1795_1265# u_t028_001/m2_1714_1982# u_t028_001/m2_1886_1259#
+ u_t028_001/m2_1290_2126# u_t028_001/m2_1714_438# u_t028_001/m2_431_1210# u_t028_001/m2_2573_2898#
+ u_t028_001/m2_2154_303# u_t028_001/m2_871_2081# VSUBS detronyx_12t_2w2r_rc4_4x4_routed_5layer_direct
Xu_t019_012 u_t019_012/c0_w0_bl u_t019_012/c0_w0_br u_t019_012/c0_w1_bl u_t019_012/c0_w1_br
+ u_t019_012/c0_r0_rbl u_t019_012/c0_r1_rbl u_t019_012/c1_w0_bl u_t019_012/c1_w0_br
+ u_t019_012/c1_w1_bl u_t019_012/c1_w1_br u_t019_012/c1_r0_rbl u_t019_012/c1_r1_rbl
+ u_t019_012/c2_w0_bl u_t019_012/c2_w0_br u_t019_012/c2_w1_bl u_t019_012/c2_w1_br
+ u_t019_012/c2_r0_rbl u_t019_012/c2_r1_rbl u_t019_012/c3_w0_bl u_t019_012/c3_w0_br
+ u_t019_012/c3_w1_bl u_t019_012/c3_w1_br u_t019_012/c3_r0_rbl u_t019_012/c3_r1_rbl
+ u_t019_012/r0_w0_wl u_t019_012/r0_w1_wl u_t019_012/r0_r0_rwl u_t019_012/r0_r1_rwl
+ u_t019_012/r1_w0_wl u_t019_012/r1_w1_wl u_t019_012/r1_r0_rwl u_t019_012/r1_r1_rwl
+ u_t019_012/r2_w0_wl u_t019_012/r2_w1_wl u_t019_012/r2_r0_rwl u_t019_012/r2_r1_rwl
+ u_t019_012/r3_w0_wl u_t019_012/r3_w1_wl u_t019_012/r3_r0_rwl u_t019_012/r3_r1_rwl
+ VSS VSS u_t019_012/m2_717_1265# u_t019_012/m2_603_2031# u_t019_012/m2_1290_336#
+ u_t019_012/m2_2000_2037# u_t019_012/m2_791_2909# u_t019_012/m2_7_2126# u_t019_012/m2_2154_2081#
+ u_t019_012/m2_1795_2037# u_t019_012/m2_871_303# u_t019_012/m2_431_438# u_t019_012/m2_1290_2898#
+ u_t019_012/m2_1714_1210# u_t019_012/m2_431_1982# u_t019_012/m2_512_1265# u_t019_012/m2_2573_2126#
+ u_t019_012/m2_603_1259# u_t019_012/m2_2074_2909# u_t019_012/m2_7_336# u_t019_012/m2_717_2037#
+ u_t019_012/m2_1886_2031# u_t019_012/m2_2573_336# u_t019_012/m2_7_2898# u_t019_012/m2_2000_1265#
+ u_t019_012/m2_512_2037# u_t019_012/m2_1795_1265# u_t019_012/m2_1714_1982# u_t019_012/m2_1886_1259#
+ u_t019_012/m2_1290_2126# u_t019_012/m2_1714_438# u_t019_012/m2_431_1210# u_t019_012/m2_2573_2898#
+ u_t019_012/m2_2154_303# u_t019_012/m2_871_2081# VSUBS detronyx_12t_2w2r_rc4_4x4_routed_5layer_direct
Xu_t019_001 u_t019_001/c0_w0_bl u_t019_001/c0_w0_br u_t019_001/c0_w1_bl u_t019_001/c0_w1_br
+ u_t019_001/c0_r0_rbl u_t019_001/c0_r1_rbl u_t019_001/c1_w0_bl u_t019_001/c1_w0_br
+ u_t019_001/c1_w1_bl u_t019_001/c1_w1_br u_t019_001/c1_r0_rbl u_t019_001/c1_r1_rbl
+ u_t019_001/c2_w0_bl u_t019_001/c2_w0_br u_t019_001/c2_w1_bl u_t019_001/c2_w1_br
+ u_t019_001/c2_r0_rbl u_t019_001/c2_r1_rbl u_t019_001/c3_w0_bl u_t019_001/c3_w0_br
+ u_t019_001/c3_w1_bl u_t019_001/c3_w1_br u_t019_001/c3_r0_rbl u_t019_001/c3_r1_rbl
+ u_t019_001/r0_w0_wl u_t019_001/r0_w1_wl u_t019_001/r0_r0_rwl u_t019_001/r0_r1_rwl
+ u_t019_001/r1_w0_wl u_t019_001/r1_w1_wl u_t019_001/r1_r0_rwl u_t019_001/r1_r1_rwl
+ u_t019_001/r2_w0_wl u_t019_001/r2_w1_wl u_t019_001/r2_r0_rwl u_t019_001/r2_r1_rwl
+ u_t019_001/r3_w0_wl u_t019_001/r3_w1_wl u_t019_001/r3_r0_rwl u_t019_001/r3_r1_rwl
+ VSS VSS u_t019_001/m2_717_1265# u_t019_001/m2_603_2031# u_t019_001/m2_1290_336#
+ u_t019_001/m2_2000_2037# u_t019_001/m2_791_2909# u_t019_001/m2_7_2126# u_t019_001/m2_2154_2081#
+ u_t019_001/m2_1795_2037# u_t019_001/m2_871_303# u_t019_001/m2_431_438# u_t019_001/m2_1290_2898#
+ u_t019_001/m2_1714_1210# u_t019_001/m2_431_1982# u_t019_001/m2_512_1265# u_t019_001/m2_2573_2126#
+ u_t019_001/m2_603_1259# u_t019_001/m2_2074_2909# u_t019_001/m2_7_336# u_t019_001/m2_717_2037#
+ u_t019_001/m2_1886_2031# u_t019_001/m2_2573_336# u_t019_001/m2_7_2898# u_t019_001/m2_2000_1265#
+ u_t019_001/m2_512_2037# u_t019_001/m2_1795_1265# u_t019_001/m2_1714_1982# u_t019_001/m2_1886_1259#
+ u_t019_001/m2_1290_2126# u_t019_001/m2_1714_438# u_t019_001/m2_431_1210# u_t019_001/m2_2573_2898#
+ u_t019_001/m2_2154_303# u_t019_001/m2_871_2081# VSUBS detronyx_12t_2w2r_rc4_4x4_routed_5layer_direct
Xgf180mcu_as_sc_mcu7t3v3__nand4_2_16 VSS VSS VSS VSS VSS VSS gf180mcu_as_sc_mcu7t3v3__inv_2_128/A
+ gf180mcu_as_sc_mcu7t3v3__inv_2_128/VNW VSUBS gf180mcu_as_sc_mcu7t3v3__nand4_2
Xgf180mcu_as_sc_mcu7t3v3__nand4_2_38 VSS VSS VSS VSS VSS VSS gf180mcu_as_sc_mcu7t3v3__inv_2_196/A
+ gf180mcu_as_sc_mcu7t3v3__inv_2_196/VNW VSUBS gf180mcu_as_sc_mcu7t3v3__nand4_2
Xgf180mcu_as_sc_mcu7t3v3__nand4_2_27 VSS VSS VSS VSS VSS VSS gf180mcu_as_sc_mcu7t3v3__inv_2_160/A
+ gf180mcu_as_sc_mcu7t3v3__inv_2_160/VNW VSUBS gf180mcu_as_sc_mcu7t3v3__nand4_2
Xgf180mcu_as_sc_mcu7t3v3__nand4_2_49 VSS VSS VSS VSS VSS VSS gf180mcu_as_sc_mcu7t3v3__inv_2_227/A
+ gf180mcu_as_sc_mcu7t3v3__inv_2_227/VNW VSUBS gf180mcu_as_sc_mcu7t3v3__nand4_2
Xu_t025_015 u_t025_015/c0_w0_bl u_t025_015/c0_w0_br u_t025_015/c0_w1_bl u_t025_015/c0_w1_br
+ u_t025_015/c0_r0_rbl u_t025_015/c0_r1_rbl u_t025_015/c1_w0_bl u_t025_015/c1_w0_br
+ u_t025_015/c1_w1_bl u_t025_015/c1_w1_br u_t025_015/c1_r0_rbl u_t025_015/c1_r1_rbl
+ u_t025_015/c2_w0_bl u_t025_015/c2_w0_br u_t025_015/c2_w1_bl u_t025_015/c2_w1_br
+ u_t025_015/c2_r0_rbl u_t025_015/c2_r1_rbl u_t025_015/c3_w0_bl u_t025_015/c3_w0_br
+ u_t025_015/c3_w1_bl u_t025_015/c3_w1_br u_t025_015/c3_r0_rbl u_t025_015/c3_r1_rbl
+ u_t025_015/r0_w0_wl u_t025_015/r0_w1_wl u_t025_015/r0_r0_rwl u_t025_015/r0_r1_rwl
+ u_t025_015/r1_w0_wl u_t025_015/r1_w1_wl u_t025_015/r1_r0_rwl u_t025_015/r1_r1_rwl
+ u_t025_015/r2_w0_wl u_t025_015/r2_w1_wl u_t025_015/r2_r0_rwl u_t025_015/r2_r1_rwl
+ u_t025_015/r3_w0_wl u_t025_015/r3_w1_wl u_t025_015/r3_r0_rwl u_t025_015/r3_r1_rwl
+ VSS VSS u_t025_015/m2_717_1265# u_t025_015/m2_603_2031# u_t025_015/m2_1290_336#
+ u_t025_015/m2_2000_2037# u_t025_015/m2_791_2909# u_t025_015/m2_7_2126# u_t025_015/m2_2154_2081#
+ u_t025_015/m2_1795_2037# u_t025_015/m2_871_303# u_t025_015/m2_431_438# u_t025_015/m2_1290_2898#
+ u_t025_015/m2_1714_1210# u_t025_015/m2_431_1982# u_t025_015/m2_512_1265# u_t025_015/m2_2573_2126#
+ u_t025_015/m2_603_1259# u_t025_015/m2_2074_2909# u_t025_015/m2_7_336# u_t025_015/m2_717_2037#
+ u_t025_015/m2_1886_2031# u_t025_015/m2_2573_336# u_t025_015/m2_7_2898# u_t025_015/m2_2000_1265#
+ u_t025_015/m2_512_2037# u_t025_015/m2_1795_1265# u_t025_015/m2_1714_1982# u_t025_015/m2_1886_1259#
+ u_t025_015/m2_1290_2126# u_t025_015/m2_1714_438# u_t025_015/m2_431_1210# u_t025_015/m2_2573_2898#
+ u_t025_015/m2_2154_303# u_t025_015/m2_871_2081# VSUBS detronyx_12t_2w2r_rc4_4x4_routed_5layer_direct
Xu_t025_004 u_t025_004/c0_w0_bl u_t025_004/c0_w0_br u_t025_004/c0_w1_bl u_t025_004/c0_w1_br
+ u_t025_004/c0_r0_rbl u_t025_004/c0_r1_rbl u_t025_004/c1_w0_bl u_t025_004/c1_w0_br
+ u_t025_004/c1_w1_bl u_t025_004/c1_w1_br u_t025_004/c1_r0_rbl u_t025_004/c1_r1_rbl
+ u_t025_004/c2_w0_bl u_t025_004/c2_w0_br u_t025_004/c2_w1_bl u_t025_004/c2_w1_br
+ u_t025_004/c2_r0_rbl u_t025_004/c2_r1_rbl u_t025_004/c3_w0_bl u_t025_004/c3_w0_br
+ u_t025_004/c3_w1_bl u_t025_004/c3_w1_br u_t025_004/c3_r0_rbl u_t025_004/c3_r1_rbl
+ u_t025_004/r0_w0_wl u_t025_004/r0_w1_wl u_t025_004/r0_r0_rwl u_t025_004/r0_r1_rwl
+ u_t025_004/r1_w0_wl u_t025_004/r1_w1_wl u_t025_004/r1_r0_rwl u_t025_004/r1_r1_rwl
+ u_t025_004/r2_w0_wl u_t025_004/r2_w1_wl u_t025_004/r2_r0_rwl u_t025_004/r2_r1_rwl
+ u_t025_004/r3_w0_wl u_t025_004/r3_w1_wl u_t025_004/r3_r0_rwl u_t025_004/r3_r1_rwl
+ VSS VSS u_t025_004/m2_717_1265# u_t025_004/m2_603_2031# u_t025_004/m2_1290_336#
+ u_t025_004/m2_2000_2037# u_t025_004/m2_791_2909# u_t025_004/m2_7_2126# u_t025_004/m2_2154_2081#
+ u_t025_004/m2_1795_2037# u_t025_004/m2_871_303# u_t025_004/m2_431_438# u_t025_004/m2_1290_2898#
+ u_t025_004/m2_1714_1210# u_t025_004/m2_431_1982# u_t025_004/m2_512_1265# u_t025_004/m2_2573_2126#
+ u_t025_004/m2_603_1259# u_t025_004/m2_2074_2909# u_t025_004/m2_7_336# u_t025_004/m2_717_2037#
+ u_t025_004/m2_1886_2031# u_t025_004/m2_2573_336# u_t025_004/m2_7_2898# u_t025_004/m2_2000_1265#
+ u_t025_004/m2_512_2037# u_t025_004/m2_1795_1265# u_t025_004/m2_1714_1982# u_t025_004/m2_1886_1259#
+ u_t025_004/m2_1290_2126# u_t025_004/m2_1714_438# u_t025_004/m2_431_1210# u_t025_004/m2_2573_2898#
+ u_t025_004/m2_2154_303# u_t025_004/m2_871_2081# VSUBS detronyx_12t_2w2r_rc4_4x4_routed_5layer_direct
Xgf180mcu_as_sc_mcu7t3v3__inv_2_1135 VSS VSS gf180mcu_as_sc_mcu7t3v3__inv_2_1135/Y
+ gf180mcu_as_sc_mcu7t3v3__inv_2_1136/Y gf180mcu_as_sc_mcu7t3v3__inv_2_1136/VNW VSUBS
+ gf180mcu_as_sc_mcu7t3v3__inv_2
Xgf180mcu_as_sc_mcu7t3v3__inv_2_1113 VSS VSS VSS gf180mcu_as_sc_mcu7t3v3__inv_2_1114/Y
+ gf180mcu_as_sc_mcu7t3v3__inv_2_1115/VNW VSUBS gf180mcu_as_sc_mcu7t3v3__inv_2
Xgf180mcu_as_sc_mcu7t3v3__inv_2_1146 VSS VSS VSS gf180mcu_as_sc_mcu7t3v3__inv_2_1147/Y
+ gf180mcu_as_sc_mcu7t3v3__inv_2_1148/VNW VSUBS gf180mcu_as_sc_mcu7t3v3__inv_2
Xgf180mcu_as_sc_mcu7t3v3__inv_2_1124 VSS VSS gf180mcu_as_sc_mcu7t3v3__inv_2_1124/Y
+ gf180mcu_as_sc_mcu7t3v3__inv_2_1124/A gf180mcu_as_sc_mcu7t3v3__inv_2_1124/VNW VSUBS
+ gf180mcu_as_sc_mcu7t3v3__inv_2
Xgf180mcu_as_sc_mcu7t3v3__inv_2_1157 VSS VSS gf180mcu_as_sc_mcu7t3v3__inv_2_1157/Y
+ gf180mcu_as_sc_mcu7t3v3__inv_2_1157/A gf180mcu_as_sc_mcu7t3v3__inv_2_1290/VNW VSUBS
+ gf180mcu_as_sc_mcu7t3v3__inv_2
Xgf180mcu_as_sc_mcu7t3v3__inv_2_1102 VSS VSS gf180mcu_as_sc_mcu7t3v3__inv_2_1102/Y
+ gf180mcu_as_sc_mcu7t3v3__inv_2_1103/Y gf180mcu_as_sc_mcu7t3v3__inv_2_1103/VNW VSUBS
+ gf180mcu_as_sc_mcu7t3v3__inv_2
Xgf180mcu_as_sc_mcu7t3v3__inv_2_1168 VSS VSS gf180mcu_as_sc_mcu7t3v3__inv_2_1175/A
+ gf180mcu_as_sc_mcu7t3v3__inv_2_1168/A gf180mcu_as_sc_mcu7t3v3__inv_2_1301/VNW VSUBS
+ gf180mcu_as_sc_mcu7t3v3__inv_2
Xgf180mcu_as_sc_mcu7t3v3__inv_2_1179 VSS VSS gf180mcu_as_sc_mcu7t3v3__inv_2_1179/Y
+ gf180mcu_as_sc_mcu7t3v3__inv_2_1179/A gf180mcu_as_sc_mcu7t3v3__inv_2_1288/VNW VSUBS
+ gf180mcu_as_sc_mcu7t3v3__inv_2
Xu_t016_015 u_t016_015/c0_w0_bl u_t016_015/c0_w0_br u_t016_015/c0_w1_bl u_t016_015/c0_w1_br
+ u_t016_015/c0_r0_rbl u_t016_015/c0_r1_rbl u_t016_015/c1_w0_bl u_t016_015/c1_w0_br
+ u_t016_015/c1_w1_bl u_t016_015/c1_w1_br u_t016_015/c1_r0_rbl u_t016_015/c1_r1_rbl
+ u_t016_015/c2_w0_bl u_t016_015/c2_w0_br u_t016_015/c2_w1_bl u_t016_015/c2_w1_br
+ u_t016_015/c2_r0_rbl u_t016_015/c2_r1_rbl u_t016_015/c3_w0_bl u_t016_015/c3_w0_br
+ u_t016_015/c3_w1_bl u_t016_015/c3_w1_br u_t016_015/c3_r0_rbl u_t016_015/c3_r1_rbl
+ u_t016_015/r0_w0_wl u_t016_015/r0_w1_wl u_t016_015/r0_r0_rwl u_t016_015/r0_r1_rwl
+ u_t016_015/r1_w0_wl u_t016_015/r1_w1_wl u_t016_015/r1_r0_rwl u_t016_015/r1_r1_rwl
+ u_t016_015/r2_w0_wl u_t016_015/r2_w1_wl u_t016_015/r2_r0_rwl u_t016_015/r2_r1_rwl
+ u_t016_015/r3_w0_wl u_t016_015/r3_w1_wl u_t016_015/r3_r0_rwl u_t016_015/r3_r1_rwl
+ VSS VSS u_t016_015/m2_717_1265# u_t016_015/m2_603_2031# u_t016_015/m2_1290_336#
+ u_t016_015/m2_2000_2037# u_t016_015/m2_791_2909# u_t016_015/m2_7_2126# u_t016_015/m2_2154_2081#
+ u_t016_015/m2_1795_2037# u_t016_015/m2_871_303# u_t016_015/m2_431_438# u_t016_015/m2_1290_2898#
+ u_t016_015/m2_1714_1210# u_t016_015/m2_431_1982# u_t016_015/m2_512_1265# u_t016_015/m2_2573_2126#
+ u_t016_015/m2_603_1259# u_t016_015/m2_2074_2909# u_t016_015/m2_7_336# u_t016_015/m2_717_2037#
+ u_t016_015/m2_1886_2031# u_t016_015/m2_2573_336# u_t016_015/m2_7_2898# u_t016_015/m2_2000_1265#
+ u_t016_015/m2_512_2037# u_t016_015/m2_1795_1265# u_t016_015/m2_1714_1982# u_t016_015/m2_1886_1259#
+ u_t016_015/m2_1290_2126# u_t016_015/m2_1714_438# u_t016_015/m2_431_1210# u_t016_015/m2_2573_2898#
+ u_t016_015/m2_2154_303# u_t016_015/m2_871_2081# VSUBS detronyx_12t_2w2r_rc4_4x4_routed_5layer_direct
Xu_t016_004 u_t016_004/c0_w0_bl u_t016_004/c0_w0_br u_t016_004/c0_w1_bl u_t016_004/c0_w1_br
+ u_t016_004/c0_r0_rbl u_t016_004/c0_r1_rbl u_t016_004/c1_w0_bl u_t016_004/c1_w0_br
+ u_t016_004/c1_w1_bl u_t016_004/c1_w1_br u_t016_004/c1_r0_rbl u_t016_004/c1_r1_rbl
+ u_t016_004/c2_w0_bl u_t016_004/c2_w0_br u_t016_004/c2_w1_bl u_t016_004/c2_w1_br
+ u_t016_004/c2_r0_rbl u_t016_004/c2_r1_rbl u_t016_004/c3_w0_bl u_t016_004/c3_w0_br
+ u_t016_004/c3_w1_bl u_t016_004/c3_w1_br u_t016_004/c3_r0_rbl u_t016_004/c3_r1_rbl
+ u_t016_004/r0_w0_wl u_t016_004/r0_w1_wl u_t016_004/r0_r0_rwl u_t016_004/r0_r1_rwl
+ u_t016_004/r1_w0_wl u_t016_004/r1_w1_wl u_t016_004/r1_r0_rwl u_t016_004/r1_r1_rwl
+ u_t016_004/r2_w0_wl u_t016_004/r2_w1_wl u_t016_004/r2_r0_rwl u_t016_004/r2_r1_rwl
+ u_t016_004/r3_w0_wl u_t016_004/r3_w1_wl u_t016_004/r3_r0_rwl u_t016_004/r3_r1_rwl
+ VSS VSS u_t016_004/m2_717_1265# u_t016_004/m2_603_2031# u_t016_004/m2_1290_336#
+ u_t016_004/m2_2000_2037# u_t016_004/m2_791_2909# u_t016_004/m2_7_2126# u_t016_004/m2_2154_2081#
+ u_t016_004/m2_1795_2037# u_t016_004/m2_871_303# u_t016_004/m2_431_438# u_t016_004/m2_1290_2898#
+ u_t016_004/m2_1714_1210# u_t016_004/m2_431_1982# u_t016_004/m2_512_1265# u_t016_004/m2_2573_2126#
+ u_t016_004/m2_603_1259# u_t016_004/m2_2074_2909# u_t016_004/m2_7_336# u_t016_004/m2_717_2037#
+ u_t016_004/m2_1886_2031# u_t016_004/m2_2573_336# u_t016_004/m2_7_2898# u_t016_004/m2_2000_1265#
+ u_t016_004/m2_512_2037# u_t016_004/m2_1795_1265# u_t016_004/m2_1714_1982# u_t016_004/m2_1886_1259#
+ u_t016_004/m2_1290_2126# u_t016_004/m2_1714_438# u_t016_004/m2_431_1210# u_t016_004/m2_2573_2898#
+ u_t016_004/m2_2154_303# u_t016_004/m2_871_2081# VSUBS detronyx_12t_2w2r_rc4_4x4_routed_5layer_direct
Xgf180mcu_as_sc_mcu7t3v3__nand3_2_60 gf180mcu_as_sc_mcu7t3v3__nand3_2_65/VDD gf180mcu_as_sc_mcu7t3v3__nor2_2_9/VSS
+ VSS VSS VSS VSS gf180mcu_as_sc_mcu7t3v3__nand3_2_65/VNW VSUBS gf180mcu_as_sc_mcu7t3v3__nand3_2
Xgf180mcu_as_sc_mcu7t3v3__inv_2_608 VSS VSS VSS gf180mcu_as_sc_mcu7t3v3__inv_2_609/Y
+ gf180mcu_as_sc_mcu7t3v3__inv_2_610/VNW VSUBS gf180mcu_as_sc_mcu7t3v3__inv_2
Xgf180mcu_as_sc_mcu7t3v3__inv_2_619 VSS VSS gf180mcu_as_sc_mcu7t3v3__inv_2_619/Y gf180mcu_as_sc_mcu7t3v3__inv_2_620/Y
+ gf180mcu_as_sc_mcu7t3v3__inv_2_620/VNW VSUBS gf180mcu_as_sc_mcu7t3v3__inv_2
Xu_t031_007 u_t031_007/c0_w0_bl u_t031_007/c0_w0_br u_t031_007/c0_w1_bl u_t031_007/c0_w1_br
+ u_t031_007/c0_r0_rbl u_t031_007/c0_r1_rbl u_t031_007/c1_w0_bl u_t031_007/c1_w0_br
+ u_t031_007/c1_w1_bl u_t031_007/c1_w1_br u_t031_007/c1_r0_rbl u_t031_007/c1_r1_rbl
+ u_t031_007/c2_w0_bl u_t031_007/c2_w0_br u_t031_007/c2_w1_bl u_t031_007/c2_w1_br
+ u_t031_007/c2_r0_rbl u_t031_007/c2_r1_rbl u_t031_007/c3_w0_bl u_t031_007/c3_w0_br
+ u_t031_007/c3_w1_bl u_t031_007/c3_w1_br u_t031_007/c3_r0_rbl u_t031_007/c3_r1_rbl
+ u_t031_007/r0_w0_wl u_t031_007/r0_w1_wl u_t031_007/r0_r0_rwl u_t031_007/r0_r1_rwl
+ u_t031_007/r1_w0_wl u_t031_007/r1_w1_wl u_t031_007/r1_r0_rwl u_t031_007/r1_r1_rwl
+ u_t031_007/r2_w0_wl u_t031_007/r2_w1_wl u_t031_007/r2_r0_rwl u_t031_007/r2_r1_rwl
+ u_t031_007/r3_w0_wl u_t031_007/r3_w1_wl u_t031_007/r3_r0_rwl u_t031_007/r3_r1_rwl
+ VSS VSS u_t031_007/m2_717_1265# u_t031_007/m2_603_2031# u_t031_007/m2_1290_336#
+ u_t031_007/m2_2000_2037# u_t031_007/m2_791_2909# u_t031_007/m2_7_2126# u_t031_007/m2_2154_2081#
+ u_t031_007/m2_1795_2037# u_t031_007/m2_871_303# u_t031_007/m2_431_438# u_t031_007/m2_1290_2898#
+ u_t031_007/m2_1714_1210# u_t031_007/m2_431_1982# u_t031_007/m2_512_1265# u_t031_007/m2_2573_2126#
+ u_t031_007/m2_603_1259# u_t031_007/m2_2074_2909# u_t031_007/m2_7_336# u_t031_007/m2_717_2037#
+ u_t031_007/m2_1886_2031# u_t031_007/m2_2573_336# u_t031_007/m2_7_2898# u_t031_007/m2_2000_1265#
+ u_t031_007/m2_512_2037# u_t031_007/m2_1795_1265# u_t031_007/m2_1714_1982# u_t031_007/m2_1886_1259#
+ u_t031_007/m2_1290_2126# u_t031_007/m2_1714_438# u_t031_007/m2_431_1210# u_t031_007/m2_2573_2898#
+ u_t031_007/m2_2154_303# u_t031_007/m2_871_2081# VSUBS detronyx_12t_2w2r_rc4_4x4_routed_5layer_direct
Xgf180mcu_as_sc_mcu7t3v3__inv_2_1680 VSS VSS gf180mcu_as_sc_mcu7t3v3__inv_2_1680/Y
+ gf180mcu_as_sc_mcu7t3v3__inv_2_1680/A gf180mcu_as_sc_mcu7t3v3__inv_2_1680/VNW VSUBS
+ gf180mcu_as_sc_mcu7t3v3__inv_2
Xgf180mcu_as_sc_mcu7t3v3__inv_2_1691 VSS VSS gf180mcu_as_sc_mcu7t3v3__inv_2_1691/Y
+ gf180mcu_as_sc_mcu7t3v3__inv_2_1691/A gf180mcu_as_sc_mcu7t3v3__inv_2_1691/VNW VSUBS
+ gf180mcu_as_sc_mcu7t3v3__inv_2
Xu_t007_015 u_t007_015/c0_w0_bl u_t007_015/c0_w0_br u_t007_015/c0_w1_bl u_t007_015/c0_w1_br
+ u_t007_015/c0_r0_rbl u_t007_015/c0_r1_rbl u_t007_015/c1_w0_bl u_t007_015/c1_w0_br
+ u_t007_015/c1_w1_bl u_t007_015/c1_w1_br u_t007_015/c1_r0_rbl u_t007_015/c1_r1_rbl
+ u_t007_015/c2_w0_bl u_t007_015/c2_w0_br u_t007_015/c2_w1_bl u_t007_015/c2_w1_br
+ u_t007_015/c2_r0_rbl u_t007_015/c2_r1_rbl u_t007_015/c3_w0_bl u_t007_015/c3_w0_br
+ u_t007_015/c3_w1_bl u_t007_015/c3_w1_br u_t007_015/c3_r0_rbl u_t007_015/c3_r1_rbl
+ u_t007_015/r0_w0_wl u_t007_015/r0_w1_wl u_t007_015/r0_r0_rwl u_t007_015/r0_r1_rwl
+ u_t007_015/r1_w0_wl u_t007_015/r1_w1_wl u_t007_015/r1_r0_rwl u_t007_015/r1_r1_rwl
+ u_t007_015/r2_w0_wl u_t007_015/r2_w1_wl u_t007_015/r2_r0_rwl u_t007_015/r2_r1_rwl
+ u_t007_015/r3_w0_wl u_t007_015/r3_w1_wl u_t007_015/r3_r0_rwl u_t007_015/r3_r1_rwl
+ VSS VSS u_t007_015/m2_717_1265# u_t007_015/m2_603_2031# u_t007_015/m2_1290_336#
+ u_t007_015/m2_2000_2037# u_t007_015/m2_791_2909# u_t007_015/m2_7_2126# u_t007_015/m2_2154_2081#
+ u_t007_015/m2_1795_2037# u_t007_015/m2_871_303# u_t007_015/m2_431_438# u_t007_015/m2_1290_2898#
+ u_t007_015/m2_1714_1210# u_t007_015/m2_431_1982# u_t007_015/m2_512_1265# u_t007_015/m2_2573_2126#
+ u_t007_015/m2_603_1259# u_t007_015/m2_2074_2909# u_t007_015/m2_7_336# u_t007_015/m2_717_2037#
+ u_t007_015/m2_1886_2031# u_t007_015/m2_2573_336# u_t007_015/m2_7_2898# u_t007_015/m2_2000_1265#
+ u_t007_015/m2_512_2037# u_t007_015/m2_1795_1265# u_t007_015/m2_1714_1982# u_t007_015/m2_1886_1259#
+ u_t007_015/m2_1290_2126# u_t007_015/m2_1714_438# u_t007_015/m2_431_1210# u_t007_015/m2_2573_2898#
+ u_t007_015/m2_2154_303# u_t007_015/m2_871_2081# VSUBS detronyx_12t_2w2r_rc4_4x4_routed_5layer_direct
Xu_t022_007 u_t022_007/c0_w0_bl u_t022_007/c0_w0_br u_t022_007/c0_w1_bl u_t022_007/c0_w1_br
+ u_t022_007/c0_r0_rbl u_t022_007/c0_r1_rbl u_t022_007/c1_w0_bl u_t022_007/c1_w0_br
+ u_t022_007/c1_w1_bl u_t022_007/c1_w1_br u_t022_007/c1_r0_rbl u_t022_007/c1_r1_rbl
+ u_t022_007/c2_w0_bl u_t022_007/c2_w0_br u_t022_007/c2_w1_bl u_t022_007/c2_w1_br
+ u_t022_007/c2_r0_rbl u_t022_007/c2_r1_rbl u_t022_007/c3_w0_bl u_t022_007/c3_w0_br
+ u_t022_007/c3_w1_bl u_t022_007/c3_w1_br u_t022_007/c3_r0_rbl u_t022_007/c3_r1_rbl
+ u_t022_007/r0_w0_wl u_t022_007/r0_w1_wl u_t022_007/r0_r0_rwl u_t022_007/r0_r1_rwl
+ u_t022_007/r1_w0_wl u_t022_007/r1_w1_wl u_t022_007/r1_r0_rwl u_t022_007/r1_r1_rwl
+ u_t022_007/r2_w0_wl u_t022_007/r2_w1_wl u_t022_007/r2_r0_rwl u_t022_007/r2_r1_rwl
+ u_t022_007/r3_w0_wl u_t022_007/r3_w1_wl u_t022_007/r3_r0_rwl u_t022_007/r3_r1_rwl
+ VSS VSS u_t022_007/m2_717_1265# u_t022_007/m2_603_2031# u_t022_007/m2_1290_336#
+ u_t022_007/m2_2000_2037# u_t022_007/m2_791_2909# u_t022_007/m2_7_2126# u_t022_007/m2_2154_2081#
+ u_t022_007/m2_1795_2037# u_t022_007/m2_871_303# u_t022_007/m2_431_438# u_t022_007/m2_1290_2898#
+ u_t022_007/m2_1714_1210# u_t022_007/m2_431_1982# u_t022_007/m2_512_1265# u_t022_007/m2_2573_2126#
+ u_t022_007/m2_603_1259# u_t022_007/m2_2074_2909# u_t022_007/m2_7_336# u_t022_007/m2_717_2037#
+ u_t022_007/m2_1886_2031# u_t022_007/m2_2573_336# u_t022_007/m2_7_2898# u_t022_007/m2_2000_1265#
+ u_t022_007/m2_512_2037# u_t022_007/m2_1795_1265# u_t022_007/m2_1714_1982# u_t022_007/m2_1886_1259#
+ u_t022_007/m2_1290_2126# u_t022_007/m2_1714_438# u_t022_007/m2_431_1210# u_t022_007/m2_2573_2898#
+ u_t022_007/m2_2154_303# u_t022_007/m2_871_2081# VSUBS detronyx_12t_2w2r_rc4_4x4_routed_5layer_direct
Xu_t007_004 u_t007_004/c0_w0_bl u_t007_004/c0_w0_br u_t007_004/c0_w1_bl u_t007_004/c0_w1_br
+ u_t007_004/c0_r0_rbl u_t007_004/c0_r1_rbl u_t007_004/c1_w0_bl u_t007_004/c1_w0_br
+ u_t007_004/c1_w1_bl u_t007_004/c1_w1_br u_t007_004/c1_r0_rbl u_t007_004/c1_r1_rbl
+ u_t007_004/c2_w0_bl u_t007_004/c2_w0_br u_t007_004/c2_w1_bl u_t007_004/c2_w1_br
+ u_t007_004/c2_r0_rbl u_t007_004/c2_r1_rbl u_t007_004/c3_w0_bl u_t007_004/c3_w0_br
+ u_t007_004/c3_w1_bl u_t007_004/c3_w1_br u_t007_004/c3_r0_rbl u_t007_004/c3_r1_rbl
+ u_t007_004/r0_w0_wl u_t007_004/r0_w1_wl u_t007_004/r0_r0_rwl u_t007_004/r0_r1_rwl
+ u_t007_004/r1_w0_wl u_t007_004/r1_w1_wl u_t007_004/r1_r0_rwl u_t007_004/r1_r1_rwl
+ u_t007_004/r2_w0_wl u_t007_004/r2_w1_wl u_t007_004/r2_r0_rwl u_t007_004/r2_r1_rwl
+ u_t007_004/r3_w0_wl u_t007_004/r3_w1_wl u_t007_004/r3_r0_rwl u_t007_004/r3_r1_rwl
+ VSS VSS u_t007_004/m2_717_1265# u_t007_004/m2_603_2031# u_t007_004/m2_1290_336#
+ u_t007_004/m2_2000_2037# u_t007_004/m2_791_2909# u_t007_004/m2_7_2126# u_t007_004/m2_2154_2081#
+ u_t007_004/m2_1795_2037# u_t007_004/m2_871_303# u_t007_004/m2_431_438# u_t007_004/m2_1290_2898#
+ u_t007_004/m2_1714_1210# u_t007_004/m2_431_1982# u_t007_004/m2_512_1265# u_t007_004/m2_2573_2126#
+ u_t007_004/m2_603_1259# u_t007_004/m2_2074_2909# u_t007_004/m2_7_336# u_t007_004/m2_717_2037#
+ u_t007_004/m2_1886_2031# u_t007_004/m2_2573_336# u_t007_004/m2_7_2898# u_t007_004/m2_2000_1265#
+ u_t007_004/m2_512_2037# u_t007_004/m2_1795_1265# u_t007_004/m2_1714_1982# u_t007_004/m2_1886_1259#
+ u_t007_004/m2_1290_2126# u_t007_004/m2_1714_438# u_t007_004/m2_431_1210# u_t007_004/m2_2573_2898#
+ u_t007_004/m2_2154_303# u_t007_004/m2_871_2081# VSUBS detronyx_12t_2w2r_rc4_4x4_routed_5layer_direct
Xgf180mcu_as_sc_mcu7t3v3__nand4_2_441 VSS VSS VSS VSS VSS VSS gf180mcu_as_sc_mcu7t3v3__inv_2_1594/A
+ gf180mcu_as_sc_mcu7t3v3__inv_2_1594/VNW VSUBS gf180mcu_as_sc_mcu7t3v3__nand4_2
Xgf180mcu_as_sc_mcu7t3v3__nand4_2_496 VSS VSS VSS VSS VSS VSS gf180mcu_as_sc_mcu7t3v3__inv_2_1622/A
+ gf180mcu_as_sc_mcu7t3v3__inv_2_1622/VNW VSUBS gf180mcu_as_sc_mcu7t3v3__nand4_2
Xgf180mcu_as_sc_mcu7t3v3__nand4_2_485 VSS VSS VSS VSS VSS VSS gf180mcu_as_sc_mcu7t3v3__inv_2_1664/A
+ gf180mcu_as_sc_mcu7t3v3__inv_2_1664/VNW VSUBS gf180mcu_as_sc_mcu7t3v3__nand4_2
Xgf180mcu_as_sc_mcu7t3v3__nand4_2_430 VSS VSS VSS VSS VSS VSS gf180mcu_as_sc_mcu7t3v3__inv_2_1562/A
+ gf180mcu_as_sc_mcu7t3v3__inv_2_1562/VNW VSUBS gf180mcu_as_sc_mcu7t3v3__nand4_2
Xgf180mcu_as_sc_mcu7t3v3__nand4_2_474 VSS VSS VSS VSS VSS VSS gf180mcu_as_sc_mcu7t3v3__inv_2_1402/A
+ gf180mcu_as_sc_mcu7t3v3__inv_2_1402/VNW VSUBS gf180mcu_as_sc_mcu7t3v3__nand4_2
Xgf180mcu_as_sc_mcu7t3v3__nand4_2_452 VSS VSS VSS VSS VSS VSS gf180mcu_as_sc_mcu7t3v3__inv_2_1344/A
+ gf180mcu_as_sc_mcu7t3v3__inv_2_1344/VNW VSUBS gf180mcu_as_sc_mcu7t3v3__nand4_2
Xgf180mcu_as_sc_mcu7t3v3__nand4_2_463 VSS VSS VSS VSS VSS VSS gf180mcu_as_sc_mcu7t3v3__inv_2_1358/A
+ gf180mcu_as_sc_mcu7t3v3__inv_2_1358/VNW VSUBS gf180mcu_as_sc_mcu7t3v3__nand4_2
Xu_t013_007 u_t013_007/c0_w0_bl u_t013_007/c0_w0_br u_t013_007/c0_w1_bl u_t013_007/c0_w1_br
+ u_t013_007/c0_r0_rbl u_t013_007/c0_r1_rbl u_t013_007/c1_w0_bl u_t013_007/c1_w0_br
+ u_t013_007/c1_w1_bl u_t013_007/c1_w1_br u_t013_007/c1_r0_rbl u_t013_007/c1_r1_rbl
+ u_t013_007/c2_w0_bl u_t013_007/c2_w0_br u_t013_007/c2_w1_bl u_t013_007/c2_w1_br
+ u_t013_007/c2_r0_rbl u_t013_007/c2_r1_rbl u_t013_007/c3_w0_bl u_t013_007/c3_w0_br
+ u_t013_007/c3_w1_bl u_t013_007/c3_w1_br u_t013_007/c3_r0_rbl u_t013_007/c3_r1_rbl
+ u_t013_007/r0_w0_wl u_t013_007/r0_w1_wl u_t013_007/r0_r0_rwl u_t013_007/r0_r1_rwl
+ u_t013_007/r1_w0_wl u_t013_007/r1_w1_wl u_t013_007/r1_r0_rwl u_t013_007/r1_r1_rwl
+ u_t013_007/r2_w0_wl u_t013_007/r2_w1_wl u_t013_007/r2_r0_rwl u_t013_007/r2_r1_rwl
+ u_t013_007/r3_w0_wl u_t013_007/r3_w1_wl u_t013_007/r3_r0_rwl u_t013_007/r3_r1_rwl
+ VSS VSS u_t013_007/m2_717_1265# u_t013_007/m2_603_2031# u_t013_007/m2_1290_336#
+ u_t013_007/m2_2000_2037# u_t013_007/m2_791_2909# u_t013_007/m2_7_2126# u_t013_007/m2_2154_2081#
+ u_t013_007/m2_1795_2037# u_t013_007/m2_871_303# u_t013_007/m2_431_438# u_t013_007/m2_1290_2898#
+ u_t013_007/m2_1714_1210# u_t013_007/m2_431_1982# u_t013_007/m2_512_1265# u_t013_007/m2_2573_2126#
+ u_t013_007/m2_603_1259# u_t013_007/m2_2074_2909# u_t013_007/m2_7_336# u_t013_007/m2_717_2037#
+ u_t013_007/m2_1886_2031# u_t013_007/m2_2573_336# u_t013_007/m2_7_2898# u_t013_007/m2_2000_1265#
+ u_t013_007/m2_512_2037# u_t013_007/m2_1795_1265# u_t013_007/m2_1714_1982# u_t013_007/m2_1886_1259#
+ u_t013_007/m2_1290_2126# u_t013_007/m2_1714_438# u_t013_007/m2_431_1210# u_t013_007/m2_2573_2898#
+ u_t013_007/m2_2154_303# u_t013_007/m2_871_2081# VSUBS detronyx_12t_2w2r_rc4_4x4_routed_5layer_direct
Xu_t004_007 u_t004_007/c0_w0_bl u_t004_007/c0_w0_br u_t004_007/c0_w1_bl u_t004_007/c0_w1_br
+ u_t004_007/c0_r0_rbl u_t004_007/c0_r1_rbl u_t004_007/c1_w0_bl u_t004_007/c1_w0_br
+ u_t004_007/c1_w1_bl u_t004_007/c1_w1_br u_t004_007/c1_r0_rbl u_t004_007/c1_r1_rbl
+ u_t004_007/c2_w0_bl u_t004_007/c2_w0_br u_t004_007/c2_w1_bl u_t004_007/c2_w1_br
+ u_t004_007/c2_r0_rbl u_t004_007/c2_r1_rbl u_t004_007/c3_w0_bl u_t004_007/c3_w0_br
+ u_t004_007/c3_w1_bl u_t004_007/c3_w1_br u_t004_007/c3_r0_rbl u_t004_007/c3_r1_rbl
+ u_t004_007/r0_w0_wl u_t004_007/r0_w1_wl u_t004_007/r0_r0_rwl u_t004_007/r0_r1_rwl
+ u_t004_007/r1_w0_wl u_t004_007/r1_w1_wl u_t004_007/r1_r0_rwl u_t004_007/r1_r1_rwl
+ u_t004_007/r2_w0_wl u_t004_007/r2_w1_wl u_t004_007/r2_r0_rwl u_t004_007/r2_r1_rwl
+ u_t004_007/r3_w0_wl u_t004_007/r3_w1_wl u_t004_007/r3_r0_rwl u_t004_007/r3_r1_rwl
+ VSS VSS u_t004_007/m2_717_1265# u_t004_007/m2_603_2031# u_t004_007/m2_1290_336#
+ u_t004_007/m2_2000_2037# u_t004_007/m2_791_2909# u_t004_007/m2_7_2126# u_t004_007/m2_2154_2081#
+ u_t004_007/m2_1795_2037# u_t004_007/m2_871_303# u_t004_007/m2_431_438# u_t004_007/m2_1290_2898#
+ u_t004_007/m2_1714_1210# u_t004_007/m2_431_1982# u_t004_007/m2_512_1265# u_t004_007/m2_2573_2126#
+ u_t004_007/m2_603_1259# u_t004_007/m2_2074_2909# u_t004_007/m2_7_336# u_t004_007/m2_717_2037#
+ u_t004_007/m2_1886_2031# u_t004_007/m2_2573_336# u_t004_007/m2_7_2898# u_t004_007/m2_2000_1265#
+ u_t004_007/m2_512_2037# u_t004_007/m2_1795_1265# u_t004_007/m2_1714_1982# u_t004_007/m2_1886_1259#
+ u_t004_007/m2_1290_2126# u_t004_007/m2_1714_438# u_t004_007/m2_431_1210# u_t004_007/m2_2573_2898#
+ u_t004_007/m2_2154_303# u_t004_007/m2_871_2081# VSUBS detronyx_12t_2w2r_rc4_4x4_routed_5layer_direct
Xgf180mcu_as_sc_mcu7t3v3__inv_2_438 VSS VSS gf180mcu_as_sc_mcu7t3v3__inv_2_551/A gf180mcu_as_sc_mcu7t3v3__inv_2_440/Y
+ gf180mcu_as_sc_mcu7t3v3__inv_2_551/VNW VSUBS gf180mcu_as_sc_mcu7t3v3__inv_2
Xgf180mcu_as_sc_mcu7t3v3__inv_2_427 gf180mcu_as_sc_mcu7t3v3__nor2_2_6/VDD gf180mcu_as_sc_mcu7t3v3__nand3_2_4/VSS
+ VSS VSS gf180mcu_as_sc_mcu7t3v3__nor2_2_6/VNW VSUBS gf180mcu_as_sc_mcu7t3v3__inv_2
Xgf180mcu_as_sc_mcu7t3v3__inv_2_405 gf180mcu_as_sc_mcu7t3v3__nand3_2_9/VDD gf180mcu_as_sc_mcu7t3v3__nor2_2_7/VSS
+ VSS VSS gf180mcu_as_sc_mcu7t3v3__nand3_2_9/VNW VSUBS gf180mcu_as_sc_mcu7t3v3__inv_2
Xgf180mcu_as_sc_mcu7t3v3__inv_2_416 gf180mcu_as_sc_mcu7t3v3__nand3_2_9/VDD gf180mcu_as_sc_mcu7t3v3__nor2_2_4/VSS
+ VSS VSS gf180mcu_as_sc_mcu7t3v3__nand3_2_9/VNW VSUBS gf180mcu_as_sc_mcu7t3v3__inv_2
Xgf180mcu_as_sc_mcu7t3v3__inv_2_449 gf180mcu_as_sc_mcu7t3v3__nand3_2_9/VDD gf180mcu_as_sc_mcu7t3v3__nor2_2_7/VSS
+ VSS VSS gf180mcu_as_sc_mcu7t3v3__nand3_2_9/VNW VSUBS gf180mcu_as_sc_mcu7t3v3__inv_2
Xgf180mcu_as_sc_mcu7t3v3__inv_2_950 VSS VSS VSS gf180mcu_as_sc_mcu7t3v3__inv_2_950/A
+ gf180mcu_as_sc_mcu7t3v3__inv_2_950/VNW VSUBS gf180mcu_as_sc_mcu7t3v3__inv_2
Xgf180mcu_as_sc_mcu7t3v3__inv_2_994 VSS VSS VSS gf180mcu_as_sc_mcu7t3v3__inv_2_995/Y
+ gf180mcu_as_sc_mcu7t3v3__inv_2_996/VNW VSUBS gf180mcu_as_sc_mcu7t3v3__inv_2
Xgf180mcu_as_sc_mcu7t3v3__inv_2_983 VSS VSS gf180mcu_as_sc_mcu7t3v3__inv_2_983/Y gf180mcu_as_sc_mcu7t3v3__inv_2_984/Y
+ gf180mcu_as_sc_mcu7t3v3__inv_2_984/VNW VSUBS gf180mcu_as_sc_mcu7t3v3__inv_2
Xgf180mcu_as_sc_mcu7t3v3__inv_2_961 VSS VSS VSS gf180mcu_as_sc_mcu7t3v3__inv_2_965/Y
+ gf180mcu_as_sc_mcu7t3v3__inv_2_969/VNW VSUBS gf180mcu_as_sc_mcu7t3v3__inv_2
Xgf180mcu_as_sc_mcu7t3v3__inv_2_972 VSS VSS gf180mcu_as_sc_mcu7t3v3__inv_2_972/Y gf180mcu_as_sc_mcu7t3v3__inv_2_972/A
+ gf180mcu_as_sc_mcu7t3v3__inv_2_972/VNW VSUBS gf180mcu_as_sc_mcu7t3v3__inv_2
Xgf180mcu_as_sc_mcu7t3v3__nand4_2_271 VSS VSS VSS VSS VSS VSS gf180mcu_as_sc_mcu7t3v3__inv_2_903/A
+ gf180mcu_as_sc_mcu7t3v3__inv_2_951/VNW VSUBS gf180mcu_as_sc_mcu7t3v3__nand4_2
Xgf180mcu_as_sc_mcu7t3v3__nand4_2_260 VSS VSS VSS VSS VSS VSS gf180mcu_as_sc_mcu7t3v3__inv_2_876/A
+ gf180mcu_as_sc_mcu7t3v3__inv_2_931/VNW VSUBS gf180mcu_as_sc_mcu7t3v3__nand4_2
Xgf180mcu_as_sc_mcu7t3v3__nand4_2_282 VSS VSS VSS VSS VSS VSS gf180mcu_as_sc_mcu7t3v3__inv_2_921/A
+ gf180mcu_as_sc_mcu7t3v3__inv_2_955/VNW VSUBS gf180mcu_as_sc_mcu7t3v3__nand4_2
Xgf180mcu_as_sc_mcu7t3v3__nand4_2_293 VSS VSS VSS VSS VSS VSS gf180mcu_as_sc_mcu7t3v3__inv_2_996/A
+ gf180mcu_as_sc_mcu7t3v3__inv_2_996/VNW VSUBS gf180mcu_as_sc_mcu7t3v3__nand4_2
Xgf180mcu_as_sc_mcu7t3v3__inv_2_268 VSS VSS gf180mcu_as_sc_mcu7t3v3__inv_2_268/Y gf180mcu_as_sc_mcu7t3v3__inv_2_268/A
+ gf180mcu_as_sc_mcu7t3v3__inv_2_268/VNW VSUBS gf180mcu_as_sc_mcu7t3v3__inv_2
Xgf180mcu_as_sc_mcu7t3v3__inv_2_202 VSS VSS gf180mcu_as_sc_mcu7t3v3__inv_2_202/Y gf180mcu_as_sc_mcu7t3v3__inv_2_203/Y
+ gf180mcu_as_sc_mcu7t3v3__inv_2_203/VNW VSUBS gf180mcu_as_sc_mcu7t3v3__inv_2
Xgf180mcu_as_sc_mcu7t3v3__inv_2_279 VSS VSS gf180mcu_as_sc_mcu7t3v3__inv_2_279/Y gf180mcu_as_sc_mcu7t3v3__inv_2_279/A
+ gf180mcu_as_sc_mcu7t3v3__inv_2_279/VNW VSUBS gf180mcu_as_sc_mcu7t3v3__inv_2
Xgf180mcu_as_sc_mcu7t3v3__inv_2_224 VSS VSS gf180mcu_as_sc_mcu7t3v3__inv_2_224/Y gf180mcu_as_sc_mcu7t3v3__inv_2_224/A
+ gf180mcu_as_sc_mcu7t3v3__inv_2_224/VNW VSUBS gf180mcu_as_sc_mcu7t3v3__inv_2
Xgf180mcu_as_sc_mcu7t3v3__inv_2_213 VSS VSS VSS gf180mcu_as_sc_mcu7t3v3__inv_2_214/Y
+ gf180mcu_as_sc_mcu7t3v3__inv_2_215/VNW VSUBS gf180mcu_as_sc_mcu7t3v3__inv_2
Xgf180mcu_as_sc_mcu7t3v3__inv_2_257 VSS VSS gf180mcu_as_sc_mcu7t3v3__inv_2_257/Y gf180mcu_as_sc_mcu7t3v3__inv_2_257/A
+ gf180mcu_as_sc_mcu7t3v3__inv_2_257/VNW VSUBS gf180mcu_as_sc_mcu7t3v3__inv_2
Xgf180mcu_as_sc_mcu7t3v3__inv_2_246 VSS VSS VSS gf180mcu_as_sc_mcu7t3v3__inv_2_247/Y
+ gf180mcu_as_sc_mcu7t3v3__inv_2_248/VNW VSUBS gf180mcu_as_sc_mcu7t3v3__inv_2
Xgf180mcu_as_sc_mcu7t3v3__inv_2_235 VSS VSS gf180mcu_as_sc_mcu7t3v3__inv_2_235/Y gf180mcu_as_sc_mcu7t3v3__inv_2_236/Y
+ gf180mcu_as_sc_mcu7t3v3__inv_2_236/VNW VSUBS gf180mcu_as_sc_mcu7t3v3__inv_2
Xu_t000_010 u_t000_010/c0_w0_bl u_t000_010/c0_w0_br u_t000_010/c0_w1_bl u_t000_010/c0_w1_br
+ u_t000_010/c0_r0_rbl u_t000_010/c0_r1_rbl u_t000_010/c1_w0_bl u_t000_010/c1_w0_br
+ u_t000_010/c1_w1_bl u_t000_010/c1_w1_br u_t000_010/c1_r0_rbl u_t000_010/c1_r1_rbl
+ u_t000_010/c2_w0_bl u_t000_010/c2_w0_br u_t000_010/c2_w1_bl u_t000_010/c2_w1_br
+ u_t000_010/c2_r0_rbl u_t000_010/c2_r1_rbl u_t000_010/c3_w0_bl u_t000_010/c3_w0_br
+ u_t000_010/c3_w1_bl u_t000_010/c3_w1_br u_t000_010/c3_r0_rbl u_t000_010/c3_r1_rbl
+ u_t000_010/r0_w0_wl u_t000_010/r0_w1_wl u_t000_010/r0_r0_rwl u_t000_010/r0_r1_rwl
+ u_t000_010/r1_w0_wl u_t000_010/r1_w1_wl u_t000_010/r1_r0_rwl u_t000_010/r1_r1_rwl
+ u_t000_010/r2_w0_wl u_t000_010/r2_w1_wl u_t000_010/r2_r0_rwl u_t000_010/r2_r1_rwl
+ u_t000_010/r3_w0_wl u_t000_010/r3_w1_wl u_t000_010/r3_r0_rwl u_t000_010/r3_r1_rwl
+ VSS VSS u_t000_010/m2_717_1265# u_t000_010/m2_603_2031# u_t000_010/m2_1290_336#
+ u_t000_010/m2_2000_2037# u_t000_010/m2_791_2909# u_t000_010/m2_7_2126# u_t000_010/m2_2154_2081#
+ u_t000_010/m2_1795_2037# u_t000_010/m2_871_303# u_t000_010/m2_431_438# u_t000_010/m2_1290_2898#
+ u_t000_010/m2_1714_1210# u_t000_010/m2_431_1982# u_t000_010/m2_512_1265# u_t000_010/m2_2573_2126#
+ u_t000_010/m2_603_1259# u_t000_010/m2_2074_2909# u_t000_010/m2_7_336# u_t000_010/m2_717_2037#
+ u_t000_010/m2_1886_2031# u_t000_010/m2_2573_336# u_t000_010/m2_7_2898# u_t000_010/m2_2000_1265#
+ u_t000_010/m2_512_2037# u_t000_010/m2_1795_1265# u_t000_010/m2_1714_1982# u_t000_010/m2_1886_1259#
+ u_t000_010/m2_1290_2126# u_t000_010/m2_1714_438# u_t000_010/m2_431_1210# u_t000_010/m2_2573_2898#
+ u_t000_010/m2_2154_303# u_t000_010/m2_871_2081# VSUBS detronyx_12t_2w2r_rc4_4x4_routed_5layer_direct
Xgf180mcu_as_sc_mcu7t3v3__inv_2_780 VSS VSS gf180mcu_as_sc_mcu7t3v3__inv_2_780/Y gf180mcu_as_sc_mcu7t3v3__inv_2_780/A
+ gf180mcu_as_sc_mcu7t3v3__inv_2_828/VNW VSUBS gf180mcu_as_sc_mcu7t3v3__inv_2
Xgf180mcu_as_sc_mcu7t3v3__inv_2_791 VSS VSS gf180mcu_as_sc_mcu7t3v3__inv_2_791/Y gf180mcu_as_sc_mcu7t3v3__inv_2_791/A
+ gf180mcu_as_sc_mcu7t3v3__inv_2_849/VNW VSUBS gf180mcu_as_sc_mcu7t3v3__inv_2
Xgf180mcu_as_sc_mcu7t3v3__inv_2_1509 VSS VSS VSS gf180mcu_as_sc_mcu7t3v3__inv_2_1510/Y
+ gf180mcu_as_sc_mcu7t3v3__inv_2_1511/VNW VSUBS gf180mcu_as_sc_mcu7t3v3__inv_2
Xgf180mcu_as_sc_mcu7t3v3__nand2_2_8 gf180mcu_as_sc_mcu7t3v3__nand3_2_9/VDD gf180mcu_as_sc_mcu7t3v3__nor2_2_4/VSS
+ VSS VSS VSS gf180mcu_as_sc_mcu7t3v3__nand3_2_9/VNW VSUBS gf180mcu_as_sc_mcu7t3v3__nand2_2
Xgf180mcu_as_sc_mcu7t3v3__nor2_2_3 gf180mcu_as_sc_mcu7t3v3__nor2_2_7/VDD gf180mcu_as_sc_mcu7t3v3__nor2_2_7/VSS
+ VSS VSS VSS gf180mcu_as_sc_mcu7t3v3__nor2_2_7/VNW VSUBS gf180mcu_as_sc_mcu7t3v3__nor2_2
Xgf180mcu_as_sc_mcu7t3v3__inv_2_1306 VSS VSS gf180mcu_as_sc_mcu7t3v3__inv_2_1306/Y
+ gf180mcu_as_sc_mcu7t3v3__inv_2_1307/Y gf180mcu_as_sc_mcu7t3v3__inv_2_1307/VNW VSUBS
+ gf180mcu_as_sc_mcu7t3v3__inv_2
Xgf180mcu_as_sc_mcu7t3v3__inv_2_1317 VSS VSS gf180mcu_as_sc_mcu7t3v3__inv_2_1317/Y
+ gf180mcu_as_sc_mcu7t3v3__inv_2_1317/A gf180mcu_as_sc_mcu7t3v3__inv_2_1317/VNW VSUBS
+ gf180mcu_as_sc_mcu7t3v3__inv_2
Xgf180mcu_as_sc_mcu7t3v3__inv_2_1339 VSS VSS gf180mcu_as_sc_mcu7t3v3__inv_2_1339/Y
+ gf180mcu_as_sc_mcu7t3v3__inv_2_1340/Y gf180mcu_as_sc_mcu7t3v3__inv_2_1340/VNW VSUBS
+ gf180mcu_as_sc_mcu7t3v3__inv_2
Xgf180mcu_as_sc_mcu7t3v3__inv_2_1328 VSS VSS gf180mcu_as_sc_mcu7t3v3__inv_2_1328/Y
+ gf180mcu_as_sc_mcu7t3v3__inv_2_1328/A gf180mcu_as_sc_mcu7t3v3__inv_2_1328/VNW VSUBS
+ gf180mcu_as_sc_mcu7t3v3__inv_2
Xu_t028_013 u_t028_013/c0_w0_bl u_t028_013/c0_w0_br u_t028_013/c0_w1_bl u_t028_013/c0_w1_br
+ u_t028_013/c0_r0_rbl u_t028_013/c0_r1_rbl u_t028_013/c1_w0_bl u_t028_013/c1_w0_br
+ u_t028_013/c1_w1_bl u_t028_013/c1_w1_br u_t028_013/c1_r0_rbl u_t028_013/c1_r1_rbl
+ u_t028_013/c2_w0_bl u_t028_013/c2_w0_br u_t028_013/c2_w1_bl u_t028_013/c2_w1_br
+ u_t028_013/c2_r0_rbl u_t028_013/c2_r1_rbl u_t028_013/c3_w0_bl u_t028_013/c3_w0_br
+ u_t028_013/c3_w1_bl u_t028_013/c3_w1_br u_t028_013/c3_r0_rbl u_t028_013/c3_r1_rbl
+ u_t028_013/r0_w0_wl u_t028_013/r0_w1_wl u_t028_013/r0_r0_rwl u_t028_013/r0_r1_rwl
+ u_t028_013/r1_w0_wl u_t028_013/r1_w1_wl u_t028_013/r1_r0_rwl u_t028_013/r1_r1_rwl
+ u_t028_013/r2_w0_wl u_t028_013/r2_w1_wl u_t028_013/r2_r0_rwl u_t028_013/r2_r1_rwl
+ u_t028_013/r3_w0_wl u_t028_013/r3_w1_wl u_t028_013/r3_r0_rwl u_t028_013/r3_r1_rwl
+ VSS VSS u_t028_013/m2_717_1265# u_t028_013/m2_603_2031# u_t028_013/m2_1290_336#
+ u_t028_013/m2_2000_2037# u_t028_013/m2_791_2909# u_t028_013/m2_7_2126# u_t028_013/m2_2154_2081#
+ u_t028_013/m2_1795_2037# u_t028_013/m2_871_303# u_t028_013/m2_431_438# u_t028_013/m2_1290_2898#
+ u_t028_013/m2_1714_1210# u_t028_013/m2_431_1982# u_t028_013/m2_512_1265# u_t028_013/m2_2573_2126#
+ u_t028_013/m2_603_1259# u_t028_013/m2_2074_2909# u_t028_013/m2_7_336# u_t028_013/m2_717_2037#
+ u_t028_013/m2_1886_2031# u_t028_013/m2_2573_336# u_t028_013/m2_7_2898# u_t028_013/m2_2000_1265#
+ u_t028_013/m2_512_2037# u_t028_013/m2_1795_1265# u_t028_013/m2_1714_1982# u_t028_013/m2_1886_1259#
+ u_t028_013/m2_1290_2126# u_t028_013/m2_1714_438# u_t028_013/m2_431_1210# u_t028_013/m2_2573_2898#
+ u_t028_013/m2_2154_303# u_t028_013/m2_871_2081# VSUBS detronyx_12t_2w2r_rc4_4x4_routed_5layer_direct
Xu_t028_002 u_t028_002/c0_w0_bl u_t028_002/c0_w0_br u_t028_002/c0_w1_bl u_t028_002/c0_w1_br
+ u_t028_002/c0_r0_rbl u_t028_002/c0_r1_rbl u_t028_002/c1_w0_bl u_t028_002/c1_w0_br
+ u_t028_002/c1_w1_bl u_t028_002/c1_w1_br u_t028_002/c1_r0_rbl u_t028_002/c1_r1_rbl
+ u_t028_002/c2_w0_bl u_t028_002/c2_w0_br u_t028_002/c2_w1_bl u_t028_002/c2_w1_br
+ u_t028_002/c2_r0_rbl u_t028_002/c2_r1_rbl u_t028_002/c3_w0_bl u_t028_002/c3_w0_br
+ u_t028_002/c3_w1_bl u_t028_002/c3_w1_br u_t028_002/c3_r0_rbl u_t028_002/c3_r1_rbl
+ u_t028_002/r0_w0_wl u_t028_002/r0_w1_wl u_t028_002/r0_r0_rwl u_t028_002/r0_r1_rwl
+ u_t028_002/r1_w0_wl u_t028_002/r1_w1_wl u_t028_002/r1_r0_rwl u_t028_002/r1_r1_rwl
+ u_t028_002/r2_w0_wl u_t028_002/r2_w1_wl u_t028_002/r2_r0_rwl u_t028_002/r2_r1_rwl
+ u_t028_002/r3_w0_wl u_t028_002/r3_w1_wl u_t028_002/r3_r0_rwl u_t028_002/r3_r1_rwl
+ VSS VSS u_t028_002/m2_717_1265# u_t028_002/m2_603_2031# u_t028_002/m2_1290_336#
+ u_t028_002/m2_2000_2037# u_t028_002/m2_791_2909# u_t028_002/m2_7_2126# u_t028_002/m2_2154_2081#
+ u_t028_002/m2_1795_2037# u_t028_002/m2_871_303# u_t028_002/m2_431_438# u_t028_002/m2_1290_2898#
+ u_t028_002/m2_1714_1210# u_t028_002/m2_431_1982# u_t028_002/m2_512_1265# u_t028_002/m2_2573_2126#
+ u_t028_002/m2_603_1259# u_t028_002/m2_2074_2909# u_t028_002/m2_7_336# u_t028_002/m2_717_2037#
+ u_t028_002/m2_1886_2031# u_t028_002/m2_2573_336# u_t028_002/m2_7_2898# u_t028_002/m2_2000_1265#
+ u_t028_002/m2_512_2037# u_t028_002/m2_1795_1265# u_t028_002/m2_1714_1982# u_t028_002/m2_1886_1259#
+ u_t028_002/m2_1290_2126# u_t028_002/m2_1714_438# u_t028_002/m2_431_1210# u_t028_002/m2_2573_2898#
+ u_t028_002/m2_2154_303# u_t028_002/m2_871_2081# VSUBS detronyx_12t_2w2r_rc4_4x4_routed_5layer_direct
Xu_t019_013 u_t019_013/c0_w0_bl u_t019_013/c0_w0_br u_t019_013/c0_w1_bl u_t019_013/c0_w1_br
+ u_t019_013/c0_r0_rbl u_t019_013/c0_r1_rbl u_t019_013/c1_w0_bl u_t019_013/c1_w0_br
+ u_t019_013/c1_w1_bl u_t019_013/c1_w1_br u_t019_013/c1_r0_rbl u_t019_013/c1_r1_rbl
+ u_t019_013/c2_w0_bl u_t019_013/c2_w0_br u_t019_013/c2_w1_bl u_t019_013/c2_w1_br
+ u_t019_013/c2_r0_rbl u_t019_013/c2_r1_rbl u_t019_013/c3_w0_bl u_t019_013/c3_w0_br
+ u_t019_013/c3_w1_bl u_t019_013/c3_w1_br u_t019_013/c3_r0_rbl u_t019_013/c3_r1_rbl
+ u_t019_013/r0_w0_wl u_t019_013/r0_w1_wl u_t019_013/r0_r0_rwl u_t019_013/r0_r1_rwl
+ u_t019_013/r1_w0_wl u_t019_013/r1_w1_wl u_t019_013/r1_r0_rwl u_t019_013/r1_r1_rwl
+ u_t019_013/r2_w0_wl u_t019_013/r2_w1_wl u_t019_013/r2_r0_rwl u_t019_013/r2_r1_rwl
+ u_t019_013/r3_w0_wl u_t019_013/r3_w1_wl u_t019_013/r3_r0_rwl u_t019_013/r3_r1_rwl
+ VSS VSS u_t019_013/m2_717_1265# u_t019_013/m2_603_2031# u_t019_013/m2_1290_336#
+ u_t019_013/m2_2000_2037# u_t019_013/m2_791_2909# u_t019_013/m2_7_2126# u_t019_013/m2_2154_2081#
+ u_t019_013/m2_1795_2037# u_t019_013/m2_871_303# u_t019_013/m2_431_438# u_t019_013/m2_1290_2898#
+ u_t019_013/m2_1714_1210# u_t019_013/m2_431_1982# u_t019_013/m2_512_1265# u_t019_013/m2_2573_2126#
+ u_t019_013/m2_603_1259# u_t019_013/m2_2074_2909# u_t019_013/m2_7_336# u_t019_013/m2_717_2037#
+ u_t019_013/m2_1886_2031# u_t019_013/m2_2573_336# u_t019_013/m2_7_2898# u_t019_013/m2_2000_1265#
+ u_t019_013/m2_512_2037# u_t019_013/m2_1795_1265# u_t019_013/m2_1714_1982# u_t019_013/m2_1886_1259#
+ u_t019_013/m2_1290_2126# u_t019_013/m2_1714_438# u_t019_013/m2_431_1210# u_t019_013/m2_2573_2898#
+ u_t019_013/m2_2154_303# u_t019_013/m2_871_2081# VSUBS detronyx_12t_2w2r_rc4_4x4_routed_5layer_direct
Xu_t019_002 u_t019_002/c0_w0_bl u_t019_002/c0_w0_br u_t019_002/c0_w1_bl u_t019_002/c0_w1_br
+ u_t019_002/c0_r0_rbl u_t019_002/c0_r1_rbl u_t019_002/c1_w0_bl u_t019_002/c1_w0_br
+ u_t019_002/c1_w1_bl u_t019_002/c1_w1_br u_t019_002/c1_r0_rbl u_t019_002/c1_r1_rbl
+ u_t019_002/c2_w0_bl u_t019_002/c2_w0_br u_t019_002/c2_w1_bl u_t019_002/c2_w1_br
+ u_t019_002/c2_r0_rbl u_t019_002/c2_r1_rbl u_t019_002/c3_w0_bl u_t019_002/c3_w0_br
+ u_t019_002/c3_w1_bl u_t019_002/c3_w1_br u_t019_002/c3_r0_rbl u_t019_002/c3_r1_rbl
+ u_t019_002/r0_w0_wl u_t019_002/r0_w1_wl u_t019_002/r0_r0_rwl u_t019_002/r0_r1_rwl
+ u_t019_002/r1_w0_wl u_t019_002/r1_w1_wl u_t019_002/r1_r0_rwl u_t019_002/r1_r1_rwl
+ u_t019_002/r2_w0_wl u_t019_002/r2_w1_wl u_t019_002/r2_r0_rwl u_t019_002/r2_r1_rwl
+ u_t019_002/r3_w0_wl u_t019_002/r3_w1_wl u_t019_002/r3_r0_rwl u_t019_002/r3_r1_rwl
+ VSS VSS u_t019_002/m2_717_1265# u_t019_002/m2_603_2031# u_t019_002/m2_1290_336#
+ u_t019_002/m2_2000_2037# u_t019_002/m2_791_2909# u_t019_002/m2_7_2126# u_t019_002/m2_2154_2081#
+ u_t019_002/m2_1795_2037# u_t019_002/m2_871_303# u_t019_002/m2_431_438# u_t019_002/m2_1290_2898#
+ u_t019_002/m2_1714_1210# u_t019_002/m2_431_1982# u_t019_002/m2_512_1265# u_t019_002/m2_2573_2126#
+ u_t019_002/m2_603_1259# u_t019_002/m2_2074_2909# u_t019_002/m2_7_336# u_t019_002/m2_717_2037#
+ u_t019_002/m2_1886_2031# u_t019_002/m2_2573_336# u_t019_002/m2_7_2898# u_t019_002/m2_2000_1265#
+ u_t019_002/m2_512_2037# u_t019_002/m2_1795_1265# u_t019_002/m2_1714_1982# u_t019_002/m2_1886_1259#
+ u_t019_002/m2_1290_2126# u_t019_002/m2_1714_438# u_t019_002/m2_431_1210# u_t019_002/m2_2573_2898#
+ u_t019_002/m2_2154_303# u_t019_002/m2_871_2081# VSUBS detronyx_12t_2w2r_rc4_4x4_routed_5layer_direct
Xgf180mcu_as_sc_mcu7t3v3__nand4_2_17 VSS VSS VSS VSS VSS VSS gf180mcu_as_sc_mcu7t3v3__inv_2_131/A
+ gf180mcu_as_sc_mcu7t3v3__inv_2_131/VNW VSUBS gf180mcu_as_sc_mcu7t3v3__nand4_2
Xgf180mcu_as_sc_mcu7t3v3__nand4_2_39 VSS VSS VSS VSS VSS VSS gf180mcu_as_sc_mcu7t3v3__inv_2_197/A
+ gf180mcu_as_sc_mcu7t3v3__inv_2_197/VNW VSUBS gf180mcu_as_sc_mcu7t3v3__nand4_2
Xgf180mcu_as_sc_mcu7t3v3__nand4_2_28 VSS VSS VSS VSS VSS VSS gf180mcu_as_sc_mcu7t3v3__inv_2_165/A
+ gf180mcu_as_sc_mcu7t3v3__inv_2_165/VNW VSUBS gf180mcu_as_sc_mcu7t3v3__nand4_2
Xu_t025_005 u_t025_005/c0_w0_bl u_t025_005/c0_w0_br u_t025_005/c0_w1_bl u_t025_005/c0_w1_br
+ u_t025_005/c0_r0_rbl u_t025_005/c0_r1_rbl u_t025_005/c1_w0_bl u_t025_005/c1_w0_br
+ u_t025_005/c1_w1_bl u_t025_005/c1_w1_br u_t025_005/c1_r0_rbl u_t025_005/c1_r1_rbl
+ u_t025_005/c2_w0_bl u_t025_005/c2_w0_br u_t025_005/c2_w1_bl u_t025_005/c2_w1_br
+ u_t025_005/c2_r0_rbl u_t025_005/c2_r1_rbl u_t025_005/c3_w0_bl u_t025_005/c3_w0_br
+ u_t025_005/c3_w1_bl u_t025_005/c3_w1_br u_t025_005/c3_r0_rbl u_t025_005/c3_r1_rbl
+ u_t025_005/r0_w0_wl u_t025_005/r0_w1_wl u_t025_005/r0_r0_rwl u_t025_005/r0_r1_rwl
+ u_t025_005/r1_w0_wl u_t025_005/r1_w1_wl u_t025_005/r1_r0_rwl u_t025_005/r1_r1_rwl
+ u_t025_005/r2_w0_wl u_t025_005/r2_w1_wl u_t025_005/r2_r0_rwl u_t025_005/r2_r1_rwl
+ u_t025_005/r3_w0_wl u_t025_005/r3_w1_wl u_t025_005/r3_r0_rwl u_t025_005/r3_r1_rwl
+ VSS VSS u_t025_005/m2_717_1265# u_t025_005/m2_603_2031# u_t025_005/m2_1290_336#
+ u_t025_005/m2_2000_2037# u_t025_005/m2_791_2909# u_t025_005/m2_7_2126# u_t025_005/m2_2154_2081#
+ u_t025_005/m2_1795_2037# u_t025_005/m2_871_303# u_t025_005/m2_431_438# u_t025_005/m2_1290_2898#
+ u_t025_005/m2_1714_1210# u_t025_005/m2_431_1982# u_t025_005/m2_512_1265# u_t025_005/m2_2573_2126#
+ u_t025_005/m2_603_1259# u_t025_005/m2_2074_2909# u_t025_005/m2_7_336# u_t025_005/m2_717_2037#
+ u_t025_005/m2_1886_2031# u_t025_005/m2_2573_336# u_t025_005/m2_7_2898# u_t025_005/m2_2000_1265#
+ u_t025_005/m2_512_2037# u_t025_005/m2_1795_1265# u_t025_005/m2_1714_1982# u_t025_005/m2_1886_1259#
+ u_t025_005/m2_1290_2126# u_t025_005/m2_1714_438# u_t025_005/m2_431_1210# u_t025_005/m2_2573_2898#
+ u_t025_005/m2_2154_303# u_t025_005/m2_871_2081# VSUBS detronyx_12t_2w2r_rc4_4x4_routed_5layer_direct
Xgf180mcu_as_sc_mcu7t3v3__inv_2_1136 VSS VSS gf180mcu_as_sc_mcu7t3v3__inv_2_1136/Y
+ gf180mcu_as_sc_mcu7t3v3__inv_2_1136/A gf180mcu_as_sc_mcu7t3v3__inv_2_1136/VNW VSUBS
+ gf180mcu_as_sc_mcu7t3v3__inv_2
Xgf180mcu_as_sc_mcu7t3v3__inv_2_1114 VSS VSS gf180mcu_as_sc_mcu7t3v3__inv_2_1114/Y
+ gf180mcu_as_sc_mcu7t3v3__inv_2_1115/Y gf180mcu_as_sc_mcu7t3v3__inv_2_1115/VNW VSUBS
+ gf180mcu_as_sc_mcu7t3v3__inv_2
Xgf180mcu_as_sc_mcu7t3v3__inv_2_1147 VSS VSS gf180mcu_as_sc_mcu7t3v3__inv_2_1147/Y
+ gf180mcu_as_sc_mcu7t3v3__inv_2_1148/Y gf180mcu_as_sc_mcu7t3v3__inv_2_1148/VNW VSUBS
+ gf180mcu_as_sc_mcu7t3v3__inv_2
Xgf180mcu_as_sc_mcu7t3v3__inv_2_1125 VSS VSS VSS gf180mcu_as_sc_mcu7t3v3__inv_2_1126/Y
+ gf180mcu_as_sc_mcu7t3v3__inv_2_1130/VNW VSUBS gf180mcu_as_sc_mcu7t3v3__inv_2
Xgf180mcu_as_sc_mcu7t3v3__inv_2_1158 VSS VSS gf180mcu_as_sc_mcu7t3v3__inv_2_1291/A
+ gf180mcu_as_sc_mcu7t3v3__inv_2_1159/Y gf180mcu_as_sc_mcu7t3v3__inv_2_1291/VNW VSUBS
+ gf180mcu_as_sc_mcu7t3v3__inv_2
Xgf180mcu_as_sc_mcu7t3v3__inv_2_1103 VSS VSS gf180mcu_as_sc_mcu7t3v3__inv_2_1103/Y
+ gf180mcu_as_sc_mcu7t3v3__inv_2_1103/A gf180mcu_as_sc_mcu7t3v3__inv_2_1103/VNW VSUBS
+ gf180mcu_as_sc_mcu7t3v3__inv_2
Xgf180mcu_as_sc_mcu7t3v3__inv_2_1169 VSS VSS gf180mcu_as_sc_mcu7t3v3__inv_2_1169/Y
+ gf180mcu_as_sc_mcu7t3v3__inv_2_1169/A gf180mcu_as_sc_mcu7t3v3__inv_2_1287/VNW VSUBS
+ gf180mcu_as_sc_mcu7t3v3__inv_2
Xu_t031_008 u_t031_008/c0_w0_bl u_t031_008/c0_w0_br u_t031_008/c0_w1_bl u_t031_008/c0_w1_br
+ u_t031_008/c0_r0_rbl u_t031_008/c0_r1_rbl u_t031_008/c1_w0_bl u_t031_008/c1_w0_br
+ u_t031_008/c1_w1_bl u_t031_008/c1_w1_br u_t031_008/c1_r0_rbl u_t031_008/c1_r1_rbl
+ u_t031_008/c2_w0_bl u_t031_008/c2_w0_br u_t031_008/c2_w1_bl u_t031_008/c2_w1_br
+ u_t031_008/c2_r0_rbl u_t031_008/c2_r1_rbl u_t031_008/c3_w0_bl u_t031_008/c3_w0_br
+ u_t031_008/c3_w1_bl u_t031_008/c3_w1_br u_t031_008/c3_r0_rbl u_t031_008/c3_r1_rbl
+ u_t031_008/r0_w0_wl u_t031_008/r0_w1_wl u_t031_008/r0_r0_rwl u_t031_008/r0_r1_rwl
+ u_t031_008/r1_w0_wl u_t031_008/r1_w1_wl u_t031_008/r1_r0_rwl u_t031_008/r1_r1_rwl
+ u_t031_008/r2_w0_wl u_t031_008/r2_w1_wl u_t031_008/r2_r0_rwl u_t031_008/r2_r1_rwl
+ u_t031_008/r3_w0_wl u_t031_008/r3_w1_wl u_t031_008/r3_r0_rwl u_t031_008/r3_r1_rwl
+ VSS VSS u_t031_008/m2_717_1265# u_t031_008/m2_603_2031# u_t031_008/m2_1290_336#
+ u_t031_008/m2_2000_2037# u_t031_008/m2_791_2909# u_t031_008/m2_7_2126# u_t031_008/m2_2154_2081#
+ u_t031_008/m2_1795_2037# u_t031_008/m2_871_303# u_t031_008/m2_431_438# u_t031_008/m2_1290_2898#
+ u_t031_008/m2_1714_1210# u_t031_008/m2_431_1982# u_t031_008/m2_512_1265# u_t031_008/m2_2573_2126#
+ u_t031_008/m2_603_1259# u_t031_008/m2_2074_2909# u_t031_008/m2_7_336# u_t031_008/m2_717_2037#
+ u_t031_008/m2_1886_2031# u_t031_008/m2_2573_336# u_t031_008/m2_7_2898# u_t031_008/m2_2000_1265#
+ u_t031_008/m2_512_2037# u_t031_008/m2_1795_1265# u_t031_008/m2_1714_1982# u_t031_008/m2_1886_1259#
+ u_t031_008/m2_1290_2126# u_t031_008/m2_1714_438# u_t031_008/m2_431_1210# u_t031_008/m2_2573_2898#
+ u_t031_008/m2_2154_303# u_t031_008/m2_871_2081# VSUBS detronyx_12t_2w2r_rc4_4x4_routed_5layer_direct
Xu_t016_005 u_t016_005/c0_w0_bl u_t016_005/c0_w0_br u_t016_005/c0_w1_bl u_t016_005/c0_w1_br
+ u_t016_005/c0_r0_rbl u_t016_005/c0_r1_rbl u_t016_005/c1_w0_bl u_t016_005/c1_w0_br
+ u_t016_005/c1_w1_bl u_t016_005/c1_w1_br u_t016_005/c1_r0_rbl u_t016_005/c1_r1_rbl
+ u_t016_005/c2_w0_bl u_t016_005/c2_w0_br u_t016_005/c2_w1_bl u_t016_005/c2_w1_br
+ u_t016_005/c2_r0_rbl u_t016_005/c2_r1_rbl u_t016_005/c3_w0_bl u_t016_005/c3_w0_br
+ u_t016_005/c3_w1_bl u_t016_005/c3_w1_br u_t016_005/c3_r0_rbl u_t016_005/c3_r1_rbl
+ u_t016_005/r0_w0_wl u_t016_005/r0_w1_wl u_t016_005/r0_r0_rwl u_t016_005/r0_r1_rwl
+ u_t016_005/r1_w0_wl u_t016_005/r1_w1_wl u_t016_005/r1_r0_rwl u_t016_005/r1_r1_rwl
+ u_t016_005/r2_w0_wl u_t016_005/r2_w1_wl u_t016_005/r2_r0_rwl u_t016_005/r2_r1_rwl
+ u_t016_005/r3_w0_wl u_t016_005/r3_w1_wl u_t016_005/r3_r0_rwl u_t016_005/r3_r1_rwl
+ VSS VSS u_t016_005/m2_717_1265# u_t016_005/m2_603_2031# u_t016_005/m2_1290_336#
+ u_t016_005/m2_2000_2037# u_t016_005/m2_791_2909# u_t016_005/m2_7_2126# u_t016_005/m2_2154_2081#
+ u_t016_005/m2_1795_2037# u_t016_005/m2_871_303# u_t016_005/m2_431_438# u_t016_005/m2_1290_2898#
+ u_t016_005/m2_1714_1210# u_t016_005/m2_431_1982# u_t016_005/m2_512_1265# u_t016_005/m2_2573_2126#
+ u_t016_005/m2_603_1259# u_t016_005/m2_2074_2909# u_t016_005/m2_7_336# u_t016_005/m2_717_2037#
+ u_t016_005/m2_1886_2031# u_t016_005/m2_2573_336# u_t016_005/m2_7_2898# u_t016_005/m2_2000_1265#
+ u_t016_005/m2_512_2037# u_t016_005/m2_1795_1265# u_t016_005/m2_1714_1982# u_t016_005/m2_1886_1259#
+ u_t016_005/m2_1290_2126# u_t016_005/m2_1714_438# u_t016_005/m2_431_1210# u_t016_005/m2_2573_2898#
+ u_t016_005/m2_2154_303# u_t016_005/m2_871_2081# VSUBS detronyx_12t_2w2r_rc4_4x4_routed_5layer_direct
Xgf180mcu_as_sc_mcu7t3v3__nand3_2_50 gf180mcu_as_sc_mcu7t3v3__nor2_2_9/VDD gf180mcu_as_sc_mcu7t3v3__nor2_2_9/VSS
+ VSS VSS VSS VSS gf180mcu_as_sc_mcu7t3v3__nor2_2_9/VNW VSUBS gf180mcu_as_sc_mcu7t3v3__nand3_2
Xgf180mcu_as_sc_mcu7t3v3__nand3_2_61 gf180mcu_as_sc_mcu7t3v3__nand3_2_65/VDD gf180mcu_as_sc_mcu7t3v3__nand3_2_62/VSS
+ VSS VSS VSS VSS gf180mcu_as_sc_mcu7t3v3__nand3_2_65/VNW VSUBS gf180mcu_as_sc_mcu7t3v3__nand3_2
Xgf180mcu_as_sc_mcu7t3v3__inv_2_609 VSS VSS gf180mcu_as_sc_mcu7t3v3__inv_2_609/Y gf180mcu_as_sc_mcu7t3v3__inv_2_610/Y
+ gf180mcu_as_sc_mcu7t3v3__inv_2_610/VNW VSUBS gf180mcu_as_sc_mcu7t3v3__inv_2
Xgf180mcu_as_sc_mcu7t3v3__inv_2_1681 VSS VSS gf180mcu_as_sc_mcu7t3v3__inv_2_1681/Y
+ gf180mcu_as_sc_mcu7t3v3__inv_2_1681/A gf180mcu_as_sc_mcu7t3v3__inv_2_1681/VNW VSUBS
+ gf180mcu_as_sc_mcu7t3v3__inv_2
Xgf180mcu_as_sc_mcu7t3v3__inv_2_1670 VSS VSS VSS gf180mcu_as_sc_mcu7t3v3__inv_2_1671/Y
+ gf180mcu_as_sc_mcu7t3v3__inv_2_1672/VNW VSUBS gf180mcu_as_sc_mcu7t3v3__inv_2
Xgf180mcu_as_sc_mcu7t3v3__inv_2_1692 VSS VSS VSS gf180mcu_as_sc_mcu7t3v3__inv_2_1693/Y
+ gf180mcu_as_sc_mcu7t3v3__inv_2_1694/VNW VSUBS gf180mcu_as_sc_mcu7t3v3__inv_2
Xu_t007_005 u_t007_005/c0_w0_bl u_t007_005/c0_w0_br u_t007_005/c0_w1_bl u_t007_005/c0_w1_br
+ u_t007_005/c0_r0_rbl u_t007_005/c0_r1_rbl u_t007_005/c1_w0_bl u_t007_005/c1_w0_br
+ u_t007_005/c1_w1_bl u_t007_005/c1_w1_br u_t007_005/c1_r0_rbl u_t007_005/c1_r1_rbl
+ u_t007_005/c2_w0_bl u_t007_005/c2_w0_br u_t007_005/c2_w1_bl u_t007_005/c2_w1_br
+ u_t007_005/c2_r0_rbl u_t007_005/c2_r1_rbl u_t007_005/c3_w0_bl u_t007_005/c3_w0_br
+ u_t007_005/c3_w1_bl u_t007_005/c3_w1_br u_t007_005/c3_r0_rbl u_t007_005/c3_r1_rbl
+ u_t007_005/r0_w0_wl u_t007_005/r0_w1_wl u_t007_005/r0_r0_rwl u_t007_005/r0_r1_rwl
+ u_t007_005/r1_w0_wl u_t007_005/r1_w1_wl u_t007_005/r1_r0_rwl u_t007_005/r1_r1_rwl
+ u_t007_005/r2_w0_wl u_t007_005/r2_w1_wl u_t007_005/r2_r0_rwl u_t007_005/r2_r1_rwl
+ u_t007_005/r3_w0_wl u_t007_005/r3_w1_wl u_t007_005/r3_r0_rwl u_t007_005/r3_r1_rwl
+ VSS VSS u_t007_005/m2_717_1265# u_t007_005/m2_603_2031# u_t007_005/m2_1290_336#
+ u_t007_005/m2_2000_2037# u_t007_005/m2_791_2909# u_t007_005/m2_7_2126# u_t007_005/m2_2154_2081#
+ u_t007_005/m2_1795_2037# u_t007_005/m2_871_303# u_t007_005/m2_431_438# u_t007_005/m2_1290_2898#
+ u_t007_005/m2_1714_1210# u_t007_005/m2_431_1982# u_t007_005/m2_512_1265# u_t007_005/m2_2573_2126#
+ u_t007_005/m2_603_1259# u_t007_005/m2_2074_2909# u_t007_005/m2_7_336# u_t007_005/m2_717_2037#
+ u_t007_005/m2_1886_2031# u_t007_005/m2_2573_336# u_t007_005/m2_7_2898# u_t007_005/m2_2000_1265#
+ u_t007_005/m2_512_2037# u_t007_005/m2_1795_1265# u_t007_005/m2_1714_1982# u_t007_005/m2_1886_1259#
+ u_t007_005/m2_1290_2126# u_t007_005/m2_1714_438# u_t007_005/m2_431_1210# u_t007_005/m2_2573_2898#
+ u_t007_005/m2_2154_303# u_t007_005/m2_871_2081# VSUBS detronyx_12t_2w2r_rc4_4x4_routed_5layer_direct
Xu_t022_008 u_t022_008/c0_w0_bl u_t022_008/c0_w0_br u_t022_008/c0_w1_bl u_t022_008/c0_w1_br
+ u_t022_008/c0_r0_rbl u_t022_008/c0_r1_rbl u_t022_008/c1_w0_bl u_t022_008/c1_w0_br
+ u_t022_008/c1_w1_bl u_t022_008/c1_w1_br u_t022_008/c1_r0_rbl u_t022_008/c1_r1_rbl
+ u_t022_008/c2_w0_bl u_t022_008/c2_w0_br u_t022_008/c2_w1_bl u_t022_008/c2_w1_br
+ u_t022_008/c2_r0_rbl u_t022_008/c2_r1_rbl u_t022_008/c3_w0_bl u_t022_008/c3_w0_br
+ u_t022_008/c3_w1_bl u_t022_008/c3_w1_br u_t022_008/c3_r0_rbl u_t022_008/c3_r1_rbl
+ u_t022_008/r0_w0_wl u_t022_008/r0_w1_wl u_t022_008/r0_r0_rwl u_t022_008/r0_r1_rwl
+ u_t022_008/r1_w0_wl u_t022_008/r1_w1_wl u_t022_008/r1_r0_rwl u_t022_008/r1_r1_rwl
+ u_t022_008/r2_w0_wl u_t022_008/r2_w1_wl u_t022_008/r2_r0_rwl u_t022_008/r2_r1_rwl
+ u_t022_008/r3_w0_wl u_t022_008/r3_w1_wl u_t022_008/r3_r0_rwl u_t022_008/r3_r1_rwl
+ VSS VSS u_t022_008/m2_717_1265# u_t022_008/m2_603_2031# u_t022_008/m2_1290_336#
+ u_t022_008/m2_2000_2037# u_t022_008/m2_791_2909# u_t022_008/m2_7_2126# u_t022_008/m2_2154_2081#
+ u_t022_008/m2_1795_2037# u_t022_008/m2_871_303# u_t022_008/m2_431_438# u_t022_008/m2_1290_2898#
+ u_t022_008/m2_1714_1210# u_t022_008/m2_431_1982# u_t022_008/m2_512_1265# u_t022_008/m2_2573_2126#
+ u_t022_008/m2_603_1259# u_t022_008/m2_2074_2909# u_t022_008/m2_7_336# u_t022_008/m2_717_2037#
+ u_t022_008/m2_1886_2031# u_t022_008/m2_2573_336# u_t022_008/m2_7_2898# u_t022_008/m2_2000_1265#
+ u_t022_008/m2_512_2037# u_t022_008/m2_1795_1265# u_t022_008/m2_1714_1982# u_t022_008/m2_1886_1259#
+ u_t022_008/m2_1290_2126# u_t022_008/m2_1714_438# u_t022_008/m2_431_1210# u_t022_008/m2_2573_2898#
+ u_t022_008/m2_2154_303# u_t022_008/m2_871_2081# VSUBS detronyx_12t_2w2r_rc4_4x4_routed_5layer_direct
Xgf180mcu_as_sc_mcu7t3v3__nand4_2_442 VSS VSS VSS VSS VSS VSS gf180mcu_as_sc_mcu7t3v3__inv_2_1597/A
+ gf180mcu_as_sc_mcu7t3v3__inv_2_1597/VNW VSUBS gf180mcu_as_sc_mcu7t3v3__nand4_2
Xgf180mcu_as_sc_mcu7t3v3__nand4_2_431 VSS VSS VSS VSS VSS VSS gf180mcu_as_sc_mcu7t3v3__inv_2_1564/A
+ gf180mcu_as_sc_mcu7t3v3__inv_2_1598/VNW VSUBS gf180mcu_as_sc_mcu7t3v3__nand4_2
Xgf180mcu_as_sc_mcu7t3v3__nand4_2_420 VSS VSS VSS VSS VSS VSS gf180mcu_as_sc_mcu7t3v3__inv_2_1532/A
+ gf180mcu_as_sc_mcu7t3v3__inv_2_1532/VNW VSUBS gf180mcu_as_sc_mcu7t3v3__nand4_2
Xgf180mcu_as_sc_mcu7t3v3__nand4_2_453 VSS VSS VSS VSS VSS VSS gf180mcu_as_sc_mcu7t3v3__inv_2_1348/A
+ gf180mcu_as_sc_mcu7t3v3__inv_2_1348/VNW VSUBS gf180mcu_as_sc_mcu7t3v3__nand4_2
Xgf180mcu_as_sc_mcu7t3v3__nand4_2_497 VSS VSS VSS VSS VSS VSS gf180mcu_as_sc_mcu7t3v3__inv_2_1626/A
+ gf180mcu_as_sc_mcu7t3v3__inv_2_1626/VNW VSUBS gf180mcu_as_sc_mcu7t3v3__nand4_2
Xgf180mcu_as_sc_mcu7t3v3__nand4_2_486 VSS VSS VSS VSS VSS VSS gf180mcu_as_sc_mcu7t3v3__inv_2_1668/A
+ gf180mcu_as_sc_mcu7t3v3__inv_2_1668/VNW VSUBS gf180mcu_as_sc_mcu7t3v3__nand4_2
Xgf180mcu_as_sc_mcu7t3v3__nand4_2_464 VSS VSS VSS VSS VSS VSS gf180mcu_as_sc_mcu7t3v3__inv_2_1362/A
+ gf180mcu_as_sc_mcu7t3v3__inv_2_1362/VNW VSUBS gf180mcu_as_sc_mcu7t3v3__nand4_2
Xgf180mcu_as_sc_mcu7t3v3__nand4_2_475 VSS VSS VSS VSS VSS VSS gf180mcu_as_sc_mcu7t3v3__inv_2_1406/A
+ gf180mcu_as_sc_mcu7t3v3__inv_2_1406/VNW VSUBS gf180mcu_as_sc_mcu7t3v3__nand4_2
Xu_t013_008 u_t013_008/c0_w0_bl u_t013_008/c0_w0_br u_t013_008/c0_w1_bl u_t013_008/c0_w1_br
+ u_t013_008/c0_r0_rbl u_t013_008/c0_r1_rbl u_t013_008/c1_w0_bl u_t013_008/c1_w0_br
+ u_t013_008/c1_w1_bl u_t013_008/c1_w1_br u_t013_008/c1_r0_rbl u_t013_008/c1_r1_rbl
+ u_t013_008/c2_w0_bl u_t013_008/c2_w0_br u_t013_008/c2_w1_bl u_t013_008/c2_w1_br
+ u_t013_008/c2_r0_rbl u_t013_008/c2_r1_rbl u_t013_008/c3_w0_bl u_t013_008/c3_w0_br
+ u_t013_008/c3_w1_bl u_t013_008/c3_w1_br u_t013_008/c3_r0_rbl u_t013_008/c3_r1_rbl
+ u_t013_008/r0_w0_wl u_t013_008/r0_w1_wl u_t013_008/r0_r0_rwl u_t013_008/r0_r1_rwl
+ u_t013_008/r1_w0_wl u_t013_008/r1_w1_wl u_t013_008/r1_r0_rwl u_t013_008/r1_r1_rwl
+ u_t013_008/r2_w0_wl u_t013_008/r2_w1_wl u_t013_008/r2_r0_rwl u_t013_008/r2_r1_rwl
+ u_t013_008/r3_w0_wl u_t013_008/r3_w1_wl u_t013_008/r3_r0_rwl u_t013_008/r3_r1_rwl
+ VSS VSS u_t013_008/m2_717_1265# u_t013_008/m2_603_2031# u_t013_008/m2_1290_336#
+ u_t013_008/m2_2000_2037# u_t013_008/m2_791_2909# u_t013_008/m2_7_2126# u_t013_008/m2_2154_2081#
+ u_t013_008/m2_1795_2037# u_t013_008/m2_871_303# u_t013_008/m2_431_438# u_t013_008/m2_1290_2898#
+ u_t013_008/m2_1714_1210# u_t013_008/m2_431_1982# u_t013_008/m2_512_1265# u_t013_008/m2_2573_2126#
+ u_t013_008/m2_603_1259# u_t013_008/m2_2074_2909# u_t013_008/m2_7_336# u_t013_008/m2_717_2037#
+ u_t013_008/m2_1886_2031# u_t013_008/m2_2573_336# u_t013_008/m2_7_2898# u_t013_008/m2_2000_1265#
+ u_t013_008/m2_512_2037# u_t013_008/m2_1795_1265# u_t013_008/m2_1714_1982# u_t013_008/m2_1886_1259#
+ u_t013_008/m2_1290_2126# u_t013_008/m2_1714_438# u_t013_008/m2_431_1210# u_t013_008/m2_2573_2898#
+ u_t013_008/m2_2154_303# u_t013_008/m2_871_2081# VSUBS detronyx_12t_2w2r_rc4_4x4_routed_5layer_direct
Xu_t004_008 u_t004_008/c0_w0_bl u_t004_008/c0_w0_br u_t004_008/c0_w1_bl u_t004_008/c0_w1_br
+ u_t004_008/c0_r0_rbl u_t004_008/c0_r1_rbl u_t004_008/c1_w0_bl u_t004_008/c1_w0_br
+ u_t004_008/c1_w1_bl u_t004_008/c1_w1_br u_t004_008/c1_r0_rbl u_t004_008/c1_r1_rbl
+ u_t004_008/c2_w0_bl u_t004_008/c2_w0_br u_t004_008/c2_w1_bl u_t004_008/c2_w1_br
+ u_t004_008/c2_r0_rbl u_t004_008/c2_r1_rbl u_t004_008/c3_w0_bl u_t004_008/c3_w0_br
+ u_t004_008/c3_w1_bl u_t004_008/c3_w1_br u_t004_008/c3_r0_rbl u_t004_008/c3_r1_rbl
+ u_t004_008/r0_w0_wl u_t004_008/r0_w1_wl u_t004_008/r0_r0_rwl u_t004_008/r0_r1_rwl
+ u_t004_008/r1_w0_wl u_t004_008/r1_w1_wl u_t004_008/r1_r0_rwl u_t004_008/r1_r1_rwl
+ u_t004_008/r2_w0_wl u_t004_008/r2_w1_wl u_t004_008/r2_r0_rwl u_t004_008/r2_r1_rwl
+ u_t004_008/r3_w0_wl u_t004_008/r3_w1_wl u_t004_008/r3_r0_rwl u_t004_008/r3_r1_rwl
+ VSS VSS u_t004_008/m2_717_1265# u_t004_008/m2_603_2031# u_t004_008/m2_1290_336#
+ u_t004_008/m2_2000_2037# u_t004_008/m2_791_2909# u_t004_008/m2_7_2126# u_t004_008/m2_2154_2081#
+ u_t004_008/m2_1795_2037# u_t004_008/m2_871_303# u_t004_008/m2_431_438# u_t004_008/m2_1290_2898#
+ u_t004_008/m2_1714_1210# u_t004_008/m2_431_1982# u_t004_008/m2_512_1265# u_t004_008/m2_2573_2126#
+ u_t004_008/m2_603_1259# u_t004_008/m2_2074_2909# u_t004_008/m2_7_336# u_t004_008/m2_717_2037#
+ u_t004_008/m2_1886_2031# u_t004_008/m2_2573_336# u_t004_008/m2_7_2898# u_t004_008/m2_2000_1265#
+ u_t004_008/m2_512_2037# u_t004_008/m2_1795_1265# u_t004_008/m2_1714_1982# u_t004_008/m2_1886_1259#
+ u_t004_008/m2_1290_2126# u_t004_008/m2_1714_438# u_t004_008/m2_431_1210# u_t004_008/m2_2573_2898#
+ u_t004_008/m2_2154_303# u_t004_008/m2_871_2081# VSUBS detronyx_12t_2w2r_rc4_4x4_routed_5layer_direct
Xgf180mcu_as_sc_mcu7t3v3__inv_2_439 VSS VSS gf180mcu_as_sc_mcu7t3v3__inv_2_549/A gf180mcu_as_sc_mcu7t3v3__inv_2_483/Y
+ gf180mcu_as_sc_mcu7t3v3__inv_2_549/VNW VSUBS gf180mcu_as_sc_mcu7t3v3__inv_2
Xgf180mcu_as_sc_mcu7t3v3__inv_2_428 gf180mcu_as_sc_mcu7t3v3__nor2_2_7/VDD gf180mcu_as_sc_mcu7t3v3__nand3_2_4/VSS
+ VSS VSS gf180mcu_as_sc_mcu7t3v3__nor2_2_7/VNW VSUBS gf180mcu_as_sc_mcu7t3v3__inv_2
Xgf180mcu_as_sc_mcu7t3v3__inv_2_406 gf180mcu_as_sc_mcu7t3v3__nand3_2_9/VDD gf180mcu_as_sc_mcu7t3v3__nor2_2_4/VSS
+ VSS VSS gf180mcu_as_sc_mcu7t3v3__nand3_2_9/VNW VSUBS gf180mcu_as_sc_mcu7t3v3__inv_2
Xgf180mcu_as_sc_mcu7t3v3__inv_2_417 gf180mcu_as_sc_mcu7t3v3__nor2_2_4/VDD gf180mcu_as_sc_mcu7t3v3__nor2_2_4/VSS
+ VSS VSS gf180mcu_as_sc_mcu7t3v3__nor2_2_4/VNW VSUBS gf180mcu_as_sc_mcu7t3v3__inv_2
Xgf180mcu_as_sc_mcu7t3v3__inv_2_940 VSS VSS VSS gf180mcu_as_sc_mcu7t3v3__inv_2_940/A
+ gf180mcu_as_sc_mcu7t3v3__inv_2_940/VNW VSUBS gf180mcu_as_sc_mcu7t3v3__inv_2
Xgf180mcu_as_sc_mcu7t3v3__inv_2_951 VSS VSS VSS gf180mcu_as_sc_mcu7t3v3__inv_2_951/A
+ gf180mcu_as_sc_mcu7t3v3__inv_2_951/VNW VSUBS gf180mcu_as_sc_mcu7t3v3__inv_2
Xgf180mcu_as_sc_mcu7t3v3__inv_2_995 VSS VSS gf180mcu_as_sc_mcu7t3v3__inv_2_995/Y gf180mcu_as_sc_mcu7t3v3__inv_2_996/Y
+ gf180mcu_as_sc_mcu7t3v3__inv_2_996/VNW VSUBS gf180mcu_as_sc_mcu7t3v3__inv_2
Xgf180mcu_as_sc_mcu7t3v3__inv_2_984 VSS VSS gf180mcu_as_sc_mcu7t3v3__inv_2_984/Y gf180mcu_as_sc_mcu7t3v3__inv_2_984/A
+ gf180mcu_as_sc_mcu7t3v3__inv_2_984/VNW VSUBS gf180mcu_as_sc_mcu7t3v3__inv_2
Xgf180mcu_as_sc_mcu7t3v3__inv_2_973 VSS VSS gf180mcu_as_sc_mcu7t3v3__inv_2_973/Y gf180mcu_as_sc_mcu7t3v3__inv_2_973/A
+ gf180mcu_as_sc_mcu7t3v3__inv_2_989/VNW VSUBS gf180mcu_as_sc_mcu7t3v3__inv_2
Xgf180mcu_as_sc_mcu7t3v3__inv_2_962 VSS VSS VSS gf180mcu_as_sc_mcu7t3v3__inv_2_963/Y
+ gf180mcu_as_sc_mcu7t3v3__inv_2_964/VNW VSUBS gf180mcu_as_sc_mcu7t3v3__inv_2
Xgf180mcu_as_sc_mcu7t3v3__nand4_2_272 VSS VSS VSS VSS VSS VSS gf180mcu_as_sc_mcu7t3v3__inv_2_906/A
+ gf180mcu_as_sc_mcu7t3v3__inv_2_952/VNW VSUBS gf180mcu_as_sc_mcu7t3v3__nand4_2
Xgf180mcu_as_sc_mcu7t3v3__nand4_2_294 VSS VSS VSS VSS VSS VSS gf180mcu_as_sc_mcu7t3v3__inv_2_1000/A
+ gf180mcu_as_sc_mcu7t3v3__inv_2_999/VNW VSUBS gf180mcu_as_sc_mcu7t3v3__nand4_2
Xgf180mcu_as_sc_mcu7t3v3__nand4_2_250 VSS VSS VSS VSS VSS VSS gf180mcu_as_sc_mcu7t3v3__inv_2_858/A
+ gf180mcu_as_sc_mcu7t3v3__inv_2_936/VNW VSUBS gf180mcu_as_sc_mcu7t3v3__nand4_2
Xgf180mcu_as_sc_mcu7t3v3__nand4_2_261 VSS VSS VSS VSS VSS VSS gf180mcu_as_sc_mcu7t3v3__inv_2_879/A
+ gf180mcu_as_sc_mcu7t3v3__inv_2_932/VNW VSUBS gf180mcu_as_sc_mcu7t3v3__nand4_2
Xgf180mcu_as_sc_mcu7t3v3__nand4_2_283 VSS VSS VSS VSS VSS VSS gf180mcu_as_sc_mcu7t3v3__inv_2_924/A
+ gf180mcu_as_sc_mcu7t3v3__inv_2_959/VNW VSUBS gf180mcu_as_sc_mcu7t3v3__nand4_2
Xgf180mcu_as_sc_mcu7t3v3__inv_2_203 VSS VSS gf180mcu_as_sc_mcu7t3v3__inv_2_203/Y gf180mcu_as_sc_mcu7t3v3__inv_2_203/A
+ gf180mcu_as_sc_mcu7t3v3__inv_2_203/VNW VSUBS gf180mcu_as_sc_mcu7t3v3__inv_2
Xgf180mcu_as_sc_mcu7t3v3__inv_2_225 VSS VSS VSS gf180mcu_as_sc_mcu7t3v3__inv_2_226/Y
+ gf180mcu_as_sc_mcu7t3v3__inv_2_227/VNW VSUBS gf180mcu_as_sc_mcu7t3v3__inv_2
Xgf180mcu_as_sc_mcu7t3v3__inv_2_214 VSS VSS gf180mcu_as_sc_mcu7t3v3__inv_2_214/Y gf180mcu_as_sc_mcu7t3v3__inv_2_215/Y
+ gf180mcu_as_sc_mcu7t3v3__inv_2_215/VNW VSUBS gf180mcu_as_sc_mcu7t3v3__inv_2
Xu_t000_011 u_t000_011/c0_w0_bl u_t000_011/c0_w0_br u_t000_011/c0_w1_bl u_t000_011/c0_w1_br
+ u_t000_011/c0_r0_rbl u_t000_011/c0_r1_rbl u_t000_011/c1_w0_bl u_t000_011/c1_w0_br
+ u_t000_011/c1_w1_bl u_t000_011/c1_w1_br u_t000_011/c1_r0_rbl u_t000_011/c1_r1_rbl
+ u_t000_011/c2_w0_bl u_t000_011/c2_w0_br u_t000_011/c2_w1_bl u_t000_011/c2_w1_br
+ u_t000_011/c2_r0_rbl u_t000_011/c2_r1_rbl u_t000_011/c3_w0_bl u_t000_011/c3_w0_br
+ u_t000_011/c3_w1_bl u_t000_011/c3_w1_br u_t000_011/c3_r0_rbl u_t000_011/c3_r1_rbl
+ u_t000_011/r0_w0_wl u_t000_011/r0_w1_wl u_t000_011/r0_r0_rwl u_t000_011/r0_r1_rwl
+ u_t000_011/r1_w0_wl u_t000_011/r1_w1_wl u_t000_011/r1_r0_rwl u_t000_011/r1_r1_rwl
+ u_t000_011/r2_w0_wl u_t000_011/r2_w1_wl u_t000_011/r2_r0_rwl u_t000_011/r2_r1_rwl
+ u_t000_011/r3_w0_wl u_t000_011/r3_w1_wl u_t000_011/r3_r0_rwl u_t000_011/r3_r1_rwl
+ VSS VSS u_t000_011/m2_717_1265# u_t000_011/m2_603_2031# u_t000_011/m2_1290_336#
+ u_t000_011/m2_2000_2037# u_t000_011/m2_791_2909# u_t000_011/m2_7_2126# u_t000_011/m2_2154_2081#
+ u_t000_011/m2_1795_2037# u_t000_011/m2_871_303# u_t000_011/m2_431_438# u_t000_011/m2_1290_2898#
+ u_t000_011/m2_1714_1210# u_t000_011/m2_431_1982# u_t000_011/m2_512_1265# u_t000_011/m2_2573_2126#
+ u_t000_011/m2_603_1259# u_t000_011/m2_2074_2909# u_t000_011/m2_7_336# u_t000_011/m2_717_2037#
+ u_t000_011/m2_1886_2031# u_t000_011/m2_2573_336# u_t000_011/m2_7_2898# u_t000_011/m2_2000_1265#
+ u_t000_011/m2_512_2037# u_t000_011/m2_1795_1265# u_t000_011/m2_1714_1982# u_t000_011/m2_1886_1259#
+ u_t000_011/m2_1290_2126# u_t000_011/m2_1714_438# u_t000_011/m2_431_1210# u_t000_011/m2_2573_2898#
+ u_t000_011/m2_2154_303# u_t000_011/m2_871_2081# VSUBS detronyx_12t_2w2r_rc4_4x4_routed_5layer_direct
Xu_t000_000 VSS u_t000_000/c0_w0_br VSS u_t000_000/c0_w1_br u_t000_000/c0_r0_rbl u_t000_000/c0_r1_rbl
+ VSS VSS VSS VSS VSS VSS u_t000_000/c2_w0_bl u_t000_000/c2_w0_br u_t000_000/c2_w1_bl
+ u_t000_000/c2_w1_br u_t000_000/c2_r0_rbl u_t000_000/c2_r1_rbl u_t000_000/c3_w0_bl
+ u_t000_000/c3_w0_br u_t000_000/c3_w1_bl u_t000_000/c3_w1_br u_t000_000/c3_r0_rbl
+ u_t000_000/c3_r1_rbl VSS VSS VSS VSS VSS VSS VSS VSS VSS VSS VSS VSS VSS VSS VSS
+ VSS VSS VSS u_t000_000/m2_717_1265# u_t000_000/m2_603_2031# u_t000_000/m2_1290_336#
+ u_t000_000/m2_2000_2037# u_t000_000/m2_791_2909# u_t000_000/m2_7_2126# u_t000_000/m2_2154_2081#
+ u_t000_000/m2_1795_2037# u_t000_000/m2_871_303# u_t000_000/m2_431_438# u_t000_000/m2_1290_2898#
+ u_t000_000/m2_1714_1210# u_t000_000/m2_431_1982# u_t000_000/m2_512_1265# u_t000_000/m2_2573_2126#
+ u_t000_000/m2_603_1259# u_t000_000/m2_2074_2909# u_t000_000/m2_7_336# u_t000_000/m2_717_2037#
+ u_t000_000/m2_1886_2031# u_t000_000/m2_2573_336# u_t000_000/m2_7_2898# u_t000_000/m2_2000_1265#
+ u_t000_000/m2_512_2037# u_t000_000/m2_1795_1265# u_t000_000/m2_1714_1982# u_t000_000/m2_1886_1259#
+ u_t000_000/m2_1290_2126# u_t000_000/m2_1714_438# u_t000_000/m2_431_1210# u_t000_000/m2_2573_2898#
+ u_t000_000/m2_2154_303# u_t000_000/m2_871_2081# VSUBS detronyx_12t_2w2r_rc4_4x4_routed_5layer_direct
Xgf180mcu_as_sc_mcu7t3v3__inv_2_269 VSS VSS VSS gf180mcu_as_sc_mcu7t3v3__inv_2_285/Y
+ gf180mcu_as_sc_mcu7t3v3__inv_2_301/VNW VSUBS gf180mcu_as_sc_mcu7t3v3__inv_2
Xgf180mcu_as_sc_mcu7t3v3__inv_2_258 VSS VSS VSS gf180mcu_as_sc_mcu7t3v3__inv_2_259/Y
+ gf180mcu_as_sc_mcu7t3v3__inv_2_260/VNW VSUBS gf180mcu_as_sc_mcu7t3v3__inv_2
Xgf180mcu_as_sc_mcu7t3v3__inv_2_247 VSS VSS gf180mcu_as_sc_mcu7t3v3__inv_2_247/Y gf180mcu_as_sc_mcu7t3v3__inv_2_248/Y
+ gf180mcu_as_sc_mcu7t3v3__inv_2_248/VNW VSUBS gf180mcu_as_sc_mcu7t3v3__inv_2
Xgf180mcu_as_sc_mcu7t3v3__inv_2_236 VSS VSS gf180mcu_as_sc_mcu7t3v3__inv_2_236/Y gf180mcu_as_sc_mcu7t3v3__inv_2_236/A
+ gf180mcu_as_sc_mcu7t3v3__inv_2_236/VNW VSUBS gf180mcu_as_sc_mcu7t3v3__inv_2
Xgf180mcu_as_sc_mcu7t3v3__inv_2_770 VSS VSS gf180mcu_as_sc_mcu7t3v3__inv_2_770/Y gf180mcu_as_sc_mcu7t3v3__inv_2_770/A
+ gf180mcu_as_sc_mcu7t3v3__inv_2_824/VNW VSUBS gf180mcu_as_sc_mcu7t3v3__inv_2
Xgf180mcu_as_sc_mcu7t3v3__inv_2_781 VSS VSS gf180mcu_as_sc_mcu7t3v3__inv_2_796/A gf180mcu_as_sc_mcu7t3v3__inv_2_781/A
+ gf180mcu_as_sc_mcu7t3v3__inv_2_851/VNW VSUBS gf180mcu_as_sc_mcu7t3v3__inv_2
Xgf180mcu_as_sc_mcu7t3v3__inv_2_792 VSS VSS gf180mcu_as_sc_mcu7t3v3__inv_2_844/A gf180mcu_as_sc_mcu7t3v3__inv_2_793/Y
+ gf180mcu_as_sc_mcu7t3v3__inv_2_844/VNW VSUBS gf180mcu_as_sc_mcu7t3v3__inv_2
Xgf180mcu_as_sc_mcu7t3v3__nor2_2_4 gf180mcu_as_sc_mcu7t3v3__nor2_2_4/VDD gf180mcu_as_sc_mcu7t3v3__nor2_2_4/VSS
+ VSS VSS VSS gf180mcu_as_sc_mcu7t3v3__nor2_2_4/VNW VSUBS gf180mcu_as_sc_mcu7t3v3__nor2_2
Xgf180mcu_as_sc_mcu7t3v3__nand2_2_9 gf180mcu_as_sc_mcu7t3v3__nand3_2_9/VDD gf180mcu_as_sc_mcu7t3v3__nor2_2_4/VSS
+ VSS VSS VSS gf180mcu_as_sc_mcu7t3v3__nand3_2_9/VNW VSUBS gf180mcu_as_sc_mcu7t3v3__nand2_2
Xgf180mcu_as_sc_mcu7t3v3__inv_2_1307 VSS VSS gf180mcu_as_sc_mcu7t3v3__inv_2_1307/Y
+ gf180mcu_as_sc_mcu7t3v3__inv_2_1307/A gf180mcu_as_sc_mcu7t3v3__inv_2_1307/VNW VSUBS
+ gf180mcu_as_sc_mcu7t3v3__inv_2
Xgf180mcu_as_sc_mcu7t3v3__inv_2_1329 VSS VSS gf180mcu_as_sc_mcu7t3v3__inv_2_1329/Y
+ gf180mcu_as_sc_mcu7t3v3__inv_2_1333/Y gf180mcu_as_sc_mcu7t3v3__inv_2_1333/VNW VSUBS
+ gf180mcu_as_sc_mcu7t3v3__inv_2
Xgf180mcu_as_sc_mcu7t3v3__inv_2_1318 VSS VSS VSS gf180mcu_as_sc_mcu7t3v3__inv_2_1319/Y
+ gf180mcu_as_sc_mcu7t3v3__inv_2_1320/VNW VSUBS gf180mcu_as_sc_mcu7t3v3__inv_2
Xu_t028_014 u_t028_014/c0_w0_bl u_t028_014/c0_w0_br u_t028_014/c0_w1_bl u_t028_014/c0_w1_br
+ u_t028_014/c0_r0_rbl u_t028_014/c0_r1_rbl u_t028_014/c1_w0_bl u_t028_014/c1_w0_br
+ u_t028_014/c1_w1_bl u_t028_014/c1_w1_br u_t028_014/c1_r0_rbl u_t028_014/c1_r1_rbl
+ u_t028_014/c2_w0_bl u_t028_014/c2_w0_br u_t028_014/c2_w1_bl u_t028_014/c2_w1_br
+ u_t028_014/c2_r0_rbl u_t028_014/c2_r1_rbl u_t028_014/c3_w0_bl u_t028_014/c3_w0_br
+ u_t028_014/c3_w1_bl u_t028_014/c3_w1_br u_t028_014/c3_r0_rbl u_t028_014/c3_r1_rbl
+ u_t028_014/r0_w0_wl u_t028_014/r0_w1_wl u_t028_014/r0_r0_rwl u_t028_014/r0_r1_rwl
+ u_t028_014/r1_w0_wl u_t028_014/r1_w1_wl u_t028_014/r1_r0_rwl u_t028_014/r1_r1_rwl
+ u_t028_014/r2_w0_wl u_t028_014/r2_w1_wl u_t028_014/r2_r0_rwl u_t028_014/r2_r1_rwl
+ u_t028_014/r3_w0_wl u_t028_014/r3_w1_wl u_t028_014/r3_r0_rwl u_t028_014/r3_r1_rwl
+ VSS VSS u_t028_014/m2_717_1265# u_t028_014/m2_603_2031# u_t028_014/m2_1290_336#
+ u_t028_014/m2_2000_2037# u_t028_014/m2_791_2909# u_t028_014/m2_7_2126# u_t028_014/m2_2154_2081#
+ u_t028_014/m2_1795_2037# u_t028_014/m2_871_303# u_t028_014/m2_431_438# u_t028_014/m2_1290_2898#
+ u_t028_014/m2_1714_1210# u_t028_014/m2_431_1982# u_t028_014/m2_512_1265# u_t028_014/m2_2573_2126#
+ u_t028_014/m2_603_1259# u_t028_014/m2_2074_2909# u_t028_014/m2_7_336# u_t028_014/m2_717_2037#
+ u_t028_014/m2_1886_2031# u_t028_014/m2_2573_336# u_t028_014/m2_7_2898# u_t028_014/m2_2000_1265#
+ u_t028_014/m2_512_2037# u_t028_014/m2_1795_1265# u_t028_014/m2_1714_1982# u_t028_014/m2_1886_1259#
+ u_t028_014/m2_1290_2126# u_t028_014/m2_1714_438# u_t028_014/m2_431_1210# u_t028_014/m2_2573_2898#
+ u_t028_014/m2_2154_303# u_t028_014/m2_871_2081# VSUBS detronyx_12t_2w2r_rc4_4x4_routed_5layer_direct
Xu_t028_003 u_t028_003/c0_w0_bl u_t028_003/c0_w0_br u_t028_003/c0_w1_bl u_t028_003/c0_w1_br
+ u_t028_003/c0_r0_rbl u_t028_003/c0_r1_rbl u_t028_003/c1_w0_bl u_t028_003/c1_w0_br
+ u_t028_003/c1_w1_bl u_t028_003/c1_w1_br u_t028_003/c1_r0_rbl u_t028_003/c1_r1_rbl
+ u_t028_003/c2_w0_bl u_t028_003/c2_w0_br u_t028_003/c2_w1_bl u_t028_003/c2_w1_br
+ u_t028_003/c2_r0_rbl u_t028_003/c2_r1_rbl u_t028_003/c3_w0_bl u_t028_003/c3_w0_br
+ u_t028_003/c3_w1_bl u_t028_003/c3_w1_br u_t028_003/c3_r0_rbl u_t028_003/c3_r1_rbl
+ u_t028_003/r0_w0_wl u_t028_003/r0_w1_wl u_t028_003/r0_r0_rwl u_t028_003/r0_r1_rwl
+ u_t028_003/r1_w0_wl u_t028_003/r1_w1_wl u_t028_003/r1_r0_rwl u_t028_003/r1_r1_rwl
+ u_t028_003/r2_w0_wl u_t028_003/r2_w1_wl u_t028_003/r2_r0_rwl u_t028_003/r2_r1_rwl
+ u_t028_003/r3_w0_wl u_t028_003/r3_w1_wl u_t028_003/r3_r0_rwl u_t028_003/r3_r1_rwl
+ VSS VSS u_t028_003/m2_717_1265# u_t028_003/m2_603_2031# u_t028_003/m2_1290_336#
+ u_t028_003/m2_2000_2037# u_t028_003/m2_791_2909# u_t028_003/m2_7_2126# u_t028_003/m2_2154_2081#
+ u_t028_003/m2_1795_2037# u_t028_003/m2_871_303# u_t028_003/m2_431_438# u_t028_003/m2_1290_2898#
+ u_t028_003/m2_1714_1210# u_t028_003/m2_431_1982# u_t028_003/m2_512_1265# u_t028_003/m2_2573_2126#
+ u_t028_003/m2_603_1259# u_t028_003/m2_2074_2909# u_t028_003/m2_7_336# u_t028_003/m2_717_2037#
+ u_t028_003/m2_1886_2031# u_t028_003/m2_2573_336# u_t028_003/m2_7_2898# u_t028_003/m2_2000_1265#
+ u_t028_003/m2_512_2037# u_t028_003/m2_1795_1265# u_t028_003/m2_1714_1982# u_t028_003/m2_1886_1259#
+ u_t028_003/m2_1290_2126# u_t028_003/m2_1714_438# u_t028_003/m2_431_1210# u_t028_003/m2_2573_2898#
+ u_t028_003/m2_2154_303# u_t028_003/m2_871_2081# VSUBS detronyx_12t_2w2r_rc4_4x4_routed_5layer_direct
Xu_t019_014 u_t019_014/c0_w0_bl u_t019_014/c0_w0_br u_t019_014/c0_w1_bl u_t019_014/c0_w1_br
+ u_t019_014/c0_r0_rbl u_t019_014/c0_r1_rbl u_t019_014/c1_w0_bl u_t019_014/c1_w0_br
+ u_t019_014/c1_w1_bl u_t019_014/c1_w1_br u_t019_014/c1_r0_rbl u_t019_014/c1_r1_rbl
+ u_t019_014/c2_w0_bl u_t019_014/c2_w0_br u_t019_014/c2_w1_bl u_t019_014/c2_w1_br
+ u_t019_014/c2_r0_rbl u_t019_014/c2_r1_rbl u_t019_014/c3_w0_bl u_t019_014/c3_w0_br
+ u_t019_014/c3_w1_bl u_t019_014/c3_w1_br u_t019_014/c3_r0_rbl u_t019_014/c3_r1_rbl
+ u_t019_014/r0_w0_wl u_t019_014/r0_w1_wl u_t019_014/r0_r0_rwl u_t019_014/r0_r1_rwl
+ u_t019_014/r1_w0_wl u_t019_014/r1_w1_wl u_t019_014/r1_r0_rwl u_t019_014/r1_r1_rwl
+ u_t019_014/r2_w0_wl u_t019_014/r2_w1_wl u_t019_014/r2_r0_rwl u_t019_014/r2_r1_rwl
+ u_t019_014/r3_w0_wl u_t019_014/r3_w1_wl u_t019_014/r3_r0_rwl u_t019_014/r3_r1_rwl
+ VSS VSS u_t019_014/m2_717_1265# u_t019_014/m2_603_2031# u_t019_014/m2_1290_336#
+ u_t019_014/m2_2000_2037# u_t019_014/m2_791_2909# u_t019_014/m2_7_2126# u_t019_014/m2_2154_2081#
+ u_t019_014/m2_1795_2037# u_t019_014/m2_871_303# u_t019_014/m2_431_438# u_t019_014/m2_1290_2898#
+ u_t019_014/m2_1714_1210# u_t019_014/m2_431_1982# u_t019_014/m2_512_1265# u_t019_014/m2_2573_2126#
+ u_t019_014/m2_603_1259# u_t019_014/m2_2074_2909# u_t019_014/m2_7_336# u_t019_014/m2_717_2037#
+ u_t019_014/m2_1886_2031# u_t019_014/m2_2573_336# u_t019_014/m2_7_2898# u_t019_014/m2_2000_1265#
+ u_t019_014/m2_512_2037# u_t019_014/m2_1795_1265# u_t019_014/m2_1714_1982# u_t019_014/m2_1886_1259#
+ u_t019_014/m2_1290_2126# u_t019_014/m2_1714_438# u_t019_014/m2_431_1210# u_t019_014/m2_2573_2898#
+ u_t019_014/m2_2154_303# u_t019_014/m2_871_2081# VSUBS detronyx_12t_2w2r_rc4_4x4_routed_5layer_direct
Xu_t019_003 u_t019_003/c0_w0_bl u_t019_003/c0_w0_br u_t019_003/c0_w1_bl u_t019_003/c0_w1_br
+ u_t019_003/c0_r0_rbl u_t019_003/c0_r1_rbl u_t019_003/c1_w0_bl u_t019_003/c1_w0_br
+ u_t019_003/c1_w1_bl u_t019_003/c1_w1_br u_t019_003/c1_r0_rbl u_t019_003/c1_r1_rbl
+ u_t019_003/c2_w0_bl u_t019_003/c2_w0_br u_t019_003/c2_w1_bl u_t019_003/c2_w1_br
+ u_t019_003/c2_r0_rbl u_t019_003/c2_r1_rbl u_t019_003/c3_w0_bl u_t019_003/c3_w0_br
+ u_t019_003/c3_w1_bl u_t019_003/c3_w1_br u_t019_003/c3_r0_rbl u_t019_003/c3_r1_rbl
+ u_t019_003/r0_w0_wl u_t019_003/r0_w1_wl u_t019_003/r0_r0_rwl u_t019_003/r0_r1_rwl
+ u_t019_003/r1_w0_wl u_t019_003/r1_w1_wl u_t019_003/r1_r0_rwl u_t019_003/r1_r1_rwl
+ u_t019_003/r2_w0_wl u_t019_003/r2_w1_wl u_t019_003/r2_r0_rwl u_t019_003/r2_r1_rwl
+ u_t019_003/r3_w0_wl u_t019_003/r3_w1_wl u_t019_003/r3_r0_rwl u_t019_003/r3_r1_rwl
+ VSS VSS u_t019_003/m2_717_1265# u_t019_003/m2_603_2031# u_t019_003/m2_1290_336#
+ u_t019_003/m2_2000_2037# u_t019_003/m2_791_2909# u_t019_003/m2_7_2126# u_t019_003/m2_2154_2081#
+ u_t019_003/m2_1795_2037# u_t019_003/m2_871_303# u_t019_003/m2_431_438# u_t019_003/m2_1290_2898#
+ u_t019_003/m2_1714_1210# u_t019_003/m2_431_1982# u_t019_003/m2_512_1265# u_t019_003/m2_2573_2126#
+ u_t019_003/m2_603_1259# u_t019_003/m2_2074_2909# u_t019_003/m2_7_336# u_t019_003/m2_717_2037#
+ u_t019_003/m2_1886_2031# u_t019_003/m2_2573_336# u_t019_003/m2_7_2898# u_t019_003/m2_2000_1265#
+ u_t019_003/m2_512_2037# u_t019_003/m2_1795_1265# u_t019_003/m2_1714_1982# u_t019_003/m2_1886_1259#
+ u_t019_003/m2_1290_2126# u_t019_003/m2_1714_438# u_t019_003/m2_431_1210# u_t019_003/m2_2573_2898#
+ u_t019_003/m2_2154_303# u_t019_003/m2_871_2081# VSUBS detronyx_12t_2w2r_rc4_4x4_routed_5layer_direct
Xgf180mcu_as_sc_mcu7t3v3__nand4_2_18 VSS VSS VSS VSS VSS VSS gf180mcu_as_sc_mcu7t3v3__inv_2_134/A
+ gf180mcu_as_sc_mcu7t3v3__inv_2_134/VNW VSUBS gf180mcu_as_sc_mcu7t3v3__nand4_2
Xgf180mcu_as_sc_mcu7t3v3__nand4_2_29 VSS VSS VSS VSS VSS VSS gf180mcu_as_sc_mcu7t3v3__inv_2_168/A
+ gf180mcu_as_sc_mcu7t3v3__inv_2_168/VNW VSUBS gf180mcu_as_sc_mcu7t3v3__nand4_2
Xu_t025_006 u_t025_006/c0_w0_bl u_t025_006/c0_w0_br u_t025_006/c0_w1_bl u_t025_006/c0_w1_br
+ u_t025_006/c0_r0_rbl u_t025_006/c0_r1_rbl u_t025_006/c1_w0_bl u_t025_006/c1_w0_br
+ u_t025_006/c1_w1_bl u_t025_006/c1_w1_br u_t025_006/c1_r0_rbl u_t025_006/c1_r1_rbl
+ u_t025_006/c2_w0_bl u_t025_006/c2_w0_br u_t025_006/c2_w1_bl u_t025_006/c2_w1_br
+ u_t025_006/c2_r0_rbl u_t025_006/c2_r1_rbl u_t025_006/c3_w0_bl u_t025_006/c3_w0_br
+ u_t025_006/c3_w1_bl u_t025_006/c3_w1_br u_t025_006/c3_r0_rbl u_t025_006/c3_r1_rbl
+ u_t025_006/r0_w0_wl u_t025_006/r0_w1_wl u_t025_006/r0_r0_rwl u_t025_006/r0_r1_rwl
+ u_t025_006/r1_w0_wl u_t025_006/r1_w1_wl u_t025_006/r1_r0_rwl u_t025_006/r1_r1_rwl
+ u_t025_006/r2_w0_wl u_t025_006/r2_w1_wl u_t025_006/r2_r0_rwl u_t025_006/r2_r1_rwl
+ u_t025_006/r3_w0_wl u_t025_006/r3_w1_wl u_t025_006/r3_r0_rwl u_t025_006/r3_r1_rwl
+ VSS VSS u_t025_006/m2_717_1265# u_t025_006/m2_603_2031# u_t025_006/m2_1290_336#
+ u_t025_006/m2_2000_2037# u_t025_006/m2_791_2909# u_t025_006/m2_7_2126# u_t025_006/m2_2154_2081#
+ u_t025_006/m2_1795_2037# u_t025_006/m2_871_303# u_t025_006/m2_431_438# u_t025_006/m2_1290_2898#
+ u_t025_006/m2_1714_1210# u_t025_006/m2_431_1982# u_t025_006/m2_512_1265# u_t025_006/m2_2573_2126#
+ u_t025_006/m2_603_1259# u_t025_006/m2_2074_2909# u_t025_006/m2_7_336# u_t025_006/m2_717_2037#
+ u_t025_006/m2_1886_2031# u_t025_006/m2_2573_336# u_t025_006/m2_7_2898# u_t025_006/m2_2000_1265#
+ u_t025_006/m2_512_2037# u_t025_006/m2_1795_1265# u_t025_006/m2_1714_1982# u_t025_006/m2_1886_1259#
+ u_t025_006/m2_1290_2126# u_t025_006/m2_1714_438# u_t025_006/m2_431_1210# u_t025_006/m2_2573_2898#
+ u_t025_006/m2_2154_303# u_t025_006/m2_871_2081# VSUBS detronyx_12t_2w2r_rc4_4x4_routed_5layer_direct
Xgf180mcu_as_sc_mcu7t3v3__inv_2_1115 VSS VSS gf180mcu_as_sc_mcu7t3v3__inv_2_1115/Y
+ gf180mcu_as_sc_mcu7t3v3__inv_2_1115/A gf180mcu_as_sc_mcu7t3v3__inv_2_1115/VNW VSUBS
+ gf180mcu_as_sc_mcu7t3v3__inv_2
Xgf180mcu_as_sc_mcu7t3v3__inv_2_1126 VSS VSS gf180mcu_as_sc_mcu7t3v3__inv_2_1126/Y
+ gf180mcu_as_sc_mcu7t3v3__inv_2_1130/Y gf180mcu_as_sc_mcu7t3v3__inv_2_1130/VNW VSUBS
+ gf180mcu_as_sc_mcu7t3v3__inv_2
Xgf180mcu_as_sc_mcu7t3v3__inv_2_1104 VSS VSS VSS gf180mcu_as_sc_mcu7t3v3__inv_2_1108/Y
+ gf180mcu_as_sc_mcu7t3v3__inv_2_1112/VNW VSUBS gf180mcu_as_sc_mcu7t3v3__inv_2
Xgf180mcu_as_sc_mcu7t3v3__inv_2_1137 VSS VSS VSS gf180mcu_as_sc_mcu7t3v3__inv_2_1138/Y
+ gf180mcu_as_sc_mcu7t3v3__inv_2_1139/VNW VSUBS gf180mcu_as_sc_mcu7t3v3__inv_2
Xgf180mcu_as_sc_mcu7t3v3__inv_2_1148 VSS VSS gf180mcu_as_sc_mcu7t3v3__inv_2_1148/Y
+ gf180mcu_as_sc_mcu7t3v3__inv_2_1148/A gf180mcu_as_sc_mcu7t3v3__inv_2_1148/VNW VSUBS
+ gf180mcu_as_sc_mcu7t3v3__inv_2
Xgf180mcu_as_sc_mcu7t3v3__inv_2_1159 VSS VSS gf180mcu_as_sc_mcu7t3v3__inv_2_1159/Y
+ gf180mcu_as_sc_mcu7t3v3__inv_2_1159/A gf180mcu_as_sc_mcu7t3v3__inv_2_1291/VNW VSUBS
+ gf180mcu_as_sc_mcu7t3v3__inv_2
Xu_t031_009 u_t031_009/c0_w0_bl u_t031_009/c0_w0_br u_t031_009/c0_w1_bl u_t031_009/c0_w1_br
+ u_t031_009/c0_r0_rbl u_t031_009/c0_r1_rbl u_t031_009/c1_w0_bl u_t031_009/c1_w0_br
+ u_t031_009/c1_w1_bl u_t031_009/c1_w1_br u_t031_009/c1_r0_rbl u_t031_009/c1_r1_rbl
+ u_t031_009/c2_w0_bl u_t031_009/c2_w0_br u_t031_009/c2_w1_bl u_t031_009/c2_w1_br
+ u_t031_009/c2_r0_rbl u_t031_009/c2_r1_rbl u_t031_009/c3_w0_bl u_t031_009/c3_w0_br
+ u_t031_009/c3_w1_bl u_t031_009/c3_w1_br u_t031_009/c3_r0_rbl u_t031_009/c3_r1_rbl
+ u_t031_009/r0_w0_wl u_t031_009/r0_w1_wl u_t031_009/r0_r0_rwl u_t031_009/r0_r1_rwl
+ u_t031_009/r1_w0_wl u_t031_009/r1_w1_wl u_t031_009/r1_r0_rwl u_t031_009/r1_r1_rwl
+ u_t031_009/r2_w0_wl u_t031_009/r2_w1_wl u_t031_009/r2_r0_rwl u_t031_009/r2_r1_rwl
+ u_t031_009/r3_w0_wl u_t031_009/r3_w1_wl u_t031_009/r3_r0_rwl u_t031_009/r3_r1_rwl
+ VSS VSS u_t031_009/m2_717_1265# u_t031_009/m2_603_2031# u_t031_009/m2_1290_336#
+ u_t031_009/m2_2000_2037# u_t031_009/m2_791_2909# u_t031_009/m2_7_2126# u_t031_009/m2_2154_2081#
+ u_t031_009/m2_1795_2037# u_t031_009/m2_871_303# u_t031_009/m2_431_438# u_t031_009/m2_1290_2898#
+ u_t031_009/m2_1714_1210# u_t031_009/m2_431_1982# u_t031_009/m2_512_1265# u_t031_009/m2_2573_2126#
+ u_t031_009/m2_603_1259# u_t031_009/m2_2074_2909# u_t031_009/m2_7_336# u_t031_009/m2_717_2037#
+ u_t031_009/m2_1886_2031# u_t031_009/m2_2573_336# u_t031_009/m2_7_2898# u_t031_009/m2_2000_1265#
+ u_t031_009/m2_512_2037# u_t031_009/m2_1795_1265# u_t031_009/m2_1714_1982# u_t031_009/m2_1886_1259#
+ u_t031_009/m2_1290_2126# u_t031_009/m2_1714_438# u_t031_009/m2_431_1210# u_t031_009/m2_2573_2898#
+ u_t031_009/m2_2154_303# u_t031_009/m2_871_2081# VSUBS detronyx_12t_2w2r_rc4_4x4_routed_5layer_direct
Xu_t016_006 u_t016_006/c0_w0_bl u_t016_006/c0_w0_br u_t016_006/c0_w1_bl u_t016_006/c0_w1_br
+ u_t016_006/c0_r0_rbl u_t016_006/c0_r1_rbl u_t016_006/c1_w0_bl u_t016_006/c1_w0_br
+ u_t016_006/c1_w1_bl u_t016_006/c1_w1_br u_t016_006/c1_r0_rbl u_t016_006/c1_r1_rbl
+ u_t016_006/c2_w0_bl u_t016_006/c2_w0_br u_t016_006/c2_w1_bl u_t016_006/c2_w1_br
+ u_t016_006/c2_r0_rbl u_t016_006/c2_r1_rbl u_t016_006/c3_w0_bl u_t016_006/c3_w0_br
+ u_t016_006/c3_w1_bl u_t016_006/c3_w1_br u_t016_006/c3_r0_rbl u_t016_006/c3_r1_rbl
+ u_t016_006/r0_w0_wl u_t016_006/r0_w1_wl u_t016_006/r0_r0_rwl u_t016_006/r0_r1_rwl
+ u_t016_006/r1_w0_wl u_t016_006/r1_w1_wl u_t016_006/r1_r0_rwl u_t016_006/r1_r1_rwl
+ u_t016_006/r2_w0_wl u_t016_006/r2_w1_wl u_t016_006/r2_r0_rwl u_t016_006/r2_r1_rwl
+ u_t016_006/r3_w0_wl u_t016_006/r3_w1_wl u_t016_006/r3_r0_rwl u_t016_006/r3_r1_rwl
+ VSS VSS u_t016_006/m2_717_1265# u_t016_006/m2_603_2031# u_t016_006/m2_1290_336#
+ u_t016_006/m2_2000_2037# u_t016_006/m2_791_2909# u_t016_006/m2_7_2126# u_t016_006/m2_2154_2081#
+ u_t016_006/m2_1795_2037# u_t016_006/m2_871_303# u_t016_006/m2_431_438# u_t016_006/m2_1290_2898#
+ u_t016_006/m2_1714_1210# u_t016_006/m2_431_1982# u_t016_006/m2_512_1265# u_t016_006/m2_2573_2126#
+ u_t016_006/m2_603_1259# u_t016_006/m2_2074_2909# u_t016_006/m2_7_336# u_t016_006/m2_717_2037#
+ u_t016_006/m2_1886_2031# u_t016_006/m2_2573_336# u_t016_006/m2_7_2898# u_t016_006/m2_2000_1265#
+ u_t016_006/m2_512_2037# u_t016_006/m2_1795_1265# u_t016_006/m2_1714_1982# u_t016_006/m2_1886_1259#
+ u_t016_006/m2_1290_2126# u_t016_006/m2_1714_438# u_t016_006/m2_431_1210# u_t016_006/m2_2573_2898#
+ u_t016_006/m2_2154_303# u_t016_006/m2_871_2081# VSUBS detronyx_12t_2w2r_rc4_4x4_routed_5layer_direct
Xgf180mcu_as_sc_mcu7t3v3__nand3_2_51 gf180mcu_as_sc_mcu7t3v3__nand3_2_65/VDD gf180mcu_as_sc_mcu7t3v3__nor2_2_9/VSS
+ VSS VSS VSS VSS gf180mcu_as_sc_mcu7t3v3__nand3_2_65/VNW VSUBS gf180mcu_as_sc_mcu7t3v3__nand3_2
Xgf180mcu_as_sc_mcu7t3v3__nand3_2_62 gf180mcu_as_sc_mcu7t3v3__nand3_2_65/VDD gf180mcu_as_sc_mcu7t3v3__nand3_2_62/VSS
+ VSS VSS VSS VSS gf180mcu_as_sc_mcu7t3v3__nand3_2_65/VNW VSUBS gf180mcu_as_sc_mcu7t3v3__nand3_2
Xgf180mcu_as_sc_mcu7t3v3__nand3_2_40 gf180mcu_as_sc_mcu7t3v3__nand3_2_9/VDD gf180mcu_as_sc_mcu7t3v3__nor2_2_7/VSS
+ VSS VSS VSS VSS gf180mcu_as_sc_mcu7t3v3__nand3_2_9/VNW VSUBS gf180mcu_as_sc_mcu7t3v3__nand3_2
Xgf180mcu_as_sc_mcu7t3v3__inv_2_1660 VSS VSS gf180mcu_as_sc_mcu7t3v3__inv_2_1660/Y
+ gf180mcu_as_sc_mcu7t3v3__inv_2_1660/A gf180mcu_as_sc_mcu7t3v3__inv_2_1660/VNW VSUBS
+ gf180mcu_as_sc_mcu7t3v3__inv_2
Xgf180mcu_as_sc_mcu7t3v3__inv_2_1671 VSS VSS gf180mcu_as_sc_mcu7t3v3__inv_2_1671/Y
+ gf180mcu_as_sc_mcu7t3v3__inv_2_1672/Y gf180mcu_as_sc_mcu7t3v3__inv_2_1672/VNW VSUBS
+ gf180mcu_as_sc_mcu7t3v3__inv_2
Xgf180mcu_as_sc_mcu7t3v3__inv_2_1682 VSS VSS VSS gf180mcu_as_sc_mcu7t3v3__inv_2_1683/Y
+ gf180mcu_as_sc_mcu7t3v3__inv_2_1684/VNW VSUBS gf180mcu_as_sc_mcu7t3v3__inv_2
Xgf180mcu_as_sc_mcu7t3v3__inv_2_1693 VSS VSS gf180mcu_as_sc_mcu7t3v3__inv_2_1693/Y
+ gf180mcu_as_sc_mcu7t3v3__inv_2_1694/Y gf180mcu_as_sc_mcu7t3v3__inv_2_1694/VNW VSUBS
+ gf180mcu_as_sc_mcu7t3v3__inv_2
Xu_t007_006 u_t007_006/c0_w0_bl u_t007_006/c0_w0_br u_t007_006/c0_w1_bl u_t007_006/c0_w1_br
+ u_t007_006/c0_r0_rbl u_t007_006/c0_r1_rbl u_t007_006/c1_w0_bl u_t007_006/c1_w0_br
+ u_t007_006/c1_w1_bl u_t007_006/c1_w1_br u_t007_006/c1_r0_rbl u_t007_006/c1_r1_rbl
+ u_t007_006/c2_w0_bl u_t007_006/c2_w0_br u_t007_006/c2_w1_bl u_t007_006/c2_w1_br
+ u_t007_006/c2_r0_rbl u_t007_006/c2_r1_rbl u_t007_006/c3_w0_bl u_t007_006/c3_w0_br
+ u_t007_006/c3_w1_bl u_t007_006/c3_w1_br u_t007_006/c3_r0_rbl u_t007_006/c3_r1_rbl
+ u_t007_006/r0_w0_wl u_t007_006/r0_w1_wl u_t007_006/r0_r0_rwl u_t007_006/r0_r1_rwl
+ u_t007_006/r1_w0_wl u_t007_006/r1_w1_wl u_t007_006/r1_r0_rwl u_t007_006/r1_r1_rwl
+ u_t007_006/r2_w0_wl u_t007_006/r2_w1_wl u_t007_006/r2_r0_rwl u_t007_006/r2_r1_rwl
+ u_t007_006/r3_w0_wl u_t007_006/r3_w1_wl u_t007_006/r3_r0_rwl u_t007_006/r3_r1_rwl
+ VSS VSS u_t007_006/m2_717_1265# u_t007_006/m2_603_2031# u_t007_006/m2_1290_336#
+ u_t007_006/m2_2000_2037# u_t007_006/m2_791_2909# u_t007_006/m2_7_2126# u_t007_006/m2_2154_2081#
+ u_t007_006/m2_1795_2037# u_t007_006/m2_871_303# u_t007_006/m2_431_438# u_t007_006/m2_1290_2898#
+ u_t007_006/m2_1714_1210# u_t007_006/m2_431_1982# u_t007_006/m2_512_1265# u_t007_006/m2_2573_2126#
+ u_t007_006/m2_603_1259# u_t007_006/m2_2074_2909# u_t007_006/m2_7_336# u_t007_006/m2_717_2037#
+ u_t007_006/m2_1886_2031# u_t007_006/m2_2573_336# u_t007_006/m2_7_2898# u_t007_006/m2_2000_1265#
+ u_t007_006/m2_512_2037# u_t007_006/m2_1795_1265# u_t007_006/m2_1714_1982# u_t007_006/m2_1886_1259#
+ u_t007_006/m2_1290_2126# u_t007_006/m2_1714_438# u_t007_006/m2_431_1210# u_t007_006/m2_2573_2898#
+ u_t007_006/m2_2154_303# u_t007_006/m2_871_2081# VSUBS detronyx_12t_2w2r_rc4_4x4_routed_5layer_direct
Xu_t022_009 u_t022_009/c0_w0_bl u_t022_009/c0_w0_br u_t022_009/c0_w1_bl u_t022_009/c0_w1_br
+ u_t022_009/c0_r0_rbl u_t022_009/c0_r1_rbl u_t022_009/c1_w0_bl u_t022_009/c1_w0_br
+ u_t022_009/c1_w1_bl u_t022_009/c1_w1_br u_t022_009/c1_r0_rbl u_t022_009/c1_r1_rbl
+ u_t022_009/c2_w0_bl u_t022_009/c2_w0_br u_t022_009/c2_w1_bl u_t022_009/c2_w1_br
+ u_t022_009/c2_r0_rbl u_t022_009/c2_r1_rbl u_t022_009/c3_w0_bl u_t022_009/c3_w0_br
+ u_t022_009/c3_w1_bl u_t022_009/c3_w1_br u_t022_009/c3_r0_rbl u_t022_009/c3_r1_rbl
+ u_t022_009/r0_w0_wl u_t022_009/r0_w1_wl u_t022_009/r0_r0_rwl u_t022_009/r0_r1_rwl
+ u_t022_009/r1_w0_wl u_t022_009/r1_w1_wl u_t022_009/r1_r0_rwl u_t022_009/r1_r1_rwl
+ u_t022_009/r2_w0_wl u_t022_009/r2_w1_wl u_t022_009/r2_r0_rwl u_t022_009/r2_r1_rwl
+ u_t022_009/r3_w0_wl u_t022_009/r3_w1_wl u_t022_009/r3_r0_rwl u_t022_009/r3_r1_rwl
+ VSS VSS u_t022_009/m2_717_1265# u_t022_009/m2_603_2031# u_t022_009/m2_1290_336#
+ u_t022_009/m2_2000_2037# u_t022_009/m2_791_2909# u_t022_009/m2_7_2126# u_t022_009/m2_2154_2081#
+ u_t022_009/m2_1795_2037# u_t022_009/m2_871_303# u_t022_009/m2_431_438# u_t022_009/m2_1290_2898#
+ u_t022_009/m2_1714_1210# u_t022_009/m2_431_1982# u_t022_009/m2_512_1265# u_t022_009/m2_2573_2126#
+ u_t022_009/m2_603_1259# u_t022_009/m2_2074_2909# u_t022_009/m2_7_336# u_t022_009/m2_717_2037#
+ u_t022_009/m2_1886_2031# u_t022_009/m2_2573_336# u_t022_009/m2_7_2898# u_t022_009/m2_2000_1265#
+ u_t022_009/m2_512_2037# u_t022_009/m2_1795_1265# u_t022_009/m2_1714_1982# u_t022_009/m2_1886_1259#
+ u_t022_009/m2_1290_2126# u_t022_009/m2_1714_438# u_t022_009/m2_431_1210# u_t022_009/m2_2573_2898#
+ u_t022_009/m2_2154_303# u_t022_009/m2_871_2081# VSUBS detronyx_12t_2w2r_rc4_4x4_routed_5layer_direct
Xgf180mcu_as_sc_mcu7t3v3__nand4_2_432 VSS VSS VSS VSS VSS VSS gf180mcu_as_sc_mcu7t3v3__inv_2_1567/A
+ gf180mcu_as_sc_mcu7t3v3__inv_2_1588/VNW VSUBS gf180mcu_as_sc_mcu7t3v3__nand4_2
Xgf180mcu_as_sc_mcu7t3v3__nand4_2_443 VSS VSS VSS VSS VSS VSS gf180mcu_as_sc_mcu7t3v3__inv_2_1601/A
+ gf180mcu_as_sc_mcu7t3v3__inv_2_1601/VNW VSUBS gf180mcu_as_sc_mcu7t3v3__nand4_2
Xgf180mcu_as_sc_mcu7t3v3__nand4_2_487 VSS VSS VSS VSS VSS VSS gf180mcu_as_sc_mcu7t3v3__inv_2_1672/A
+ gf180mcu_as_sc_mcu7t3v3__inv_2_1672/VNW VSUBS gf180mcu_as_sc_mcu7t3v3__nand4_2
Xgf180mcu_as_sc_mcu7t3v3__nand4_2_421 VSS VSS VSS VSS VSS VSS gf180mcu_as_sc_mcu7t3v3__inv_2_1535/A
+ gf180mcu_as_sc_mcu7t3v3__inv_2_1535/VNW VSUBS gf180mcu_as_sc_mcu7t3v3__nand4_2
Xgf180mcu_as_sc_mcu7t3v3__nand4_2_465 VSS VSS VSS VSS VSS VSS gf180mcu_as_sc_mcu7t3v3__inv_2_1366/A
+ gf180mcu_as_sc_mcu7t3v3__inv_2_1366/VNW VSUBS gf180mcu_as_sc_mcu7t3v3__nand4_2
Xgf180mcu_as_sc_mcu7t3v3__nand4_2_476 VSS VSS VSS VSS VSS VSS gf180mcu_as_sc_mcu7t3v3__inv_2_1359/A
+ gf180mcu_as_sc_mcu7t3v3__inv_2_1395/VNW VSUBS gf180mcu_as_sc_mcu7t3v3__nand4_2
Xgf180mcu_as_sc_mcu7t3v3__nand4_2_410 VSS VSS VSS VSS VSS VSS gf180mcu_as_sc_mcu7t3v3__inv_2_1500/A
+ gf180mcu_as_sc_mcu7t3v3__inv_2_1500/VNW VSUBS gf180mcu_as_sc_mcu7t3v3__nand4_2
Xgf180mcu_as_sc_mcu7t3v3__nand4_2_454 VSS VSS VSS VSS VSS VSS gf180mcu_as_sc_mcu7t3v3__inv_2_1352/A
+ gf180mcu_as_sc_mcu7t3v3__inv_2_1352/VNW VSUBS gf180mcu_as_sc_mcu7t3v3__nand4_2
Xu_t013_009 u_t013_009/c0_w0_bl u_t013_009/c0_w0_br u_t013_009/c0_w1_bl u_t013_009/c0_w1_br
+ u_t013_009/c0_r0_rbl u_t013_009/c0_r1_rbl u_t013_009/c1_w0_bl u_t013_009/c1_w0_br
+ u_t013_009/c1_w1_bl u_t013_009/c1_w1_br u_t013_009/c1_r0_rbl u_t013_009/c1_r1_rbl
+ u_t013_009/c2_w0_bl u_t013_009/c2_w0_br u_t013_009/c2_w1_bl u_t013_009/c2_w1_br
+ u_t013_009/c2_r0_rbl u_t013_009/c2_r1_rbl u_t013_009/c3_w0_bl u_t013_009/c3_w0_br
+ u_t013_009/c3_w1_bl u_t013_009/c3_w1_br u_t013_009/c3_r0_rbl u_t013_009/c3_r1_rbl
+ u_t013_009/r0_w0_wl u_t013_009/r0_w1_wl u_t013_009/r0_r0_rwl u_t013_009/r0_r1_rwl
+ u_t013_009/r1_w0_wl u_t013_009/r1_w1_wl u_t013_009/r1_r0_rwl u_t013_009/r1_r1_rwl
+ u_t013_009/r2_w0_wl u_t013_009/r2_w1_wl u_t013_009/r2_r0_rwl u_t013_009/r2_r1_rwl
+ u_t013_009/r3_w0_wl u_t013_009/r3_w1_wl u_t013_009/r3_r0_rwl u_t013_009/r3_r1_rwl
+ VSS VSS u_t013_009/m2_717_1265# u_t013_009/m2_603_2031# u_t013_009/m2_1290_336#
+ u_t013_009/m2_2000_2037# u_t013_009/m2_791_2909# u_t013_009/m2_7_2126# u_t013_009/m2_2154_2081#
+ u_t013_009/m2_1795_2037# u_t013_009/m2_871_303# u_t013_009/m2_431_438# u_t013_009/m2_1290_2898#
+ u_t013_009/m2_1714_1210# u_t013_009/m2_431_1982# u_t013_009/m2_512_1265# u_t013_009/m2_2573_2126#
+ u_t013_009/m2_603_1259# u_t013_009/m2_2074_2909# u_t013_009/m2_7_336# u_t013_009/m2_717_2037#
+ u_t013_009/m2_1886_2031# u_t013_009/m2_2573_336# u_t013_009/m2_7_2898# u_t013_009/m2_2000_1265#
+ u_t013_009/m2_512_2037# u_t013_009/m2_1795_1265# u_t013_009/m2_1714_1982# u_t013_009/m2_1886_1259#
+ u_t013_009/m2_1290_2126# u_t013_009/m2_1714_438# u_t013_009/m2_431_1210# u_t013_009/m2_2573_2898#
+ u_t013_009/m2_2154_303# u_t013_009/m2_871_2081# VSUBS detronyx_12t_2w2r_rc4_4x4_routed_5layer_direct
Xgf180mcu_as_sc_mcu7t3v3__nand4_2_498 VSS VSS VSS VSS VSS VSS gf180mcu_as_sc_mcu7t3v3__inv_2_1697/A
+ gf180mcu_as_sc_mcu7t3v3__inv_2_1697/VNW VSUBS gf180mcu_as_sc_mcu7t3v3__nand4_2
Xgf180mcu_as_sc_mcu7t3v3__inv_2_0 VSS VSS gf180mcu_as_sc_mcu7t3v3__inv_2_0/Y gf180mcu_as_sc_mcu7t3v3__inv_2_0/A
+ gf180mcu_as_sc_mcu7t3v3__inv_2_0/VNW VSUBS gf180mcu_as_sc_mcu7t3v3__inv_2
Xgf180mcu_as_sc_mcu7t3v3__inv_2_418 gf180mcu_as_sc_mcu7t3v3__nor2_2_4/VDD gf180mcu_as_sc_mcu7t3v3__nand2_2_3/VSS
+ VSS VSS gf180mcu_as_sc_mcu7t3v3__nor2_2_4/VNW VSUBS gf180mcu_as_sc_mcu7t3v3__inv_2
Xgf180mcu_as_sc_mcu7t3v3__inv_2_407 gf180mcu_as_sc_mcu7t3v3__nand3_2_9/VDD gf180mcu_as_sc_mcu7t3v3__nor2_2_7/VSS
+ gf180mcu_as_sc_mcu7t3v3__inv_2_407/Y VSS gf180mcu_as_sc_mcu7t3v3__nand3_2_9/VNW
+ VSUBS gf180mcu_as_sc_mcu7t3v3__inv_2
Xu_t004_009 u_t004_009/c0_w0_bl u_t004_009/c0_w0_br u_t004_009/c0_w1_bl u_t004_009/c0_w1_br
+ u_t004_009/c0_r0_rbl u_t004_009/c0_r1_rbl u_t004_009/c1_w0_bl u_t004_009/c1_w0_br
+ u_t004_009/c1_w1_bl u_t004_009/c1_w1_br u_t004_009/c1_r0_rbl u_t004_009/c1_r1_rbl
+ u_t004_009/c2_w0_bl u_t004_009/c2_w0_br u_t004_009/c2_w1_bl u_t004_009/c2_w1_br
+ u_t004_009/c2_r0_rbl u_t004_009/c2_r1_rbl u_t004_009/c3_w0_bl u_t004_009/c3_w0_br
+ u_t004_009/c3_w1_bl u_t004_009/c3_w1_br u_t004_009/c3_r0_rbl u_t004_009/c3_r1_rbl
+ u_t004_009/r0_w0_wl u_t004_009/r0_w1_wl u_t004_009/r0_r0_rwl u_t004_009/r0_r1_rwl
+ u_t004_009/r1_w0_wl u_t004_009/r1_w1_wl u_t004_009/r1_r0_rwl u_t004_009/r1_r1_rwl
+ u_t004_009/r2_w0_wl u_t004_009/r2_w1_wl u_t004_009/r2_r0_rwl u_t004_009/r2_r1_rwl
+ u_t004_009/r3_w0_wl u_t004_009/r3_w1_wl u_t004_009/r3_r0_rwl u_t004_009/r3_r1_rwl
+ VSS VSS u_t004_009/m2_717_1265# u_t004_009/m2_603_2031# u_t004_009/m2_1290_336#
+ u_t004_009/m2_2000_2037# u_t004_009/m2_791_2909# u_t004_009/m2_7_2126# u_t004_009/m2_2154_2081#
+ u_t004_009/m2_1795_2037# u_t004_009/m2_871_303# u_t004_009/m2_431_438# u_t004_009/m2_1290_2898#
+ u_t004_009/m2_1714_1210# u_t004_009/m2_431_1982# u_t004_009/m2_512_1265# u_t004_009/m2_2573_2126#
+ u_t004_009/m2_603_1259# u_t004_009/m2_2074_2909# u_t004_009/m2_7_336# u_t004_009/m2_717_2037#
+ u_t004_009/m2_1886_2031# u_t004_009/m2_2573_336# u_t004_009/m2_7_2898# u_t004_009/m2_2000_1265#
+ u_t004_009/m2_512_2037# u_t004_009/m2_1795_1265# u_t004_009/m2_1714_1982# u_t004_009/m2_1886_1259#
+ u_t004_009/m2_1290_2126# u_t004_009/m2_1714_438# u_t004_009/m2_431_1210# u_t004_009/m2_2573_2898#
+ u_t004_009/m2_2154_303# u_t004_009/m2_871_2081# VSUBS detronyx_12t_2w2r_rc4_4x4_routed_5layer_direct
Xgf180mcu_as_sc_mcu7t3v3__inv_2_429 gf180mcu_as_sc_mcu7t3v3__nor2_2_7/VDD gf180mcu_as_sc_mcu7t3v3__nor2_2_7/VSS
+ VSS VSS gf180mcu_as_sc_mcu7t3v3__nor2_2_7/VNW VSUBS gf180mcu_as_sc_mcu7t3v3__inv_2
Xgf180mcu_as_sc_mcu7t3v3__inv_2_1490 VSS VSS gf180mcu_as_sc_mcu7t3v3__inv_2_1490/Y
+ gf180mcu_as_sc_mcu7t3v3__inv_2_1491/Y gf180mcu_as_sc_mcu7t3v3__inv_2_1491/VNW VSUBS
+ gf180mcu_as_sc_mcu7t3v3__inv_2
Xgf180mcu_as_sc_mcu7t3v3__inv_2_952 VSS VSS VSS gf180mcu_as_sc_mcu7t3v3__inv_2_952/A
+ gf180mcu_as_sc_mcu7t3v3__inv_2_952/VNW VSUBS gf180mcu_as_sc_mcu7t3v3__inv_2
Xgf180mcu_as_sc_mcu7t3v3__inv_2_930 VSS VSS VSS gf180mcu_as_sc_mcu7t3v3__inv_2_930/A
+ gf180mcu_as_sc_mcu7t3v3__inv_2_930/VNW VSUBS gf180mcu_as_sc_mcu7t3v3__inv_2
Xgf180mcu_as_sc_mcu7t3v3__inv_2_963 VSS VSS gf180mcu_as_sc_mcu7t3v3__inv_2_963/Y gf180mcu_as_sc_mcu7t3v3__inv_2_964/Y
+ gf180mcu_as_sc_mcu7t3v3__inv_2_964/VNW VSUBS gf180mcu_as_sc_mcu7t3v3__inv_2
Xgf180mcu_as_sc_mcu7t3v3__inv_2_941 VSS VSS VSS gf180mcu_as_sc_mcu7t3v3__inv_2_941/A
+ gf180mcu_as_sc_mcu7t3v3__inv_2_941/VNW VSUBS gf180mcu_as_sc_mcu7t3v3__inv_2
Xgf180mcu_as_sc_mcu7t3v3__inv_2_996 VSS VSS gf180mcu_as_sc_mcu7t3v3__inv_2_996/Y gf180mcu_as_sc_mcu7t3v3__inv_2_996/A
+ gf180mcu_as_sc_mcu7t3v3__inv_2_996/VNW VSUBS gf180mcu_as_sc_mcu7t3v3__inv_2
Xgf180mcu_as_sc_mcu7t3v3__inv_2_974 VSS VSS VSS gf180mcu_as_sc_mcu7t3v3__inv_2_975/Y
+ gf180mcu_as_sc_mcu7t3v3__inv_2_976/VNW VSUBS gf180mcu_as_sc_mcu7t3v3__inv_2
Xgf180mcu_as_sc_mcu7t3v3__inv_2_985 VSS VSS gf180mcu_as_sc_mcu7t3v3__inv_2_985/Y gf180mcu_as_sc_mcu7t3v3__inv_2_985/A
+ gf180mcu_as_sc_mcu7t3v3__inv_2_985/VNW VSUBS gf180mcu_as_sc_mcu7t3v3__inv_2
Xgf180mcu_as_sc_mcu7t3v3__nand4_2_284 VSS VSS VSS VSS VSS VSS gf180mcu_as_sc_mcu7t3v3__inv_2_1008/A
+ gf180mcu_as_sc_mcu7t3v3__inv_2_1053/VNW VSUBS gf180mcu_as_sc_mcu7t3v3__nand4_2
Xgf180mcu_as_sc_mcu7t3v3__nand4_2_273 VSS VSS VSS VSS VSS VSS gf180mcu_as_sc_mcu7t3v3__inv_2_904/A
+ gf180mcu_as_sc_mcu7t3v3__inv_2_956/VNW VSUBS gf180mcu_as_sc_mcu7t3v3__nand4_2
Xgf180mcu_as_sc_mcu7t3v3__nand4_2_240 VSS VSS VSS VSS VSS VSS gf180mcu_as_sc_mcu7t3v3__inv_2_801/A
+ gf180mcu_as_sc_mcu7t3v3__inv_2_847/VNW VSUBS gf180mcu_as_sc_mcu7t3v3__nand4_2
Xgf180mcu_as_sc_mcu7t3v3__nand4_2_295 VSS VSS VSS VSS VSS VSS gf180mcu_as_sc_mcu7t3v3__inv_2_1004/A
+ gf180mcu_as_sc_mcu7t3v3__inv_2_1004/VNW VSUBS gf180mcu_as_sc_mcu7t3v3__nand4_2
Xgf180mcu_as_sc_mcu7t3v3__nand4_2_251 VSS VSS VSS VSS VSS VSS gf180mcu_as_sc_mcu7t3v3__inv_2_861/A
+ gf180mcu_as_sc_mcu7t3v3__inv_2_937/VNW VSUBS gf180mcu_as_sc_mcu7t3v3__nand4_2
Xgf180mcu_as_sc_mcu7t3v3__nand4_2_262 VSS VSS VSS VSS VSS VSS gf180mcu_as_sc_mcu7t3v3__inv_2_882/A
+ gf180mcu_as_sc_mcu7t3v3__inv_2_933/VNW VSUBS gf180mcu_as_sc_mcu7t3v3__nand4_2
Xgf180mcu_as_sc_mcu7t3v3__inv_2_204 VSS VSS VSS gf180mcu_as_sc_mcu7t3v3__inv_2_205/Y
+ gf180mcu_as_sc_mcu7t3v3__inv_2_206/VNW VSUBS gf180mcu_as_sc_mcu7t3v3__inv_2
Xgf180mcu_as_sc_mcu7t3v3__inv_2_259 VSS VSS gf180mcu_as_sc_mcu7t3v3__inv_2_259/Y gf180mcu_as_sc_mcu7t3v3__inv_2_260/Y
+ gf180mcu_as_sc_mcu7t3v3__inv_2_260/VNW VSUBS gf180mcu_as_sc_mcu7t3v3__inv_2
Xgf180mcu_as_sc_mcu7t3v3__inv_2_226 VSS VSS gf180mcu_as_sc_mcu7t3v3__inv_2_226/Y gf180mcu_as_sc_mcu7t3v3__inv_2_227/Y
+ gf180mcu_as_sc_mcu7t3v3__inv_2_227/VNW VSUBS gf180mcu_as_sc_mcu7t3v3__inv_2
Xgf180mcu_as_sc_mcu7t3v3__inv_2_215 VSS VSS gf180mcu_as_sc_mcu7t3v3__inv_2_215/Y gf180mcu_as_sc_mcu7t3v3__inv_2_215/A
+ gf180mcu_as_sc_mcu7t3v3__inv_2_215/VNW VSUBS gf180mcu_as_sc_mcu7t3v3__inv_2
Xgf180mcu_as_sc_mcu7t3v3__inv_2_248 VSS VSS gf180mcu_as_sc_mcu7t3v3__inv_2_248/Y gf180mcu_as_sc_mcu7t3v3__inv_2_248/A
+ gf180mcu_as_sc_mcu7t3v3__inv_2_248/VNW VSUBS gf180mcu_as_sc_mcu7t3v3__inv_2
Xgf180mcu_as_sc_mcu7t3v3__inv_2_237 VSS VSS VSS gf180mcu_as_sc_mcu7t3v3__inv_2_238/Y
+ gf180mcu_as_sc_mcu7t3v3__inv_2_239/VNW VSUBS gf180mcu_as_sc_mcu7t3v3__inv_2
Xu_t000_012 u_t000_012/c0_w0_bl u_t000_012/c0_w0_br u_t000_012/c0_w1_bl u_t000_012/c0_w1_br
+ u_t000_012/c0_r0_rbl u_t000_012/c0_r1_rbl u_t000_012/c1_w0_bl u_t000_012/c1_w0_br
+ u_t000_012/c1_w1_bl u_t000_012/c1_w1_br u_t000_012/c1_r0_rbl u_t000_012/c1_r1_rbl
+ u_t000_012/c2_w0_bl u_t000_012/c2_w0_br u_t000_012/c2_w1_bl u_t000_012/c2_w1_br
+ u_t000_012/c2_r0_rbl u_t000_012/c2_r1_rbl u_t000_012/c3_w0_bl u_t000_012/c3_w0_br
+ u_t000_012/c3_w1_bl u_t000_012/c3_w1_br u_t000_012/c3_r0_rbl u_t000_012/c3_r1_rbl
+ u_t000_012/r0_w0_wl u_t000_012/r0_w1_wl u_t000_012/r0_r0_rwl u_t000_012/r0_r1_rwl
+ u_t000_012/r1_w0_wl u_t000_012/r1_w1_wl u_t000_012/r1_r0_rwl u_t000_012/r1_r1_rwl
+ u_t000_012/r2_w0_wl u_t000_012/r2_w1_wl u_t000_012/r2_r0_rwl u_t000_012/r2_r1_rwl
+ u_t000_012/r3_w0_wl u_t000_012/r3_w1_wl u_t000_012/r3_r0_rwl u_t000_012/r3_r1_rwl
+ VSS VSS u_t000_012/m2_717_1265# u_t000_012/m2_603_2031# u_t000_012/m2_1290_336#
+ u_t000_012/m2_2000_2037# u_t000_012/m2_791_2909# u_t000_012/m2_7_2126# u_t000_012/m2_2154_2081#
+ u_t000_012/m2_1795_2037# u_t000_012/m2_871_303# u_t000_012/m2_431_438# u_t000_012/m2_1290_2898#
+ u_t000_012/m2_1714_1210# u_t000_012/m2_431_1982# u_t000_012/m2_512_1265# u_t000_012/m2_2573_2126#
+ u_t000_012/m2_603_1259# u_t000_012/m2_2074_2909# u_t000_012/m2_7_336# u_t000_012/m2_717_2037#
+ u_t000_012/m2_1886_2031# u_t000_012/m2_2573_336# u_t000_012/m2_7_2898# u_t000_012/m2_2000_1265#
+ u_t000_012/m2_512_2037# u_t000_012/m2_1795_1265# u_t000_012/m2_1714_1982# u_t000_012/m2_1886_1259#
+ u_t000_012/m2_1290_2126# u_t000_012/m2_1714_438# u_t000_012/m2_431_1210# u_t000_012/m2_2573_2898#
+ u_t000_012/m2_2154_303# u_t000_012/m2_871_2081# VSUBS detronyx_12t_2w2r_rc4_4x4_routed_5layer_direct
Xu_t000_001 u_t000_001/c0_w0_bl u_t000_001/c0_w0_br u_t000_001/c0_w1_bl u_t000_001/c0_w1_br
+ u_t000_001/c0_r0_rbl u_t000_001/c0_r1_rbl u_t000_001/c1_w0_bl u_t000_001/c1_w0_br
+ u_t000_001/c1_w1_bl u_t000_001/c1_w1_br u_t000_001/c1_r0_rbl u_t000_001/c1_r1_rbl
+ u_t000_001/c2_w0_bl u_t000_001/c2_w0_br u_t000_001/c2_w1_bl u_t000_001/c2_w1_br
+ u_t000_001/c2_r0_rbl u_t000_001/c2_r1_rbl u_t000_001/c3_w0_bl u_t000_001/c3_w0_br
+ u_t000_001/c3_w1_bl u_t000_001/c3_w1_br u_t000_001/c3_r0_rbl u_t000_001/c3_r1_rbl
+ u_t000_001/r0_w0_wl u_t000_001/r0_w1_wl u_t000_001/r0_r0_rwl u_t000_001/r0_r1_rwl
+ u_t000_001/r1_w0_wl u_t000_001/r1_w1_wl u_t000_001/r1_r0_rwl u_t000_001/r1_r1_rwl
+ u_t000_001/r2_w0_wl u_t000_001/r2_w1_wl u_t000_001/r2_r0_rwl u_t000_001/r2_r1_rwl
+ u_t000_001/r3_w0_wl u_t000_001/r3_w1_wl u_t000_001/r3_r0_rwl u_t000_001/r3_r1_rwl
+ VSS VSS u_t000_001/m2_717_1265# u_t000_001/m2_603_2031# u_t000_001/m2_1290_336#
+ u_t000_001/m2_2000_2037# u_t000_001/m2_791_2909# u_t000_001/m2_7_2126# u_t000_001/m2_2154_2081#
+ u_t000_001/m2_1795_2037# u_t000_001/m2_871_303# u_t000_001/m2_431_438# u_t000_001/m2_1290_2898#
+ u_t000_001/m2_1714_1210# u_t000_001/m2_431_1982# u_t000_001/m2_512_1265# u_t000_001/m2_2573_2126#
+ u_t000_001/m2_603_1259# u_t000_001/m2_2074_2909# u_t000_001/m2_7_336# u_t000_001/m2_717_2037#
+ u_t000_001/m2_1886_2031# u_t000_001/m2_2573_336# u_t000_001/m2_7_2898# u_t000_001/m2_2000_1265#
+ u_t000_001/m2_512_2037# u_t000_001/m2_1795_1265# u_t000_001/m2_1714_1982# u_t000_001/m2_1886_1259#
+ u_t000_001/m2_1290_2126# u_t000_001/m2_1714_438# u_t000_001/m2_431_1210# u_t000_001/m2_2573_2898#
+ u_t000_001/m2_2154_303# u_t000_001/m2_871_2081# VSUBS detronyx_12t_2w2r_rc4_4x4_routed_5layer_direct
Xgf180mcu_as_sc_mcu7t3v3__inv_2_771 VSS VSS gf180mcu_as_sc_mcu7t3v3__inv_2_771/Y gf180mcu_as_sc_mcu7t3v3__inv_2_771/A
+ gf180mcu_as_sc_mcu7t3v3__inv_2_833/VNW VSUBS gf180mcu_as_sc_mcu7t3v3__inv_2
Xgf180mcu_as_sc_mcu7t3v3__inv_2_760 VSS VSS gf180mcu_as_sc_mcu7t3v3__inv_2_760/Y gf180mcu_as_sc_mcu7t3v3__inv_2_760/A
+ gf180mcu_as_sc_mcu7t3v3__inv_2_832/VNW VSUBS gf180mcu_as_sc_mcu7t3v3__inv_2
Xgf180mcu_as_sc_mcu7t3v3__inv_2_782 VSS VSS gf180mcu_as_sc_mcu7t3v3__inv_2_815/A gf180mcu_as_sc_mcu7t3v3__inv_2_783/Y
+ gf180mcu_as_sc_mcu7t3v3__inv_2_815/VNW VSUBS gf180mcu_as_sc_mcu7t3v3__inv_2
Xgf180mcu_as_sc_mcu7t3v3__inv_2_793 VSS VSS gf180mcu_as_sc_mcu7t3v3__inv_2_793/Y gf180mcu_as_sc_mcu7t3v3__inv_2_793/A
+ gf180mcu_as_sc_mcu7t3v3__inv_2_844/VNW VSUBS gf180mcu_as_sc_mcu7t3v3__inv_2
Xgf180mcu_as_sc_mcu7t3v3__inv_2_590 VSS VSS gf180mcu_as_sc_mcu7t3v3__inv_2_590/Y gf180mcu_as_sc_mcu7t3v3__inv_2_590/A
+ gf180mcu_as_sc_mcu7t3v3__inv_2_590/VNW VSUBS gf180mcu_as_sc_mcu7t3v3__inv_2
Xgf180mcu_as_sc_mcu7t3v3__nor2_2_5 gf180mcu_as_sc_mcu7t3v3__nor2_2_6/VDD gf180mcu_as_sc_mcu7t3v3__nor2_2_6/VSS
+ VSS VSS VSS gf180mcu_as_sc_mcu7t3v3__nor2_2_6/VNW VSUBS gf180mcu_as_sc_mcu7t3v3__nor2_2
Xgf180mcu_as_sc_mcu7t3v3__inv_2_1308 VSS VSS gf180mcu_as_sc_mcu7t3v3__inv_2_1355/A
+ gf180mcu_as_sc_mcu7t3v3__inv_2_1308/A gf180mcu_as_sc_mcu7t3v3__inv_2_1355/VNW VSUBS
+ gf180mcu_as_sc_mcu7t3v3__inv_2
Xgf180mcu_as_sc_mcu7t3v3__inv_2_1319 VSS VSS gf180mcu_as_sc_mcu7t3v3__inv_2_1319/Y
+ gf180mcu_as_sc_mcu7t3v3__inv_2_1320/Y gf180mcu_as_sc_mcu7t3v3__inv_2_1320/VNW VSUBS
+ gf180mcu_as_sc_mcu7t3v3__inv_2
Xu_t028_015 u_t028_015/c0_w0_bl u_t028_015/c0_w0_br u_t028_015/c0_w1_bl u_t028_015/c0_w1_br
+ u_t028_015/c0_r0_rbl u_t028_015/c0_r1_rbl u_t028_015/c1_w0_bl u_t028_015/c1_w0_br
+ u_t028_015/c1_w1_bl u_t028_015/c1_w1_br u_t028_015/c1_r0_rbl u_t028_015/c1_r1_rbl
+ u_t028_015/c2_w0_bl u_t028_015/c2_w0_br u_t028_015/c2_w1_bl u_t028_015/c2_w1_br
+ u_t028_015/c2_r0_rbl u_t028_015/c2_r1_rbl u_t028_015/c3_w0_bl u_t028_015/c3_w0_br
+ u_t028_015/c3_w1_bl u_t028_015/c3_w1_br u_t028_015/c3_r0_rbl u_t028_015/c3_r1_rbl
+ u_t028_015/r0_w0_wl u_t028_015/r0_w1_wl u_t028_015/r0_r0_rwl u_t028_015/r0_r1_rwl
+ u_t028_015/r1_w0_wl u_t028_015/r1_w1_wl u_t028_015/r1_r0_rwl u_t028_015/r1_r1_rwl
+ u_t028_015/r2_w0_wl u_t028_015/r2_w1_wl u_t028_015/r2_r0_rwl u_t028_015/r2_r1_rwl
+ u_t028_015/r3_w0_wl u_t028_015/r3_w1_wl u_t028_015/r3_r0_rwl u_t028_015/r3_r1_rwl
+ VSS VSS u_t028_015/m2_717_1265# u_t028_015/m2_603_2031# u_t028_015/m2_1290_336#
+ u_t028_015/m2_2000_2037# u_t028_015/m2_791_2909# u_t028_015/m2_7_2126# u_t028_015/m2_2154_2081#
+ u_t028_015/m2_1795_2037# u_t028_015/m2_871_303# u_t028_015/m2_431_438# u_t028_015/m2_1290_2898#
+ u_t028_015/m2_1714_1210# u_t028_015/m2_431_1982# u_t028_015/m2_512_1265# u_t028_015/m2_2573_2126#
+ u_t028_015/m2_603_1259# u_t028_015/m2_2074_2909# u_t028_015/m2_7_336# u_t028_015/m2_717_2037#
+ u_t028_015/m2_1886_2031# u_t028_015/m2_2573_336# u_t028_015/m2_7_2898# u_t028_015/m2_2000_1265#
+ u_t028_015/m2_512_2037# u_t028_015/m2_1795_1265# u_t028_015/m2_1714_1982# u_t028_015/m2_1886_1259#
+ u_t028_015/m2_1290_2126# u_t028_015/m2_1714_438# u_t028_015/m2_431_1210# u_t028_015/m2_2573_2898#
+ u_t028_015/m2_2154_303# u_t028_015/m2_871_2081# VSUBS detronyx_12t_2w2r_rc4_4x4_routed_5layer_direct
Xu_t028_004 u_t028_004/c0_w0_bl u_t028_004/c0_w0_br u_t028_004/c0_w1_bl u_t028_004/c0_w1_br
+ u_t028_004/c0_r0_rbl u_t028_004/c0_r1_rbl u_t028_004/c1_w0_bl u_t028_004/c1_w0_br
+ u_t028_004/c1_w1_bl u_t028_004/c1_w1_br u_t028_004/c1_r0_rbl u_t028_004/c1_r1_rbl
+ u_t028_004/c2_w0_bl u_t028_004/c2_w0_br u_t028_004/c2_w1_bl u_t028_004/c2_w1_br
+ u_t028_004/c2_r0_rbl u_t028_004/c2_r1_rbl u_t028_004/c3_w0_bl u_t028_004/c3_w0_br
+ u_t028_004/c3_w1_bl u_t028_004/c3_w1_br u_t028_004/c3_r0_rbl u_t028_004/c3_r1_rbl
+ u_t028_004/r0_w0_wl u_t028_004/r0_w1_wl u_t028_004/r0_r0_rwl u_t028_004/r0_r1_rwl
+ u_t028_004/r1_w0_wl u_t028_004/r1_w1_wl u_t028_004/r1_r0_rwl u_t028_004/r1_r1_rwl
+ u_t028_004/r2_w0_wl u_t028_004/r2_w1_wl u_t028_004/r2_r0_rwl u_t028_004/r2_r1_rwl
+ u_t028_004/r3_w0_wl u_t028_004/r3_w1_wl u_t028_004/r3_r0_rwl u_t028_004/r3_r1_rwl
+ VSS VSS u_t028_004/m2_717_1265# u_t028_004/m2_603_2031# u_t028_004/m2_1290_336#
+ u_t028_004/m2_2000_2037# u_t028_004/m2_791_2909# u_t028_004/m2_7_2126# u_t028_004/m2_2154_2081#
+ u_t028_004/m2_1795_2037# u_t028_004/m2_871_303# u_t028_004/m2_431_438# u_t028_004/m2_1290_2898#
+ u_t028_004/m2_1714_1210# u_t028_004/m2_431_1982# u_t028_004/m2_512_1265# u_t028_004/m2_2573_2126#
+ u_t028_004/m2_603_1259# u_t028_004/m2_2074_2909# u_t028_004/m2_7_336# u_t028_004/m2_717_2037#
+ u_t028_004/m2_1886_2031# u_t028_004/m2_2573_336# u_t028_004/m2_7_2898# u_t028_004/m2_2000_1265#
+ u_t028_004/m2_512_2037# u_t028_004/m2_1795_1265# u_t028_004/m2_1714_1982# u_t028_004/m2_1886_1259#
+ u_t028_004/m2_1290_2126# u_t028_004/m2_1714_438# u_t028_004/m2_431_1210# u_t028_004/m2_2573_2898#
+ u_t028_004/m2_2154_303# u_t028_004/m2_871_2081# VSUBS detronyx_12t_2w2r_rc4_4x4_routed_5layer_direct
Xu_t019_015 u_t019_015/c0_w0_bl u_t019_015/c0_w0_br u_t019_015/c0_w1_bl u_t019_015/c0_w1_br
+ u_t019_015/c0_r0_rbl u_t019_015/c0_r1_rbl u_t019_015/c1_w0_bl u_t019_015/c1_w0_br
+ u_t019_015/c1_w1_bl u_t019_015/c1_w1_br u_t019_015/c1_r0_rbl u_t019_015/c1_r1_rbl
+ u_t019_015/c2_w0_bl u_t019_015/c2_w0_br u_t019_015/c2_w1_bl u_t019_015/c2_w1_br
+ u_t019_015/c2_r0_rbl u_t019_015/c2_r1_rbl u_t019_015/c3_w0_bl u_t019_015/c3_w0_br
+ u_t019_015/c3_w1_bl u_t019_015/c3_w1_br u_t019_015/c3_r0_rbl u_t019_015/c3_r1_rbl
+ u_t019_015/r0_w0_wl u_t019_015/r0_w1_wl u_t019_015/r0_r0_rwl u_t019_015/r0_r1_rwl
+ u_t019_015/r1_w0_wl u_t019_015/r1_w1_wl u_t019_015/r1_r0_rwl u_t019_015/r1_r1_rwl
+ u_t019_015/r2_w0_wl u_t019_015/r2_w1_wl u_t019_015/r2_r0_rwl u_t019_015/r2_r1_rwl
+ u_t019_015/r3_w0_wl u_t019_015/r3_w1_wl u_t019_015/r3_r0_rwl u_t019_015/r3_r1_rwl
+ VSS VSS u_t019_015/m2_717_1265# u_t019_015/m2_603_2031# u_t019_015/m2_1290_336#
+ u_t019_015/m2_2000_2037# u_t019_015/m2_791_2909# u_t019_015/m2_7_2126# u_t019_015/m2_2154_2081#
+ u_t019_015/m2_1795_2037# u_t019_015/m2_871_303# u_t019_015/m2_431_438# u_t019_015/m2_1290_2898#
+ u_t019_015/m2_1714_1210# u_t019_015/m2_431_1982# u_t019_015/m2_512_1265# u_t019_015/m2_2573_2126#
+ u_t019_015/m2_603_1259# u_t019_015/m2_2074_2909# u_t019_015/m2_7_336# u_t019_015/m2_717_2037#
+ u_t019_015/m2_1886_2031# u_t019_015/m2_2573_336# u_t019_015/m2_7_2898# u_t019_015/m2_2000_1265#
+ u_t019_015/m2_512_2037# u_t019_015/m2_1795_1265# u_t019_015/m2_1714_1982# u_t019_015/m2_1886_1259#
+ u_t019_015/m2_1290_2126# u_t019_015/m2_1714_438# u_t019_015/m2_431_1210# u_t019_015/m2_2573_2898#
+ u_t019_015/m2_2154_303# u_t019_015/m2_871_2081# VSUBS detronyx_12t_2w2r_rc4_4x4_routed_5layer_direct
Xu_t019_004 u_t019_004/c0_w0_bl u_t019_004/c0_w0_br u_t019_004/c0_w1_bl u_t019_004/c0_w1_br
+ u_t019_004/c0_r0_rbl u_t019_004/c0_r1_rbl u_t019_004/c1_w0_bl u_t019_004/c1_w0_br
+ u_t019_004/c1_w1_bl u_t019_004/c1_w1_br u_t019_004/c1_r0_rbl u_t019_004/c1_r1_rbl
+ u_t019_004/c2_w0_bl u_t019_004/c2_w0_br u_t019_004/c2_w1_bl u_t019_004/c2_w1_br
+ u_t019_004/c2_r0_rbl u_t019_004/c2_r1_rbl u_t019_004/c3_w0_bl u_t019_004/c3_w0_br
+ u_t019_004/c3_w1_bl u_t019_004/c3_w1_br u_t019_004/c3_r0_rbl u_t019_004/c3_r1_rbl
+ u_t019_004/r0_w0_wl u_t019_004/r0_w1_wl u_t019_004/r0_r0_rwl u_t019_004/r0_r1_rwl
+ u_t019_004/r1_w0_wl u_t019_004/r1_w1_wl u_t019_004/r1_r0_rwl u_t019_004/r1_r1_rwl
+ u_t019_004/r2_w0_wl u_t019_004/r2_w1_wl u_t019_004/r2_r0_rwl u_t019_004/r2_r1_rwl
+ u_t019_004/r3_w0_wl u_t019_004/r3_w1_wl u_t019_004/r3_r0_rwl u_t019_004/r3_r1_rwl
+ VSS VSS u_t019_004/m2_717_1265# u_t019_004/m2_603_2031# u_t019_004/m2_1290_336#
+ u_t019_004/m2_2000_2037# u_t019_004/m2_791_2909# u_t019_004/m2_7_2126# u_t019_004/m2_2154_2081#
+ u_t019_004/m2_1795_2037# u_t019_004/m2_871_303# u_t019_004/m2_431_438# u_t019_004/m2_1290_2898#
+ u_t019_004/m2_1714_1210# u_t019_004/m2_431_1982# u_t019_004/m2_512_1265# u_t019_004/m2_2573_2126#
+ u_t019_004/m2_603_1259# u_t019_004/m2_2074_2909# u_t019_004/m2_7_336# u_t019_004/m2_717_2037#
+ u_t019_004/m2_1886_2031# u_t019_004/m2_2573_336# u_t019_004/m2_7_2898# u_t019_004/m2_2000_1265#
+ u_t019_004/m2_512_2037# u_t019_004/m2_1795_1265# u_t019_004/m2_1714_1982# u_t019_004/m2_1886_1259#
+ u_t019_004/m2_1290_2126# u_t019_004/m2_1714_438# u_t019_004/m2_431_1210# u_t019_004/m2_2573_2898#
+ u_t019_004/m2_2154_303# u_t019_004/m2_871_2081# VSUBS detronyx_12t_2w2r_rc4_4x4_routed_5layer_direct
Xgf180mcu_as_sc_mcu7t3v3__nand4_2_19 VSS VSS VSS VSS VSS VSS gf180mcu_as_sc_mcu7t3v3__inv_2_137/A
+ gf180mcu_as_sc_mcu7t3v3__inv_2_137/VNW VSUBS gf180mcu_as_sc_mcu7t3v3__nand4_2
Xu_t025_007 u_t025_007/c0_w0_bl u_t025_007/c0_w0_br u_t025_007/c0_w1_bl u_t025_007/c0_w1_br
+ u_t025_007/c0_r0_rbl u_t025_007/c0_r1_rbl u_t025_007/c1_w0_bl u_t025_007/c1_w0_br
+ u_t025_007/c1_w1_bl u_t025_007/c1_w1_br u_t025_007/c1_r0_rbl u_t025_007/c1_r1_rbl
+ u_t025_007/c2_w0_bl u_t025_007/c2_w0_br u_t025_007/c2_w1_bl u_t025_007/c2_w1_br
+ u_t025_007/c2_r0_rbl u_t025_007/c2_r1_rbl u_t025_007/c3_w0_bl u_t025_007/c3_w0_br
+ u_t025_007/c3_w1_bl u_t025_007/c3_w1_br u_t025_007/c3_r0_rbl u_t025_007/c3_r1_rbl
+ u_t025_007/r0_w0_wl u_t025_007/r0_w1_wl u_t025_007/r0_r0_rwl u_t025_007/r0_r1_rwl
+ u_t025_007/r1_w0_wl u_t025_007/r1_w1_wl u_t025_007/r1_r0_rwl u_t025_007/r1_r1_rwl
+ u_t025_007/r2_w0_wl u_t025_007/r2_w1_wl u_t025_007/r2_r0_rwl u_t025_007/r2_r1_rwl
+ u_t025_007/r3_w0_wl u_t025_007/r3_w1_wl u_t025_007/r3_r0_rwl u_t025_007/r3_r1_rwl
+ VSS VSS u_t025_007/m2_717_1265# u_t025_007/m2_603_2031# u_t025_007/m2_1290_336#
+ u_t025_007/m2_2000_2037# u_t025_007/m2_791_2909# u_t025_007/m2_7_2126# u_t025_007/m2_2154_2081#
+ u_t025_007/m2_1795_2037# u_t025_007/m2_871_303# u_t025_007/m2_431_438# u_t025_007/m2_1290_2898#
+ u_t025_007/m2_1714_1210# u_t025_007/m2_431_1982# u_t025_007/m2_512_1265# u_t025_007/m2_2573_2126#
+ u_t025_007/m2_603_1259# u_t025_007/m2_2074_2909# u_t025_007/m2_7_336# u_t025_007/m2_717_2037#
+ u_t025_007/m2_1886_2031# u_t025_007/m2_2573_336# u_t025_007/m2_7_2898# u_t025_007/m2_2000_1265#
+ u_t025_007/m2_512_2037# u_t025_007/m2_1795_1265# u_t025_007/m2_1714_1982# u_t025_007/m2_1886_1259#
+ u_t025_007/m2_1290_2126# u_t025_007/m2_1714_438# u_t025_007/m2_431_1210# u_t025_007/m2_2573_2898#
+ u_t025_007/m2_2154_303# u_t025_007/m2_871_2081# VSUBS detronyx_12t_2w2r_rc4_4x4_routed_5layer_direct
Xgf180mcu_as_sc_mcu7t3v3__inv_2_1127 VSS VSS VSS gf180mcu_as_sc_mcu7t3v3__inv_2_1128/Y
+ gf180mcu_as_sc_mcu7t3v3__inv_2_1129/VNW VSUBS gf180mcu_as_sc_mcu7t3v3__inv_2
Xgf180mcu_as_sc_mcu7t3v3__inv_2_1138 VSS VSS gf180mcu_as_sc_mcu7t3v3__inv_2_1138/Y
+ gf180mcu_as_sc_mcu7t3v3__inv_2_1139/Y gf180mcu_as_sc_mcu7t3v3__inv_2_1139/VNW VSUBS
+ gf180mcu_as_sc_mcu7t3v3__inv_2
Xgf180mcu_as_sc_mcu7t3v3__inv_2_1116 VSS VSS VSS gf180mcu_as_sc_mcu7t3v3__inv_2_1117/Y
+ gf180mcu_as_sc_mcu7t3v3__inv_2_1118/VNW VSUBS gf180mcu_as_sc_mcu7t3v3__inv_2
Xgf180mcu_as_sc_mcu7t3v3__inv_2_1149 VSS VSS VSS gf180mcu_as_sc_mcu7t3v3__inv_2_1150/Y
+ gf180mcu_as_sc_mcu7t3v3__inv_2_1151/VNW VSUBS gf180mcu_as_sc_mcu7t3v3__inv_2
Xgf180mcu_as_sc_mcu7t3v3__inv_2_1105 VSS VSS VSS gf180mcu_as_sc_mcu7t3v3__inv_2_1106/Y
+ gf180mcu_as_sc_mcu7t3v3__inv_2_1107/VNW VSUBS gf180mcu_as_sc_mcu7t3v3__inv_2
Xu_t016_007 u_t016_007/c0_w0_bl u_t016_007/c0_w0_br u_t016_007/c0_w1_bl u_t016_007/c0_w1_br
+ u_t016_007/c0_r0_rbl u_t016_007/c0_r1_rbl u_t016_007/c1_w0_bl u_t016_007/c1_w0_br
+ u_t016_007/c1_w1_bl u_t016_007/c1_w1_br u_t016_007/c1_r0_rbl u_t016_007/c1_r1_rbl
+ u_t016_007/c2_w0_bl u_t016_007/c2_w0_br u_t016_007/c2_w1_bl u_t016_007/c2_w1_br
+ u_t016_007/c2_r0_rbl u_t016_007/c2_r1_rbl u_t016_007/c3_w0_bl u_t016_007/c3_w0_br
+ u_t016_007/c3_w1_bl u_t016_007/c3_w1_br u_t016_007/c3_r0_rbl u_t016_007/c3_r1_rbl
+ u_t016_007/r0_w0_wl u_t016_007/r0_w1_wl u_t016_007/r0_r0_rwl u_t016_007/r0_r1_rwl
+ u_t016_007/r1_w0_wl u_t016_007/r1_w1_wl u_t016_007/r1_r0_rwl u_t016_007/r1_r1_rwl
+ u_t016_007/r2_w0_wl u_t016_007/r2_w1_wl u_t016_007/r2_r0_rwl u_t016_007/r2_r1_rwl
+ u_t016_007/r3_w0_wl u_t016_007/r3_w1_wl u_t016_007/r3_r0_rwl u_t016_007/r3_r1_rwl
+ VSS VSS u_t016_007/m2_717_1265# u_t016_007/m2_603_2031# u_t016_007/m2_1290_336#
+ u_t016_007/m2_2000_2037# u_t016_007/m2_791_2909# u_t016_007/m2_7_2126# u_t016_007/m2_2154_2081#
+ u_t016_007/m2_1795_2037# u_t016_007/m2_871_303# u_t016_007/m2_431_438# u_t016_007/m2_1290_2898#
+ u_t016_007/m2_1714_1210# u_t016_007/m2_431_1982# u_t016_007/m2_512_1265# u_t016_007/m2_2573_2126#
+ u_t016_007/m2_603_1259# u_t016_007/m2_2074_2909# u_t016_007/m2_7_336# u_t016_007/m2_717_2037#
+ u_t016_007/m2_1886_2031# u_t016_007/m2_2573_336# u_t016_007/m2_7_2898# u_t016_007/m2_2000_1265#
+ u_t016_007/m2_512_2037# u_t016_007/m2_1795_1265# u_t016_007/m2_1714_1982# u_t016_007/m2_1886_1259#
+ u_t016_007/m2_1290_2126# u_t016_007/m2_1714_438# u_t016_007/m2_431_1210# u_t016_007/m2_2573_2898#
+ u_t016_007/m2_2154_303# u_t016_007/m2_871_2081# VSUBS detronyx_12t_2w2r_rc4_4x4_routed_5layer_direct
Xgf180mcu_as_sc_mcu7t3v3__nand3_2_30 gf180mcu_as_sc_mcu7t3v3__nor2_2_7/VDD gf180mcu_as_sc_mcu7t3v3__nand3_2_4/VSS
+ VSS VSS VSS VSS gf180mcu_as_sc_mcu7t3v3__nor2_2_7/VNW VSUBS gf180mcu_as_sc_mcu7t3v3__nand3_2
Xgf180mcu_as_sc_mcu7t3v3__nand3_2_63 gf180mcu_as_sc_mcu7t3v3__nor2_2_9/VDD gf180mcu_as_sc_mcu7t3v3__nand3_2_63/VSS
+ VSS VSS VSS VSS gf180mcu_as_sc_mcu7t3v3__nor2_2_9/VNW VSUBS gf180mcu_as_sc_mcu7t3v3__nand3_2
Xgf180mcu_as_sc_mcu7t3v3__nand3_2_52 gf180mcu_as_sc_mcu7t3v3__nand3_2_65/VDD gf180mcu_as_sc_mcu7t3v3__nand3_2_62/VSS
+ VSS VSS VSS VSS gf180mcu_as_sc_mcu7t3v3__nand3_2_65/VNW VSUBS gf180mcu_as_sc_mcu7t3v3__nand3_2
Xgf180mcu_as_sc_mcu7t3v3__nand3_2_41 gf180mcu_as_sc_mcu7t3v3__nor2_2_4/VDD gf180mcu_as_sc_mcu7t3v3__nor2_2_4/VSS
+ VSS VSS VSS VSS gf180mcu_as_sc_mcu7t3v3__nor2_2_4/VNW VSUBS gf180mcu_as_sc_mcu7t3v3__nand3_2
Xgf180mcu_as_sc_mcu7t3v3__inv_2_1661 VSS VSS gf180mcu_as_sc_mcu7t3v3__inv_2_1661/Y
+ gf180mcu_as_sc_mcu7t3v3__inv_2_1665/Y gf180mcu_as_sc_mcu7t3v3__inv_2_1665/VNW VSUBS
+ gf180mcu_as_sc_mcu7t3v3__inv_2
Xgf180mcu_as_sc_mcu7t3v3__inv_2_1650 VSS VSS VSS gf180mcu_as_sc_mcu7t3v3__inv_2_1651/Y
+ gf180mcu_as_sc_mcu7t3v3__inv_2_1652/VNW VSUBS gf180mcu_as_sc_mcu7t3v3__inv_2
Xgf180mcu_as_sc_mcu7t3v3__inv_2_1672 VSS VSS gf180mcu_as_sc_mcu7t3v3__inv_2_1672/Y
+ gf180mcu_as_sc_mcu7t3v3__inv_2_1672/A gf180mcu_as_sc_mcu7t3v3__inv_2_1672/VNW VSUBS
+ gf180mcu_as_sc_mcu7t3v3__inv_2
Xgf180mcu_as_sc_mcu7t3v3__inv_2_1683 VSS VSS gf180mcu_as_sc_mcu7t3v3__inv_2_1683/Y
+ gf180mcu_as_sc_mcu7t3v3__inv_2_1684/Y gf180mcu_as_sc_mcu7t3v3__inv_2_1684/VNW VSUBS
+ gf180mcu_as_sc_mcu7t3v3__inv_2
Xgf180mcu_as_sc_mcu7t3v3__inv_2_1694 VSS VSS gf180mcu_as_sc_mcu7t3v3__inv_2_1694/Y
+ gf180mcu_as_sc_mcu7t3v3__inv_2_1694/A gf180mcu_as_sc_mcu7t3v3__inv_2_1694/VNW VSUBS
+ gf180mcu_as_sc_mcu7t3v3__inv_2
Xu_t007_007 u_t007_007/c0_w0_bl u_t007_007/c0_w0_br u_t007_007/c0_w1_bl u_t007_007/c0_w1_br
+ u_t007_007/c0_r0_rbl u_t007_007/c0_r1_rbl u_t007_007/c1_w0_bl u_t007_007/c1_w0_br
+ u_t007_007/c1_w1_bl u_t007_007/c1_w1_br u_t007_007/c1_r0_rbl u_t007_007/c1_r1_rbl
+ u_t007_007/c2_w0_bl u_t007_007/c2_w0_br u_t007_007/c2_w1_bl u_t007_007/c2_w1_br
+ u_t007_007/c2_r0_rbl u_t007_007/c2_r1_rbl u_t007_007/c3_w0_bl u_t007_007/c3_w0_br
+ u_t007_007/c3_w1_bl u_t007_007/c3_w1_br u_t007_007/c3_r0_rbl u_t007_007/c3_r1_rbl
+ u_t007_007/r0_w0_wl u_t007_007/r0_w1_wl u_t007_007/r0_r0_rwl u_t007_007/r0_r1_rwl
+ u_t007_007/r1_w0_wl u_t007_007/r1_w1_wl u_t007_007/r1_r0_rwl u_t007_007/r1_r1_rwl
+ u_t007_007/r2_w0_wl u_t007_007/r2_w1_wl u_t007_007/r2_r0_rwl u_t007_007/r2_r1_rwl
+ u_t007_007/r3_w0_wl u_t007_007/r3_w1_wl u_t007_007/r3_r0_rwl u_t007_007/r3_r1_rwl
+ VSS VSS u_t007_007/m2_717_1265# u_t007_007/m2_603_2031# u_t007_007/m2_1290_336#
+ u_t007_007/m2_2000_2037# u_t007_007/m2_791_2909# u_t007_007/m2_7_2126# u_t007_007/m2_2154_2081#
+ u_t007_007/m2_1795_2037# u_t007_007/m2_871_303# u_t007_007/m2_431_438# u_t007_007/m2_1290_2898#
+ u_t007_007/m2_1714_1210# u_t007_007/m2_431_1982# u_t007_007/m2_512_1265# u_t007_007/m2_2573_2126#
+ u_t007_007/m2_603_1259# u_t007_007/m2_2074_2909# u_t007_007/m2_7_336# u_t007_007/m2_717_2037#
+ u_t007_007/m2_1886_2031# u_t007_007/m2_2573_336# u_t007_007/m2_7_2898# u_t007_007/m2_2000_1265#
+ u_t007_007/m2_512_2037# u_t007_007/m2_1795_1265# u_t007_007/m2_1714_1982# u_t007_007/m2_1886_1259#
+ u_t007_007/m2_1290_2126# u_t007_007/m2_1714_438# u_t007_007/m2_431_1210# u_t007_007/m2_2573_2898#
+ u_t007_007/m2_2154_303# u_t007_007/m2_871_2081# VSUBS detronyx_12t_2w2r_rc4_4x4_routed_5layer_direct
Xu_t030_010 u_t030_010/c0_w0_bl u_t030_010/c0_w0_br u_t030_010/c0_w1_bl u_t030_010/c0_w1_br
+ u_t030_010/c0_r0_rbl u_t030_010/c0_r1_rbl u_t030_010/c1_w0_bl u_t030_010/c1_w0_br
+ u_t030_010/c1_w1_bl u_t030_010/c1_w1_br u_t030_010/c1_r0_rbl u_t030_010/c1_r1_rbl
+ u_t030_010/c2_w0_bl u_t030_010/c2_w0_br u_t030_010/c2_w1_bl u_t030_010/c2_w1_br
+ u_t030_010/c2_r0_rbl u_t030_010/c2_r1_rbl u_t030_010/c3_w0_bl u_t030_010/c3_w0_br
+ u_t030_010/c3_w1_bl u_t030_010/c3_w1_br u_t030_010/c3_r0_rbl u_t030_010/c3_r1_rbl
+ u_t030_010/r0_w0_wl u_t030_010/r0_w1_wl u_t030_010/r0_r0_rwl u_t030_010/r0_r1_rwl
+ u_t030_010/r1_w0_wl u_t030_010/r1_w1_wl u_t030_010/r1_r0_rwl u_t030_010/r1_r1_rwl
+ u_t030_010/r2_w0_wl u_t030_010/r2_w1_wl u_t030_010/r2_r0_rwl u_t030_010/r2_r1_rwl
+ u_t030_010/r3_w0_wl u_t030_010/r3_w1_wl u_t030_010/r3_r0_rwl u_t030_010/r3_r1_rwl
+ VSS VSS u_t030_010/m2_717_1265# u_t030_010/m2_603_2031# u_t030_010/m2_1290_336#
+ u_t030_010/m2_2000_2037# u_t030_010/m2_791_2909# u_t030_010/m2_7_2126# u_t030_010/m2_2154_2081#
+ u_t030_010/m2_1795_2037# u_t030_010/m2_871_303# u_t030_010/m2_431_438# u_t030_010/m2_1290_2898#
+ u_t030_010/m2_1714_1210# u_t030_010/m2_431_1982# u_t030_010/m2_512_1265# u_t030_010/m2_2573_2126#
+ u_t030_010/m2_603_1259# u_t030_010/m2_2074_2909# u_t030_010/m2_7_336# u_t030_010/m2_717_2037#
+ u_t030_010/m2_1886_2031# u_t030_010/m2_2573_336# u_t030_010/m2_7_2898# u_t030_010/m2_2000_1265#
+ u_t030_010/m2_512_2037# u_t030_010/m2_1795_1265# u_t030_010/m2_1714_1982# u_t030_010/m2_1886_1259#
+ u_t030_010/m2_1290_2126# u_t030_010/m2_1714_438# u_t030_010/m2_431_1210# u_t030_010/m2_2573_2898#
+ u_t030_010/m2_2154_303# u_t030_010/m2_871_2081# VSUBS detronyx_12t_2w2r_rc4_4x4_routed_5layer_direct
Xgf180mcu_as_sc_mcu7t3v3__nand4_2_499 VSS VSS VSS VSS VSS VSS gf180mcu_as_sc_mcu7t3v3__inv_2_1634/A
+ gf180mcu_as_sc_mcu7t3v3__inv_2_1634/VNW VSUBS gf180mcu_as_sc_mcu7t3v3__nand4_2
Xgf180mcu_as_sc_mcu7t3v3__nand4_2_433 VSS VSS VSS VSS VSS VSS gf180mcu_as_sc_mcu7t3v3__inv_2_1570/A
+ gf180mcu_as_sc_mcu7t3v3__inv_2_1570/VNW VSUBS gf180mcu_as_sc_mcu7t3v3__nand4_2
Xgf180mcu_as_sc_mcu7t3v3__nand4_2_444 VSS VSS VSS VSS VSS VSS gf180mcu_as_sc_mcu7t3v3__inv_2_1602/A
+ gf180mcu_as_sc_mcu7t3v3__inv_2_1669/VNW VSUBS gf180mcu_as_sc_mcu7t3v3__nand4_2
Xgf180mcu_as_sc_mcu7t3v3__nand4_2_488 VSS VSS VSS VSS VSS VSS gf180mcu_as_sc_mcu7t3v3__inv_2_1676/A
+ gf180mcu_as_sc_mcu7t3v3__inv_2_1676/VNW VSUBS gf180mcu_as_sc_mcu7t3v3__nand4_2
Xgf180mcu_as_sc_mcu7t3v3__nand4_2_422 VSS VSS VSS VSS VSS VSS gf180mcu_as_sc_mcu7t3v3__inv_2_1538/A
+ gf180mcu_as_sc_mcu7t3v3__inv_2_1538/VNW VSUBS gf180mcu_as_sc_mcu7t3v3__nand4_2
Xgf180mcu_as_sc_mcu7t3v3__nand4_2_466 VSS VSS VSS VSS VSS VSS gf180mcu_as_sc_mcu7t3v3__inv_2_1370/A
+ gf180mcu_as_sc_mcu7t3v3__inv_2_1370/VNW VSUBS gf180mcu_as_sc_mcu7t3v3__nand4_2
Xgf180mcu_as_sc_mcu7t3v3__nand4_2_400 VSS VSS VSS VSS VSS VSS gf180mcu_as_sc_mcu7t3v3__inv_2_1470/A
+ gf180mcu_as_sc_mcu7t3v3__inv_2_1470/VNW VSUBS gf180mcu_as_sc_mcu7t3v3__nand4_2
Xgf180mcu_as_sc_mcu7t3v3__nand4_2_477 VSS VSS VSS VSS VSS VSS gf180mcu_as_sc_mcu7t3v3__inv_2_1375/A
+ gf180mcu_as_sc_mcu7t3v3__inv_2_1375/VNW VSUBS gf180mcu_as_sc_mcu7t3v3__nand4_2
Xgf180mcu_as_sc_mcu7t3v3__nand4_2_411 VSS VSS VSS VSS VSS VSS gf180mcu_as_sc_mcu7t3v3__inv_2_1503/A
+ gf180mcu_as_sc_mcu7t3v3__inv_2_1503/VNW VSUBS gf180mcu_as_sc_mcu7t3v3__nand4_2
Xgf180mcu_as_sc_mcu7t3v3__nand4_2_455 VSS VSS VSS VSS VSS VSS gf180mcu_as_sc_mcu7t3v3__inv_2_1308/A
+ gf180mcu_as_sc_mcu7t3v3__inv_2_1355/VNW VSUBS gf180mcu_as_sc_mcu7t3v3__nand4_2
Xu_t021_010 u_t021_010/c0_w0_bl u_t021_010/c0_w0_br u_t021_010/c0_w1_bl u_t021_010/c0_w1_br
+ u_t021_010/c0_r0_rbl u_t021_010/c0_r1_rbl u_t021_010/c1_w0_bl u_t021_010/c1_w0_br
+ u_t021_010/c1_w1_bl u_t021_010/c1_w1_br u_t021_010/c1_r0_rbl u_t021_010/c1_r1_rbl
+ u_t021_010/c2_w0_bl u_t021_010/c2_w0_br u_t021_010/c2_w1_bl u_t021_010/c2_w1_br
+ u_t021_010/c2_r0_rbl u_t021_010/c2_r1_rbl u_t021_010/c3_w0_bl u_t021_010/c3_w0_br
+ u_t021_010/c3_w1_bl u_t021_010/c3_w1_br u_t021_010/c3_r0_rbl u_t021_010/c3_r1_rbl
+ u_t021_010/r0_w0_wl u_t021_010/r0_w1_wl u_t021_010/r0_r0_rwl u_t021_010/r0_r1_rwl
+ u_t021_010/r1_w0_wl u_t021_010/r1_w1_wl u_t021_010/r1_r0_rwl u_t021_010/r1_r1_rwl
+ u_t021_010/r2_w0_wl u_t021_010/r2_w1_wl u_t021_010/r2_r0_rwl u_t021_010/r2_r1_rwl
+ u_t021_010/r3_w0_wl u_t021_010/r3_w1_wl u_t021_010/r3_r0_rwl u_t021_010/r3_r1_rwl
+ VSS VSS u_t021_010/m2_717_1265# u_t021_010/m2_603_2031# u_t021_010/m2_1290_336#
+ u_t021_010/m2_2000_2037# u_t021_010/m2_791_2909# u_t021_010/m2_7_2126# u_t021_010/m2_2154_2081#
+ u_t021_010/m2_1795_2037# u_t021_010/m2_871_303# u_t021_010/m2_431_438# u_t021_010/m2_1290_2898#
+ u_t021_010/m2_1714_1210# u_t021_010/m2_431_1982# u_t021_010/m2_512_1265# u_t021_010/m2_2573_2126#
+ u_t021_010/m2_603_1259# u_t021_010/m2_2074_2909# u_t021_010/m2_7_336# u_t021_010/m2_717_2037#
+ u_t021_010/m2_1886_2031# u_t021_010/m2_2573_336# u_t021_010/m2_7_2898# u_t021_010/m2_2000_1265#
+ u_t021_010/m2_512_2037# u_t021_010/m2_1795_1265# u_t021_010/m2_1714_1982# u_t021_010/m2_1886_1259#
+ u_t021_010/m2_1290_2126# u_t021_010/m2_1714_438# u_t021_010/m2_431_1210# u_t021_010/m2_2573_2898#
+ u_t021_010/m2_2154_303# u_t021_010/m2_871_2081# VSUBS detronyx_12t_2w2r_rc4_4x4_routed_5layer_direct
Xgf180mcu_as_sc_mcu7t3v3__inv_2_1 VSS VSS VSS gf180mcu_as_sc_mcu7t3v3__inv_2_5/Y gf180mcu_as_sc_mcu7t3v3__inv_2_9/VNW
+ VSUBS gf180mcu_as_sc_mcu7t3v3__inv_2
Xgf180mcu_as_sc_mcu7t3v3__inv_2_419 gf180mcu_as_sc_mcu7t3v3__nor2_2_6/VDD gf180mcu_as_sc_mcu7t3v3__nor2_2_6/VSS
+ gf180mcu_as_sc_mcu7t3v3__inv_2_419/Y VSS gf180mcu_as_sc_mcu7t3v3__nor2_2_6/VNW VSUBS
+ gf180mcu_as_sc_mcu7t3v3__inv_2
Xgf180mcu_as_sc_mcu7t3v3__inv_2_408 gf180mcu_as_sc_mcu7t3v3__nand3_2_9/VDD gf180mcu_as_sc_mcu7t3v3__nor2_2_4/VSS
+ gf180mcu_as_sc_mcu7t3v3__inv_2_408/Y VSS gf180mcu_as_sc_mcu7t3v3__nand3_2_9/VNW
+ VSUBS gf180mcu_as_sc_mcu7t3v3__inv_2
Xu_t012_010 u_t012_010/c0_w0_bl u_t012_010/c0_w0_br u_t012_010/c0_w1_bl u_t012_010/c0_w1_br
+ u_t012_010/c0_r0_rbl u_t012_010/c0_r1_rbl u_t012_010/c1_w0_bl u_t012_010/c1_w0_br
+ u_t012_010/c1_w1_bl u_t012_010/c1_w1_br u_t012_010/c1_r0_rbl u_t012_010/c1_r1_rbl
+ u_t012_010/c2_w0_bl u_t012_010/c2_w0_br u_t012_010/c2_w1_bl u_t012_010/c2_w1_br
+ u_t012_010/c2_r0_rbl u_t012_010/c2_r1_rbl u_t012_010/c3_w0_bl u_t012_010/c3_w0_br
+ u_t012_010/c3_w1_bl u_t012_010/c3_w1_br u_t012_010/c3_r0_rbl u_t012_010/c3_r1_rbl
+ u_t012_010/r0_w0_wl u_t012_010/r0_w1_wl u_t012_010/r0_r0_rwl u_t012_010/r0_r1_rwl
+ u_t012_010/r1_w0_wl u_t012_010/r1_w1_wl u_t012_010/r1_r0_rwl u_t012_010/r1_r1_rwl
+ u_t012_010/r2_w0_wl u_t012_010/r2_w1_wl u_t012_010/r2_r0_rwl u_t012_010/r2_r1_rwl
+ u_t012_010/r3_w0_wl u_t012_010/r3_w1_wl u_t012_010/r3_r0_rwl u_t012_010/r3_r1_rwl
+ VSS VSS u_t012_010/m2_717_1265# u_t012_010/m2_603_2031# u_t012_010/m2_1290_336#
+ u_t012_010/m2_2000_2037# u_t012_010/m2_791_2909# u_t012_010/m2_7_2126# u_t012_010/m2_2154_2081#
+ u_t012_010/m2_1795_2037# u_t012_010/m2_871_303# u_t012_010/m2_431_438# u_t012_010/m2_1290_2898#
+ u_t012_010/m2_1714_1210# u_t012_010/m2_431_1982# u_t012_010/m2_512_1265# u_t012_010/m2_2573_2126#
+ u_t012_010/m2_603_1259# u_t012_010/m2_2074_2909# u_t012_010/m2_7_336# u_t012_010/m2_717_2037#
+ u_t012_010/m2_1886_2031# u_t012_010/m2_2573_336# u_t012_010/m2_7_2898# u_t012_010/m2_2000_1265#
+ u_t012_010/m2_512_2037# u_t012_010/m2_1795_1265# u_t012_010/m2_1714_1982# u_t012_010/m2_1886_1259#
+ u_t012_010/m2_1290_2126# u_t012_010/m2_1714_438# u_t012_010/m2_431_1210# u_t012_010/m2_2573_2898#
+ u_t012_010/m2_2154_303# u_t012_010/m2_871_2081# VSUBS detronyx_12t_2w2r_rc4_4x4_routed_5layer_direct
Xgf180mcu_as_sc_mcu7t3v3__inv_2_1480 VSS VSS VSS gf180mcu_as_sc_mcu7t3v3__inv_2_1481/Y
+ gf180mcu_as_sc_mcu7t3v3__inv_2_1482/VNW VSUBS gf180mcu_as_sc_mcu7t3v3__inv_2
Xgf180mcu_as_sc_mcu7t3v3__inv_2_1491 VSS VSS gf180mcu_as_sc_mcu7t3v3__inv_2_1491/Y
+ gf180mcu_as_sc_mcu7t3v3__inv_2_1491/A gf180mcu_as_sc_mcu7t3v3__inv_2_1491/VNW VSUBS
+ gf180mcu_as_sc_mcu7t3v3__inv_2
Xu_t003_010 u_t003_010/c0_w0_bl u_t003_010/c0_w0_br u_t003_010/c0_w1_bl u_t003_010/c0_w1_br
+ u_t003_010/c0_r0_rbl u_t003_010/c0_r1_rbl u_t003_010/c1_w0_bl u_t003_010/c1_w0_br
+ u_t003_010/c1_w1_bl u_t003_010/c1_w1_br u_t003_010/c1_r0_rbl u_t003_010/c1_r1_rbl
+ u_t003_010/c2_w0_bl u_t003_010/c2_w0_br u_t003_010/c2_w1_bl u_t003_010/c2_w1_br
+ u_t003_010/c2_r0_rbl u_t003_010/c2_r1_rbl u_t003_010/c3_w0_bl u_t003_010/c3_w0_br
+ u_t003_010/c3_w1_bl u_t003_010/c3_w1_br u_t003_010/c3_r0_rbl u_t003_010/c3_r1_rbl
+ u_t003_010/r0_w0_wl u_t003_010/r0_w1_wl u_t003_010/r0_r0_rwl u_t003_010/r0_r1_rwl
+ u_t003_010/r1_w0_wl u_t003_010/r1_w1_wl u_t003_010/r1_r0_rwl u_t003_010/r1_r1_rwl
+ u_t003_010/r2_w0_wl u_t003_010/r2_w1_wl u_t003_010/r2_r0_rwl u_t003_010/r2_r1_rwl
+ u_t003_010/r3_w0_wl u_t003_010/r3_w1_wl u_t003_010/r3_r0_rwl u_t003_010/r3_r1_rwl
+ VSS VSS u_t003_010/m2_717_1265# u_t003_010/m2_603_2031# u_t003_010/m2_1290_336#
+ u_t003_010/m2_2000_2037# u_t003_010/m2_791_2909# u_t003_010/m2_7_2126# u_t003_010/m2_2154_2081#
+ u_t003_010/m2_1795_2037# u_t003_010/m2_871_303# u_t003_010/m2_431_438# u_t003_010/m2_1290_2898#
+ u_t003_010/m2_1714_1210# u_t003_010/m2_431_1982# u_t003_010/m2_512_1265# u_t003_010/m2_2573_2126#
+ u_t003_010/m2_603_1259# u_t003_010/m2_2074_2909# u_t003_010/m2_7_336# u_t003_010/m2_717_2037#
+ u_t003_010/m2_1886_2031# u_t003_010/m2_2573_336# u_t003_010/m2_7_2898# u_t003_010/m2_2000_1265#
+ u_t003_010/m2_512_2037# u_t003_010/m2_1795_1265# u_t003_010/m2_1714_1982# u_t003_010/m2_1886_1259#
+ u_t003_010/m2_1290_2126# u_t003_010/m2_1714_438# u_t003_010/m2_431_1210# u_t003_010/m2_2573_2898#
+ u_t003_010/m2_2154_303# u_t003_010/m2_871_2081# VSUBS detronyx_12t_2w2r_rc4_4x4_routed_5layer_direct
Xgf180mcu_as_sc_mcu7t3v3__inv_2_920 VSS VSS gf180mcu_as_sc_mcu7t3v3__inv_2_920/Y gf180mcu_as_sc_mcu7t3v3__inv_2_920/A
+ gf180mcu_as_sc_mcu7t3v3__inv_2_947/VNW VSUBS gf180mcu_as_sc_mcu7t3v3__inv_2
Xgf180mcu_as_sc_mcu7t3v3__inv_2_953 VSS VSS VSS gf180mcu_as_sc_mcu7t3v3__inv_2_953/A
+ gf180mcu_as_sc_mcu7t3v3__inv_2_953/VNW VSUBS gf180mcu_as_sc_mcu7t3v3__inv_2
Xgf180mcu_as_sc_mcu7t3v3__inv_2_986 VSS VSS VSS gf180mcu_as_sc_mcu7t3v3__inv_2_987/Y
+ gf180mcu_as_sc_mcu7t3v3__inv_2_988/VNW VSUBS gf180mcu_as_sc_mcu7t3v3__inv_2
Xgf180mcu_as_sc_mcu7t3v3__inv_2_997 VSS VSS gf180mcu_as_sc_mcu7t3v3__inv_2_997/Y gf180mcu_as_sc_mcu7t3v3__inv_2_997/A
+ gf180mcu_as_sc_mcu7t3v3__inv_2_997/VNW VSUBS gf180mcu_as_sc_mcu7t3v3__inv_2
Xgf180mcu_as_sc_mcu7t3v3__inv_2_975 VSS VSS gf180mcu_as_sc_mcu7t3v3__inv_2_975/Y gf180mcu_as_sc_mcu7t3v3__inv_2_976/Y
+ gf180mcu_as_sc_mcu7t3v3__inv_2_976/VNW VSUBS gf180mcu_as_sc_mcu7t3v3__inv_2
Xgf180mcu_as_sc_mcu7t3v3__inv_2_931 VSS VSS VSS gf180mcu_as_sc_mcu7t3v3__inv_2_931/A
+ gf180mcu_as_sc_mcu7t3v3__inv_2_931/VNW VSUBS gf180mcu_as_sc_mcu7t3v3__inv_2
Xgf180mcu_as_sc_mcu7t3v3__inv_2_964 VSS VSS gf180mcu_as_sc_mcu7t3v3__inv_2_964/Y gf180mcu_as_sc_mcu7t3v3__inv_2_964/A
+ gf180mcu_as_sc_mcu7t3v3__inv_2_964/VNW VSUBS gf180mcu_as_sc_mcu7t3v3__inv_2
Xgf180mcu_as_sc_mcu7t3v3__inv_2_942 VSS VSS VSS gf180mcu_as_sc_mcu7t3v3__inv_2_942/A
+ gf180mcu_as_sc_mcu7t3v3__inv_2_942/VNW VSUBS gf180mcu_as_sc_mcu7t3v3__inv_2
Xgf180mcu_as_sc_mcu7t3v3__nand4_2_285 VSS VSS VSS VSS VSS VSS gf180mcu_as_sc_mcu7t3v3__inv_2_1012/A
+ gf180mcu_as_sc_mcu7t3v3__inv_2_1012/VNW VSUBS gf180mcu_as_sc_mcu7t3v3__nand4_2
Xgf180mcu_as_sc_mcu7t3v3__nand4_2_274 VSS VSS VSS VSS VSS VSS gf180mcu_as_sc_mcu7t3v3__inv_2_908/A
+ gf180mcu_as_sc_mcu7t3v3__inv_2_953/VNW VSUBS gf180mcu_as_sc_mcu7t3v3__nand4_2
Xgf180mcu_as_sc_mcu7t3v3__nand4_2_230 VSS VSS VSS VSS VSS VSS gf180mcu_as_sc_mcu7t3v3__inv_2_781/A
+ gf180mcu_as_sc_mcu7t3v3__inv_2_851/VNW VSUBS gf180mcu_as_sc_mcu7t3v3__nand4_2
Xgf180mcu_as_sc_mcu7t3v3__nand4_2_241 VSS VSS VSS VSS VSS VSS gf180mcu_as_sc_mcu7t3v3__inv_2_803/A
+ gf180mcu_as_sc_mcu7t3v3__inv_2_837/VNW VSUBS gf180mcu_as_sc_mcu7t3v3__nand4_2
Xgf180mcu_as_sc_mcu7t3v3__nand4_2_296 VSS VSS VSS VSS VSS VSS gf180mcu_as_sc_mcu7t3v3__inv_2_960/A
+ gf180mcu_as_sc_mcu7t3v3__inv_2_960/VNW VSUBS gf180mcu_as_sc_mcu7t3v3__nand4_2
Xgf180mcu_as_sc_mcu7t3v3__nand4_2_252 VSS VSS VSS VSS VSS VSS gf180mcu_as_sc_mcu7t3v3__inv_2_864/A
+ gf180mcu_as_sc_mcu7t3v3__inv_2_938/VNW VSUBS gf180mcu_as_sc_mcu7t3v3__nand4_2
Xgf180mcu_as_sc_mcu7t3v3__nand4_2_263 VSS VSS VSS VSS VSS VSS gf180mcu_as_sc_mcu7t3v3__inv_2_885/A
+ gf180mcu_as_sc_mcu7t3v3__inv_2_934/VNW VSUBS gf180mcu_as_sc_mcu7t3v3__nand4_2
Xgf180mcu_as_sc_mcu7t3v3__inv_2_205 VSS VSS gf180mcu_as_sc_mcu7t3v3__inv_2_205/Y gf180mcu_as_sc_mcu7t3v3__inv_2_206/Y
+ gf180mcu_as_sc_mcu7t3v3__inv_2_206/VNW VSUBS gf180mcu_as_sc_mcu7t3v3__inv_2
Xgf180mcu_as_sc_mcu7t3v3__inv_2_227 VSS VSS gf180mcu_as_sc_mcu7t3v3__inv_2_227/Y gf180mcu_as_sc_mcu7t3v3__inv_2_227/A
+ gf180mcu_as_sc_mcu7t3v3__inv_2_227/VNW VSUBS gf180mcu_as_sc_mcu7t3v3__inv_2
Xgf180mcu_as_sc_mcu7t3v3__inv_2_216 VSS VSS VSS gf180mcu_as_sc_mcu7t3v3__inv_2_217/Y
+ gf180mcu_as_sc_mcu7t3v3__inv_2_218/VNW VSUBS gf180mcu_as_sc_mcu7t3v3__inv_2
Xgf180mcu_as_sc_mcu7t3v3__inv_2_249 VSS VSS VSS gf180mcu_as_sc_mcu7t3v3__inv_2_250/Y
+ gf180mcu_as_sc_mcu7t3v3__inv_2_251/VNW VSUBS gf180mcu_as_sc_mcu7t3v3__inv_2
Xgf180mcu_as_sc_mcu7t3v3__inv_2_238 VSS VSS gf180mcu_as_sc_mcu7t3v3__inv_2_238/Y gf180mcu_as_sc_mcu7t3v3__inv_2_239/Y
+ gf180mcu_as_sc_mcu7t3v3__inv_2_239/VNW VSUBS gf180mcu_as_sc_mcu7t3v3__inv_2
Xu_t000_013 u_t000_013/c0_w0_bl u_t000_013/c0_w0_br u_t000_013/c0_w1_bl u_t000_013/c0_w1_br
+ u_t000_013/c0_r0_rbl u_t000_013/c0_r1_rbl u_t000_013/c1_w0_bl u_t000_013/c1_w0_br
+ u_t000_013/c1_w1_bl u_t000_013/c1_w1_br u_t000_013/c1_r0_rbl u_t000_013/c1_r1_rbl
+ u_t000_013/c2_w0_bl u_t000_013/c2_w0_br u_t000_013/c2_w1_bl u_t000_013/c2_w1_br
+ u_t000_013/c2_r0_rbl u_t000_013/c2_r1_rbl u_t000_013/c3_w0_bl u_t000_013/c3_w0_br
+ u_t000_013/c3_w1_bl u_t000_013/c3_w1_br u_t000_013/c3_r0_rbl u_t000_013/c3_r1_rbl
+ u_t000_013/r0_w0_wl u_t000_013/r0_w1_wl u_t000_013/r0_r0_rwl u_t000_013/r0_r1_rwl
+ u_t000_013/r1_w0_wl u_t000_013/r1_w1_wl u_t000_013/r1_r0_rwl u_t000_013/r1_r1_rwl
+ u_t000_013/r2_w0_wl u_t000_013/r2_w1_wl u_t000_013/r2_r0_rwl u_t000_013/r2_r1_rwl
+ u_t000_013/r3_w0_wl u_t000_013/r3_w1_wl u_t000_013/r3_r0_rwl u_t000_013/r3_r1_rwl
+ VSS VSS u_t000_013/m2_717_1265# u_t000_013/m2_603_2031# u_t000_013/m2_1290_336#
+ u_t000_013/m2_2000_2037# u_t000_013/m2_791_2909# u_t000_013/m2_7_2126# u_t000_013/m2_2154_2081#
+ u_t000_013/m2_1795_2037# u_t000_013/m2_871_303# u_t000_013/m2_431_438# u_t000_013/m2_1290_2898#
+ u_t000_013/m2_1714_1210# u_t000_013/m2_431_1982# u_t000_013/m2_512_1265# u_t000_013/m2_2573_2126#
+ u_t000_013/m2_603_1259# u_t000_013/m2_2074_2909# u_t000_013/m2_7_336# u_t000_013/m2_717_2037#
+ u_t000_013/m2_1886_2031# u_t000_013/m2_2573_336# u_t000_013/m2_7_2898# u_t000_013/m2_2000_1265#
+ u_t000_013/m2_512_2037# u_t000_013/m2_1795_1265# u_t000_013/m2_1714_1982# u_t000_013/m2_1886_1259#
+ u_t000_013/m2_1290_2126# u_t000_013/m2_1714_438# u_t000_013/m2_431_1210# u_t000_013/m2_2573_2898#
+ u_t000_013/m2_2154_303# u_t000_013/m2_871_2081# VSUBS detronyx_12t_2w2r_rc4_4x4_routed_5layer_direct
Xu_t000_002 u_t000_002/c0_w0_bl u_t000_002/c0_w0_br u_t000_002/c0_w1_bl u_t000_002/c0_w1_br
+ u_t000_002/c0_r0_rbl u_t000_002/c0_r1_rbl u_t000_002/c1_w0_bl u_t000_002/c1_w0_br
+ u_t000_002/c1_w1_bl u_t000_002/c1_w1_br u_t000_002/c1_r0_rbl u_t000_002/c1_r1_rbl
+ u_t000_002/c2_w0_bl u_t000_002/c2_w0_br u_t000_002/c2_w1_bl u_t000_002/c2_w1_br
+ u_t000_002/c2_r0_rbl u_t000_002/c2_r1_rbl u_t000_002/c3_w0_bl u_t000_002/c3_w0_br
+ u_t000_002/c3_w1_bl u_t000_002/c3_w1_br u_t000_002/c3_r0_rbl u_t000_002/c3_r1_rbl
+ u_t000_002/r0_w0_wl u_t000_002/r0_w1_wl u_t000_002/r0_r0_rwl u_t000_002/r0_r1_rwl
+ u_t000_002/r1_w0_wl u_t000_002/r1_w1_wl u_t000_002/r1_r0_rwl u_t000_002/r1_r1_rwl
+ u_t000_002/r2_w0_wl u_t000_002/r2_w1_wl u_t000_002/r2_r0_rwl u_t000_002/r2_r1_rwl
+ u_t000_002/r3_w0_wl u_t000_002/r3_w1_wl u_t000_002/r3_r0_rwl u_t000_002/r3_r1_rwl
+ VSS VSS u_t000_002/m2_717_1265# u_t000_002/m2_603_2031# u_t000_002/m2_1290_336#
+ u_t000_002/m2_2000_2037# u_t000_002/m2_791_2909# u_t000_002/m2_7_2126# u_t000_002/m2_2154_2081#
+ u_t000_002/m2_1795_2037# u_t000_002/m2_871_303# u_t000_002/m2_431_438# u_t000_002/m2_1290_2898#
+ u_t000_002/m2_1714_1210# u_t000_002/m2_431_1982# u_t000_002/m2_512_1265# u_t000_002/m2_2573_2126#
+ u_t000_002/m2_603_1259# u_t000_002/m2_2074_2909# u_t000_002/m2_7_336# u_t000_002/m2_717_2037#
+ u_t000_002/m2_1886_2031# u_t000_002/m2_2573_336# u_t000_002/m2_7_2898# u_t000_002/m2_2000_1265#
+ u_t000_002/m2_512_2037# u_t000_002/m2_1795_1265# u_t000_002/m2_1714_1982# u_t000_002/m2_1886_1259#
+ u_t000_002/m2_1290_2126# u_t000_002/m2_1714_438# u_t000_002/m2_431_1210# u_t000_002/m2_2573_2898#
+ u_t000_002/m2_2154_303# u_t000_002/m2_871_2081# VSUBS detronyx_12t_2w2r_rc4_4x4_routed_5layer_direct
Xgf180mcu_as_sc_mcu7t3v3__inv_2_772 VSS VSS gf180mcu_as_sc_mcu7t3v3__inv_2_825/A gf180mcu_as_sc_mcu7t3v3__inv_2_773/Y
+ gf180mcu_as_sc_mcu7t3v3__inv_2_825/VNW VSUBS gf180mcu_as_sc_mcu7t3v3__inv_2
Xgf180mcu_as_sc_mcu7t3v3__inv_2_761 VSS VSS gf180mcu_as_sc_mcu7t3v3__inv_2_821/A gf180mcu_as_sc_mcu7t3v3__inv_2_762/Y
+ gf180mcu_as_sc_mcu7t3v3__inv_2_821/VNW VSUBS gf180mcu_as_sc_mcu7t3v3__inv_2
Xgf180mcu_as_sc_mcu7t3v3__inv_2_750 VSS VSS gf180mcu_as_sc_mcu7t3v3__inv_2_830/A gf180mcu_as_sc_mcu7t3v3__inv_2_751/Y
+ gf180mcu_as_sc_mcu7t3v3__inv_2_830/VNW VSUBS gf180mcu_as_sc_mcu7t3v3__inv_2
Xgf180mcu_as_sc_mcu7t3v3__inv_2_783 VSS VSS gf180mcu_as_sc_mcu7t3v3__inv_2_783/Y gf180mcu_as_sc_mcu7t3v3__inv_2_783/A
+ gf180mcu_as_sc_mcu7t3v3__inv_2_815/VNW VSUBS gf180mcu_as_sc_mcu7t3v3__inv_2
Xgf180mcu_as_sc_mcu7t3v3__inv_2_794 VSS VSS gf180mcu_as_sc_mcu7t3v3__inv_2_845/A gf180mcu_as_sc_mcu7t3v3__inv_2_795/Y
+ gf180mcu_as_sc_mcu7t3v3__inv_2_845/VNW VSUBS gf180mcu_as_sc_mcu7t3v3__inv_2
Xgf180mcu_as_sc_mcu7t3v3__inv_2_591 VSS VSS gf180mcu_as_sc_mcu7t3v3__inv_2_607/A gf180mcu_as_sc_mcu7t3v3__inv_2_592/Y
+ gf180mcu_as_sc_mcu7t3v3__inv_2_607/VNW VSUBS gf180mcu_as_sc_mcu7t3v3__inv_2
Xgf180mcu_as_sc_mcu7t3v3__inv_2_580 VSS VSS gf180mcu_as_sc_mcu7t3v3__inv_2_581/A gf180mcu_as_sc_mcu7t3v3__inv_2_580/A
+ gf180mcu_as_sc_mcu7t3v3__inv_2_585/VNW VSUBS gf180mcu_as_sc_mcu7t3v3__inv_2
Xgf180mcu_as_sc_mcu7t3v3__nor2_2_6 gf180mcu_as_sc_mcu7t3v3__nor2_2_6/VDD gf180mcu_as_sc_mcu7t3v3__nor2_2_6/VSS
+ VSS VSS VSS gf180mcu_as_sc_mcu7t3v3__nor2_2_6/VNW VSUBS gf180mcu_as_sc_mcu7t3v3__nor2_2
Xgf180mcu_as_sc_mcu7t3v3__inv_2_1309 VSS VSS VSS gf180mcu_as_sc_mcu7t3v3__inv_2_1313/Y
+ gf180mcu_as_sc_mcu7t3v3__inv_2_1317/VNW VSUBS gf180mcu_as_sc_mcu7t3v3__inv_2
Xu_t028_005 u_t028_005/c0_w0_bl u_t028_005/c0_w0_br u_t028_005/c0_w1_bl u_t028_005/c0_w1_br
+ u_t028_005/c0_r0_rbl u_t028_005/c0_r1_rbl u_t028_005/c1_w0_bl u_t028_005/c1_w0_br
+ u_t028_005/c1_w1_bl u_t028_005/c1_w1_br u_t028_005/c1_r0_rbl u_t028_005/c1_r1_rbl
+ u_t028_005/c2_w0_bl u_t028_005/c2_w0_br u_t028_005/c2_w1_bl u_t028_005/c2_w1_br
+ u_t028_005/c2_r0_rbl u_t028_005/c2_r1_rbl u_t028_005/c3_w0_bl u_t028_005/c3_w0_br
+ u_t028_005/c3_w1_bl u_t028_005/c3_w1_br u_t028_005/c3_r0_rbl u_t028_005/c3_r1_rbl
+ u_t028_005/r0_w0_wl u_t028_005/r0_w1_wl u_t028_005/r0_r0_rwl u_t028_005/r0_r1_rwl
+ u_t028_005/r1_w0_wl u_t028_005/r1_w1_wl u_t028_005/r1_r0_rwl u_t028_005/r1_r1_rwl
+ u_t028_005/r2_w0_wl u_t028_005/r2_w1_wl u_t028_005/r2_r0_rwl u_t028_005/r2_r1_rwl
+ u_t028_005/r3_w0_wl u_t028_005/r3_w1_wl u_t028_005/r3_r0_rwl u_t028_005/r3_r1_rwl
+ VSS VSS u_t028_005/m2_717_1265# u_t028_005/m2_603_2031# u_t028_005/m2_1290_336#
+ u_t028_005/m2_2000_2037# u_t028_005/m2_791_2909# u_t028_005/m2_7_2126# u_t028_005/m2_2154_2081#
+ u_t028_005/m2_1795_2037# u_t028_005/m2_871_303# u_t028_005/m2_431_438# u_t028_005/m2_1290_2898#
+ u_t028_005/m2_1714_1210# u_t028_005/m2_431_1982# u_t028_005/m2_512_1265# u_t028_005/m2_2573_2126#
+ u_t028_005/m2_603_1259# u_t028_005/m2_2074_2909# u_t028_005/m2_7_336# u_t028_005/m2_717_2037#
+ u_t028_005/m2_1886_2031# u_t028_005/m2_2573_336# u_t028_005/m2_7_2898# u_t028_005/m2_2000_1265#
+ u_t028_005/m2_512_2037# u_t028_005/m2_1795_1265# u_t028_005/m2_1714_1982# u_t028_005/m2_1886_1259#
+ u_t028_005/m2_1290_2126# u_t028_005/m2_1714_438# u_t028_005/m2_431_1210# u_t028_005/m2_2573_2898#
+ u_t028_005/m2_2154_303# u_t028_005/m2_871_2081# VSUBS detronyx_12t_2w2r_rc4_4x4_routed_5layer_direct
Xu_t019_005 u_t019_005/c0_w0_bl u_t019_005/c0_w0_br u_t019_005/c0_w1_bl u_t019_005/c0_w1_br
+ u_t019_005/c0_r0_rbl u_t019_005/c0_r1_rbl u_t019_005/c1_w0_bl u_t019_005/c1_w0_br
+ u_t019_005/c1_w1_bl u_t019_005/c1_w1_br u_t019_005/c1_r0_rbl u_t019_005/c1_r1_rbl
+ u_t019_005/c2_w0_bl u_t019_005/c2_w0_br u_t019_005/c2_w1_bl u_t019_005/c2_w1_br
+ u_t019_005/c2_r0_rbl u_t019_005/c2_r1_rbl u_t019_005/c3_w0_bl u_t019_005/c3_w0_br
+ u_t019_005/c3_w1_bl u_t019_005/c3_w1_br u_t019_005/c3_r0_rbl u_t019_005/c3_r1_rbl
+ u_t019_005/r0_w0_wl u_t019_005/r0_w1_wl u_t019_005/r0_r0_rwl u_t019_005/r0_r1_rwl
+ u_t019_005/r1_w0_wl u_t019_005/r1_w1_wl u_t019_005/r1_r0_rwl u_t019_005/r1_r1_rwl
+ u_t019_005/r2_w0_wl u_t019_005/r2_w1_wl u_t019_005/r2_r0_rwl u_t019_005/r2_r1_rwl
+ u_t019_005/r3_w0_wl u_t019_005/r3_w1_wl u_t019_005/r3_r0_rwl u_t019_005/r3_r1_rwl
+ VSS VSS u_t019_005/m2_717_1265# u_t019_005/m2_603_2031# u_t019_005/m2_1290_336#
+ u_t019_005/m2_2000_2037# u_t019_005/m2_791_2909# u_t019_005/m2_7_2126# u_t019_005/m2_2154_2081#
+ u_t019_005/m2_1795_2037# u_t019_005/m2_871_303# u_t019_005/m2_431_438# u_t019_005/m2_1290_2898#
+ u_t019_005/m2_1714_1210# u_t019_005/m2_431_1982# u_t019_005/m2_512_1265# u_t019_005/m2_2573_2126#
+ u_t019_005/m2_603_1259# u_t019_005/m2_2074_2909# u_t019_005/m2_7_336# u_t019_005/m2_717_2037#
+ u_t019_005/m2_1886_2031# u_t019_005/m2_2573_336# u_t019_005/m2_7_2898# u_t019_005/m2_2000_1265#
+ u_t019_005/m2_512_2037# u_t019_005/m2_1795_1265# u_t019_005/m2_1714_1982# u_t019_005/m2_1886_1259#
+ u_t019_005/m2_1290_2126# u_t019_005/m2_1714_438# u_t019_005/m2_431_1210# u_t019_005/m2_2573_2898#
+ u_t019_005/m2_2154_303# u_t019_005/m2_871_2081# VSUBS detronyx_12t_2w2r_rc4_4x4_routed_5layer_direct
Xu_t025_008 u_t025_008/c0_w0_bl u_t025_008/c0_w0_br u_t025_008/c0_w1_bl u_t025_008/c0_w1_br
+ u_t025_008/c0_r0_rbl u_t025_008/c0_r1_rbl u_t025_008/c1_w0_bl u_t025_008/c1_w0_br
+ u_t025_008/c1_w1_bl u_t025_008/c1_w1_br u_t025_008/c1_r0_rbl u_t025_008/c1_r1_rbl
+ u_t025_008/c2_w0_bl u_t025_008/c2_w0_br u_t025_008/c2_w1_bl u_t025_008/c2_w1_br
+ u_t025_008/c2_r0_rbl u_t025_008/c2_r1_rbl u_t025_008/c3_w0_bl u_t025_008/c3_w0_br
+ u_t025_008/c3_w1_bl u_t025_008/c3_w1_br u_t025_008/c3_r0_rbl u_t025_008/c3_r1_rbl
+ u_t025_008/r0_w0_wl u_t025_008/r0_w1_wl u_t025_008/r0_r0_rwl u_t025_008/r0_r1_rwl
+ u_t025_008/r1_w0_wl u_t025_008/r1_w1_wl u_t025_008/r1_r0_rwl u_t025_008/r1_r1_rwl
+ u_t025_008/r2_w0_wl u_t025_008/r2_w1_wl u_t025_008/r2_r0_rwl u_t025_008/r2_r1_rwl
+ u_t025_008/r3_w0_wl u_t025_008/r3_w1_wl u_t025_008/r3_r0_rwl u_t025_008/r3_r1_rwl
+ VSS VSS u_t025_008/m2_717_1265# u_t025_008/m2_603_2031# u_t025_008/m2_1290_336#
+ u_t025_008/m2_2000_2037# u_t025_008/m2_791_2909# u_t025_008/m2_7_2126# u_t025_008/m2_2154_2081#
+ u_t025_008/m2_1795_2037# u_t025_008/m2_871_303# u_t025_008/m2_431_438# u_t025_008/m2_1290_2898#
+ u_t025_008/m2_1714_1210# u_t025_008/m2_431_1982# u_t025_008/m2_512_1265# u_t025_008/m2_2573_2126#
+ u_t025_008/m2_603_1259# u_t025_008/m2_2074_2909# u_t025_008/m2_7_336# u_t025_008/m2_717_2037#
+ u_t025_008/m2_1886_2031# u_t025_008/m2_2573_336# u_t025_008/m2_7_2898# u_t025_008/m2_2000_1265#
+ u_t025_008/m2_512_2037# u_t025_008/m2_1795_1265# u_t025_008/m2_1714_1982# u_t025_008/m2_1886_1259#
+ u_t025_008/m2_1290_2126# u_t025_008/m2_1714_438# u_t025_008/m2_431_1210# u_t025_008/m2_2573_2898#
+ u_t025_008/m2_2154_303# u_t025_008/m2_871_2081# VSUBS detronyx_12t_2w2r_rc4_4x4_routed_5layer_direct
Xgf180mcu_as_sc_mcu7t3v3__inv_2_1128 VSS VSS gf180mcu_as_sc_mcu7t3v3__inv_2_1128/Y
+ gf180mcu_as_sc_mcu7t3v3__inv_2_1129/Y gf180mcu_as_sc_mcu7t3v3__inv_2_1129/VNW VSUBS
+ gf180mcu_as_sc_mcu7t3v3__inv_2
Xgf180mcu_as_sc_mcu7t3v3__inv_2_1139 VSS VSS gf180mcu_as_sc_mcu7t3v3__inv_2_1139/Y
+ gf180mcu_as_sc_mcu7t3v3__inv_2_1139/A gf180mcu_as_sc_mcu7t3v3__inv_2_1139/VNW VSUBS
+ gf180mcu_as_sc_mcu7t3v3__inv_2
Xgf180mcu_as_sc_mcu7t3v3__inv_2_1117 VSS VSS gf180mcu_as_sc_mcu7t3v3__inv_2_1117/Y
+ gf180mcu_as_sc_mcu7t3v3__inv_2_1118/Y gf180mcu_as_sc_mcu7t3v3__inv_2_1118/VNW VSUBS
+ gf180mcu_as_sc_mcu7t3v3__inv_2
Xgf180mcu_as_sc_mcu7t3v3__inv_2_1106 VSS VSS gf180mcu_as_sc_mcu7t3v3__inv_2_1106/Y
+ gf180mcu_as_sc_mcu7t3v3__inv_2_1107/Y gf180mcu_as_sc_mcu7t3v3__inv_2_1107/VNW VSUBS
+ gf180mcu_as_sc_mcu7t3v3__inv_2
Xu_t016_008 u_t016_008/c0_w0_bl u_t016_008/c0_w0_br u_t016_008/c0_w1_bl u_t016_008/c0_w1_br
+ u_t016_008/c0_r0_rbl u_t016_008/c0_r1_rbl u_t016_008/c1_w0_bl u_t016_008/c1_w0_br
+ u_t016_008/c1_w1_bl u_t016_008/c1_w1_br u_t016_008/c1_r0_rbl u_t016_008/c1_r1_rbl
+ u_t016_008/c2_w0_bl u_t016_008/c2_w0_br u_t016_008/c2_w1_bl u_t016_008/c2_w1_br
+ u_t016_008/c2_r0_rbl u_t016_008/c2_r1_rbl u_t016_008/c3_w0_bl u_t016_008/c3_w0_br
+ u_t016_008/c3_w1_bl u_t016_008/c3_w1_br u_t016_008/c3_r0_rbl u_t016_008/c3_r1_rbl
+ u_t016_008/r0_w0_wl u_t016_008/r0_w1_wl u_t016_008/r0_r0_rwl u_t016_008/r0_r1_rwl
+ u_t016_008/r1_w0_wl u_t016_008/r1_w1_wl u_t016_008/r1_r0_rwl u_t016_008/r1_r1_rwl
+ u_t016_008/r2_w0_wl u_t016_008/r2_w1_wl u_t016_008/r2_r0_rwl u_t016_008/r2_r1_rwl
+ u_t016_008/r3_w0_wl u_t016_008/r3_w1_wl u_t016_008/r3_r0_rwl u_t016_008/r3_r1_rwl
+ VSS VSS u_t016_008/m2_717_1265# u_t016_008/m2_603_2031# u_t016_008/m2_1290_336#
+ u_t016_008/m2_2000_2037# u_t016_008/m2_791_2909# u_t016_008/m2_7_2126# u_t016_008/m2_2154_2081#
+ u_t016_008/m2_1795_2037# u_t016_008/m2_871_303# u_t016_008/m2_431_438# u_t016_008/m2_1290_2898#
+ u_t016_008/m2_1714_1210# u_t016_008/m2_431_1982# u_t016_008/m2_512_1265# u_t016_008/m2_2573_2126#
+ u_t016_008/m2_603_1259# u_t016_008/m2_2074_2909# u_t016_008/m2_7_336# u_t016_008/m2_717_2037#
+ u_t016_008/m2_1886_2031# u_t016_008/m2_2573_336# u_t016_008/m2_7_2898# u_t016_008/m2_2000_1265#
+ u_t016_008/m2_512_2037# u_t016_008/m2_1795_1265# u_t016_008/m2_1714_1982# u_t016_008/m2_1886_1259#
+ u_t016_008/m2_1290_2126# u_t016_008/m2_1714_438# u_t016_008/m2_431_1210# u_t016_008/m2_2573_2898#
+ u_t016_008/m2_2154_303# u_t016_008/m2_871_2081# VSUBS detronyx_12t_2w2r_rc4_4x4_routed_5layer_direct
Xgf180mcu_as_sc_mcu7t3v3__nand3_2_53 gf180mcu_as_sc_mcu7t3v3__nor2_2_9/VDD gf180mcu_as_sc_mcu7t3v3__nand3_2_63/VSS
+ VSS VSS VSS VSS gf180mcu_as_sc_mcu7t3v3__nor2_2_9/VNW VSUBS gf180mcu_as_sc_mcu7t3v3__nand3_2
Xgf180mcu_as_sc_mcu7t3v3__nand3_2_64 gf180mcu_as_sc_mcu7t3v3__nor2_2_9/VDD gf180mcu_as_sc_mcu7t3v3__nor2_2_9/VSS
+ VSS VSS VSS VSS gf180mcu_as_sc_mcu7t3v3__nor2_2_9/VNW VSUBS gf180mcu_as_sc_mcu7t3v3__nand3_2
Xgf180mcu_as_sc_mcu7t3v3__nand3_2_20 gf180mcu_as_sc_mcu7t3v3__nor2_2_4/VDD gf180mcu_as_sc_mcu7t3v3__nand2_2_3/VSS
+ VSS VSS VSS VSS gf180mcu_as_sc_mcu7t3v3__nor2_2_4/VNW VSUBS gf180mcu_as_sc_mcu7t3v3__nand3_2
Xgf180mcu_as_sc_mcu7t3v3__nand3_2_42 gf180mcu_as_sc_mcu7t3v3__nor2_2_4/VDD gf180mcu_as_sc_mcu7t3v3__nand2_2_3/VSS
+ VSS VSS VSS VSS gf180mcu_as_sc_mcu7t3v3__nor2_2_4/VNW VSUBS gf180mcu_as_sc_mcu7t3v3__nand3_2
Xgf180mcu_as_sc_mcu7t3v3__nand3_2_31 gf180mcu_as_sc_mcu7t3v3__nor2_2_7/VDD gf180mcu_as_sc_mcu7t3v3__nor2_2_7/VSS
+ VSS VSS VSS VSS gf180mcu_as_sc_mcu7t3v3__nor2_2_7/VNW VSUBS gf180mcu_as_sc_mcu7t3v3__nand3_2
Xgf180mcu_as_sc_mcu7t3v3__inv_2_1640 VSS VSS VSS gf180mcu_as_sc_mcu7t3v3__inv_2_1641/Y
+ gf180mcu_as_sc_mcu7t3v3__inv_2_1642/VNW VSUBS gf180mcu_as_sc_mcu7t3v3__inv_2
Xgf180mcu_as_sc_mcu7t3v3__inv_2_1673 VSS VSS VSS gf180mcu_as_sc_mcu7t3v3__inv_2_1677/Y
+ gf180mcu_as_sc_mcu7t3v3__inv_2_1681/VNW VSUBS gf180mcu_as_sc_mcu7t3v3__inv_2
Xgf180mcu_as_sc_mcu7t3v3__inv_2_1651 VSS VSS gf180mcu_as_sc_mcu7t3v3__inv_2_1651/Y
+ gf180mcu_as_sc_mcu7t3v3__inv_2_1652/Y gf180mcu_as_sc_mcu7t3v3__inv_2_1652/VNW VSUBS
+ gf180mcu_as_sc_mcu7t3v3__inv_2
Xgf180mcu_as_sc_mcu7t3v3__inv_2_1662 VSS VSS VSS gf180mcu_as_sc_mcu7t3v3__inv_2_1663/Y
+ gf180mcu_as_sc_mcu7t3v3__inv_2_1664/VNW VSUBS gf180mcu_as_sc_mcu7t3v3__inv_2
Xgf180mcu_as_sc_mcu7t3v3__inv_2_1684 VSS VSS gf180mcu_as_sc_mcu7t3v3__inv_2_1684/Y
+ gf180mcu_as_sc_mcu7t3v3__inv_2_1684/A gf180mcu_as_sc_mcu7t3v3__inv_2_1684/VNW VSUBS
+ gf180mcu_as_sc_mcu7t3v3__inv_2
Xgf180mcu_as_sc_mcu7t3v3__inv_2_1695 VSS VSS VSS gf180mcu_as_sc_mcu7t3v3__inv_2_1696/Y
+ gf180mcu_as_sc_mcu7t3v3__inv_2_1697/VNW VSUBS gf180mcu_as_sc_mcu7t3v3__inv_2
Xu_t007_008 u_t007_008/c0_w0_bl u_t007_008/c0_w0_br u_t007_008/c0_w1_bl u_t007_008/c0_w1_br
+ u_t007_008/c0_r0_rbl u_t007_008/c0_r1_rbl u_t007_008/c1_w0_bl u_t007_008/c1_w0_br
+ u_t007_008/c1_w1_bl u_t007_008/c1_w1_br u_t007_008/c1_r0_rbl u_t007_008/c1_r1_rbl
+ u_t007_008/c2_w0_bl u_t007_008/c2_w0_br u_t007_008/c2_w1_bl u_t007_008/c2_w1_br
+ u_t007_008/c2_r0_rbl u_t007_008/c2_r1_rbl u_t007_008/c3_w0_bl u_t007_008/c3_w0_br
+ u_t007_008/c3_w1_bl u_t007_008/c3_w1_br u_t007_008/c3_r0_rbl u_t007_008/c3_r1_rbl
+ u_t007_008/r0_w0_wl u_t007_008/r0_w1_wl u_t007_008/r0_r0_rwl u_t007_008/r0_r1_rwl
+ u_t007_008/r1_w0_wl u_t007_008/r1_w1_wl u_t007_008/r1_r0_rwl u_t007_008/r1_r1_rwl
+ u_t007_008/r2_w0_wl u_t007_008/r2_w1_wl u_t007_008/r2_r0_rwl u_t007_008/r2_r1_rwl
+ u_t007_008/r3_w0_wl u_t007_008/r3_w1_wl u_t007_008/r3_r0_rwl u_t007_008/r3_r1_rwl
+ VSS VSS u_t007_008/m2_717_1265# u_t007_008/m2_603_2031# u_t007_008/m2_1290_336#
+ u_t007_008/m2_2000_2037# u_t007_008/m2_791_2909# u_t007_008/m2_7_2126# u_t007_008/m2_2154_2081#
+ u_t007_008/m2_1795_2037# u_t007_008/m2_871_303# u_t007_008/m2_431_438# u_t007_008/m2_1290_2898#
+ u_t007_008/m2_1714_1210# u_t007_008/m2_431_1982# u_t007_008/m2_512_1265# u_t007_008/m2_2573_2126#
+ u_t007_008/m2_603_1259# u_t007_008/m2_2074_2909# u_t007_008/m2_7_336# u_t007_008/m2_717_2037#
+ u_t007_008/m2_1886_2031# u_t007_008/m2_2573_336# u_t007_008/m2_7_2898# u_t007_008/m2_2000_1265#
+ u_t007_008/m2_512_2037# u_t007_008/m2_1795_1265# u_t007_008/m2_1714_1982# u_t007_008/m2_1886_1259#
+ u_t007_008/m2_1290_2126# u_t007_008/m2_1714_438# u_t007_008/m2_431_1210# u_t007_008/m2_2573_2898#
+ u_t007_008/m2_2154_303# u_t007_008/m2_871_2081# VSUBS detronyx_12t_2w2r_rc4_4x4_routed_5layer_direct
Xu_t030_011 u_t030_011/c0_w0_bl u_t030_011/c0_w0_br u_t030_011/c0_w1_bl u_t030_011/c0_w1_br
+ u_t030_011/c0_r0_rbl u_t030_011/c0_r1_rbl u_t030_011/c1_w0_bl u_t030_011/c1_w0_br
+ u_t030_011/c1_w1_bl u_t030_011/c1_w1_br u_t030_011/c1_r0_rbl u_t030_011/c1_r1_rbl
+ u_t030_011/c2_w0_bl u_t030_011/c2_w0_br u_t030_011/c2_w1_bl u_t030_011/c2_w1_br
+ u_t030_011/c2_r0_rbl u_t030_011/c2_r1_rbl u_t030_011/c3_w0_bl u_t030_011/c3_w0_br
+ u_t030_011/c3_w1_bl u_t030_011/c3_w1_br u_t030_011/c3_r0_rbl u_t030_011/c3_r1_rbl
+ u_t030_011/r0_w0_wl u_t030_011/r0_w1_wl u_t030_011/r0_r0_rwl u_t030_011/r0_r1_rwl
+ u_t030_011/r1_w0_wl u_t030_011/r1_w1_wl u_t030_011/r1_r0_rwl u_t030_011/r1_r1_rwl
+ u_t030_011/r2_w0_wl u_t030_011/r2_w1_wl u_t030_011/r2_r0_rwl u_t030_011/r2_r1_rwl
+ u_t030_011/r3_w0_wl u_t030_011/r3_w1_wl u_t030_011/r3_r0_rwl u_t030_011/r3_r1_rwl
+ VSS VSS u_t030_011/m2_717_1265# u_t030_011/m2_603_2031# u_t030_011/m2_1290_336#
+ u_t030_011/m2_2000_2037# u_t030_011/m2_791_2909# u_t030_011/m2_7_2126# u_t030_011/m2_2154_2081#
+ u_t030_011/m2_1795_2037# u_t030_011/m2_871_303# u_t030_011/m2_431_438# u_t030_011/m2_1290_2898#
+ u_t030_011/m2_1714_1210# u_t030_011/m2_431_1982# u_t030_011/m2_512_1265# u_t030_011/m2_2573_2126#
+ u_t030_011/m2_603_1259# u_t030_011/m2_2074_2909# u_t030_011/m2_7_336# u_t030_011/m2_717_2037#
+ u_t030_011/m2_1886_2031# u_t030_011/m2_2573_336# u_t030_011/m2_7_2898# u_t030_011/m2_2000_1265#
+ u_t030_011/m2_512_2037# u_t030_011/m2_1795_1265# u_t030_011/m2_1714_1982# u_t030_011/m2_1886_1259#
+ u_t030_011/m2_1290_2126# u_t030_011/m2_1714_438# u_t030_011/m2_431_1210# u_t030_011/m2_2573_2898#
+ u_t030_011/m2_2154_303# u_t030_011/m2_871_2081# VSUBS detronyx_12t_2w2r_rc4_4x4_routed_5layer_direct
Xu_t030_000 VSS u_t030_000/c0_w0_br VSS u_t030_000/c0_w1_br u_t030_000/c0_r0_rbl u_t030_000/c0_r1_rbl
+ VSS VSS VSS VSS VSS VSS u_t030_000/c2_w0_bl u_t030_000/c2_w0_br u_t030_000/c2_w1_bl
+ u_t030_000/c2_w1_br u_t030_000/c2_r0_rbl u_t030_000/c2_r1_rbl u_t030_000/c3_w0_bl
+ u_t030_000/c3_w0_br u_t030_000/c3_w1_bl u_t030_000/c3_w1_br u_t030_000/c3_r0_rbl
+ u_t030_000/c3_r1_rbl VSS VSS VSS VSS VSS VSS VSS VSS VSS VSS VSS VSS VSS VSS VSS
+ VSS VSS VSS u_t030_000/m2_717_1265# VSS VSS VSS VSS u_t030_000/m2_7_2126# VSS VSS
+ VSS VSS VSS VSS VSS u_t030_000/m2_512_1265# VSS u_t030_000/m2_603_1259# VSS VSS
+ VSS VSS VSS VSS u_t030_000/m2_2000_1265# VSS u_t030_000/m2_1795_1265# VSS u_t030_000/m2_1886_1259#
+ u_t030_000/m2_1290_2126# VSS VSS VSS VSS VSS VSUBS detronyx_12t_2w2r_rc4_4x4_routed_5layer_direct
Xgf180mcu_as_sc_mcu7t3v3__nand4_2_401 VSS VSS VSS VSS VSS VSS gf180mcu_as_sc_mcu7t3v3__inv_2_1473/A
+ gf180mcu_as_sc_mcu7t3v3__inv_2_1473/VNW VSUBS gf180mcu_as_sc_mcu7t3v3__nand4_2
Xgf180mcu_as_sc_mcu7t3v3__nand4_2_434 VSS VSS VSS VSS VSS VSS gf180mcu_as_sc_mcu7t3v3__inv_2_1573/A
+ gf180mcu_as_sc_mcu7t3v3__inv_2_1573/VNW VSUBS gf180mcu_as_sc_mcu7t3v3__nand4_2
Xgf180mcu_as_sc_mcu7t3v3__nand4_2_445 VSS VSS VSS VSS VSS VSS gf180mcu_as_sc_mcu7t3v3__inv_2_1606/A
+ gf180mcu_as_sc_mcu7t3v3__inv_2_1606/VNW VSUBS gf180mcu_as_sc_mcu7t3v3__nand4_2
Xgf180mcu_as_sc_mcu7t3v3__nand4_2_489 VSS VSS VSS VSS VSS VSS gf180mcu_as_sc_mcu7t3v3__inv_2_1680/A
+ gf180mcu_as_sc_mcu7t3v3__inv_2_1680/VNW VSUBS gf180mcu_as_sc_mcu7t3v3__nand4_2
Xgf180mcu_as_sc_mcu7t3v3__nand4_2_423 VSS VSS VSS VSS VSS VSS gf180mcu_as_sc_mcu7t3v3__inv_2_1541/A
+ gf180mcu_as_sc_mcu7t3v3__inv_2_1541/VNW VSUBS gf180mcu_as_sc_mcu7t3v3__nand4_2
Xgf180mcu_as_sc_mcu7t3v3__nand4_2_467 VSS VSS VSS VSS VSS VSS gf180mcu_as_sc_mcu7t3v3__inv_2_1374/A
+ gf180mcu_as_sc_mcu7t3v3__inv_2_1374/VNW VSUBS gf180mcu_as_sc_mcu7t3v3__nand4_2
Xgf180mcu_as_sc_mcu7t3v3__nand4_2_478 VSS VSS VSS VSS VSS VSS gf180mcu_as_sc_mcu7t3v3__inv_2_1391/A
+ gf180mcu_as_sc_mcu7t3v3__inv_2_1391/VNW VSUBS gf180mcu_as_sc_mcu7t3v3__nand4_2
Xgf180mcu_as_sc_mcu7t3v3__nand4_2_412 VSS VSS VSS VSS VSS VSS gf180mcu_as_sc_mcu7t3v3__inv_2_1506/A
+ gf180mcu_as_sc_mcu7t3v3__inv_2_1506/VNW VSUBS gf180mcu_as_sc_mcu7t3v3__nand4_2
Xgf180mcu_as_sc_mcu7t3v3__inv_2_2 VSS VSS VSS gf180mcu_as_sc_mcu7t3v3__inv_2_3/Y gf180mcu_as_sc_mcu7t3v3__inv_2_4/VNW
+ VSUBS gf180mcu_as_sc_mcu7t3v3__inv_2
Xgf180mcu_as_sc_mcu7t3v3__nand4_2_456 VSS VSS VSS VSS VSS VSS gf180mcu_as_sc_mcu7t3v3__inv_2_1312/A
+ gf180mcu_as_sc_mcu7t3v3__inv_2_1312/VNW VSUBS gf180mcu_as_sc_mcu7t3v3__nand4_2
Xu_t021_011 u_t021_011/c0_w0_bl u_t021_011/c0_w0_br u_t021_011/c0_w1_bl u_t021_011/c0_w1_br
+ u_t021_011/c0_r0_rbl u_t021_011/c0_r1_rbl u_t021_011/c1_w0_bl u_t021_011/c1_w0_br
+ u_t021_011/c1_w1_bl u_t021_011/c1_w1_br u_t021_011/c1_r0_rbl u_t021_011/c1_r1_rbl
+ u_t021_011/c2_w0_bl u_t021_011/c2_w0_br u_t021_011/c2_w1_bl u_t021_011/c2_w1_br
+ u_t021_011/c2_r0_rbl u_t021_011/c2_r1_rbl u_t021_011/c3_w0_bl u_t021_011/c3_w0_br
+ u_t021_011/c3_w1_bl u_t021_011/c3_w1_br u_t021_011/c3_r0_rbl u_t021_011/c3_r1_rbl
+ u_t021_011/r0_w0_wl u_t021_011/r0_w1_wl u_t021_011/r0_r0_rwl u_t021_011/r0_r1_rwl
+ u_t021_011/r1_w0_wl u_t021_011/r1_w1_wl u_t021_011/r1_r0_rwl u_t021_011/r1_r1_rwl
+ u_t021_011/r2_w0_wl u_t021_011/r2_w1_wl u_t021_011/r2_r0_rwl u_t021_011/r2_r1_rwl
+ u_t021_011/r3_w0_wl u_t021_011/r3_w1_wl u_t021_011/r3_r0_rwl u_t021_011/r3_r1_rwl
+ VSS VSS u_t021_011/m2_717_1265# u_t021_011/m2_603_2031# u_t021_011/m2_1290_336#
+ u_t021_011/m2_2000_2037# u_t021_011/m2_791_2909# u_t021_011/m2_7_2126# u_t021_011/m2_2154_2081#
+ u_t021_011/m2_1795_2037# u_t021_011/m2_871_303# u_t021_011/m2_431_438# u_t021_011/m2_1290_2898#
+ u_t021_011/m2_1714_1210# u_t021_011/m2_431_1982# u_t021_011/m2_512_1265# u_t021_011/m2_2573_2126#
+ u_t021_011/m2_603_1259# u_t021_011/m2_2074_2909# u_t021_011/m2_7_336# u_t021_011/m2_717_2037#
+ u_t021_011/m2_1886_2031# u_t021_011/m2_2573_336# u_t021_011/m2_7_2898# u_t021_011/m2_2000_1265#
+ u_t021_011/m2_512_2037# u_t021_011/m2_1795_1265# u_t021_011/m2_1714_1982# u_t021_011/m2_1886_1259#
+ u_t021_011/m2_1290_2126# u_t021_011/m2_1714_438# u_t021_011/m2_431_1210# u_t021_011/m2_2573_2898#
+ u_t021_011/m2_2154_303# u_t021_011/m2_871_2081# VSUBS detronyx_12t_2w2r_rc4_4x4_routed_5layer_direct
Xu_t021_000 VSS u_t021_000/c0_w0_br VSS u_t021_000/c0_w1_br u_t021_000/c0_r0_rbl u_t021_000/c0_r1_rbl
+ VSS VSS VSS VSS VSS VSS u_t021_000/c2_w0_bl u_t021_000/c2_w0_br u_t021_000/c2_w1_bl
+ u_t021_000/c2_w1_br u_t021_000/c2_r0_rbl u_t021_000/c2_r1_rbl u_t021_000/c3_w0_bl
+ u_t021_000/c3_w0_br u_t021_000/c3_w1_bl u_t021_000/c3_w1_br u_t021_000/c3_r0_rbl
+ u_t021_000/c3_r1_rbl VSS VSS VSS VSS VSS VSS VSS VSS VSS VSS VSS VSS VSS VSS VSS
+ VSS VSS VSS u_t021_000/m2_717_1265# VSS VSS VSS VSS VSS VSS VSS VSS VSS VSS VSS
+ VSS u_t021_000/m2_512_1265# u_t021_000/m2_2573_2126# VSS VSS VSS VSS VSS u_t021_000/m2_2573_336#
+ VSS u_t021_000/m2_2000_1265# VSS u_t021_000/m2_1795_1265# VSS VSS VSS VSS VSS u_t021_000/m2_2573_2898#
+ VSS VSS VSUBS detronyx_12t_2w2r_rc4_4x4_routed_5layer_direct
Xgf180mcu_as_sc_mcu7t3v3__inv_2_409 gf180mcu_as_sc_mcu7t3v3__nor2_2_4/VDD gf180mcu_as_sc_mcu7t3v3__nor2_2_4/VSS
+ VSS VSS gf180mcu_as_sc_mcu7t3v3__nor2_2_4/VNW VSUBS gf180mcu_as_sc_mcu7t3v3__inv_2
Xu_t012_011 u_t012_011/c0_w0_bl u_t012_011/c0_w0_br u_t012_011/c0_w1_bl u_t012_011/c0_w1_br
+ u_t012_011/c0_r0_rbl u_t012_011/c0_r1_rbl u_t012_011/c1_w0_bl u_t012_011/c1_w0_br
+ u_t012_011/c1_w1_bl u_t012_011/c1_w1_br u_t012_011/c1_r0_rbl u_t012_011/c1_r1_rbl
+ u_t012_011/c2_w0_bl u_t012_011/c2_w0_br u_t012_011/c2_w1_bl u_t012_011/c2_w1_br
+ u_t012_011/c2_r0_rbl u_t012_011/c2_r1_rbl u_t012_011/c3_w0_bl u_t012_011/c3_w0_br
+ u_t012_011/c3_w1_bl u_t012_011/c3_w1_br u_t012_011/c3_r0_rbl u_t012_011/c3_r1_rbl
+ u_t012_011/r0_w0_wl u_t012_011/r0_w1_wl u_t012_011/r0_r0_rwl u_t012_011/r0_r1_rwl
+ u_t012_011/r1_w0_wl u_t012_011/r1_w1_wl u_t012_011/r1_r0_rwl u_t012_011/r1_r1_rwl
+ u_t012_011/r2_w0_wl u_t012_011/r2_w1_wl u_t012_011/r2_r0_rwl u_t012_011/r2_r1_rwl
+ u_t012_011/r3_w0_wl u_t012_011/r3_w1_wl u_t012_011/r3_r0_rwl u_t012_011/r3_r1_rwl
+ VSS VSS u_t012_011/m2_717_1265# u_t012_011/m2_603_2031# u_t012_011/m2_1290_336#
+ u_t012_011/m2_2000_2037# u_t012_011/m2_791_2909# u_t012_011/m2_7_2126# u_t012_011/m2_2154_2081#
+ u_t012_011/m2_1795_2037# u_t012_011/m2_871_303# u_t012_011/m2_431_438# u_t012_011/m2_1290_2898#
+ u_t012_011/m2_1714_1210# u_t012_011/m2_431_1982# u_t012_011/m2_512_1265# u_t012_011/m2_2573_2126#
+ u_t012_011/m2_603_1259# u_t012_011/m2_2074_2909# u_t012_011/m2_7_336# u_t012_011/m2_717_2037#
+ u_t012_011/m2_1886_2031# u_t012_011/m2_2573_336# u_t012_011/m2_7_2898# u_t012_011/m2_2000_1265#
+ u_t012_011/m2_512_2037# u_t012_011/m2_1795_1265# u_t012_011/m2_1714_1982# u_t012_011/m2_1886_1259#
+ u_t012_011/m2_1290_2126# u_t012_011/m2_1714_438# u_t012_011/m2_431_1210# u_t012_011/m2_2573_2898#
+ u_t012_011/m2_2154_303# u_t012_011/m2_871_2081# VSUBS detronyx_12t_2w2r_rc4_4x4_routed_5layer_direct
Xu_t012_000 VSS u_t012_000/c0_w0_br VSS u_t012_000/c0_w1_br u_t012_000/c0_r0_rbl u_t012_000/c0_r1_rbl
+ VSS VSS VSS VSS VSS VSS u_t012_000/c2_w0_bl u_t012_000/c2_w0_br u_t012_000/c2_w1_bl
+ u_t012_000/c2_w1_br u_t012_000/c2_r0_rbl u_t012_000/c2_r1_rbl u_t012_000/c3_w0_bl
+ u_t012_000/c3_w0_br u_t012_000/c3_w1_bl u_t012_000/c3_w1_br u_t012_000/c3_r0_rbl
+ u_t012_000/c3_r1_rbl VSS VSS VSS VSS VSS VSS VSS VSS VSS VSS VSS VSS VSS VSS VSS
+ VSS VSS VSS u_t012_000/m2_717_1265# u_t012_000/m2_603_2031# u_t012_000/m2_1290_336#
+ u_t012_000/m2_2000_2037# u_t012_000/m2_791_2909# u_t012_000/m2_7_2126# u_t012_000/m2_2154_2081#
+ u_t012_000/m2_1795_2037# u_t012_000/m2_871_303# u_t012_000/m2_431_438# u_t012_000/m2_1290_2898#
+ u_t012_000/m2_1714_1210# u_t012_000/m2_431_1982# u_t012_000/m2_512_1265# u_t012_000/m2_2573_2126#
+ u_t012_000/m2_603_1259# u_t012_000/m2_2074_2909# u_t012_000/m2_7_336# u_t012_000/m2_717_2037#
+ u_t012_000/m2_1886_2031# u_t012_000/m2_2573_336# u_t012_000/m2_7_2898# u_t012_000/m2_2000_1265#
+ u_t012_000/m2_512_2037# u_t012_000/m2_1795_1265# u_t012_000/m2_1714_1982# u_t012_000/m2_1886_1259#
+ u_t012_000/m2_1290_2126# u_t012_000/m2_1714_438# u_t012_000/m2_431_1210# u_t012_000/m2_2573_2898#
+ u_t012_000/m2_2154_303# u_t012_000/m2_871_2081# VSUBS detronyx_12t_2w2r_rc4_4x4_routed_5layer_direct
Xgf180mcu_as_sc_mcu7t3v3__inv_2_1470 VSS VSS gf180mcu_as_sc_mcu7t3v3__inv_2_1470/Y
+ gf180mcu_as_sc_mcu7t3v3__inv_2_1470/A gf180mcu_as_sc_mcu7t3v3__inv_2_1470/VNW VSUBS
+ gf180mcu_as_sc_mcu7t3v3__inv_2
Xgf180mcu_as_sc_mcu7t3v3__inv_2_1481 VSS VSS gf180mcu_as_sc_mcu7t3v3__inv_2_1481/Y
+ gf180mcu_as_sc_mcu7t3v3__inv_2_1482/Y gf180mcu_as_sc_mcu7t3v3__inv_2_1482/VNW VSUBS
+ gf180mcu_as_sc_mcu7t3v3__inv_2
Xgf180mcu_as_sc_mcu7t3v3__inv_2_1492 VSS VSS VSS gf180mcu_as_sc_mcu7t3v3__inv_2_1493/Y
+ gf180mcu_as_sc_mcu7t3v3__inv_2_1494/VNW VSUBS gf180mcu_as_sc_mcu7t3v3__inv_2
Xu_t003_011 u_t003_011/c0_w0_bl u_t003_011/c0_w0_br u_t003_011/c0_w1_bl u_t003_011/c0_w1_br
+ u_t003_011/c0_r0_rbl u_t003_011/c0_r1_rbl u_t003_011/c1_w0_bl u_t003_011/c1_w0_br
+ u_t003_011/c1_w1_bl u_t003_011/c1_w1_br u_t003_011/c1_r0_rbl u_t003_011/c1_r1_rbl
+ u_t003_011/c2_w0_bl u_t003_011/c2_w0_br u_t003_011/c2_w1_bl u_t003_011/c2_w1_br
+ u_t003_011/c2_r0_rbl u_t003_011/c2_r1_rbl u_t003_011/c3_w0_bl u_t003_011/c3_w0_br
+ u_t003_011/c3_w1_bl u_t003_011/c3_w1_br u_t003_011/c3_r0_rbl u_t003_011/c3_r1_rbl
+ u_t003_011/r0_w0_wl u_t003_011/r0_w1_wl u_t003_011/r0_r0_rwl u_t003_011/r0_r1_rwl
+ u_t003_011/r1_w0_wl u_t003_011/r1_w1_wl u_t003_011/r1_r0_rwl u_t003_011/r1_r1_rwl
+ u_t003_011/r2_w0_wl u_t003_011/r2_w1_wl u_t003_011/r2_r0_rwl u_t003_011/r2_r1_rwl
+ u_t003_011/r3_w0_wl u_t003_011/r3_w1_wl u_t003_011/r3_r0_rwl u_t003_011/r3_r1_rwl
+ VSS VSS u_t003_011/m2_717_1265# u_t003_011/m2_603_2031# u_t003_011/m2_1290_336#
+ u_t003_011/m2_2000_2037# u_t003_011/m2_791_2909# u_t003_011/m2_7_2126# u_t003_011/m2_2154_2081#
+ u_t003_011/m2_1795_2037# u_t003_011/m2_871_303# u_t003_011/m2_431_438# u_t003_011/m2_1290_2898#
+ u_t003_011/m2_1714_1210# u_t003_011/m2_431_1982# u_t003_011/m2_512_1265# u_t003_011/m2_2573_2126#
+ u_t003_011/m2_603_1259# u_t003_011/m2_2074_2909# u_t003_011/m2_7_336# u_t003_011/m2_717_2037#
+ u_t003_011/m2_1886_2031# u_t003_011/m2_2573_336# u_t003_011/m2_7_2898# u_t003_011/m2_2000_1265#
+ u_t003_011/m2_512_2037# u_t003_011/m2_1795_1265# u_t003_011/m2_1714_1982# u_t003_011/m2_1886_1259#
+ u_t003_011/m2_1290_2126# u_t003_011/m2_1714_438# u_t003_011/m2_431_1210# u_t003_011/m2_2573_2898#
+ u_t003_011/m2_2154_303# u_t003_011/m2_871_2081# VSUBS detronyx_12t_2w2r_rc4_4x4_routed_5layer_direct
Xgf180mcu_as_sc_mcu7t3v3__inv_2_954 VSS VSS VSS gf180mcu_as_sc_mcu7t3v3__inv_2_954/A
+ gf180mcu_as_sc_mcu7t3v3__inv_2_954/VNW VSUBS gf180mcu_as_sc_mcu7t3v3__inv_2
Xgf180mcu_as_sc_mcu7t3v3__inv_2_910 VSS VSS gf180mcu_as_sc_mcu7t3v3__inv_2_910/Y gf180mcu_as_sc_mcu7t3v3__inv_2_910/A
+ gf180mcu_as_sc_mcu7t3v3__inv_2_954/VNW VSUBS gf180mcu_as_sc_mcu7t3v3__inv_2
Xgf180mcu_as_sc_mcu7t3v3__inv_2_921 VSS VSS gf180mcu_as_sc_mcu7t3v3__inv_2_921/Y gf180mcu_as_sc_mcu7t3v3__inv_2_921/A
+ gf180mcu_as_sc_mcu7t3v3__inv_2_955/VNW VSUBS gf180mcu_as_sc_mcu7t3v3__inv_2
Xu_t003_000 VSS u_t003_000/c0_w0_br VSS u_t003_000/c0_w1_br u_t003_000/c0_r0_rbl u_t003_000/c0_r1_rbl
+ VSS VSS VSS VSS VSS VSS u_t003_000/c2_w0_bl u_t003_000/c2_w0_br u_t003_000/c2_w1_bl
+ u_t003_000/c2_w1_br u_t003_000/c2_r0_rbl u_t003_000/c2_r1_rbl u_t003_000/c3_w0_bl
+ u_t003_000/c3_w0_br u_t003_000/c3_w1_bl u_t003_000/c3_w1_br u_t003_000/c3_r0_rbl
+ u_t003_000/c3_r1_rbl VSS VSS VSS VSS VSS VSS VSS VSS VSS VSS VSS VSS VSS VSS VSS
+ VSS VSS VSS u_t003_000/m2_717_1265# u_t003_000/m2_603_2031# u_t003_000/m2_1290_336#
+ u_t003_000/m2_2000_2037# u_t003_000/m2_791_2909# u_t003_000/m2_7_2126# u_t003_000/m2_2154_2081#
+ u_t003_000/m2_1795_2037# u_t003_000/m2_871_303# u_t003_000/m2_431_438# u_t003_000/m2_1290_2898#
+ u_t003_000/m2_1714_1210# u_t003_000/m2_431_1982# u_t003_000/m2_512_1265# u_t003_000/m2_2573_2126#
+ u_t003_000/m2_603_1259# u_t003_000/m2_2074_2909# u_t003_000/m2_7_336# u_t003_000/m2_717_2037#
+ u_t003_000/m2_1886_2031# u_t003_000/m2_2573_336# u_t003_000/m2_7_2898# u_t003_000/m2_2000_1265#
+ u_t003_000/m2_512_2037# u_t003_000/m2_1795_1265# u_t003_000/m2_1714_1982# u_t003_000/m2_1886_1259#
+ u_t003_000/m2_1290_2126# u_t003_000/m2_1714_438# u_t003_000/m2_431_1210# u_t003_000/m2_2573_2898#
+ u_t003_000/m2_2154_303# u_t003_000/m2_871_2081# VSUBS detronyx_12t_2w2r_rc4_4x4_routed_5layer_direct
Xgf180mcu_as_sc_mcu7t3v3__inv_2_998 VSS VSS VSS gf180mcu_as_sc_mcu7t3v3__inv_2_999/Y
+ gf180mcu_as_sc_mcu7t3v3__inv_2_999/VNW VSUBS gf180mcu_as_sc_mcu7t3v3__inv_2
Xgf180mcu_as_sc_mcu7t3v3__inv_2_987 VSS VSS gf180mcu_as_sc_mcu7t3v3__inv_2_987/Y gf180mcu_as_sc_mcu7t3v3__inv_2_988/Y
+ gf180mcu_as_sc_mcu7t3v3__inv_2_988/VNW VSUBS gf180mcu_as_sc_mcu7t3v3__inv_2
Xgf180mcu_as_sc_mcu7t3v3__inv_2_976 VSS VSS gf180mcu_as_sc_mcu7t3v3__inv_2_976/Y gf180mcu_as_sc_mcu7t3v3__inv_2_976/A
+ gf180mcu_as_sc_mcu7t3v3__inv_2_976/VNW VSUBS gf180mcu_as_sc_mcu7t3v3__inv_2
Xgf180mcu_as_sc_mcu7t3v3__inv_2_965 VSS VSS gf180mcu_as_sc_mcu7t3v3__inv_2_965/Y gf180mcu_as_sc_mcu7t3v3__inv_2_969/Y
+ gf180mcu_as_sc_mcu7t3v3__inv_2_969/VNW VSUBS gf180mcu_as_sc_mcu7t3v3__inv_2
Xgf180mcu_as_sc_mcu7t3v3__inv_2_932 VSS VSS VSS gf180mcu_as_sc_mcu7t3v3__inv_2_932/A
+ gf180mcu_as_sc_mcu7t3v3__inv_2_932/VNW VSUBS gf180mcu_as_sc_mcu7t3v3__inv_2
Xgf180mcu_as_sc_mcu7t3v3__inv_2_943 VSS VSS VSS gf180mcu_as_sc_mcu7t3v3__inv_2_943/A
+ gf180mcu_as_sc_mcu7t3v3__inv_2_943/VNW VSUBS gf180mcu_as_sc_mcu7t3v3__inv_2
Xgf180mcu_as_sc_mcu7t3v3__nand4_2_220 VSS VSS VSS VSS VSS VSS gf180mcu_as_sc_mcu7t3v3__inv_2_762/A
+ gf180mcu_as_sc_mcu7t3v3__inv_2_821/VNW VSUBS gf180mcu_as_sc_mcu7t3v3__nand4_2
Xgf180mcu_as_sc_mcu7t3v3__nand4_2_231 VSS VSS VSS VSS VSS VSS gf180mcu_as_sc_mcu7t3v3__inv_2_804/A
+ gf180mcu_as_sc_mcu7t3v3__inv_2_850/VNW VSUBS gf180mcu_as_sc_mcu7t3v3__nand4_2
Xgf180mcu_as_sc_mcu7t3v3__nand4_2_242 VSS VSS VSS VSS VSS VSS gf180mcu_as_sc_mcu7t3v3__inv_2_806/A
+ gf180mcu_as_sc_mcu7t3v3__inv_2_838/VNW VSUBS gf180mcu_as_sc_mcu7t3v3__nand4_2
Xgf180mcu_as_sc_mcu7t3v3__nand4_2_253 VSS VSS VSS VSS VSS VSS gf180mcu_as_sc_mcu7t3v3__inv_2_862/A
+ gf180mcu_as_sc_mcu7t3v3__inv_2_942/VNW VSUBS gf180mcu_as_sc_mcu7t3v3__nand4_2
Xgf180mcu_as_sc_mcu7t3v3__nand4_2_286 VSS VSS VSS VSS VSS VSS gf180mcu_as_sc_mcu7t3v3__inv_2_1016/A
+ gf180mcu_as_sc_mcu7t3v3__inv_2_1016/VNW VSUBS gf180mcu_as_sc_mcu7t3v3__nand4_2
Xgf180mcu_as_sc_mcu7t3v3__nand4_2_297 VSS VSS VSS VSS VSS VSS gf180mcu_as_sc_mcu7t3v3__inv_2_964/A
+ gf180mcu_as_sc_mcu7t3v3__inv_2_964/VNW VSUBS gf180mcu_as_sc_mcu7t3v3__nand4_2
Xgf180mcu_as_sc_mcu7t3v3__nand4_2_264 VSS VSS VSS VSS VSS VSS gf180mcu_as_sc_mcu7t3v3__inv_2_883/A
+ gf180mcu_as_sc_mcu7t3v3__inv_2_941/VNW VSUBS gf180mcu_as_sc_mcu7t3v3__nand4_2
Xgf180mcu_as_sc_mcu7t3v3__nand4_2_275 VSS VSS VSS VSS VSS VSS gf180mcu_as_sc_mcu7t3v3__inv_2_894/A
+ gf180mcu_as_sc_mcu7t3v3__inv_2_957/VNW VSUBS gf180mcu_as_sc_mcu7t3v3__nand4_2
Xgf180mcu_as_sc_mcu7t3v3__inv_2_206 VSS VSS gf180mcu_as_sc_mcu7t3v3__inv_2_206/Y gf180mcu_as_sc_mcu7t3v3__inv_2_206/A
+ gf180mcu_as_sc_mcu7t3v3__inv_2_206/VNW VSUBS gf180mcu_as_sc_mcu7t3v3__inv_2
Xgf180mcu_as_sc_mcu7t3v3__inv_2_228 VSS VSS VSS gf180mcu_as_sc_mcu7t3v3__inv_2_229/Y
+ gf180mcu_as_sc_mcu7t3v3__inv_2_230/VNW VSUBS gf180mcu_as_sc_mcu7t3v3__inv_2
Xgf180mcu_as_sc_mcu7t3v3__inv_2_217 VSS VSS gf180mcu_as_sc_mcu7t3v3__inv_2_217/Y gf180mcu_as_sc_mcu7t3v3__inv_2_218/Y
+ gf180mcu_as_sc_mcu7t3v3__inv_2_218/VNW VSUBS gf180mcu_as_sc_mcu7t3v3__inv_2
Xgf180mcu_as_sc_mcu7t3v3__inv_2_239 VSS VSS gf180mcu_as_sc_mcu7t3v3__inv_2_239/Y gf180mcu_as_sc_mcu7t3v3__inv_2_239/A
+ gf180mcu_as_sc_mcu7t3v3__inv_2_239/VNW VSUBS gf180mcu_as_sc_mcu7t3v3__inv_2
Xu_t000_014 u_t000_014/c0_w0_bl u_t000_014/c0_w0_br u_t000_014/c0_w1_bl u_t000_014/c0_w1_br
+ u_t000_014/c0_r0_rbl u_t000_014/c0_r1_rbl u_t000_014/c1_w0_bl u_t000_014/c1_w0_br
+ u_t000_014/c1_w1_bl u_t000_014/c1_w1_br u_t000_014/c1_r0_rbl u_t000_014/c1_r1_rbl
+ u_t000_014/c2_w0_bl u_t000_014/c2_w0_br u_t000_014/c2_w1_bl u_t000_014/c2_w1_br
+ u_t000_014/c2_r0_rbl u_t000_014/c2_r1_rbl u_t000_014/c3_w0_bl u_t000_014/c3_w0_br
+ u_t000_014/c3_w1_bl u_t000_014/c3_w1_br u_t000_014/c3_r0_rbl u_t000_014/c3_r1_rbl
+ u_t000_014/r0_w0_wl u_t000_014/r0_w1_wl u_t000_014/r0_r0_rwl u_t000_014/r0_r1_rwl
+ u_t000_014/r1_w0_wl u_t000_014/r1_w1_wl u_t000_014/r1_r0_rwl u_t000_014/r1_r1_rwl
+ u_t000_014/r2_w0_wl u_t000_014/r2_w1_wl u_t000_014/r2_r0_rwl u_t000_014/r2_r1_rwl
+ u_t000_014/r3_w0_wl u_t000_014/r3_w1_wl u_t000_014/r3_r0_rwl u_t000_014/r3_r1_rwl
+ VSS VSS u_t000_014/m2_717_1265# u_t000_014/m2_603_2031# u_t000_014/m2_1290_336#
+ u_t000_014/m2_2000_2037# u_t000_014/m2_791_2909# u_t000_014/m2_7_2126# u_t000_014/m2_2154_2081#
+ u_t000_014/m2_1795_2037# u_t000_014/m2_871_303# u_t000_014/m2_431_438# u_t000_014/m2_1290_2898#
+ u_t000_014/m2_1714_1210# u_t000_014/m2_431_1982# u_t000_014/m2_512_1265# u_t000_014/m2_2573_2126#
+ u_t000_014/m2_603_1259# u_t000_014/m2_2074_2909# u_t000_014/m2_7_336# u_t000_014/m2_717_2037#
+ u_t000_014/m2_1886_2031# u_t000_014/m2_2573_336# u_t000_014/m2_7_2898# u_t000_014/m2_2000_1265#
+ u_t000_014/m2_512_2037# u_t000_014/m2_1795_1265# u_t000_014/m2_1714_1982# u_t000_014/m2_1886_1259#
+ u_t000_014/m2_1290_2126# u_t000_014/m2_1714_438# u_t000_014/m2_431_1210# u_t000_014/m2_2573_2898#
+ u_t000_014/m2_2154_303# u_t000_014/m2_871_2081# VSUBS detronyx_12t_2w2r_rc4_4x4_routed_5layer_direct
Xu_t000_003 u_t000_003/c0_w0_bl u_t000_003/c0_w0_br u_t000_003/c0_w1_bl u_t000_003/c0_w1_br
+ u_t000_003/c0_r0_rbl u_t000_003/c0_r1_rbl u_t000_003/c1_w0_bl u_t000_003/c1_w0_br
+ u_t000_003/c1_w1_bl u_t000_003/c1_w1_br u_t000_003/c1_r0_rbl u_t000_003/c1_r1_rbl
+ u_t000_003/c2_w0_bl u_t000_003/c2_w0_br u_t000_003/c2_w1_bl u_t000_003/c2_w1_br
+ u_t000_003/c2_r0_rbl u_t000_003/c2_r1_rbl u_t000_003/c3_w0_bl u_t000_003/c3_w0_br
+ u_t000_003/c3_w1_bl u_t000_003/c3_w1_br u_t000_003/c3_r0_rbl u_t000_003/c3_r1_rbl
+ u_t000_003/r0_w0_wl u_t000_003/r0_w1_wl u_t000_003/r0_r0_rwl u_t000_003/r0_r1_rwl
+ u_t000_003/r1_w0_wl u_t000_003/r1_w1_wl u_t000_003/r1_r0_rwl u_t000_003/r1_r1_rwl
+ u_t000_003/r2_w0_wl u_t000_003/r2_w1_wl u_t000_003/r2_r0_rwl u_t000_003/r2_r1_rwl
+ u_t000_003/r3_w0_wl u_t000_003/r3_w1_wl u_t000_003/r3_r0_rwl u_t000_003/r3_r1_rwl
+ VSS VSS u_t000_003/m2_717_1265# u_t000_003/m2_603_2031# u_t000_003/m2_1290_336#
+ u_t000_003/m2_2000_2037# u_t000_003/m2_791_2909# u_t000_003/m2_7_2126# u_t000_003/m2_2154_2081#
+ u_t000_003/m2_1795_2037# u_t000_003/m2_871_303# u_t000_003/m2_431_438# u_t000_003/m2_1290_2898#
+ u_t000_003/m2_1714_1210# u_t000_003/m2_431_1982# u_t000_003/m2_512_1265# u_t000_003/m2_2573_2126#
+ u_t000_003/m2_603_1259# u_t000_003/m2_2074_2909# u_t000_003/m2_7_336# u_t000_003/m2_717_2037#
+ u_t000_003/m2_1886_2031# u_t000_003/m2_2573_336# u_t000_003/m2_7_2898# u_t000_003/m2_2000_1265#
+ u_t000_003/m2_512_2037# u_t000_003/m2_1795_1265# u_t000_003/m2_1714_1982# u_t000_003/m2_1886_1259#
+ u_t000_003/m2_1290_2126# u_t000_003/m2_1714_438# u_t000_003/m2_431_1210# u_t000_003/m2_2573_2898#
+ u_t000_003/m2_2154_303# u_t000_003/m2_871_2081# VSUBS detronyx_12t_2w2r_rc4_4x4_routed_5layer_direct
Xgf180mcu_as_sc_mcu7t3v3__inv_2_773 VSS VSS gf180mcu_as_sc_mcu7t3v3__inv_2_773/Y gf180mcu_as_sc_mcu7t3v3__inv_2_773/A
+ gf180mcu_as_sc_mcu7t3v3__inv_2_825/VNW VSUBS gf180mcu_as_sc_mcu7t3v3__inv_2
Xgf180mcu_as_sc_mcu7t3v3__inv_2_762 VSS VSS gf180mcu_as_sc_mcu7t3v3__inv_2_762/Y gf180mcu_as_sc_mcu7t3v3__inv_2_762/A
+ gf180mcu_as_sc_mcu7t3v3__inv_2_821/VNW VSUBS gf180mcu_as_sc_mcu7t3v3__inv_2
Xgf180mcu_as_sc_mcu7t3v3__inv_2_751 VSS VSS gf180mcu_as_sc_mcu7t3v3__inv_2_751/Y gf180mcu_as_sc_mcu7t3v3__inv_2_751/A
+ gf180mcu_as_sc_mcu7t3v3__inv_2_830/VNW VSUBS gf180mcu_as_sc_mcu7t3v3__inv_2
Xgf180mcu_as_sc_mcu7t3v3__inv_2_795 VSS VSS gf180mcu_as_sc_mcu7t3v3__inv_2_795/Y gf180mcu_as_sc_mcu7t3v3__inv_2_795/A
+ gf180mcu_as_sc_mcu7t3v3__inv_2_845/VNW VSUBS gf180mcu_as_sc_mcu7t3v3__inv_2
Xgf180mcu_as_sc_mcu7t3v3__inv_2_784 VSS VSS gf180mcu_as_sc_mcu7t3v3__inv_2_842/A gf180mcu_as_sc_mcu7t3v3__inv_2_787/Y
+ gf180mcu_as_sc_mcu7t3v3__inv_2_842/VNW VSUBS gf180mcu_as_sc_mcu7t3v3__inv_2
Xgf180mcu_as_sc_mcu7t3v3__inv_2_740 VSS VSS gf180mcu_as_sc_mcu7t3v3__inv_2_740/Y gf180mcu_as_sc_mcu7t3v3__inv_2_740/A
+ gf180mcu_as_sc_mcu7t3v3__inv_2_740/VNW VSUBS gf180mcu_as_sc_mcu7t3v3__inv_2
Xgf180mcu_as_sc_mcu7t3v3__inv_2_581 VSS VSS gf180mcu_as_sc_mcu7t3v3__inv_2_585/A gf180mcu_as_sc_mcu7t3v3__inv_2_581/A
+ gf180mcu_as_sc_mcu7t3v3__inv_2_585/VNW VSUBS gf180mcu_as_sc_mcu7t3v3__inv_2
Xgf180mcu_as_sc_mcu7t3v3__inv_2_570 VSS VSS gf180mcu_as_sc_mcu7t3v3__inv_2_570/Y gf180mcu_as_sc_mcu7t3v3__inv_2_570/A
+ gf180mcu_as_sc_mcu7t3v3__inv_2_570/VNW VSUBS gf180mcu_as_sc_mcu7t3v3__inv_2
Xgf180mcu_as_sc_mcu7t3v3__inv_2_592 VSS VSS gf180mcu_as_sc_mcu7t3v3__inv_2_592/Y gf180mcu_as_sc_mcu7t3v3__inv_2_592/A
+ gf180mcu_as_sc_mcu7t3v3__inv_2_607/VNW VSUBS gf180mcu_as_sc_mcu7t3v3__inv_2
Xgf180mcu_as_sc_mcu7t3v3__nor2_2_7 gf180mcu_as_sc_mcu7t3v3__nor2_2_7/VDD gf180mcu_as_sc_mcu7t3v3__nor2_2_7/VSS
+ VSS VSS VSS gf180mcu_as_sc_mcu7t3v3__nor2_2_7/VNW VSUBS gf180mcu_as_sc_mcu7t3v3__nor2_2
Xu_t028_006 u_t028_006/c0_w0_bl u_t028_006/c0_w0_br u_t028_006/c0_w1_bl u_t028_006/c0_w1_br
+ u_t028_006/c0_r0_rbl u_t028_006/c0_r1_rbl u_t028_006/c1_w0_bl u_t028_006/c1_w0_br
+ u_t028_006/c1_w1_bl u_t028_006/c1_w1_br u_t028_006/c1_r0_rbl u_t028_006/c1_r1_rbl
+ u_t028_006/c2_w0_bl u_t028_006/c2_w0_br u_t028_006/c2_w1_bl u_t028_006/c2_w1_br
+ u_t028_006/c2_r0_rbl u_t028_006/c2_r1_rbl u_t028_006/c3_w0_bl u_t028_006/c3_w0_br
+ u_t028_006/c3_w1_bl u_t028_006/c3_w1_br u_t028_006/c3_r0_rbl u_t028_006/c3_r1_rbl
+ u_t028_006/r0_w0_wl u_t028_006/r0_w1_wl u_t028_006/r0_r0_rwl u_t028_006/r0_r1_rwl
+ u_t028_006/r1_w0_wl u_t028_006/r1_w1_wl u_t028_006/r1_r0_rwl u_t028_006/r1_r1_rwl
+ u_t028_006/r2_w0_wl u_t028_006/r2_w1_wl u_t028_006/r2_r0_rwl u_t028_006/r2_r1_rwl
+ u_t028_006/r3_w0_wl u_t028_006/r3_w1_wl u_t028_006/r3_r0_rwl u_t028_006/r3_r1_rwl
+ VSS VSS u_t028_006/m2_717_1265# u_t028_006/m2_603_2031# u_t028_006/m2_1290_336#
+ u_t028_006/m2_2000_2037# u_t028_006/m2_791_2909# u_t028_006/m2_7_2126# u_t028_006/m2_2154_2081#
+ u_t028_006/m2_1795_2037# u_t028_006/m2_871_303# u_t028_006/m2_431_438# u_t028_006/m2_1290_2898#
+ u_t028_006/m2_1714_1210# u_t028_006/m2_431_1982# u_t028_006/m2_512_1265# u_t028_006/m2_2573_2126#
+ u_t028_006/m2_603_1259# u_t028_006/m2_2074_2909# u_t028_006/m2_7_336# u_t028_006/m2_717_2037#
+ u_t028_006/m2_1886_2031# u_t028_006/m2_2573_336# u_t028_006/m2_7_2898# u_t028_006/m2_2000_1265#
+ u_t028_006/m2_512_2037# u_t028_006/m2_1795_1265# u_t028_006/m2_1714_1982# u_t028_006/m2_1886_1259#
+ u_t028_006/m2_1290_2126# u_t028_006/m2_1714_438# u_t028_006/m2_431_1210# u_t028_006/m2_2573_2898#
+ u_t028_006/m2_2154_303# u_t028_006/m2_871_2081# VSUBS detronyx_12t_2w2r_rc4_4x4_routed_5layer_direct
Xu_t019_006 u_t019_006/c0_w0_bl u_t019_006/c0_w0_br u_t019_006/c0_w1_bl u_t019_006/c0_w1_br
+ u_t019_006/c0_r0_rbl u_t019_006/c0_r1_rbl u_t019_006/c1_w0_bl u_t019_006/c1_w0_br
+ u_t019_006/c1_w1_bl u_t019_006/c1_w1_br u_t019_006/c1_r0_rbl u_t019_006/c1_r1_rbl
+ u_t019_006/c2_w0_bl u_t019_006/c2_w0_br u_t019_006/c2_w1_bl u_t019_006/c2_w1_br
+ u_t019_006/c2_r0_rbl u_t019_006/c2_r1_rbl u_t019_006/c3_w0_bl u_t019_006/c3_w0_br
+ u_t019_006/c3_w1_bl u_t019_006/c3_w1_br u_t019_006/c3_r0_rbl u_t019_006/c3_r1_rbl
+ u_t019_006/r0_w0_wl u_t019_006/r0_w1_wl u_t019_006/r0_r0_rwl u_t019_006/r0_r1_rwl
+ u_t019_006/r1_w0_wl u_t019_006/r1_w1_wl u_t019_006/r1_r0_rwl u_t019_006/r1_r1_rwl
+ u_t019_006/r2_w0_wl u_t019_006/r2_w1_wl u_t019_006/r2_r0_rwl u_t019_006/r2_r1_rwl
+ u_t019_006/r3_w0_wl u_t019_006/r3_w1_wl u_t019_006/r3_r0_rwl u_t019_006/r3_r1_rwl
+ VSS VSS u_t019_006/m2_717_1265# u_t019_006/m2_603_2031# u_t019_006/m2_1290_336#
+ u_t019_006/m2_2000_2037# u_t019_006/m2_791_2909# u_t019_006/m2_7_2126# u_t019_006/m2_2154_2081#
+ u_t019_006/m2_1795_2037# u_t019_006/m2_871_303# u_t019_006/m2_431_438# u_t019_006/m2_1290_2898#
+ u_t019_006/m2_1714_1210# u_t019_006/m2_431_1982# u_t019_006/m2_512_1265# u_t019_006/m2_2573_2126#
+ u_t019_006/m2_603_1259# u_t019_006/m2_2074_2909# u_t019_006/m2_7_336# u_t019_006/m2_717_2037#
+ u_t019_006/m2_1886_2031# u_t019_006/m2_2573_336# u_t019_006/m2_7_2898# u_t019_006/m2_2000_1265#
+ u_t019_006/m2_512_2037# u_t019_006/m2_1795_1265# u_t019_006/m2_1714_1982# u_t019_006/m2_1886_1259#
+ u_t019_006/m2_1290_2126# u_t019_006/m2_1714_438# u_t019_006/m2_431_1210# u_t019_006/m2_2573_2898#
+ u_t019_006/m2_2154_303# u_t019_006/m2_871_2081# VSUBS detronyx_12t_2w2r_rc4_4x4_routed_5layer_direct
Xu_t025_009 u_t025_009/c0_w0_bl u_t025_009/c0_w0_br u_t025_009/c0_w1_bl u_t025_009/c0_w1_br
+ u_t025_009/c0_r0_rbl u_t025_009/c0_r1_rbl u_t025_009/c1_w0_bl u_t025_009/c1_w0_br
+ u_t025_009/c1_w1_bl u_t025_009/c1_w1_br u_t025_009/c1_r0_rbl u_t025_009/c1_r1_rbl
+ u_t025_009/c2_w0_bl u_t025_009/c2_w0_br u_t025_009/c2_w1_bl u_t025_009/c2_w1_br
+ u_t025_009/c2_r0_rbl u_t025_009/c2_r1_rbl u_t025_009/c3_w0_bl u_t025_009/c3_w0_br
+ u_t025_009/c3_w1_bl u_t025_009/c3_w1_br u_t025_009/c3_r0_rbl u_t025_009/c3_r1_rbl
+ u_t025_009/r0_w0_wl u_t025_009/r0_w1_wl u_t025_009/r0_r0_rwl u_t025_009/r0_r1_rwl
+ u_t025_009/r1_w0_wl u_t025_009/r1_w1_wl u_t025_009/r1_r0_rwl u_t025_009/r1_r1_rwl
+ u_t025_009/r2_w0_wl u_t025_009/r2_w1_wl u_t025_009/r2_r0_rwl u_t025_009/r2_r1_rwl
+ u_t025_009/r3_w0_wl u_t025_009/r3_w1_wl u_t025_009/r3_r0_rwl u_t025_009/r3_r1_rwl
+ VSS VSS u_t025_009/m2_717_1265# u_t025_009/m2_603_2031# u_t025_009/m2_1290_336#
+ u_t025_009/m2_2000_2037# u_t025_009/m2_791_2909# u_t025_009/m2_7_2126# u_t025_009/m2_2154_2081#
+ u_t025_009/m2_1795_2037# u_t025_009/m2_871_303# u_t025_009/m2_431_438# u_t025_009/m2_1290_2898#
+ u_t025_009/m2_1714_1210# u_t025_009/m2_431_1982# u_t025_009/m2_512_1265# u_t025_009/m2_2573_2126#
+ u_t025_009/m2_603_1259# u_t025_009/m2_2074_2909# u_t025_009/m2_7_336# u_t025_009/m2_717_2037#
+ u_t025_009/m2_1886_2031# u_t025_009/m2_2573_336# u_t025_009/m2_7_2898# u_t025_009/m2_2000_1265#
+ u_t025_009/m2_512_2037# u_t025_009/m2_1795_1265# u_t025_009/m2_1714_1982# u_t025_009/m2_1886_1259#
+ u_t025_009/m2_1290_2126# u_t025_009/m2_1714_438# u_t025_009/m2_431_1210# u_t025_009/m2_2573_2898#
+ u_t025_009/m2_2154_303# u_t025_009/m2_871_2081# VSUBS detronyx_12t_2w2r_rc4_4x4_routed_5layer_direct
Xgf180mcu_as_sc_mcu7t3v3__inv_2_1129 VSS VSS gf180mcu_as_sc_mcu7t3v3__inv_2_1129/Y
+ gf180mcu_as_sc_mcu7t3v3__inv_2_1129/A gf180mcu_as_sc_mcu7t3v3__inv_2_1129/VNW VSUBS
+ gf180mcu_as_sc_mcu7t3v3__inv_2
Xgf180mcu_as_sc_mcu7t3v3__inv_2_1118 VSS VSS gf180mcu_as_sc_mcu7t3v3__inv_2_1118/Y
+ gf180mcu_as_sc_mcu7t3v3__inv_2_1118/A gf180mcu_as_sc_mcu7t3v3__inv_2_1118/VNW VSUBS
+ gf180mcu_as_sc_mcu7t3v3__inv_2
Xgf180mcu_as_sc_mcu7t3v3__inv_2_1107 VSS VSS gf180mcu_as_sc_mcu7t3v3__inv_2_1107/Y
+ gf180mcu_as_sc_mcu7t3v3__inv_2_1107/A gf180mcu_as_sc_mcu7t3v3__inv_2_1107/VNW VSUBS
+ gf180mcu_as_sc_mcu7t3v3__inv_2
Xu_t016_009 u_t016_009/c0_w0_bl u_t016_009/c0_w0_br u_t016_009/c0_w1_bl u_t016_009/c0_w1_br
+ u_t016_009/c0_r0_rbl u_t016_009/c0_r1_rbl u_t016_009/c1_w0_bl u_t016_009/c1_w0_br
+ u_t016_009/c1_w1_bl u_t016_009/c1_w1_br u_t016_009/c1_r0_rbl u_t016_009/c1_r1_rbl
+ u_t016_009/c2_w0_bl u_t016_009/c2_w0_br u_t016_009/c2_w1_bl u_t016_009/c2_w1_br
+ u_t016_009/c2_r0_rbl u_t016_009/c2_r1_rbl u_t016_009/c3_w0_bl u_t016_009/c3_w0_br
+ u_t016_009/c3_w1_bl u_t016_009/c3_w1_br u_t016_009/c3_r0_rbl u_t016_009/c3_r1_rbl
+ u_t016_009/r0_w0_wl u_t016_009/r0_w1_wl u_t016_009/r0_r0_rwl u_t016_009/r0_r1_rwl
+ u_t016_009/r1_w0_wl u_t016_009/r1_w1_wl u_t016_009/r1_r0_rwl u_t016_009/r1_r1_rwl
+ u_t016_009/r2_w0_wl u_t016_009/r2_w1_wl u_t016_009/r2_r0_rwl u_t016_009/r2_r1_rwl
+ u_t016_009/r3_w0_wl u_t016_009/r3_w1_wl u_t016_009/r3_r0_rwl u_t016_009/r3_r1_rwl
+ VSS VSS u_t016_009/m2_717_1265# u_t016_009/m2_603_2031# u_t016_009/m2_1290_336#
+ u_t016_009/m2_2000_2037# u_t016_009/m2_791_2909# u_t016_009/m2_7_2126# u_t016_009/m2_2154_2081#
+ u_t016_009/m2_1795_2037# u_t016_009/m2_871_303# u_t016_009/m2_431_438# u_t016_009/m2_1290_2898#
+ u_t016_009/m2_1714_1210# u_t016_009/m2_431_1982# u_t016_009/m2_512_1265# u_t016_009/m2_2573_2126#
+ u_t016_009/m2_603_1259# u_t016_009/m2_2074_2909# u_t016_009/m2_7_336# u_t016_009/m2_717_2037#
+ u_t016_009/m2_1886_2031# u_t016_009/m2_2573_336# u_t016_009/m2_7_2898# u_t016_009/m2_2000_1265#
+ u_t016_009/m2_512_2037# u_t016_009/m2_1795_1265# u_t016_009/m2_1714_1982# u_t016_009/m2_1886_1259#
+ u_t016_009/m2_1290_2126# u_t016_009/m2_1714_438# u_t016_009/m2_431_1210# u_t016_009/m2_2573_2898#
+ u_t016_009/m2_2154_303# u_t016_009/m2_871_2081# VSUBS detronyx_12t_2w2r_rc4_4x4_routed_5layer_direct
Xgf180mcu_as_sc_mcu7t3v3__nand3_2_65 gf180mcu_as_sc_mcu7t3v3__nand3_2_65/VDD gf180mcu_as_sc_mcu7t3v3__nor2_2_9/VSS
+ VSS VSS VSS VSS gf180mcu_as_sc_mcu7t3v3__nand3_2_65/VNW VSUBS gf180mcu_as_sc_mcu7t3v3__nand3_2
Xgf180mcu_as_sc_mcu7t3v3__nand3_2_54 gf180mcu_as_sc_mcu7t3v3__nor2_2_9/VDD gf180mcu_as_sc_mcu7t3v3__nor2_2_9/VSS
+ VSS VSS VSS VSS gf180mcu_as_sc_mcu7t3v3__nor2_2_9/VNW VSUBS gf180mcu_as_sc_mcu7t3v3__nand3_2
Xgf180mcu_as_sc_mcu7t3v3__nand3_2_21 gf180mcu_as_sc_mcu7t3v3__nand3_2_9/VDD gf180mcu_as_sc_mcu7t3v3__nor2_2_4/VSS
+ VSS VSS VSS VSS gf180mcu_as_sc_mcu7t3v3__nand3_2_9/VNW VSUBS gf180mcu_as_sc_mcu7t3v3__nand3_2
Xgf180mcu_as_sc_mcu7t3v3__nand3_2_43 gf180mcu_as_sc_mcu7t3v3__nand3_2_9/VDD gf180mcu_as_sc_mcu7t3v3__nor2_2_4/VSS
+ VSS VSS VSS VSS gf180mcu_as_sc_mcu7t3v3__nand3_2_9/VNW VSUBS gf180mcu_as_sc_mcu7t3v3__nand3_2
Xgf180mcu_as_sc_mcu7t3v3__nand3_2_32 gf180mcu_as_sc_mcu7t3v3__nand3_2_9/VDD gf180mcu_as_sc_mcu7t3v3__nor2_2_7/VSS
+ VSS VSS VSS VSS gf180mcu_as_sc_mcu7t3v3__nand3_2_9/VNW VSUBS gf180mcu_as_sc_mcu7t3v3__nand3_2
Xgf180mcu_as_sc_mcu7t3v3__nand3_2_10 gf180mcu_as_sc_mcu7t3v3__nand3_2_9/VDD gf180mcu_as_sc_mcu7t3v3__nor2_2_7/VSS
+ VSS VSS VSS VSS gf180mcu_as_sc_mcu7t3v3__nand3_2_9/VNW VSUBS gf180mcu_as_sc_mcu7t3v3__nand3_2
Xgf180mcu_as_sc_mcu7t3v3__inv_2_1630 VSS VSS gf180mcu_as_sc_mcu7t3v3__inv_2_1630/Y
+ gf180mcu_as_sc_mcu7t3v3__inv_2_1631/Y gf180mcu_as_sc_mcu7t3v3__inv_2_1631/VNW VSUBS
+ gf180mcu_as_sc_mcu7t3v3__inv_2
Xgf180mcu_as_sc_mcu7t3v3__inv_2_1641 VSS VSS gf180mcu_as_sc_mcu7t3v3__inv_2_1641/Y
+ gf180mcu_as_sc_mcu7t3v3__inv_2_1642/Y gf180mcu_as_sc_mcu7t3v3__inv_2_1642/VNW VSUBS
+ gf180mcu_as_sc_mcu7t3v3__inv_2
Xgf180mcu_as_sc_mcu7t3v3__inv_2_1685 VSS VSS VSS gf180mcu_as_sc_mcu7t3v3__inv_2_1685/A
+ gf180mcu_as_sc_mcu7t3v3__inv_2_1685/VNW VSUBS gf180mcu_as_sc_mcu7t3v3__inv_2
Xgf180mcu_as_sc_mcu7t3v3__inv_2_1652 VSS VSS gf180mcu_as_sc_mcu7t3v3__inv_2_1652/Y
+ gf180mcu_as_sc_mcu7t3v3__inv_2_1652/A gf180mcu_as_sc_mcu7t3v3__inv_2_1652/VNW VSUBS
+ gf180mcu_as_sc_mcu7t3v3__inv_2
Xgf180mcu_as_sc_mcu7t3v3__inv_2_1663 VSS VSS gf180mcu_as_sc_mcu7t3v3__inv_2_1663/Y
+ gf180mcu_as_sc_mcu7t3v3__inv_2_1664/Y gf180mcu_as_sc_mcu7t3v3__inv_2_1664/VNW VSUBS
+ gf180mcu_as_sc_mcu7t3v3__inv_2
Xgf180mcu_as_sc_mcu7t3v3__inv_2_1674 VSS VSS VSS gf180mcu_as_sc_mcu7t3v3__inv_2_1675/Y
+ gf180mcu_as_sc_mcu7t3v3__inv_2_1676/VNW VSUBS gf180mcu_as_sc_mcu7t3v3__inv_2
Xgf180mcu_as_sc_mcu7t3v3__inv_2_1696 VSS VSS gf180mcu_as_sc_mcu7t3v3__inv_2_1696/Y
+ gf180mcu_as_sc_mcu7t3v3__inv_2_1697/Y gf180mcu_as_sc_mcu7t3v3__inv_2_1697/VNW VSUBS
+ gf180mcu_as_sc_mcu7t3v3__inv_2
Xu_t030_012 u_t030_012/c0_w0_bl u_t030_012/c0_w0_br u_t030_012/c0_w1_bl u_t030_012/c0_w1_br
+ u_t030_012/c0_r0_rbl u_t030_012/c0_r1_rbl u_t030_012/c1_w0_bl u_t030_012/c1_w0_br
+ u_t030_012/c1_w1_bl u_t030_012/c1_w1_br u_t030_012/c1_r0_rbl u_t030_012/c1_r1_rbl
+ u_t030_012/c2_w0_bl u_t030_012/c2_w0_br u_t030_012/c2_w1_bl u_t030_012/c2_w1_br
+ u_t030_012/c2_r0_rbl u_t030_012/c2_r1_rbl u_t030_012/c3_w0_bl u_t030_012/c3_w0_br
+ u_t030_012/c3_w1_bl u_t030_012/c3_w1_br u_t030_012/c3_r0_rbl u_t030_012/c3_r1_rbl
+ u_t030_012/r0_w0_wl u_t030_012/r0_w1_wl u_t030_012/r0_r0_rwl u_t030_012/r0_r1_rwl
+ u_t030_012/r1_w0_wl u_t030_012/r1_w1_wl u_t030_012/r1_r0_rwl u_t030_012/r1_r1_rwl
+ u_t030_012/r2_w0_wl u_t030_012/r2_w1_wl u_t030_012/r2_r0_rwl u_t030_012/r2_r1_rwl
+ u_t030_012/r3_w0_wl u_t030_012/r3_w1_wl u_t030_012/r3_r0_rwl u_t030_012/r3_r1_rwl
+ VSS VSS u_t030_012/m2_717_1265# u_t030_012/m2_603_2031# u_t030_012/m2_1290_336#
+ u_t030_012/m2_2000_2037# u_t030_012/m2_791_2909# u_t030_012/m2_7_2126# u_t030_012/m2_2154_2081#
+ u_t030_012/m2_1795_2037# u_t030_012/m2_871_303# u_t030_012/m2_431_438# u_t030_012/m2_1290_2898#
+ u_t030_012/m2_1714_1210# u_t030_012/m2_431_1982# u_t030_012/m2_512_1265# u_t030_012/m2_2573_2126#
+ u_t030_012/m2_603_1259# u_t030_012/m2_2074_2909# u_t030_012/m2_7_336# u_t030_012/m2_717_2037#
+ u_t030_012/m2_1886_2031# u_t030_012/m2_2573_336# u_t030_012/m2_7_2898# u_t030_012/m2_2000_1265#
+ u_t030_012/m2_512_2037# u_t030_012/m2_1795_1265# u_t030_012/m2_1714_1982# u_t030_012/m2_1886_1259#
+ u_t030_012/m2_1290_2126# u_t030_012/m2_1714_438# u_t030_012/m2_431_1210# u_t030_012/m2_2573_2898#
+ u_t030_012/m2_2154_303# u_t030_012/m2_871_2081# VSUBS detronyx_12t_2w2r_rc4_4x4_routed_5layer_direct
Xu_t007_009 u_t007_009/c0_w0_bl u_t007_009/c0_w0_br u_t007_009/c0_w1_bl u_t007_009/c0_w1_br
+ u_t007_009/c0_r0_rbl u_t007_009/c0_r1_rbl u_t007_009/c1_w0_bl u_t007_009/c1_w0_br
+ u_t007_009/c1_w1_bl u_t007_009/c1_w1_br u_t007_009/c1_r0_rbl u_t007_009/c1_r1_rbl
+ u_t007_009/c2_w0_bl u_t007_009/c2_w0_br u_t007_009/c2_w1_bl u_t007_009/c2_w1_br
+ u_t007_009/c2_r0_rbl u_t007_009/c2_r1_rbl u_t007_009/c3_w0_bl u_t007_009/c3_w0_br
+ u_t007_009/c3_w1_bl u_t007_009/c3_w1_br u_t007_009/c3_r0_rbl u_t007_009/c3_r1_rbl
+ u_t007_009/r0_w0_wl u_t007_009/r0_w1_wl u_t007_009/r0_r0_rwl u_t007_009/r0_r1_rwl
+ u_t007_009/r1_w0_wl u_t007_009/r1_w1_wl u_t007_009/r1_r0_rwl u_t007_009/r1_r1_rwl
+ u_t007_009/r2_w0_wl u_t007_009/r2_w1_wl u_t007_009/r2_r0_rwl u_t007_009/r2_r1_rwl
+ u_t007_009/r3_w0_wl u_t007_009/r3_w1_wl u_t007_009/r3_r0_rwl u_t007_009/r3_r1_rwl
+ VSS VSS u_t007_009/m2_717_1265# u_t007_009/m2_603_2031# u_t007_009/m2_1290_336#
+ u_t007_009/m2_2000_2037# u_t007_009/m2_791_2909# u_t007_009/m2_7_2126# u_t007_009/m2_2154_2081#
+ u_t007_009/m2_1795_2037# u_t007_009/m2_871_303# u_t007_009/m2_431_438# u_t007_009/m2_1290_2898#
+ u_t007_009/m2_1714_1210# u_t007_009/m2_431_1982# u_t007_009/m2_512_1265# u_t007_009/m2_2573_2126#
+ u_t007_009/m2_603_1259# u_t007_009/m2_2074_2909# u_t007_009/m2_7_336# u_t007_009/m2_717_2037#
+ u_t007_009/m2_1886_2031# u_t007_009/m2_2573_336# u_t007_009/m2_7_2898# u_t007_009/m2_2000_1265#
+ u_t007_009/m2_512_2037# u_t007_009/m2_1795_1265# u_t007_009/m2_1714_1982# u_t007_009/m2_1886_1259#
+ u_t007_009/m2_1290_2126# u_t007_009/m2_1714_438# u_t007_009/m2_431_1210# u_t007_009/m2_2573_2898#
+ u_t007_009/m2_2154_303# u_t007_009/m2_871_2081# VSUBS detronyx_12t_2w2r_rc4_4x4_routed_5layer_direct
Xu_t030_001 u_t030_001/c0_w0_bl u_t030_001/c0_w0_br u_t030_001/c0_w1_bl u_t030_001/c0_w1_br
+ u_t030_001/c0_r0_rbl u_t030_001/c0_r1_rbl u_t030_001/c1_w0_bl u_t030_001/c1_w0_br
+ u_t030_001/c1_w1_bl u_t030_001/c1_w1_br u_t030_001/c1_r0_rbl u_t030_001/c1_r1_rbl
+ u_t030_001/c2_w0_bl u_t030_001/c2_w0_br u_t030_001/c2_w1_bl u_t030_001/c2_w1_br
+ u_t030_001/c2_r0_rbl u_t030_001/c2_r1_rbl u_t030_001/c3_w0_bl u_t030_001/c3_w0_br
+ u_t030_001/c3_w1_bl u_t030_001/c3_w1_br u_t030_001/c3_r0_rbl u_t030_001/c3_r1_rbl
+ u_t030_001/r0_w0_wl u_t030_001/r0_w1_wl u_t030_001/r0_r0_rwl u_t030_001/r0_r1_rwl
+ u_t030_001/r1_w0_wl u_t030_001/r1_w1_wl u_t030_001/r1_r0_rwl u_t030_001/r1_r1_rwl
+ u_t030_001/r2_w0_wl u_t030_001/r2_w1_wl u_t030_001/r2_r0_rwl u_t030_001/r2_r1_rwl
+ u_t030_001/r3_w0_wl u_t030_001/r3_w1_wl u_t030_001/r3_r0_rwl u_t030_001/r3_r1_rwl
+ VSS VSS u_t030_001/m2_717_1265# u_t030_001/m2_603_2031# u_t030_001/m2_1290_336#
+ u_t030_001/m2_2000_2037# u_t030_001/m2_791_2909# u_t030_001/m2_7_2126# u_t030_001/m2_2154_2081#
+ u_t030_001/m2_1795_2037# u_t030_001/m2_871_303# u_t030_001/m2_431_438# u_t030_001/m2_1290_2898#
+ u_t030_001/m2_1714_1210# u_t030_001/m2_431_1982# u_t030_001/m2_512_1265# u_t030_001/m2_2573_2126#
+ u_t030_001/m2_603_1259# u_t030_001/m2_2074_2909# u_t030_001/m2_7_336# u_t030_001/m2_717_2037#
+ u_t030_001/m2_1886_2031# u_t030_001/m2_2573_336# u_t030_001/m2_7_2898# u_t030_001/m2_2000_1265#
+ u_t030_001/m2_512_2037# u_t030_001/m2_1795_1265# u_t030_001/m2_1714_1982# u_t030_001/m2_1886_1259#
+ u_t030_001/m2_1290_2126# u_t030_001/m2_1714_438# u_t030_001/m2_431_1210# u_t030_001/m2_2573_2898#
+ u_t030_001/m2_2154_303# u_t030_001/m2_871_2081# VSUBS detronyx_12t_2w2r_rc4_4x4_routed_5layer_direct
Xgf180mcu_as_sc_mcu7t3v3__nand4_2_435 VSS VSS VSS VSS VSS VSS gf180mcu_as_sc_mcu7t3v3__inv_2_1576/A
+ gf180mcu_as_sc_mcu7t3v3__inv_2_1576/VNW VSUBS gf180mcu_as_sc_mcu7t3v3__nand4_2
Xgf180mcu_as_sc_mcu7t3v3__nand4_2_424 VSS VSS VSS VSS VSS VSS gf180mcu_as_sc_mcu7t3v3__inv_2_1544/A
+ gf180mcu_as_sc_mcu7t3v3__inv_2_1544/VNW VSUBS gf180mcu_as_sc_mcu7t3v3__nand4_2
Xgf180mcu_as_sc_mcu7t3v3__nand4_2_402 VSS VSS VSS VSS VSS VSS gf180mcu_as_sc_mcu7t3v3__inv_2_1476/A
+ gf180mcu_as_sc_mcu7t3v3__inv_2_1476/VNW VSUBS gf180mcu_as_sc_mcu7t3v3__nand4_2
Xgf180mcu_as_sc_mcu7t3v3__nand4_2_413 VSS VSS VSS VSS VSS VSS gf180mcu_as_sc_mcu7t3v3__inv_2_1511/A
+ gf180mcu_as_sc_mcu7t3v3__inv_2_1511/VNW VSUBS gf180mcu_as_sc_mcu7t3v3__nand4_2
Xgf180mcu_as_sc_mcu7t3v3__nand4_2_446 VSS VSS VSS VSS VSS VSS gf180mcu_as_sc_mcu7t3v3__inv_2_1694/A
+ gf180mcu_as_sc_mcu7t3v3__inv_2_1694/VNW VSUBS gf180mcu_as_sc_mcu7t3v3__nand4_2
Xgf180mcu_as_sc_mcu7t3v3__nand4_2_468 VSS VSS VSS VSS VSS VSS gf180mcu_as_sc_mcu7t3v3__inv_2_1378/A
+ gf180mcu_as_sc_mcu7t3v3__inv_2_1378/VNW VSUBS gf180mcu_as_sc_mcu7t3v3__nand4_2
Xgf180mcu_as_sc_mcu7t3v3__inv_2_3 VSS VSS gf180mcu_as_sc_mcu7t3v3__inv_2_3/Y gf180mcu_as_sc_mcu7t3v3__inv_2_4/Y
+ gf180mcu_as_sc_mcu7t3v3__inv_2_4/VNW VSUBS gf180mcu_as_sc_mcu7t3v3__inv_2
Xgf180mcu_as_sc_mcu7t3v3__nand4_2_457 VSS VSS VSS VSS VSS VSS gf180mcu_as_sc_mcu7t3v3__inv_2_1316/A
+ gf180mcu_as_sc_mcu7t3v3__inv_2_1316/VNW VSUBS gf180mcu_as_sc_mcu7t3v3__nand4_2
Xgf180mcu_as_sc_mcu7t3v3__nand4_2_479 VSS VSS VSS VSS VSS VSS gf180mcu_as_sc_mcu7t3v3__inv_2_1363/A
+ gf180mcu_as_sc_mcu7t3v3__inv_2_1403/VNW VSUBS gf180mcu_as_sc_mcu7t3v3__nand4_2
Xu_t021_012 u_t021_012/c0_w0_bl u_t021_012/c0_w0_br u_t021_012/c0_w1_bl u_t021_012/c0_w1_br
+ u_t021_012/c0_r0_rbl u_t021_012/c0_r1_rbl u_t021_012/c1_w0_bl u_t021_012/c1_w0_br
+ u_t021_012/c1_w1_bl u_t021_012/c1_w1_br u_t021_012/c1_r0_rbl u_t021_012/c1_r1_rbl
+ u_t021_012/c2_w0_bl u_t021_012/c2_w0_br u_t021_012/c2_w1_bl u_t021_012/c2_w1_br
+ u_t021_012/c2_r0_rbl u_t021_012/c2_r1_rbl u_t021_012/c3_w0_bl u_t021_012/c3_w0_br
+ u_t021_012/c3_w1_bl u_t021_012/c3_w1_br u_t021_012/c3_r0_rbl u_t021_012/c3_r1_rbl
+ u_t021_012/r0_w0_wl u_t021_012/r0_w1_wl u_t021_012/r0_r0_rwl u_t021_012/r0_r1_rwl
+ u_t021_012/r1_w0_wl u_t021_012/r1_w1_wl u_t021_012/r1_r0_rwl u_t021_012/r1_r1_rwl
+ u_t021_012/r2_w0_wl u_t021_012/r2_w1_wl u_t021_012/r2_r0_rwl u_t021_012/r2_r1_rwl
+ u_t021_012/r3_w0_wl u_t021_012/r3_w1_wl u_t021_012/r3_r0_rwl u_t021_012/r3_r1_rwl
+ VSS VSS u_t021_012/m2_717_1265# u_t021_012/m2_603_2031# u_t021_012/m2_1290_336#
+ u_t021_012/m2_2000_2037# u_t021_012/m2_791_2909# u_t021_012/m2_7_2126# u_t021_012/m2_2154_2081#
+ u_t021_012/m2_1795_2037# u_t021_012/m2_871_303# u_t021_012/m2_431_438# u_t021_012/m2_1290_2898#
+ u_t021_012/m2_1714_1210# u_t021_012/m2_431_1982# u_t021_012/m2_512_1265# u_t021_012/m2_2573_2126#
+ u_t021_012/m2_603_1259# u_t021_012/m2_2074_2909# u_t021_012/m2_7_336# u_t021_012/m2_717_2037#
+ u_t021_012/m2_1886_2031# u_t021_012/m2_2573_336# u_t021_012/m2_7_2898# u_t021_012/m2_2000_1265#
+ u_t021_012/m2_512_2037# u_t021_012/m2_1795_1265# u_t021_012/m2_1714_1982# u_t021_012/m2_1886_1259#
+ u_t021_012/m2_1290_2126# u_t021_012/m2_1714_438# u_t021_012/m2_431_1210# u_t021_012/m2_2573_2898#
+ u_t021_012/m2_2154_303# u_t021_012/m2_871_2081# VSUBS detronyx_12t_2w2r_rc4_4x4_routed_5layer_direct
Xu_t021_001 u_t021_001/c0_w0_bl u_t021_001/c0_w0_br u_t021_001/c0_w1_bl u_t021_001/c0_w1_br
+ u_t021_001/c0_r0_rbl u_t021_001/c0_r1_rbl u_t021_001/c1_w0_bl u_t021_001/c1_w0_br
+ u_t021_001/c1_w1_bl u_t021_001/c1_w1_br u_t021_001/c1_r0_rbl u_t021_001/c1_r1_rbl
+ u_t021_001/c2_w0_bl u_t021_001/c2_w0_br u_t021_001/c2_w1_bl u_t021_001/c2_w1_br
+ u_t021_001/c2_r0_rbl u_t021_001/c2_r1_rbl u_t021_001/c3_w0_bl u_t021_001/c3_w0_br
+ u_t021_001/c3_w1_bl u_t021_001/c3_w1_br u_t021_001/c3_r0_rbl u_t021_001/c3_r1_rbl
+ u_t021_001/r0_w0_wl u_t021_001/r0_w1_wl u_t021_001/r0_r0_rwl u_t021_001/r0_r1_rwl
+ u_t021_001/r1_w0_wl u_t021_001/r1_w1_wl u_t021_001/r1_r0_rwl u_t021_001/r1_r1_rwl
+ u_t021_001/r2_w0_wl u_t021_001/r2_w1_wl u_t021_001/r2_r0_rwl u_t021_001/r2_r1_rwl
+ u_t021_001/r3_w0_wl u_t021_001/r3_w1_wl u_t021_001/r3_r0_rwl u_t021_001/r3_r1_rwl
+ VSS VSS u_t021_001/m2_717_1265# u_t021_001/m2_603_2031# u_t021_001/m2_1290_336#
+ u_t021_001/m2_2000_2037# u_t021_001/m2_791_2909# u_t021_001/m2_7_2126# u_t021_001/m2_2154_2081#
+ u_t021_001/m2_1795_2037# u_t021_001/m2_871_303# u_t021_001/m2_431_438# u_t021_001/m2_1290_2898#
+ u_t021_001/m2_1714_1210# u_t021_001/m2_431_1982# u_t021_001/m2_512_1265# u_t021_001/m2_2573_2126#
+ u_t021_001/m2_603_1259# u_t021_001/m2_2074_2909# u_t021_001/m2_7_336# u_t021_001/m2_717_2037#
+ u_t021_001/m2_1886_2031# u_t021_001/m2_2573_336# u_t021_001/m2_7_2898# u_t021_001/m2_2000_1265#
+ u_t021_001/m2_512_2037# u_t021_001/m2_1795_1265# u_t021_001/m2_1714_1982# u_t021_001/m2_1886_1259#
+ u_t021_001/m2_1290_2126# u_t021_001/m2_1714_438# u_t021_001/m2_431_1210# u_t021_001/m2_2573_2898#
+ u_t021_001/m2_2154_303# u_t021_001/m2_871_2081# VSUBS detronyx_12t_2w2r_rc4_4x4_routed_5layer_direct
Xu_t012_012 u_t012_012/c0_w0_bl u_t012_012/c0_w0_br u_t012_012/c0_w1_bl u_t012_012/c0_w1_br
+ u_t012_012/c0_r0_rbl u_t012_012/c0_r1_rbl u_t012_012/c1_w0_bl u_t012_012/c1_w0_br
+ u_t012_012/c1_w1_bl u_t012_012/c1_w1_br u_t012_012/c1_r0_rbl u_t012_012/c1_r1_rbl
+ u_t012_012/c2_w0_bl u_t012_012/c2_w0_br u_t012_012/c2_w1_bl u_t012_012/c2_w1_br
+ u_t012_012/c2_r0_rbl u_t012_012/c2_r1_rbl u_t012_012/c3_w0_bl u_t012_012/c3_w0_br
+ u_t012_012/c3_w1_bl u_t012_012/c3_w1_br u_t012_012/c3_r0_rbl u_t012_012/c3_r1_rbl
+ u_t012_012/r0_w0_wl u_t012_012/r0_w1_wl u_t012_012/r0_r0_rwl u_t012_012/r0_r1_rwl
+ u_t012_012/r1_w0_wl u_t012_012/r1_w1_wl u_t012_012/r1_r0_rwl u_t012_012/r1_r1_rwl
+ u_t012_012/r2_w0_wl u_t012_012/r2_w1_wl u_t012_012/r2_r0_rwl u_t012_012/r2_r1_rwl
+ u_t012_012/r3_w0_wl u_t012_012/r3_w1_wl u_t012_012/r3_r0_rwl u_t012_012/r3_r1_rwl
+ VSS VSS u_t012_012/m2_717_1265# u_t012_012/m2_603_2031# u_t012_012/m2_1290_336#
+ u_t012_012/m2_2000_2037# u_t012_012/m2_791_2909# u_t012_012/m2_7_2126# u_t012_012/m2_2154_2081#
+ u_t012_012/m2_1795_2037# u_t012_012/m2_871_303# u_t012_012/m2_431_438# u_t012_012/m2_1290_2898#
+ u_t012_012/m2_1714_1210# u_t012_012/m2_431_1982# u_t012_012/m2_512_1265# u_t012_012/m2_2573_2126#
+ u_t012_012/m2_603_1259# u_t012_012/m2_2074_2909# u_t012_012/m2_7_336# u_t012_012/m2_717_2037#
+ u_t012_012/m2_1886_2031# u_t012_012/m2_2573_336# u_t012_012/m2_7_2898# u_t012_012/m2_2000_1265#
+ u_t012_012/m2_512_2037# u_t012_012/m2_1795_1265# u_t012_012/m2_1714_1982# u_t012_012/m2_1886_1259#
+ u_t012_012/m2_1290_2126# u_t012_012/m2_1714_438# u_t012_012/m2_431_1210# u_t012_012/m2_2573_2898#
+ u_t012_012/m2_2154_303# u_t012_012/m2_871_2081# VSUBS detronyx_12t_2w2r_rc4_4x4_routed_5layer_direct
Xu_t012_001 u_t012_001/c0_w0_bl u_t012_001/c0_w0_br u_t012_001/c0_w1_bl u_t012_001/c0_w1_br
+ u_t012_001/c0_r0_rbl u_t012_001/c0_r1_rbl u_t012_001/c1_w0_bl u_t012_001/c1_w0_br
+ u_t012_001/c1_w1_bl u_t012_001/c1_w1_br u_t012_001/c1_r0_rbl u_t012_001/c1_r1_rbl
+ u_t012_001/c2_w0_bl u_t012_001/c2_w0_br u_t012_001/c2_w1_bl u_t012_001/c2_w1_br
+ u_t012_001/c2_r0_rbl u_t012_001/c2_r1_rbl u_t012_001/c3_w0_bl u_t012_001/c3_w0_br
+ u_t012_001/c3_w1_bl u_t012_001/c3_w1_br u_t012_001/c3_r0_rbl u_t012_001/c3_r1_rbl
+ u_t012_001/r0_w0_wl u_t012_001/r0_w1_wl u_t012_001/r0_r0_rwl u_t012_001/r0_r1_rwl
+ u_t012_001/r1_w0_wl u_t012_001/r1_w1_wl u_t012_001/r1_r0_rwl u_t012_001/r1_r1_rwl
+ u_t012_001/r2_w0_wl u_t012_001/r2_w1_wl u_t012_001/r2_r0_rwl u_t012_001/r2_r1_rwl
+ u_t012_001/r3_w0_wl u_t012_001/r3_w1_wl u_t012_001/r3_r0_rwl u_t012_001/r3_r1_rwl
+ VSS VSS u_t012_001/m2_717_1265# u_t012_001/m2_603_2031# u_t012_001/m2_1290_336#
+ u_t012_001/m2_2000_2037# u_t012_001/m2_791_2909# u_t012_001/m2_7_2126# u_t012_001/m2_2154_2081#
+ u_t012_001/m2_1795_2037# u_t012_001/m2_871_303# u_t012_001/m2_431_438# u_t012_001/m2_1290_2898#
+ u_t012_001/m2_1714_1210# u_t012_001/m2_431_1982# u_t012_001/m2_512_1265# u_t012_001/m2_2573_2126#
+ u_t012_001/m2_603_1259# u_t012_001/m2_2074_2909# u_t012_001/m2_7_336# u_t012_001/m2_717_2037#
+ u_t012_001/m2_1886_2031# u_t012_001/m2_2573_336# u_t012_001/m2_7_2898# u_t012_001/m2_2000_1265#
+ u_t012_001/m2_512_2037# u_t012_001/m2_1795_1265# u_t012_001/m2_1714_1982# u_t012_001/m2_1886_1259#
+ u_t012_001/m2_1290_2126# u_t012_001/m2_1714_438# u_t012_001/m2_431_1210# u_t012_001/m2_2573_2898#
+ u_t012_001/m2_2154_303# u_t012_001/m2_871_2081# VSUBS detronyx_12t_2w2r_rc4_4x4_routed_5layer_direct
Xgf180mcu_as_sc_mcu7t3v3__inv_2_1471 VSS VSS VSS gf180mcu_as_sc_mcu7t3v3__inv_2_1472/Y
+ gf180mcu_as_sc_mcu7t3v3__inv_2_1473/VNW VSUBS gf180mcu_as_sc_mcu7t3v3__inv_2
Xgf180mcu_as_sc_mcu7t3v3__inv_2_1460 VSS VSS gf180mcu_as_sc_mcu7t3v3__inv_2_1460/Y
+ gf180mcu_as_sc_mcu7t3v3__inv_2_1461/Y gf180mcu_as_sc_mcu7t3v3__inv_2_1461/VNW VSUBS
+ gf180mcu_as_sc_mcu7t3v3__inv_2
Xgf180mcu_as_sc_mcu7t3v3__inv_2_1482 VSS VSS gf180mcu_as_sc_mcu7t3v3__inv_2_1482/Y
+ gf180mcu_as_sc_mcu7t3v3__inv_2_1482/A gf180mcu_as_sc_mcu7t3v3__inv_2_1482/VNW VSUBS
+ gf180mcu_as_sc_mcu7t3v3__inv_2
Xgf180mcu_as_sc_mcu7t3v3__inv_2_1493 VSS VSS gf180mcu_as_sc_mcu7t3v3__inv_2_1493/Y
+ gf180mcu_as_sc_mcu7t3v3__inv_2_1494/Y gf180mcu_as_sc_mcu7t3v3__inv_2_1494/VNW VSUBS
+ gf180mcu_as_sc_mcu7t3v3__inv_2
Xgf180mcu_as_sc_mcu7t3v3__inv_2_911 VSS VSS gf180mcu_as_sc_mcu7t3v3__inv_2_944/A gf180mcu_as_sc_mcu7t3v3__inv_2_912/Y
+ gf180mcu_as_sc_mcu7t3v3__inv_2_944/VNW VSUBS gf180mcu_as_sc_mcu7t3v3__inv_2
Xgf180mcu_as_sc_mcu7t3v3__inv_2_922 VSS VSS gf180mcu_as_sc_mcu7t3v3__inv_2_948/A gf180mcu_as_sc_mcu7t3v3__inv_2_923/Y
+ gf180mcu_as_sc_mcu7t3v3__inv_2_948/VNW VSUBS gf180mcu_as_sc_mcu7t3v3__inv_2
Xgf180mcu_as_sc_mcu7t3v3__inv_2_900 VSS VSS gf180mcu_as_sc_mcu7t3v3__inv_2_900/Y gf180mcu_as_sc_mcu7t3v3__inv_2_900/A
+ gf180mcu_as_sc_mcu7t3v3__inv_2_950/VNW VSUBS gf180mcu_as_sc_mcu7t3v3__inv_2
Xu_t003_012 u_t003_012/c0_w0_bl u_t003_012/c0_w0_br u_t003_012/c0_w1_bl u_t003_012/c0_w1_br
+ u_t003_012/c0_r0_rbl u_t003_012/c0_r1_rbl u_t003_012/c1_w0_bl u_t003_012/c1_w0_br
+ u_t003_012/c1_w1_bl u_t003_012/c1_w1_br u_t003_012/c1_r0_rbl u_t003_012/c1_r1_rbl
+ u_t003_012/c2_w0_bl u_t003_012/c2_w0_br u_t003_012/c2_w1_bl u_t003_012/c2_w1_br
+ u_t003_012/c2_r0_rbl u_t003_012/c2_r1_rbl u_t003_012/c3_w0_bl u_t003_012/c3_w0_br
+ u_t003_012/c3_w1_bl u_t003_012/c3_w1_br u_t003_012/c3_r0_rbl u_t003_012/c3_r1_rbl
+ u_t003_012/r0_w0_wl u_t003_012/r0_w1_wl u_t003_012/r0_r0_rwl u_t003_012/r0_r1_rwl
+ u_t003_012/r1_w0_wl u_t003_012/r1_w1_wl u_t003_012/r1_r0_rwl u_t003_012/r1_r1_rwl
+ u_t003_012/r2_w0_wl u_t003_012/r2_w1_wl u_t003_012/r2_r0_rwl u_t003_012/r2_r1_rwl
+ u_t003_012/r3_w0_wl u_t003_012/r3_w1_wl u_t003_012/r3_r0_rwl u_t003_012/r3_r1_rwl
+ VSS VSS u_t003_012/m2_717_1265# u_t003_012/m2_603_2031# u_t003_012/m2_1290_336#
+ u_t003_012/m2_2000_2037# u_t003_012/m2_791_2909# u_t003_012/m2_7_2126# u_t003_012/m2_2154_2081#
+ u_t003_012/m2_1795_2037# u_t003_012/m2_871_303# u_t003_012/m2_431_438# u_t003_012/m2_1290_2898#
+ u_t003_012/m2_1714_1210# u_t003_012/m2_431_1982# u_t003_012/m2_512_1265# u_t003_012/m2_2573_2126#
+ u_t003_012/m2_603_1259# u_t003_012/m2_2074_2909# u_t003_012/m2_7_336# u_t003_012/m2_717_2037#
+ u_t003_012/m2_1886_2031# u_t003_012/m2_2573_336# u_t003_012/m2_7_2898# u_t003_012/m2_2000_1265#
+ u_t003_012/m2_512_2037# u_t003_012/m2_1795_1265# u_t003_012/m2_1714_1982# u_t003_012/m2_1886_1259#
+ u_t003_012/m2_1290_2126# u_t003_012/m2_1714_438# u_t003_012/m2_431_1210# u_t003_012/m2_2573_2898#
+ u_t003_012/m2_2154_303# u_t003_012/m2_871_2081# VSUBS detronyx_12t_2w2r_rc4_4x4_routed_5layer_direct
Xu_t003_001 u_t003_001/c0_w0_bl u_t003_001/c0_w0_br u_t003_001/c0_w1_bl u_t003_001/c0_w1_br
+ u_t003_001/c0_r0_rbl u_t003_001/c0_r1_rbl u_t003_001/c1_w0_bl u_t003_001/c1_w0_br
+ u_t003_001/c1_w1_bl u_t003_001/c1_w1_br u_t003_001/c1_r0_rbl u_t003_001/c1_r1_rbl
+ u_t003_001/c2_w0_bl u_t003_001/c2_w0_br u_t003_001/c2_w1_bl u_t003_001/c2_w1_br
+ u_t003_001/c2_r0_rbl u_t003_001/c2_r1_rbl u_t003_001/c3_w0_bl u_t003_001/c3_w0_br
+ u_t003_001/c3_w1_bl u_t003_001/c3_w1_br u_t003_001/c3_r0_rbl u_t003_001/c3_r1_rbl
+ u_t003_001/r0_w0_wl u_t003_001/r0_w1_wl u_t003_001/r0_r0_rwl u_t003_001/r0_r1_rwl
+ u_t003_001/r1_w0_wl u_t003_001/r1_w1_wl u_t003_001/r1_r0_rwl u_t003_001/r1_r1_rwl
+ u_t003_001/r2_w0_wl u_t003_001/r2_w1_wl u_t003_001/r2_r0_rwl u_t003_001/r2_r1_rwl
+ u_t003_001/r3_w0_wl u_t003_001/r3_w1_wl u_t003_001/r3_r0_rwl u_t003_001/r3_r1_rwl
+ VSS VSS u_t003_001/m2_717_1265# u_t003_001/m2_603_2031# u_t003_001/m2_1290_336#
+ u_t003_001/m2_2000_2037# u_t003_001/m2_791_2909# u_t003_001/m2_7_2126# u_t003_001/m2_2154_2081#
+ u_t003_001/m2_1795_2037# u_t003_001/m2_871_303# u_t003_001/m2_431_438# u_t003_001/m2_1290_2898#
+ u_t003_001/m2_1714_1210# u_t003_001/m2_431_1982# u_t003_001/m2_512_1265# u_t003_001/m2_2573_2126#
+ u_t003_001/m2_603_1259# u_t003_001/m2_2074_2909# u_t003_001/m2_7_336# u_t003_001/m2_717_2037#
+ u_t003_001/m2_1886_2031# u_t003_001/m2_2573_336# u_t003_001/m2_7_2898# u_t003_001/m2_2000_1265#
+ u_t003_001/m2_512_2037# u_t003_001/m2_1795_1265# u_t003_001/m2_1714_1982# u_t003_001/m2_1886_1259#
+ u_t003_001/m2_1290_2126# u_t003_001/m2_1714_438# u_t003_001/m2_431_1210# u_t003_001/m2_2573_2898#
+ u_t003_001/m2_2154_303# u_t003_001/m2_871_2081# VSUBS detronyx_12t_2w2r_rc4_4x4_routed_5layer_direct
Xgf180mcu_as_sc_mcu7t3v3__inv_2_944 VSS VSS VSS gf180mcu_as_sc_mcu7t3v3__inv_2_944/A
+ gf180mcu_as_sc_mcu7t3v3__inv_2_944/VNW VSUBS gf180mcu_as_sc_mcu7t3v3__inv_2
Xgf180mcu_as_sc_mcu7t3v3__inv_2_955 VSS VSS VSS gf180mcu_as_sc_mcu7t3v3__inv_2_955/A
+ gf180mcu_as_sc_mcu7t3v3__inv_2_955/VNW VSUBS gf180mcu_as_sc_mcu7t3v3__inv_2
Xgf180mcu_as_sc_mcu7t3v3__inv_2_999 VSS VSS gf180mcu_as_sc_mcu7t3v3__inv_2_999/Y gf180mcu_as_sc_mcu7t3v3__inv_2_999/A
+ gf180mcu_as_sc_mcu7t3v3__inv_2_999/VNW VSUBS gf180mcu_as_sc_mcu7t3v3__inv_2
Xgf180mcu_as_sc_mcu7t3v3__inv_2_988 VSS VSS gf180mcu_as_sc_mcu7t3v3__inv_2_988/Y gf180mcu_as_sc_mcu7t3v3__inv_2_988/A
+ gf180mcu_as_sc_mcu7t3v3__inv_2_988/VNW VSUBS gf180mcu_as_sc_mcu7t3v3__inv_2
Xgf180mcu_as_sc_mcu7t3v3__inv_2_933 VSS VSS VSS gf180mcu_as_sc_mcu7t3v3__inv_2_933/A
+ gf180mcu_as_sc_mcu7t3v3__inv_2_933/VNW VSUBS gf180mcu_as_sc_mcu7t3v3__inv_2
Xgf180mcu_as_sc_mcu7t3v3__inv_2_977 VSS VSS VSS gf180mcu_as_sc_mcu7t3v3__inv_2_981/Y
+ gf180mcu_as_sc_mcu7t3v3__inv_2_985/VNW VSUBS gf180mcu_as_sc_mcu7t3v3__inv_2
Xgf180mcu_as_sc_mcu7t3v3__inv_2_966 VSS VSS VSS gf180mcu_as_sc_mcu7t3v3__inv_2_967/Y
+ gf180mcu_as_sc_mcu7t3v3__inv_2_968/VNW VSUBS gf180mcu_as_sc_mcu7t3v3__inv_2
Xgf180mcu_as_sc_mcu7t3v3__nand4_2_276 VSS VSS VSS VSS VSS VSS gf180mcu_as_sc_mcu7t3v3__inv_2_912/A
+ gf180mcu_as_sc_mcu7t3v3__inv_2_944/VNW VSUBS gf180mcu_as_sc_mcu7t3v3__nand4_2
Xgf180mcu_as_sc_mcu7t3v3__nand4_2_221 VSS VSS VSS VSS VSS VSS gf180mcu_as_sc_mcu7t3v3__inv_2_760/A
+ gf180mcu_as_sc_mcu7t3v3__inv_2_832/VNW VSUBS gf180mcu_as_sc_mcu7t3v3__nand4_2
Xgf180mcu_as_sc_mcu7t3v3__nand4_2_210 VSS VSS VSS VSS VSS VSS gf180mcu_as_sc_mcu7t3v3__inv_2_689/A
+ gf180mcu_as_sc_mcu7t3v3__inv_2_689/VNW VSUBS gf180mcu_as_sc_mcu7t3v3__nand4_2
Xgf180mcu_as_sc_mcu7t3v3__nand4_2_232 VSS VSS VSS VSS VSS VSS gf180mcu_as_sc_mcu7t3v3__inv_2_783/A
+ gf180mcu_as_sc_mcu7t3v3__inv_2_815/VNW VSUBS gf180mcu_as_sc_mcu7t3v3__nand4_2
Xgf180mcu_as_sc_mcu7t3v3__nand4_2_243 VSS VSS VSS VSS VSS VSS gf180mcu_as_sc_mcu7t3v3__inv_2_809/A
+ gf180mcu_as_sc_mcu7t3v3__inv_2_839/VNW VSUBS gf180mcu_as_sc_mcu7t3v3__nand4_2
Xgf180mcu_as_sc_mcu7t3v3__nand4_2_254 VSS VSS VSS VSS VSS VSS gf180mcu_as_sc_mcu7t3v3__inv_2_866/A
+ gf180mcu_as_sc_mcu7t3v3__inv_2_939/VNW VSUBS gf180mcu_as_sc_mcu7t3v3__nand4_2
Xgf180mcu_as_sc_mcu7t3v3__nand4_2_265 VSS VSS VSS VSS VSS VSS gf180mcu_as_sc_mcu7t3v3__inv_2_887/A
+ gf180mcu_as_sc_mcu7t3v3__inv_2_935/VNW VSUBS gf180mcu_as_sc_mcu7t3v3__nand4_2
Xgf180mcu_as_sc_mcu7t3v3__nand4_2_287 VSS VSS VSS VSS VSS VSS gf180mcu_as_sc_mcu7t3v3__inv_2_1061/A
+ gf180mcu_as_sc_mcu7t3v3__inv_2_1061/VNW VSUBS gf180mcu_as_sc_mcu7t3v3__nand4_2
Xgf180mcu_as_sc_mcu7t3v3__nand4_2_298 VSS VSS VSS VSS VSS VSS gf180mcu_as_sc_mcu7t3v3__inv_2_968/A
+ gf180mcu_as_sc_mcu7t3v3__inv_2_968/VNW VSUBS gf180mcu_as_sc_mcu7t3v3__nand4_2
Xgf180mcu_as_sc_mcu7t3v3__inv_2_207 VSS VSS VSS gf180mcu_as_sc_mcu7t3v3__inv_2_208/Y
+ gf180mcu_as_sc_mcu7t3v3__inv_2_209/VNW VSUBS gf180mcu_as_sc_mcu7t3v3__inv_2
Xu_t000_004 u_t000_004/c0_w0_bl u_t000_004/c0_w0_br u_t000_004/c0_w1_bl u_t000_004/c0_w1_br
+ u_t000_004/c0_r0_rbl u_t000_004/c0_r1_rbl u_t000_004/c1_w0_bl u_t000_004/c1_w0_br
+ u_t000_004/c1_w1_bl u_t000_004/c1_w1_br u_t000_004/c1_r0_rbl u_t000_004/c1_r1_rbl
+ u_t000_004/c2_w0_bl u_t000_004/c2_w0_br u_t000_004/c2_w1_bl u_t000_004/c2_w1_br
+ u_t000_004/c2_r0_rbl u_t000_004/c2_r1_rbl u_t000_004/c3_w0_bl u_t000_004/c3_w0_br
+ u_t000_004/c3_w1_bl u_t000_004/c3_w1_br u_t000_004/c3_r0_rbl u_t000_004/c3_r1_rbl
+ u_t000_004/r0_w0_wl u_t000_004/r0_w1_wl u_t000_004/r0_r0_rwl u_t000_004/r0_r1_rwl
+ u_t000_004/r1_w0_wl u_t000_004/r1_w1_wl u_t000_004/r1_r0_rwl u_t000_004/r1_r1_rwl
+ u_t000_004/r2_w0_wl u_t000_004/r2_w1_wl u_t000_004/r2_r0_rwl u_t000_004/r2_r1_rwl
+ u_t000_004/r3_w0_wl u_t000_004/r3_w1_wl u_t000_004/r3_r0_rwl u_t000_004/r3_r1_rwl
+ VSS VSS u_t000_004/m2_717_1265# u_t000_004/m2_603_2031# u_t000_004/m2_1290_336#
+ u_t000_004/m2_2000_2037# u_t000_004/m2_791_2909# u_t000_004/m2_7_2126# u_t000_004/m2_2154_2081#
+ u_t000_004/m2_1795_2037# u_t000_004/m2_871_303# u_t000_004/m2_431_438# u_t000_004/m2_1290_2898#
+ u_t000_004/m2_1714_1210# u_t000_004/m2_431_1982# u_t000_004/m2_512_1265# u_t000_004/m2_2573_2126#
+ u_t000_004/m2_603_1259# u_t000_004/m2_2074_2909# u_t000_004/m2_7_336# u_t000_004/m2_717_2037#
+ u_t000_004/m2_1886_2031# u_t000_004/m2_2573_336# u_t000_004/m2_7_2898# u_t000_004/m2_2000_1265#
+ u_t000_004/m2_512_2037# u_t000_004/m2_1795_1265# u_t000_004/m2_1714_1982# u_t000_004/m2_1886_1259#
+ u_t000_004/m2_1290_2126# u_t000_004/m2_1714_438# u_t000_004/m2_431_1210# u_t000_004/m2_2573_2898#
+ u_t000_004/m2_2154_303# u_t000_004/m2_871_2081# VSUBS detronyx_12t_2w2r_rc4_4x4_routed_5layer_direct
Xgf180mcu_as_sc_mcu7t3v3__inv_2_229 VSS VSS gf180mcu_as_sc_mcu7t3v3__inv_2_229/Y gf180mcu_as_sc_mcu7t3v3__inv_2_230/Y
+ gf180mcu_as_sc_mcu7t3v3__inv_2_230/VNW VSUBS gf180mcu_as_sc_mcu7t3v3__inv_2
Xgf180mcu_as_sc_mcu7t3v3__inv_2_218 VSS VSS gf180mcu_as_sc_mcu7t3v3__inv_2_218/Y gf180mcu_as_sc_mcu7t3v3__inv_2_218/A
+ gf180mcu_as_sc_mcu7t3v3__inv_2_218/VNW VSUBS gf180mcu_as_sc_mcu7t3v3__inv_2
Xu_t000_015 u_t000_015/c0_w0_bl u_t000_015/c0_w0_br u_t000_015/c0_w1_bl u_t000_015/c0_w1_br
+ u_t000_015/c0_r0_rbl u_t000_015/c0_r1_rbl u_t000_015/c1_w0_bl u_t000_015/c1_w0_br
+ u_t000_015/c1_w1_bl u_t000_015/c1_w1_br u_t000_015/c1_r0_rbl u_t000_015/c1_r1_rbl
+ u_t000_015/c2_w0_bl u_t000_015/c2_w0_br u_t000_015/c2_w1_bl u_t000_015/c2_w1_br
+ u_t000_015/c2_r0_rbl u_t000_015/c2_r1_rbl u_t000_015/c3_w0_bl u_t000_015/c3_w0_br
+ u_t000_015/c3_w1_bl u_t000_015/c3_w1_br u_t000_015/c3_r0_rbl u_t000_015/c3_r1_rbl
+ u_t000_015/r0_w0_wl u_t000_015/r0_w1_wl u_t000_015/r0_r0_rwl u_t000_015/r0_r1_rwl
+ u_t000_015/r1_w0_wl u_t000_015/r1_w1_wl u_t000_015/r1_r0_rwl u_t000_015/r1_r1_rwl
+ u_t000_015/r2_w0_wl u_t000_015/r2_w1_wl u_t000_015/r2_r0_rwl u_t000_015/r2_r1_rwl
+ u_t000_015/r3_w0_wl u_t000_015/r3_w1_wl u_t000_015/r3_r0_rwl u_t000_015/r3_r1_rwl
+ VSS VSS u_t000_015/m2_717_1265# u_t000_015/m2_603_2031# u_t000_015/m2_1290_336#
+ u_t000_015/m2_2000_2037# u_t000_015/m2_791_2909# u_t000_015/m2_7_2126# u_t000_015/m2_2154_2081#
+ u_t000_015/m2_1795_2037# u_t000_015/m2_871_303# u_t000_015/m2_431_438# u_t000_015/m2_1290_2898#
+ u_t000_015/m2_1714_1210# u_t000_015/m2_431_1982# u_t000_015/m2_512_1265# u_t000_015/m2_2573_2126#
+ u_t000_015/m2_603_1259# u_t000_015/m2_2074_2909# u_t000_015/m2_7_336# u_t000_015/m2_717_2037#
+ u_t000_015/m2_1886_2031# u_t000_015/m2_2573_336# u_t000_015/m2_7_2898# u_t000_015/m2_2000_1265#
+ u_t000_015/m2_512_2037# u_t000_015/m2_1795_1265# u_t000_015/m2_1714_1982# u_t000_015/m2_1886_1259#
+ u_t000_015/m2_1290_2126# u_t000_015/m2_1714_438# u_t000_015/m2_431_1210# u_t000_015/m2_2573_2898#
+ u_t000_015/m2_2154_303# u_t000_015/m2_871_2081# VSUBS detronyx_12t_2w2r_rc4_4x4_routed_5layer_direct
Xgf180mcu_as_sc_mcu7t3v3__inv_2_1290 VSS VSS VSS gf180mcu_as_sc_mcu7t3v3__inv_2_1290/A
+ gf180mcu_as_sc_mcu7t3v3__inv_2_1290/VNW VSUBS gf180mcu_as_sc_mcu7t3v3__inv_2
Xgf180mcu_as_sc_mcu7t3v3__inv_2_763 VSS VSS gf180mcu_as_sc_mcu7t3v3__inv_2_822/A gf180mcu_as_sc_mcu7t3v3__inv_2_764/Y
+ gf180mcu_as_sc_mcu7t3v3__inv_2_822/VNW VSUBS gf180mcu_as_sc_mcu7t3v3__inv_2
Xgf180mcu_as_sc_mcu7t3v3__inv_2_752 VSS VSS gf180mcu_as_sc_mcu7t3v3__inv_2_836/A gf180mcu_as_sc_mcu7t3v3__inv_2_756/Y
+ gf180mcu_as_sc_mcu7t3v3__inv_2_836/VNW VSUBS gf180mcu_as_sc_mcu7t3v3__inv_2
Xgf180mcu_as_sc_mcu7t3v3__inv_2_730 VSS VSS gf180mcu_as_sc_mcu7t3v3__inv_2_730/Y gf180mcu_as_sc_mcu7t3v3__inv_2_730/A
+ gf180mcu_as_sc_mcu7t3v3__inv_2_730/VNW VSUBS gf180mcu_as_sc_mcu7t3v3__inv_2
Xgf180mcu_as_sc_mcu7t3v3__inv_2_741 VSS VSS VSS gf180mcu_as_sc_mcu7t3v3__inv_2_741/A
+ gf180mcu_as_sc_mcu7t3v3__inv_2_741/VNW VSUBS gf180mcu_as_sc_mcu7t3v3__inv_2
Xgf180mcu_as_sc_mcu7t3v3__inv_2_774 VSS VSS gf180mcu_as_sc_mcu7t3v3__inv_2_826/A gf180mcu_as_sc_mcu7t3v3__inv_2_775/Y
+ gf180mcu_as_sc_mcu7t3v3__inv_2_826/VNW VSUBS gf180mcu_as_sc_mcu7t3v3__inv_2
Xgf180mcu_as_sc_mcu7t3v3__inv_2_785 VSS VSS gf180mcu_as_sc_mcu7t3v3__inv_2_816/A gf180mcu_as_sc_mcu7t3v3__inv_2_786/Y
+ gf180mcu_as_sc_mcu7t3v3__inv_2_816/VNW VSUBS gf180mcu_as_sc_mcu7t3v3__inv_2
Xgf180mcu_as_sc_mcu7t3v3__inv_2_796 VSS VSS gf180mcu_as_sc_mcu7t3v3__inv_2_851/A gf180mcu_as_sc_mcu7t3v3__inv_2_796/A
+ gf180mcu_as_sc_mcu7t3v3__inv_2_851/VNW VSUBS gf180mcu_as_sc_mcu7t3v3__inv_2
Xgf180mcu_as_sc_mcu7t3v3__inv_2_571 VSS VSS VSS gf180mcu_as_sc_mcu7t3v3__inv_2_572/Y
+ gf180mcu_as_sc_mcu7t3v3__inv_2_573/VNW VSUBS gf180mcu_as_sc_mcu7t3v3__inv_2
Xgf180mcu_as_sc_mcu7t3v3__inv_2_582 VSS VSS VSS gf180mcu_as_sc_mcu7t3v3__inv_2_583/Y
+ gf180mcu_as_sc_mcu7t3v3__inv_2_584/VNW VSUBS gf180mcu_as_sc_mcu7t3v3__inv_2
Xgf180mcu_as_sc_mcu7t3v3__inv_2_593 VSS VSS gf180mcu_as_sc_mcu7t3v3__inv_2_638/A gf180mcu_as_sc_mcu7t3v3__inv_2_594/Y
+ gf180mcu_as_sc_mcu7t3v3__inv_2_638/VNW VSUBS gf180mcu_as_sc_mcu7t3v3__inv_2
Xgf180mcu_as_sc_mcu7t3v3__inv_2_560 VSS VSS VSS gf180mcu_as_sc_mcu7t3v3__inv_2_560/A
+ gf180mcu_as_sc_mcu7t3v3__inv_2_560/VNW VSUBS gf180mcu_as_sc_mcu7t3v3__inv_2
Xgf180mcu_as_sc_mcu7t3v3__nor2_2_8 gf180mcu_as_sc_mcu7t3v3__nor2_2_9/VDD gf180mcu_as_sc_mcu7t3v3__nor2_2_9/VSS
+ VSS VSS VSS gf180mcu_as_sc_mcu7t3v3__nor2_2_9/VNW VSUBS gf180mcu_as_sc_mcu7t3v3__nor2_2
Xu_t028_007 u_t028_007/c0_w0_bl u_t028_007/c0_w0_br u_t028_007/c0_w1_bl u_t028_007/c0_w1_br
+ u_t028_007/c0_r0_rbl u_t028_007/c0_r1_rbl u_t028_007/c1_w0_bl u_t028_007/c1_w0_br
+ u_t028_007/c1_w1_bl u_t028_007/c1_w1_br u_t028_007/c1_r0_rbl u_t028_007/c1_r1_rbl
+ u_t028_007/c2_w0_bl u_t028_007/c2_w0_br u_t028_007/c2_w1_bl u_t028_007/c2_w1_br
+ u_t028_007/c2_r0_rbl u_t028_007/c2_r1_rbl u_t028_007/c3_w0_bl u_t028_007/c3_w0_br
+ u_t028_007/c3_w1_bl u_t028_007/c3_w1_br u_t028_007/c3_r0_rbl u_t028_007/c3_r1_rbl
+ u_t028_007/r0_w0_wl u_t028_007/r0_w1_wl u_t028_007/r0_r0_rwl u_t028_007/r0_r1_rwl
+ u_t028_007/r1_w0_wl u_t028_007/r1_w1_wl u_t028_007/r1_r0_rwl u_t028_007/r1_r1_rwl
+ u_t028_007/r2_w0_wl u_t028_007/r2_w1_wl u_t028_007/r2_r0_rwl u_t028_007/r2_r1_rwl
+ u_t028_007/r3_w0_wl u_t028_007/r3_w1_wl u_t028_007/r3_r0_rwl u_t028_007/r3_r1_rwl
+ VSS VSS u_t028_007/m2_717_1265# u_t028_007/m2_603_2031# u_t028_007/m2_1290_336#
+ u_t028_007/m2_2000_2037# u_t028_007/m2_791_2909# u_t028_007/m2_7_2126# u_t028_007/m2_2154_2081#
+ u_t028_007/m2_1795_2037# u_t028_007/m2_871_303# u_t028_007/m2_431_438# u_t028_007/m2_1290_2898#
+ u_t028_007/m2_1714_1210# u_t028_007/m2_431_1982# u_t028_007/m2_512_1265# u_t028_007/m2_2573_2126#
+ u_t028_007/m2_603_1259# u_t028_007/m2_2074_2909# u_t028_007/m2_7_336# u_t028_007/m2_717_2037#
+ u_t028_007/m2_1886_2031# u_t028_007/m2_2573_336# u_t028_007/m2_7_2898# u_t028_007/m2_2000_1265#
+ u_t028_007/m2_512_2037# u_t028_007/m2_1795_1265# u_t028_007/m2_1714_1982# u_t028_007/m2_1886_1259#
+ u_t028_007/m2_1290_2126# u_t028_007/m2_1714_438# u_t028_007/m2_431_1210# u_t028_007/m2_2573_2898#
+ u_t028_007/m2_2154_303# u_t028_007/m2_871_2081# VSUBS detronyx_12t_2w2r_rc4_4x4_routed_5layer_direct
Xgf180mcu_as_sc_mcu7t3v3__inv_2_390 gf180mcu_as_sc_mcu7t3v3__nand3_2_9/VDD gf180mcu_as_sc_mcu7t3v3__nor2_2_4/VSS
+ VSS VSS gf180mcu_as_sc_mcu7t3v3__nand3_2_9/VNW VSUBS gf180mcu_as_sc_mcu7t3v3__inv_2
Xu_t019_007 u_t019_007/c0_w0_bl u_t019_007/c0_w0_br u_t019_007/c0_w1_bl u_t019_007/c0_w1_br
+ u_t019_007/c0_r0_rbl u_t019_007/c0_r1_rbl u_t019_007/c1_w0_bl u_t019_007/c1_w0_br
+ u_t019_007/c1_w1_bl u_t019_007/c1_w1_br u_t019_007/c1_r0_rbl u_t019_007/c1_r1_rbl
+ u_t019_007/c2_w0_bl u_t019_007/c2_w0_br u_t019_007/c2_w1_bl u_t019_007/c2_w1_br
+ u_t019_007/c2_r0_rbl u_t019_007/c2_r1_rbl u_t019_007/c3_w0_bl u_t019_007/c3_w0_br
+ u_t019_007/c3_w1_bl u_t019_007/c3_w1_br u_t019_007/c3_r0_rbl u_t019_007/c3_r1_rbl
+ u_t019_007/r0_w0_wl u_t019_007/r0_w1_wl u_t019_007/r0_r0_rwl u_t019_007/r0_r1_rwl
+ u_t019_007/r1_w0_wl u_t019_007/r1_w1_wl u_t019_007/r1_r0_rwl u_t019_007/r1_r1_rwl
+ u_t019_007/r2_w0_wl u_t019_007/r2_w1_wl u_t019_007/r2_r0_rwl u_t019_007/r2_r1_rwl
+ u_t019_007/r3_w0_wl u_t019_007/r3_w1_wl u_t019_007/r3_r0_rwl u_t019_007/r3_r1_rwl
+ VSS VSS u_t019_007/m2_717_1265# u_t019_007/m2_603_2031# u_t019_007/m2_1290_336#
+ u_t019_007/m2_2000_2037# u_t019_007/m2_791_2909# u_t019_007/m2_7_2126# u_t019_007/m2_2154_2081#
+ u_t019_007/m2_1795_2037# u_t019_007/m2_871_303# u_t019_007/m2_431_438# u_t019_007/m2_1290_2898#
+ u_t019_007/m2_1714_1210# u_t019_007/m2_431_1982# u_t019_007/m2_512_1265# u_t019_007/m2_2573_2126#
+ u_t019_007/m2_603_1259# u_t019_007/m2_2074_2909# u_t019_007/m2_7_336# u_t019_007/m2_717_2037#
+ u_t019_007/m2_1886_2031# u_t019_007/m2_2573_336# u_t019_007/m2_7_2898# u_t019_007/m2_2000_1265#
+ u_t019_007/m2_512_2037# u_t019_007/m2_1795_1265# u_t019_007/m2_1714_1982# u_t019_007/m2_1886_1259#
+ u_t019_007/m2_1290_2126# u_t019_007/m2_1714_438# u_t019_007/m2_431_1210# u_t019_007/m2_2573_2898#
+ u_t019_007/m2_2154_303# u_t019_007/m2_871_2081# VSUBS detronyx_12t_2w2r_rc4_4x4_routed_5layer_direct
Xgf180mcu_as_sc_mcu7t3v3__inv_2_1108 VSS VSS gf180mcu_as_sc_mcu7t3v3__inv_2_1108/Y
+ gf180mcu_as_sc_mcu7t3v3__inv_2_1112/Y gf180mcu_as_sc_mcu7t3v3__inv_2_1112/VNW VSUBS
+ gf180mcu_as_sc_mcu7t3v3__inv_2
Xgf180mcu_as_sc_mcu7t3v3__inv_2_1119 VSS VSS VSS gf180mcu_as_sc_mcu7t3v3__inv_2_1120/Y
+ gf180mcu_as_sc_mcu7t3v3__inv_2_1121/VNW VSUBS gf180mcu_as_sc_mcu7t3v3__inv_2
Xu_t024_010 u_t024_010/c0_w0_bl u_t024_010/c0_w0_br u_t024_010/c0_w1_bl u_t024_010/c0_w1_br
+ u_t024_010/c0_r0_rbl u_t024_010/c0_r1_rbl u_t024_010/c1_w0_bl u_t024_010/c1_w0_br
+ u_t024_010/c1_w1_bl u_t024_010/c1_w1_br u_t024_010/c1_r0_rbl u_t024_010/c1_r1_rbl
+ u_t024_010/c2_w0_bl u_t024_010/c2_w0_br u_t024_010/c2_w1_bl u_t024_010/c2_w1_br
+ u_t024_010/c2_r0_rbl u_t024_010/c2_r1_rbl u_t024_010/c3_w0_bl u_t024_010/c3_w0_br
+ u_t024_010/c3_w1_bl u_t024_010/c3_w1_br u_t024_010/c3_r0_rbl u_t024_010/c3_r1_rbl
+ u_t024_010/r0_w0_wl u_t024_010/r0_w1_wl u_t024_010/r0_r0_rwl u_t024_010/r0_r1_rwl
+ u_t024_010/r1_w0_wl u_t024_010/r1_w1_wl u_t024_010/r1_r0_rwl u_t024_010/r1_r1_rwl
+ u_t024_010/r2_w0_wl u_t024_010/r2_w1_wl u_t024_010/r2_r0_rwl u_t024_010/r2_r1_rwl
+ u_t024_010/r3_w0_wl u_t024_010/r3_w1_wl u_t024_010/r3_r0_rwl u_t024_010/r3_r1_rwl
+ VSS VSS u_t024_010/m2_717_1265# u_t024_010/m2_603_2031# u_t024_010/m2_1290_336#
+ u_t024_010/m2_2000_2037# u_t024_010/m2_791_2909# u_t024_010/m2_7_2126# u_t024_010/m2_2154_2081#
+ u_t024_010/m2_1795_2037# u_t024_010/m2_871_303# u_t024_010/m2_431_438# u_t024_010/m2_1290_2898#
+ u_t024_010/m2_1714_1210# u_t024_010/m2_431_1982# u_t024_010/m2_512_1265# u_t024_010/m2_2573_2126#
+ u_t024_010/m2_603_1259# u_t024_010/m2_2074_2909# u_t024_010/m2_7_336# u_t024_010/m2_717_2037#
+ u_t024_010/m2_1886_2031# u_t024_010/m2_2573_336# u_t024_010/m2_7_2898# u_t024_010/m2_2000_1265#
+ u_t024_010/m2_512_2037# u_t024_010/m2_1795_1265# u_t024_010/m2_1714_1982# u_t024_010/m2_1886_1259#
+ u_t024_010/m2_1290_2126# u_t024_010/m2_1714_438# u_t024_010/m2_431_1210# u_t024_010/m2_2573_2898#
+ u_t024_010/m2_2154_303# u_t024_010/m2_871_2081# VSUBS detronyx_12t_2w2r_rc4_4x4_routed_5layer_direct
Xgf180mcu_as_sc_mcu7t3v3__nand3_2_55 gf180mcu_as_sc_mcu7t3v3__nand3_2_65/VDD gf180mcu_as_sc_mcu7t3v3__nor2_2_9/VSS
+ VSS VSS VSS VSS gf180mcu_as_sc_mcu7t3v3__nand3_2_65/VNW VSUBS gf180mcu_as_sc_mcu7t3v3__nand3_2
Xgf180mcu_as_sc_mcu7t3v3__nand3_2_44 gf180mcu_as_sc_mcu7t3v3__nand3_2_65/VDD gf180mcu_as_sc_mcu7t3v3__nand3_2_62/VSS
+ VSS VSS VSS VSS gf180mcu_as_sc_mcu7t3v3__nand3_2_65/VNW VSUBS gf180mcu_as_sc_mcu7t3v3__nand3_2
Xgf180mcu_as_sc_mcu7t3v3__nand3_2_33 gf180mcu_as_sc_mcu7t3v3__nand3_2_9/VDD gf180mcu_as_sc_mcu7t3v3__nor2_2_4/VSS
+ VSS VSS VSS VSS gf180mcu_as_sc_mcu7t3v3__nand3_2_9/VNW VSUBS gf180mcu_as_sc_mcu7t3v3__nand3_2
Xgf180mcu_as_sc_mcu7t3v3__nand3_2_22 gf180mcu_as_sc_mcu7t3v3__nand3_2_9/VDD gf180mcu_as_sc_mcu7t3v3__nor2_2_7/VSS
+ VSS VSS VSS VSS gf180mcu_as_sc_mcu7t3v3__nand3_2_9/VNW VSUBS gf180mcu_as_sc_mcu7t3v3__nand3_2
Xgf180mcu_as_sc_mcu7t3v3__nand3_2_11 gf180mcu_as_sc_mcu7t3v3__nor2_2_4/VDD gf180mcu_as_sc_mcu7t3v3__nor2_2_4/VSS
+ VSS VSS VSS VSS gf180mcu_as_sc_mcu7t3v3__nor2_2_4/VNW VSUBS gf180mcu_as_sc_mcu7t3v3__nand3_2
Xgf180mcu_as_sc_mcu7t3v3__inv_2_1642 VSS VSS gf180mcu_as_sc_mcu7t3v3__inv_2_1642/Y
+ gf180mcu_as_sc_mcu7t3v3__inv_2_1642/A gf180mcu_as_sc_mcu7t3v3__inv_2_1642/VNW VSUBS
+ gf180mcu_as_sc_mcu7t3v3__inv_2
Xgf180mcu_as_sc_mcu7t3v3__inv_2_1631 VSS VSS gf180mcu_as_sc_mcu7t3v3__inv_2_1631/Y
+ gf180mcu_as_sc_mcu7t3v3__inv_2_1631/A gf180mcu_as_sc_mcu7t3v3__inv_2_1631/VNW VSUBS
+ gf180mcu_as_sc_mcu7t3v3__inv_2
Xgf180mcu_as_sc_mcu7t3v3__inv_2_1653 VSS VSS gf180mcu_as_sc_mcu7t3v3__inv_2_1653/Y
+ gf180mcu_as_sc_mcu7t3v3__inv_2_1653/A gf180mcu_as_sc_mcu7t3v3__inv_2_1653/VNW VSUBS
+ gf180mcu_as_sc_mcu7t3v3__inv_2
Xgf180mcu_as_sc_mcu7t3v3__inv_2_1620 VSS VSS VSS gf180mcu_as_sc_mcu7t3v3__inv_2_1621/Y
+ gf180mcu_as_sc_mcu7t3v3__inv_2_1622/VNW VSUBS gf180mcu_as_sc_mcu7t3v3__inv_2
Xgf180mcu_as_sc_mcu7t3v3__inv_2_1664 VSS VSS gf180mcu_as_sc_mcu7t3v3__inv_2_1664/Y
+ gf180mcu_as_sc_mcu7t3v3__inv_2_1664/A gf180mcu_as_sc_mcu7t3v3__inv_2_1664/VNW VSUBS
+ gf180mcu_as_sc_mcu7t3v3__inv_2
Xgf180mcu_as_sc_mcu7t3v3__inv_2_1675 VSS VSS gf180mcu_as_sc_mcu7t3v3__inv_2_1675/Y
+ gf180mcu_as_sc_mcu7t3v3__inv_2_1676/Y gf180mcu_as_sc_mcu7t3v3__inv_2_1676/VNW VSUBS
+ gf180mcu_as_sc_mcu7t3v3__inv_2
Xgf180mcu_as_sc_mcu7t3v3__inv_2_1686 VSS VSS VSS gf180mcu_as_sc_mcu7t3v3__inv_2_1687/Y
+ gf180mcu_as_sc_mcu7t3v3__inv_2_1688/VNW VSUBS gf180mcu_as_sc_mcu7t3v3__inv_2
Xgf180mcu_as_sc_mcu7t3v3__inv_2_1697 VSS VSS gf180mcu_as_sc_mcu7t3v3__inv_2_1697/Y
+ gf180mcu_as_sc_mcu7t3v3__inv_2_1697/A gf180mcu_as_sc_mcu7t3v3__inv_2_1697/VNW VSUBS
+ gf180mcu_as_sc_mcu7t3v3__inv_2
Xu_t030_013 u_t030_013/c0_w0_bl u_t030_013/c0_w0_br u_t030_013/c0_w1_bl u_t030_013/c0_w1_br
+ u_t030_013/c0_r0_rbl u_t030_013/c0_r1_rbl u_t030_013/c1_w0_bl u_t030_013/c1_w0_br
+ u_t030_013/c1_w1_bl u_t030_013/c1_w1_br u_t030_013/c1_r0_rbl u_t030_013/c1_r1_rbl
+ u_t030_013/c2_w0_bl u_t030_013/c2_w0_br u_t030_013/c2_w1_bl u_t030_013/c2_w1_br
+ u_t030_013/c2_r0_rbl u_t030_013/c2_r1_rbl u_t030_013/c3_w0_bl u_t030_013/c3_w0_br
+ u_t030_013/c3_w1_bl u_t030_013/c3_w1_br u_t030_013/c3_r0_rbl u_t030_013/c3_r1_rbl
+ u_t030_013/r0_w0_wl u_t030_013/r0_w1_wl u_t030_013/r0_r0_rwl u_t030_013/r0_r1_rwl
+ u_t030_013/r1_w0_wl u_t030_013/r1_w1_wl u_t030_013/r1_r0_rwl u_t030_013/r1_r1_rwl
+ u_t030_013/r2_w0_wl u_t030_013/r2_w1_wl u_t030_013/r2_r0_rwl u_t030_013/r2_r1_rwl
+ u_t030_013/r3_w0_wl u_t030_013/r3_w1_wl u_t030_013/r3_r0_rwl u_t030_013/r3_r1_rwl
+ VSS VSS u_t030_013/m2_717_1265# u_t030_013/m2_603_2031# u_t030_013/m2_1290_336#
+ u_t030_013/m2_2000_2037# u_t030_013/m2_791_2909# u_t030_013/m2_7_2126# u_t030_013/m2_2154_2081#
+ u_t030_013/m2_1795_2037# u_t030_013/m2_871_303# u_t030_013/m2_431_438# u_t030_013/m2_1290_2898#
+ u_t030_013/m2_1714_1210# u_t030_013/m2_431_1982# u_t030_013/m2_512_1265# u_t030_013/m2_2573_2126#
+ u_t030_013/m2_603_1259# u_t030_013/m2_2074_2909# u_t030_013/m2_7_336# u_t030_013/m2_717_2037#
+ u_t030_013/m2_1886_2031# u_t030_013/m2_2573_336# u_t030_013/m2_7_2898# u_t030_013/m2_2000_1265#
+ u_t030_013/m2_512_2037# u_t030_013/m2_1795_1265# u_t030_013/m2_1714_1982# u_t030_013/m2_1886_1259#
+ u_t030_013/m2_1290_2126# u_t030_013/m2_1714_438# u_t030_013/m2_431_1210# u_t030_013/m2_2573_2898#
+ u_t030_013/m2_2154_303# u_t030_013/m2_871_2081# VSUBS detronyx_12t_2w2r_rc4_4x4_routed_5layer_direct
Xu_t015_010 u_t015_010/c0_w0_bl u_t015_010/c0_w0_br u_t015_010/c0_w1_bl u_t015_010/c0_w1_br
+ u_t015_010/c0_r0_rbl u_t015_010/c0_r1_rbl u_t015_010/c1_w0_bl u_t015_010/c1_w0_br
+ u_t015_010/c1_w1_bl u_t015_010/c1_w1_br u_t015_010/c1_r0_rbl u_t015_010/c1_r1_rbl
+ u_t015_010/c2_w0_bl u_t015_010/c2_w0_br u_t015_010/c2_w1_bl u_t015_010/c2_w1_br
+ u_t015_010/c2_r0_rbl u_t015_010/c2_r1_rbl u_t015_010/c3_w0_bl u_t015_010/c3_w0_br
+ u_t015_010/c3_w1_bl u_t015_010/c3_w1_br u_t015_010/c3_r0_rbl u_t015_010/c3_r1_rbl
+ u_t015_010/r0_w0_wl u_t015_010/r0_w1_wl u_t015_010/r0_r0_rwl u_t015_010/r0_r1_rwl
+ u_t015_010/r1_w0_wl u_t015_010/r1_w1_wl u_t015_010/r1_r0_rwl u_t015_010/r1_r1_rwl
+ u_t015_010/r2_w0_wl u_t015_010/r2_w1_wl u_t015_010/r2_r0_rwl u_t015_010/r2_r1_rwl
+ u_t015_010/r3_w0_wl u_t015_010/r3_w1_wl u_t015_010/r3_r0_rwl u_t015_010/r3_r1_rwl
+ VSS VSS u_t015_010/m2_717_1265# u_t015_010/m2_603_2031# u_t015_010/m2_1290_336#
+ u_t015_010/m2_2000_2037# u_t015_010/m2_791_2909# u_t015_010/m2_7_2126# u_t015_010/m2_2154_2081#
+ u_t015_010/m2_1795_2037# u_t015_010/m2_871_303# u_t015_010/m2_431_438# u_t015_010/m2_1290_2898#
+ u_t015_010/m2_1714_1210# u_t015_010/m2_431_1982# u_t015_010/m2_512_1265# u_t015_010/m2_2573_2126#
+ u_t015_010/m2_603_1259# u_t015_010/m2_2074_2909# u_t015_010/m2_7_336# u_t015_010/m2_717_2037#
+ u_t015_010/m2_1886_2031# u_t015_010/m2_2573_336# u_t015_010/m2_7_2898# u_t015_010/m2_2000_1265#
+ u_t015_010/m2_512_2037# u_t015_010/m2_1795_1265# u_t015_010/m2_1714_1982# u_t015_010/m2_1886_1259#
+ u_t015_010/m2_1290_2126# u_t015_010/m2_1714_438# u_t015_010/m2_431_1210# u_t015_010/m2_2573_2898#
+ u_t015_010/m2_2154_303# u_t015_010/m2_871_2081# VSUBS detronyx_12t_2w2r_rc4_4x4_routed_5layer_direct
Xu_t030_002 u_t030_002/c0_w0_bl u_t030_002/c0_w0_br u_t030_002/c0_w1_bl u_t030_002/c0_w1_br
+ u_t030_002/c0_r0_rbl u_t030_002/c0_r1_rbl u_t030_002/c1_w0_bl u_t030_002/c1_w0_br
+ u_t030_002/c1_w1_bl u_t030_002/c1_w1_br u_t030_002/c1_r0_rbl u_t030_002/c1_r1_rbl
+ u_t030_002/c2_w0_bl u_t030_002/c2_w0_br u_t030_002/c2_w1_bl u_t030_002/c2_w1_br
+ u_t030_002/c2_r0_rbl u_t030_002/c2_r1_rbl u_t030_002/c3_w0_bl u_t030_002/c3_w0_br
+ u_t030_002/c3_w1_bl u_t030_002/c3_w1_br u_t030_002/c3_r0_rbl u_t030_002/c3_r1_rbl
+ u_t030_002/r0_w0_wl u_t030_002/r0_w1_wl u_t030_002/r0_r0_rwl u_t030_002/r0_r1_rwl
+ u_t030_002/r1_w0_wl u_t030_002/r1_w1_wl u_t030_002/r1_r0_rwl u_t030_002/r1_r1_rwl
+ u_t030_002/r2_w0_wl u_t030_002/r2_w1_wl u_t030_002/r2_r0_rwl u_t030_002/r2_r1_rwl
+ u_t030_002/r3_w0_wl u_t030_002/r3_w1_wl u_t030_002/r3_r0_rwl u_t030_002/r3_r1_rwl
+ VSS VSS u_t030_002/m2_717_1265# u_t030_002/m2_603_2031# u_t030_002/m2_1290_336#
+ u_t030_002/m2_2000_2037# u_t030_002/m2_791_2909# u_t030_002/m2_7_2126# u_t030_002/m2_2154_2081#
+ u_t030_002/m2_1795_2037# u_t030_002/m2_871_303# u_t030_002/m2_431_438# u_t030_002/m2_1290_2898#
+ u_t030_002/m2_1714_1210# u_t030_002/m2_431_1982# u_t030_002/m2_512_1265# u_t030_002/m2_2573_2126#
+ u_t030_002/m2_603_1259# u_t030_002/m2_2074_2909# u_t030_002/m2_7_336# u_t030_002/m2_717_2037#
+ u_t030_002/m2_1886_2031# u_t030_002/m2_2573_336# u_t030_002/m2_7_2898# u_t030_002/m2_2000_1265#
+ u_t030_002/m2_512_2037# u_t030_002/m2_1795_1265# u_t030_002/m2_1714_1982# u_t030_002/m2_1886_1259#
+ u_t030_002/m2_1290_2126# u_t030_002/m2_1714_438# u_t030_002/m2_431_1210# u_t030_002/m2_2573_2898#
+ u_t030_002/m2_2154_303# u_t030_002/m2_871_2081# VSUBS detronyx_12t_2w2r_rc4_4x4_routed_5layer_direct
Xgf180mcu_as_sc_mcu7t3v3__nand4_2_436 VSS VSS VSS VSS VSS VSS gf180mcu_as_sc_mcu7t3v3__inv_2_1579/A
+ gf180mcu_as_sc_mcu7t3v3__inv_2_1579/VNW VSUBS gf180mcu_as_sc_mcu7t3v3__nand4_2
Xgf180mcu_as_sc_mcu7t3v3__nand4_2_425 VSS VSS VSS VSS VSS VSS gf180mcu_as_sc_mcu7t3v3__inv_2_1547/A
+ gf180mcu_as_sc_mcu7t3v3__inv_2_1547/VNW VSUBS gf180mcu_as_sc_mcu7t3v3__nand4_2
Xgf180mcu_as_sc_mcu7t3v3__nand4_2_414 VSS VSS VSS VSS VSS VSS gf180mcu_as_sc_mcu7t3v3__inv_2_1514/A
+ gf180mcu_as_sc_mcu7t3v3__inv_2_1514/VNW VSUBS gf180mcu_as_sc_mcu7t3v3__nand4_2
Xgf180mcu_as_sc_mcu7t3v3__nand4_2_469 VSS VSS VSS VSS VSS VSS gf180mcu_as_sc_mcu7t3v3__inv_2_1382/A
+ gf180mcu_as_sc_mcu7t3v3__inv_2_1382/VNW VSUBS gf180mcu_as_sc_mcu7t3v3__nand4_2
Xgf180mcu_as_sc_mcu7t3v3__nand4_2_403 VSS VSS VSS VSS VSS VSS gf180mcu_as_sc_mcu7t3v3__inv_2_1477/A
+ gf180mcu_as_sc_mcu7t3v3__inv_2_1508/VNW VSUBS gf180mcu_as_sc_mcu7t3v3__nand4_2
Xgf180mcu_as_sc_mcu7t3v3__nand4_2_447 VSS VSS VSS VSS VSS VSS gf180mcu_as_sc_mcu7t3v3__inv_2_1324/A
+ gf180mcu_as_sc_mcu7t3v3__inv_2_1324/VNW VSUBS gf180mcu_as_sc_mcu7t3v3__nand4_2
Xgf180mcu_as_sc_mcu7t3v3__nand4_2_458 VSS VSS VSS VSS VSS VSS gf180mcu_as_sc_mcu7t3v3__inv_2_1320/A
+ gf180mcu_as_sc_mcu7t3v3__inv_2_1320/VNW VSUBS gf180mcu_as_sc_mcu7t3v3__nand4_2
Xu_t006_010 u_t006_010/c0_w0_bl u_t006_010/c0_w0_br u_t006_010/c0_w1_bl u_t006_010/c0_w1_br
+ u_t006_010/c0_r0_rbl u_t006_010/c0_r1_rbl u_t006_010/c1_w0_bl u_t006_010/c1_w0_br
+ u_t006_010/c1_w1_bl u_t006_010/c1_w1_br u_t006_010/c1_r0_rbl u_t006_010/c1_r1_rbl
+ u_t006_010/c2_w0_bl u_t006_010/c2_w0_br u_t006_010/c2_w1_bl u_t006_010/c2_w1_br
+ u_t006_010/c2_r0_rbl u_t006_010/c2_r1_rbl u_t006_010/c3_w0_bl u_t006_010/c3_w0_br
+ u_t006_010/c3_w1_bl u_t006_010/c3_w1_br u_t006_010/c3_r0_rbl u_t006_010/c3_r1_rbl
+ u_t006_010/r0_w0_wl u_t006_010/r0_w1_wl u_t006_010/r0_r0_rwl u_t006_010/r0_r1_rwl
+ u_t006_010/r1_w0_wl u_t006_010/r1_w1_wl u_t006_010/r1_r0_rwl u_t006_010/r1_r1_rwl
+ u_t006_010/r2_w0_wl u_t006_010/r2_w1_wl u_t006_010/r2_r0_rwl u_t006_010/r2_r1_rwl
+ u_t006_010/r3_w0_wl u_t006_010/r3_w1_wl u_t006_010/r3_r0_rwl u_t006_010/r3_r1_rwl
+ VSS VSS u_t006_010/m2_717_1265# u_t006_010/m2_603_2031# u_t006_010/m2_1290_336#
+ u_t006_010/m2_2000_2037# u_t006_010/m2_791_2909# u_t006_010/m2_7_2126# u_t006_010/m2_2154_2081#
+ u_t006_010/m2_1795_2037# u_t006_010/m2_871_303# u_t006_010/m2_431_438# u_t006_010/m2_1290_2898#
+ u_t006_010/m2_1714_1210# u_t006_010/m2_431_1982# u_t006_010/m2_512_1265# u_t006_010/m2_2573_2126#
+ u_t006_010/m2_603_1259# u_t006_010/m2_2074_2909# u_t006_010/m2_7_336# u_t006_010/m2_717_2037#
+ u_t006_010/m2_1886_2031# u_t006_010/m2_2573_336# u_t006_010/m2_7_2898# u_t006_010/m2_2000_1265#
+ u_t006_010/m2_512_2037# u_t006_010/m2_1795_1265# u_t006_010/m2_1714_1982# u_t006_010/m2_1886_1259#
+ u_t006_010/m2_1290_2126# u_t006_010/m2_1714_438# u_t006_010/m2_431_1210# u_t006_010/m2_2573_2898#
+ u_t006_010/m2_2154_303# u_t006_010/m2_871_2081# VSUBS detronyx_12t_2w2r_rc4_4x4_routed_5layer_direct
Xgf180mcu_as_sc_mcu7t3v3__inv_2_4 VSS VSS gf180mcu_as_sc_mcu7t3v3__inv_2_4/Y gf180mcu_as_sc_mcu7t3v3__inv_2_4/A
+ gf180mcu_as_sc_mcu7t3v3__inv_2_4/VNW VSUBS gf180mcu_as_sc_mcu7t3v3__inv_2
Xu_t021_013 u_t021_013/c0_w0_bl u_t021_013/c0_w0_br u_t021_013/c0_w1_bl u_t021_013/c0_w1_br
+ u_t021_013/c0_r0_rbl u_t021_013/c0_r1_rbl u_t021_013/c1_w0_bl u_t021_013/c1_w0_br
+ u_t021_013/c1_w1_bl u_t021_013/c1_w1_br u_t021_013/c1_r0_rbl u_t021_013/c1_r1_rbl
+ u_t021_013/c2_w0_bl u_t021_013/c2_w0_br u_t021_013/c2_w1_bl u_t021_013/c2_w1_br
+ u_t021_013/c2_r0_rbl u_t021_013/c2_r1_rbl u_t021_013/c3_w0_bl u_t021_013/c3_w0_br
+ u_t021_013/c3_w1_bl u_t021_013/c3_w1_br u_t021_013/c3_r0_rbl u_t021_013/c3_r1_rbl
+ u_t021_013/r0_w0_wl u_t021_013/r0_w1_wl u_t021_013/r0_r0_rwl u_t021_013/r0_r1_rwl
+ u_t021_013/r1_w0_wl u_t021_013/r1_w1_wl u_t021_013/r1_r0_rwl u_t021_013/r1_r1_rwl
+ u_t021_013/r2_w0_wl u_t021_013/r2_w1_wl u_t021_013/r2_r0_rwl u_t021_013/r2_r1_rwl
+ u_t021_013/r3_w0_wl u_t021_013/r3_w1_wl u_t021_013/r3_r0_rwl u_t021_013/r3_r1_rwl
+ VSS VSS u_t021_013/m2_717_1265# u_t021_013/m2_603_2031# u_t021_013/m2_1290_336#
+ u_t021_013/m2_2000_2037# u_t021_013/m2_791_2909# u_t021_013/m2_7_2126# u_t021_013/m2_2154_2081#
+ u_t021_013/m2_1795_2037# u_t021_013/m2_871_303# u_t021_013/m2_431_438# u_t021_013/m2_1290_2898#
+ u_t021_013/m2_1714_1210# u_t021_013/m2_431_1982# u_t021_013/m2_512_1265# u_t021_013/m2_2573_2126#
+ u_t021_013/m2_603_1259# u_t021_013/m2_2074_2909# u_t021_013/m2_7_336# u_t021_013/m2_717_2037#
+ u_t021_013/m2_1886_2031# u_t021_013/m2_2573_336# u_t021_013/m2_7_2898# u_t021_013/m2_2000_1265#
+ u_t021_013/m2_512_2037# u_t021_013/m2_1795_1265# u_t021_013/m2_1714_1982# u_t021_013/m2_1886_1259#
+ u_t021_013/m2_1290_2126# u_t021_013/m2_1714_438# u_t021_013/m2_431_1210# u_t021_013/m2_2573_2898#
+ u_t021_013/m2_2154_303# u_t021_013/m2_871_2081# VSUBS detronyx_12t_2w2r_rc4_4x4_routed_5layer_direct
Xu_t021_002 u_t021_002/c0_w0_bl u_t021_002/c0_w0_br u_t021_002/c0_w1_bl u_t021_002/c0_w1_br
+ u_t021_002/c0_r0_rbl u_t021_002/c0_r1_rbl u_t021_002/c1_w0_bl u_t021_002/c1_w0_br
+ u_t021_002/c1_w1_bl u_t021_002/c1_w1_br u_t021_002/c1_r0_rbl u_t021_002/c1_r1_rbl
+ u_t021_002/c2_w0_bl u_t021_002/c2_w0_br u_t021_002/c2_w1_bl u_t021_002/c2_w1_br
+ u_t021_002/c2_r0_rbl u_t021_002/c2_r1_rbl u_t021_002/c3_w0_bl u_t021_002/c3_w0_br
+ u_t021_002/c3_w1_bl u_t021_002/c3_w1_br u_t021_002/c3_r0_rbl u_t021_002/c3_r1_rbl
+ u_t021_002/r0_w0_wl u_t021_002/r0_w1_wl u_t021_002/r0_r0_rwl u_t021_002/r0_r1_rwl
+ u_t021_002/r1_w0_wl u_t021_002/r1_w1_wl u_t021_002/r1_r0_rwl u_t021_002/r1_r1_rwl
+ u_t021_002/r2_w0_wl u_t021_002/r2_w1_wl u_t021_002/r2_r0_rwl u_t021_002/r2_r1_rwl
+ u_t021_002/r3_w0_wl u_t021_002/r3_w1_wl u_t021_002/r3_r0_rwl u_t021_002/r3_r1_rwl
+ VSS VSS u_t021_002/m2_717_1265# u_t021_002/m2_603_2031# u_t021_002/m2_1290_336#
+ u_t021_002/m2_2000_2037# u_t021_002/m2_791_2909# u_t021_002/m2_7_2126# u_t021_002/m2_2154_2081#
+ u_t021_002/m2_1795_2037# u_t021_002/m2_871_303# u_t021_002/m2_431_438# u_t021_002/m2_1290_2898#
+ u_t021_002/m2_1714_1210# u_t021_002/m2_431_1982# u_t021_002/m2_512_1265# u_t021_002/m2_2573_2126#
+ u_t021_002/m2_603_1259# u_t021_002/m2_2074_2909# u_t021_002/m2_7_336# u_t021_002/m2_717_2037#
+ u_t021_002/m2_1886_2031# u_t021_002/m2_2573_336# u_t021_002/m2_7_2898# u_t021_002/m2_2000_1265#
+ u_t021_002/m2_512_2037# u_t021_002/m2_1795_1265# u_t021_002/m2_1714_1982# u_t021_002/m2_1886_1259#
+ u_t021_002/m2_1290_2126# u_t021_002/m2_1714_438# u_t021_002/m2_431_1210# u_t021_002/m2_2573_2898#
+ u_t021_002/m2_2154_303# u_t021_002/m2_871_2081# VSUBS detronyx_12t_2w2r_rc4_4x4_routed_5layer_direct
Xu_t012_013 u_t012_013/c0_w0_bl u_t012_013/c0_w0_br u_t012_013/c0_w1_bl u_t012_013/c0_w1_br
+ u_t012_013/c0_r0_rbl u_t012_013/c0_r1_rbl u_t012_013/c1_w0_bl u_t012_013/c1_w0_br
+ u_t012_013/c1_w1_bl u_t012_013/c1_w1_br u_t012_013/c1_r0_rbl u_t012_013/c1_r1_rbl
+ u_t012_013/c2_w0_bl u_t012_013/c2_w0_br u_t012_013/c2_w1_bl u_t012_013/c2_w1_br
+ u_t012_013/c2_r0_rbl u_t012_013/c2_r1_rbl u_t012_013/c3_w0_bl u_t012_013/c3_w0_br
+ u_t012_013/c3_w1_bl u_t012_013/c3_w1_br u_t012_013/c3_r0_rbl u_t012_013/c3_r1_rbl
+ u_t012_013/r0_w0_wl u_t012_013/r0_w1_wl u_t012_013/r0_r0_rwl u_t012_013/r0_r1_rwl
+ u_t012_013/r1_w0_wl u_t012_013/r1_w1_wl u_t012_013/r1_r0_rwl u_t012_013/r1_r1_rwl
+ u_t012_013/r2_w0_wl u_t012_013/r2_w1_wl u_t012_013/r2_r0_rwl u_t012_013/r2_r1_rwl
+ u_t012_013/r3_w0_wl u_t012_013/r3_w1_wl u_t012_013/r3_r0_rwl u_t012_013/r3_r1_rwl
+ VSS VSS u_t012_013/m2_717_1265# u_t012_013/m2_603_2031# u_t012_013/m2_1290_336#
+ u_t012_013/m2_2000_2037# u_t012_013/m2_791_2909# u_t012_013/m2_7_2126# u_t012_013/m2_2154_2081#
+ u_t012_013/m2_1795_2037# u_t012_013/m2_871_303# u_t012_013/m2_431_438# u_t012_013/m2_1290_2898#
+ u_t012_013/m2_1714_1210# u_t012_013/m2_431_1982# u_t012_013/m2_512_1265# u_t012_013/m2_2573_2126#
+ u_t012_013/m2_603_1259# u_t012_013/m2_2074_2909# u_t012_013/m2_7_336# u_t012_013/m2_717_2037#
+ u_t012_013/m2_1886_2031# u_t012_013/m2_2573_336# u_t012_013/m2_7_2898# u_t012_013/m2_2000_1265#
+ u_t012_013/m2_512_2037# u_t012_013/m2_1795_1265# u_t012_013/m2_1714_1982# u_t012_013/m2_1886_1259#
+ u_t012_013/m2_1290_2126# u_t012_013/m2_1714_438# u_t012_013/m2_431_1210# u_t012_013/m2_2573_2898#
+ u_t012_013/m2_2154_303# u_t012_013/m2_871_2081# VSUBS detronyx_12t_2w2r_rc4_4x4_routed_5layer_direct
Xu_t012_002 u_t012_002/c0_w0_bl u_t012_002/c0_w0_br u_t012_002/c0_w1_bl u_t012_002/c0_w1_br
+ u_t012_002/c0_r0_rbl u_t012_002/c0_r1_rbl u_t012_002/c1_w0_bl u_t012_002/c1_w0_br
+ u_t012_002/c1_w1_bl u_t012_002/c1_w1_br u_t012_002/c1_r0_rbl u_t012_002/c1_r1_rbl
+ u_t012_002/c2_w0_bl u_t012_002/c2_w0_br u_t012_002/c2_w1_bl u_t012_002/c2_w1_br
+ u_t012_002/c2_r0_rbl u_t012_002/c2_r1_rbl u_t012_002/c3_w0_bl u_t012_002/c3_w0_br
+ u_t012_002/c3_w1_bl u_t012_002/c3_w1_br u_t012_002/c3_r0_rbl u_t012_002/c3_r1_rbl
+ u_t012_002/r0_w0_wl u_t012_002/r0_w1_wl u_t012_002/r0_r0_rwl u_t012_002/r0_r1_rwl
+ u_t012_002/r1_w0_wl u_t012_002/r1_w1_wl u_t012_002/r1_r0_rwl u_t012_002/r1_r1_rwl
+ u_t012_002/r2_w0_wl u_t012_002/r2_w1_wl u_t012_002/r2_r0_rwl u_t012_002/r2_r1_rwl
+ u_t012_002/r3_w0_wl u_t012_002/r3_w1_wl u_t012_002/r3_r0_rwl u_t012_002/r3_r1_rwl
+ VSS VSS u_t012_002/m2_717_1265# u_t012_002/m2_603_2031# u_t012_002/m2_1290_336#
+ u_t012_002/m2_2000_2037# u_t012_002/m2_791_2909# u_t012_002/m2_7_2126# u_t012_002/m2_2154_2081#
+ u_t012_002/m2_1795_2037# u_t012_002/m2_871_303# u_t012_002/m2_431_438# u_t012_002/m2_1290_2898#
+ u_t012_002/m2_1714_1210# u_t012_002/m2_431_1982# u_t012_002/m2_512_1265# u_t012_002/m2_2573_2126#
+ u_t012_002/m2_603_1259# u_t012_002/m2_2074_2909# u_t012_002/m2_7_336# u_t012_002/m2_717_2037#
+ u_t012_002/m2_1886_2031# u_t012_002/m2_2573_336# u_t012_002/m2_7_2898# u_t012_002/m2_2000_1265#
+ u_t012_002/m2_512_2037# u_t012_002/m2_1795_1265# u_t012_002/m2_1714_1982# u_t012_002/m2_1886_1259#
+ u_t012_002/m2_1290_2126# u_t012_002/m2_1714_438# u_t012_002/m2_431_1210# u_t012_002/m2_2573_2898#
+ u_t012_002/m2_2154_303# u_t012_002/m2_871_2081# VSUBS detronyx_12t_2w2r_rc4_4x4_routed_5layer_direct
Xgf180mcu_as_sc_mcu7t3v3__inv_2_1472 VSS VSS gf180mcu_as_sc_mcu7t3v3__inv_2_1472/Y
+ gf180mcu_as_sc_mcu7t3v3__inv_2_1473/Y gf180mcu_as_sc_mcu7t3v3__inv_2_1473/VNW VSUBS
+ gf180mcu_as_sc_mcu7t3v3__inv_2
Xgf180mcu_as_sc_mcu7t3v3__inv_2_1483 VSS VSS VSS gf180mcu_as_sc_mcu7t3v3__inv_2_1484/Y
+ gf180mcu_as_sc_mcu7t3v3__inv_2_1485/VNW VSUBS gf180mcu_as_sc_mcu7t3v3__inv_2
Xgf180mcu_as_sc_mcu7t3v3__inv_2_1494 VSS VSS gf180mcu_as_sc_mcu7t3v3__inv_2_1494/Y
+ gf180mcu_as_sc_mcu7t3v3__inv_2_1494/A gf180mcu_as_sc_mcu7t3v3__inv_2_1494/VNW VSUBS
+ gf180mcu_as_sc_mcu7t3v3__inv_2
Xgf180mcu_as_sc_mcu7t3v3__inv_2_1450 VSS VSS VSS gf180mcu_as_sc_mcu7t3v3__inv_2_1451/Y
+ gf180mcu_as_sc_mcu7t3v3__inv_2_1452/VNW VSUBS gf180mcu_as_sc_mcu7t3v3__inv_2
Xgf180mcu_as_sc_mcu7t3v3__inv_2_1461 VSS VSS gf180mcu_as_sc_mcu7t3v3__inv_2_1461/Y
+ gf180mcu_as_sc_mcu7t3v3__inv_2_1461/A gf180mcu_as_sc_mcu7t3v3__inv_2_1461/VNW VSUBS
+ gf180mcu_as_sc_mcu7t3v3__inv_2
Xgf180mcu_as_sc_mcu7t3v3__inv_2_912 VSS VSS gf180mcu_as_sc_mcu7t3v3__inv_2_912/Y gf180mcu_as_sc_mcu7t3v3__inv_2_912/A
+ gf180mcu_as_sc_mcu7t3v3__inv_2_944/VNW VSUBS gf180mcu_as_sc_mcu7t3v3__inv_2
Xgf180mcu_as_sc_mcu7t3v3__inv_2_945 VSS VSS VSS gf180mcu_as_sc_mcu7t3v3__inv_2_945/A
+ gf180mcu_as_sc_mcu7t3v3__inv_2_945/VNW VSUBS gf180mcu_as_sc_mcu7t3v3__inv_2
Xgf180mcu_as_sc_mcu7t3v3__inv_2_923 VSS VSS gf180mcu_as_sc_mcu7t3v3__inv_2_923/Y gf180mcu_as_sc_mcu7t3v3__inv_2_923/A
+ gf180mcu_as_sc_mcu7t3v3__inv_2_948/VNW VSUBS gf180mcu_as_sc_mcu7t3v3__inv_2
Xgf180mcu_as_sc_mcu7t3v3__inv_2_901 VSS VSS gf180mcu_as_sc_mcu7t3v3__inv_2_956/A gf180mcu_as_sc_mcu7t3v3__inv_2_904/Y
+ gf180mcu_as_sc_mcu7t3v3__inv_2_956/VNW VSUBS gf180mcu_as_sc_mcu7t3v3__inv_2
Xgf180mcu_as_sc_mcu7t3v3__inv_2_934 VSS VSS VSS gf180mcu_as_sc_mcu7t3v3__inv_2_934/A
+ gf180mcu_as_sc_mcu7t3v3__inv_2_934/VNW VSUBS gf180mcu_as_sc_mcu7t3v3__inv_2
Xu_t003_013 u_t003_013/c0_w0_bl u_t003_013/c0_w0_br u_t003_013/c0_w1_bl u_t003_013/c0_w1_br
+ u_t003_013/c0_r0_rbl u_t003_013/c0_r1_rbl u_t003_013/c1_w0_bl u_t003_013/c1_w0_br
+ u_t003_013/c1_w1_bl u_t003_013/c1_w1_br u_t003_013/c1_r0_rbl u_t003_013/c1_r1_rbl
+ u_t003_013/c2_w0_bl u_t003_013/c2_w0_br u_t003_013/c2_w1_bl u_t003_013/c2_w1_br
+ u_t003_013/c2_r0_rbl u_t003_013/c2_r1_rbl u_t003_013/c3_w0_bl u_t003_013/c3_w0_br
+ u_t003_013/c3_w1_bl u_t003_013/c3_w1_br u_t003_013/c3_r0_rbl u_t003_013/c3_r1_rbl
+ u_t003_013/r0_w0_wl u_t003_013/r0_w1_wl u_t003_013/r0_r0_rwl u_t003_013/r0_r1_rwl
+ u_t003_013/r1_w0_wl u_t003_013/r1_w1_wl u_t003_013/r1_r0_rwl u_t003_013/r1_r1_rwl
+ u_t003_013/r2_w0_wl u_t003_013/r2_w1_wl u_t003_013/r2_r0_rwl u_t003_013/r2_r1_rwl
+ u_t003_013/r3_w0_wl u_t003_013/r3_w1_wl u_t003_013/r3_r0_rwl u_t003_013/r3_r1_rwl
+ VSS VSS u_t003_013/m2_717_1265# u_t003_013/m2_603_2031# u_t003_013/m2_1290_336#
+ u_t003_013/m2_2000_2037# u_t003_013/m2_791_2909# u_t003_013/m2_7_2126# u_t003_013/m2_2154_2081#
+ u_t003_013/m2_1795_2037# u_t003_013/m2_871_303# u_t003_013/m2_431_438# u_t003_013/m2_1290_2898#
+ u_t003_013/m2_1714_1210# u_t003_013/m2_431_1982# u_t003_013/m2_512_1265# u_t003_013/m2_2573_2126#
+ u_t003_013/m2_603_1259# u_t003_013/m2_2074_2909# u_t003_013/m2_7_336# u_t003_013/m2_717_2037#
+ u_t003_013/m2_1886_2031# u_t003_013/m2_2573_336# u_t003_013/m2_7_2898# u_t003_013/m2_2000_1265#
+ u_t003_013/m2_512_2037# u_t003_013/m2_1795_1265# u_t003_013/m2_1714_1982# u_t003_013/m2_1886_1259#
+ u_t003_013/m2_1290_2126# u_t003_013/m2_1714_438# u_t003_013/m2_431_1210# u_t003_013/m2_2573_2898#
+ u_t003_013/m2_2154_303# u_t003_013/m2_871_2081# VSUBS detronyx_12t_2w2r_rc4_4x4_routed_5layer_direct
Xu_t003_002 u_t003_002/c0_w0_bl u_t003_002/c0_w0_br u_t003_002/c0_w1_bl u_t003_002/c0_w1_br
+ u_t003_002/c0_r0_rbl u_t003_002/c0_r1_rbl u_t003_002/c1_w0_bl u_t003_002/c1_w0_br
+ u_t003_002/c1_w1_bl u_t003_002/c1_w1_br u_t003_002/c1_r0_rbl u_t003_002/c1_r1_rbl
+ u_t003_002/c2_w0_bl u_t003_002/c2_w0_br u_t003_002/c2_w1_bl u_t003_002/c2_w1_br
+ u_t003_002/c2_r0_rbl u_t003_002/c2_r1_rbl u_t003_002/c3_w0_bl u_t003_002/c3_w0_br
+ u_t003_002/c3_w1_bl u_t003_002/c3_w1_br u_t003_002/c3_r0_rbl u_t003_002/c3_r1_rbl
+ u_t003_002/r0_w0_wl u_t003_002/r0_w1_wl u_t003_002/r0_r0_rwl u_t003_002/r0_r1_rwl
+ u_t003_002/r1_w0_wl u_t003_002/r1_w1_wl u_t003_002/r1_r0_rwl u_t003_002/r1_r1_rwl
+ u_t003_002/r2_w0_wl u_t003_002/r2_w1_wl u_t003_002/r2_r0_rwl u_t003_002/r2_r1_rwl
+ u_t003_002/r3_w0_wl u_t003_002/r3_w1_wl u_t003_002/r3_r0_rwl u_t003_002/r3_r1_rwl
+ VSS VSS u_t003_002/m2_717_1265# u_t003_002/m2_603_2031# u_t003_002/m2_1290_336#
+ u_t003_002/m2_2000_2037# u_t003_002/m2_791_2909# u_t003_002/m2_7_2126# u_t003_002/m2_2154_2081#
+ u_t003_002/m2_1795_2037# u_t003_002/m2_871_303# u_t003_002/m2_431_438# u_t003_002/m2_1290_2898#
+ u_t003_002/m2_1714_1210# u_t003_002/m2_431_1982# u_t003_002/m2_512_1265# u_t003_002/m2_2573_2126#
+ u_t003_002/m2_603_1259# u_t003_002/m2_2074_2909# u_t003_002/m2_7_336# u_t003_002/m2_717_2037#
+ u_t003_002/m2_1886_2031# u_t003_002/m2_2573_336# u_t003_002/m2_7_2898# u_t003_002/m2_2000_1265#
+ u_t003_002/m2_512_2037# u_t003_002/m2_1795_1265# u_t003_002/m2_1714_1982# u_t003_002/m2_1886_1259#
+ u_t003_002/m2_1290_2126# u_t003_002/m2_1714_438# u_t003_002/m2_431_1210# u_t003_002/m2_2573_2898#
+ u_t003_002/m2_2154_303# u_t003_002/m2_871_2081# VSUBS detronyx_12t_2w2r_rc4_4x4_routed_5layer_direct
Xgf180mcu_as_sc_mcu7t3v3__inv_2_956 VSS VSS VSS gf180mcu_as_sc_mcu7t3v3__inv_2_956/A
+ gf180mcu_as_sc_mcu7t3v3__inv_2_956/VNW VSUBS gf180mcu_as_sc_mcu7t3v3__inv_2
Xgf180mcu_as_sc_mcu7t3v3__inv_2_978 VSS VSS VSS gf180mcu_as_sc_mcu7t3v3__inv_2_979/Y
+ gf180mcu_as_sc_mcu7t3v3__inv_2_980/VNW VSUBS gf180mcu_as_sc_mcu7t3v3__inv_2
Xgf180mcu_as_sc_mcu7t3v3__inv_2_989 VSS VSS VSS gf180mcu_as_sc_mcu7t3v3__inv_2_989/A
+ gf180mcu_as_sc_mcu7t3v3__inv_2_989/VNW VSUBS gf180mcu_as_sc_mcu7t3v3__inv_2
Xgf180mcu_as_sc_mcu7t3v3__inv_2_967 VSS VSS gf180mcu_as_sc_mcu7t3v3__inv_2_967/Y gf180mcu_as_sc_mcu7t3v3__inv_2_968/Y
+ gf180mcu_as_sc_mcu7t3v3__inv_2_968/VNW VSUBS gf180mcu_as_sc_mcu7t3v3__inv_2
Xgf180mcu_as_sc_mcu7t3v3__nand4_2_266 VSS VSS VSS VSS VSS VSS gf180mcu_as_sc_mcu7t3v3__inv_2_891/A
+ gf180mcu_as_sc_mcu7t3v3__inv_2_949/VNW VSUBS gf180mcu_as_sc_mcu7t3v3__nand4_2
Xgf180mcu_as_sc_mcu7t3v3__nand4_2_277 VSS VSS VSS VSS VSS VSS gf180mcu_as_sc_mcu7t3v3__inv_2_910/A
+ gf180mcu_as_sc_mcu7t3v3__inv_2_954/VNW VSUBS gf180mcu_as_sc_mcu7t3v3__nand4_2
Xgf180mcu_as_sc_mcu7t3v3__nand4_2_200 VSS VSS VSS VSS VSS VSS gf180mcu_as_sc_mcu7t3v3__inv_2_684/A
+ gf180mcu_as_sc_mcu7t3v3__inv_2_684/VNW VSUBS gf180mcu_as_sc_mcu7t3v3__nand4_2
Xgf180mcu_as_sc_mcu7t3v3__nand4_2_222 VSS VSS VSS VSS VSS VSS gf180mcu_as_sc_mcu7t3v3__inv_2_764/A
+ gf180mcu_as_sc_mcu7t3v3__inv_2_822/VNW VSUBS gf180mcu_as_sc_mcu7t3v3__nand4_2
Xgf180mcu_as_sc_mcu7t3v3__nand4_2_211 VSS VSS VSS VSS VSS VSS gf180mcu_as_sc_mcu7t3v3__inv_2_661/A
+ gf180mcu_as_sc_mcu7t3v3__inv_2_661/VNW VSUBS gf180mcu_as_sc_mcu7t3v3__nand4_2
Xgf180mcu_as_sc_mcu7t3v3__nand4_2_233 VSS VSS VSS VSS VSS VSS gf180mcu_as_sc_mcu7t3v3__inv_2_786/A
+ gf180mcu_as_sc_mcu7t3v3__inv_2_816/VNW VSUBS gf180mcu_as_sc_mcu7t3v3__nand4_2
Xgf180mcu_as_sc_mcu7t3v3__nand4_2_244 VSS VSS VSS VSS VSS VSS gf180mcu_as_sc_mcu7t3v3__inv_2_812/A
+ gf180mcu_as_sc_mcu7t3v3__inv_2_840/VNW VSUBS gf180mcu_as_sc_mcu7t3v3__nand4_2
Xgf180mcu_as_sc_mcu7t3v3__nand4_2_288 VSS VSS VSS VSS VSS VSS gf180mcu_as_sc_mcu7t3v3__inv_2_976/A
+ gf180mcu_as_sc_mcu7t3v3__inv_2_976/VNW VSUBS gf180mcu_as_sc_mcu7t3v3__nand4_2
Xgf180mcu_as_sc_mcu7t3v3__nand4_2_299 VSS VSS VSS VSS VSS VSS gf180mcu_as_sc_mcu7t3v3__inv_2_972/A
+ gf180mcu_as_sc_mcu7t3v3__inv_2_972/VNW VSUBS gf180mcu_as_sc_mcu7t3v3__nand4_2
Xgf180mcu_as_sc_mcu7t3v3__nand4_2_255 VSS VSS VSS VSS VSS VSS gf180mcu_as_sc_mcu7t3v3__inv_2_888/A
+ gf180mcu_as_sc_mcu7t3v3__inv_2_943/VNW VSUBS gf180mcu_as_sc_mcu7t3v3__nand4_2
Xgf180mcu_as_sc_mcu7t3v3__inv_2_219 VSS VSS VSS gf180mcu_as_sc_mcu7t3v3__inv_2_220/Y
+ gf180mcu_as_sc_mcu7t3v3__inv_2_221/VNW VSUBS gf180mcu_as_sc_mcu7t3v3__inv_2
Xgf180mcu_as_sc_mcu7t3v3__inv_2_208 VSS VSS gf180mcu_as_sc_mcu7t3v3__inv_2_208/Y gf180mcu_as_sc_mcu7t3v3__inv_2_209/Y
+ gf180mcu_as_sc_mcu7t3v3__inv_2_209/VNW VSUBS gf180mcu_as_sc_mcu7t3v3__inv_2
Xu_t000_005 u_t000_005/c0_w0_bl u_t000_005/c0_w0_br u_t000_005/c0_w1_bl u_t000_005/c0_w1_br
+ u_t000_005/c0_r0_rbl u_t000_005/c0_r1_rbl u_t000_005/c1_w0_bl u_t000_005/c1_w0_br
+ u_t000_005/c1_w1_bl u_t000_005/c1_w1_br u_t000_005/c1_r0_rbl u_t000_005/c1_r1_rbl
+ u_t000_005/c2_w0_bl u_t000_005/c2_w0_br u_t000_005/c2_w1_bl u_t000_005/c2_w1_br
+ u_t000_005/c2_r0_rbl u_t000_005/c2_r1_rbl u_t000_005/c3_w0_bl u_t000_005/c3_w0_br
+ u_t000_005/c3_w1_bl u_t000_005/c3_w1_br u_t000_005/c3_r0_rbl u_t000_005/c3_r1_rbl
+ u_t000_005/r0_w0_wl u_t000_005/r0_w1_wl u_t000_005/r0_r0_rwl u_t000_005/r0_r1_rwl
+ u_t000_005/r1_w0_wl u_t000_005/r1_w1_wl u_t000_005/r1_r0_rwl u_t000_005/r1_r1_rwl
+ u_t000_005/r2_w0_wl u_t000_005/r2_w1_wl u_t000_005/r2_r0_rwl u_t000_005/r2_r1_rwl
+ u_t000_005/r3_w0_wl u_t000_005/r3_w1_wl u_t000_005/r3_r0_rwl u_t000_005/r3_r1_rwl
+ VSS VSS u_t000_005/m2_717_1265# u_t000_005/m2_603_2031# u_t000_005/m2_1290_336#
+ u_t000_005/m2_2000_2037# u_t000_005/m2_791_2909# u_t000_005/m2_7_2126# u_t000_005/m2_2154_2081#
+ u_t000_005/m2_1795_2037# u_t000_005/m2_871_303# u_t000_005/m2_431_438# u_t000_005/m2_1290_2898#
+ u_t000_005/m2_1714_1210# u_t000_005/m2_431_1982# u_t000_005/m2_512_1265# u_t000_005/m2_2573_2126#
+ u_t000_005/m2_603_1259# u_t000_005/m2_2074_2909# u_t000_005/m2_7_336# u_t000_005/m2_717_2037#
+ u_t000_005/m2_1886_2031# u_t000_005/m2_2573_336# u_t000_005/m2_7_2898# u_t000_005/m2_2000_1265#
+ u_t000_005/m2_512_2037# u_t000_005/m2_1795_1265# u_t000_005/m2_1714_1982# u_t000_005/m2_1886_1259#
+ u_t000_005/m2_1290_2126# u_t000_005/m2_1714_438# u_t000_005/m2_431_1210# u_t000_005/m2_2573_2898#
+ u_t000_005/m2_2154_303# u_t000_005/m2_871_2081# VSUBS detronyx_12t_2w2r_rc4_4x4_routed_5layer_direct
Xgf180mcu_as_sc_mcu7t3v3__inv_2_1280 VSS VSS VSS gf180mcu_as_sc_mcu7t3v3__inv_2_1280/A
+ gf180mcu_as_sc_mcu7t3v3__inv_2_1280/VNW VSUBS gf180mcu_as_sc_mcu7t3v3__inv_2
Xgf180mcu_as_sc_mcu7t3v3__inv_2_1291 VSS VSS VSS gf180mcu_as_sc_mcu7t3v3__inv_2_1291/A
+ gf180mcu_as_sc_mcu7t3v3__inv_2_1291/VNW VSUBS gf180mcu_as_sc_mcu7t3v3__inv_2
Xgf180mcu_as_sc_mcu7t3v3__inv_2_775 VSS VSS gf180mcu_as_sc_mcu7t3v3__inv_2_775/Y gf180mcu_as_sc_mcu7t3v3__inv_2_775/A
+ gf180mcu_as_sc_mcu7t3v3__inv_2_826/VNW VSUBS gf180mcu_as_sc_mcu7t3v3__inv_2
Xgf180mcu_as_sc_mcu7t3v3__inv_2_764 VSS VSS gf180mcu_as_sc_mcu7t3v3__inv_2_764/Y gf180mcu_as_sc_mcu7t3v3__inv_2_764/A
+ gf180mcu_as_sc_mcu7t3v3__inv_2_822/VNW VSUBS gf180mcu_as_sc_mcu7t3v3__inv_2
Xgf180mcu_as_sc_mcu7t3v3__inv_2_753 VSS VSS gf180mcu_as_sc_mcu7t3v3__inv_2_831/A gf180mcu_as_sc_mcu7t3v3__inv_2_754/Y
+ gf180mcu_as_sc_mcu7t3v3__inv_2_831/VNW VSUBS gf180mcu_as_sc_mcu7t3v3__inv_2
Xgf180mcu_as_sc_mcu7t3v3__inv_2_720 VSS VSS gf180mcu_as_sc_mcu7t3v3__inv_2_720/Y gf180mcu_as_sc_mcu7t3v3__inv_2_720/A
+ gf180mcu_as_sc_mcu7t3v3__inv_2_720/VNW VSUBS gf180mcu_as_sc_mcu7t3v3__inv_2
Xgf180mcu_as_sc_mcu7t3v3__inv_2_786 VSS VSS gf180mcu_as_sc_mcu7t3v3__inv_2_786/Y gf180mcu_as_sc_mcu7t3v3__inv_2_786/A
+ gf180mcu_as_sc_mcu7t3v3__inv_2_816/VNW VSUBS gf180mcu_as_sc_mcu7t3v3__inv_2
Xgf180mcu_as_sc_mcu7t3v3__inv_2_797 VSS VSS gf180mcu_as_sc_mcu7t3v3__inv_2_846/A gf180mcu_as_sc_mcu7t3v3__inv_2_798/Y
+ gf180mcu_as_sc_mcu7t3v3__inv_2_846/VNW VSUBS gf180mcu_as_sc_mcu7t3v3__inv_2
Xgf180mcu_as_sc_mcu7t3v3__inv_2_731 VSS VSS gf180mcu_as_sc_mcu7t3v3__inv_2_731/Y gf180mcu_as_sc_mcu7t3v3__inv_2_731/A
+ gf180mcu_as_sc_mcu7t3v3__inv_2_731/VNW VSUBS gf180mcu_as_sc_mcu7t3v3__inv_2
Xgf180mcu_as_sc_mcu7t3v3__inv_2_742 VSS VSS VSS gf180mcu_as_sc_mcu7t3v3__inv_2_743/Y
+ gf180mcu_as_sc_mcu7t3v3__inv_2_743/VNW VSUBS gf180mcu_as_sc_mcu7t3v3__inv_2
Xgf180mcu_as_sc_mcu7t3v3__nand4_2_0 VSS VSS VSS VSS VSS VSS gf180mcu_as_sc_mcu7t3v3__nand4_2_0/Y
+ gf180mcu_as_sc_mcu7t3v3__inv_2_99/VNW VSUBS gf180mcu_as_sc_mcu7t3v3__nand4_2
Xgf180mcu_as_sc_mcu7t3v3__inv_2_550 VSS VSS VSS gf180mcu_as_sc_mcu7t3v3__inv_2_550/A
+ gf180mcu_as_sc_mcu7t3v3__inv_2_550/VNW VSUBS gf180mcu_as_sc_mcu7t3v3__inv_2
Xgf180mcu_as_sc_mcu7t3v3__inv_2_572 VSS VSS gf180mcu_as_sc_mcu7t3v3__inv_2_572/Y gf180mcu_as_sc_mcu7t3v3__inv_2_573/Y
+ gf180mcu_as_sc_mcu7t3v3__inv_2_573/VNW VSUBS gf180mcu_as_sc_mcu7t3v3__inv_2
Xgf180mcu_as_sc_mcu7t3v3__inv_2_583 VSS VSS gf180mcu_as_sc_mcu7t3v3__inv_2_583/Y gf180mcu_as_sc_mcu7t3v3__inv_2_584/Y
+ gf180mcu_as_sc_mcu7t3v3__inv_2_584/VNW VSUBS gf180mcu_as_sc_mcu7t3v3__inv_2
Xgf180mcu_as_sc_mcu7t3v3__inv_2_594 VSS VSS gf180mcu_as_sc_mcu7t3v3__inv_2_594/Y gf180mcu_as_sc_mcu7t3v3__inv_2_594/A
+ gf180mcu_as_sc_mcu7t3v3__inv_2_638/VNW VSUBS gf180mcu_as_sc_mcu7t3v3__inv_2
Xgf180mcu_as_sc_mcu7t3v3__inv_2_561 VSS VSS VSS gf180mcu_as_sc_mcu7t3v3__inv_2_561/A
+ gf180mcu_as_sc_mcu7t3v3__inv_2_561/VNW VSUBS gf180mcu_as_sc_mcu7t3v3__inv_2
Xgf180mcu_as_sc_mcu7t3v3__nor2_2_9 gf180mcu_as_sc_mcu7t3v3__nor2_2_9/VDD gf180mcu_as_sc_mcu7t3v3__nor2_2_9/VSS
+ VSS VSS VSS gf180mcu_as_sc_mcu7t3v3__nor2_2_9/VNW VSUBS gf180mcu_as_sc_mcu7t3v3__nor2_2
Xu_t028_008 u_t028_008/c0_w0_bl u_t028_008/c0_w0_br u_t028_008/c0_w1_bl u_t028_008/c0_w1_br
+ u_t028_008/c0_r0_rbl u_t028_008/c0_r1_rbl u_t028_008/c1_w0_bl u_t028_008/c1_w0_br
+ u_t028_008/c1_w1_bl u_t028_008/c1_w1_br u_t028_008/c1_r0_rbl u_t028_008/c1_r1_rbl
+ u_t028_008/c2_w0_bl u_t028_008/c2_w0_br u_t028_008/c2_w1_bl u_t028_008/c2_w1_br
+ u_t028_008/c2_r0_rbl u_t028_008/c2_r1_rbl u_t028_008/c3_w0_bl u_t028_008/c3_w0_br
+ u_t028_008/c3_w1_bl u_t028_008/c3_w1_br u_t028_008/c3_r0_rbl u_t028_008/c3_r1_rbl
+ u_t028_008/r0_w0_wl u_t028_008/r0_w1_wl u_t028_008/r0_r0_rwl u_t028_008/r0_r1_rwl
+ u_t028_008/r1_w0_wl u_t028_008/r1_w1_wl u_t028_008/r1_r0_rwl u_t028_008/r1_r1_rwl
+ u_t028_008/r2_w0_wl u_t028_008/r2_w1_wl u_t028_008/r2_r0_rwl u_t028_008/r2_r1_rwl
+ u_t028_008/r3_w0_wl u_t028_008/r3_w1_wl u_t028_008/r3_r0_rwl u_t028_008/r3_r1_rwl
+ VSS VSS u_t028_008/m2_717_1265# u_t028_008/m2_603_2031# u_t028_008/m2_1290_336#
+ u_t028_008/m2_2000_2037# u_t028_008/m2_791_2909# u_t028_008/m2_7_2126# u_t028_008/m2_2154_2081#
+ u_t028_008/m2_1795_2037# u_t028_008/m2_871_303# u_t028_008/m2_431_438# u_t028_008/m2_1290_2898#
+ u_t028_008/m2_1714_1210# u_t028_008/m2_431_1982# u_t028_008/m2_512_1265# u_t028_008/m2_2573_2126#
+ u_t028_008/m2_603_1259# u_t028_008/m2_2074_2909# u_t028_008/m2_7_336# u_t028_008/m2_717_2037#
+ u_t028_008/m2_1886_2031# u_t028_008/m2_2573_336# u_t028_008/m2_7_2898# u_t028_008/m2_2000_1265#
+ u_t028_008/m2_512_2037# u_t028_008/m2_1795_1265# u_t028_008/m2_1714_1982# u_t028_008/m2_1886_1259#
+ u_t028_008/m2_1290_2126# u_t028_008/m2_1714_438# u_t028_008/m2_431_1210# u_t028_008/m2_2573_2898#
+ u_t028_008/m2_2154_303# u_t028_008/m2_871_2081# VSUBS detronyx_12t_2w2r_rc4_4x4_routed_5layer_direct
Xgf180mcu_as_sc_mcu7t3v3__inv_2_391 gf180mcu_as_sc_mcu7t3v3__nor2_2_6/VDD gf180mcu_as_sc_mcu7t3v3__nor2_2_6/VSS
+ VSS VSS gf180mcu_as_sc_mcu7t3v3__nor2_2_6/VNW VSUBS gf180mcu_as_sc_mcu7t3v3__inv_2
Xgf180mcu_as_sc_mcu7t3v3__inv_2_380 gf180mcu_as_sc_mcu7t3v3__nor2_2_6/VDD gf180mcu_as_sc_mcu7t3v3__nand3_2_4/VSS
+ VSS VSS gf180mcu_as_sc_mcu7t3v3__nor2_2_6/VNW VSUBS gf180mcu_as_sc_mcu7t3v3__inv_2
Xu_t019_008 u_t019_008/c0_w0_bl u_t019_008/c0_w0_br u_t019_008/c0_w1_bl u_t019_008/c0_w1_br
+ u_t019_008/c0_r0_rbl u_t019_008/c0_r1_rbl u_t019_008/c1_w0_bl u_t019_008/c1_w0_br
+ u_t019_008/c1_w1_bl u_t019_008/c1_w1_br u_t019_008/c1_r0_rbl u_t019_008/c1_r1_rbl
+ u_t019_008/c2_w0_bl u_t019_008/c2_w0_br u_t019_008/c2_w1_bl u_t019_008/c2_w1_br
+ u_t019_008/c2_r0_rbl u_t019_008/c2_r1_rbl u_t019_008/c3_w0_bl u_t019_008/c3_w0_br
+ u_t019_008/c3_w1_bl u_t019_008/c3_w1_br u_t019_008/c3_r0_rbl u_t019_008/c3_r1_rbl
+ u_t019_008/r0_w0_wl u_t019_008/r0_w1_wl u_t019_008/r0_r0_rwl u_t019_008/r0_r1_rwl
+ u_t019_008/r1_w0_wl u_t019_008/r1_w1_wl u_t019_008/r1_r0_rwl u_t019_008/r1_r1_rwl
+ u_t019_008/r2_w0_wl u_t019_008/r2_w1_wl u_t019_008/r2_r0_rwl u_t019_008/r2_r1_rwl
+ u_t019_008/r3_w0_wl u_t019_008/r3_w1_wl u_t019_008/r3_r0_rwl u_t019_008/r3_r1_rwl
+ VSS VSS u_t019_008/m2_717_1265# u_t019_008/m2_603_2031# u_t019_008/m2_1290_336#
+ u_t019_008/m2_2000_2037# u_t019_008/m2_791_2909# u_t019_008/m2_7_2126# u_t019_008/m2_2154_2081#
+ u_t019_008/m2_1795_2037# u_t019_008/m2_871_303# u_t019_008/m2_431_438# u_t019_008/m2_1290_2898#
+ u_t019_008/m2_1714_1210# u_t019_008/m2_431_1982# u_t019_008/m2_512_1265# u_t019_008/m2_2573_2126#
+ u_t019_008/m2_603_1259# u_t019_008/m2_2074_2909# u_t019_008/m2_7_336# u_t019_008/m2_717_2037#
+ u_t019_008/m2_1886_2031# u_t019_008/m2_2573_336# u_t019_008/m2_7_2898# u_t019_008/m2_2000_1265#
+ u_t019_008/m2_512_2037# u_t019_008/m2_1795_1265# u_t019_008/m2_1714_1982# u_t019_008/m2_1886_1259#
+ u_t019_008/m2_1290_2126# u_t019_008/m2_1714_438# u_t019_008/m2_431_1210# u_t019_008/m2_2573_2898#
+ u_t019_008/m2_2154_303# u_t019_008/m2_871_2081# VSUBS detronyx_12t_2w2r_rc4_4x4_routed_5layer_direct
Xgf180mcu_as_sc_mcu7t3v3__inv_2_1109 VSS VSS VSS gf180mcu_as_sc_mcu7t3v3__inv_2_1110/Y
+ gf180mcu_as_sc_mcu7t3v3__inv_2_1111/VNW VSUBS gf180mcu_as_sc_mcu7t3v3__inv_2
Xgf180mcu_as_sc_mcu7t3v3__nand3_2_12 gf180mcu_as_sc_mcu7t3v3__nor2_2_4/VDD gf180mcu_as_sc_mcu7t3v3__nand2_2_3/VSS
+ VSS VSS VSS VSS gf180mcu_as_sc_mcu7t3v3__nor2_2_4/VNW VSUBS gf180mcu_as_sc_mcu7t3v3__nand3_2
Xu_t024_011 u_t024_011/c0_w0_bl u_t024_011/c0_w0_br u_t024_011/c0_w1_bl u_t024_011/c0_w1_br
+ u_t024_011/c0_r0_rbl u_t024_011/c0_r1_rbl u_t024_011/c1_w0_bl u_t024_011/c1_w0_br
+ u_t024_011/c1_w1_bl u_t024_011/c1_w1_br u_t024_011/c1_r0_rbl u_t024_011/c1_r1_rbl
+ u_t024_011/c2_w0_bl u_t024_011/c2_w0_br u_t024_011/c2_w1_bl u_t024_011/c2_w1_br
+ u_t024_011/c2_r0_rbl u_t024_011/c2_r1_rbl u_t024_011/c3_w0_bl u_t024_011/c3_w0_br
+ u_t024_011/c3_w1_bl u_t024_011/c3_w1_br u_t024_011/c3_r0_rbl u_t024_011/c3_r1_rbl
+ u_t024_011/r0_w0_wl u_t024_011/r0_w1_wl u_t024_011/r0_r0_rwl u_t024_011/r0_r1_rwl
+ u_t024_011/r1_w0_wl u_t024_011/r1_w1_wl u_t024_011/r1_r0_rwl u_t024_011/r1_r1_rwl
+ u_t024_011/r2_w0_wl u_t024_011/r2_w1_wl u_t024_011/r2_r0_rwl u_t024_011/r2_r1_rwl
+ u_t024_011/r3_w0_wl u_t024_011/r3_w1_wl u_t024_011/r3_r0_rwl u_t024_011/r3_r1_rwl
+ VSS VSS u_t024_011/m2_717_1265# u_t024_011/m2_603_2031# u_t024_011/m2_1290_336#
+ u_t024_011/m2_2000_2037# u_t024_011/m2_791_2909# u_t024_011/m2_7_2126# u_t024_011/m2_2154_2081#
+ u_t024_011/m2_1795_2037# u_t024_011/m2_871_303# u_t024_011/m2_431_438# u_t024_011/m2_1290_2898#
+ u_t024_011/m2_1714_1210# u_t024_011/m2_431_1982# u_t024_011/m2_512_1265# u_t024_011/m2_2573_2126#
+ u_t024_011/m2_603_1259# u_t024_011/m2_2074_2909# u_t024_011/m2_7_336# u_t024_011/m2_717_2037#
+ u_t024_011/m2_1886_2031# u_t024_011/m2_2573_336# u_t024_011/m2_7_2898# u_t024_011/m2_2000_1265#
+ u_t024_011/m2_512_2037# u_t024_011/m2_1795_1265# u_t024_011/m2_1714_1982# u_t024_011/m2_1886_1259#
+ u_t024_011/m2_1290_2126# u_t024_011/m2_1714_438# u_t024_011/m2_431_1210# u_t024_011/m2_2573_2898#
+ u_t024_011/m2_2154_303# u_t024_011/m2_871_2081# VSUBS detronyx_12t_2w2r_rc4_4x4_routed_5layer_direct
Xgf180mcu_as_sc_mcu7t3v3__nand3_2_56 gf180mcu_as_sc_mcu7t3v3__nand3_2_65/VDD gf180mcu_as_sc_mcu7t3v3__nor2_2_9/VSS
+ VSS VSS VSS VSS gf180mcu_as_sc_mcu7t3v3__nand3_2_65/VNW VSUBS gf180mcu_as_sc_mcu7t3v3__nand3_2
Xgf180mcu_as_sc_mcu7t3v3__nand3_2_45 gf180mcu_as_sc_mcu7t3v3__nor2_2_9/VDD gf180mcu_as_sc_mcu7t3v3__nand3_2_63/VSS
+ VSS VSS VSS VSS gf180mcu_as_sc_mcu7t3v3__nor2_2_9/VNW VSUBS gf180mcu_as_sc_mcu7t3v3__nand3_2
Xu_t024_000 VSS u_t024_000/c0_w0_br VSS u_t024_000/c0_w1_br u_t024_000/c0_r0_rbl u_t024_000/c0_r1_rbl
+ VSS VSS VSS VSS VSS VSS u_t024_000/c2_w0_bl u_t024_000/c2_w0_br u_t024_000/c2_w1_bl
+ u_t024_000/c2_w1_br u_t024_000/c2_r0_rbl u_t024_000/c2_r1_rbl u_t024_000/c3_w0_bl
+ u_t024_000/c3_w0_br u_t024_000/c3_w1_bl u_t024_000/c3_w1_br u_t024_000/c3_r0_rbl
+ u_t024_000/c3_r1_rbl VSS VSS VSS VSS VSS VSS VSS VSS VSS VSS VSS VSS VSS VSS VSS
+ VSS VSS VSS u_t024_000/m2_717_1265# VSS VSS VSS VSS VSS VSS VSS VSS VSS VSS VSS
+ VSS u_t024_000/m2_512_1265# u_t024_000/m2_2573_2126# VSS VSS VSS VSS VSS u_t024_000/m2_2573_336#
+ VSS u_t024_000/m2_2000_1265# VSS u_t024_000/m2_1795_1265# VSS VSS VSS VSS VSS u_t024_000/m2_2573_2898#
+ VSS VSS VSUBS detronyx_12t_2w2r_rc4_4x4_routed_5layer_direct
Xgf180mcu_as_sc_mcu7t3v3__nand3_2_23 gf180mcu_as_sc_mcu7t3v3__nand3_2_9/VDD gf180mcu_as_sc_mcu7t3v3__nor2_2_4/VSS
+ VSS VSS VSS VSS gf180mcu_as_sc_mcu7t3v3__nand3_2_9/VNW VSUBS gf180mcu_as_sc_mcu7t3v3__nand3_2
Xgf180mcu_as_sc_mcu7t3v3__nand3_2_34 gf180mcu_as_sc_mcu7t3v3__nor2_2_7/VDD gf180mcu_as_sc_mcu7t3v3__nor2_2_7/VSS
+ VSS VSS VSS VSS gf180mcu_as_sc_mcu7t3v3__nor2_2_7/VNW VSUBS gf180mcu_as_sc_mcu7t3v3__nand3_2
Xgf180mcu_as_sc_mcu7t3v3__inv_2_1632 VSS VSS VSS gf180mcu_as_sc_mcu7t3v3__inv_2_1633/Y
+ gf180mcu_as_sc_mcu7t3v3__inv_2_1634/VNW VSUBS gf180mcu_as_sc_mcu7t3v3__inv_2
Xgf180mcu_as_sc_mcu7t3v3__inv_2_1665 VSS VSS gf180mcu_as_sc_mcu7t3v3__inv_2_1665/Y
+ gf180mcu_as_sc_mcu7t3v3__inv_2_1665/A gf180mcu_as_sc_mcu7t3v3__inv_2_1665/VNW VSUBS
+ gf180mcu_as_sc_mcu7t3v3__inv_2
Xgf180mcu_as_sc_mcu7t3v3__inv_2_1643 VSS VSS gf180mcu_as_sc_mcu7t3v3__inv_2_1643/Y
+ gf180mcu_as_sc_mcu7t3v3__inv_2_1653/Y gf180mcu_as_sc_mcu7t3v3__inv_2_1653/VNW VSUBS
+ gf180mcu_as_sc_mcu7t3v3__inv_2
Xgf180mcu_as_sc_mcu7t3v3__inv_2_1621 VSS VSS gf180mcu_as_sc_mcu7t3v3__inv_2_1621/Y
+ gf180mcu_as_sc_mcu7t3v3__inv_2_1622/Y gf180mcu_as_sc_mcu7t3v3__inv_2_1622/VNW VSUBS
+ gf180mcu_as_sc_mcu7t3v3__inv_2
Xgf180mcu_as_sc_mcu7t3v3__inv_2_1654 VSS VSS VSS gf180mcu_as_sc_mcu7t3v3__inv_2_1655/Y
+ gf180mcu_as_sc_mcu7t3v3__inv_2_1656/VNW VSUBS gf180mcu_as_sc_mcu7t3v3__inv_2
Xgf180mcu_as_sc_mcu7t3v3__inv_2_1676 VSS VSS gf180mcu_as_sc_mcu7t3v3__inv_2_1676/Y
+ gf180mcu_as_sc_mcu7t3v3__inv_2_1676/A gf180mcu_as_sc_mcu7t3v3__inv_2_1676/VNW VSUBS
+ gf180mcu_as_sc_mcu7t3v3__inv_2
Xgf180mcu_as_sc_mcu7t3v3__inv_2_1687 VSS VSS gf180mcu_as_sc_mcu7t3v3__inv_2_1687/Y
+ gf180mcu_as_sc_mcu7t3v3__inv_2_1688/Y gf180mcu_as_sc_mcu7t3v3__inv_2_1688/VNW VSUBS
+ gf180mcu_as_sc_mcu7t3v3__inv_2
Xgf180mcu_as_sc_mcu7t3v3__inv_2_1610 VSS VSS gf180mcu_as_sc_mcu7t3v3__inv_2_1610/Y
+ gf180mcu_as_sc_mcu7t3v3__inv_2_1610/A gf180mcu_as_sc_mcu7t3v3__inv_2_1610/VNW VSUBS
+ gf180mcu_as_sc_mcu7t3v3__inv_2
Xgf180mcu_as_sc_mcu7t3v3__inv_2_1698 gf180mcu_as_sc_mcu7t3v3__nand3_2_9/VDD gf180mcu_as_sc_mcu7t3v3__nor2_2_7/VSS
+ VSS VSS gf180mcu_as_sc_mcu7t3v3__nand3_2_9/VNW VSUBS gf180mcu_as_sc_mcu7t3v3__inv_2
Xu_t015_011 u_t015_011/c0_w0_bl u_t015_011/c0_w0_br u_t015_011/c0_w1_bl u_t015_011/c0_w1_br
+ u_t015_011/c0_r0_rbl u_t015_011/c0_r1_rbl u_t015_011/c1_w0_bl u_t015_011/c1_w0_br
+ u_t015_011/c1_w1_bl u_t015_011/c1_w1_br u_t015_011/c1_r0_rbl u_t015_011/c1_r1_rbl
+ u_t015_011/c2_w0_bl u_t015_011/c2_w0_br u_t015_011/c2_w1_bl u_t015_011/c2_w1_br
+ u_t015_011/c2_r0_rbl u_t015_011/c2_r1_rbl u_t015_011/c3_w0_bl u_t015_011/c3_w0_br
+ u_t015_011/c3_w1_bl u_t015_011/c3_w1_br u_t015_011/c3_r0_rbl u_t015_011/c3_r1_rbl
+ u_t015_011/r0_w0_wl u_t015_011/r0_w1_wl u_t015_011/r0_r0_rwl u_t015_011/r0_r1_rwl
+ u_t015_011/r1_w0_wl u_t015_011/r1_w1_wl u_t015_011/r1_r0_rwl u_t015_011/r1_r1_rwl
+ u_t015_011/r2_w0_wl u_t015_011/r2_w1_wl u_t015_011/r2_r0_rwl u_t015_011/r2_r1_rwl
+ u_t015_011/r3_w0_wl u_t015_011/r3_w1_wl u_t015_011/r3_r0_rwl u_t015_011/r3_r1_rwl
+ VSS VSS u_t015_011/m2_717_1265# u_t015_011/m2_603_2031# u_t015_011/m2_1290_336#
+ u_t015_011/m2_2000_2037# u_t015_011/m2_791_2909# u_t015_011/m2_7_2126# u_t015_011/m2_2154_2081#
+ u_t015_011/m2_1795_2037# u_t015_011/m2_871_303# u_t015_011/m2_431_438# u_t015_011/m2_1290_2898#
+ u_t015_011/m2_1714_1210# u_t015_011/m2_431_1982# u_t015_011/m2_512_1265# u_t015_011/m2_2573_2126#
+ u_t015_011/m2_603_1259# u_t015_011/m2_2074_2909# u_t015_011/m2_7_336# u_t015_011/m2_717_2037#
+ u_t015_011/m2_1886_2031# u_t015_011/m2_2573_336# u_t015_011/m2_7_2898# u_t015_011/m2_2000_1265#
+ u_t015_011/m2_512_2037# u_t015_011/m2_1795_1265# u_t015_011/m2_1714_1982# u_t015_011/m2_1886_1259#
+ u_t015_011/m2_1290_2126# u_t015_011/m2_1714_438# u_t015_011/m2_431_1210# u_t015_011/m2_2573_2898#
+ u_t015_011/m2_2154_303# u_t015_011/m2_871_2081# VSUBS detronyx_12t_2w2r_rc4_4x4_routed_5layer_direct
Xu_t015_000 VSS u_t015_000/c0_w0_br VSS u_t015_000/c0_w1_br u_t015_000/c0_r0_rbl u_t015_000/c0_r1_rbl
+ VSS VSS VSS VSS VSS VSS u_t015_000/c2_w0_bl u_t015_000/c2_w0_br u_t015_000/c2_w1_bl
+ u_t015_000/c2_w1_br u_t015_000/c2_r0_rbl u_t015_000/c2_r1_rbl u_t015_000/c3_w0_bl
+ u_t015_000/c3_w0_br u_t015_000/c3_w1_bl u_t015_000/c3_w1_br u_t015_000/c3_r0_rbl
+ u_t015_000/c3_r1_rbl VSS VSS VSS VSS VSS VSS VSS VSS VSS VSS VSS VSS VSS VSS VSS
+ VSS VSS VSS u_t015_000/m2_717_1265# u_t015_000/m2_603_2031# u_t015_000/m2_1290_336#
+ u_t015_000/m2_2000_2037# u_t015_000/m2_791_2909# u_t015_000/m2_7_2126# u_t015_000/m2_2154_2081#
+ u_t015_000/m2_1795_2037# u_t015_000/m2_871_303# u_t015_000/m2_431_438# u_t015_000/m2_1290_2898#
+ u_t015_000/m2_1714_1210# u_t015_000/m2_431_1982# u_t015_000/m2_512_1265# u_t015_000/m2_2573_2126#
+ u_t015_000/m2_603_1259# u_t015_000/m2_2074_2909# u_t015_000/m2_7_336# u_t015_000/m2_717_2037#
+ u_t015_000/m2_1886_2031# u_t015_000/m2_2573_336# u_t015_000/m2_7_2898# u_t015_000/m2_2000_1265#
+ u_t015_000/m2_512_2037# u_t015_000/m2_1795_1265# u_t015_000/m2_1714_1982# u_t015_000/m2_1886_1259#
+ u_t015_000/m2_1290_2126# u_t015_000/m2_1714_438# u_t015_000/m2_431_1210# u_t015_000/m2_2573_2898#
+ u_t015_000/m2_2154_303# u_t015_000/m2_871_2081# VSUBS detronyx_12t_2w2r_rc4_4x4_routed_5layer_direct
Xu_t030_014 u_t030_014/c0_w0_bl u_t030_014/c0_w0_br u_t030_014/c0_w1_bl u_t030_014/c0_w1_br
+ u_t030_014/c0_r0_rbl u_t030_014/c0_r1_rbl u_t030_014/c1_w0_bl u_t030_014/c1_w0_br
+ u_t030_014/c1_w1_bl u_t030_014/c1_w1_br u_t030_014/c1_r0_rbl u_t030_014/c1_r1_rbl
+ u_t030_014/c2_w0_bl u_t030_014/c2_w0_br u_t030_014/c2_w1_bl u_t030_014/c2_w1_br
+ u_t030_014/c2_r0_rbl u_t030_014/c2_r1_rbl u_t030_014/c3_w0_bl u_t030_014/c3_w0_br
+ u_t030_014/c3_w1_bl u_t030_014/c3_w1_br u_t030_014/c3_r0_rbl u_t030_014/c3_r1_rbl
+ u_t030_014/r0_w0_wl u_t030_014/r0_w1_wl u_t030_014/r0_r0_rwl u_t030_014/r0_r1_rwl
+ u_t030_014/r1_w0_wl u_t030_014/r1_w1_wl u_t030_014/r1_r0_rwl u_t030_014/r1_r1_rwl
+ u_t030_014/r2_w0_wl u_t030_014/r2_w1_wl u_t030_014/r2_r0_rwl u_t030_014/r2_r1_rwl
+ u_t030_014/r3_w0_wl u_t030_014/r3_w1_wl u_t030_014/r3_r0_rwl u_t030_014/r3_r1_rwl
+ VSS VSS u_t030_014/m2_717_1265# u_t030_014/m2_603_2031# u_t030_014/m2_1290_336#
+ u_t030_014/m2_2000_2037# u_t030_014/m2_791_2909# u_t030_014/m2_7_2126# u_t030_014/m2_2154_2081#
+ u_t030_014/m2_1795_2037# u_t030_014/m2_871_303# u_t030_014/m2_431_438# u_t030_014/m2_1290_2898#
+ u_t030_014/m2_1714_1210# u_t030_014/m2_431_1982# u_t030_014/m2_512_1265# u_t030_014/m2_2573_2126#
+ u_t030_014/m2_603_1259# u_t030_014/m2_2074_2909# u_t030_014/m2_7_336# u_t030_014/m2_717_2037#
+ u_t030_014/m2_1886_2031# u_t030_014/m2_2573_336# u_t030_014/m2_7_2898# u_t030_014/m2_2000_1265#
+ u_t030_014/m2_512_2037# u_t030_014/m2_1795_1265# u_t030_014/m2_1714_1982# u_t030_014/m2_1886_1259#
+ u_t030_014/m2_1290_2126# u_t030_014/m2_1714_438# u_t030_014/m2_431_1210# u_t030_014/m2_2573_2898#
+ u_t030_014/m2_2154_303# u_t030_014/m2_871_2081# VSUBS detronyx_12t_2w2r_rc4_4x4_routed_5layer_direct
Xu_t030_003 u_t030_003/c0_w0_bl u_t030_003/c0_w0_br u_t030_003/c0_w1_bl u_t030_003/c0_w1_br
+ u_t030_003/c0_r0_rbl u_t030_003/c0_r1_rbl u_t030_003/c1_w0_bl u_t030_003/c1_w0_br
+ u_t030_003/c1_w1_bl u_t030_003/c1_w1_br u_t030_003/c1_r0_rbl u_t030_003/c1_r1_rbl
+ u_t030_003/c2_w0_bl u_t030_003/c2_w0_br u_t030_003/c2_w1_bl u_t030_003/c2_w1_br
+ u_t030_003/c2_r0_rbl u_t030_003/c2_r1_rbl u_t030_003/c3_w0_bl u_t030_003/c3_w0_br
+ u_t030_003/c3_w1_bl u_t030_003/c3_w1_br u_t030_003/c3_r0_rbl u_t030_003/c3_r1_rbl
+ u_t030_003/r0_w0_wl u_t030_003/r0_w1_wl u_t030_003/r0_r0_rwl u_t030_003/r0_r1_rwl
+ u_t030_003/r1_w0_wl u_t030_003/r1_w1_wl u_t030_003/r1_r0_rwl u_t030_003/r1_r1_rwl
+ u_t030_003/r2_w0_wl u_t030_003/r2_w1_wl u_t030_003/r2_r0_rwl u_t030_003/r2_r1_rwl
+ u_t030_003/r3_w0_wl u_t030_003/r3_w1_wl u_t030_003/r3_r0_rwl u_t030_003/r3_r1_rwl
+ VSS VSS u_t030_003/m2_717_1265# u_t030_003/m2_603_2031# u_t030_003/m2_1290_336#
+ u_t030_003/m2_2000_2037# u_t030_003/m2_791_2909# u_t030_003/m2_7_2126# u_t030_003/m2_2154_2081#
+ u_t030_003/m2_1795_2037# u_t030_003/m2_871_303# u_t030_003/m2_431_438# u_t030_003/m2_1290_2898#
+ u_t030_003/m2_1714_1210# u_t030_003/m2_431_1982# u_t030_003/m2_512_1265# u_t030_003/m2_2573_2126#
+ u_t030_003/m2_603_1259# u_t030_003/m2_2074_2909# u_t030_003/m2_7_336# u_t030_003/m2_717_2037#
+ u_t030_003/m2_1886_2031# u_t030_003/m2_2573_336# u_t030_003/m2_7_2898# u_t030_003/m2_2000_1265#
+ u_t030_003/m2_512_2037# u_t030_003/m2_1795_1265# u_t030_003/m2_1714_1982# u_t030_003/m2_1886_1259#
+ u_t030_003/m2_1290_2126# u_t030_003/m2_1714_438# u_t030_003/m2_431_1210# u_t030_003/m2_2573_2898#
+ u_t030_003/m2_2154_303# u_t030_003/m2_871_2081# VSUBS detronyx_12t_2w2r_rc4_4x4_routed_5layer_direct
Xgf180mcu_as_sc_mcu7t3v3__nand4_2_437 VSS VSS VSS VSS VSS VSS gf180mcu_as_sc_mcu7t3v3__inv_2_1582/A
+ gf180mcu_as_sc_mcu7t3v3__inv_2_1582/VNW VSUBS gf180mcu_as_sc_mcu7t3v3__nand4_2
Xgf180mcu_as_sc_mcu7t3v3__nand4_2_426 VSS VSS VSS VSS VSS VSS gf180mcu_as_sc_mcu7t3v3__inv_2_1550/A
+ gf180mcu_as_sc_mcu7t3v3__inv_2_1550/VNW VSUBS gf180mcu_as_sc_mcu7t3v3__nand4_2
Xgf180mcu_as_sc_mcu7t3v3__nand4_2_415 VSS VSS VSS VSS VSS VSS gf180mcu_as_sc_mcu7t3v3__inv_2_1519/A
+ gf180mcu_as_sc_mcu7t3v3__inv_2_1519/VNW VSUBS gf180mcu_as_sc_mcu7t3v3__nand4_2
Xgf180mcu_as_sc_mcu7t3v3__nand4_2_404 VSS VSS VSS VSS VSS VSS gf180mcu_as_sc_mcu7t3v3__inv_2_1482/A
+ gf180mcu_as_sc_mcu7t3v3__inv_2_1482/VNW VSUBS gf180mcu_as_sc_mcu7t3v3__nand4_2
Xgf180mcu_as_sc_mcu7t3v3__nand4_2_459 VSS VSS VSS VSS VSS VSS gf180mcu_as_sc_mcu7t3v3__inv_2_1333/A
+ gf180mcu_as_sc_mcu7t3v3__inv_2_1333/VNW VSUBS gf180mcu_as_sc_mcu7t3v3__nand4_2
Xgf180mcu_as_sc_mcu7t3v3__nand4_2_448 VSS VSS VSS VSS VSS VSS gf180mcu_as_sc_mcu7t3v3__inv_2_1328/A
+ gf180mcu_as_sc_mcu7t3v3__inv_2_1328/VNW VSUBS gf180mcu_as_sc_mcu7t3v3__nand4_2
Xu_t006_011 u_t006_011/c0_w0_bl u_t006_011/c0_w0_br u_t006_011/c0_w1_bl u_t006_011/c0_w1_br
+ u_t006_011/c0_r0_rbl u_t006_011/c0_r1_rbl u_t006_011/c1_w0_bl u_t006_011/c1_w0_br
+ u_t006_011/c1_w1_bl u_t006_011/c1_w1_br u_t006_011/c1_r0_rbl u_t006_011/c1_r1_rbl
+ u_t006_011/c2_w0_bl u_t006_011/c2_w0_br u_t006_011/c2_w1_bl u_t006_011/c2_w1_br
+ u_t006_011/c2_r0_rbl u_t006_011/c2_r1_rbl u_t006_011/c3_w0_bl u_t006_011/c3_w0_br
+ u_t006_011/c3_w1_bl u_t006_011/c3_w1_br u_t006_011/c3_r0_rbl u_t006_011/c3_r1_rbl
+ u_t006_011/r0_w0_wl u_t006_011/r0_w1_wl u_t006_011/r0_r0_rwl u_t006_011/r0_r1_rwl
+ u_t006_011/r1_w0_wl u_t006_011/r1_w1_wl u_t006_011/r1_r0_rwl u_t006_011/r1_r1_rwl
+ u_t006_011/r2_w0_wl u_t006_011/r2_w1_wl u_t006_011/r2_r0_rwl u_t006_011/r2_r1_rwl
+ u_t006_011/r3_w0_wl u_t006_011/r3_w1_wl u_t006_011/r3_r0_rwl u_t006_011/r3_r1_rwl
+ VSS VSS u_t006_011/m2_717_1265# u_t006_011/m2_603_2031# u_t006_011/m2_1290_336#
+ u_t006_011/m2_2000_2037# u_t006_011/m2_791_2909# u_t006_011/m2_7_2126# u_t006_011/m2_2154_2081#
+ u_t006_011/m2_1795_2037# u_t006_011/m2_871_303# u_t006_011/m2_431_438# u_t006_011/m2_1290_2898#
+ u_t006_011/m2_1714_1210# u_t006_011/m2_431_1982# u_t006_011/m2_512_1265# u_t006_011/m2_2573_2126#
+ u_t006_011/m2_603_1259# u_t006_011/m2_2074_2909# u_t006_011/m2_7_336# u_t006_011/m2_717_2037#
+ u_t006_011/m2_1886_2031# u_t006_011/m2_2573_336# u_t006_011/m2_7_2898# u_t006_011/m2_2000_1265#
+ u_t006_011/m2_512_2037# u_t006_011/m2_1795_1265# u_t006_011/m2_1714_1982# u_t006_011/m2_1886_1259#
+ u_t006_011/m2_1290_2126# u_t006_011/m2_1714_438# u_t006_011/m2_431_1210# u_t006_011/m2_2573_2898#
+ u_t006_011/m2_2154_303# u_t006_011/m2_871_2081# VSUBS detronyx_12t_2w2r_rc4_4x4_routed_5layer_direct
Xu_t021_003 u_t021_003/c0_w0_bl u_t021_003/c0_w0_br u_t021_003/c0_w1_bl u_t021_003/c0_w1_br
+ u_t021_003/c0_r0_rbl u_t021_003/c0_r1_rbl u_t021_003/c1_w0_bl u_t021_003/c1_w0_br
+ u_t021_003/c1_w1_bl u_t021_003/c1_w1_br u_t021_003/c1_r0_rbl u_t021_003/c1_r1_rbl
+ u_t021_003/c2_w0_bl u_t021_003/c2_w0_br u_t021_003/c2_w1_bl u_t021_003/c2_w1_br
+ u_t021_003/c2_r0_rbl u_t021_003/c2_r1_rbl u_t021_003/c3_w0_bl u_t021_003/c3_w0_br
+ u_t021_003/c3_w1_bl u_t021_003/c3_w1_br u_t021_003/c3_r0_rbl u_t021_003/c3_r1_rbl
+ u_t021_003/r0_w0_wl u_t021_003/r0_w1_wl u_t021_003/r0_r0_rwl u_t021_003/r0_r1_rwl
+ u_t021_003/r1_w0_wl u_t021_003/r1_w1_wl u_t021_003/r1_r0_rwl u_t021_003/r1_r1_rwl
+ u_t021_003/r2_w0_wl u_t021_003/r2_w1_wl u_t021_003/r2_r0_rwl u_t021_003/r2_r1_rwl
+ u_t021_003/r3_w0_wl u_t021_003/r3_w1_wl u_t021_003/r3_r0_rwl u_t021_003/r3_r1_rwl
+ VSS VSS u_t021_003/m2_717_1265# u_t021_003/m2_603_2031# u_t021_003/m2_1290_336#
+ u_t021_003/m2_2000_2037# u_t021_003/m2_791_2909# u_t021_003/m2_7_2126# u_t021_003/m2_2154_2081#
+ u_t021_003/m2_1795_2037# u_t021_003/m2_871_303# u_t021_003/m2_431_438# u_t021_003/m2_1290_2898#
+ u_t021_003/m2_1714_1210# u_t021_003/m2_431_1982# u_t021_003/m2_512_1265# u_t021_003/m2_2573_2126#
+ u_t021_003/m2_603_1259# u_t021_003/m2_2074_2909# u_t021_003/m2_7_336# u_t021_003/m2_717_2037#
+ u_t021_003/m2_1886_2031# u_t021_003/m2_2573_336# u_t021_003/m2_7_2898# u_t021_003/m2_2000_1265#
+ u_t021_003/m2_512_2037# u_t021_003/m2_1795_1265# u_t021_003/m2_1714_1982# u_t021_003/m2_1886_1259#
+ u_t021_003/m2_1290_2126# u_t021_003/m2_1714_438# u_t021_003/m2_431_1210# u_t021_003/m2_2573_2898#
+ u_t021_003/m2_2154_303# u_t021_003/m2_871_2081# VSUBS detronyx_12t_2w2r_rc4_4x4_routed_5layer_direct
Xgf180mcu_as_sc_mcu7t3v3__inv_2_5 VSS VSS gf180mcu_as_sc_mcu7t3v3__inv_2_5/Y gf180mcu_as_sc_mcu7t3v3__inv_2_9/Y
+ gf180mcu_as_sc_mcu7t3v3__inv_2_9/VNW VSUBS gf180mcu_as_sc_mcu7t3v3__inv_2
Xu_t006_000 VSS u_t006_000/c0_w0_br VSS u_t006_000/c0_w1_br u_t006_000/c0_r0_rbl u_t006_000/c0_r1_rbl
+ VSS VSS VSS VSS VSS VSS u_t006_000/c2_w0_bl u_t006_000/c2_w0_br u_t006_000/c2_w1_bl
+ u_t006_000/c2_w1_br u_t006_000/c2_r0_rbl u_t006_000/c2_r1_rbl u_t006_000/c3_w0_bl
+ u_t006_000/c3_w0_br u_t006_000/c3_w1_bl u_t006_000/c3_w1_br u_t006_000/c3_r0_rbl
+ u_t006_000/c3_r1_rbl VSS VSS VSS VSS VSS VSS VSS VSS VSS VSS VSS VSS VSS VSS VSS
+ VSS VSS VSS u_t006_000/m2_717_1265# u_t006_000/m2_603_2031# u_t006_000/m2_1290_336#
+ u_t006_000/m2_2000_2037# u_t006_000/m2_791_2909# u_t006_000/m2_7_2126# u_t006_000/m2_2154_2081#
+ u_t006_000/m2_1795_2037# u_t006_000/m2_871_303# u_t006_000/m2_431_438# u_t006_000/m2_1290_2898#
+ u_t006_000/m2_1714_1210# u_t006_000/m2_431_1982# u_t006_000/m2_512_1265# u_t006_000/m2_2573_2126#
+ u_t006_000/m2_603_1259# u_t006_000/m2_2074_2909# u_t006_000/m2_7_336# u_t006_000/m2_717_2037#
+ u_t006_000/m2_1886_2031# u_t006_000/m2_2573_336# u_t006_000/m2_7_2898# u_t006_000/m2_2000_1265#
+ u_t006_000/m2_512_2037# u_t006_000/m2_1795_1265# u_t006_000/m2_1714_1982# u_t006_000/m2_1886_1259#
+ u_t006_000/m2_1290_2126# u_t006_000/m2_1714_438# u_t006_000/m2_431_1210# u_t006_000/m2_2573_2898#
+ u_t006_000/m2_2154_303# u_t006_000/m2_871_2081# VSUBS detronyx_12t_2w2r_rc4_4x4_routed_5layer_direct
Xu_t021_014 u_t021_014/c0_w0_bl u_t021_014/c0_w0_br u_t021_014/c0_w1_bl u_t021_014/c0_w1_br
+ u_t021_014/c0_r0_rbl u_t021_014/c0_r1_rbl u_t021_014/c1_w0_bl u_t021_014/c1_w0_br
+ u_t021_014/c1_w1_bl u_t021_014/c1_w1_br u_t021_014/c1_r0_rbl u_t021_014/c1_r1_rbl
+ u_t021_014/c2_w0_bl u_t021_014/c2_w0_br u_t021_014/c2_w1_bl u_t021_014/c2_w1_br
+ u_t021_014/c2_r0_rbl u_t021_014/c2_r1_rbl u_t021_014/c3_w0_bl u_t021_014/c3_w0_br
+ u_t021_014/c3_w1_bl u_t021_014/c3_w1_br u_t021_014/c3_r0_rbl u_t021_014/c3_r1_rbl
+ u_t021_014/r0_w0_wl u_t021_014/r0_w1_wl u_t021_014/r0_r0_rwl u_t021_014/r0_r1_rwl
+ u_t021_014/r1_w0_wl u_t021_014/r1_w1_wl u_t021_014/r1_r0_rwl u_t021_014/r1_r1_rwl
+ u_t021_014/r2_w0_wl u_t021_014/r2_w1_wl u_t021_014/r2_r0_rwl u_t021_014/r2_r1_rwl
+ u_t021_014/r3_w0_wl u_t021_014/r3_w1_wl u_t021_014/r3_r0_rwl u_t021_014/r3_r1_rwl
+ VSS VSS u_t021_014/m2_717_1265# u_t021_014/m2_603_2031# u_t021_014/m2_1290_336#
+ u_t021_014/m2_2000_2037# u_t021_014/m2_791_2909# u_t021_014/m2_7_2126# u_t021_014/m2_2154_2081#
+ u_t021_014/m2_1795_2037# u_t021_014/m2_871_303# u_t021_014/m2_431_438# u_t021_014/m2_1290_2898#
+ u_t021_014/m2_1714_1210# u_t021_014/m2_431_1982# u_t021_014/m2_512_1265# u_t021_014/m2_2573_2126#
+ u_t021_014/m2_603_1259# u_t021_014/m2_2074_2909# u_t021_014/m2_7_336# u_t021_014/m2_717_2037#
+ u_t021_014/m2_1886_2031# u_t021_014/m2_2573_336# u_t021_014/m2_7_2898# u_t021_014/m2_2000_1265#
+ u_t021_014/m2_512_2037# u_t021_014/m2_1795_1265# u_t021_014/m2_1714_1982# u_t021_014/m2_1886_1259#
+ u_t021_014/m2_1290_2126# u_t021_014/m2_1714_438# u_t021_014/m2_431_1210# u_t021_014/m2_2573_2898#
+ u_t021_014/m2_2154_303# u_t021_014/m2_871_2081# VSUBS detronyx_12t_2w2r_rc4_4x4_routed_5layer_direct
Xu_t012_014 u_t012_014/c0_w0_bl u_t012_014/c0_w0_br u_t012_014/c0_w1_bl u_t012_014/c0_w1_br
+ u_t012_014/c0_r0_rbl u_t012_014/c0_r1_rbl u_t012_014/c1_w0_bl u_t012_014/c1_w0_br
+ u_t012_014/c1_w1_bl u_t012_014/c1_w1_br u_t012_014/c1_r0_rbl u_t012_014/c1_r1_rbl
+ u_t012_014/c2_w0_bl u_t012_014/c2_w0_br u_t012_014/c2_w1_bl u_t012_014/c2_w1_br
+ u_t012_014/c2_r0_rbl u_t012_014/c2_r1_rbl u_t012_014/c3_w0_bl u_t012_014/c3_w0_br
+ u_t012_014/c3_w1_bl u_t012_014/c3_w1_br u_t012_014/c3_r0_rbl u_t012_014/c3_r1_rbl
+ u_t012_014/r0_w0_wl u_t012_014/r0_w1_wl u_t012_014/r0_r0_rwl u_t012_014/r0_r1_rwl
+ u_t012_014/r1_w0_wl u_t012_014/r1_w1_wl u_t012_014/r1_r0_rwl u_t012_014/r1_r1_rwl
+ u_t012_014/r2_w0_wl u_t012_014/r2_w1_wl u_t012_014/r2_r0_rwl u_t012_014/r2_r1_rwl
+ u_t012_014/r3_w0_wl u_t012_014/r3_w1_wl u_t012_014/r3_r0_rwl u_t012_014/r3_r1_rwl
+ VSS VSS u_t012_014/m2_717_1265# u_t012_014/m2_603_2031# u_t012_014/m2_1290_336#
+ u_t012_014/m2_2000_2037# u_t012_014/m2_791_2909# u_t012_014/m2_7_2126# u_t012_014/m2_2154_2081#
+ u_t012_014/m2_1795_2037# u_t012_014/m2_871_303# u_t012_014/m2_431_438# u_t012_014/m2_1290_2898#
+ u_t012_014/m2_1714_1210# u_t012_014/m2_431_1982# u_t012_014/m2_512_1265# u_t012_014/m2_2573_2126#
+ u_t012_014/m2_603_1259# u_t012_014/m2_2074_2909# u_t012_014/m2_7_336# u_t012_014/m2_717_2037#
+ u_t012_014/m2_1886_2031# u_t012_014/m2_2573_336# u_t012_014/m2_7_2898# u_t012_014/m2_2000_1265#
+ u_t012_014/m2_512_2037# u_t012_014/m2_1795_1265# u_t012_014/m2_1714_1982# u_t012_014/m2_1886_1259#
+ u_t012_014/m2_1290_2126# u_t012_014/m2_1714_438# u_t012_014/m2_431_1210# u_t012_014/m2_2573_2898#
+ u_t012_014/m2_2154_303# u_t012_014/m2_871_2081# VSUBS detronyx_12t_2w2r_rc4_4x4_routed_5layer_direct
Xu_t012_003 u_t012_003/c0_w0_bl u_t012_003/c0_w0_br u_t012_003/c0_w1_bl u_t012_003/c0_w1_br
+ u_t012_003/c0_r0_rbl u_t012_003/c0_r1_rbl u_t012_003/c1_w0_bl u_t012_003/c1_w0_br
+ u_t012_003/c1_w1_bl u_t012_003/c1_w1_br u_t012_003/c1_r0_rbl u_t012_003/c1_r1_rbl
+ u_t012_003/c2_w0_bl u_t012_003/c2_w0_br u_t012_003/c2_w1_bl u_t012_003/c2_w1_br
+ u_t012_003/c2_r0_rbl u_t012_003/c2_r1_rbl u_t012_003/c3_w0_bl u_t012_003/c3_w0_br
+ u_t012_003/c3_w1_bl u_t012_003/c3_w1_br u_t012_003/c3_r0_rbl u_t012_003/c3_r1_rbl
+ u_t012_003/r0_w0_wl u_t012_003/r0_w1_wl u_t012_003/r0_r0_rwl u_t012_003/r0_r1_rwl
+ u_t012_003/r1_w0_wl u_t012_003/r1_w1_wl u_t012_003/r1_r0_rwl u_t012_003/r1_r1_rwl
+ u_t012_003/r2_w0_wl u_t012_003/r2_w1_wl u_t012_003/r2_r0_rwl u_t012_003/r2_r1_rwl
+ u_t012_003/r3_w0_wl u_t012_003/r3_w1_wl u_t012_003/r3_r0_rwl u_t012_003/r3_r1_rwl
+ VSS VSS u_t012_003/m2_717_1265# u_t012_003/m2_603_2031# u_t012_003/m2_1290_336#
+ u_t012_003/m2_2000_2037# u_t012_003/m2_791_2909# u_t012_003/m2_7_2126# u_t012_003/m2_2154_2081#
+ u_t012_003/m2_1795_2037# u_t012_003/m2_871_303# u_t012_003/m2_431_438# u_t012_003/m2_1290_2898#
+ u_t012_003/m2_1714_1210# u_t012_003/m2_431_1982# u_t012_003/m2_512_1265# u_t012_003/m2_2573_2126#
+ u_t012_003/m2_603_1259# u_t012_003/m2_2074_2909# u_t012_003/m2_7_336# u_t012_003/m2_717_2037#
+ u_t012_003/m2_1886_2031# u_t012_003/m2_2573_336# u_t012_003/m2_7_2898# u_t012_003/m2_2000_1265#
+ u_t012_003/m2_512_2037# u_t012_003/m2_1795_1265# u_t012_003/m2_1714_1982# u_t012_003/m2_1886_1259#
+ u_t012_003/m2_1290_2126# u_t012_003/m2_1714_438# u_t012_003/m2_431_1210# u_t012_003/m2_2573_2898#
+ u_t012_003/m2_2154_303# u_t012_003/m2_871_2081# VSUBS detronyx_12t_2w2r_rc4_4x4_routed_5layer_direct
Xgf180mcu_as_sc_mcu7t3v3__inv_2_1473 VSS VSS gf180mcu_as_sc_mcu7t3v3__inv_2_1473/Y
+ gf180mcu_as_sc_mcu7t3v3__inv_2_1473/A gf180mcu_as_sc_mcu7t3v3__inv_2_1473/VNW VSUBS
+ gf180mcu_as_sc_mcu7t3v3__inv_2
Xgf180mcu_as_sc_mcu7t3v3__inv_2_1462 VSS VSS VSS gf180mcu_as_sc_mcu7t3v3__inv_2_1463/Y
+ gf180mcu_as_sc_mcu7t3v3__inv_2_1464/VNW VSUBS gf180mcu_as_sc_mcu7t3v3__inv_2
Xgf180mcu_as_sc_mcu7t3v3__inv_2_1484 VSS VSS gf180mcu_as_sc_mcu7t3v3__inv_2_1484/Y
+ gf180mcu_as_sc_mcu7t3v3__inv_2_1485/Y gf180mcu_as_sc_mcu7t3v3__inv_2_1485/VNW VSUBS
+ gf180mcu_as_sc_mcu7t3v3__inv_2
Xgf180mcu_as_sc_mcu7t3v3__inv_2_1495 VSS VSS VSS gf180mcu_as_sc_mcu7t3v3__inv_2_1496/Y
+ gf180mcu_as_sc_mcu7t3v3__inv_2_1497/VNW VSUBS gf180mcu_as_sc_mcu7t3v3__inv_2
Xgf180mcu_as_sc_mcu7t3v3__inv_2_1451 VSS VSS gf180mcu_as_sc_mcu7t3v3__inv_2_1451/Y
+ gf180mcu_as_sc_mcu7t3v3__inv_2_1452/Y gf180mcu_as_sc_mcu7t3v3__inv_2_1452/VNW VSUBS
+ gf180mcu_as_sc_mcu7t3v3__inv_2
Xgf180mcu_as_sc_mcu7t3v3__inv_2_1440 VSS VSS gf180mcu_as_sc_mcu7t3v3__inv_2_1440/Y
+ gf180mcu_as_sc_mcu7t3v3__inv_2_1440/A gf180mcu_as_sc_mcu7t3v3__inv_2_1440/VNW VSUBS
+ gf180mcu_as_sc_mcu7t3v3__inv_2
Xu_t003_003 u_t003_003/c0_w0_bl u_t003_003/c0_w0_br u_t003_003/c0_w1_bl u_t003_003/c0_w1_br
+ u_t003_003/c0_r0_rbl u_t003_003/c0_r1_rbl u_t003_003/c1_w0_bl u_t003_003/c1_w0_br
+ u_t003_003/c1_w1_bl u_t003_003/c1_w1_br u_t003_003/c1_r0_rbl u_t003_003/c1_r1_rbl
+ u_t003_003/c2_w0_bl u_t003_003/c2_w0_br u_t003_003/c2_w1_bl u_t003_003/c2_w1_br
+ u_t003_003/c2_r0_rbl u_t003_003/c2_r1_rbl u_t003_003/c3_w0_bl u_t003_003/c3_w0_br
+ u_t003_003/c3_w1_bl u_t003_003/c3_w1_br u_t003_003/c3_r0_rbl u_t003_003/c3_r1_rbl
+ u_t003_003/r0_w0_wl u_t003_003/r0_w1_wl u_t003_003/r0_r0_rwl u_t003_003/r0_r1_rwl
+ u_t003_003/r1_w0_wl u_t003_003/r1_w1_wl u_t003_003/r1_r0_rwl u_t003_003/r1_r1_rwl
+ u_t003_003/r2_w0_wl u_t003_003/r2_w1_wl u_t003_003/r2_r0_rwl u_t003_003/r2_r1_rwl
+ u_t003_003/r3_w0_wl u_t003_003/r3_w1_wl u_t003_003/r3_r0_rwl u_t003_003/r3_r1_rwl
+ VSS VSS u_t003_003/m2_717_1265# u_t003_003/m2_603_2031# u_t003_003/m2_1290_336#
+ u_t003_003/m2_2000_2037# u_t003_003/m2_791_2909# u_t003_003/m2_7_2126# u_t003_003/m2_2154_2081#
+ u_t003_003/m2_1795_2037# u_t003_003/m2_871_303# u_t003_003/m2_431_438# u_t003_003/m2_1290_2898#
+ u_t003_003/m2_1714_1210# u_t003_003/m2_431_1982# u_t003_003/m2_512_1265# u_t003_003/m2_2573_2126#
+ u_t003_003/m2_603_1259# u_t003_003/m2_2074_2909# u_t003_003/m2_7_336# u_t003_003/m2_717_2037#
+ u_t003_003/m2_1886_2031# u_t003_003/m2_2573_336# u_t003_003/m2_7_2898# u_t003_003/m2_2000_1265#
+ u_t003_003/m2_512_2037# u_t003_003/m2_1795_1265# u_t003_003/m2_1714_1982# u_t003_003/m2_1886_1259#
+ u_t003_003/m2_1290_2126# u_t003_003/m2_1714_438# u_t003_003/m2_431_1210# u_t003_003/m2_2573_2898#
+ u_t003_003/m2_2154_303# u_t003_003/m2_871_2081# VSUBS detronyx_12t_2w2r_rc4_4x4_routed_5layer_direct
Xgf180mcu_as_sc_mcu7t3v3__inv_2_913 VSS VSS gf180mcu_as_sc_mcu7t3v3__inv_2_945/A gf180mcu_as_sc_mcu7t3v3__inv_2_914/Y
+ gf180mcu_as_sc_mcu7t3v3__inv_2_945/VNW VSUBS gf180mcu_as_sc_mcu7t3v3__inv_2
Xgf180mcu_as_sc_mcu7t3v3__inv_2_946 VSS VSS VSS gf180mcu_as_sc_mcu7t3v3__inv_2_946/A
+ gf180mcu_as_sc_mcu7t3v3__inv_2_946/VNW VSUBS gf180mcu_as_sc_mcu7t3v3__inv_2
Xgf180mcu_as_sc_mcu7t3v3__inv_2_902 VSS VSS gf180mcu_as_sc_mcu7t3v3__inv_2_951/A gf180mcu_as_sc_mcu7t3v3__inv_2_903/Y
+ gf180mcu_as_sc_mcu7t3v3__inv_2_951/VNW VSUBS gf180mcu_as_sc_mcu7t3v3__inv_2
Xgf180mcu_as_sc_mcu7t3v3__inv_2_979 VSS VSS gf180mcu_as_sc_mcu7t3v3__inv_2_979/Y gf180mcu_as_sc_mcu7t3v3__inv_2_980/Y
+ gf180mcu_as_sc_mcu7t3v3__inv_2_980/VNW VSUBS gf180mcu_as_sc_mcu7t3v3__inv_2
Xgf180mcu_as_sc_mcu7t3v3__inv_2_935 VSS VSS VSS gf180mcu_as_sc_mcu7t3v3__inv_2_935/A
+ gf180mcu_as_sc_mcu7t3v3__inv_2_935/VNW VSUBS gf180mcu_as_sc_mcu7t3v3__inv_2
Xgf180mcu_as_sc_mcu7t3v3__inv_2_968 VSS VSS gf180mcu_as_sc_mcu7t3v3__inv_2_968/Y gf180mcu_as_sc_mcu7t3v3__inv_2_968/A
+ gf180mcu_as_sc_mcu7t3v3__inv_2_968/VNW VSUBS gf180mcu_as_sc_mcu7t3v3__inv_2
Xgf180mcu_as_sc_mcu7t3v3__inv_2_924 VSS VSS gf180mcu_as_sc_mcu7t3v3__inv_2_959/A gf180mcu_as_sc_mcu7t3v3__inv_2_924/A
+ gf180mcu_as_sc_mcu7t3v3__inv_2_959/VNW VSUBS gf180mcu_as_sc_mcu7t3v3__inv_2
Xgf180mcu_as_sc_mcu7t3v3__inv_2_957 VSS VSS VSS gf180mcu_as_sc_mcu7t3v3__inv_2_957/A
+ gf180mcu_as_sc_mcu7t3v3__inv_2_957/VNW VSUBS gf180mcu_as_sc_mcu7t3v3__inv_2
Xu_t003_014 u_t003_014/c0_w0_bl u_t003_014/c0_w0_br u_t003_014/c0_w1_bl u_t003_014/c0_w1_br
+ u_t003_014/c0_r0_rbl u_t003_014/c0_r1_rbl u_t003_014/c1_w0_bl u_t003_014/c1_w0_br
+ u_t003_014/c1_w1_bl u_t003_014/c1_w1_br u_t003_014/c1_r0_rbl u_t003_014/c1_r1_rbl
+ u_t003_014/c2_w0_bl u_t003_014/c2_w0_br u_t003_014/c2_w1_bl u_t003_014/c2_w1_br
+ u_t003_014/c2_r0_rbl u_t003_014/c2_r1_rbl u_t003_014/c3_w0_bl u_t003_014/c3_w0_br
+ u_t003_014/c3_w1_bl u_t003_014/c3_w1_br u_t003_014/c3_r0_rbl u_t003_014/c3_r1_rbl
+ u_t003_014/r0_w0_wl u_t003_014/r0_w1_wl u_t003_014/r0_r0_rwl u_t003_014/r0_r1_rwl
+ u_t003_014/r1_w0_wl u_t003_014/r1_w1_wl u_t003_014/r1_r0_rwl u_t003_014/r1_r1_rwl
+ u_t003_014/r2_w0_wl u_t003_014/r2_w1_wl u_t003_014/r2_r0_rwl u_t003_014/r2_r1_rwl
+ u_t003_014/r3_w0_wl u_t003_014/r3_w1_wl u_t003_014/r3_r0_rwl u_t003_014/r3_r1_rwl
+ VSS VSS u_t003_014/m2_717_1265# u_t003_014/m2_603_2031# u_t003_014/m2_1290_336#
+ u_t003_014/m2_2000_2037# u_t003_014/m2_791_2909# u_t003_014/m2_7_2126# u_t003_014/m2_2154_2081#
+ u_t003_014/m2_1795_2037# u_t003_014/m2_871_303# u_t003_014/m2_431_438# u_t003_014/m2_1290_2898#
+ u_t003_014/m2_1714_1210# u_t003_014/m2_431_1982# u_t003_014/m2_512_1265# u_t003_014/m2_2573_2126#
+ u_t003_014/m2_603_1259# u_t003_014/m2_2074_2909# u_t003_014/m2_7_336# u_t003_014/m2_717_2037#
+ u_t003_014/m2_1886_2031# u_t003_014/m2_2573_336# u_t003_014/m2_7_2898# u_t003_014/m2_2000_1265#
+ u_t003_014/m2_512_2037# u_t003_014/m2_1795_1265# u_t003_014/m2_1714_1982# u_t003_014/m2_1886_1259#
+ u_t003_014/m2_1290_2126# u_t003_014/m2_1714_438# u_t003_014/m2_431_1210# u_t003_014/m2_2573_2898#
+ u_t003_014/m2_2154_303# u_t003_014/m2_871_2081# VSUBS detronyx_12t_2w2r_rc4_4x4_routed_5layer_direct
Xgf180mcu_as_sc_mcu7t3v3__nand4_2_201 VSS VSS VSS VSS VSS VSS gf180mcu_as_sc_mcu7t3v3__inv_2_688/A
+ gf180mcu_as_sc_mcu7t3v3__inv_2_688/VNW VSUBS gf180mcu_as_sc_mcu7t3v3__nand4_2
Xgf180mcu_as_sc_mcu7t3v3__nand4_2_278 VSS VSS VSS VSS VSS VSS gf180mcu_as_sc_mcu7t3v3__inv_2_914/A
+ gf180mcu_as_sc_mcu7t3v3__inv_2_945/VNW VSUBS gf180mcu_as_sc_mcu7t3v3__nand4_2
Xgf180mcu_as_sc_mcu7t3v3__nand4_2_223 VSS VSS VSS VSS VSS VSS gf180mcu_as_sc_mcu7t3v3__inv_2_767/A
+ gf180mcu_as_sc_mcu7t3v3__inv_2_823/VNW VSUBS gf180mcu_as_sc_mcu7t3v3__nand4_2
Xgf180mcu_as_sc_mcu7t3v3__nand4_2_212 VSS VSS VSS VSS VSS VSS gf180mcu_as_sc_mcu7t3v3__inv_2_679/A
+ gf180mcu_as_sc_mcu7t3v3__inv_2_679/VNW VSUBS gf180mcu_as_sc_mcu7t3v3__nand4_2
Xgf180mcu_as_sc_mcu7t3v3__nand4_2_245 VSS VSS VSS VSS VSS VSS gf180mcu_as_sc_mcu7t3v3__inv_2_810/A
+ gf180mcu_as_sc_mcu7t3v3__inv_2_848/VNW VSUBS gf180mcu_as_sc_mcu7t3v3__nand4_2
Xgf180mcu_as_sc_mcu7t3v3__nand4_2_234 VSS VSS VSS VSS VSS VSS gf180mcu_as_sc_mcu7t3v3__inv_2_787/A
+ gf180mcu_as_sc_mcu7t3v3__inv_2_842/VNW VSUBS gf180mcu_as_sc_mcu7t3v3__nand4_2
Xgf180mcu_as_sc_mcu7t3v3__nand4_2_289 VSS VSS VSS VSS VSS VSS gf180mcu_as_sc_mcu7t3v3__inv_2_980/A
+ gf180mcu_as_sc_mcu7t3v3__inv_2_980/VNW VSUBS gf180mcu_as_sc_mcu7t3v3__nand4_2
Xgf180mcu_as_sc_mcu7t3v3__nand4_2_256 VSS VSS VSS VSS VSS VSS gf180mcu_as_sc_mcu7t3v3__inv_2_868/A
+ gf180mcu_as_sc_mcu7t3v3__inv_2_928/VNW VSUBS gf180mcu_as_sc_mcu7t3v3__nand4_2
Xgf180mcu_as_sc_mcu7t3v3__nand4_2_267 VSS VSS VSS VSS VSS VSS gf180mcu_as_sc_mcu7t3v3__inv_2_893/A
+ gf180mcu_as_sc_mcu7t3v3__inv_2_925/VNW VSUBS gf180mcu_as_sc_mcu7t3v3__nand4_2
Xgf180mcu_as_sc_mcu7t3v3__inv_2_209 VSS VSS gf180mcu_as_sc_mcu7t3v3__inv_2_209/Y gf180mcu_as_sc_mcu7t3v3__inv_2_209/A
+ gf180mcu_as_sc_mcu7t3v3__inv_2_209/VNW VSUBS gf180mcu_as_sc_mcu7t3v3__inv_2
Xu_t000_006 u_t000_006/c0_w0_bl u_t000_006/c0_w0_br u_t000_006/c0_w1_bl u_t000_006/c0_w1_br
+ u_t000_006/c0_r0_rbl u_t000_006/c0_r1_rbl u_t000_006/c1_w0_bl u_t000_006/c1_w0_br
+ u_t000_006/c1_w1_bl u_t000_006/c1_w1_br u_t000_006/c1_r0_rbl u_t000_006/c1_r1_rbl
+ u_t000_006/c2_w0_bl u_t000_006/c2_w0_br u_t000_006/c2_w1_bl u_t000_006/c2_w1_br
+ u_t000_006/c2_r0_rbl u_t000_006/c2_r1_rbl u_t000_006/c3_w0_bl u_t000_006/c3_w0_br
+ u_t000_006/c3_w1_bl u_t000_006/c3_w1_br u_t000_006/c3_r0_rbl u_t000_006/c3_r1_rbl
+ u_t000_006/r0_w0_wl u_t000_006/r0_w1_wl u_t000_006/r0_r0_rwl u_t000_006/r0_r1_rwl
+ u_t000_006/r1_w0_wl u_t000_006/r1_w1_wl u_t000_006/r1_r0_rwl u_t000_006/r1_r1_rwl
+ u_t000_006/r2_w0_wl u_t000_006/r2_w1_wl u_t000_006/r2_r0_rwl u_t000_006/r2_r1_rwl
+ u_t000_006/r3_w0_wl u_t000_006/r3_w1_wl u_t000_006/r3_r0_rwl u_t000_006/r3_r1_rwl
+ VSS VSS u_t000_006/m2_717_1265# u_t000_006/m2_603_2031# u_t000_006/m2_1290_336#
+ u_t000_006/m2_2000_2037# u_t000_006/m2_791_2909# u_t000_006/m2_7_2126# u_t000_006/m2_2154_2081#
+ u_t000_006/m2_1795_2037# u_t000_006/m2_871_303# u_t000_006/m2_431_438# u_t000_006/m2_1290_2898#
+ u_t000_006/m2_1714_1210# u_t000_006/m2_431_1982# u_t000_006/m2_512_1265# u_t000_006/m2_2573_2126#
+ u_t000_006/m2_603_1259# u_t000_006/m2_2074_2909# u_t000_006/m2_7_336# u_t000_006/m2_717_2037#
+ u_t000_006/m2_1886_2031# u_t000_006/m2_2573_336# u_t000_006/m2_7_2898# u_t000_006/m2_2000_1265#
+ u_t000_006/m2_512_2037# u_t000_006/m2_1795_1265# u_t000_006/m2_1714_1982# u_t000_006/m2_1886_1259#
+ u_t000_006/m2_1290_2126# u_t000_006/m2_1714_438# u_t000_006/m2_431_1210# u_t000_006/m2_2573_2898#
+ u_t000_006/m2_2154_303# u_t000_006/m2_871_2081# VSUBS detronyx_12t_2w2r_rc4_4x4_routed_5layer_direct
Xgf180mcu_as_sc_mcu7t3v3__inv_2_1270 gf180mcu_as_sc_mcu7t3v3__nand3_2_65/VDD gf180mcu_as_sc_mcu7t3v3__nand3_2_62/VSS
+ VSS VSS gf180mcu_as_sc_mcu7t3v3__nand3_2_65/VNW VSUBS gf180mcu_as_sc_mcu7t3v3__inv_2
Xgf180mcu_as_sc_mcu7t3v3__inv_2_1281 VSS VSS VSS gf180mcu_as_sc_mcu7t3v3__inv_2_1281/A
+ gf180mcu_as_sc_mcu7t3v3__inv_2_1281/VNW VSUBS gf180mcu_as_sc_mcu7t3v3__inv_2
Xgf180mcu_as_sc_mcu7t3v3__inv_2_1292 VSS VSS VSS gf180mcu_as_sc_mcu7t3v3__inv_2_1292/A
+ gf180mcu_as_sc_mcu7t3v3__inv_2_1292/VNW VSUBS gf180mcu_as_sc_mcu7t3v3__inv_2
Xgf180mcu_as_sc_mcu7t3v3__inv_2_765 VSS VSS gf180mcu_as_sc_mcu7t3v3__inv_2_765/Y gf180mcu_as_sc_mcu7t3v3__inv_2_765/A
+ gf180mcu_as_sc_mcu7t3v3__inv_2_835/VNW VSUBS gf180mcu_as_sc_mcu7t3v3__inv_2
Xgf180mcu_as_sc_mcu7t3v3__inv_2_754 VSS VSS gf180mcu_as_sc_mcu7t3v3__inv_2_754/Y gf180mcu_as_sc_mcu7t3v3__inv_2_754/A
+ gf180mcu_as_sc_mcu7t3v3__inv_2_831/VNW VSUBS gf180mcu_as_sc_mcu7t3v3__inv_2
Xgf180mcu_as_sc_mcu7t3v3__inv_2_776 VSS VSS gf180mcu_as_sc_mcu7t3v3__inv_2_827/A gf180mcu_as_sc_mcu7t3v3__inv_2_777/Y
+ gf180mcu_as_sc_mcu7t3v3__inv_2_827/VNW VSUBS gf180mcu_as_sc_mcu7t3v3__inv_2
Xgf180mcu_as_sc_mcu7t3v3__inv_2_710 VSS VSS VSS gf180mcu_as_sc_mcu7t3v3__inv_2_711/Y
+ gf180mcu_as_sc_mcu7t3v3__inv_2_712/VNW VSUBS gf180mcu_as_sc_mcu7t3v3__inv_2
Xgf180mcu_as_sc_mcu7t3v3__inv_2_732 VSS VSS VSS gf180mcu_as_sc_mcu7t3v3__inv_2_733/Y
+ gf180mcu_as_sc_mcu7t3v3__inv_2_733/VNW VSUBS gf180mcu_as_sc_mcu7t3v3__inv_2
Xgf180mcu_as_sc_mcu7t3v3__inv_2_721 VSS VSS gf180mcu_as_sc_mcu7t3v3__inv_2_737/A gf180mcu_as_sc_mcu7t3v3__inv_2_721/A
+ gf180mcu_as_sc_mcu7t3v3__inv_2_737/VNW VSUBS gf180mcu_as_sc_mcu7t3v3__inv_2
Xgf180mcu_as_sc_mcu7t3v3__inv_2_798 VSS VSS gf180mcu_as_sc_mcu7t3v3__inv_2_798/Y gf180mcu_as_sc_mcu7t3v3__inv_2_798/A
+ gf180mcu_as_sc_mcu7t3v3__inv_2_846/VNW VSUBS gf180mcu_as_sc_mcu7t3v3__inv_2
Xgf180mcu_as_sc_mcu7t3v3__inv_2_787 VSS VSS gf180mcu_as_sc_mcu7t3v3__inv_2_787/Y gf180mcu_as_sc_mcu7t3v3__inv_2_787/A
+ gf180mcu_as_sc_mcu7t3v3__inv_2_842/VNW VSUBS gf180mcu_as_sc_mcu7t3v3__inv_2
Xgf180mcu_as_sc_mcu7t3v3__inv_2_743 VSS VSS gf180mcu_as_sc_mcu7t3v3__inv_2_743/Y gf180mcu_as_sc_mcu7t3v3__inv_2_743/A
+ gf180mcu_as_sc_mcu7t3v3__inv_2_743/VNW VSUBS gf180mcu_as_sc_mcu7t3v3__inv_2
Xgf180mcu_as_sc_mcu7t3v3__nand4_2_1 VSS VSS VSS VSS VSS VSS gf180mcu_as_sc_mcu7t3v3__inv_2_81/A
+ gf180mcu_as_sc_mcu7t3v3__inv_2_81/VNW VSUBS gf180mcu_as_sc_mcu7t3v3__nand4_2
Xgf180mcu_as_sc_mcu7t3v3__inv_2_540 VSS VSS VSS gf180mcu_as_sc_mcu7t3v3__inv_2_541/Y
+ gf180mcu_as_sc_mcu7t3v3__inv_2_542/VNW VSUBS gf180mcu_as_sc_mcu7t3v3__inv_2
Xgf180mcu_as_sc_mcu7t3v3__inv_2_551 VSS VSS VSS gf180mcu_as_sc_mcu7t3v3__inv_2_551/A
+ gf180mcu_as_sc_mcu7t3v3__inv_2_551/VNW VSUBS gf180mcu_as_sc_mcu7t3v3__inv_2
Xgf180mcu_as_sc_mcu7t3v3__inv_2_573 VSS VSS gf180mcu_as_sc_mcu7t3v3__inv_2_573/Y gf180mcu_as_sc_mcu7t3v3__inv_2_573/A
+ gf180mcu_as_sc_mcu7t3v3__inv_2_573/VNW VSUBS gf180mcu_as_sc_mcu7t3v3__inv_2
Xgf180mcu_as_sc_mcu7t3v3__inv_2_584 VSS VSS gf180mcu_as_sc_mcu7t3v3__inv_2_584/Y gf180mcu_as_sc_mcu7t3v3__inv_2_584/A
+ gf180mcu_as_sc_mcu7t3v3__inv_2_584/VNW VSUBS gf180mcu_as_sc_mcu7t3v3__inv_2
Xgf180mcu_as_sc_mcu7t3v3__inv_2_595 VSS VSS VSS gf180mcu_as_sc_mcu7t3v3__inv_2_599/Y
+ gf180mcu_as_sc_mcu7t3v3__inv_2_603/VNW VSUBS gf180mcu_as_sc_mcu7t3v3__inv_2
Xgf180mcu_as_sc_mcu7t3v3__inv_2_562 VSS VSS VSS gf180mcu_as_sc_mcu7t3v3__inv_2_562/A
+ gf180mcu_as_sc_mcu7t3v3__inv_2_562/VNW VSUBS gf180mcu_as_sc_mcu7t3v3__inv_2
Xu_t028_009 u_t028_009/c0_w0_bl u_t028_009/c0_w0_br u_t028_009/c0_w1_bl u_t028_009/c0_w1_br
+ u_t028_009/c0_r0_rbl u_t028_009/c0_r1_rbl u_t028_009/c1_w0_bl u_t028_009/c1_w0_br
+ u_t028_009/c1_w1_bl u_t028_009/c1_w1_br u_t028_009/c1_r0_rbl u_t028_009/c1_r1_rbl
+ u_t028_009/c2_w0_bl u_t028_009/c2_w0_br u_t028_009/c2_w1_bl u_t028_009/c2_w1_br
+ u_t028_009/c2_r0_rbl u_t028_009/c2_r1_rbl u_t028_009/c3_w0_bl u_t028_009/c3_w0_br
+ u_t028_009/c3_w1_bl u_t028_009/c3_w1_br u_t028_009/c3_r0_rbl u_t028_009/c3_r1_rbl
+ u_t028_009/r0_w0_wl u_t028_009/r0_w1_wl u_t028_009/r0_r0_rwl u_t028_009/r0_r1_rwl
+ u_t028_009/r1_w0_wl u_t028_009/r1_w1_wl u_t028_009/r1_r0_rwl u_t028_009/r1_r1_rwl
+ u_t028_009/r2_w0_wl u_t028_009/r2_w1_wl u_t028_009/r2_r0_rwl u_t028_009/r2_r1_rwl
+ u_t028_009/r3_w0_wl u_t028_009/r3_w1_wl u_t028_009/r3_r0_rwl u_t028_009/r3_r1_rwl
+ VSS VSS u_t028_009/m2_717_1265# u_t028_009/m2_603_2031# u_t028_009/m2_1290_336#
+ u_t028_009/m2_2000_2037# u_t028_009/m2_791_2909# u_t028_009/m2_7_2126# u_t028_009/m2_2154_2081#
+ u_t028_009/m2_1795_2037# u_t028_009/m2_871_303# u_t028_009/m2_431_438# u_t028_009/m2_1290_2898#
+ u_t028_009/m2_1714_1210# u_t028_009/m2_431_1982# u_t028_009/m2_512_1265# u_t028_009/m2_2573_2126#
+ u_t028_009/m2_603_1259# u_t028_009/m2_2074_2909# u_t028_009/m2_7_336# u_t028_009/m2_717_2037#
+ u_t028_009/m2_1886_2031# u_t028_009/m2_2573_336# u_t028_009/m2_7_2898# u_t028_009/m2_2000_1265#
+ u_t028_009/m2_512_2037# u_t028_009/m2_1795_1265# u_t028_009/m2_1714_1982# u_t028_009/m2_1886_1259#
+ u_t028_009/m2_1290_2126# u_t028_009/m2_1714_438# u_t028_009/m2_431_1210# u_t028_009/m2_2573_2898#
+ u_t028_009/m2_2154_303# u_t028_009/m2_871_2081# VSUBS detronyx_12t_2w2r_rc4_4x4_routed_5layer_direct
Xgf180mcu_as_sc_mcu7t3v3__inv_2_370 VSS VSS gf180mcu_as_sc_mcu7t3v3__inv_2_370/Y gf180mcu_as_sc_mcu7t3v3__inv_2_371/Y
+ gf180mcu_as_sc_mcu7t3v3__inv_2_371/VNW VSUBS gf180mcu_as_sc_mcu7t3v3__inv_2
Xgf180mcu_as_sc_mcu7t3v3__inv_2_392 gf180mcu_as_sc_mcu7t3v3__nor2_2_6/VDD gf180mcu_as_sc_mcu7t3v3__nand3_2_4/VSS
+ VSS VSS gf180mcu_as_sc_mcu7t3v3__nor2_2_6/VNW VSUBS gf180mcu_as_sc_mcu7t3v3__inv_2
Xgf180mcu_as_sc_mcu7t3v3__inv_2_381 gf180mcu_as_sc_mcu7t3v3__nor2_2_7/VDD gf180mcu_as_sc_mcu7t3v3__nand3_2_4/VSS
+ VSS VSS gf180mcu_as_sc_mcu7t3v3__nor2_2_7/VNW VSUBS gf180mcu_as_sc_mcu7t3v3__inv_2
Xu_t019_009 u_t019_009/c0_w0_bl u_t019_009/c0_w0_br u_t019_009/c0_w1_bl u_t019_009/c0_w1_br
+ u_t019_009/c0_r0_rbl u_t019_009/c0_r1_rbl u_t019_009/c1_w0_bl u_t019_009/c1_w0_br
+ u_t019_009/c1_w1_bl u_t019_009/c1_w1_br u_t019_009/c1_r0_rbl u_t019_009/c1_r1_rbl
+ u_t019_009/c2_w0_bl u_t019_009/c2_w0_br u_t019_009/c2_w1_bl u_t019_009/c2_w1_br
+ u_t019_009/c2_r0_rbl u_t019_009/c2_r1_rbl u_t019_009/c3_w0_bl u_t019_009/c3_w0_br
+ u_t019_009/c3_w1_bl u_t019_009/c3_w1_br u_t019_009/c3_r0_rbl u_t019_009/c3_r1_rbl
+ u_t019_009/r0_w0_wl u_t019_009/r0_w1_wl u_t019_009/r0_r0_rwl u_t019_009/r0_r1_rwl
+ u_t019_009/r1_w0_wl u_t019_009/r1_w1_wl u_t019_009/r1_r0_rwl u_t019_009/r1_r1_rwl
+ u_t019_009/r2_w0_wl u_t019_009/r2_w1_wl u_t019_009/r2_r0_rwl u_t019_009/r2_r1_rwl
+ u_t019_009/r3_w0_wl u_t019_009/r3_w1_wl u_t019_009/r3_r0_rwl u_t019_009/r3_r1_rwl
+ VSS VSS u_t019_009/m2_717_1265# u_t019_009/m2_603_2031# u_t019_009/m2_1290_336#
+ u_t019_009/m2_2000_2037# u_t019_009/m2_791_2909# u_t019_009/m2_7_2126# u_t019_009/m2_2154_2081#
+ u_t019_009/m2_1795_2037# u_t019_009/m2_871_303# u_t019_009/m2_431_438# u_t019_009/m2_1290_2898#
+ u_t019_009/m2_1714_1210# u_t019_009/m2_431_1982# u_t019_009/m2_512_1265# u_t019_009/m2_2573_2126#
+ u_t019_009/m2_603_1259# u_t019_009/m2_2074_2909# u_t019_009/m2_7_336# u_t019_009/m2_717_2037#
+ u_t019_009/m2_1886_2031# u_t019_009/m2_2573_336# u_t019_009/m2_7_2898# u_t019_009/m2_2000_1265#
+ u_t019_009/m2_512_2037# u_t019_009/m2_1795_1265# u_t019_009/m2_1714_1982# u_t019_009/m2_1886_1259#
+ u_t019_009/m2_1290_2126# u_t019_009/m2_1714_438# u_t019_009/m2_431_1210# u_t019_009/m2_2573_2898#
+ u_t019_009/m2_2154_303# u_t019_009/m2_871_2081# VSUBS detronyx_12t_2w2r_rc4_4x4_routed_5layer_direct
Xgf180mcu_as_sc_mcu7t3v3__nand3_2_46 gf180mcu_as_sc_mcu7t3v3__nor2_2_9/VDD gf180mcu_as_sc_mcu7t3v3__nor2_2_9/VSS
+ VSS VSS VSS VSS gf180mcu_as_sc_mcu7t3v3__nor2_2_9/VNW VSUBS gf180mcu_as_sc_mcu7t3v3__nand3_2
Xgf180mcu_as_sc_mcu7t3v3__nand3_2_13 gf180mcu_as_sc_mcu7t3v3__nor2_2_6/VDD gf180mcu_as_sc_mcu7t3v3__nor2_2_6/VSS
+ VSS VSS VSS VSS gf180mcu_as_sc_mcu7t3v3__nor2_2_6/VNW VSUBS gf180mcu_as_sc_mcu7t3v3__nand3_2
Xgf180mcu_as_sc_mcu7t3v3__nand3_2_24 gf180mcu_as_sc_mcu7t3v3__nor2_2_6/VDD gf180mcu_as_sc_mcu7t3v3__nand3_2_4/VSS
+ VSS VSS VSS VSS gf180mcu_as_sc_mcu7t3v3__nor2_2_6/VNW VSUBS gf180mcu_as_sc_mcu7t3v3__nand3_2
Xgf180mcu_as_sc_mcu7t3v3__nand3_2_35 gf180mcu_as_sc_mcu7t3v3__nor2_2_4/VDD gf180mcu_as_sc_mcu7t3v3__nor2_2_4/VSS
+ VSS VSS VSS VSS gf180mcu_as_sc_mcu7t3v3__nor2_2_4/VNW VSUBS gf180mcu_as_sc_mcu7t3v3__nand3_2
Xu_t024_012 u_t024_012/c0_w0_bl u_t024_012/c0_w0_br u_t024_012/c0_w1_bl u_t024_012/c0_w1_br
+ u_t024_012/c0_r0_rbl u_t024_012/c0_r1_rbl u_t024_012/c1_w0_bl u_t024_012/c1_w0_br
+ u_t024_012/c1_w1_bl u_t024_012/c1_w1_br u_t024_012/c1_r0_rbl u_t024_012/c1_r1_rbl
+ u_t024_012/c2_w0_bl u_t024_012/c2_w0_br u_t024_012/c2_w1_bl u_t024_012/c2_w1_br
+ u_t024_012/c2_r0_rbl u_t024_012/c2_r1_rbl u_t024_012/c3_w0_bl u_t024_012/c3_w0_br
+ u_t024_012/c3_w1_bl u_t024_012/c3_w1_br u_t024_012/c3_r0_rbl u_t024_012/c3_r1_rbl
+ u_t024_012/r0_w0_wl u_t024_012/r0_w1_wl u_t024_012/r0_r0_rwl u_t024_012/r0_r1_rwl
+ u_t024_012/r1_w0_wl u_t024_012/r1_w1_wl u_t024_012/r1_r0_rwl u_t024_012/r1_r1_rwl
+ u_t024_012/r2_w0_wl u_t024_012/r2_w1_wl u_t024_012/r2_r0_rwl u_t024_012/r2_r1_rwl
+ u_t024_012/r3_w0_wl u_t024_012/r3_w1_wl u_t024_012/r3_r0_rwl u_t024_012/r3_r1_rwl
+ VSS VSS u_t024_012/m2_717_1265# u_t024_012/m2_603_2031# u_t024_012/m2_1290_336#
+ u_t024_012/m2_2000_2037# u_t024_012/m2_791_2909# u_t024_012/m2_7_2126# u_t024_012/m2_2154_2081#
+ u_t024_012/m2_1795_2037# u_t024_012/m2_871_303# u_t024_012/m2_431_438# u_t024_012/m2_1290_2898#
+ u_t024_012/m2_1714_1210# u_t024_012/m2_431_1982# u_t024_012/m2_512_1265# u_t024_012/m2_2573_2126#
+ u_t024_012/m2_603_1259# u_t024_012/m2_2074_2909# u_t024_012/m2_7_336# u_t024_012/m2_717_2037#
+ u_t024_012/m2_1886_2031# u_t024_012/m2_2573_336# u_t024_012/m2_7_2898# u_t024_012/m2_2000_1265#
+ u_t024_012/m2_512_2037# u_t024_012/m2_1795_1265# u_t024_012/m2_1714_1982# u_t024_012/m2_1886_1259#
+ u_t024_012/m2_1290_2126# u_t024_012/m2_1714_438# u_t024_012/m2_431_1210# u_t024_012/m2_2573_2898#
+ u_t024_012/m2_2154_303# u_t024_012/m2_871_2081# VSUBS detronyx_12t_2w2r_rc4_4x4_routed_5layer_direct
Xu_t024_001 u_t024_001/c0_w0_bl u_t024_001/c0_w0_br u_t024_001/c0_w1_bl u_t024_001/c0_w1_br
+ u_t024_001/c0_r0_rbl u_t024_001/c0_r1_rbl u_t024_001/c1_w0_bl u_t024_001/c1_w0_br
+ u_t024_001/c1_w1_bl u_t024_001/c1_w1_br u_t024_001/c1_r0_rbl u_t024_001/c1_r1_rbl
+ u_t024_001/c2_w0_bl u_t024_001/c2_w0_br u_t024_001/c2_w1_bl u_t024_001/c2_w1_br
+ u_t024_001/c2_r0_rbl u_t024_001/c2_r1_rbl u_t024_001/c3_w0_bl u_t024_001/c3_w0_br
+ u_t024_001/c3_w1_bl u_t024_001/c3_w1_br u_t024_001/c3_r0_rbl u_t024_001/c3_r1_rbl
+ u_t024_001/r0_w0_wl u_t024_001/r0_w1_wl u_t024_001/r0_r0_rwl u_t024_001/r0_r1_rwl
+ u_t024_001/r1_w0_wl u_t024_001/r1_w1_wl u_t024_001/r1_r0_rwl u_t024_001/r1_r1_rwl
+ u_t024_001/r2_w0_wl u_t024_001/r2_w1_wl u_t024_001/r2_r0_rwl u_t024_001/r2_r1_rwl
+ u_t024_001/r3_w0_wl u_t024_001/r3_w1_wl u_t024_001/r3_r0_rwl u_t024_001/r3_r1_rwl
+ VSS VSS u_t024_001/m2_717_1265# u_t024_001/m2_603_2031# u_t024_001/m2_1290_336#
+ u_t024_001/m2_2000_2037# u_t024_001/m2_791_2909# u_t024_001/m2_7_2126# u_t024_001/m2_2154_2081#
+ u_t024_001/m2_1795_2037# u_t024_001/m2_871_303# u_t024_001/m2_431_438# u_t024_001/m2_1290_2898#
+ u_t024_001/m2_1714_1210# u_t024_001/m2_431_1982# u_t024_001/m2_512_1265# u_t024_001/m2_2573_2126#
+ u_t024_001/m2_603_1259# u_t024_001/m2_2074_2909# u_t024_001/m2_7_336# u_t024_001/m2_717_2037#
+ u_t024_001/m2_1886_2031# u_t024_001/m2_2573_336# u_t024_001/m2_7_2898# u_t024_001/m2_2000_1265#
+ u_t024_001/m2_512_2037# u_t024_001/m2_1795_1265# u_t024_001/m2_1714_1982# u_t024_001/m2_1886_1259#
+ u_t024_001/m2_1290_2126# u_t024_001/m2_1714_438# u_t024_001/m2_431_1210# u_t024_001/m2_2573_2898#
+ u_t024_001/m2_2154_303# u_t024_001/m2_871_2081# VSUBS detronyx_12t_2w2r_rc4_4x4_routed_5layer_direct
Xgf180mcu_as_sc_mcu7t3v3__nand3_2_57 gf180mcu_as_sc_mcu7t3v3__nand3_2_65/VDD gf180mcu_as_sc_mcu7t3v3__nand3_2_62/VSS
+ VSS VSS VSS VSS gf180mcu_as_sc_mcu7t3v3__nand3_2_65/VNW VSUBS gf180mcu_as_sc_mcu7t3v3__nand3_2
Xgf180mcu_as_sc_mcu7t3v3__inv_2_1633 VSS VSS gf180mcu_as_sc_mcu7t3v3__inv_2_1633/Y
+ gf180mcu_as_sc_mcu7t3v3__inv_2_1634/Y gf180mcu_as_sc_mcu7t3v3__inv_2_1634/VNW VSUBS
+ gf180mcu_as_sc_mcu7t3v3__inv_2
Xgf180mcu_as_sc_mcu7t3v3__inv_2_1644 VSS VSS VSS gf180mcu_as_sc_mcu7t3v3__inv_2_1645/Y
+ gf180mcu_as_sc_mcu7t3v3__inv_2_1649/VNW VSUBS gf180mcu_as_sc_mcu7t3v3__inv_2
Xgf180mcu_as_sc_mcu7t3v3__inv_2_1677 VSS VSS gf180mcu_as_sc_mcu7t3v3__inv_2_1677/Y
+ gf180mcu_as_sc_mcu7t3v3__inv_2_1681/Y gf180mcu_as_sc_mcu7t3v3__inv_2_1681/VNW VSUBS
+ gf180mcu_as_sc_mcu7t3v3__inv_2
Xgf180mcu_as_sc_mcu7t3v3__inv_2_1611 VSS VSS gf180mcu_as_sc_mcu7t3v3__inv_2_1611/Y
+ gf180mcu_as_sc_mcu7t3v3__inv_2_1611/A gf180mcu_as_sc_mcu7t3v3__inv_2_1689/VNW VSUBS
+ gf180mcu_as_sc_mcu7t3v3__inv_2
Xgf180mcu_as_sc_mcu7t3v3__inv_2_1600 VSS VSS gf180mcu_as_sc_mcu7t3v3__inv_2_1600/Y
+ gf180mcu_as_sc_mcu7t3v3__inv_2_1601/Y gf180mcu_as_sc_mcu7t3v3__inv_2_1601/VNW VSUBS
+ gf180mcu_as_sc_mcu7t3v3__inv_2
Xgf180mcu_as_sc_mcu7t3v3__inv_2_1622 VSS VSS gf180mcu_as_sc_mcu7t3v3__inv_2_1622/Y
+ gf180mcu_as_sc_mcu7t3v3__inv_2_1622/A gf180mcu_as_sc_mcu7t3v3__inv_2_1622/VNW VSUBS
+ gf180mcu_as_sc_mcu7t3v3__inv_2
Xgf180mcu_as_sc_mcu7t3v3__inv_2_1655 VSS VSS gf180mcu_as_sc_mcu7t3v3__inv_2_1655/Y
+ gf180mcu_as_sc_mcu7t3v3__inv_2_1656/Y gf180mcu_as_sc_mcu7t3v3__inv_2_1656/VNW VSUBS
+ gf180mcu_as_sc_mcu7t3v3__inv_2
Xgf180mcu_as_sc_mcu7t3v3__inv_2_1666 VSS VSS VSS gf180mcu_as_sc_mcu7t3v3__inv_2_1667/Y
+ gf180mcu_as_sc_mcu7t3v3__inv_2_1668/VNW VSUBS gf180mcu_as_sc_mcu7t3v3__inv_2
Xgf180mcu_as_sc_mcu7t3v3__inv_2_1688 VSS VSS gf180mcu_as_sc_mcu7t3v3__inv_2_1688/Y
+ gf180mcu_as_sc_mcu7t3v3__inv_2_1688/A gf180mcu_as_sc_mcu7t3v3__inv_2_1688/VNW VSUBS
+ gf180mcu_as_sc_mcu7t3v3__inv_2
Xgf180mcu_as_sc_mcu7t3v3__inv_2_1699 gf180mcu_as_sc_mcu7t3v3__nand3_2_9/VDD gf180mcu_as_sc_mcu7t3v3__nor2_2_4/VSS
+ VSS VSS gf180mcu_as_sc_mcu7t3v3__nand3_2_9/VNW VSUBS gf180mcu_as_sc_mcu7t3v3__inv_2
Xu_t015_012 u_t015_012/c0_w0_bl u_t015_012/c0_w0_br u_t015_012/c0_w1_bl u_t015_012/c0_w1_br
+ u_t015_012/c0_r0_rbl u_t015_012/c0_r1_rbl u_t015_012/c1_w0_bl u_t015_012/c1_w0_br
+ u_t015_012/c1_w1_bl u_t015_012/c1_w1_br u_t015_012/c1_r0_rbl u_t015_012/c1_r1_rbl
+ u_t015_012/c2_w0_bl u_t015_012/c2_w0_br u_t015_012/c2_w1_bl u_t015_012/c2_w1_br
+ u_t015_012/c2_r0_rbl u_t015_012/c2_r1_rbl u_t015_012/c3_w0_bl u_t015_012/c3_w0_br
+ u_t015_012/c3_w1_bl u_t015_012/c3_w1_br u_t015_012/c3_r0_rbl u_t015_012/c3_r1_rbl
+ u_t015_012/r0_w0_wl u_t015_012/r0_w1_wl u_t015_012/r0_r0_rwl u_t015_012/r0_r1_rwl
+ u_t015_012/r1_w0_wl u_t015_012/r1_w1_wl u_t015_012/r1_r0_rwl u_t015_012/r1_r1_rwl
+ u_t015_012/r2_w0_wl u_t015_012/r2_w1_wl u_t015_012/r2_r0_rwl u_t015_012/r2_r1_rwl
+ u_t015_012/r3_w0_wl u_t015_012/r3_w1_wl u_t015_012/r3_r0_rwl u_t015_012/r3_r1_rwl
+ VSS VSS u_t015_012/m2_717_1265# u_t015_012/m2_603_2031# u_t015_012/m2_1290_336#
+ u_t015_012/m2_2000_2037# u_t015_012/m2_791_2909# u_t015_012/m2_7_2126# u_t015_012/m2_2154_2081#
+ u_t015_012/m2_1795_2037# u_t015_012/m2_871_303# u_t015_012/m2_431_438# u_t015_012/m2_1290_2898#
+ u_t015_012/m2_1714_1210# u_t015_012/m2_431_1982# u_t015_012/m2_512_1265# u_t015_012/m2_2573_2126#
+ u_t015_012/m2_603_1259# u_t015_012/m2_2074_2909# u_t015_012/m2_7_336# u_t015_012/m2_717_2037#
+ u_t015_012/m2_1886_2031# u_t015_012/m2_2573_336# u_t015_012/m2_7_2898# u_t015_012/m2_2000_1265#
+ u_t015_012/m2_512_2037# u_t015_012/m2_1795_1265# u_t015_012/m2_1714_1982# u_t015_012/m2_1886_1259#
+ u_t015_012/m2_1290_2126# u_t015_012/m2_1714_438# u_t015_012/m2_431_1210# u_t015_012/m2_2573_2898#
+ u_t015_012/m2_2154_303# u_t015_012/m2_871_2081# VSUBS detronyx_12t_2w2r_rc4_4x4_routed_5layer_direct
Xu_t015_001 u_t015_001/c0_w0_bl u_t015_001/c0_w0_br u_t015_001/c0_w1_bl u_t015_001/c0_w1_br
+ u_t015_001/c0_r0_rbl u_t015_001/c0_r1_rbl u_t015_001/c1_w0_bl u_t015_001/c1_w0_br
+ u_t015_001/c1_w1_bl u_t015_001/c1_w1_br u_t015_001/c1_r0_rbl u_t015_001/c1_r1_rbl
+ u_t015_001/c2_w0_bl u_t015_001/c2_w0_br u_t015_001/c2_w1_bl u_t015_001/c2_w1_br
+ u_t015_001/c2_r0_rbl u_t015_001/c2_r1_rbl u_t015_001/c3_w0_bl u_t015_001/c3_w0_br
+ u_t015_001/c3_w1_bl u_t015_001/c3_w1_br u_t015_001/c3_r0_rbl u_t015_001/c3_r1_rbl
+ u_t015_001/r0_w0_wl u_t015_001/r0_w1_wl u_t015_001/r0_r0_rwl u_t015_001/r0_r1_rwl
+ u_t015_001/r1_w0_wl u_t015_001/r1_w1_wl u_t015_001/r1_r0_rwl u_t015_001/r1_r1_rwl
+ u_t015_001/r2_w0_wl u_t015_001/r2_w1_wl u_t015_001/r2_r0_rwl u_t015_001/r2_r1_rwl
+ u_t015_001/r3_w0_wl u_t015_001/r3_w1_wl u_t015_001/r3_r0_rwl u_t015_001/r3_r1_rwl
+ VSS VSS u_t015_001/m2_717_1265# u_t015_001/m2_603_2031# u_t015_001/m2_1290_336#
+ u_t015_001/m2_2000_2037# u_t015_001/m2_791_2909# u_t015_001/m2_7_2126# u_t015_001/m2_2154_2081#
+ u_t015_001/m2_1795_2037# u_t015_001/m2_871_303# u_t015_001/m2_431_438# u_t015_001/m2_1290_2898#
+ u_t015_001/m2_1714_1210# u_t015_001/m2_431_1982# u_t015_001/m2_512_1265# u_t015_001/m2_2573_2126#
+ u_t015_001/m2_603_1259# u_t015_001/m2_2074_2909# u_t015_001/m2_7_336# u_t015_001/m2_717_2037#
+ u_t015_001/m2_1886_2031# u_t015_001/m2_2573_336# u_t015_001/m2_7_2898# u_t015_001/m2_2000_1265#
+ u_t015_001/m2_512_2037# u_t015_001/m2_1795_1265# u_t015_001/m2_1714_1982# u_t015_001/m2_1886_1259#
+ u_t015_001/m2_1290_2126# u_t015_001/m2_1714_438# u_t015_001/m2_431_1210# u_t015_001/m2_2573_2898#
+ u_t015_001/m2_2154_303# u_t015_001/m2_871_2081# VSUBS detronyx_12t_2w2r_rc4_4x4_routed_5layer_direct
Xu_t030_015 u_t030_015/c0_w0_bl u_t030_015/c0_w0_br u_t030_015/c0_w1_bl u_t030_015/c0_w1_br
+ u_t030_015/c0_r0_rbl u_t030_015/c0_r1_rbl u_t030_015/c1_w0_bl u_t030_015/c1_w0_br
+ u_t030_015/c1_w1_bl u_t030_015/c1_w1_br u_t030_015/c1_r0_rbl u_t030_015/c1_r1_rbl
+ u_t030_015/c2_w0_bl u_t030_015/c2_w0_br u_t030_015/c2_w1_bl u_t030_015/c2_w1_br
+ u_t030_015/c2_r0_rbl u_t030_015/c2_r1_rbl u_t030_015/c3_w0_bl u_t030_015/c3_w0_br
+ u_t030_015/c3_w1_bl u_t030_015/c3_w1_br u_t030_015/c3_r0_rbl u_t030_015/c3_r1_rbl
+ u_t030_015/r0_w0_wl u_t030_015/r0_w1_wl u_t030_015/r0_r0_rwl u_t030_015/r0_r1_rwl
+ u_t030_015/r1_w0_wl u_t030_015/r1_w1_wl u_t030_015/r1_r0_rwl u_t030_015/r1_r1_rwl
+ u_t030_015/r2_w0_wl u_t030_015/r2_w1_wl u_t030_015/r2_r0_rwl u_t030_015/r2_r1_rwl
+ u_t030_015/r3_w0_wl u_t030_015/r3_w1_wl u_t030_015/r3_r0_rwl u_t030_015/r3_r1_rwl
+ VSS VSS u_t030_015/m2_717_1265# u_t030_015/m2_603_2031# u_t030_015/m2_1290_336#
+ u_t030_015/m2_2000_2037# u_t030_015/m2_791_2909# u_t030_015/m2_7_2126# u_t030_015/m2_2154_2081#
+ u_t030_015/m2_1795_2037# u_t030_015/m2_871_303# u_t030_015/m2_431_438# u_t030_015/m2_1290_2898#
+ u_t030_015/m2_1714_1210# u_t030_015/m2_431_1982# u_t030_015/m2_512_1265# u_t030_015/m2_2573_2126#
+ u_t030_015/m2_603_1259# u_t030_015/m2_2074_2909# u_t030_015/m2_7_336# u_t030_015/m2_717_2037#
+ u_t030_015/m2_1886_2031# u_t030_015/m2_2573_336# u_t030_015/m2_7_2898# u_t030_015/m2_2000_1265#
+ u_t030_015/m2_512_2037# u_t030_015/m2_1795_1265# u_t030_015/m2_1714_1982# u_t030_015/m2_1886_1259#
+ u_t030_015/m2_1290_2126# u_t030_015/m2_1714_438# u_t030_015/m2_431_1210# u_t030_015/m2_2573_2898#
+ u_t030_015/m2_2154_303# u_t030_015/m2_871_2081# VSUBS detronyx_12t_2w2r_rc4_4x4_routed_5layer_direct
Xu_t030_004 u_t030_004/c0_w0_bl u_t030_004/c0_w0_br u_t030_004/c0_w1_bl u_t030_004/c0_w1_br
+ u_t030_004/c0_r0_rbl u_t030_004/c0_r1_rbl u_t030_004/c1_w0_bl u_t030_004/c1_w0_br
+ u_t030_004/c1_w1_bl u_t030_004/c1_w1_br u_t030_004/c1_r0_rbl u_t030_004/c1_r1_rbl
+ u_t030_004/c2_w0_bl u_t030_004/c2_w0_br u_t030_004/c2_w1_bl u_t030_004/c2_w1_br
+ u_t030_004/c2_r0_rbl u_t030_004/c2_r1_rbl u_t030_004/c3_w0_bl u_t030_004/c3_w0_br
+ u_t030_004/c3_w1_bl u_t030_004/c3_w1_br u_t030_004/c3_r0_rbl u_t030_004/c3_r1_rbl
+ u_t030_004/r0_w0_wl u_t030_004/r0_w1_wl u_t030_004/r0_r0_rwl u_t030_004/r0_r1_rwl
+ u_t030_004/r1_w0_wl u_t030_004/r1_w1_wl u_t030_004/r1_r0_rwl u_t030_004/r1_r1_rwl
+ u_t030_004/r2_w0_wl u_t030_004/r2_w1_wl u_t030_004/r2_r0_rwl u_t030_004/r2_r1_rwl
+ u_t030_004/r3_w0_wl u_t030_004/r3_w1_wl u_t030_004/r3_r0_rwl u_t030_004/r3_r1_rwl
+ VSS VSS u_t030_004/m2_717_1265# u_t030_004/m2_603_2031# u_t030_004/m2_1290_336#
+ u_t030_004/m2_2000_2037# u_t030_004/m2_791_2909# u_t030_004/m2_7_2126# u_t030_004/m2_2154_2081#
+ u_t030_004/m2_1795_2037# u_t030_004/m2_871_303# u_t030_004/m2_431_438# u_t030_004/m2_1290_2898#
+ u_t030_004/m2_1714_1210# u_t030_004/m2_431_1982# u_t030_004/m2_512_1265# u_t030_004/m2_2573_2126#
+ u_t030_004/m2_603_1259# u_t030_004/m2_2074_2909# u_t030_004/m2_7_336# u_t030_004/m2_717_2037#
+ u_t030_004/m2_1886_2031# u_t030_004/m2_2573_336# u_t030_004/m2_7_2898# u_t030_004/m2_2000_1265#
+ u_t030_004/m2_512_2037# u_t030_004/m2_1795_1265# u_t030_004/m2_1714_1982# u_t030_004/m2_1886_1259#
+ u_t030_004/m2_1290_2126# u_t030_004/m2_1714_438# u_t030_004/m2_431_1210# u_t030_004/m2_2573_2898#
+ u_t030_004/m2_2154_303# u_t030_004/m2_871_2081# VSUBS detronyx_12t_2w2r_rc4_4x4_routed_5layer_direct
Xgf180mcu_as_sc_mcu7t3v3__nand4_2_438 VSS VSS VSS VSS VSS VSS gf180mcu_as_sc_mcu7t3v3__inv_2_1585/A
+ gf180mcu_as_sc_mcu7t3v3__inv_2_1585/VNW VSUBS gf180mcu_as_sc_mcu7t3v3__nand4_2
Xgf180mcu_as_sc_mcu7t3v3__nand4_2_427 VSS VSS VSS VSS VSS VSS gf180mcu_as_sc_mcu7t3v3__inv_2_1553/A
+ gf180mcu_as_sc_mcu7t3v3__inv_2_1553/VNW VSUBS gf180mcu_as_sc_mcu7t3v3__nand4_2
Xgf180mcu_as_sc_mcu7t3v3__nand4_2_416 VSS VSS VSS VSS VSS VSS gf180mcu_as_sc_mcu7t3v3__inv_2_1520/A
+ gf180mcu_as_sc_mcu7t3v3__inv_2_1520/VNW VSUBS gf180mcu_as_sc_mcu7t3v3__nand4_2
Xgf180mcu_as_sc_mcu7t3v3__nand4_2_405 VSS VSS VSS VSS VSS VSS gf180mcu_as_sc_mcu7t3v3__inv_2_1485/A
+ gf180mcu_as_sc_mcu7t3v3__inv_2_1485/VNW VSUBS gf180mcu_as_sc_mcu7t3v3__nand4_2
Xgf180mcu_as_sc_mcu7t3v3__inv_2_6 VSS VSS VSS gf180mcu_as_sc_mcu7t3v3__inv_2_7/Y gf180mcu_as_sc_mcu7t3v3__inv_2_8/VNW
+ VSUBS gf180mcu_as_sc_mcu7t3v3__inv_2
Xgf180mcu_as_sc_mcu7t3v3__nand4_2_449 VSS VSS VSS VSS VSS VSS gf180mcu_as_sc_mcu7t3v3__inv_2_1332/A
+ gf180mcu_as_sc_mcu7t3v3__inv_2_1332/VNW VSUBS gf180mcu_as_sc_mcu7t3v3__nand4_2
Xu_t021_015 u_t021_015/c0_w0_bl u_t021_015/c0_w0_br u_t021_015/c0_w1_bl u_t021_015/c0_w1_br
+ u_t021_015/c0_r0_rbl u_t021_015/c0_r1_rbl u_t021_015/c1_w0_bl u_t021_015/c1_w0_br
+ u_t021_015/c1_w1_bl u_t021_015/c1_w1_br u_t021_015/c1_r0_rbl u_t021_015/c1_r1_rbl
+ u_t021_015/c2_w0_bl u_t021_015/c2_w0_br u_t021_015/c2_w1_bl u_t021_015/c2_w1_br
+ u_t021_015/c2_r0_rbl u_t021_015/c2_r1_rbl u_t021_015/c3_w0_bl u_t021_015/c3_w0_br
+ u_t021_015/c3_w1_bl u_t021_015/c3_w1_br u_t021_015/c3_r0_rbl u_t021_015/c3_r1_rbl
+ u_t021_015/r0_w0_wl u_t021_015/r0_w1_wl u_t021_015/r0_r0_rwl u_t021_015/r0_r1_rwl
+ u_t021_015/r1_w0_wl u_t021_015/r1_w1_wl u_t021_015/r1_r0_rwl u_t021_015/r1_r1_rwl
+ u_t021_015/r2_w0_wl u_t021_015/r2_w1_wl u_t021_015/r2_r0_rwl u_t021_015/r2_r1_rwl
+ u_t021_015/r3_w0_wl u_t021_015/r3_w1_wl u_t021_015/r3_r0_rwl u_t021_015/r3_r1_rwl
+ VSS VSS u_t021_015/m2_717_1265# u_t021_015/m2_603_2031# u_t021_015/m2_1290_336#
+ u_t021_015/m2_2000_2037# u_t021_015/m2_791_2909# u_t021_015/m2_7_2126# u_t021_015/m2_2154_2081#
+ u_t021_015/m2_1795_2037# u_t021_015/m2_871_303# u_t021_015/m2_431_438# u_t021_015/m2_1290_2898#
+ u_t021_015/m2_1714_1210# u_t021_015/m2_431_1982# u_t021_015/m2_512_1265# u_t021_015/m2_2573_2126#
+ u_t021_015/m2_603_1259# u_t021_015/m2_2074_2909# u_t021_015/m2_7_336# u_t021_015/m2_717_2037#
+ u_t021_015/m2_1886_2031# u_t021_015/m2_2573_336# u_t021_015/m2_7_2898# u_t021_015/m2_2000_1265#
+ u_t021_015/m2_512_2037# u_t021_015/m2_1795_1265# u_t021_015/m2_1714_1982# u_t021_015/m2_1886_1259#
+ u_t021_015/m2_1290_2126# u_t021_015/m2_1714_438# u_t021_015/m2_431_1210# u_t021_015/m2_2573_2898#
+ u_t021_015/m2_2154_303# u_t021_015/m2_871_2081# VSUBS detronyx_12t_2w2r_rc4_4x4_routed_5layer_direct
Xu_t006_012 u_t006_012/c0_w0_bl u_t006_012/c0_w0_br u_t006_012/c0_w1_bl u_t006_012/c0_w1_br
+ u_t006_012/c0_r0_rbl u_t006_012/c0_r1_rbl u_t006_012/c1_w0_bl u_t006_012/c1_w0_br
+ u_t006_012/c1_w1_bl u_t006_012/c1_w1_br u_t006_012/c1_r0_rbl u_t006_012/c1_r1_rbl
+ u_t006_012/c2_w0_bl u_t006_012/c2_w0_br u_t006_012/c2_w1_bl u_t006_012/c2_w1_br
+ u_t006_012/c2_r0_rbl u_t006_012/c2_r1_rbl u_t006_012/c3_w0_bl u_t006_012/c3_w0_br
+ u_t006_012/c3_w1_bl u_t006_012/c3_w1_br u_t006_012/c3_r0_rbl u_t006_012/c3_r1_rbl
+ u_t006_012/r0_w0_wl u_t006_012/r0_w1_wl u_t006_012/r0_r0_rwl u_t006_012/r0_r1_rwl
+ u_t006_012/r1_w0_wl u_t006_012/r1_w1_wl u_t006_012/r1_r0_rwl u_t006_012/r1_r1_rwl
+ u_t006_012/r2_w0_wl u_t006_012/r2_w1_wl u_t006_012/r2_r0_rwl u_t006_012/r2_r1_rwl
+ u_t006_012/r3_w0_wl u_t006_012/r3_w1_wl u_t006_012/r3_r0_rwl u_t006_012/r3_r1_rwl
+ VSS VSS u_t006_012/m2_717_1265# u_t006_012/m2_603_2031# u_t006_012/m2_1290_336#
+ u_t006_012/m2_2000_2037# u_t006_012/m2_791_2909# u_t006_012/m2_7_2126# u_t006_012/m2_2154_2081#
+ u_t006_012/m2_1795_2037# u_t006_012/m2_871_303# u_t006_012/m2_431_438# u_t006_012/m2_1290_2898#
+ u_t006_012/m2_1714_1210# u_t006_012/m2_431_1982# u_t006_012/m2_512_1265# u_t006_012/m2_2573_2126#
+ u_t006_012/m2_603_1259# u_t006_012/m2_2074_2909# u_t006_012/m2_7_336# u_t006_012/m2_717_2037#
+ u_t006_012/m2_1886_2031# u_t006_012/m2_2573_336# u_t006_012/m2_7_2898# u_t006_012/m2_2000_1265#
+ u_t006_012/m2_512_2037# u_t006_012/m2_1795_1265# u_t006_012/m2_1714_1982# u_t006_012/m2_1886_1259#
+ u_t006_012/m2_1290_2126# u_t006_012/m2_1714_438# u_t006_012/m2_431_1210# u_t006_012/m2_2573_2898#
+ u_t006_012/m2_2154_303# u_t006_012/m2_871_2081# VSUBS detronyx_12t_2w2r_rc4_4x4_routed_5layer_direct
Xu_t021_004 u_t021_004/c0_w0_bl u_t021_004/c0_w0_br u_t021_004/c0_w1_bl u_t021_004/c0_w1_br
+ u_t021_004/c0_r0_rbl u_t021_004/c0_r1_rbl u_t021_004/c1_w0_bl u_t021_004/c1_w0_br
+ u_t021_004/c1_w1_bl u_t021_004/c1_w1_br u_t021_004/c1_r0_rbl u_t021_004/c1_r1_rbl
+ u_t021_004/c2_w0_bl u_t021_004/c2_w0_br u_t021_004/c2_w1_bl u_t021_004/c2_w1_br
+ u_t021_004/c2_r0_rbl u_t021_004/c2_r1_rbl u_t021_004/c3_w0_bl u_t021_004/c3_w0_br
+ u_t021_004/c3_w1_bl u_t021_004/c3_w1_br u_t021_004/c3_r0_rbl u_t021_004/c3_r1_rbl
+ u_t021_004/r0_w0_wl u_t021_004/r0_w1_wl u_t021_004/r0_r0_rwl u_t021_004/r0_r1_rwl
+ u_t021_004/r1_w0_wl u_t021_004/r1_w1_wl u_t021_004/r1_r0_rwl u_t021_004/r1_r1_rwl
+ u_t021_004/r2_w0_wl u_t021_004/r2_w1_wl u_t021_004/r2_r0_rwl u_t021_004/r2_r1_rwl
+ u_t021_004/r3_w0_wl u_t021_004/r3_w1_wl u_t021_004/r3_r0_rwl u_t021_004/r3_r1_rwl
+ VSS VSS u_t021_004/m2_717_1265# u_t021_004/m2_603_2031# u_t021_004/m2_1290_336#
+ u_t021_004/m2_2000_2037# u_t021_004/m2_791_2909# u_t021_004/m2_7_2126# u_t021_004/m2_2154_2081#
+ u_t021_004/m2_1795_2037# u_t021_004/m2_871_303# u_t021_004/m2_431_438# u_t021_004/m2_1290_2898#
+ u_t021_004/m2_1714_1210# u_t021_004/m2_431_1982# u_t021_004/m2_512_1265# u_t021_004/m2_2573_2126#
+ u_t021_004/m2_603_1259# u_t021_004/m2_2074_2909# u_t021_004/m2_7_336# u_t021_004/m2_717_2037#
+ u_t021_004/m2_1886_2031# u_t021_004/m2_2573_336# u_t021_004/m2_7_2898# u_t021_004/m2_2000_1265#
+ u_t021_004/m2_512_2037# u_t021_004/m2_1795_1265# u_t021_004/m2_1714_1982# u_t021_004/m2_1886_1259#
+ u_t021_004/m2_1290_2126# u_t021_004/m2_1714_438# u_t021_004/m2_431_1210# u_t021_004/m2_2573_2898#
+ u_t021_004/m2_2154_303# u_t021_004/m2_871_2081# VSUBS detronyx_12t_2w2r_rc4_4x4_routed_5layer_direct
Xu_t006_001 u_t006_001/c0_w0_bl u_t006_001/c0_w0_br u_t006_001/c0_w1_bl u_t006_001/c0_w1_br
+ u_t006_001/c0_r0_rbl u_t006_001/c0_r1_rbl u_t006_001/c1_w0_bl u_t006_001/c1_w0_br
+ u_t006_001/c1_w1_bl u_t006_001/c1_w1_br u_t006_001/c1_r0_rbl u_t006_001/c1_r1_rbl
+ u_t006_001/c2_w0_bl u_t006_001/c2_w0_br u_t006_001/c2_w1_bl u_t006_001/c2_w1_br
+ u_t006_001/c2_r0_rbl u_t006_001/c2_r1_rbl u_t006_001/c3_w0_bl u_t006_001/c3_w0_br
+ u_t006_001/c3_w1_bl u_t006_001/c3_w1_br u_t006_001/c3_r0_rbl u_t006_001/c3_r1_rbl
+ u_t006_001/r0_w0_wl u_t006_001/r0_w1_wl u_t006_001/r0_r0_rwl u_t006_001/r0_r1_rwl
+ u_t006_001/r1_w0_wl u_t006_001/r1_w1_wl u_t006_001/r1_r0_rwl u_t006_001/r1_r1_rwl
+ u_t006_001/r2_w0_wl u_t006_001/r2_w1_wl u_t006_001/r2_r0_rwl u_t006_001/r2_r1_rwl
+ u_t006_001/r3_w0_wl u_t006_001/r3_w1_wl u_t006_001/r3_r0_rwl u_t006_001/r3_r1_rwl
+ VSS VSS u_t006_001/m2_717_1265# u_t006_001/m2_603_2031# u_t006_001/m2_1290_336#
+ u_t006_001/m2_2000_2037# u_t006_001/m2_791_2909# u_t006_001/m2_7_2126# u_t006_001/m2_2154_2081#
+ u_t006_001/m2_1795_2037# u_t006_001/m2_871_303# u_t006_001/m2_431_438# u_t006_001/m2_1290_2898#
+ u_t006_001/m2_1714_1210# u_t006_001/m2_431_1982# u_t006_001/m2_512_1265# u_t006_001/m2_2573_2126#
+ u_t006_001/m2_603_1259# u_t006_001/m2_2074_2909# u_t006_001/m2_7_336# u_t006_001/m2_717_2037#
+ u_t006_001/m2_1886_2031# u_t006_001/m2_2573_336# u_t006_001/m2_7_2898# u_t006_001/m2_2000_1265#
+ u_t006_001/m2_512_2037# u_t006_001/m2_1795_1265# u_t006_001/m2_1714_1982# u_t006_001/m2_1886_1259#
+ u_t006_001/m2_1290_2126# u_t006_001/m2_1714_438# u_t006_001/m2_431_1210# u_t006_001/m2_2573_2898#
+ u_t006_001/m2_2154_303# u_t006_001/m2_871_2081# VSUBS detronyx_12t_2w2r_rc4_4x4_routed_5layer_direct
Xu_t012_015 u_t012_015/c0_w0_bl u_t012_015/c0_w0_br u_t012_015/c0_w1_bl u_t012_015/c0_w1_br
+ u_t012_015/c0_r0_rbl u_t012_015/c0_r1_rbl u_t012_015/c1_w0_bl u_t012_015/c1_w0_br
+ u_t012_015/c1_w1_bl u_t012_015/c1_w1_br u_t012_015/c1_r0_rbl u_t012_015/c1_r1_rbl
+ u_t012_015/c2_w0_bl u_t012_015/c2_w0_br u_t012_015/c2_w1_bl u_t012_015/c2_w1_br
+ u_t012_015/c2_r0_rbl u_t012_015/c2_r1_rbl u_t012_015/c3_w0_bl u_t012_015/c3_w0_br
+ u_t012_015/c3_w1_bl u_t012_015/c3_w1_br u_t012_015/c3_r0_rbl u_t012_015/c3_r1_rbl
+ u_t012_015/r0_w0_wl u_t012_015/r0_w1_wl u_t012_015/r0_r0_rwl u_t012_015/r0_r1_rwl
+ u_t012_015/r1_w0_wl u_t012_015/r1_w1_wl u_t012_015/r1_r0_rwl u_t012_015/r1_r1_rwl
+ u_t012_015/r2_w0_wl u_t012_015/r2_w1_wl u_t012_015/r2_r0_rwl u_t012_015/r2_r1_rwl
+ u_t012_015/r3_w0_wl u_t012_015/r3_w1_wl u_t012_015/r3_r0_rwl u_t012_015/r3_r1_rwl
+ VSS VSS u_t012_015/m2_717_1265# u_t012_015/m2_603_2031# u_t012_015/m2_1290_336#
+ u_t012_015/m2_2000_2037# u_t012_015/m2_791_2909# u_t012_015/m2_7_2126# u_t012_015/m2_2154_2081#
+ u_t012_015/m2_1795_2037# u_t012_015/m2_871_303# u_t012_015/m2_431_438# u_t012_015/m2_1290_2898#
+ u_t012_015/m2_1714_1210# u_t012_015/m2_431_1982# u_t012_015/m2_512_1265# u_t012_015/m2_2573_2126#
+ u_t012_015/m2_603_1259# u_t012_015/m2_2074_2909# u_t012_015/m2_7_336# u_t012_015/m2_717_2037#
+ u_t012_015/m2_1886_2031# u_t012_015/m2_2573_336# u_t012_015/m2_7_2898# u_t012_015/m2_2000_1265#
+ u_t012_015/m2_512_2037# u_t012_015/m2_1795_1265# u_t012_015/m2_1714_1982# u_t012_015/m2_1886_1259#
+ u_t012_015/m2_1290_2126# u_t012_015/m2_1714_438# u_t012_015/m2_431_1210# u_t012_015/m2_2573_2898#
+ u_t012_015/m2_2154_303# u_t012_015/m2_871_2081# VSUBS detronyx_12t_2w2r_rc4_4x4_routed_5layer_direct
Xu_t012_004 u_t012_004/c0_w0_bl u_t012_004/c0_w0_br u_t012_004/c0_w1_bl u_t012_004/c0_w1_br
+ u_t012_004/c0_r0_rbl u_t012_004/c0_r1_rbl u_t012_004/c1_w0_bl u_t012_004/c1_w0_br
+ u_t012_004/c1_w1_bl u_t012_004/c1_w1_br u_t012_004/c1_r0_rbl u_t012_004/c1_r1_rbl
+ u_t012_004/c2_w0_bl u_t012_004/c2_w0_br u_t012_004/c2_w1_bl u_t012_004/c2_w1_br
+ u_t012_004/c2_r0_rbl u_t012_004/c2_r1_rbl u_t012_004/c3_w0_bl u_t012_004/c3_w0_br
+ u_t012_004/c3_w1_bl u_t012_004/c3_w1_br u_t012_004/c3_r0_rbl u_t012_004/c3_r1_rbl
+ u_t012_004/r0_w0_wl u_t012_004/r0_w1_wl u_t012_004/r0_r0_rwl u_t012_004/r0_r1_rwl
+ u_t012_004/r1_w0_wl u_t012_004/r1_w1_wl u_t012_004/r1_r0_rwl u_t012_004/r1_r1_rwl
+ u_t012_004/r2_w0_wl u_t012_004/r2_w1_wl u_t012_004/r2_r0_rwl u_t012_004/r2_r1_rwl
+ u_t012_004/r3_w0_wl u_t012_004/r3_w1_wl u_t012_004/r3_r0_rwl u_t012_004/r3_r1_rwl
+ VSS VSS u_t012_004/m2_717_1265# u_t012_004/m2_603_2031# u_t012_004/m2_1290_336#
+ u_t012_004/m2_2000_2037# u_t012_004/m2_791_2909# u_t012_004/m2_7_2126# u_t012_004/m2_2154_2081#
+ u_t012_004/m2_1795_2037# u_t012_004/m2_871_303# u_t012_004/m2_431_438# u_t012_004/m2_1290_2898#
+ u_t012_004/m2_1714_1210# u_t012_004/m2_431_1982# u_t012_004/m2_512_1265# u_t012_004/m2_2573_2126#
+ u_t012_004/m2_603_1259# u_t012_004/m2_2074_2909# u_t012_004/m2_7_336# u_t012_004/m2_717_2037#
+ u_t012_004/m2_1886_2031# u_t012_004/m2_2573_336# u_t012_004/m2_7_2898# u_t012_004/m2_2000_1265#
+ u_t012_004/m2_512_2037# u_t012_004/m2_1795_1265# u_t012_004/m2_1714_1982# u_t012_004/m2_1886_1259#
+ u_t012_004/m2_1290_2126# u_t012_004/m2_1714_438# u_t012_004/m2_431_1210# u_t012_004/m2_2573_2898#
+ u_t012_004/m2_2154_303# u_t012_004/m2_871_2081# VSUBS detronyx_12t_2w2r_rc4_4x4_routed_5layer_direct
Xgf180mcu_as_sc_mcu7t3v3__inv_2_1474 VSS VSS VSS gf180mcu_as_sc_mcu7t3v3__inv_2_1475/Y
+ gf180mcu_as_sc_mcu7t3v3__inv_2_1476/VNW VSUBS gf180mcu_as_sc_mcu7t3v3__inv_2
Xgf180mcu_as_sc_mcu7t3v3__inv_2_1463 VSS VSS gf180mcu_as_sc_mcu7t3v3__inv_2_1463/Y
+ gf180mcu_as_sc_mcu7t3v3__inv_2_1464/Y gf180mcu_as_sc_mcu7t3v3__inv_2_1464/VNW VSUBS
+ gf180mcu_as_sc_mcu7t3v3__inv_2
Xgf180mcu_as_sc_mcu7t3v3__inv_2_1485 VSS VSS gf180mcu_as_sc_mcu7t3v3__inv_2_1485/Y
+ gf180mcu_as_sc_mcu7t3v3__inv_2_1485/A gf180mcu_as_sc_mcu7t3v3__inv_2_1485/VNW VSUBS
+ gf180mcu_as_sc_mcu7t3v3__inv_2
Xgf180mcu_as_sc_mcu7t3v3__inv_2_1496 VSS VSS gf180mcu_as_sc_mcu7t3v3__inv_2_1496/Y
+ gf180mcu_as_sc_mcu7t3v3__inv_2_1497/Y gf180mcu_as_sc_mcu7t3v3__inv_2_1497/VNW VSUBS
+ gf180mcu_as_sc_mcu7t3v3__inv_2
Xgf180mcu_as_sc_mcu7t3v3__inv_2_1452 VSS VSS gf180mcu_as_sc_mcu7t3v3__inv_2_1452/Y
+ gf180mcu_as_sc_mcu7t3v3__inv_2_1452/A gf180mcu_as_sc_mcu7t3v3__inv_2_1452/VNW VSUBS
+ gf180mcu_as_sc_mcu7t3v3__inv_2
Xgf180mcu_as_sc_mcu7t3v3__inv_2_1441 VSS VSS VSS gf180mcu_as_sc_mcu7t3v3__inv_2_1442/Y
+ gf180mcu_as_sc_mcu7t3v3__inv_2_1443/VNW VSUBS gf180mcu_as_sc_mcu7t3v3__inv_2
Xgf180mcu_as_sc_mcu7t3v3__inv_2_1430 VSS VSS gf180mcu_as_sc_mcu7t3v3__inv_2_1430/Y
+ gf180mcu_as_sc_mcu7t3v3__inv_2_1431/Y gf180mcu_as_sc_mcu7t3v3__inv_2_1431/VNW VSUBS
+ gf180mcu_as_sc_mcu7t3v3__inv_2
Xu_t003_015 u_t003_015/c0_w0_bl u_t003_015/c0_w0_br u_t003_015/c0_w1_bl u_t003_015/c0_w1_br
+ u_t003_015/c0_r0_rbl u_t003_015/c0_r1_rbl u_t003_015/c1_w0_bl u_t003_015/c1_w0_br
+ u_t003_015/c1_w1_bl u_t003_015/c1_w1_br u_t003_015/c1_r0_rbl u_t003_015/c1_r1_rbl
+ u_t003_015/c2_w0_bl u_t003_015/c2_w0_br u_t003_015/c2_w1_bl u_t003_015/c2_w1_br
+ u_t003_015/c2_r0_rbl u_t003_015/c2_r1_rbl u_t003_015/c3_w0_bl u_t003_015/c3_w0_br
+ u_t003_015/c3_w1_bl u_t003_015/c3_w1_br u_t003_015/c3_r0_rbl u_t003_015/c3_r1_rbl
+ u_t003_015/r0_w0_wl u_t003_015/r0_w1_wl u_t003_015/r0_r0_rwl u_t003_015/r0_r1_rwl
+ u_t003_015/r1_w0_wl u_t003_015/r1_w1_wl u_t003_015/r1_r0_rwl u_t003_015/r1_r1_rwl
+ u_t003_015/r2_w0_wl u_t003_015/r2_w1_wl u_t003_015/r2_r0_rwl u_t003_015/r2_r1_rwl
+ u_t003_015/r3_w0_wl u_t003_015/r3_w1_wl u_t003_015/r3_r0_rwl u_t003_015/r3_r1_rwl
+ VSS VSS u_t003_015/m2_717_1265# u_t003_015/m2_603_2031# u_t003_015/m2_1290_336#
+ u_t003_015/m2_2000_2037# u_t003_015/m2_791_2909# u_t003_015/m2_7_2126# u_t003_015/m2_2154_2081#
+ u_t003_015/m2_1795_2037# u_t003_015/m2_871_303# u_t003_015/m2_431_438# u_t003_015/m2_1290_2898#
+ u_t003_015/m2_1714_1210# u_t003_015/m2_431_1982# u_t003_015/m2_512_1265# u_t003_015/m2_2573_2126#
+ u_t003_015/m2_603_1259# u_t003_015/m2_2074_2909# u_t003_015/m2_7_336# u_t003_015/m2_717_2037#
+ u_t003_015/m2_1886_2031# u_t003_015/m2_2573_336# u_t003_015/m2_7_2898# u_t003_015/m2_2000_1265#
+ u_t003_015/m2_512_2037# u_t003_015/m2_1795_1265# u_t003_015/m2_1714_1982# u_t003_015/m2_1886_1259#
+ u_t003_015/m2_1290_2126# u_t003_015/m2_1714_438# u_t003_015/m2_431_1210# u_t003_015/m2_2573_2898#
+ u_t003_015/m2_2154_303# u_t003_015/m2_871_2081# VSUBS detronyx_12t_2w2r_rc4_4x4_routed_5layer_direct
Xu_t003_004 u_t003_004/c0_w0_bl u_t003_004/c0_w0_br u_t003_004/c0_w1_bl u_t003_004/c0_w1_br
+ u_t003_004/c0_r0_rbl u_t003_004/c0_r1_rbl u_t003_004/c1_w0_bl u_t003_004/c1_w0_br
+ u_t003_004/c1_w1_bl u_t003_004/c1_w1_br u_t003_004/c1_r0_rbl u_t003_004/c1_r1_rbl
+ u_t003_004/c2_w0_bl u_t003_004/c2_w0_br u_t003_004/c2_w1_bl u_t003_004/c2_w1_br
+ u_t003_004/c2_r0_rbl u_t003_004/c2_r1_rbl u_t003_004/c3_w0_bl u_t003_004/c3_w0_br
+ u_t003_004/c3_w1_bl u_t003_004/c3_w1_br u_t003_004/c3_r0_rbl u_t003_004/c3_r1_rbl
+ u_t003_004/r0_w0_wl u_t003_004/r0_w1_wl u_t003_004/r0_r0_rwl u_t003_004/r0_r1_rwl
+ u_t003_004/r1_w0_wl u_t003_004/r1_w1_wl u_t003_004/r1_r0_rwl u_t003_004/r1_r1_rwl
+ u_t003_004/r2_w0_wl u_t003_004/r2_w1_wl u_t003_004/r2_r0_rwl u_t003_004/r2_r1_rwl
+ u_t003_004/r3_w0_wl u_t003_004/r3_w1_wl u_t003_004/r3_r0_rwl u_t003_004/r3_r1_rwl
+ VSS VSS u_t003_004/m2_717_1265# u_t003_004/m2_603_2031# u_t003_004/m2_1290_336#
+ u_t003_004/m2_2000_2037# u_t003_004/m2_791_2909# u_t003_004/m2_7_2126# u_t003_004/m2_2154_2081#
+ u_t003_004/m2_1795_2037# u_t003_004/m2_871_303# u_t003_004/m2_431_438# u_t003_004/m2_1290_2898#
+ u_t003_004/m2_1714_1210# u_t003_004/m2_431_1982# u_t003_004/m2_512_1265# u_t003_004/m2_2573_2126#
+ u_t003_004/m2_603_1259# u_t003_004/m2_2074_2909# u_t003_004/m2_7_336# u_t003_004/m2_717_2037#
+ u_t003_004/m2_1886_2031# u_t003_004/m2_2573_336# u_t003_004/m2_7_2898# u_t003_004/m2_2000_1265#
+ u_t003_004/m2_512_2037# u_t003_004/m2_1795_1265# u_t003_004/m2_1714_1982# u_t003_004/m2_1886_1259#
+ u_t003_004/m2_1290_2126# u_t003_004/m2_1714_438# u_t003_004/m2_431_1210# u_t003_004/m2_2573_2898#
+ u_t003_004/m2_2154_303# u_t003_004/m2_871_2081# VSUBS detronyx_12t_2w2r_rc4_4x4_routed_5layer_direct
Xgf180mcu_as_sc_mcu7t3v3__inv_2_914 VSS VSS gf180mcu_as_sc_mcu7t3v3__inv_2_914/Y gf180mcu_as_sc_mcu7t3v3__inv_2_914/A
+ gf180mcu_as_sc_mcu7t3v3__inv_2_945/VNW VSUBS gf180mcu_as_sc_mcu7t3v3__inv_2
Xgf180mcu_as_sc_mcu7t3v3__inv_2_947 VSS VSS VSS gf180mcu_as_sc_mcu7t3v3__inv_2_947/A
+ gf180mcu_as_sc_mcu7t3v3__inv_2_947/VNW VSUBS gf180mcu_as_sc_mcu7t3v3__inv_2
Xgf180mcu_as_sc_mcu7t3v3__inv_2_903 VSS VSS gf180mcu_as_sc_mcu7t3v3__inv_2_903/Y gf180mcu_as_sc_mcu7t3v3__inv_2_903/A
+ gf180mcu_as_sc_mcu7t3v3__inv_2_951/VNW VSUBS gf180mcu_as_sc_mcu7t3v3__inv_2
Xgf180mcu_as_sc_mcu7t3v3__inv_2_936 VSS VSS VSS gf180mcu_as_sc_mcu7t3v3__inv_2_936/A
+ gf180mcu_as_sc_mcu7t3v3__inv_2_936/VNW VSUBS gf180mcu_as_sc_mcu7t3v3__inv_2
Xgf180mcu_as_sc_mcu7t3v3__inv_2_969 VSS VSS gf180mcu_as_sc_mcu7t3v3__inv_2_969/Y gf180mcu_as_sc_mcu7t3v3__inv_2_969/A
+ gf180mcu_as_sc_mcu7t3v3__inv_2_969/VNW VSUBS gf180mcu_as_sc_mcu7t3v3__inv_2
Xgf180mcu_as_sc_mcu7t3v3__inv_2_958 VSS VSS VSS gf180mcu_as_sc_mcu7t3v3__inv_2_959/Y
+ gf180mcu_as_sc_mcu7t3v3__inv_2_959/VNW VSUBS gf180mcu_as_sc_mcu7t3v3__inv_2
Xgf180mcu_as_sc_mcu7t3v3__inv_2_925 VSS VSS VSS gf180mcu_as_sc_mcu7t3v3__inv_2_925/A
+ gf180mcu_as_sc_mcu7t3v3__inv_2_925/VNW VSUBS gf180mcu_as_sc_mcu7t3v3__inv_2
Xgf180mcu_as_sc_mcu7t3v3__nand4_2_202 VSS VSS VSS VSS VSS VSS gf180mcu_as_sc_mcu7t3v3__inv_2_692/A
+ gf180mcu_as_sc_mcu7t3v3__inv_2_692/VNW VSUBS gf180mcu_as_sc_mcu7t3v3__nand4_2
Xgf180mcu_as_sc_mcu7t3v3__nand4_2_224 VSS VSS VSS VSS VSS VSS gf180mcu_as_sc_mcu7t3v3__inv_2_770/A
+ gf180mcu_as_sc_mcu7t3v3__inv_2_824/VNW VSUBS gf180mcu_as_sc_mcu7t3v3__nand4_2
Xgf180mcu_as_sc_mcu7t3v3__nand4_2_213 VSS VSS VSS VSS VSS VSS gf180mcu_as_sc_mcu7t3v3__inv_2_780/A
+ gf180mcu_as_sc_mcu7t3v3__inv_2_828/VNW VSUBS gf180mcu_as_sc_mcu7t3v3__nand4_2
Xgf180mcu_as_sc_mcu7t3v3__nand4_2_235 VSS VSS VSS VSS VSS VSS gf180mcu_as_sc_mcu7t3v3__inv_2_790/A
+ gf180mcu_as_sc_mcu7t3v3__inv_2_843/VNW VSUBS gf180mcu_as_sc_mcu7t3v3__nand4_2
Xgf180mcu_as_sc_mcu7t3v3__nand4_2_268 VSS VSS VSS VSS VSS VSS gf180mcu_as_sc_mcu7t3v3__inv_2_896/A
+ gf180mcu_as_sc_mcu7t3v3__inv_2_926/VNW VSUBS gf180mcu_as_sc_mcu7t3v3__nand4_2
Xgf180mcu_as_sc_mcu7t3v3__nand4_2_279 VSS VSS VSS VSS VSS VSS gf180mcu_as_sc_mcu7t3v3__inv_2_917/A
+ gf180mcu_as_sc_mcu7t3v3__inv_2_946/VNW VSUBS gf180mcu_as_sc_mcu7t3v3__nand4_2
Xgf180mcu_as_sc_mcu7t3v3__nand4_2_246 VSS VSS VSS VSS VSS VSS gf180mcu_as_sc_mcu7t3v3__inv_2_814/A
+ gf180mcu_as_sc_mcu7t3v3__inv_2_841/VNW VSUBS gf180mcu_as_sc_mcu7t3v3__nand4_2
Xgf180mcu_as_sc_mcu7t3v3__nand4_2_257 VSS VSS VSS VSS VSS VSS gf180mcu_as_sc_mcu7t3v3__inv_2_871/A
+ gf180mcu_as_sc_mcu7t3v3__inv_2_929/VNW VSUBS gf180mcu_as_sc_mcu7t3v3__nand4_2
Xu_t000_007 u_t000_007/c0_w0_bl u_t000_007/c0_w0_br u_t000_007/c0_w1_bl u_t000_007/c0_w1_br
+ u_t000_007/c0_r0_rbl u_t000_007/c0_r1_rbl u_t000_007/c1_w0_bl u_t000_007/c1_w0_br
+ u_t000_007/c1_w1_bl u_t000_007/c1_w1_br u_t000_007/c1_r0_rbl u_t000_007/c1_r1_rbl
+ u_t000_007/c2_w0_bl u_t000_007/c2_w0_br u_t000_007/c2_w1_bl u_t000_007/c2_w1_br
+ u_t000_007/c2_r0_rbl u_t000_007/c2_r1_rbl u_t000_007/c3_w0_bl u_t000_007/c3_w0_br
+ u_t000_007/c3_w1_bl u_t000_007/c3_w1_br u_t000_007/c3_r0_rbl u_t000_007/c3_r1_rbl
+ u_t000_007/r0_w0_wl u_t000_007/r0_w1_wl u_t000_007/r0_r0_rwl u_t000_007/r0_r1_rwl
+ u_t000_007/r1_w0_wl u_t000_007/r1_w1_wl u_t000_007/r1_r0_rwl u_t000_007/r1_r1_rwl
+ u_t000_007/r2_w0_wl u_t000_007/r2_w1_wl u_t000_007/r2_r0_rwl u_t000_007/r2_r1_rwl
+ u_t000_007/r3_w0_wl u_t000_007/r3_w1_wl u_t000_007/r3_r0_rwl u_t000_007/r3_r1_rwl
+ VSS VSS u_t000_007/m2_717_1265# u_t000_007/m2_603_2031# u_t000_007/m2_1290_336#
+ u_t000_007/m2_2000_2037# u_t000_007/m2_791_2909# u_t000_007/m2_7_2126# u_t000_007/m2_2154_2081#
+ u_t000_007/m2_1795_2037# u_t000_007/m2_871_303# u_t000_007/m2_431_438# u_t000_007/m2_1290_2898#
+ u_t000_007/m2_1714_1210# u_t000_007/m2_431_1982# u_t000_007/m2_512_1265# u_t000_007/m2_2573_2126#
+ u_t000_007/m2_603_1259# u_t000_007/m2_2074_2909# u_t000_007/m2_7_336# u_t000_007/m2_717_2037#
+ u_t000_007/m2_1886_2031# u_t000_007/m2_2573_336# u_t000_007/m2_7_2898# u_t000_007/m2_2000_1265#
+ u_t000_007/m2_512_2037# u_t000_007/m2_1795_1265# u_t000_007/m2_1714_1982# u_t000_007/m2_1886_1259#
+ u_t000_007/m2_1290_2126# u_t000_007/m2_1714_438# u_t000_007/m2_431_1210# u_t000_007/m2_2573_2898#
+ u_t000_007/m2_2154_303# u_t000_007/m2_871_2081# VSUBS detronyx_12t_2w2r_rc4_4x4_routed_5layer_direct
Xgf180mcu_as_sc_mcu7t3v3__inv_2_1260 gf180mcu_as_sc_mcu7t3v3__nor2_2_9/VDD gf180mcu_as_sc_mcu7t3v3__nor2_2_9/VSS
+ VSS VSS gf180mcu_as_sc_mcu7t3v3__nor2_2_9/VNW VSUBS gf180mcu_as_sc_mcu7t3v3__inv_2
Xgf180mcu_as_sc_mcu7t3v3__inv_2_1271 VSS VSS VSS gf180mcu_as_sc_mcu7t3v3__inv_2_1271/A
+ gf180mcu_as_sc_mcu7t3v3__inv_2_1271/VNW VSUBS gf180mcu_as_sc_mcu7t3v3__inv_2
Xgf180mcu_as_sc_mcu7t3v3__inv_2_1282 VSS VSS VSS gf180mcu_as_sc_mcu7t3v3__inv_2_1282/A
+ gf180mcu_as_sc_mcu7t3v3__inv_2_1282/VNW VSUBS gf180mcu_as_sc_mcu7t3v3__inv_2
Xgf180mcu_as_sc_mcu7t3v3__inv_2_1293 VSS VSS VSS gf180mcu_as_sc_mcu7t3v3__inv_2_1293/A
+ gf180mcu_as_sc_mcu7t3v3__inv_2_1293/VNW VSUBS gf180mcu_as_sc_mcu7t3v3__inv_2
Xgf180mcu_as_sc_mcu7t3v3__inv_2_711 VSS VSS gf180mcu_as_sc_mcu7t3v3__inv_2_711/Y gf180mcu_as_sc_mcu7t3v3__inv_2_712/Y
+ gf180mcu_as_sc_mcu7t3v3__inv_2_712/VNW VSUBS gf180mcu_as_sc_mcu7t3v3__inv_2
Xgf180mcu_as_sc_mcu7t3v3__inv_2_700 VSS VSS gf180mcu_as_sc_mcu7t3v3__inv_2_721/A gf180mcu_as_sc_mcu7t3v3__inv_2_700/A
+ gf180mcu_as_sc_mcu7t3v3__inv_2_737/VNW VSUBS gf180mcu_as_sc_mcu7t3v3__inv_2
Xgf180mcu_as_sc_mcu7t3v3__inv_2_766 VSS VSS gf180mcu_as_sc_mcu7t3v3__inv_2_823/A gf180mcu_as_sc_mcu7t3v3__inv_2_767/Y
+ gf180mcu_as_sc_mcu7t3v3__inv_2_823/VNW VSUBS gf180mcu_as_sc_mcu7t3v3__inv_2
Xgf180mcu_as_sc_mcu7t3v3__inv_2_755 VSS VSS gf180mcu_as_sc_mcu7t3v3__inv_2_835/A gf180mcu_as_sc_mcu7t3v3__inv_2_765/Y
+ gf180mcu_as_sc_mcu7t3v3__inv_2_835/VNW VSUBS gf180mcu_as_sc_mcu7t3v3__inv_2
Xgf180mcu_as_sc_mcu7t3v3__inv_2_777 VSS VSS gf180mcu_as_sc_mcu7t3v3__inv_2_777/Y gf180mcu_as_sc_mcu7t3v3__inv_2_777/A
+ gf180mcu_as_sc_mcu7t3v3__inv_2_827/VNW VSUBS gf180mcu_as_sc_mcu7t3v3__inv_2
Xgf180mcu_as_sc_mcu7t3v3__inv_2_744 VSS VSS VSS gf180mcu_as_sc_mcu7t3v3__inv_2_745/Y
+ gf180mcu_as_sc_mcu7t3v3__inv_2_746/VNW VSUBS gf180mcu_as_sc_mcu7t3v3__inv_2
Xgf180mcu_as_sc_mcu7t3v3__inv_2_722 VSS VSS VSS gf180mcu_as_sc_mcu7t3v3__inv_2_723/Y
+ gf180mcu_as_sc_mcu7t3v3__inv_2_724/VNW VSUBS gf180mcu_as_sc_mcu7t3v3__inv_2
Xgf180mcu_as_sc_mcu7t3v3__inv_2_799 VSS VSS gf180mcu_as_sc_mcu7t3v3__inv_2_850/A gf180mcu_as_sc_mcu7t3v3__inv_2_804/Y
+ gf180mcu_as_sc_mcu7t3v3__inv_2_850/VNW VSUBS gf180mcu_as_sc_mcu7t3v3__inv_2
Xgf180mcu_as_sc_mcu7t3v3__inv_2_788 VSS VSS gf180mcu_as_sc_mcu7t3v3__inv_2_849/A gf180mcu_as_sc_mcu7t3v3__inv_2_791/Y
+ gf180mcu_as_sc_mcu7t3v3__inv_2_849/VNW VSUBS gf180mcu_as_sc_mcu7t3v3__inv_2
Xgf180mcu_as_sc_mcu7t3v3__inv_2_733 VSS VSS gf180mcu_as_sc_mcu7t3v3__inv_2_733/Y gf180mcu_as_sc_mcu7t3v3__inv_2_733/A
+ gf180mcu_as_sc_mcu7t3v3__inv_2_733/VNW VSUBS gf180mcu_as_sc_mcu7t3v3__inv_2
Xgf180mcu_as_sc_mcu7t3v3__inv_2_1090 VSS VSS gf180mcu_as_sc_mcu7t3v3__inv_2_1090/Y
+ gf180mcu_as_sc_mcu7t3v3__inv_2_1091/Y gf180mcu_as_sc_mcu7t3v3__inv_2_1091/VNW VSUBS
+ gf180mcu_as_sc_mcu7t3v3__inv_2
Xgf180mcu_as_sc_mcu7t3v3__nand4_2_2 VSS VSS VSS VSS VSS VSS gf180mcu_as_sc_mcu7t3v3__inv_2_87/A
+ gf180mcu_as_sc_mcu7t3v3__inv_2_98/VNW VSUBS gf180mcu_as_sc_mcu7t3v3__nand4_2
Xgf180mcu_as_sc_mcu7t3v3__inv_2_541 VSS VSS gf180mcu_as_sc_mcu7t3v3__inv_2_541/Y gf180mcu_as_sc_mcu7t3v3__inv_2_542/Y
+ gf180mcu_as_sc_mcu7t3v3__inv_2_542/VNW VSUBS gf180mcu_as_sc_mcu7t3v3__inv_2
Xgf180mcu_as_sc_mcu7t3v3__inv_2_530 gf180mcu_as_sc_mcu7t3v3__nor2_2_4/VDD gf180mcu_as_sc_mcu7t3v3__nor2_2_4/VSS
+ VSS VSS gf180mcu_as_sc_mcu7t3v3__nor2_2_4/VNW VSUBS gf180mcu_as_sc_mcu7t3v3__inv_2
Xgf180mcu_as_sc_mcu7t3v3__inv_2_552 VSS VSS VSS gf180mcu_as_sc_mcu7t3v3__inv_2_552/A
+ gf180mcu_as_sc_mcu7t3v3__inv_2_552/VNW VSUBS gf180mcu_as_sc_mcu7t3v3__inv_2
Xgf180mcu_as_sc_mcu7t3v3__inv_2_563 VSS VSS VSS gf180mcu_as_sc_mcu7t3v3__inv_2_563/A
+ gf180mcu_as_sc_mcu7t3v3__inv_2_563/VNW VSUBS gf180mcu_as_sc_mcu7t3v3__inv_2
Xgf180mcu_as_sc_mcu7t3v3__inv_2_585 VSS VSS VSS gf180mcu_as_sc_mcu7t3v3__inv_2_585/A
+ gf180mcu_as_sc_mcu7t3v3__inv_2_585/VNW VSUBS gf180mcu_as_sc_mcu7t3v3__inv_2
Xgf180mcu_as_sc_mcu7t3v3__inv_2_574 VSS VSS VSS gf180mcu_as_sc_mcu7t3v3__inv_2_575/Y
+ gf180mcu_as_sc_mcu7t3v3__inv_2_576/VNW VSUBS gf180mcu_as_sc_mcu7t3v3__inv_2
Xgf180mcu_as_sc_mcu7t3v3__inv_2_596 VSS VSS VSS gf180mcu_as_sc_mcu7t3v3__inv_2_597/Y
+ gf180mcu_as_sc_mcu7t3v3__inv_2_598/VNW VSUBS gf180mcu_as_sc_mcu7t3v3__inv_2
Xgf180mcu_as_sc_mcu7t3v3__inv_2_393 gf180mcu_as_sc_mcu7t3v3__nor2_2_7/VDD gf180mcu_as_sc_mcu7t3v3__nand3_2_4/VSS
+ VSS VSS gf180mcu_as_sc_mcu7t3v3__nor2_2_7/VNW VSUBS gf180mcu_as_sc_mcu7t3v3__inv_2
Xgf180mcu_as_sc_mcu7t3v3__inv_2_382 gf180mcu_as_sc_mcu7t3v3__nor2_2_7/VDD gf180mcu_as_sc_mcu7t3v3__nor2_2_7/VSS
+ VSS VSS gf180mcu_as_sc_mcu7t3v3__nor2_2_7/VNW VSUBS gf180mcu_as_sc_mcu7t3v3__inv_2
Xgf180mcu_as_sc_mcu7t3v3__inv_2_371 VSS VSS gf180mcu_as_sc_mcu7t3v3__inv_2_371/Y gf180mcu_as_sc_mcu7t3v3__inv_2_371/A
+ gf180mcu_as_sc_mcu7t3v3__inv_2_371/VNW VSUBS gf180mcu_as_sc_mcu7t3v3__inv_2
Xgf180mcu_as_sc_mcu7t3v3__inv_2_360 VSS VSS VSS gf180mcu_as_sc_mcu7t3v3__inv_2_361/Y
+ gf180mcu_as_sc_mcu7t3v3__inv_2_362/VNW VSUBS gf180mcu_as_sc_mcu7t3v3__inv_2
Xu_t027_010 u_t027_010/c0_w0_bl u_t027_010/c0_w0_br u_t027_010/c0_w1_bl u_t027_010/c0_w1_br
+ u_t027_010/c0_r0_rbl u_t027_010/c0_r1_rbl u_t027_010/c1_w0_bl u_t027_010/c1_w0_br
+ u_t027_010/c1_w1_bl u_t027_010/c1_w1_br u_t027_010/c1_r0_rbl u_t027_010/c1_r1_rbl
+ u_t027_010/c2_w0_bl u_t027_010/c2_w0_br u_t027_010/c2_w1_bl u_t027_010/c2_w1_br
+ u_t027_010/c2_r0_rbl u_t027_010/c2_r1_rbl u_t027_010/c3_w0_bl u_t027_010/c3_w0_br
+ u_t027_010/c3_w1_bl u_t027_010/c3_w1_br u_t027_010/c3_r0_rbl u_t027_010/c3_r1_rbl
+ u_t027_010/r0_w0_wl u_t027_010/r0_w1_wl u_t027_010/r0_r0_rwl u_t027_010/r0_r1_rwl
+ u_t027_010/r1_w0_wl u_t027_010/r1_w1_wl u_t027_010/r1_r0_rwl u_t027_010/r1_r1_rwl
+ u_t027_010/r2_w0_wl u_t027_010/r2_w1_wl u_t027_010/r2_r0_rwl u_t027_010/r2_r1_rwl
+ u_t027_010/r3_w0_wl u_t027_010/r3_w1_wl u_t027_010/r3_r0_rwl u_t027_010/r3_r1_rwl
+ VSS VSS u_t027_010/m2_717_1265# u_t027_010/m2_603_2031# u_t027_010/m2_1290_336#
+ u_t027_010/m2_2000_2037# u_t027_010/m2_791_2909# u_t027_010/m2_7_2126# u_t027_010/m2_2154_2081#
+ u_t027_010/m2_1795_2037# u_t027_010/m2_871_303# u_t027_010/m2_431_438# u_t027_010/m2_1290_2898#
+ u_t027_010/m2_1714_1210# u_t027_010/m2_431_1982# u_t027_010/m2_512_1265# u_t027_010/m2_2573_2126#
+ u_t027_010/m2_603_1259# u_t027_010/m2_2074_2909# u_t027_010/m2_7_336# u_t027_010/m2_717_2037#
+ u_t027_010/m2_1886_2031# u_t027_010/m2_2573_336# u_t027_010/m2_7_2898# u_t027_010/m2_2000_1265#
+ u_t027_010/m2_512_2037# u_t027_010/m2_1795_1265# u_t027_010/m2_1714_1982# u_t027_010/m2_1886_1259#
+ u_t027_010/m2_1290_2126# u_t027_010/m2_1714_438# u_t027_010/m2_431_1210# u_t027_010/m2_2573_2898#
+ u_t027_010/m2_2154_303# u_t027_010/m2_871_2081# VSUBS detronyx_12t_2w2r_rc4_4x4_routed_5layer_direct
Xu_t018_010 u_t018_010/c0_w0_bl u_t018_010/c0_w0_br u_t018_010/c0_w1_bl u_t018_010/c0_w1_br
+ u_t018_010/c0_r0_rbl u_t018_010/c0_r1_rbl u_t018_010/c1_w0_bl u_t018_010/c1_w0_br
+ u_t018_010/c1_w1_bl u_t018_010/c1_w1_br u_t018_010/c1_r0_rbl u_t018_010/c1_r1_rbl
+ u_t018_010/c2_w0_bl u_t018_010/c2_w0_br u_t018_010/c2_w1_bl u_t018_010/c2_w1_br
+ u_t018_010/c2_r0_rbl u_t018_010/c2_r1_rbl u_t018_010/c3_w0_bl u_t018_010/c3_w0_br
+ u_t018_010/c3_w1_bl u_t018_010/c3_w1_br u_t018_010/c3_r0_rbl u_t018_010/c3_r1_rbl
+ u_t018_010/r0_w0_wl u_t018_010/r0_w1_wl u_t018_010/r0_r0_rwl u_t018_010/r0_r1_rwl
+ u_t018_010/r1_w0_wl u_t018_010/r1_w1_wl u_t018_010/r1_r0_rwl u_t018_010/r1_r1_rwl
+ u_t018_010/r2_w0_wl u_t018_010/r2_w1_wl u_t018_010/r2_r0_rwl u_t018_010/r2_r1_rwl
+ u_t018_010/r3_w0_wl u_t018_010/r3_w1_wl u_t018_010/r3_r0_rwl u_t018_010/r3_r1_rwl
+ VSS VSS u_t018_010/m2_717_1265# u_t018_010/m2_603_2031# u_t018_010/m2_1290_336#
+ u_t018_010/m2_2000_2037# u_t018_010/m2_791_2909# u_t018_010/m2_7_2126# u_t018_010/m2_2154_2081#
+ u_t018_010/m2_1795_2037# u_t018_010/m2_871_303# u_t018_010/m2_431_438# u_t018_010/m2_1290_2898#
+ u_t018_010/m2_1714_1210# u_t018_010/m2_431_1982# u_t018_010/m2_512_1265# u_t018_010/m2_2573_2126#
+ u_t018_010/m2_603_1259# u_t018_010/m2_2074_2909# u_t018_010/m2_7_336# u_t018_010/m2_717_2037#
+ u_t018_010/m2_1886_2031# u_t018_010/m2_2573_336# u_t018_010/m2_7_2898# u_t018_010/m2_2000_1265#
+ u_t018_010/m2_512_2037# u_t018_010/m2_1795_1265# u_t018_010/m2_1714_1982# u_t018_010/m2_1886_1259#
+ u_t018_010/m2_1290_2126# u_t018_010/m2_1714_438# u_t018_010/m2_431_1210# u_t018_010/m2_2573_2898#
+ u_t018_010/m2_2154_303# u_t018_010/m2_871_2081# VSUBS detronyx_12t_2w2r_rc4_4x4_routed_5layer_direct
Xu_t009_010 u_t009_010/c0_w0_bl u_t009_010/c0_w0_br u_t009_010/c0_w1_bl u_t009_010/c0_w1_br
+ u_t009_010/c0_r0_rbl u_t009_010/c0_r1_rbl u_t009_010/c1_w0_bl u_t009_010/c1_w0_br
+ u_t009_010/c1_w1_bl u_t009_010/c1_w1_br u_t009_010/c1_r0_rbl u_t009_010/c1_r1_rbl
+ u_t009_010/c2_w0_bl u_t009_010/c2_w0_br u_t009_010/c2_w1_bl u_t009_010/c2_w1_br
+ u_t009_010/c2_r0_rbl u_t009_010/c2_r1_rbl u_t009_010/c3_w0_bl u_t009_010/c3_w0_br
+ u_t009_010/c3_w1_bl u_t009_010/c3_w1_br u_t009_010/c3_r0_rbl u_t009_010/c3_r1_rbl
+ u_t009_010/r0_w0_wl u_t009_010/r0_w1_wl u_t009_010/r0_r0_rwl u_t009_010/r0_r1_rwl
+ u_t009_010/r1_w0_wl u_t009_010/r1_w1_wl u_t009_010/r1_r0_rwl u_t009_010/r1_r1_rwl
+ u_t009_010/r2_w0_wl u_t009_010/r2_w1_wl u_t009_010/r2_r0_rwl u_t009_010/r2_r1_rwl
+ u_t009_010/r3_w0_wl u_t009_010/r3_w1_wl u_t009_010/r3_r0_rwl u_t009_010/r3_r1_rwl
+ VSS VSS u_t009_010/m2_717_1265# u_t009_010/m2_603_2031# u_t009_010/m2_1290_336#
+ u_t009_010/m2_2000_2037# u_t009_010/m2_791_2909# u_t009_010/m2_7_2126# u_t009_010/m2_2154_2081#
+ u_t009_010/m2_1795_2037# u_t009_010/m2_871_303# u_t009_010/m2_431_438# u_t009_010/m2_1290_2898#
+ u_t009_010/m2_1714_1210# u_t009_010/m2_431_1982# u_t009_010/m2_512_1265# u_t009_010/m2_2573_2126#
+ u_t009_010/m2_603_1259# u_t009_010/m2_2074_2909# u_t009_010/m2_7_336# u_t009_010/m2_717_2037#
+ u_t009_010/m2_1886_2031# u_t009_010/m2_2573_336# u_t009_010/m2_7_2898# u_t009_010/m2_2000_1265#
+ u_t009_010/m2_512_2037# u_t009_010/m2_1795_1265# u_t009_010/m2_1714_1982# u_t009_010/m2_1886_1259#
+ u_t009_010/m2_1290_2126# u_t009_010/m2_1714_438# u_t009_010/m2_431_1210# u_t009_010/m2_2573_2898#
+ u_t009_010/m2_2154_303# u_t009_010/m2_871_2081# VSUBS detronyx_12t_2w2r_rc4_4x4_routed_5layer_direct
Xu_t024_002 u_t024_002/c0_w0_bl u_t024_002/c0_w0_br u_t024_002/c0_w1_bl u_t024_002/c0_w1_br
+ u_t024_002/c0_r0_rbl u_t024_002/c0_r1_rbl u_t024_002/c1_w0_bl u_t024_002/c1_w0_br
+ u_t024_002/c1_w1_bl u_t024_002/c1_w1_br u_t024_002/c1_r0_rbl u_t024_002/c1_r1_rbl
+ u_t024_002/c2_w0_bl u_t024_002/c2_w0_br u_t024_002/c2_w1_bl u_t024_002/c2_w1_br
+ u_t024_002/c2_r0_rbl u_t024_002/c2_r1_rbl u_t024_002/c3_w0_bl u_t024_002/c3_w0_br
+ u_t024_002/c3_w1_bl u_t024_002/c3_w1_br u_t024_002/c3_r0_rbl u_t024_002/c3_r1_rbl
+ u_t024_002/r0_w0_wl u_t024_002/r0_w1_wl u_t024_002/r0_r0_rwl u_t024_002/r0_r1_rwl
+ u_t024_002/r1_w0_wl u_t024_002/r1_w1_wl u_t024_002/r1_r0_rwl u_t024_002/r1_r1_rwl
+ u_t024_002/r2_w0_wl u_t024_002/r2_w1_wl u_t024_002/r2_r0_rwl u_t024_002/r2_r1_rwl
+ u_t024_002/r3_w0_wl u_t024_002/r3_w1_wl u_t024_002/r3_r0_rwl u_t024_002/r3_r1_rwl
+ VSS VSS u_t024_002/m2_717_1265# u_t024_002/m2_603_2031# u_t024_002/m2_1290_336#
+ u_t024_002/m2_2000_2037# u_t024_002/m2_791_2909# u_t024_002/m2_7_2126# u_t024_002/m2_2154_2081#
+ u_t024_002/m2_1795_2037# u_t024_002/m2_871_303# u_t024_002/m2_431_438# u_t024_002/m2_1290_2898#
+ u_t024_002/m2_1714_1210# u_t024_002/m2_431_1982# u_t024_002/m2_512_1265# u_t024_002/m2_2573_2126#
+ u_t024_002/m2_603_1259# u_t024_002/m2_2074_2909# u_t024_002/m2_7_336# u_t024_002/m2_717_2037#
+ u_t024_002/m2_1886_2031# u_t024_002/m2_2573_336# u_t024_002/m2_7_2898# u_t024_002/m2_2000_1265#
+ u_t024_002/m2_512_2037# u_t024_002/m2_1795_1265# u_t024_002/m2_1714_1982# u_t024_002/m2_1886_1259#
+ u_t024_002/m2_1290_2126# u_t024_002/m2_1714_438# u_t024_002/m2_431_1210# u_t024_002/m2_2573_2898#
+ u_t024_002/m2_2154_303# u_t024_002/m2_871_2081# VSUBS detronyx_12t_2w2r_rc4_4x4_routed_5layer_direct
Xgf180mcu_as_sc_mcu7t3v3__nand3_2_58 gf180mcu_as_sc_mcu7t3v3__nor2_2_9/VDD gf180mcu_as_sc_mcu7t3v3__nand3_2_63/VSS
+ VSS VSS VSS VSS gf180mcu_as_sc_mcu7t3v3__nor2_2_9/VNW VSUBS gf180mcu_as_sc_mcu7t3v3__nand3_2
Xgf180mcu_as_sc_mcu7t3v3__nand3_2_47 gf180mcu_as_sc_mcu7t3v3__nand3_2_65/VDD gf180mcu_as_sc_mcu7t3v3__nor2_2_9/VSS
+ VSS VSS VSS VSS gf180mcu_as_sc_mcu7t3v3__nand3_2_65/VNW VSUBS gf180mcu_as_sc_mcu7t3v3__nand3_2
Xgf180mcu_as_sc_mcu7t3v3__nand3_2_36 gf180mcu_as_sc_mcu7t3v3__nor2_2_6/VDD gf180mcu_as_sc_mcu7t3v3__nor2_2_6/VSS
+ VSS VSS VSS VSS gf180mcu_as_sc_mcu7t3v3__nor2_2_6/VNW VSUBS gf180mcu_as_sc_mcu7t3v3__nand3_2
Xgf180mcu_as_sc_mcu7t3v3__nand3_2_25 gf180mcu_as_sc_mcu7t3v3__nor2_2_6/VDD gf180mcu_as_sc_mcu7t3v3__nor2_2_6/VSS
+ VSS VSS VSS VSS gf180mcu_as_sc_mcu7t3v3__nor2_2_6/VNW VSUBS gf180mcu_as_sc_mcu7t3v3__nand3_2
Xgf180mcu_as_sc_mcu7t3v3__nand3_2_14 gf180mcu_as_sc_mcu7t3v3__nor2_2_4/VDD gf180mcu_as_sc_mcu7t3v3__nand2_2_3/VSS
+ VSS VSS VSS VSS gf180mcu_as_sc_mcu7t3v3__nor2_2_4/VNW VSUBS gf180mcu_as_sc_mcu7t3v3__nand3_2
Xu_t024_013 u_t024_013/c0_w0_bl u_t024_013/c0_w0_br u_t024_013/c0_w1_bl u_t024_013/c0_w1_br
+ u_t024_013/c0_r0_rbl u_t024_013/c0_r1_rbl u_t024_013/c1_w0_bl u_t024_013/c1_w0_br
+ u_t024_013/c1_w1_bl u_t024_013/c1_w1_br u_t024_013/c1_r0_rbl u_t024_013/c1_r1_rbl
+ u_t024_013/c2_w0_bl u_t024_013/c2_w0_br u_t024_013/c2_w1_bl u_t024_013/c2_w1_br
+ u_t024_013/c2_r0_rbl u_t024_013/c2_r1_rbl u_t024_013/c3_w0_bl u_t024_013/c3_w0_br
+ u_t024_013/c3_w1_bl u_t024_013/c3_w1_br u_t024_013/c3_r0_rbl u_t024_013/c3_r1_rbl
+ u_t024_013/r0_w0_wl u_t024_013/r0_w1_wl u_t024_013/r0_r0_rwl u_t024_013/r0_r1_rwl
+ u_t024_013/r1_w0_wl u_t024_013/r1_w1_wl u_t024_013/r1_r0_rwl u_t024_013/r1_r1_rwl
+ u_t024_013/r2_w0_wl u_t024_013/r2_w1_wl u_t024_013/r2_r0_rwl u_t024_013/r2_r1_rwl
+ u_t024_013/r3_w0_wl u_t024_013/r3_w1_wl u_t024_013/r3_r0_rwl u_t024_013/r3_r1_rwl
+ VSS VSS u_t024_013/m2_717_1265# u_t024_013/m2_603_2031# u_t024_013/m2_1290_336#
+ u_t024_013/m2_2000_2037# u_t024_013/m2_791_2909# u_t024_013/m2_7_2126# u_t024_013/m2_2154_2081#
+ u_t024_013/m2_1795_2037# u_t024_013/m2_871_303# u_t024_013/m2_431_438# u_t024_013/m2_1290_2898#
+ u_t024_013/m2_1714_1210# u_t024_013/m2_431_1982# u_t024_013/m2_512_1265# u_t024_013/m2_2573_2126#
+ u_t024_013/m2_603_1259# u_t024_013/m2_2074_2909# u_t024_013/m2_7_336# u_t024_013/m2_717_2037#
+ u_t024_013/m2_1886_2031# u_t024_013/m2_2573_336# u_t024_013/m2_7_2898# u_t024_013/m2_2000_1265#
+ u_t024_013/m2_512_2037# u_t024_013/m2_1795_1265# u_t024_013/m2_1714_1982# u_t024_013/m2_1886_1259#
+ u_t024_013/m2_1290_2126# u_t024_013/m2_1714_438# u_t024_013/m2_431_1210# u_t024_013/m2_2573_2898#
+ u_t024_013/m2_2154_303# u_t024_013/m2_871_2081# VSUBS detronyx_12t_2w2r_rc4_4x4_routed_5layer_direct
Xgf180mcu_as_sc_mcu7t3v3__inv_2_1612 VSS VSS VSS gf180mcu_as_sc_mcu7t3v3__inv_2_1613/Y
+ gf180mcu_as_sc_mcu7t3v3__inv_2_1614/VNW VSUBS gf180mcu_as_sc_mcu7t3v3__inv_2
Xgf180mcu_as_sc_mcu7t3v3__inv_2_1601 VSS VSS gf180mcu_as_sc_mcu7t3v3__inv_2_1601/Y
+ gf180mcu_as_sc_mcu7t3v3__inv_2_1601/A gf180mcu_as_sc_mcu7t3v3__inv_2_1601/VNW VSUBS
+ gf180mcu_as_sc_mcu7t3v3__inv_2
Xgf180mcu_as_sc_mcu7t3v3__inv_2_190 VSS VSS gf180mcu_as_sc_mcu7t3v3__inv_2_190/Y gf180mcu_as_sc_mcu7t3v3__inv_2_190/A
+ gf180mcu_as_sc_mcu7t3v3__inv_2_190/VNW VSUBS gf180mcu_as_sc_mcu7t3v3__inv_2
Xgf180mcu_as_sc_mcu7t3v3__inv_2_1634 VSS VSS gf180mcu_as_sc_mcu7t3v3__inv_2_1634/Y
+ gf180mcu_as_sc_mcu7t3v3__inv_2_1634/A gf180mcu_as_sc_mcu7t3v3__inv_2_1634/VNW VSUBS
+ gf180mcu_as_sc_mcu7t3v3__inv_2
Xgf180mcu_as_sc_mcu7t3v3__inv_2_1645 VSS VSS gf180mcu_as_sc_mcu7t3v3__inv_2_1645/Y
+ gf180mcu_as_sc_mcu7t3v3__inv_2_1649/Y gf180mcu_as_sc_mcu7t3v3__inv_2_1649/VNW VSUBS
+ gf180mcu_as_sc_mcu7t3v3__inv_2
Xgf180mcu_as_sc_mcu7t3v3__inv_2_1689 VSS VSS VSS gf180mcu_as_sc_mcu7t3v3__inv_2_1689/A
+ gf180mcu_as_sc_mcu7t3v3__inv_2_1689/VNW VSUBS gf180mcu_as_sc_mcu7t3v3__inv_2
Xgf180mcu_as_sc_mcu7t3v3__inv_2_1623 VSS VSS gf180mcu_as_sc_mcu7t3v3__inv_2_1623/Y
+ gf180mcu_as_sc_mcu7t3v3__inv_2_1627/Y gf180mcu_as_sc_mcu7t3v3__inv_2_1627/VNW VSUBS
+ gf180mcu_as_sc_mcu7t3v3__inv_2
Xgf180mcu_as_sc_mcu7t3v3__inv_2_1656 VSS VSS gf180mcu_as_sc_mcu7t3v3__inv_2_1656/Y
+ gf180mcu_as_sc_mcu7t3v3__inv_2_1656/A gf180mcu_as_sc_mcu7t3v3__inv_2_1656/VNW VSUBS
+ gf180mcu_as_sc_mcu7t3v3__inv_2
Xgf180mcu_as_sc_mcu7t3v3__inv_2_1667 VSS VSS gf180mcu_as_sc_mcu7t3v3__inv_2_1667/Y
+ gf180mcu_as_sc_mcu7t3v3__inv_2_1668/Y gf180mcu_as_sc_mcu7t3v3__inv_2_1668/VNW VSUBS
+ gf180mcu_as_sc_mcu7t3v3__inv_2
Xgf180mcu_as_sc_mcu7t3v3__inv_2_1678 VSS VSS VSS gf180mcu_as_sc_mcu7t3v3__inv_2_1679/Y
+ gf180mcu_as_sc_mcu7t3v3__inv_2_1680/VNW VSUBS gf180mcu_as_sc_mcu7t3v3__inv_2
Xu_t015_013 u_t015_013/c0_w0_bl u_t015_013/c0_w0_br u_t015_013/c0_w1_bl u_t015_013/c0_w1_br
+ u_t015_013/c0_r0_rbl u_t015_013/c0_r1_rbl u_t015_013/c1_w0_bl u_t015_013/c1_w0_br
+ u_t015_013/c1_w1_bl u_t015_013/c1_w1_br u_t015_013/c1_r0_rbl u_t015_013/c1_r1_rbl
+ u_t015_013/c2_w0_bl u_t015_013/c2_w0_br u_t015_013/c2_w1_bl u_t015_013/c2_w1_br
+ u_t015_013/c2_r0_rbl u_t015_013/c2_r1_rbl u_t015_013/c3_w0_bl u_t015_013/c3_w0_br
+ u_t015_013/c3_w1_bl u_t015_013/c3_w1_br u_t015_013/c3_r0_rbl u_t015_013/c3_r1_rbl
+ u_t015_013/r0_w0_wl u_t015_013/r0_w1_wl u_t015_013/r0_r0_rwl u_t015_013/r0_r1_rwl
+ u_t015_013/r1_w0_wl u_t015_013/r1_w1_wl u_t015_013/r1_r0_rwl u_t015_013/r1_r1_rwl
+ u_t015_013/r2_w0_wl u_t015_013/r2_w1_wl u_t015_013/r2_r0_rwl u_t015_013/r2_r1_rwl
+ u_t015_013/r3_w0_wl u_t015_013/r3_w1_wl u_t015_013/r3_r0_rwl u_t015_013/r3_r1_rwl
+ VSS VSS u_t015_013/m2_717_1265# u_t015_013/m2_603_2031# u_t015_013/m2_1290_336#
+ u_t015_013/m2_2000_2037# u_t015_013/m2_791_2909# u_t015_013/m2_7_2126# u_t015_013/m2_2154_2081#
+ u_t015_013/m2_1795_2037# u_t015_013/m2_871_303# u_t015_013/m2_431_438# u_t015_013/m2_1290_2898#
+ u_t015_013/m2_1714_1210# u_t015_013/m2_431_1982# u_t015_013/m2_512_1265# u_t015_013/m2_2573_2126#
+ u_t015_013/m2_603_1259# u_t015_013/m2_2074_2909# u_t015_013/m2_7_336# u_t015_013/m2_717_2037#
+ u_t015_013/m2_1886_2031# u_t015_013/m2_2573_336# u_t015_013/m2_7_2898# u_t015_013/m2_2000_1265#
+ u_t015_013/m2_512_2037# u_t015_013/m2_1795_1265# u_t015_013/m2_1714_1982# u_t015_013/m2_1886_1259#
+ u_t015_013/m2_1290_2126# u_t015_013/m2_1714_438# u_t015_013/m2_431_1210# u_t015_013/m2_2573_2898#
+ u_t015_013/m2_2154_303# u_t015_013/m2_871_2081# VSUBS detronyx_12t_2w2r_rc4_4x4_routed_5layer_direct
Xu_t015_002 u_t015_002/c0_w0_bl u_t015_002/c0_w0_br u_t015_002/c0_w1_bl u_t015_002/c0_w1_br
+ u_t015_002/c0_r0_rbl u_t015_002/c0_r1_rbl u_t015_002/c1_w0_bl u_t015_002/c1_w0_br
+ u_t015_002/c1_w1_bl u_t015_002/c1_w1_br u_t015_002/c1_r0_rbl u_t015_002/c1_r1_rbl
+ u_t015_002/c2_w0_bl u_t015_002/c2_w0_br u_t015_002/c2_w1_bl u_t015_002/c2_w1_br
+ u_t015_002/c2_r0_rbl u_t015_002/c2_r1_rbl u_t015_002/c3_w0_bl u_t015_002/c3_w0_br
+ u_t015_002/c3_w1_bl u_t015_002/c3_w1_br u_t015_002/c3_r0_rbl u_t015_002/c3_r1_rbl
+ u_t015_002/r0_w0_wl u_t015_002/r0_w1_wl u_t015_002/r0_r0_rwl u_t015_002/r0_r1_rwl
+ u_t015_002/r1_w0_wl u_t015_002/r1_w1_wl u_t015_002/r1_r0_rwl u_t015_002/r1_r1_rwl
+ u_t015_002/r2_w0_wl u_t015_002/r2_w1_wl u_t015_002/r2_r0_rwl u_t015_002/r2_r1_rwl
+ u_t015_002/r3_w0_wl u_t015_002/r3_w1_wl u_t015_002/r3_r0_rwl u_t015_002/r3_r1_rwl
+ VSS VSS u_t015_002/m2_717_1265# u_t015_002/m2_603_2031# u_t015_002/m2_1290_336#
+ u_t015_002/m2_2000_2037# u_t015_002/m2_791_2909# u_t015_002/m2_7_2126# u_t015_002/m2_2154_2081#
+ u_t015_002/m2_1795_2037# u_t015_002/m2_871_303# u_t015_002/m2_431_438# u_t015_002/m2_1290_2898#
+ u_t015_002/m2_1714_1210# u_t015_002/m2_431_1982# u_t015_002/m2_512_1265# u_t015_002/m2_2573_2126#
+ u_t015_002/m2_603_1259# u_t015_002/m2_2074_2909# u_t015_002/m2_7_336# u_t015_002/m2_717_2037#
+ u_t015_002/m2_1886_2031# u_t015_002/m2_2573_336# u_t015_002/m2_7_2898# u_t015_002/m2_2000_1265#
+ u_t015_002/m2_512_2037# u_t015_002/m2_1795_1265# u_t015_002/m2_1714_1982# u_t015_002/m2_1886_1259#
+ u_t015_002/m2_1290_2126# u_t015_002/m2_1714_438# u_t015_002/m2_431_1210# u_t015_002/m2_2573_2898#
+ u_t015_002/m2_2154_303# u_t015_002/m2_871_2081# VSUBS detronyx_12t_2w2r_rc4_4x4_routed_5layer_direct
Xu_t030_005 u_t030_005/c0_w0_bl u_t030_005/c0_w0_br u_t030_005/c0_w1_bl u_t030_005/c0_w1_br
+ u_t030_005/c0_r0_rbl u_t030_005/c0_r1_rbl u_t030_005/c1_w0_bl u_t030_005/c1_w0_br
+ u_t030_005/c1_w1_bl u_t030_005/c1_w1_br u_t030_005/c1_r0_rbl u_t030_005/c1_r1_rbl
+ u_t030_005/c2_w0_bl u_t030_005/c2_w0_br u_t030_005/c2_w1_bl u_t030_005/c2_w1_br
+ u_t030_005/c2_r0_rbl u_t030_005/c2_r1_rbl u_t030_005/c3_w0_bl u_t030_005/c3_w0_br
+ u_t030_005/c3_w1_bl u_t030_005/c3_w1_br u_t030_005/c3_r0_rbl u_t030_005/c3_r1_rbl
+ u_t030_005/r0_w0_wl u_t030_005/r0_w1_wl u_t030_005/r0_r0_rwl u_t030_005/r0_r1_rwl
+ u_t030_005/r1_w0_wl u_t030_005/r1_w1_wl u_t030_005/r1_r0_rwl u_t030_005/r1_r1_rwl
+ u_t030_005/r2_w0_wl u_t030_005/r2_w1_wl u_t030_005/r2_r0_rwl u_t030_005/r2_r1_rwl
+ u_t030_005/r3_w0_wl u_t030_005/r3_w1_wl u_t030_005/r3_r0_rwl u_t030_005/r3_r1_rwl
+ VSS VSS u_t030_005/m2_717_1265# u_t030_005/m2_603_2031# u_t030_005/m2_1290_336#
+ u_t030_005/m2_2000_2037# u_t030_005/m2_791_2909# u_t030_005/m2_7_2126# u_t030_005/m2_2154_2081#
+ u_t030_005/m2_1795_2037# u_t030_005/m2_871_303# u_t030_005/m2_431_438# u_t030_005/m2_1290_2898#
+ u_t030_005/m2_1714_1210# u_t030_005/m2_431_1982# u_t030_005/m2_512_1265# u_t030_005/m2_2573_2126#
+ u_t030_005/m2_603_1259# u_t030_005/m2_2074_2909# u_t030_005/m2_7_336# u_t030_005/m2_717_2037#
+ u_t030_005/m2_1886_2031# u_t030_005/m2_2573_336# u_t030_005/m2_7_2898# u_t030_005/m2_2000_1265#
+ u_t030_005/m2_512_2037# u_t030_005/m2_1795_1265# u_t030_005/m2_1714_1982# u_t030_005/m2_1886_1259#
+ u_t030_005/m2_1290_2126# u_t030_005/m2_1714_438# u_t030_005/m2_431_1210# u_t030_005/m2_2573_2898#
+ u_t030_005/m2_2154_303# u_t030_005/m2_871_2081# VSUBS detronyx_12t_2w2r_rc4_4x4_routed_5layer_direct
Xgf180mcu_as_sc_mcu7t3v3__nand4_2_417 VSS VSS VSS VSS VSS VSS gf180mcu_as_sc_mcu7t3v3__inv_2_1523/A
+ gf180mcu_as_sc_mcu7t3v3__inv_2_1523/VNW VSUBS gf180mcu_as_sc_mcu7t3v3__nand4_2
Xgf180mcu_as_sc_mcu7t3v3__nand4_2_406 VSS VSS VSS VSS VSS VSS gf180mcu_as_sc_mcu7t3v3__inv_2_1488/A
+ gf180mcu_as_sc_mcu7t3v3__inv_2_1488/VNW VSUBS gf180mcu_as_sc_mcu7t3v3__nand4_2
Xu_t006_002 u_t006_002/c0_w0_bl u_t006_002/c0_w0_br u_t006_002/c0_w1_bl u_t006_002/c0_w1_br
+ u_t006_002/c0_r0_rbl u_t006_002/c0_r1_rbl u_t006_002/c1_w0_bl u_t006_002/c1_w0_br
+ u_t006_002/c1_w1_bl u_t006_002/c1_w1_br u_t006_002/c1_r0_rbl u_t006_002/c1_r1_rbl
+ u_t006_002/c2_w0_bl u_t006_002/c2_w0_br u_t006_002/c2_w1_bl u_t006_002/c2_w1_br
+ u_t006_002/c2_r0_rbl u_t006_002/c2_r1_rbl u_t006_002/c3_w0_bl u_t006_002/c3_w0_br
+ u_t006_002/c3_w1_bl u_t006_002/c3_w1_br u_t006_002/c3_r0_rbl u_t006_002/c3_r1_rbl
+ u_t006_002/r0_w0_wl u_t006_002/r0_w1_wl u_t006_002/r0_r0_rwl u_t006_002/r0_r1_rwl
+ u_t006_002/r1_w0_wl u_t006_002/r1_w1_wl u_t006_002/r1_r0_rwl u_t006_002/r1_r1_rwl
+ u_t006_002/r2_w0_wl u_t006_002/r2_w1_wl u_t006_002/r2_r0_rwl u_t006_002/r2_r1_rwl
+ u_t006_002/r3_w0_wl u_t006_002/r3_w1_wl u_t006_002/r3_r0_rwl u_t006_002/r3_r1_rwl
+ VSS VSS u_t006_002/m2_717_1265# u_t006_002/m2_603_2031# u_t006_002/m2_1290_336#
+ u_t006_002/m2_2000_2037# u_t006_002/m2_791_2909# u_t006_002/m2_7_2126# u_t006_002/m2_2154_2081#
+ u_t006_002/m2_1795_2037# u_t006_002/m2_871_303# u_t006_002/m2_431_438# u_t006_002/m2_1290_2898#
+ u_t006_002/m2_1714_1210# u_t006_002/m2_431_1982# u_t006_002/m2_512_1265# u_t006_002/m2_2573_2126#
+ u_t006_002/m2_603_1259# u_t006_002/m2_2074_2909# u_t006_002/m2_7_336# u_t006_002/m2_717_2037#
+ u_t006_002/m2_1886_2031# u_t006_002/m2_2573_336# u_t006_002/m2_7_2898# u_t006_002/m2_2000_1265#
+ u_t006_002/m2_512_2037# u_t006_002/m2_1795_1265# u_t006_002/m2_1714_1982# u_t006_002/m2_1886_1259#
+ u_t006_002/m2_1290_2126# u_t006_002/m2_1714_438# u_t006_002/m2_431_1210# u_t006_002/m2_2573_2898#
+ u_t006_002/m2_2154_303# u_t006_002/m2_871_2081# VSUBS detronyx_12t_2w2r_rc4_4x4_routed_5layer_direct
Xgf180mcu_as_sc_mcu7t3v3__nand4_2_439 VSS VSS VSS VSS VSS VSS gf180mcu_as_sc_mcu7t3v3__inv_2_1587/A
+ gf180mcu_as_sc_mcu7t3v3__inv_2_1587/VNW VSUBS gf180mcu_as_sc_mcu7t3v3__nand4_2
Xgf180mcu_as_sc_mcu7t3v3__nand4_2_428 VSS VSS VSS VSS VSS VSS gf180mcu_as_sc_mcu7t3v3__inv_2_1556/A
+ gf180mcu_as_sc_mcu7t3v3__inv_2_1556/VNW VSUBS gf180mcu_as_sc_mcu7t3v3__nand4_2
Xgf180mcu_as_sc_mcu7t3v3__inv_2_7 VSS VSS gf180mcu_as_sc_mcu7t3v3__inv_2_7/Y gf180mcu_as_sc_mcu7t3v3__inv_2_8/Y
+ gf180mcu_as_sc_mcu7t3v3__inv_2_8/VNW VSUBS gf180mcu_as_sc_mcu7t3v3__inv_2
Xu_t006_013 u_t006_013/c0_w0_bl u_t006_013/c0_w0_br u_t006_013/c0_w1_bl u_t006_013/c0_w1_br
+ u_t006_013/c0_r0_rbl u_t006_013/c0_r1_rbl u_t006_013/c1_w0_bl u_t006_013/c1_w0_br
+ u_t006_013/c1_w1_bl u_t006_013/c1_w1_br u_t006_013/c1_r0_rbl u_t006_013/c1_r1_rbl
+ u_t006_013/c2_w0_bl u_t006_013/c2_w0_br u_t006_013/c2_w1_bl u_t006_013/c2_w1_br
+ u_t006_013/c2_r0_rbl u_t006_013/c2_r1_rbl u_t006_013/c3_w0_bl u_t006_013/c3_w0_br
+ u_t006_013/c3_w1_bl u_t006_013/c3_w1_br u_t006_013/c3_r0_rbl u_t006_013/c3_r1_rbl
+ u_t006_013/r0_w0_wl u_t006_013/r0_w1_wl u_t006_013/r0_r0_rwl u_t006_013/r0_r1_rwl
+ u_t006_013/r1_w0_wl u_t006_013/r1_w1_wl u_t006_013/r1_r0_rwl u_t006_013/r1_r1_rwl
+ u_t006_013/r2_w0_wl u_t006_013/r2_w1_wl u_t006_013/r2_r0_rwl u_t006_013/r2_r1_rwl
+ u_t006_013/r3_w0_wl u_t006_013/r3_w1_wl u_t006_013/r3_r0_rwl u_t006_013/r3_r1_rwl
+ VSS VSS u_t006_013/m2_717_1265# u_t006_013/m2_603_2031# u_t006_013/m2_1290_336#
+ u_t006_013/m2_2000_2037# u_t006_013/m2_791_2909# u_t006_013/m2_7_2126# u_t006_013/m2_2154_2081#
+ u_t006_013/m2_1795_2037# u_t006_013/m2_871_303# u_t006_013/m2_431_438# u_t006_013/m2_1290_2898#
+ u_t006_013/m2_1714_1210# u_t006_013/m2_431_1982# u_t006_013/m2_512_1265# u_t006_013/m2_2573_2126#
+ u_t006_013/m2_603_1259# u_t006_013/m2_2074_2909# u_t006_013/m2_7_336# u_t006_013/m2_717_2037#
+ u_t006_013/m2_1886_2031# u_t006_013/m2_2573_336# u_t006_013/m2_7_2898# u_t006_013/m2_2000_1265#
+ u_t006_013/m2_512_2037# u_t006_013/m2_1795_1265# u_t006_013/m2_1714_1982# u_t006_013/m2_1886_1259#
+ u_t006_013/m2_1290_2126# u_t006_013/m2_1714_438# u_t006_013/m2_431_1210# u_t006_013/m2_2573_2898#
+ u_t006_013/m2_2154_303# u_t006_013/m2_871_2081# VSUBS detronyx_12t_2w2r_rc4_4x4_routed_5layer_direct
Xu_t021_005 u_t021_005/c0_w0_bl u_t021_005/c0_w0_br u_t021_005/c0_w1_bl u_t021_005/c0_w1_br
+ u_t021_005/c0_r0_rbl u_t021_005/c0_r1_rbl u_t021_005/c1_w0_bl u_t021_005/c1_w0_br
+ u_t021_005/c1_w1_bl u_t021_005/c1_w1_br u_t021_005/c1_r0_rbl u_t021_005/c1_r1_rbl
+ u_t021_005/c2_w0_bl u_t021_005/c2_w0_br u_t021_005/c2_w1_bl u_t021_005/c2_w1_br
+ u_t021_005/c2_r0_rbl u_t021_005/c2_r1_rbl u_t021_005/c3_w0_bl u_t021_005/c3_w0_br
+ u_t021_005/c3_w1_bl u_t021_005/c3_w1_br u_t021_005/c3_r0_rbl u_t021_005/c3_r1_rbl
+ u_t021_005/r0_w0_wl u_t021_005/r0_w1_wl u_t021_005/r0_r0_rwl u_t021_005/r0_r1_rwl
+ u_t021_005/r1_w0_wl u_t021_005/r1_w1_wl u_t021_005/r1_r0_rwl u_t021_005/r1_r1_rwl
+ u_t021_005/r2_w0_wl u_t021_005/r2_w1_wl u_t021_005/r2_r0_rwl u_t021_005/r2_r1_rwl
+ u_t021_005/r3_w0_wl u_t021_005/r3_w1_wl u_t021_005/r3_r0_rwl u_t021_005/r3_r1_rwl
+ VSS VSS u_t021_005/m2_717_1265# u_t021_005/m2_603_2031# u_t021_005/m2_1290_336#
+ u_t021_005/m2_2000_2037# u_t021_005/m2_791_2909# u_t021_005/m2_7_2126# u_t021_005/m2_2154_2081#
+ u_t021_005/m2_1795_2037# u_t021_005/m2_871_303# u_t021_005/m2_431_438# u_t021_005/m2_1290_2898#
+ u_t021_005/m2_1714_1210# u_t021_005/m2_431_1982# u_t021_005/m2_512_1265# u_t021_005/m2_2573_2126#
+ u_t021_005/m2_603_1259# u_t021_005/m2_2074_2909# u_t021_005/m2_7_336# u_t021_005/m2_717_2037#
+ u_t021_005/m2_1886_2031# u_t021_005/m2_2573_336# u_t021_005/m2_7_2898# u_t021_005/m2_2000_1265#
+ u_t021_005/m2_512_2037# u_t021_005/m2_1795_1265# u_t021_005/m2_1714_1982# u_t021_005/m2_1886_1259#
+ u_t021_005/m2_1290_2126# u_t021_005/m2_1714_438# u_t021_005/m2_431_1210# u_t021_005/m2_2573_2898#
+ u_t021_005/m2_2154_303# u_t021_005/m2_871_2081# VSUBS detronyx_12t_2w2r_rc4_4x4_routed_5layer_direct
Xu_t012_005 u_t012_005/c0_w0_bl u_t012_005/c0_w0_br u_t012_005/c0_w1_bl u_t012_005/c0_w1_br
+ u_t012_005/c0_r0_rbl u_t012_005/c0_r1_rbl u_t012_005/c1_w0_bl u_t012_005/c1_w0_br
+ u_t012_005/c1_w1_bl u_t012_005/c1_w1_br u_t012_005/c1_r0_rbl u_t012_005/c1_r1_rbl
+ u_t012_005/c2_w0_bl u_t012_005/c2_w0_br u_t012_005/c2_w1_bl u_t012_005/c2_w1_br
+ u_t012_005/c2_r0_rbl u_t012_005/c2_r1_rbl u_t012_005/c3_w0_bl u_t012_005/c3_w0_br
+ u_t012_005/c3_w1_bl u_t012_005/c3_w1_br u_t012_005/c3_r0_rbl u_t012_005/c3_r1_rbl
+ u_t012_005/r0_w0_wl u_t012_005/r0_w1_wl u_t012_005/r0_r0_rwl u_t012_005/r0_r1_rwl
+ u_t012_005/r1_w0_wl u_t012_005/r1_w1_wl u_t012_005/r1_r0_rwl u_t012_005/r1_r1_rwl
+ u_t012_005/r2_w0_wl u_t012_005/r2_w1_wl u_t012_005/r2_r0_rwl u_t012_005/r2_r1_rwl
+ u_t012_005/r3_w0_wl u_t012_005/r3_w1_wl u_t012_005/r3_r0_rwl u_t012_005/r3_r1_rwl
+ VSS VSS u_t012_005/m2_717_1265# u_t012_005/m2_603_2031# u_t012_005/m2_1290_336#
+ u_t012_005/m2_2000_2037# u_t012_005/m2_791_2909# u_t012_005/m2_7_2126# u_t012_005/m2_2154_2081#
+ u_t012_005/m2_1795_2037# u_t012_005/m2_871_303# u_t012_005/m2_431_438# u_t012_005/m2_1290_2898#
+ u_t012_005/m2_1714_1210# u_t012_005/m2_431_1982# u_t012_005/m2_512_1265# u_t012_005/m2_2573_2126#
+ u_t012_005/m2_603_1259# u_t012_005/m2_2074_2909# u_t012_005/m2_7_336# u_t012_005/m2_717_2037#
+ u_t012_005/m2_1886_2031# u_t012_005/m2_2573_336# u_t012_005/m2_7_2898# u_t012_005/m2_2000_1265#
+ u_t012_005/m2_512_2037# u_t012_005/m2_1795_1265# u_t012_005/m2_1714_1982# u_t012_005/m2_1886_1259#
+ u_t012_005/m2_1290_2126# u_t012_005/m2_1714_438# u_t012_005/m2_431_1210# u_t012_005/m2_2573_2898#
+ u_t012_005/m2_2154_303# u_t012_005/m2_871_2081# VSUBS detronyx_12t_2w2r_rc4_4x4_routed_5layer_direct
Xgf180mcu_as_sc_mcu7t3v3__inv_2_1420 VSS VSS VSS gf180mcu_as_sc_mcu7t3v3__inv_2_1421/Y
+ gf180mcu_as_sc_mcu7t3v3__inv_2_1422/VNW VSUBS gf180mcu_as_sc_mcu7t3v3__inv_2
Xgf180mcu_as_sc_mcu7t3v3__inv_2_1453 VSS VSS VSS gf180mcu_as_sc_mcu7t3v3__inv_2_1454/Y
+ gf180mcu_as_sc_mcu7t3v3__inv_2_1455/VNW VSUBS gf180mcu_as_sc_mcu7t3v3__inv_2
Xgf180mcu_as_sc_mcu7t3v3__inv_2_1442 VSS VSS gf180mcu_as_sc_mcu7t3v3__inv_2_1442/Y
+ gf180mcu_as_sc_mcu7t3v3__inv_2_1443/Y gf180mcu_as_sc_mcu7t3v3__inv_2_1443/VNW VSUBS
+ gf180mcu_as_sc_mcu7t3v3__inv_2
Xgf180mcu_as_sc_mcu7t3v3__inv_2_1431 VSS VSS gf180mcu_as_sc_mcu7t3v3__inv_2_1431/Y
+ gf180mcu_as_sc_mcu7t3v3__inv_2_1431/A gf180mcu_as_sc_mcu7t3v3__inv_2_1431/VNW VSUBS
+ gf180mcu_as_sc_mcu7t3v3__inv_2
Xgf180mcu_as_sc_mcu7t3v3__inv_2_1475 VSS VSS gf180mcu_as_sc_mcu7t3v3__inv_2_1475/Y
+ gf180mcu_as_sc_mcu7t3v3__inv_2_1476/Y gf180mcu_as_sc_mcu7t3v3__inv_2_1476/VNW VSUBS
+ gf180mcu_as_sc_mcu7t3v3__inv_2
Xgf180mcu_as_sc_mcu7t3v3__inv_2_1464 VSS VSS gf180mcu_as_sc_mcu7t3v3__inv_2_1464/Y
+ gf180mcu_as_sc_mcu7t3v3__inv_2_1464/A gf180mcu_as_sc_mcu7t3v3__inv_2_1464/VNW VSUBS
+ gf180mcu_as_sc_mcu7t3v3__inv_2
Xgf180mcu_as_sc_mcu7t3v3__inv_2_1486 VSS VSS VSS gf180mcu_as_sc_mcu7t3v3__inv_2_1487/Y
+ gf180mcu_as_sc_mcu7t3v3__inv_2_1488/VNW VSUBS gf180mcu_as_sc_mcu7t3v3__inv_2
Xgf180mcu_as_sc_mcu7t3v3__inv_2_1497 VSS VSS gf180mcu_as_sc_mcu7t3v3__inv_2_1497/Y
+ gf180mcu_as_sc_mcu7t3v3__inv_2_1497/A gf180mcu_as_sc_mcu7t3v3__inv_2_1497/VNW VSUBS
+ gf180mcu_as_sc_mcu7t3v3__inv_2
Xgf180mcu_as_sc_mcu7t3v3__inv_2_904 VSS VSS gf180mcu_as_sc_mcu7t3v3__inv_2_904/Y gf180mcu_as_sc_mcu7t3v3__inv_2_904/A
+ gf180mcu_as_sc_mcu7t3v3__inv_2_956/VNW VSUBS gf180mcu_as_sc_mcu7t3v3__inv_2
Xu_t003_005 u_t003_005/c0_w0_bl u_t003_005/c0_w0_br u_t003_005/c0_w1_bl u_t003_005/c0_w1_br
+ u_t003_005/c0_r0_rbl u_t003_005/c0_r1_rbl u_t003_005/c1_w0_bl u_t003_005/c1_w0_br
+ u_t003_005/c1_w1_bl u_t003_005/c1_w1_br u_t003_005/c1_r0_rbl u_t003_005/c1_r1_rbl
+ u_t003_005/c2_w0_bl u_t003_005/c2_w0_br u_t003_005/c2_w1_bl u_t003_005/c2_w1_br
+ u_t003_005/c2_r0_rbl u_t003_005/c2_r1_rbl u_t003_005/c3_w0_bl u_t003_005/c3_w0_br
+ u_t003_005/c3_w1_bl u_t003_005/c3_w1_br u_t003_005/c3_r0_rbl u_t003_005/c3_r1_rbl
+ u_t003_005/r0_w0_wl u_t003_005/r0_w1_wl u_t003_005/r0_r0_rwl u_t003_005/r0_r1_rwl
+ u_t003_005/r1_w0_wl u_t003_005/r1_w1_wl u_t003_005/r1_r0_rwl u_t003_005/r1_r1_rwl
+ u_t003_005/r2_w0_wl u_t003_005/r2_w1_wl u_t003_005/r2_r0_rwl u_t003_005/r2_r1_rwl
+ u_t003_005/r3_w0_wl u_t003_005/r3_w1_wl u_t003_005/r3_r0_rwl u_t003_005/r3_r1_rwl
+ VSS VSS u_t003_005/m2_717_1265# u_t003_005/m2_603_2031# u_t003_005/m2_1290_336#
+ u_t003_005/m2_2000_2037# u_t003_005/m2_791_2909# u_t003_005/m2_7_2126# u_t003_005/m2_2154_2081#
+ u_t003_005/m2_1795_2037# u_t003_005/m2_871_303# u_t003_005/m2_431_438# u_t003_005/m2_1290_2898#
+ u_t003_005/m2_1714_1210# u_t003_005/m2_431_1982# u_t003_005/m2_512_1265# u_t003_005/m2_2573_2126#
+ u_t003_005/m2_603_1259# u_t003_005/m2_2074_2909# u_t003_005/m2_7_336# u_t003_005/m2_717_2037#
+ u_t003_005/m2_1886_2031# u_t003_005/m2_2573_336# u_t003_005/m2_7_2898# u_t003_005/m2_2000_1265#
+ u_t003_005/m2_512_2037# u_t003_005/m2_1795_1265# u_t003_005/m2_1714_1982# u_t003_005/m2_1886_1259#
+ u_t003_005/m2_1290_2126# u_t003_005/m2_1714_438# u_t003_005/m2_431_1210# u_t003_005/m2_2573_2898#
+ u_t003_005/m2_2154_303# u_t003_005/m2_871_2081# VSUBS detronyx_12t_2w2r_rc4_4x4_routed_5layer_direct
Xgf180mcu_as_sc_mcu7t3v3__inv_2_926 VSS VSS VSS gf180mcu_as_sc_mcu7t3v3__inv_2_926/A
+ gf180mcu_as_sc_mcu7t3v3__inv_2_926/VNW VSUBS gf180mcu_as_sc_mcu7t3v3__inv_2
Xgf180mcu_as_sc_mcu7t3v3__inv_2_948 VSS VSS VSS gf180mcu_as_sc_mcu7t3v3__inv_2_948/A
+ gf180mcu_as_sc_mcu7t3v3__inv_2_948/VNW VSUBS gf180mcu_as_sc_mcu7t3v3__inv_2
Xgf180mcu_as_sc_mcu7t3v3__inv_2_937 VSS VSS VSS gf180mcu_as_sc_mcu7t3v3__inv_2_937/A
+ gf180mcu_as_sc_mcu7t3v3__inv_2_937/VNW VSUBS gf180mcu_as_sc_mcu7t3v3__inv_2
Xgf180mcu_as_sc_mcu7t3v3__inv_2_959 VSS VSS gf180mcu_as_sc_mcu7t3v3__inv_2_959/Y gf180mcu_as_sc_mcu7t3v3__inv_2_959/A
+ gf180mcu_as_sc_mcu7t3v3__inv_2_959/VNW VSUBS gf180mcu_as_sc_mcu7t3v3__inv_2
Xgf180mcu_as_sc_mcu7t3v3__inv_2_915 VSS VSS gf180mcu_as_sc_mcu7t3v3__inv_2_957/A gf180mcu_as_sc_mcu7t3v3__inv_2_915/A
+ gf180mcu_as_sc_mcu7t3v3__inv_2_957/VNW VSUBS gf180mcu_as_sc_mcu7t3v3__inv_2
Xgf180mcu_as_sc_mcu7t3v3__nand4_2_269 VSS VSS VSS VSS VSS VSS gf180mcu_as_sc_mcu7t3v3__inv_2_899/A
+ gf180mcu_as_sc_mcu7t3v3__inv_2_927/VNW VSUBS gf180mcu_as_sc_mcu7t3v3__nand4_2
Xgf180mcu_as_sc_mcu7t3v3__nand4_2_203 VSS VSS VSS VSS VSS VSS gf180mcu_as_sc_mcu7t3v3__inv_2_652/A
+ gf180mcu_as_sc_mcu7t3v3__inv_2_652/VNW VSUBS gf180mcu_as_sc_mcu7t3v3__nand4_2
Xgf180mcu_as_sc_mcu7t3v3__nand4_2_225 VSS VSS VSS VSS VSS VSS gf180mcu_as_sc_mcu7t3v3__inv_2_773/A
+ gf180mcu_as_sc_mcu7t3v3__inv_2_825/VNW VSUBS gf180mcu_as_sc_mcu7t3v3__nand4_2
Xgf180mcu_as_sc_mcu7t3v3__nand4_2_214 VSS VSS VSS VSS VSS VSS gf180mcu_as_sc_mcu7t3v3__inv_2_749/A
+ gf180mcu_as_sc_mcu7t3v3__inv_2_829/VNW VSUBS gf180mcu_as_sc_mcu7t3v3__nand4_2
Xgf180mcu_as_sc_mcu7t3v3__nand4_2_247 VSS VSS VSS VSS VSS VSS gf180mcu_as_sc_mcu7t3v3__inv_2_819/A
+ gf180mcu_as_sc_mcu7t3v3__inv_2_819/VNW VSUBS gf180mcu_as_sc_mcu7t3v3__nand4_2
Xgf180mcu_as_sc_mcu7t3v3__nand4_2_236 VSS VSS VSS VSS VSS VSS gf180mcu_as_sc_mcu7t3v3__inv_2_793/A
+ gf180mcu_as_sc_mcu7t3v3__inv_2_844/VNW VSUBS gf180mcu_as_sc_mcu7t3v3__nand4_2
Xgf180mcu_as_sc_mcu7t3v3__nand4_2_258 VSS VSS VSS VSS VSS VSS gf180mcu_as_sc_mcu7t3v3__inv_2_874/A
+ gf180mcu_as_sc_mcu7t3v3__inv_2_930/VNW VSUBS gf180mcu_as_sc_mcu7t3v3__nand4_2
Xu_t000_008 u_t000_008/c0_w0_bl u_t000_008/c0_w0_br u_t000_008/c0_w1_bl u_t000_008/c0_w1_br
+ u_t000_008/c0_r0_rbl u_t000_008/c0_r1_rbl u_t000_008/c1_w0_bl u_t000_008/c1_w0_br
+ u_t000_008/c1_w1_bl u_t000_008/c1_w1_br u_t000_008/c1_r0_rbl u_t000_008/c1_r1_rbl
+ u_t000_008/c2_w0_bl u_t000_008/c2_w0_br u_t000_008/c2_w1_bl u_t000_008/c2_w1_br
+ u_t000_008/c2_r0_rbl u_t000_008/c2_r1_rbl u_t000_008/c3_w0_bl u_t000_008/c3_w0_br
+ u_t000_008/c3_w1_bl u_t000_008/c3_w1_br u_t000_008/c3_r0_rbl u_t000_008/c3_r1_rbl
+ u_t000_008/r0_w0_wl u_t000_008/r0_w1_wl u_t000_008/r0_r0_rwl u_t000_008/r0_r1_rwl
+ u_t000_008/r1_w0_wl u_t000_008/r1_w1_wl u_t000_008/r1_r0_rwl u_t000_008/r1_r1_rwl
+ u_t000_008/r2_w0_wl u_t000_008/r2_w1_wl u_t000_008/r2_r0_rwl u_t000_008/r2_r1_rwl
+ u_t000_008/r3_w0_wl u_t000_008/r3_w1_wl u_t000_008/r3_r0_rwl u_t000_008/r3_r1_rwl
+ VSS VSS u_t000_008/m2_717_1265# u_t000_008/m2_603_2031# u_t000_008/m2_1290_336#
+ u_t000_008/m2_2000_2037# u_t000_008/m2_791_2909# u_t000_008/m2_7_2126# u_t000_008/m2_2154_2081#
+ u_t000_008/m2_1795_2037# u_t000_008/m2_871_303# u_t000_008/m2_431_438# u_t000_008/m2_1290_2898#
+ u_t000_008/m2_1714_1210# u_t000_008/m2_431_1982# u_t000_008/m2_512_1265# u_t000_008/m2_2573_2126#
+ u_t000_008/m2_603_1259# u_t000_008/m2_2074_2909# u_t000_008/m2_7_336# u_t000_008/m2_717_2037#
+ u_t000_008/m2_1886_2031# u_t000_008/m2_2573_336# u_t000_008/m2_7_2898# u_t000_008/m2_2000_1265#
+ u_t000_008/m2_512_2037# u_t000_008/m2_1795_1265# u_t000_008/m2_1714_1982# u_t000_008/m2_1886_1259#
+ u_t000_008/m2_1290_2126# u_t000_008/m2_1714_438# u_t000_008/m2_431_1210# u_t000_008/m2_2573_2898#
+ u_t000_008/m2_2154_303# u_t000_008/m2_871_2081# VSUBS detronyx_12t_2w2r_rc4_4x4_routed_5layer_direct
Xgf180mcu_as_sc_mcu7t3v3__inv_2_1250 gf180mcu_as_sc_mcu7t3v3__nor2_2_9/VDD gf180mcu_as_sc_mcu7t3v3__nor2_2_9/VSS
+ VSS VSS gf180mcu_as_sc_mcu7t3v3__nor2_2_9/VNW VSUBS gf180mcu_as_sc_mcu7t3v3__inv_2
Xgf180mcu_as_sc_mcu7t3v3__inv_2_1261 gf180mcu_as_sc_mcu7t3v3__nand3_2_65/VDD gf180mcu_as_sc_mcu7t3v3__nand3_2_62/VSS
+ VSS VSS gf180mcu_as_sc_mcu7t3v3__nand3_2_65/VNW VSUBS gf180mcu_as_sc_mcu7t3v3__inv_2
Xgf180mcu_as_sc_mcu7t3v3__inv_2_1283 VSS VSS VSS gf180mcu_as_sc_mcu7t3v3__inv_2_1283/A
+ gf180mcu_as_sc_mcu7t3v3__inv_2_1283/VNW VSUBS gf180mcu_as_sc_mcu7t3v3__inv_2
Xgf180mcu_as_sc_mcu7t3v3__inv_2_1272 VSS VSS VSS gf180mcu_as_sc_mcu7t3v3__inv_2_1272/A
+ gf180mcu_as_sc_mcu7t3v3__inv_2_1272/VNW VSUBS gf180mcu_as_sc_mcu7t3v3__inv_2
Xgf180mcu_as_sc_mcu7t3v3__inv_2_1294 VSS VSS VSS gf180mcu_as_sc_mcu7t3v3__inv_2_1294/A
+ gf180mcu_as_sc_mcu7t3v3__inv_2_1294/VNW VSUBS gf180mcu_as_sc_mcu7t3v3__inv_2
Xgf180mcu_as_sc_mcu7t3v3__inv_2_745 VSS VSS gf180mcu_as_sc_mcu7t3v3__inv_2_745/Y gf180mcu_as_sc_mcu7t3v3__inv_2_746/Y
+ gf180mcu_as_sc_mcu7t3v3__inv_2_746/VNW VSUBS gf180mcu_as_sc_mcu7t3v3__inv_2
Xgf180mcu_as_sc_mcu7t3v3__inv_2_723 VSS VSS gf180mcu_as_sc_mcu7t3v3__inv_2_723/Y gf180mcu_as_sc_mcu7t3v3__inv_2_724/Y
+ gf180mcu_as_sc_mcu7t3v3__inv_2_724/VNW VSUBS gf180mcu_as_sc_mcu7t3v3__inv_2
Xgf180mcu_as_sc_mcu7t3v3__inv_2_712 VSS VSS gf180mcu_as_sc_mcu7t3v3__inv_2_712/Y gf180mcu_as_sc_mcu7t3v3__inv_2_712/A
+ gf180mcu_as_sc_mcu7t3v3__inv_2_712/VNW VSUBS gf180mcu_as_sc_mcu7t3v3__inv_2
Xgf180mcu_as_sc_mcu7t3v3__inv_2_701 VSS VSS gf180mcu_as_sc_mcu7t3v3__inv_2_701/Y gf180mcu_as_sc_mcu7t3v3__inv_2_701/A
+ gf180mcu_as_sc_mcu7t3v3__inv_2_701/VNW VSUBS gf180mcu_as_sc_mcu7t3v3__inv_2
Xgf180mcu_as_sc_mcu7t3v3__inv_2_734 VSS VSS VSS gf180mcu_as_sc_mcu7t3v3__inv_2_735/Y
+ gf180mcu_as_sc_mcu7t3v3__inv_2_736/VNW VSUBS gf180mcu_as_sc_mcu7t3v3__inv_2
Xgf180mcu_as_sc_mcu7t3v3__inv_2_767 VSS VSS gf180mcu_as_sc_mcu7t3v3__inv_2_767/Y gf180mcu_as_sc_mcu7t3v3__inv_2_767/A
+ gf180mcu_as_sc_mcu7t3v3__inv_2_823/VNW VSUBS gf180mcu_as_sc_mcu7t3v3__inv_2
Xgf180mcu_as_sc_mcu7t3v3__inv_2_756 VSS VSS gf180mcu_as_sc_mcu7t3v3__inv_2_756/Y gf180mcu_as_sc_mcu7t3v3__inv_2_756/A
+ gf180mcu_as_sc_mcu7t3v3__inv_2_836/VNW VSUBS gf180mcu_as_sc_mcu7t3v3__inv_2
Xgf180mcu_as_sc_mcu7t3v3__inv_2_778 VSS VSS gf180mcu_as_sc_mcu7t3v3__inv_2_834/A gf180mcu_as_sc_mcu7t3v3__inv_2_778/A
+ gf180mcu_as_sc_mcu7t3v3__inv_2_834/VNW VSUBS gf180mcu_as_sc_mcu7t3v3__inv_2
Xgf180mcu_as_sc_mcu7t3v3__inv_2_789 VSS VSS gf180mcu_as_sc_mcu7t3v3__inv_2_843/A gf180mcu_as_sc_mcu7t3v3__inv_2_790/Y
+ gf180mcu_as_sc_mcu7t3v3__inv_2_843/VNW VSUBS gf180mcu_as_sc_mcu7t3v3__inv_2
Xgf180mcu_as_sc_mcu7t3v3__inv_2_1091 VSS VSS gf180mcu_as_sc_mcu7t3v3__inv_2_1091/Y
+ gf180mcu_as_sc_mcu7t3v3__inv_2_1091/A gf180mcu_as_sc_mcu7t3v3__inv_2_1091/VNW VSUBS
+ gf180mcu_as_sc_mcu7t3v3__inv_2
Xgf180mcu_as_sc_mcu7t3v3__inv_2_1080 VSS VSS gf180mcu_as_sc_mcu7t3v3__inv_2_1080/Y
+ gf180mcu_as_sc_mcu7t3v3__inv_2_1080/A gf180mcu_as_sc_mcu7t3v3__inv_2_1080/VNW VSUBS
+ gf180mcu_as_sc_mcu7t3v3__inv_2
Xgf180mcu_as_sc_mcu7t3v3__nand4_2_3 VSS VSS VSS VSS VSS VSS gf180mcu_as_sc_mcu7t3v3__nand4_2_3/Y
+ gf180mcu_as_sc_mcu7t3v3__nand4_2_3/VNW VSUBS gf180mcu_as_sc_mcu7t3v3__nand4_2
Xgf180mcu_as_sc_mcu7t3v3__inv_2_542 VSS VSS gf180mcu_as_sc_mcu7t3v3__inv_2_542/Y gf180mcu_as_sc_mcu7t3v3__inv_2_542/A
+ gf180mcu_as_sc_mcu7t3v3__inv_2_542/VNW VSUBS gf180mcu_as_sc_mcu7t3v3__inv_2
Xgf180mcu_as_sc_mcu7t3v3__inv_2_586 VSS VSS VSS gf180mcu_as_sc_mcu7t3v3__inv_2_587/Y
+ gf180mcu_as_sc_mcu7t3v3__inv_2_588/VNW VSUBS gf180mcu_as_sc_mcu7t3v3__inv_2
Xgf180mcu_as_sc_mcu7t3v3__inv_2_564 VSS VSS gf180mcu_as_sc_mcu7t3v3__inv_2_590/A gf180mcu_as_sc_mcu7t3v3__inv_2_564/A
+ gf180mcu_as_sc_mcu7t3v3__inv_2_590/VNW VSUBS gf180mcu_as_sc_mcu7t3v3__inv_2
Xgf180mcu_as_sc_mcu7t3v3__inv_2_575 VSS VSS gf180mcu_as_sc_mcu7t3v3__inv_2_575/Y gf180mcu_as_sc_mcu7t3v3__inv_2_576/Y
+ gf180mcu_as_sc_mcu7t3v3__inv_2_576/VNW VSUBS gf180mcu_as_sc_mcu7t3v3__inv_2
Xgf180mcu_as_sc_mcu7t3v3__inv_2_520 gf180mcu_as_sc_mcu7t3v3__nor2_2_6/VDD gf180mcu_as_sc_mcu7t3v3__nor2_2_6/VSS
+ VSS VSS gf180mcu_as_sc_mcu7t3v3__nor2_2_6/VNW VSUBS gf180mcu_as_sc_mcu7t3v3__inv_2
Xgf180mcu_as_sc_mcu7t3v3__inv_2_531 gf180mcu_as_sc_mcu7t3v3__nor2_2_4/VDD gf180mcu_as_sc_mcu7t3v3__nand2_2_3/VSS
+ VSS VSS gf180mcu_as_sc_mcu7t3v3__nor2_2_4/VNW VSUBS gf180mcu_as_sc_mcu7t3v3__inv_2
Xgf180mcu_as_sc_mcu7t3v3__inv_2_553 VSS VSS VSS gf180mcu_as_sc_mcu7t3v3__inv_2_553/A
+ gf180mcu_as_sc_mcu7t3v3__inv_2_553/VNW VSUBS gf180mcu_as_sc_mcu7t3v3__inv_2
Xgf180mcu_as_sc_mcu7t3v3__inv_2_597 VSS VSS gf180mcu_as_sc_mcu7t3v3__inv_2_597/Y gf180mcu_as_sc_mcu7t3v3__inv_2_598/Y
+ gf180mcu_as_sc_mcu7t3v3__inv_2_598/VNW VSUBS gf180mcu_as_sc_mcu7t3v3__inv_2
Xgf180mcu_as_sc_mcu7t3v3__inv_2_372 gf180mcu_as_sc_mcu7t3v3__nor2_2_7/VDD gf180mcu_as_sc_mcu7t3v3__nand3_2_4/VSS
+ gf180mcu_as_sc_mcu7t3v3__inv_2_372/Y VSS gf180mcu_as_sc_mcu7t3v3__nor2_2_7/VNW VSUBS
+ gf180mcu_as_sc_mcu7t3v3__inv_2
Xgf180mcu_as_sc_mcu7t3v3__inv_2_394 gf180mcu_as_sc_mcu7t3v3__nor2_2_7/VDD gf180mcu_as_sc_mcu7t3v3__nor2_2_7/VSS
+ VSS VSS gf180mcu_as_sc_mcu7t3v3__nor2_2_7/VNW VSUBS gf180mcu_as_sc_mcu7t3v3__inv_2
Xgf180mcu_as_sc_mcu7t3v3__inv_2_383 gf180mcu_as_sc_mcu7t3v3__nand3_2_9/VDD gf180mcu_as_sc_mcu7t3v3__nor2_2_7/VSS
+ VSS VSS gf180mcu_as_sc_mcu7t3v3__nand3_2_9/VNW VSUBS gf180mcu_as_sc_mcu7t3v3__inv_2
Xgf180mcu_as_sc_mcu7t3v3__inv_2_361 VSS VSS gf180mcu_as_sc_mcu7t3v3__inv_2_361/Y gf180mcu_as_sc_mcu7t3v3__inv_2_362/Y
+ gf180mcu_as_sc_mcu7t3v3__inv_2_362/VNW VSUBS gf180mcu_as_sc_mcu7t3v3__inv_2
Xgf180mcu_as_sc_mcu7t3v3__inv_2_350 VSS VSS gf180mcu_as_sc_mcu7t3v3__inv_2_350/Y gf180mcu_as_sc_mcu7t3v3__inv_2_350/A
+ gf180mcu_as_sc_mcu7t3v3__inv_2_350/VNW VSUBS gf180mcu_as_sc_mcu7t3v3__inv_2
Xu_t027_011 u_t027_011/c0_w0_bl u_t027_011/c0_w0_br u_t027_011/c0_w1_bl u_t027_011/c0_w1_br
+ u_t027_011/c0_r0_rbl u_t027_011/c0_r1_rbl u_t027_011/c1_w0_bl u_t027_011/c1_w0_br
+ u_t027_011/c1_w1_bl u_t027_011/c1_w1_br u_t027_011/c1_r0_rbl u_t027_011/c1_r1_rbl
+ u_t027_011/c2_w0_bl u_t027_011/c2_w0_br u_t027_011/c2_w1_bl u_t027_011/c2_w1_br
+ u_t027_011/c2_r0_rbl u_t027_011/c2_r1_rbl u_t027_011/c3_w0_bl u_t027_011/c3_w0_br
+ u_t027_011/c3_w1_bl u_t027_011/c3_w1_br u_t027_011/c3_r0_rbl u_t027_011/c3_r1_rbl
+ u_t027_011/r0_w0_wl u_t027_011/r0_w1_wl u_t027_011/r0_r0_rwl u_t027_011/r0_r1_rwl
+ u_t027_011/r1_w0_wl u_t027_011/r1_w1_wl u_t027_011/r1_r0_rwl u_t027_011/r1_r1_rwl
+ u_t027_011/r2_w0_wl u_t027_011/r2_w1_wl u_t027_011/r2_r0_rwl u_t027_011/r2_r1_rwl
+ u_t027_011/r3_w0_wl u_t027_011/r3_w1_wl u_t027_011/r3_r0_rwl u_t027_011/r3_r1_rwl
+ VSS VSS u_t027_011/m2_717_1265# u_t027_011/m2_603_2031# u_t027_011/m2_1290_336#
+ u_t027_011/m2_2000_2037# u_t027_011/m2_791_2909# u_t027_011/m2_7_2126# u_t027_011/m2_2154_2081#
+ u_t027_011/m2_1795_2037# u_t027_011/m2_871_303# u_t027_011/m2_431_438# u_t027_011/m2_1290_2898#
+ u_t027_011/m2_1714_1210# u_t027_011/m2_431_1982# u_t027_011/m2_512_1265# u_t027_011/m2_2573_2126#
+ u_t027_011/m2_603_1259# u_t027_011/m2_2074_2909# u_t027_011/m2_7_336# u_t027_011/m2_717_2037#
+ u_t027_011/m2_1886_2031# u_t027_011/m2_2573_336# u_t027_011/m2_7_2898# u_t027_011/m2_2000_1265#
+ u_t027_011/m2_512_2037# u_t027_011/m2_1795_1265# u_t027_011/m2_1714_1982# u_t027_011/m2_1886_1259#
+ u_t027_011/m2_1290_2126# u_t027_011/m2_1714_438# u_t027_011/m2_431_1210# u_t027_011/m2_2573_2898#
+ u_t027_011/m2_2154_303# u_t027_011/m2_871_2081# VSUBS detronyx_12t_2w2r_rc4_4x4_routed_5layer_direct
Xu_t027_000 VSS u_t027_000/c0_w0_br VSS u_t027_000/c0_w1_br u_t027_000/c0_r0_rbl u_t027_000/c0_r1_rbl
+ VSS VSS VSS VSS VSS VSS u_t027_000/c2_w0_bl u_t027_000/c2_w0_br u_t027_000/c2_w1_bl
+ u_t027_000/c2_w1_br u_t027_000/c2_r0_rbl u_t027_000/c2_r1_rbl u_t027_000/c3_w0_bl
+ u_t027_000/c3_w0_br u_t027_000/c3_w1_bl u_t027_000/c3_w1_br u_t027_000/c3_r0_rbl
+ u_t027_000/c3_r1_rbl VSS VSS VSS VSS VSS VSS VSS VSS VSS VSS VSS VSS VSS VSS VSS
+ VSS VSS VSS u_t027_000/m2_717_1265# VSS VSS VSS VSS u_t027_000/m2_7_2126# VSS VSS
+ VSS VSS VSS VSS VSS u_t027_000/m2_512_1265# u_t027_000/m2_2573_2126# u_t027_000/m2_603_1259#
+ VSS VSS VSS VSS u_t027_000/m2_2573_336# VSS u_t027_000/m2_2000_1265# VSS u_t027_000/m2_1795_1265#
+ VSS u_t027_000/m2_1886_1259# u_t027_000/m2_1290_2126# VSS VSS u_t027_000/m2_2573_2898#
+ VSS VSS VSUBS detronyx_12t_2w2r_rc4_4x4_routed_5layer_direct
Xu_t018_011 u_t018_011/c0_w0_bl u_t018_011/c0_w0_br u_t018_011/c0_w1_bl u_t018_011/c0_w1_br
+ u_t018_011/c0_r0_rbl u_t018_011/c0_r1_rbl u_t018_011/c1_w0_bl u_t018_011/c1_w0_br
+ u_t018_011/c1_w1_bl u_t018_011/c1_w1_br u_t018_011/c1_r0_rbl u_t018_011/c1_r1_rbl
+ u_t018_011/c2_w0_bl u_t018_011/c2_w0_br u_t018_011/c2_w1_bl u_t018_011/c2_w1_br
+ u_t018_011/c2_r0_rbl u_t018_011/c2_r1_rbl u_t018_011/c3_w0_bl u_t018_011/c3_w0_br
+ u_t018_011/c3_w1_bl u_t018_011/c3_w1_br u_t018_011/c3_r0_rbl u_t018_011/c3_r1_rbl
+ u_t018_011/r0_w0_wl u_t018_011/r0_w1_wl u_t018_011/r0_r0_rwl u_t018_011/r0_r1_rwl
+ u_t018_011/r1_w0_wl u_t018_011/r1_w1_wl u_t018_011/r1_r0_rwl u_t018_011/r1_r1_rwl
+ u_t018_011/r2_w0_wl u_t018_011/r2_w1_wl u_t018_011/r2_r0_rwl u_t018_011/r2_r1_rwl
+ u_t018_011/r3_w0_wl u_t018_011/r3_w1_wl u_t018_011/r3_r0_rwl u_t018_011/r3_r1_rwl
+ VSS VSS u_t018_011/m2_717_1265# u_t018_011/m2_603_2031# u_t018_011/m2_1290_336#
+ u_t018_011/m2_2000_2037# u_t018_011/m2_791_2909# u_t018_011/m2_7_2126# u_t018_011/m2_2154_2081#
+ u_t018_011/m2_1795_2037# u_t018_011/m2_871_303# u_t018_011/m2_431_438# u_t018_011/m2_1290_2898#
+ u_t018_011/m2_1714_1210# u_t018_011/m2_431_1982# u_t018_011/m2_512_1265# u_t018_011/m2_2573_2126#
+ u_t018_011/m2_603_1259# u_t018_011/m2_2074_2909# u_t018_011/m2_7_336# u_t018_011/m2_717_2037#
+ u_t018_011/m2_1886_2031# u_t018_011/m2_2573_336# u_t018_011/m2_7_2898# u_t018_011/m2_2000_1265#
+ u_t018_011/m2_512_2037# u_t018_011/m2_1795_1265# u_t018_011/m2_1714_1982# u_t018_011/m2_1886_1259#
+ u_t018_011/m2_1290_2126# u_t018_011/m2_1714_438# u_t018_011/m2_431_1210# u_t018_011/m2_2573_2898#
+ u_t018_011/m2_2154_303# u_t018_011/m2_871_2081# VSUBS detronyx_12t_2w2r_rc4_4x4_routed_5layer_direct
Xu_t018_000 VSS u_t018_000/c0_w0_br VSS u_t018_000/c0_w1_br u_t018_000/c0_r0_rbl u_t018_000/c0_r1_rbl
+ VSS VSS VSS VSS VSS VSS u_t018_000/c2_w0_bl u_t018_000/c2_w0_br u_t018_000/c2_w1_bl
+ u_t018_000/c2_w1_br u_t018_000/c2_r0_rbl u_t018_000/c2_r1_rbl u_t018_000/c3_w0_bl
+ u_t018_000/c3_w0_br u_t018_000/c3_w1_bl u_t018_000/c3_w1_br u_t018_000/c3_r0_rbl
+ u_t018_000/c3_r1_rbl VSS VSS VSS VSS VSS VSS VSS VSS VSS VSS VSS VSS VSS VSS VSS
+ VSS VSS VSS VSS VSS VSS VSS VSS VSS VSS VSS VSS VSS VSS VSS VSS VSS u_t018_000/m2_2573_2126#
+ VSS VSS VSS VSS VSS u_t018_000/m2_2573_336# VSS VSS VSS VSS u_t018_000/m2_1714_1982#
+ VSS VSS u_t018_000/m2_1714_438# VSS u_t018_000/m2_2573_2898# VSS VSS VSUBS detronyx_12t_2w2r_rc4_4x4_routed_5layer_direct
Xu_t024_014 u_t024_014/c0_w0_bl u_t024_014/c0_w0_br u_t024_014/c0_w1_bl u_t024_014/c0_w1_br
+ u_t024_014/c0_r0_rbl u_t024_014/c0_r1_rbl u_t024_014/c1_w0_bl u_t024_014/c1_w0_br
+ u_t024_014/c1_w1_bl u_t024_014/c1_w1_br u_t024_014/c1_r0_rbl u_t024_014/c1_r1_rbl
+ u_t024_014/c2_w0_bl u_t024_014/c2_w0_br u_t024_014/c2_w1_bl u_t024_014/c2_w1_br
+ u_t024_014/c2_r0_rbl u_t024_014/c2_r1_rbl u_t024_014/c3_w0_bl u_t024_014/c3_w0_br
+ u_t024_014/c3_w1_bl u_t024_014/c3_w1_br u_t024_014/c3_r0_rbl u_t024_014/c3_r1_rbl
+ u_t024_014/r0_w0_wl u_t024_014/r0_w1_wl u_t024_014/r0_r0_rwl u_t024_014/r0_r1_rwl
+ u_t024_014/r1_w0_wl u_t024_014/r1_w1_wl u_t024_014/r1_r0_rwl u_t024_014/r1_r1_rwl
+ u_t024_014/r2_w0_wl u_t024_014/r2_w1_wl u_t024_014/r2_r0_rwl u_t024_014/r2_r1_rwl
+ u_t024_014/r3_w0_wl u_t024_014/r3_w1_wl u_t024_014/r3_r0_rwl u_t024_014/r3_r1_rwl
+ VSS VSS u_t024_014/m2_717_1265# u_t024_014/m2_603_2031# u_t024_014/m2_1290_336#
+ u_t024_014/m2_2000_2037# u_t024_014/m2_791_2909# u_t024_014/m2_7_2126# u_t024_014/m2_2154_2081#
+ u_t024_014/m2_1795_2037# u_t024_014/m2_871_303# u_t024_014/m2_431_438# u_t024_014/m2_1290_2898#
+ u_t024_014/m2_1714_1210# u_t024_014/m2_431_1982# u_t024_014/m2_512_1265# u_t024_014/m2_2573_2126#
+ u_t024_014/m2_603_1259# u_t024_014/m2_2074_2909# u_t024_014/m2_7_336# u_t024_014/m2_717_2037#
+ u_t024_014/m2_1886_2031# u_t024_014/m2_2573_336# u_t024_014/m2_7_2898# u_t024_014/m2_2000_1265#
+ u_t024_014/m2_512_2037# u_t024_014/m2_1795_1265# u_t024_014/m2_1714_1982# u_t024_014/m2_1886_1259#
+ u_t024_014/m2_1290_2126# u_t024_014/m2_1714_438# u_t024_014/m2_431_1210# u_t024_014/m2_2573_2898#
+ u_t024_014/m2_2154_303# u_t024_014/m2_871_2081# VSUBS detronyx_12t_2w2r_rc4_4x4_routed_5layer_direct
Xu_t009_011 u_t009_011/c0_w0_bl u_t009_011/c0_w0_br u_t009_011/c0_w1_bl u_t009_011/c0_w1_br
+ u_t009_011/c0_r0_rbl u_t009_011/c0_r1_rbl u_t009_011/c1_w0_bl u_t009_011/c1_w0_br
+ u_t009_011/c1_w1_bl u_t009_011/c1_w1_br u_t009_011/c1_r0_rbl u_t009_011/c1_r1_rbl
+ u_t009_011/c2_w0_bl u_t009_011/c2_w0_br u_t009_011/c2_w1_bl u_t009_011/c2_w1_br
+ u_t009_011/c2_r0_rbl u_t009_011/c2_r1_rbl u_t009_011/c3_w0_bl u_t009_011/c3_w0_br
+ u_t009_011/c3_w1_bl u_t009_011/c3_w1_br u_t009_011/c3_r0_rbl u_t009_011/c3_r1_rbl
+ u_t009_011/r0_w0_wl u_t009_011/r0_w1_wl u_t009_011/r0_r0_rwl u_t009_011/r0_r1_rwl
+ u_t009_011/r1_w0_wl u_t009_011/r1_w1_wl u_t009_011/r1_r0_rwl u_t009_011/r1_r1_rwl
+ u_t009_011/r2_w0_wl u_t009_011/r2_w1_wl u_t009_011/r2_r0_rwl u_t009_011/r2_r1_rwl
+ u_t009_011/r3_w0_wl u_t009_011/r3_w1_wl u_t009_011/r3_r0_rwl u_t009_011/r3_r1_rwl
+ VSS VSS u_t009_011/m2_717_1265# u_t009_011/m2_603_2031# u_t009_011/m2_1290_336#
+ u_t009_011/m2_2000_2037# u_t009_011/m2_791_2909# u_t009_011/m2_7_2126# u_t009_011/m2_2154_2081#
+ u_t009_011/m2_1795_2037# u_t009_011/m2_871_303# u_t009_011/m2_431_438# u_t009_011/m2_1290_2898#
+ u_t009_011/m2_1714_1210# u_t009_011/m2_431_1982# u_t009_011/m2_512_1265# u_t009_011/m2_2573_2126#
+ u_t009_011/m2_603_1259# u_t009_011/m2_2074_2909# u_t009_011/m2_7_336# u_t009_011/m2_717_2037#
+ u_t009_011/m2_1886_2031# u_t009_011/m2_2573_336# u_t009_011/m2_7_2898# u_t009_011/m2_2000_1265#
+ u_t009_011/m2_512_2037# u_t009_011/m2_1795_1265# u_t009_011/m2_1714_1982# u_t009_011/m2_1886_1259#
+ u_t009_011/m2_1290_2126# u_t009_011/m2_1714_438# u_t009_011/m2_431_1210# u_t009_011/m2_2573_2898#
+ u_t009_011/m2_2154_303# u_t009_011/m2_871_2081# VSUBS detronyx_12t_2w2r_rc4_4x4_routed_5layer_direct
Xu_t024_003 u_t024_003/c0_w0_bl u_t024_003/c0_w0_br u_t024_003/c0_w1_bl u_t024_003/c0_w1_br
+ u_t024_003/c0_r0_rbl u_t024_003/c0_r1_rbl u_t024_003/c1_w0_bl u_t024_003/c1_w0_br
+ u_t024_003/c1_w1_bl u_t024_003/c1_w1_br u_t024_003/c1_r0_rbl u_t024_003/c1_r1_rbl
+ u_t024_003/c2_w0_bl u_t024_003/c2_w0_br u_t024_003/c2_w1_bl u_t024_003/c2_w1_br
+ u_t024_003/c2_r0_rbl u_t024_003/c2_r1_rbl u_t024_003/c3_w0_bl u_t024_003/c3_w0_br
+ u_t024_003/c3_w1_bl u_t024_003/c3_w1_br u_t024_003/c3_r0_rbl u_t024_003/c3_r1_rbl
+ u_t024_003/r0_w0_wl u_t024_003/r0_w1_wl u_t024_003/r0_r0_rwl u_t024_003/r0_r1_rwl
+ u_t024_003/r1_w0_wl u_t024_003/r1_w1_wl u_t024_003/r1_r0_rwl u_t024_003/r1_r1_rwl
+ u_t024_003/r2_w0_wl u_t024_003/r2_w1_wl u_t024_003/r2_r0_rwl u_t024_003/r2_r1_rwl
+ u_t024_003/r3_w0_wl u_t024_003/r3_w1_wl u_t024_003/r3_r0_rwl u_t024_003/r3_r1_rwl
+ VSS VSS u_t024_003/m2_717_1265# u_t024_003/m2_603_2031# u_t024_003/m2_1290_336#
+ u_t024_003/m2_2000_2037# u_t024_003/m2_791_2909# u_t024_003/m2_7_2126# u_t024_003/m2_2154_2081#
+ u_t024_003/m2_1795_2037# u_t024_003/m2_871_303# u_t024_003/m2_431_438# u_t024_003/m2_1290_2898#
+ u_t024_003/m2_1714_1210# u_t024_003/m2_431_1982# u_t024_003/m2_512_1265# u_t024_003/m2_2573_2126#
+ u_t024_003/m2_603_1259# u_t024_003/m2_2074_2909# u_t024_003/m2_7_336# u_t024_003/m2_717_2037#
+ u_t024_003/m2_1886_2031# u_t024_003/m2_2573_336# u_t024_003/m2_7_2898# u_t024_003/m2_2000_1265#
+ u_t024_003/m2_512_2037# u_t024_003/m2_1795_1265# u_t024_003/m2_1714_1982# u_t024_003/m2_1886_1259#
+ u_t024_003/m2_1290_2126# u_t024_003/m2_1714_438# u_t024_003/m2_431_1210# u_t024_003/m2_2573_2898#
+ u_t024_003/m2_2154_303# u_t024_003/m2_871_2081# VSUBS detronyx_12t_2w2r_rc4_4x4_routed_5layer_direct
Xgf180mcu_as_sc_mcu7t3v3__nand3_2_59 gf180mcu_as_sc_mcu7t3v3__nor2_2_9/VDD gf180mcu_as_sc_mcu7t3v3__nor2_2_9/VSS
+ VSS VSS VSS VSS gf180mcu_as_sc_mcu7t3v3__nor2_2_9/VNW VSUBS gf180mcu_as_sc_mcu7t3v3__nand3_2
Xgf180mcu_as_sc_mcu7t3v3__nand3_2_48 gf180mcu_as_sc_mcu7t3v3__nand3_2_65/VDD gf180mcu_as_sc_mcu7t3v3__nand3_2_62/VSS
+ VSS VSS VSS VSS gf180mcu_as_sc_mcu7t3v3__nand3_2_65/VNW VSUBS gf180mcu_as_sc_mcu7t3v3__nand3_2
Xgf180mcu_as_sc_mcu7t3v3__nand3_2_37 gf180mcu_as_sc_mcu7t3v3__nor2_2_6/VDD gf180mcu_as_sc_mcu7t3v3__nand3_2_4/VSS
+ VSS VSS VSS VSS gf180mcu_as_sc_mcu7t3v3__nor2_2_6/VNW VSUBS gf180mcu_as_sc_mcu7t3v3__nand3_2
Xgf180mcu_as_sc_mcu7t3v3__nand3_2_15 gf180mcu_as_sc_mcu7t3v3__nor2_2_6/VDD gf180mcu_as_sc_mcu7t3v3__nor2_2_6/VSS
+ VSS VSS VSS VSS gf180mcu_as_sc_mcu7t3v3__nor2_2_6/VNW VSUBS gf180mcu_as_sc_mcu7t3v3__nand3_2
Xgf180mcu_as_sc_mcu7t3v3__nand3_2_26 gf180mcu_as_sc_mcu7t3v3__nor2_2_7/VDD gf180mcu_as_sc_mcu7t3v3__nand3_2_4/VSS
+ VSS VSS VSS VSS gf180mcu_as_sc_mcu7t3v3__nor2_2_7/VNW VSUBS gf180mcu_as_sc_mcu7t3v3__nand3_2
Xu_t009_000 VSS u_t009_000/c0_w0_br VSS u_t009_000/c0_w1_br u_t009_000/c0_r0_rbl u_t009_000/c0_r1_rbl
+ VSS VSS VSS VSS VSS VSS u_t009_000/c2_w0_bl u_t009_000/c2_w0_br u_t009_000/c2_w1_bl
+ u_t009_000/c2_w1_br u_t009_000/c2_r0_rbl u_t009_000/c2_r1_rbl u_t009_000/c3_w0_bl
+ u_t009_000/c3_w0_br u_t009_000/c3_w1_bl u_t009_000/c3_w1_br u_t009_000/c3_r0_rbl
+ u_t009_000/c3_r1_rbl VSS VSS VSS VSS VSS VSS VSS VSS VSS VSS VSS VSS VSS VSS VSS
+ VSS VSS VSS u_t009_000/m2_717_1265# u_t009_000/m2_603_2031# u_t009_000/m2_1290_336#
+ u_t009_000/m2_2000_2037# u_t009_000/m2_791_2909# u_t009_000/m2_7_2126# u_t009_000/m2_2154_2081#
+ u_t009_000/m2_1795_2037# u_t009_000/m2_871_303# u_t009_000/m2_431_438# u_t009_000/m2_1290_2898#
+ u_t009_000/m2_1714_1210# u_t009_000/m2_431_1982# u_t009_000/m2_512_1265# u_t009_000/m2_2573_2126#
+ u_t009_000/m2_603_1259# u_t009_000/m2_2074_2909# u_t009_000/m2_7_336# u_t009_000/m2_717_2037#
+ u_t009_000/m2_1886_2031# u_t009_000/m2_2573_336# u_t009_000/m2_7_2898# u_t009_000/m2_2000_1265#
+ u_t009_000/m2_512_2037# u_t009_000/m2_1795_1265# u_t009_000/m2_1714_1982# u_t009_000/m2_1886_1259#
+ u_t009_000/m2_1290_2126# u_t009_000/m2_1714_438# u_t009_000/m2_431_1210# u_t009_000/m2_2573_2898#
+ u_t009_000/m2_2154_303# u_t009_000/m2_871_2081# VSUBS detronyx_12t_2w2r_rc4_4x4_routed_5layer_direct
Xgf180mcu_as_sc_mcu7t3v3__inv_2_1635 VSS VSS gf180mcu_as_sc_mcu7t3v3__inv_2_1669/A
+ gf180mcu_as_sc_mcu7t3v3__inv_2_1635/A gf180mcu_as_sc_mcu7t3v3__inv_2_1669/VNW VSUBS
+ gf180mcu_as_sc_mcu7t3v3__inv_2
Xgf180mcu_as_sc_mcu7t3v3__inv_2_1602 VSS VSS gf180mcu_as_sc_mcu7t3v3__inv_2_1635/A
+ gf180mcu_as_sc_mcu7t3v3__inv_2_1602/A gf180mcu_as_sc_mcu7t3v3__inv_2_1669/VNW VSUBS
+ gf180mcu_as_sc_mcu7t3v3__inv_2
Xgf180mcu_as_sc_mcu7t3v3__inv_2_1613 VSS VSS gf180mcu_as_sc_mcu7t3v3__inv_2_1613/Y
+ gf180mcu_as_sc_mcu7t3v3__inv_2_1614/Y gf180mcu_as_sc_mcu7t3v3__inv_2_1614/VNW VSUBS
+ gf180mcu_as_sc_mcu7t3v3__inv_2
Xgf180mcu_as_sc_mcu7t3v3__inv_2_1624 VSS VSS VSS gf180mcu_as_sc_mcu7t3v3__inv_2_1625/Y
+ gf180mcu_as_sc_mcu7t3v3__inv_2_1626/VNW VSUBS gf180mcu_as_sc_mcu7t3v3__inv_2
Xgf180mcu_as_sc_mcu7t3v3__inv_2_180 VSS VSS gf180mcu_as_sc_mcu7t3v3__inv_2_180/Y gf180mcu_as_sc_mcu7t3v3__inv_2_180/A
+ gf180mcu_as_sc_mcu7t3v3__inv_2_180/VNW VSUBS gf180mcu_as_sc_mcu7t3v3__inv_2
Xgf180mcu_as_sc_mcu7t3v3__inv_2_191 VSS VSS VSS gf180mcu_as_sc_mcu7t3v3__inv_2_192/Y
+ gf180mcu_as_sc_mcu7t3v3__inv_2_193/VNW VSUBS gf180mcu_as_sc_mcu7t3v3__inv_2
Xgf180mcu_as_sc_mcu7t3v3__inv_2_1657 VSS VSS VSS gf180mcu_as_sc_mcu7t3v3__inv_2_1661/Y
+ gf180mcu_as_sc_mcu7t3v3__inv_2_1665/VNW VSUBS gf180mcu_as_sc_mcu7t3v3__inv_2
Xgf180mcu_as_sc_mcu7t3v3__inv_2_1646 VSS VSS VSS gf180mcu_as_sc_mcu7t3v3__inv_2_1647/Y
+ gf180mcu_as_sc_mcu7t3v3__inv_2_1648/VNW VSUBS gf180mcu_as_sc_mcu7t3v3__inv_2
Xgf180mcu_as_sc_mcu7t3v3__inv_2_1668 VSS VSS gf180mcu_as_sc_mcu7t3v3__inv_2_1668/Y
+ gf180mcu_as_sc_mcu7t3v3__inv_2_1668/A gf180mcu_as_sc_mcu7t3v3__inv_2_1668/VNW VSUBS
+ gf180mcu_as_sc_mcu7t3v3__inv_2
Xgf180mcu_as_sc_mcu7t3v3__inv_2_1679 VSS VSS gf180mcu_as_sc_mcu7t3v3__inv_2_1679/Y
+ gf180mcu_as_sc_mcu7t3v3__inv_2_1680/Y gf180mcu_as_sc_mcu7t3v3__inv_2_1680/VNW VSUBS
+ gf180mcu_as_sc_mcu7t3v3__inv_2
Xu_t015_014 u_t015_014/c0_w0_bl u_t015_014/c0_w0_br u_t015_014/c0_w1_bl u_t015_014/c0_w1_br
+ u_t015_014/c0_r0_rbl u_t015_014/c0_r1_rbl u_t015_014/c1_w0_bl u_t015_014/c1_w0_br
+ u_t015_014/c1_w1_bl u_t015_014/c1_w1_br u_t015_014/c1_r0_rbl u_t015_014/c1_r1_rbl
+ u_t015_014/c2_w0_bl u_t015_014/c2_w0_br u_t015_014/c2_w1_bl u_t015_014/c2_w1_br
+ u_t015_014/c2_r0_rbl u_t015_014/c2_r1_rbl u_t015_014/c3_w0_bl u_t015_014/c3_w0_br
+ u_t015_014/c3_w1_bl u_t015_014/c3_w1_br u_t015_014/c3_r0_rbl u_t015_014/c3_r1_rbl
+ u_t015_014/r0_w0_wl u_t015_014/r0_w1_wl u_t015_014/r0_r0_rwl u_t015_014/r0_r1_rwl
+ u_t015_014/r1_w0_wl u_t015_014/r1_w1_wl u_t015_014/r1_r0_rwl u_t015_014/r1_r1_rwl
+ u_t015_014/r2_w0_wl u_t015_014/r2_w1_wl u_t015_014/r2_r0_rwl u_t015_014/r2_r1_rwl
+ u_t015_014/r3_w0_wl u_t015_014/r3_w1_wl u_t015_014/r3_r0_rwl u_t015_014/r3_r1_rwl
+ VSS VSS u_t015_014/m2_717_1265# u_t015_014/m2_603_2031# u_t015_014/m2_1290_336#
+ u_t015_014/m2_2000_2037# u_t015_014/m2_791_2909# u_t015_014/m2_7_2126# u_t015_014/m2_2154_2081#
+ u_t015_014/m2_1795_2037# u_t015_014/m2_871_303# u_t015_014/m2_431_438# u_t015_014/m2_1290_2898#
+ u_t015_014/m2_1714_1210# u_t015_014/m2_431_1982# u_t015_014/m2_512_1265# u_t015_014/m2_2573_2126#
+ u_t015_014/m2_603_1259# u_t015_014/m2_2074_2909# u_t015_014/m2_7_336# u_t015_014/m2_717_2037#
+ u_t015_014/m2_1886_2031# u_t015_014/m2_2573_336# u_t015_014/m2_7_2898# u_t015_014/m2_2000_1265#
+ u_t015_014/m2_512_2037# u_t015_014/m2_1795_1265# u_t015_014/m2_1714_1982# u_t015_014/m2_1886_1259#
+ u_t015_014/m2_1290_2126# u_t015_014/m2_1714_438# u_t015_014/m2_431_1210# u_t015_014/m2_2573_2898#
+ u_t015_014/m2_2154_303# u_t015_014/m2_871_2081# VSUBS detronyx_12t_2w2r_rc4_4x4_routed_5layer_direct
Xu_t030_006 u_t030_006/c0_w0_bl u_t030_006/c0_w0_br u_t030_006/c0_w1_bl u_t030_006/c0_w1_br
+ u_t030_006/c0_r0_rbl u_t030_006/c0_r1_rbl u_t030_006/c1_w0_bl u_t030_006/c1_w0_br
+ u_t030_006/c1_w1_bl u_t030_006/c1_w1_br u_t030_006/c1_r0_rbl u_t030_006/c1_r1_rbl
+ u_t030_006/c2_w0_bl u_t030_006/c2_w0_br u_t030_006/c2_w1_bl u_t030_006/c2_w1_br
+ u_t030_006/c2_r0_rbl u_t030_006/c2_r1_rbl u_t030_006/c3_w0_bl u_t030_006/c3_w0_br
+ u_t030_006/c3_w1_bl u_t030_006/c3_w1_br u_t030_006/c3_r0_rbl u_t030_006/c3_r1_rbl
+ u_t030_006/r0_w0_wl u_t030_006/r0_w1_wl u_t030_006/r0_r0_rwl u_t030_006/r0_r1_rwl
+ u_t030_006/r1_w0_wl u_t030_006/r1_w1_wl u_t030_006/r1_r0_rwl u_t030_006/r1_r1_rwl
+ u_t030_006/r2_w0_wl u_t030_006/r2_w1_wl u_t030_006/r2_r0_rwl u_t030_006/r2_r1_rwl
+ u_t030_006/r3_w0_wl u_t030_006/r3_w1_wl u_t030_006/r3_r0_rwl u_t030_006/r3_r1_rwl
+ VSS VSS u_t030_006/m2_717_1265# u_t030_006/m2_603_2031# u_t030_006/m2_1290_336#
+ u_t030_006/m2_2000_2037# u_t030_006/m2_791_2909# u_t030_006/m2_7_2126# u_t030_006/m2_2154_2081#
+ u_t030_006/m2_1795_2037# u_t030_006/m2_871_303# u_t030_006/m2_431_438# u_t030_006/m2_1290_2898#
+ u_t030_006/m2_1714_1210# u_t030_006/m2_431_1982# u_t030_006/m2_512_1265# u_t030_006/m2_2573_2126#
+ u_t030_006/m2_603_1259# u_t030_006/m2_2074_2909# u_t030_006/m2_7_336# u_t030_006/m2_717_2037#
+ u_t030_006/m2_1886_2031# u_t030_006/m2_2573_336# u_t030_006/m2_7_2898# u_t030_006/m2_2000_1265#
+ u_t030_006/m2_512_2037# u_t030_006/m2_1795_1265# u_t030_006/m2_1714_1982# u_t030_006/m2_1886_1259#
+ u_t030_006/m2_1290_2126# u_t030_006/m2_1714_438# u_t030_006/m2_431_1210# u_t030_006/m2_2573_2898#
+ u_t030_006/m2_2154_303# u_t030_006/m2_871_2081# VSUBS detronyx_12t_2w2r_rc4_4x4_routed_5layer_direct
Xu_t015_003 u_t015_003/c0_w0_bl u_t015_003/c0_w0_br u_t015_003/c0_w1_bl u_t015_003/c0_w1_br
+ u_t015_003/c0_r0_rbl u_t015_003/c0_r1_rbl u_t015_003/c1_w0_bl u_t015_003/c1_w0_br
+ u_t015_003/c1_w1_bl u_t015_003/c1_w1_br u_t015_003/c1_r0_rbl u_t015_003/c1_r1_rbl
+ u_t015_003/c2_w0_bl u_t015_003/c2_w0_br u_t015_003/c2_w1_bl u_t015_003/c2_w1_br
+ u_t015_003/c2_r0_rbl u_t015_003/c2_r1_rbl u_t015_003/c3_w0_bl u_t015_003/c3_w0_br
+ u_t015_003/c3_w1_bl u_t015_003/c3_w1_br u_t015_003/c3_r0_rbl u_t015_003/c3_r1_rbl
+ u_t015_003/r0_w0_wl u_t015_003/r0_w1_wl u_t015_003/r0_r0_rwl u_t015_003/r0_r1_rwl
+ u_t015_003/r1_w0_wl u_t015_003/r1_w1_wl u_t015_003/r1_r0_rwl u_t015_003/r1_r1_rwl
+ u_t015_003/r2_w0_wl u_t015_003/r2_w1_wl u_t015_003/r2_r0_rwl u_t015_003/r2_r1_rwl
+ u_t015_003/r3_w0_wl u_t015_003/r3_w1_wl u_t015_003/r3_r0_rwl u_t015_003/r3_r1_rwl
+ VSS VSS u_t015_003/m2_717_1265# u_t015_003/m2_603_2031# u_t015_003/m2_1290_336#
+ u_t015_003/m2_2000_2037# u_t015_003/m2_791_2909# u_t015_003/m2_7_2126# u_t015_003/m2_2154_2081#
+ u_t015_003/m2_1795_2037# u_t015_003/m2_871_303# u_t015_003/m2_431_438# u_t015_003/m2_1290_2898#
+ u_t015_003/m2_1714_1210# u_t015_003/m2_431_1982# u_t015_003/m2_512_1265# u_t015_003/m2_2573_2126#
+ u_t015_003/m2_603_1259# u_t015_003/m2_2074_2909# u_t015_003/m2_7_336# u_t015_003/m2_717_2037#
+ u_t015_003/m2_1886_2031# u_t015_003/m2_2573_336# u_t015_003/m2_7_2898# u_t015_003/m2_2000_1265#
+ u_t015_003/m2_512_2037# u_t015_003/m2_1795_1265# u_t015_003/m2_1714_1982# u_t015_003/m2_1886_1259#
+ u_t015_003/m2_1290_2126# u_t015_003/m2_1714_438# u_t015_003/m2_431_1210# u_t015_003/m2_2573_2898#
+ u_t015_003/m2_2154_303# u_t015_003/m2_871_2081# VSUBS detronyx_12t_2w2r_rc4_4x4_routed_5layer_direct
Xgf180mcu_as_sc_mcu7t3v3__nand4_2_429 VSS VSS VSS VSS VSS VSS gf180mcu_as_sc_mcu7t3v3__inv_2_1559/A
+ gf180mcu_as_sc_mcu7t3v3__inv_2_1559/VNW VSUBS gf180mcu_as_sc_mcu7t3v3__nand4_2
Xgf180mcu_as_sc_mcu7t3v3__nand4_2_418 VSS VSS VSS VSS VSS VSS gf180mcu_as_sc_mcu7t3v3__inv_2_1526/A
+ gf180mcu_as_sc_mcu7t3v3__inv_2_1526/VNW VSUBS gf180mcu_as_sc_mcu7t3v3__nand4_2
Xgf180mcu_as_sc_mcu7t3v3__nand4_2_407 VSS VSS VSS VSS VSS VSS gf180mcu_as_sc_mcu7t3v3__inv_2_1491/A
+ gf180mcu_as_sc_mcu7t3v3__inv_2_1491/VNW VSUBS gf180mcu_as_sc_mcu7t3v3__nand4_2
Xu_t006_014 u_t006_014/c0_w0_bl u_t006_014/c0_w0_br u_t006_014/c0_w1_bl u_t006_014/c0_w1_br
+ u_t006_014/c0_r0_rbl u_t006_014/c0_r1_rbl u_t006_014/c1_w0_bl u_t006_014/c1_w0_br
+ u_t006_014/c1_w1_bl u_t006_014/c1_w1_br u_t006_014/c1_r0_rbl u_t006_014/c1_r1_rbl
+ u_t006_014/c2_w0_bl u_t006_014/c2_w0_br u_t006_014/c2_w1_bl u_t006_014/c2_w1_br
+ u_t006_014/c2_r0_rbl u_t006_014/c2_r1_rbl u_t006_014/c3_w0_bl u_t006_014/c3_w0_br
+ u_t006_014/c3_w1_bl u_t006_014/c3_w1_br u_t006_014/c3_r0_rbl u_t006_014/c3_r1_rbl
+ u_t006_014/r0_w0_wl u_t006_014/r0_w1_wl u_t006_014/r0_r0_rwl u_t006_014/r0_r1_rwl
+ u_t006_014/r1_w0_wl u_t006_014/r1_w1_wl u_t006_014/r1_r0_rwl u_t006_014/r1_r1_rwl
+ u_t006_014/r2_w0_wl u_t006_014/r2_w1_wl u_t006_014/r2_r0_rwl u_t006_014/r2_r1_rwl
+ u_t006_014/r3_w0_wl u_t006_014/r3_w1_wl u_t006_014/r3_r0_rwl u_t006_014/r3_r1_rwl
+ VSS VSS u_t006_014/m2_717_1265# u_t006_014/m2_603_2031# u_t006_014/m2_1290_336#
+ u_t006_014/m2_2000_2037# u_t006_014/m2_791_2909# u_t006_014/m2_7_2126# u_t006_014/m2_2154_2081#
+ u_t006_014/m2_1795_2037# u_t006_014/m2_871_303# u_t006_014/m2_431_438# u_t006_014/m2_1290_2898#
+ u_t006_014/m2_1714_1210# u_t006_014/m2_431_1982# u_t006_014/m2_512_1265# u_t006_014/m2_2573_2126#
+ u_t006_014/m2_603_1259# u_t006_014/m2_2074_2909# u_t006_014/m2_7_336# u_t006_014/m2_717_2037#
+ u_t006_014/m2_1886_2031# u_t006_014/m2_2573_336# u_t006_014/m2_7_2898# u_t006_014/m2_2000_1265#
+ u_t006_014/m2_512_2037# u_t006_014/m2_1795_1265# u_t006_014/m2_1714_1982# u_t006_014/m2_1886_1259#
+ u_t006_014/m2_1290_2126# u_t006_014/m2_1714_438# u_t006_014/m2_431_1210# u_t006_014/m2_2573_2898#
+ u_t006_014/m2_2154_303# u_t006_014/m2_871_2081# VSUBS detronyx_12t_2w2r_rc4_4x4_routed_5layer_direct
Xu_t006_003 u_t006_003/c0_w0_bl u_t006_003/c0_w0_br u_t006_003/c0_w1_bl u_t006_003/c0_w1_br
+ u_t006_003/c0_r0_rbl u_t006_003/c0_r1_rbl u_t006_003/c1_w0_bl u_t006_003/c1_w0_br
+ u_t006_003/c1_w1_bl u_t006_003/c1_w1_br u_t006_003/c1_r0_rbl u_t006_003/c1_r1_rbl
+ u_t006_003/c2_w0_bl u_t006_003/c2_w0_br u_t006_003/c2_w1_bl u_t006_003/c2_w1_br
+ u_t006_003/c2_r0_rbl u_t006_003/c2_r1_rbl u_t006_003/c3_w0_bl u_t006_003/c3_w0_br
+ u_t006_003/c3_w1_bl u_t006_003/c3_w1_br u_t006_003/c3_r0_rbl u_t006_003/c3_r1_rbl
+ u_t006_003/r0_w0_wl u_t006_003/r0_w1_wl u_t006_003/r0_r0_rwl u_t006_003/r0_r1_rwl
+ u_t006_003/r1_w0_wl u_t006_003/r1_w1_wl u_t006_003/r1_r0_rwl u_t006_003/r1_r1_rwl
+ u_t006_003/r2_w0_wl u_t006_003/r2_w1_wl u_t006_003/r2_r0_rwl u_t006_003/r2_r1_rwl
+ u_t006_003/r3_w0_wl u_t006_003/r3_w1_wl u_t006_003/r3_r0_rwl u_t006_003/r3_r1_rwl
+ VSS VSS u_t006_003/m2_717_1265# u_t006_003/m2_603_2031# u_t006_003/m2_1290_336#
+ u_t006_003/m2_2000_2037# u_t006_003/m2_791_2909# u_t006_003/m2_7_2126# u_t006_003/m2_2154_2081#
+ u_t006_003/m2_1795_2037# u_t006_003/m2_871_303# u_t006_003/m2_431_438# u_t006_003/m2_1290_2898#
+ u_t006_003/m2_1714_1210# u_t006_003/m2_431_1982# u_t006_003/m2_512_1265# u_t006_003/m2_2573_2126#
+ u_t006_003/m2_603_1259# u_t006_003/m2_2074_2909# u_t006_003/m2_7_336# u_t006_003/m2_717_2037#
+ u_t006_003/m2_1886_2031# u_t006_003/m2_2573_336# u_t006_003/m2_7_2898# u_t006_003/m2_2000_1265#
+ u_t006_003/m2_512_2037# u_t006_003/m2_1795_1265# u_t006_003/m2_1714_1982# u_t006_003/m2_1886_1259#
+ u_t006_003/m2_1290_2126# u_t006_003/m2_1714_438# u_t006_003/m2_431_1210# u_t006_003/m2_2573_2898#
+ u_t006_003/m2_2154_303# u_t006_003/m2_871_2081# VSUBS detronyx_12t_2w2r_rc4_4x4_routed_5layer_direct
Xgf180mcu_as_sc_mcu7t3v3__inv_2_8 VSS VSS gf180mcu_as_sc_mcu7t3v3__inv_2_8/Y gf180mcu_as_sc_mcu7t3v3__inv_2_8/A
+ gf180mcu_as_sc_mcu7t3v3__inv_2_8/VNW VSUBS gf180mcu_as_sc_mcu7t3v3__inv_2
Xu_t021_006 u_t021_006/c0_w0_bl u_t021_006/c0_w0_br u_t021_006/c0_w1_bl u_t021_006/c0_w1_br
+ u_t021_006/c0_r0_rbl u_t021_006/c0_r1_rbl u_t021_006/c1_w0_bl u_t021_006/c1_w0_br
+ u_t021_006/c1_w1_bl u_t021_006/c1_w1_br u_t021_006/c1_r0_rbl u_t021_006/c1_r1_rbl
+ u_t021_006/c2_w0_bl u_t021_006/c2_w0_br u_t021_006/c2_w1_bl u_t021_006/c2_w1_br
+ u_t021_006/c2_r0_rbl u_t021_006/c2_r1_rbl u_t021_006/c3_w0_bl u_t021_006/c3_w0_br
+ u_t021_006/c3_w1_bl u_t021_006/c3_w1_br u_t021_006/c3_r0_rbl u_t021_006/c3_r1_rbl
+ u_t021_006/r0_w0_wl u_t021_006/r0_w1_wl u_t021_006/r0_r0_rwl u_t021_006/r0_r1_rwl
+ u_t021_006/r1_w0_wl u_t021_006/r1_w1_wl u_t021_006/r1_r0_rwl u_t021_006/r1_r1_rwl
+ u_t021_006/r2_w0_wl u_t021_006/r2_w1_wl u_t021_006/r2_r0_rwl u_t021_006/r2_r1_rwl
+ u_t021_006/r3_w0_wl u_t021_006/r3_w1_wl u_t021_006/r3_r0_rwl u_t021_006/r3_r1_rwl
+ VSS VSS u_t021_006/m2_717_1265# u_t021_006/m2_603_2031# u_t021_006/m2_1290_336#
+ u_t021_006/m2_2000_2037# u_t021_006/m2_791_2909# u_t021_006/m2_7_2126# u_t021_006/m2_2154_2081#
+ u_t021_006/m2_1795_2037# u_t021_006/m2_871_303# u_t021_006/m2_431_438# u_t021_006/m2_1290_2898#
+ u_t021_006/m2_1714_1210# u_t021_006/m2_431_1982# u_t021_006/m2_512_1265# u_t021_006/m2_2573_2126#
+ u_t021_006/m2_603_1259# u_t021_006/m2_2074_2909# u_t021_006/m2_7_336# u_t021_006/m2_717_2037#
+ u_t021_006/m2_1886_2031# u_t021_006/m2_2573_336# u_t021_006/m2_7_2898# u_t021_006/m2_2000_1265#
+ u_t021_006/m2_512_2037# u_t021_006/m2_1795_1265# u_t021_006/m2_1714_1982# u_t021_006/m2_1886_1259#
+ u_t021_006/m2_1290_2126# u_t021_006/m2_1714_438# u_t021_006/m2_431_1210# u_t021_006/m2_2573_2898#
+ u_t021_006/m2_2154_303# u_t021_006/m2_871_2081# VSUBS detronyx_12t_2w2r_rc4_4x4_routed_5layer_direct
Xu_t012_006 u_t012_006/c0_w0_bl u_t012_006/c0_w0_br u_t012_006/c0_w1_bl u_t012_006/c0_w1_br
+ u_t012_006/c0_r0_rbl u_t012_006/c0_r1_rbl u_t012_006/c1_w0_bl u_t012_006/c1_w0_br
+ u_t012_006/c1_w1_bl u_t012_006/c1_w1_br u_t012_006/c1_r0_rbl u_t012_006/c1_r1_rbl
+ u_t012_006/c2_w0_bl u_t012_006/c2_w0_br u_t012_006/c2_w1_bl u_t012_006/c2_w1_br
+ u_t012_006/c2_r0_rbl u_t012_006/c2_r1_rbl u_t012_006/c3_w0_bl u_t012_006/c3_w0_br
+ u_t012_006/c3_w1_bl u_t012_006/c3_w1_br u_t012_006/c3_r0_rbl u_t012_006/c3_r1_rbl
+ u_t012_006/r0_w0_wl u_t012_006/r0_w1_wl u_t012_006/r0_r0_rwl u_t012_006/r0_r1_rwl
+ u_t012_006/r1_w0_wl u_t012_006/r1_w1_wl u_t012_006/r1_r0_rwl u_t012_006/r1_r1_rwl
+ u_t012_006/r2_w0_wl u_t012_006/r2_w1_wl u_t012_006/r2_r0_rwl u_t012_006/r2_r1_rwl
+ u_t012_006/r3_w0_wl u_t012_006/r3_w1_wl u_t012_006/r3_r0_rwl u_t012_006/r3_r1_rwl
+ VSS VSS u_t012_006/m2_717_1265# u_t012_006/m2_603_2031# u_t012_006/m2_1290_336#
+ u_t012_006/m2_2000_2037# u_t012_006/m2_791_2909# u_t012_006/m2_7_2126# u_t012_006/m2_2154_2081#
+ u_t012_006/m2_1795_2037# u_t012_006/m2_871_303# u_t012_006/m2_431_438# u_t012_006/m2_1290_2898#
+ u_t012_006/m2_1714_1210# u_t012_006/m2_431_1982# u_t012_006/m2_512_1265# u_t012_006/m2_2573_2126#
+ u_t012_006/m2_603_1259# u_t012_006/m2_2074_2909# u_t012_006/m2_7_336# u_t012_006/m2_717_2037#
+ u_t012_006/m2_1886_2031# u_t012_006/m2_2573_336# u_t012_006/m2_7_2898# u_t012_006/m2_2000_1265#
+ u_t012_006/m2_512_2037# u_t012_006/m2_1795_1265# u_t012_006/m2_1714_1982# u_t012_006/m2_1886_1259#
+ u_t012_006/m2_1290_2126# u_t012_006/m2_1714_438# u_t012_006/m2_431_1210# u_t012_006/m2_2573_2898#
+ u_t012_006/m2_2154_303# u_t012_006/m2_871_2081# VSUBS detronyx_12t_2w2r_rc4_4x4_routed_5layer_direct
Xgf180mcu_as_sc_mcu7t3v3__inv_2_1465 VSS VSS VSS gf180mcu_as_sc_mcu7t3v3__inv_2_1466/Y
+ gf180mcu_as_sc_mcu7t3v3__inv_2_1467/VNW VSUBS gf180mcu_as_sc_mcu7t3v3__inv_2
Xgf180mcu_as_sc_mcu7t3v3__inv_2_1476 VSS VSS gf180mcu_as_sc_mcu7t3v3__inv_2_1476/Y
+ gf180mcu_as_sc_mcu7t3v3__inv_2_1476/A gf180mcu_as_sc_mcu7t3v3__inv_2_1476/VNW VSUBS
+ gf180mcu_as_sc_mcu7t3v3__inv_2
Xgf180mcu_as_sc_mcu7t3v3__inv_2_1487 VSS VSS gf180mcu_as_sc_mcu7t3v3__inv_2_1487/Y
+ gf180mcu_as_sc_mcu7t3v3__inv_2_1488/Y gf180mcu_as_sc_mcu7t3v3__inv_2_1488/VNW VSUBS
+ gf180mcu_as_sc_mcu7t3v3__inv_2
Xgf180mcu_as_sc_mcu7t3v3__inv_2_1421 VSS VSS gf180mcu_as_sc_mcu7t3v3__inv_2_1421/Y
+ gf180mcu_as_sc_mcu7t3v3__inv_2_1422/Y gf180mcu_as_sc_mcu7t3v3__inv_2_1422/VNW VSUBS
+ gf180mcu_as_sc_mcu7t3v3__inv_2
Xgf180mcu_as_sc_mcu7t3v3__inv_2_1410 VSS VSS gf180mcu_as_sc_mcu7t3v3__inv_2_1457/A
+ gf180mcu_as_sc_mcu7t3v3__inv_2_1410/A gf180mcu_as_sc_mcu7t3v3__inv_2_1457/VNW VSUBS
+ gf180mcu_as_sc_mcu7t3v3__inv_2
Xgf180mcu_as_sc_mcu7t3v3__inv_2_1454 VSS VSS gf180mcu_as_sc_mcu7t3v3__inv_2_1454/Y
+ gf180mcu_as_sc_mcu7t3v3__inv_2_1455/Y gf180mcu_as_sc_mcu7t3v3__inv_2_1455/VNW VSUBS
+ gf180mcu_as_sc_mcu7t3v3__inv_2
Xgf180mcu_as_sc_mcu7t3v3__inv_2_1443 VSS VSS gf180mcu_as_sc_mcu7t3v3__inv_2_1443/Y
+ gf180mcu_as_sc_mcu7t3v3__inv_2_1443/A gf180mcu_as_sc_mcu7t3v3__inv_2_1443/VNW VSUBS
+ gf180mcu_as_sc_mcu7t3v3__inv_2
Xgf180mcu_as_sc_mcu7t3v3__inv_2_1432 VSS VSS VSS gf180mcu_as_sc_mcu7t3v3__inv_2_1433/Y
+ gf180mcu_as_sc_mcu7t3v3__inv_2_1434/VNW VSUBS gf180mcu_as_sc_mcu7t3v3__inv_2
Xgf180mcu_as_sc_mcu7t3v3__inv_2_1498 VSS VSS VSS gf180mcu_as_sc_mcu7t3v3__inv_2_1499/Y
+ gf180mcu_as_sc_mcu7t3v3__inv_2_1500/VNW VSUBS gf180mcu_as_sc_mcu7t3v3__inv_2
Xgf180mcu_as_sc_mcu7t3v3__inv_2_927 VSS VSS VSS gf180mcu_as_sc_mcu7t3v3__inv_2_927/A
+ gf180mcu_as_sc_mcu7t3v3__inv_2_927/VNW VSUBS gf180mcu_as_sc_mcu7t3v3__inv_2
Xgf180mcu_as_sc_mcu7t3v3__inv_2_916 VSS VSS gf180mcu_as_sc_mcu7t3v3__inv_2_946/A gf180mcu_as_sc_mcu7t3v3__inv_2_917/Y
+ gf180mcu_as_sc_mcu7t3v3__inv_2_946/VNW VSUBS gf180mcu_as_sc_mcu7t3v3__inv_2
Xgf180mcu_as_sc_mcu7t3v3__inv_2_905 VSS VSS gf180mcu_as_sc_mcu7t3v3__inv_2_952/A gf180mcu_as_sc_mcu7t3v3__inv_2_906/Y
+ gf180mcu_as_sc_mcu7t3v3__inv_2_952/VNW VSUBS gf180mcu_as_sc_mcu7t3v3__inv_2
Xu_t003_006 u_t003_006/c0_w0_bl u_t003_006/c0_w0_br u_t003_006/c0_w1_bl u_t003_006/c0_w1_br
+ u_t003_006/c0_r0_rbl u_t003_006/c0_r1_rbl u_t003_006/c1_w0_bl u_t003_006/c1_w0_br
+ u_t003_006/c1_w1_bl u_t003_006/c1_w1_br u_t003_006/c1_r0_rbl u_t003_006/c1_r1_rbl
+ u_t003_006/c2_w0_bl u_t003_006/c2_w0_br u_t003_006/c2_w1_bl u_t003_006/c2_w1_br
+ u_t003_006/c2_r0_rbl u_t003_006/c2_r1_rbl u_t003_006/c3_w0_bl u_t003_006/c3_w0_br
+ u_t003_006/c3_w1_bl u_t003_006/c3_w1_br u_t003_006/c3_r0_rbl u_t003_006/c3_r1_rbl
+ u_t003_006/r0_w0_wl u_t003_006/r0_w1_wl u_t003_006/r0_r0_rwl u_t003_006/r0_r1_rwl
+ u_t003_006/r1_w0_wl u_t003_006/r1_w1_wl u_t003_006/r1_r0_rwl u_t003_006/r1_r1_rwl
+ u_t003_006/r2_w0_wl u_t003_006/r2_w1_wl u_t003_006/r2_r0_rwl u_t003_006/r2_r1_rwl
+ u_t003_006/r3_w0_wl u_t003_006/r3_w1_wl u_t003_006/r3_r0_rwl u_t003_006/r3_r1_rwl
+ VSS VSS u_t003_006/m2_717_1265# u_t003_006/m2_603_2031# u_t003_006/m2_1290_336#
+ u_t003_006/m2_2000_2037# u_t003_006/m2_791_2909# u_t003_006/m2_7_2126# u_t003_006/m2_2154_2081#
+ u_t003_006/m2_1795_2037# u_t003_006/m2_871_303# u_t003_006/m2_431_438# u_t003_006/m2_1290_2898#
+ u_t003_006/m2_1714_1210# u_t003_006/m2_431_1982# u_t003_006/m2_512_1265# u_t003_006/m2_2573_2126#
+ u_t003_006/m2_603_1259# u_t003_006/m2_2074_2909# u_t003_006/m2_7_336# u_t003_006/m2_717_2037#
+ u_t003_006/m2_1886_2031# u_t003_006/m2_2573_336# u_t003_006/m2_7_2898# u_t003_006/m2_2000_1265#
+ u_t003_006/m2_512_2037# u_t003_006/m2_1795_1265# u_t003_006/m2_1714_1982# u_t003_006/m2_1886_1259#
+ u_t003_006/m2_1290_2126# u_t003_006/m2_1714_438# u_t003_006/m2_431_1210# u_t003_006/m2_2573_2898#
+ u_t003_006/m2_2154_303# u_t003_006/m2_871_2081# VSUBS detronyx_12t_2w2r_rc4_4x4_routed_5layer_direct
Xgf180mcu_as_sc_mcu7t3v3__inv_2_949 VSS VSS VSS gf180mcu_as_sc_mcu7t3v3__inv_2_949/A
+ gf180mcu_as_sc_mcu7t3v3__inv_2_949/VNW VSUBS gf180mcu_as_sc_mcu7t3v3__inv_2
Xgf180mcu_as_sc_mcu7t3v3__inv_2_938 VSS VSS VSS gf180mcu_as_sc_mcu7t3v3__inv_2_938/A
+ gf180mcu_as_sc_mcu7t3v3__inv_2_938/VNW VSUBS gf180mcu_as_sc_mcu7t3v3__inv_2
Xgf180mcu_as_sc_mcu7t3v3__nand4_2_248 VSS VSS VSS VSS VSS VSS gf180mcu_as_sc_mcu7t3v3__inv_2_854/A
+ gf180mcu_as_sc_mcu7t3v3__inv_2_854/VNW VSUBS gf180mcu_as_sc_mcu7t3v3__nand4_2
Xgf180mcu_as_sc_mcu7t3v3__nand4_2_204 VSS VSS VSS VSS VSS VSS gf180mcu_as_sc_mcu7t3v3__inv_2_656/A
+ gf180mcu_as_sc_mcu7t3v3__inv_2_656/VNW VSUBS gf180mcu_as_sc_mcu7t3v3__nand4_2
Xgf180mcu_as_sc_mcu7t3v3__nand4_2_215 VSS VSS VSS VSS VSS VSS gf180mcu_as_sc_mcu7t3v3__inv_2_747/A
+ gf180mcu_as_sc_mcu7t3v3__inv_2_834/VNW VSUBS gf180mcu_as_sc_mcu7t3v3__nand4_2
Xgf180mcu_as_sc_mcu7t3v3__nand4_2_226 VSS VSS VSS VSS VSS VSS gf180mcu_as_sc_mcu7t3v3__inv_2_771/A
+ gf180mcu_as_sc_mcu7t3v3__inv_2_833/VNW VSUBS gf180mcu_as_sc_mcu7t3v3__nand4_2
Xgf180mcu_as_sc_mcu7t3v3__nand4_2_237 VSS VSS VSS VSS VSS VSS gf180mcu_as_sc_mcu7t3v3__inv_2_791/A
+ gf180mcu_as_sc_mcu7t3v3__inv_2_849/VNW VSUBS gf180mcu_as_sc_mcu7t3v3__nand4_2
Xgf180mcu_as_sc_mcu7t3v3__nand4_2_259 VSS VSS VSS VSS VSS VSS gf180mcu_as_sc_mcu7t3v3__inv_2_872/A
+ gf180mcu_as_sc_mcu7t3v3__inv_2_940/VNW VSUBS gf180mcu_as_sc_mcu7t3v3__nand4_2
Xu_t000_009 u_t000_009/c0_w0_bl u_t000_009/c0_w0_br u_t000_009/c0_w1_bl u_t000_009/c0_w1_br
+ u_t000_009/c0_r0_rbl u_t000_009/c0_r1_rbl u_t000_009/c1_w0_bl u_t000_009/c1_w0_br
+ u_t000_009/c1_w1_bl u_t000_009/c1_w1_br u_t000_009/c1_r0_rbl u_t000_009/c1_r1_rbl
+ u_t000_009/c2_w0_bl u_t000_009/c2_w0_br u_t000_009/c2_w1_bl u_t000_009/c2_w1_br
+ u_t000_009/c2_r0_rbl u_t000_009/c2_r1_rbl u_t000_009/c3_w0_bl u_t000_009/c3_w0_br
+ u_t000_009/c3_w1_bl u_t000_009/c3_w1_br u_t000_009/c3_r0_rbl u_t000_009/c3_r1_rbl
+ u_t000_009/r0_w0_wl u_t000_009/r0_w1_wl u_t000_009/r0_r0_rwl u_t000_009/r0_r1_rwl
+ u_t000_009/r1_w0_wl u_t000_009/r1_w1_wl u_t000_009/r1_r0_rwl u_t000_009/r1_r1_rwl
+ u_t000_009/r2_w0_wl u_t000_009/r2_w1_wl u_t000_009/r2_r0_rwl u_t000_009/r2_r1_rwl
+ u_t000_009/r3_w0_wl u_t000_009/r3_w1_wl u_t000_009/r3_r0_rwl u_t000_009/r3_r1_rwl
+ VSS VSS u_t000_009/m2_717_1265# u_t000_009/m2_603_2031# u_t000_009/m2_1290_336#
+ u_t000_009/m2_2000_2037# u_t000_009/m2_791_2909# u_t000_009/m2_7_2126# u_t000_009/m2_2154_2081#
+ u_t000_009/m2_1795_2037# u_t000_009/m2_871_303# u_t000_009/m2_431_438# u_t000_009/m2_1290_2898#
+ u_t000_009/m2_1714_1210# u_t000_009/m2_431_1982# u_t000_009/m2_512_1265# u_t000_009/m2_2573_2126#
+ u_t000_009/m2_603_1259# u_t000_009/m2_2074_2909# u_t000_009/m2_7_336# u_t000_009/m2_717_2037#
+ u_t000_009/m2_1886_2031# u_t000_009/m2_2573_336# u_t000_009/m2_7_2898# u_t000_009/m2_2000_1265#
+ u_t000_009/m2_512_2037# u_t000_009/m2_1795_1265# u_t000_009/m2_1714_1982# u_t000_009/m2_1886_1259#
+ u_t000_009/m2_1290_2126# u_t000_009/m2_1714_438# u_t000_009/m2_431_1210# u_t000_009/m2_2573_2898#
+ u_t000_009/m2_2154_303# u_t000_009/m2_871_2081# VSUBS detronyx_12t_2w2r_rc4_4x4_routed_5layer_direct
Xgf180mcu_as_sc_mcu7t3v3__inv_2_1262 gf180mcu_as_sc_mcu7t3v3__nand3_2_65/VDD gf180mcu_as_sc_mcu7t3v3__nor2_2_9/VSS
+ VSS VSS gf180mcu_as_sc_mcu7t3v3__nand3_2_65/VNW VSUBS gf180mcu_as_sc_mcu7t3v3__inv_2
Xgf180mcu_as_sc_mcu7t3v3__inv_2_1273 gf180mcu_as_sc_mcu7t3v3__nor2_2_9/VDD gf180mcu_as_sc_mcu7t3v3__nand3_2_63/VSS
+ VSS VSS gf180mcu_as_sc_mcu7t3v3__nor2_2_9/VNW VSUBS gf180mcu_as_sc_mcu7t3v3__inv_2
Xgf180mcu_as_sc_mcu7t3v3__inv_2_1240 gf180mcu_as_sc_mcu7t3v3__nand3_2_65/VDD gf180mcu_as_sc_mcu7t3v3__nor2_2_9/VSS
+ VSS VSS gf180mcu_as_sc_mcu7t3v3__nand3_2_65/VNW VSUBS gf180mcu_as_sc_mcu7t3v3__inv_2
Xgf180mcu_as_sc_mcu7t3v3__inv_2_1251 gf180mcu_as_sc_mcu7t3v3__nand3_2_65/VDD gf180mcu_as_sc_mcu7t3v3__nand3_2_62/VSS
+ VSS VSS gf180mcu_as_sc_mcu7t3v3__nand3_2_65/VNW VSUBS gf180mcu_as_sc_mcu7t3v3__inv_2
Xgf180mcu_as_sc_mcu7t3v3__inv_2_1284 VSS VSS VSS gf180mcu_as_sc_mcu7t3v3__inv_2_1285/Y
+ gf180mcu_as_sc_mcu7t3v3__inv_2_1286/VNW VSUBS gf180mcu_as_sc_mcu7t3v3__inv_2
Xgf180mcu_as_sc_mcu7t3v3__inv_2_1295 VSS VSS VSS gf180mcu_as_sc_mcu7t3v3__inv_2_1295/A
+ gf180mcu_as_sc_mcu7t3v3__inv_2_1295/VNW VSUBS gf180mcu_as_sc_mcu7t3v3__inv_2
Xgf180mcu_as_sc_mcu7t3v3__inv_2_768 VSS VSS gf180mcu_as_sc_mcu7t3v3__inv_2_833/A gf180mcu_as_sc_mcu7t3v3__inv_2_771/Y
+ gf180mcu_as_sc_mcu7t3v3__inv_2_833/VNW VSUBS gf180mcu_as_sc_mcu7t3v3__inv_2
Xgf180mcu_as_sc_mcu7t3v3__inv_2_757 VSS VSS gf180mcu_as_sc_mcu7t3v3__inv_2_832/A gf180mcu_as_sc_mcu7t3v3__inv_2_760/Y
+ gf180mcu_as_sc_mcu7t3v3__inv_2_832/VNW VSUBS gf180mcu_as_sc_mcu7t3v3__inv_2
Xgf180mcu_as_sc_mcu7t3v3__inv_2_779 VSS VSS gf180mcu_as_sc_mcu7t3v3__inv_2_828/A gf180mcu_as_sc_mcu7t3v3__inv_2_780/Y
+ gf180mcu_as_sc_mcu7t3v3__inv_2_828/VNW VSUBS gf180mcu_as_sc_mcu7t3v3__inv_2
Xgf180mcu_as_sc_mcu7t3v3__inv_2_746 VSS VSS gf180mcu_as_sc_mcu7t3v3__inv_2_746/Y gf180mcu_as_sc_mcu7t3v3__inv_2_746/A
+ gf180mcu_as_sc_mcu7t3v3__inv_2_746/VNW VSUBS gf180mcu_as_sc_mcu7t3v3__inv_2
Xgf180mcu_as_sc_mcu7t3v3__inv_2_724 VSS VSS gf180mcu_as_sc_mcu7t3v3__inv_2_724/Y gf180mcu_as_sc_mcu7t3v3__inv_2_724/A
+ gf180mcu_as_sc_mcu7t3v3__inv_2_724/VNW VSUBS gf180mcu_as_sc_mcu7t3v3__inv_2
Xgf180mcu_as_sc_mcu7t3v3__inv_2_702 VSS VSS VSS gf180mcu_as_sc_mcu7t3v3__inv_2_703/Y
+ gf180mcu_as_sc_mcu7t3v3__inv_2_704/VNW VSUBS gf180mcu_as_sc_mcu7t3v3__inv_2
Xgf180mcu_as_sc_mcu7t3v3__inv_2_713 VSS VSS gf180mcu_as_sc_mcu7t3v3__inv_2_713/Y gf180mcu_as_sc_mcu7t3v3__inv_2_717/Y
+ gf180mcu_as_sc_mcu7t3v3__inv_2_717/VNW VSUBS gf180mcu_as_sc_mcu7t3v3__inv_2
Xgf180mcu_as_sc_mcu7t3v3__inv_2_735 VSS VSS gf180mcu_as_sc_mcu7t3v3__inv_2_735/Y gf180mcu_as_sc_mcu7t3v3__inv_2_736/Y
+ gf180mcu_as_sc_mcu7t3v3__inv_2_736/VNW VSUBS gf180mcu_as_sc_mcu7t3v3__inv_2
Xgf180mcu_as_sc_mcu7t3v3__inv_2_1070 VSS VSS gf180mcu_as_sc_mcu7t3v3__inv_2_1070/Y
+ gf180mcu_as_sc_mcu7t3v3__inv_2_1071/Y gf180mcu_as_sc_mcu7t3v3__inv_2_1071/VNW VSUBS
+ gf180mcu_as_sc_mcu7t3v3__inv_2
Xgf180mcu_as_sc_mcu7t3v3__inv_2_1081 VSS VSS VSS gf180mcu_as_sc_mcu7t3v3__inv_2_1082/Y
+ gf180mcu_as_sc_mcu7t3v3__inv_2_1083/VNW VSUBS gf180mcu_as_sc_mcu7t3v3__inv_2
Xgf180mcu_as_sc_mcu7t3v3__inv_2_1092 VSS VSS gf180mcu_as_sc_mcu7t3v3__inv_2_1092/Y
+ gf180mcu_as_sc_mcu7t3v3__inv_2_1096/Y gf180mcu_as_sc_mcu7t3v3__inv_2_1096/VNW VSUBS
+ gf180mcu_as_sc_mcu7t3v3__inv_2
Xgf180mcu_as_sc_mcu7t3v3__nand4_2_4 VSS VSS VSS VSS VSS VSS gf180mcu_as_sc_mcu7t3v3__inv_2_78/A
+ gf180mcu_as_sc_mcu7t3v3__inv_2_94/VNW VSUBS gf180mcu_as_sc_mcu7t3v3__nand4_2
Xgf180mcu_as_sc_mcu7t3v3__inv_2_510 VSS VSS gf180mcu_as_sc_mcu7t3v3__inv_2_557/A gf180mcu_as_sc_mcu7t3v3__inv_2_511/Y
+ gf180mcu_as_sc_mcu7t3v3__inv_2_557/VNW VSUBS gf180mcu_as_sc_mcu7t3v3__inv_2
Xgf180mcu_as_sc_mcu7t3v3__inv_2_543 VSS VSS VSS gf180mcu_as_sc_mcu7t3v3__inv_2_543/A
+ gf180mcu_as_sc_mcu7t3v3__inv_2_543/VNW VSUBS gf180mcu_as_sc_mcu7t3v3__inv_2
Xgf180mcu_as_sc_mcu7t3v3__inv_2_565 VSS VSS VSS gf180mcu_as_sc_mcu7t3v3__inv_2_566/Y
+ gf180mcu_as_sc_mcu7t3v3__inv_2_567/VNW VSUBS gf180mcu_as_sc_mcu7t3v3__inv_2
Xgf180mcu_as_sc_mcu7t3v3__inv_2_587 VSS VSS gf180mcu_as_sc_mcu7t3v3__inv_2_587/Y gf180mcu_as_sc_mcu7t3v3__inv_2_588/Y
+ gf180mcu_as_sc_mcu7t3v3__inv_2_588/VNW VSUBS gf180mcu_as_sc_mcu7t3v3__inv_2
Xgf180mcu_as_sc_mcu7t3v3__inv_2_576 VSS VSS gf180mcu_as_sc_mcu7t3v3__inv_2_576/Y gf180mcu_as_sc_mcu7t3v3__inv_2_576/A
+ gf180mcu_as_sc_mcu7t3v3__inv_2_576/VNW VSUBS gf180mcu_as_sc_mcu7t3v3__inv_2
Xgf180mcu_as_sc_mcu7t3v3__inv_2_521 gf180mcu_as_sc_mcu7t3v3__nor2_2_6/VDD gf180mcu_as_sc_mcu7t3v3__nand3_2_4/VSS
+ VSS VSS gf180mcu_as_sc_mcu7t3v3__nor2_2_6/VNW VSUBS gf180mcu_as_sc_mcu7t3v3__inv_2
Xgf180mcu_as_sc_mcu7t3v3__inv_2_532 gf180mcu_as_sc_mcu7t3v3__nor2_2_7/VDD gf180mcu_as_sc_mcu7t3v3__nand3_2_4/VSS
+ VSS VSS gf180mcu_as_sc_mcu7t3v3__nor2_2_7/VNW VSUBS gf180mcu_as_sc_mcu7t3v3__inv_2
Xgf180mcu_as_sc_mcu7t3v3__inv_2_554 VSS VSS VSS gf180mcu_as_sc_mcu7t3v3__inv_2_554/A
+ gf180mcu_as_sc_mcu7t3v3__inv_2_554/VNW VSUBS gf180mcu_as_sc_mcu7t3v3__inv_2
Xgf180mcu_as_sc_mcu7t3v3__inv_2_598 VSS VSS gf180mcu_as_sc_mcu7t3v3__inv_2_598/Y gf180mcu_as_sc_mcu7t3v3__inv_2_598/A
+ gf180mcu_as_sc_mcu7t3v3__inv_2_598/VNW VSUBS gf180mcu_as_sc_mcu7t3v3__inv_2
Xgf180mcu_as_sc_mcu7t3v3__inv_2_395 gf180mcu_as_sc_mcu7t3v3__nand3_2_9/VDD gf180mcu_as_sc_mcu7t3v3__nor2_2_7/VSS
+ VSS VSS gf180mcu_as_sc_mcu7t3v3__nand3_2_9/VNW VSUBS gf180mcu_as_sc_mcu7t3v3__inv_2
Xgf180mcu_as_sc_mcu7t3v3__inv_2_384 gf180mcu_as_sc_mcu7t3v3__nand3_2_9/VDD gf180mcu_as_sc_mcu7t3v3__nor2_2_4/VSS
+ VSS VSS gf180mcu_as_sc_mcu7t3v3__nand3_2_9/VNW VSUBS gf180mcu_as_sc_mcu7t3v3__inv_2
Xgf180mcu_as_sc_mcu7t3v3__inv_2_373 gf180mcu_as_sc_mcu7t3v3__nor2_2_7/VDD gf180mcu_as_sc_mcu7t3v3__nor2_2_7/VSS
+ gf180mcu_as_sc_mcu7t3v3__inv_2_373/Y VSS gf180mcu_as_sc_mcu7t3v3__nor2_2_7/VNW VSUBS
+ gf180mcu_as_sc_mcu7t3v3__inv_2
Xgf180mcu_as_sc_mcu7t3v3__inv_2_362 VSS VSS gf180mcu_as_sc_mcu7t3v3__inv_2_362/Y gf180mcu_as_sc_mcu7t3v3__inv_2_362/A
+ gf180mcu_as_sc_mcu7t3v3__inv_2_362/VNW VSUBS gf180mcu_as_sc_mcu7t3v3__inv_2
Xgf180mcu_as_sc_mcu7t3v3__inv_2_351 VSS VSS VSS gf180mcu_as_sc_mcu7t3v3__inv_2_352/Y
+ gf180mcu_as_sc_mcu7t3v3__inv_2_353/VNW VSUBS gf180mcu_as_sc_mcu7t3v3__inv_2
Xgf180mcu_as_sc_mcu7t3v3__inv_2_340 VSS VSS gf180mcu_as_sc_mcu7t3v3__inv_2_340/Y gf180mcu_as_sc_mcu7t3v3__inv_2_341/Y
+ gf180mcu_as_sc_mcu7t3v3__inv_2_341/VNW VSUBS gf180mcu_as_sc_mcu7t3v3__inv_2
Xu_t027_001 u_t027_001/c0_w0_bl u_t027_001/c0_w0_br u_t027_001/c0_w1_bl u_t027_001/c0_w1_br
+ u_t027_001/c0_r0_rbl u_t027_001/c0_r1_rbl u_t027_001/c1_w0_bl u_t027_001/c1_w0_br
+ u_t027_001/c1_w1_bl u_t027_001/c1_w1_br u_t027_001/c1_r0_rbl u_t027_001/c1_r1_rbl
+ u_t027_001/c2_w0_bl u_t027_001/c2_w0_br u_t027_001/c2_w1_bl u_t027_001/c2_w1_br
+ u_t027_001/c2_r0_rbl u_t027_001/c2_r1_rbl u_t027_001/c3_w0_bl u_t027_001/c3_w0_br
+ u_t027_001/c3_w1_bl u_t027_001/c3_w1_br u_t027_001/c3_r0_rbl u_t027_001/c3_r1_rbl
+ u_t027_001/r0_w0_wl u_t027_001/r0_w1_wl u_t027_001/r0_r0_rwl u_t027_001/r0_r1_rwl
+ u_t027_001/r1_w0_wl u_t027_001/r1_w1_wl u_t027_001/r1_r0_rwl u_t027_001/r1_r1_rwl
+ u_t027_001/r2_w0_wl u_t027_001/r2_w1_wl u_t027_001/r2_r0_rwl u_t027_001/r2_r1_rwl
+ u_t027_001/r3_w0_wl u_t027_001/r3_w1_wl u_t027_001/r3_r0_rwl u_t027_001/r3_r1_rwl
+ VSS VSS u_t027_001/m2_717_1265# u_t027_001/m2_603_2031# u_t027_001/m2_1290_336#
+ u_t027_001/m2_2000_2037# u_t027_001/m2_791_2909# u_t027_001/m2_7_2126# u_t027_001/m2_2154_2081#
+ u_t027_001/m2_1795_2037# u_t027_001/m2_871_303# u_t027_001/m2_431_438# u_t027_001/m2_1290_2898#
+ u_t027_001/m2_1714_1210# u_t027_001/m2_431_1982# u_t027_001/m2_512_1265# u_t027_001/m2_2573_2126#
+ u_t027_001/m2_603_1259# u_t027_001/m2_2074_2909# u_t027_001/m2_7_336# u_t027_001/m2_717_2037#
+ u_t027_001/m2_1886_2031# u_t027_001/m2_2573_336# u_t027_001/m2_7_2898# u_t027_001/m2_2000_1265#
+ u_t027_001/m2_512_2037# u_t027_001/m2_1795_1265# u_t027_001/m2_1714_1982# u_t027_001/m2_1886_1259#
+ u_t027_001/m2_1290_2126# u_t027_001/m2_1714_438# u_t027_001/m2_431_1210# u_t027_001/m2_2573_2898#
+ u_t027_001/m2_2154_303# u_t027_001/m2_871_2081# VSUBS detronyx_12t_2w2r_rc4_4x4_routed_5layer_direct
Xu_t027_012 u_t027_012/c0_w0_bl u_t027_012/c0_w0_br u_t027_012/c0_w1_bl u_t027_012/c0_w1_br
+ u_t027_012/c0_r0_rbl u_t027_012/c0_r1_rbl u_t027_012/c1_w0_bl u_t027_012/c1_w0_br
+ u_t027_012/c1_w1_bl u_t027_012/c1_w1_br u_t027_012/c1_r0_rbl u_t027_012/c1_r1_rbl
+ u_t027_012/c2_w0_bl u_t027_012/c2_w0_br u_t027_012/c2_w1_bl u_t027_012/c2_w1_br
+ u_t027_012/c2_r0_rbl u_t027_012/c2_r1_rbl u_t027_012/c3_w0_bl u_t027_012/c3_w0_br
+ u_t027_012/c3_w1_bl u_t027_012/c3_w1_br u_t027_012/c3_r0_rbl u_t027_012/c3_r1_rbl
+ u_t027_012/r0_w0_wl u_t027_012/r0_w1_wl u_t027_012/r0_r0_rwl u_t027_012/r0_r1_rwl
+ u_t027_012/r1_w0_wl u_t027_012/r1_w1_wl u_t027_012/r1_r0_rwl u_t027_012/r1_r1_rwl
+ u_t027_012/r2_w0_wl u_t027_012/r2_w1_wl u_t027_012/r2_r0_rwl u_t027_012/r2_r1_rwl
+ u_t027_012/r3_w0_wl u_t027_012/r3_w1_wl u_t027_012/r3_r0_rwl u_t027_012/r3_r1_rwl
+ VSS VSS u_t027_012/m2_717_1265# u_t027_012/m2_603_2031# u_t027_012/m2_1290_336#
+ u_t027_012/m2_2000_2037# u_t027_012/m2_791_2909# u_t027_012/m2_7_2126# u_t027_012/m2_2154_2081#
+ u_t027_012/m2_1795_2037# u_t027_012/m2_871_303# u_t027_012/m2_431_438# u_t027_012/m2_1290_2898#
+ u_t027_012/m2_1714_1210# u_t027_012/m2_431_1982# u_t027_012/m2_512_1265# u_t027_012/m2_2573_2126#
+ u_t027_012/m2_603_1259# u_t027_012/m2_2074_2909# u_t027_012/m2_7_336# u_t027_012/m2_717_2037#
+ u_t027_012/m2_1886_2031# u_t027_012/m2_2573_336# u_t027_012/m2_7_2898# u_t027_012/m2_2000_1265#
+ u_t027_012/m2_512_2037# u_t027_012/m2_1795_1265# u_t027_012/m2_1714_1982# u_t027_012/m2_1886_1259#
+ u_t027_012/m2_1290_2126# u_t027_012/m2_1714_438# u_t027_012/m2_431_1210# u_t027_012/m2_2573_2898#
+ u_t027_012/m2_2154_303# u_t027_012/m2_871_2081# VSUBS detronyx_12t_2w2r_rc4_4x4_routed_5layer_direct
Xu_t018_012 u_t018_012/c0_w0_bl u_t018_012/c0_w0_br u_t018_012/c0_w1_bl u_t018_012/c0_w1_br
+ u_t018_012/c0_r0_rbl u_t018_012/c0_r1_rbl u_t018_012/c1_w0_bl u_t018_012/c1_w0_br
+ u_t018_012/c1_w1_bl u_t018_012/c1_w1_br u_t018_012/c1_r0_rbl u_t018_012/c1_r1_rbl
+ u_t018_012/c2_w0_bl u_t018_012/c2_w0_br u_t018_012/c2_w1_bl u_t018_012/c2_w1_br
+ u_t018_012/c2_r0_rbl u_t018_012/c2_r1_rbl u_t018_012/c3_w0_bl u_t018_012/c3_w0_br
+ u_t018_012/c3_w1_bl u_t018_012/c3_w1_br u_t018_012/c3_r0_rbl u_t018_012/c3_r1_rbl
+ u_t018_012/r0_w0_wl u_t018_012/r0_w1_wl u_t018_012/r0_r0_rwl u_t018_012/r0_r1_rwl
+ u_t018_012/r1_w0_wl u_t018_012/r1_w1_wl u_t018_012/r1_r0_rwl u_t018_012/r1_r1_rwl
+ u_t018_012/r2_w0_wl u_t018_012/r2_w1_wl u_t018_012/r2_r0_rwl u_t018_012/r2_r1_rwl
+ u_t018_012/r3_w0_wl u_t018_012/r3_w1_wl u_t018_012/r3_r0_rwl u_t018_012/r3_r1_rwl
+ VSS VSS u_t018_012/m2_717_1265# u_t018_012/m2_603_2031# u_t018_012/m2_1290_336#
+ u_t018_012/m2_2000_2037# u_t018_012/m2_791_2909# u_t018_012/m2_7_2126# u_t018_012/m2_2154_2081#
+ u_t018_012/m2_1795_2037# u_t018_012/m2_871_303# u_t018_012/m2_431_438# u_t018_012/m2_1290_2898#
+ u_t018_012/m2_1714_1210# u_t018_012/m2_431_1982# u_t018_012/m2_512_1265# u_t018_012/m2_2573_2126#
+ u_t018_012/m2_603_1259# u_t018_012/m2_2074_2909# u_t018_012/m2_7_336# u_t018_012/m2_717_2037#
+ u_t018_012/m2_1886_2031# u_t018_012/m2_2573_336# u_t018_012/m2_7_2898# u_t018_012/m2_2000_1265#
+ u_t018_012/m2_512_2037# u_t018_012/m2_1795_1265# u_t018_012/m2_1714_1982# u_t018_012/m2_1886_1259#
+ u_t018_012/m2_1290_2126# u_t018_012/m2_1714_438# u_t018_012/m2_431_1210# u_t018_012/m2_2573_2898#
+ u_t018_012/m2_2154_303# u_t018_012/m2_871_2081# VSUBS detronyx_12t_2w2r_rc4_4x4_routed_5layer_direct
Xu_t018_001 u_t018_001/c0_w0_bl u_t018_001/c0_w0_br u_t018_001/c0_w1_bl u_t018_001/c0_w1_br
+ u_t018_001/c0_r0_rbl u_t018_001/c0_r1_rbl u_t018_001/c1_w0_bl u_t018_001/c1_w0_br
+ u_t018_001/c1_w1_bl u_t018_001/c1_w1_br u_t018_001/c1_r0_rbl u_t018_001/c1_r1_rbl
+ u_t018_001/c2_w0_bl u_t018_001/c2_w0_br u_t018_001/c2_w1_bl u_t018_001/c2_w1_br
+ u_t018_001/c2_r0_rbl u_t018_001/c2_r1_rbl u_t018_001/c3_w0_bl u_t018_001/c3_w0_br
+ u_t018_001/c3_w1_bl u_t018_001/c3_w1_br u_t018_001/c3_r0_rbl u_t018_001/c3_r1_rbl
+ u_t018_001/r0_w0_wl u_t018_001/r0_w1_wl u_t018_001/r0_r0_rwl u_t018_001/r0_r1_rwl
+ u_t018_001/r1_w0_wl u_t018_001/r1_w1_wl u_t018_001/r1_r0_rwl u_t018_001/r1_r1_rwl
+ u_t018_001/r2_w0_wl u_t018_001/r2_w1_wl u_t018_001/r2_r0_rwl u_t018_001/r2_r1_rwl
+ u_t018_001/r3_w0_wl u_t018_001/r3_w1_wl u_t018_001/r3_r0_rwl u_t018_001/r3_r1_rwl
+ VSS VSS u_t018_001/m2_717_1265# u_t018_001/m2_603_2031# u_t018_001/m2_1290_336#
+ u_t018_001/m2_2000_2037# u_t018_001/m2_791_2909# u_t018_001/m2_7_2126# u_t018_001/m2_2154_2081#
+ u_t018_001/m2_1795_2037# u_t018_001/m2_871_303# u_t018_001/m2_431_438# u_t018_001/m2_1290_2898#
+ u_t018_001/m2_1714_1210# u_t018_001/m2_431_1982# u_t018_001/m2_512_1265# u_t018_001/m2_2573_2126#
+ u_t018_001/m2_603_1259# u_t018_001/m2_2074_2909# u_t018_001/m2_7_336# u_t018_001/m2_717_2037#
+ u_t018_001/m2_1886_2031# u_t018_001/m2_2573_336# u_t018_001/m2_7_2898# u_t018_001/m2_2000_1265#
+ u_t018_001/m2_512_2037# u_t018_001/m2_1795_1265# u_t018_001/m2_1714_1982# u_t018_001/m2_1886_1259#
+ u_t018_001/m2_1290_2126# u_t018_001/m2_1714_438# u_t018_001/m2_431_1210# u_t018_001/m2_2573_2898#
+ u_t018_001/m2_2154_303# u_t018_001/m2_871_2081# VSUBS detronyx_12t_2w2r_rc4_4x4_routed_5layer_direct
Xu_t009_001 u_t009_001/c0_w0_bl u_t009_001/c0_w0_br u_t009_001/c0_w1_bl u_t009_001/c0_w1_br
+ u_t009_001/c0_r0_rbl u_t009_001/c0_r1_rbl u_t009_001/c1_w0_bl u_t009_001/c1_w0_br
+ u_t009_001/c1_w1_bl u_t009_001/c1_w1_br u_t009_001/c1_r0_rbl u_t009_001/c1_r1_rbl
+ u_t009_001/c2_w0_bl u_t009_001/c2_w0_br u_t009_001/c2_w1_bl u_t009_001/c2_w1_br
+ u_t009_001/c2_r0_rbl u_t009_001/c2_r1_rbl u_t009_001/c3_w0_bl u_t009_001/c3_w0_br
+ u_t009_001/c3_w1_bl u_t009_001/c3_w1_br u_t009_001/c3_r0_rbl u_t009_001/c3_r1_rbl
+ u_t009_001/r0_w0_wl u_t009_001/r0_w1_wl u_t009_001/r0_r0_rwl u_t009_001/r0_r1_rwl
+ u_t009_001/r1_w0_wl u_t009_001/r1_w1_wl u_t009_001/r1_r0_rwl u_t009_001/r1_r1_rwl
+ u_t009_001/r2_w0_wl u_t009_001/r2_w1_wl u_t009_001/r2_r0_rwl u_t009_001/r2_r1_rwl
+ u_t009_001/r3_w0_wl u_t009_001/r3_w1_wl u_t009_001/r3_r0_rwl u_t009_001/r3_r1_rwl
+ VSS VSS u_t009_001/m2_717_1265# u_t009_001/m2_603_2031# u_t009_001/m2_1290_336#
+ u_t009_001/m2_2000_2037# u_t009_001/m2_791_2909# u_t009_001/m2_7_2126# u_t009_001/m2_2154_2081#
+ u_t009_001/m2_1795_2037# u_t009_001/m2_871_303# u_t009_001/m2_431_438# u_t009_001/m2_1290_2898#
+ u_t009_001/m2_1714_1210# u_t009_001/m2_431_1982# u_t009_001/m2_512_1265# u_t009_001/m2_2573_2126#
+ u_t009_001/m2_603_1259# u_t009_001/m2_2074_2909# u_t009_001/m2_7_336# u_t009_001/m2_717_2037#
+ u_t009_001/m2_1886_2031# u_t009_001/m2_2573_336# u_t009_001/m2_7_2898# u_t009_001/m2_2000_1265#
+ u_t009_001/m2_512_2037# u_t009_001/m2_1795_1265# u_t009_001/m2_1714_1982# u_t009_001/m2_1886_1259#
+ u_t009_001/m2_1290_2126# u_t009_001/m2_1714_438# u_t009_001/m2_431_1210# u_t009_001/m2_2573_2898#
+ u_t009_001/m2_2154_303# u_t009_001/m2_871_2081# VSUBS detronyx_12t_2w2r_rc4_4x4_routed_5layer_direct
Xu_t024_015 u_t024_015/c0_w0_bl u_t024_015/c0_w0_br u_t024_015/c0_w1_bl u_t024_015/c0_w1_br
+ u_t024_015/c0_r0_rbl u_t024_015/c0_r1_rbl u_t024_015/c1_w0_bl u_t024_015/c1_w0_br
+ u_t024_015/c1_w1_bl u_t024_015/c1_w1_br u_t024_015/c1_r0_rbl u_t024_015/c1_r1_rbl
+ u_t024_015/c2_w0_bl u_t024_015/c2_w0_br u_t024_015/c2_w1_bl u_t024_015/c2_w1_br
+ u_t024_015/c2_r0_rbl u_t024_015/c2_r1_rbl u_t024_015/c3_w0_bl u_t024_015/c3_w0_br
+ u_t024_015/c3_w1_bl u_t024_015/c3_w1_br u_t024_015/c3_r0_rbl u_t024_015/c3_r1_rbl
+ u_t024_015/r0_w0_wl u_t024_015/r0_w1_wl u_t024_015/r0_r0_rwl u_t024_015/r0_r1_rwl
+ u_t024_015/r1_w0_wl u_t024_015/r1_w1_wl u_t024_015/r1_r0_rwl u_t024_015/r1_r1_rwl
+ u_t024_015/r2_w0_wl u_t024_015/r2_w1_wl u_t024_015/r2_r0_rwl u_t024_015/r2_r1_rwl
+ u_t024_015/r3_w0_wl u_t024_015/r3_w1_wl u_t024_015/r3_r0_rwl u_t024_015/r3_r1_rwl
+ VSS VSS u_t024_015/m2_717_1265# u_t024_015/m2_603_2031# u_t024_015/m2_1290_336#
+ u_t024_015/m2_2000_2037# u_t024_015/m2_791_2909# u_t024_015/m2_7_2126# u_t024_015/m2_2154_2081#
+ u_t024_015/m2_1795_2037# u_t024_015/m2_871_303# u_t024_015/m2_431_438# u_t024_015/m2_1290_2898#
+ u_t024_015/m2_1714_1210# u_t024_015/m2_431_1982# u_t024_015/m2_512_1265# u_t024_015/m2_2573_2126#
+ u_t024_015/m2_603_1259# u_t024_015/m2_2074_2909# u_t024_015/m2_7_336# u_t024_015/m2_717_2037#
+ u_t024_015/m2_1886_2031# u_t024_015/m2_2573_336# u_t024_015/m2_7_2898# u_t024_015/m2_2000_1265#
+ u_t024_015/m2_512_2037# u_t024_015/m2_1795_1265# u_t024_015/m2_1714_1982# u_t024_015/m2_1886_1259#
+ u_t024_015/m2_1290_2126# u_t024_015/m2_1714_438# u_t024_015/m2_431_1210# u_t024_015/m2_2573_2898#
+ u_t024_015/m2_2154_303# u_t024_015/m2_871_2081# VSUBS detronyx_12t_2w2r_rc4_4x4_routed_5layer_direct
Xu_t009_012 u_t009_012/c0_w0_bl u_t009_012/c0_w0_br u_t009_012/c0_w1_bl u_t009_012/c0_w1_br
+ u_t009_012/c0_r0_rbl u_t009_012/c0_r1_rbl u_t009_012/c1_w0_bl u_t009_012/c1_w0_br
+ u_t009_012/c1_w1_bl u_t009_012/c1_w1_br u_t009_012/c1_r0_rbl u_t009_012/c1_r1_rbl
+ u_t009_012/c2_w0_bl u_t009_012/c2_w0_br u_t009_012/c2_w1_bl u_t009_012/c2_w1_br
+ u_t009_012/c2_r0_rbl u_t009_012/c2_r1_rbl u_t009_012/c3_w0_bl u_t009_012/c3_w0_br
+ u_t009_012/c3_w1_bl u_t009_012/c3_w1_br u_t009_012/c3_r0_rbl u_t009_012/c3_r1_rbl
+ u_t009_012/r0_w0_wl u_t009_012/r0_w1_wl u_t009_012/r0_r0_rwl u_t009_012/r0_r1_rwl
+ u_t009_012/r1_w0_wl u_t009_012/r1_w1_wl u_t009_012/r1_r0_rwl u_t009_012/r1_r1_rwl
+ u_t009_012/r2_w0_wl u_t009_012/r2_w1_wl u_t009_012/r2_r0_rwl u_t009_012/r2_r1_rwl
+ u_t009_012/r3_w0_wl u_t009_012/r3_w1_wl u_t009_012/r3_r0_rwl u_t009_012/r3_r1_rwl
+ VSS VSS u_t009_012/m2_717_1265# u_t009_012/m2_603_2031# u_t009_012/m2_1290_336#
+ u_t009_012/m2_2000_2037# u_t009_012/m2_791_2909# u_t009_012/m2_7_2126# u_t009_012/m2_2154_2081#
+ u_t009_012/m2_1795_2037# u_t009_012/m2_871_303# u_t009_012/m2_431_438# u_t009_012/m2_1290_2898#
+ u_t009_012/m2_1714_1210# u_t009_012/m2_431_1982# u_t009_012/m2_512_1265# u_t009_012/m2_2573_2126#
+ u_t009_012/m2_603_1259# u_t009_012/m2_2074_2909# u_t009_012/m2_7_336# u_t009_012/m2_717_2037#
+ u_t009_012/m2_1886_2031# u_t009_012/m2_2573_336# u_t009_012/m2_7_2898# u_t009_012/m2_2000_1265#
+ u_t009_012/m2_512_2037# u_t009_012/m2_1795_1265# u_t009_012/m2_1714_1982# u_t009_012/m2_1886_1259#
+ u_t009_012/m2_1290_2126# u_t009_012/m2_1714_438# u_t009_012/m2_431_1210# u_t009_012/m2_2573_2898#
+ u_t009_012/m2_2154_303# u_t009_012/m2_871_2081# VSUBS detronyx_12t_2w2r_rc4_4x4_routed_5layer_direct
Xu_t024_004 u_t024_004/c0_w0_bl u_t024_004/c0_w0_br u_t024_004/c0_w1_bl u_t024_004/c0_w1_br
+ u_t024_004/c0_r0_rbl u_t024_004/c0_r1_rbl u_t024_004/c1_w0_bl u_t024_004/c1_w0_br
+ u_t024_004/c1_w1_bl u_t024_004/c1_w1_br u_t024_004/c1_r0_rbl u_t024_004/c1_r1_rbl
+ u_t024_004/c2_w0_bl u_t024_004/c2_w0_br u_t024_004/c2_w1_bl u_t024_004/c2_w1_br
+ u_t024_004/c2_r0_rbl u_t024_004/c2_r1_rbl u_t024_004/c3_w0_bl u_t024_004/c3_w0_br
+ u_t024_004/c3_w1_bl u_t024_004/c3_w1_br u_t024_004/c3_r0_rbl u_t024_004/c3_r1_rbl
+ u_t024_004/r0_w0_wl u_t024_004/r0_w1_wl u_t024_004/r0_r0_rwl u_t024_004/r0_r1_rwl
+ u_t024_004/r1_w0_wl u_t024_004/r1_w1_wl u_t024_004/r1_r0_rwl u_t024_004/r1_r1_rwl
+ u_t024_004/r2_w0_wl u_t024_004/r2_w1_wl u_t024_004/r2_r0_rwl u_t024_004/r2_r1_rwl
+ u_t024_004/r3_w0_wl u_t024_004/r3_w1_wl u_t024_004/r3_r0_rwl u_t024_004/r3_r1_rwl
+ VSS VSS u_t024_004/m2_717_1265# u_t024_004/m2_603_2031# u_t024_004/m2_1290_336#
+ u_t024_004/m2_2000_2037# u_t024_004/m2_791_2909# u_t024_004/m2_7_2126# u_t024_004/m2_2154_2081#
+ u_t024_004/m2_1795_2037# u_t024_004/m2_871_303# u_t024_004/m2_431_438# u_t024_004/m2_1290_2898#
+ u_t024_004/m2_1714_1210# u_t024_004/m2_431_1982# u_t024_004/m2_512_1265# u_t024_004/m2_2573_2126#
+ u_t024_004/m2_603_1259# u_t024_004/m2_2074_2909# u_t024_004/m2_7_336# u_t024_004/m2_717_2037#
+ u_t024_004/m2_1886_2031# u_t024_004/m2_2573_336# u_t024_004/m2_7_2898# u_t024_004/m2_2000_1265#
+ u_t024_004/m2_512_2037# u_t024_004/m2_1795_1265# u_t024_004/m2_1714_1982# u_t024_004/m2_1886_1259#
+ u_t024_004/m2_1290_2126# u_t024_004/m2_1714_438# u_t024_004/m2_431_1210# u_t024_004/m2_2573_2898#
+ u_t024_004/m2_2154_303# u_t024_004/m2_871_2081# VSUBS detronyx_12t_2w2r_rc4_4x4_routed_5layer_direct
Xgf180mcu_as_sc_mcu7t3v3__nand3_2_49 gf180mcu_as_sc_mcu7t3v3__nor2_2_9/VDD gf180mcu_as_sc_mcu7t3v3__nand3_2_63/VSS
+ VSS VSS VSS VSS gf180mcu_as_sc_mcu7t3v3__nor2_2_9/VNW VSUBS gf180mcu_as_sc_mcu7t3v3__nand3_2
Xgf180mcu_as_sc_mcu7t3v3__nand3_2_16 gf180mcu_as_sc_mcu7t3v3__nor2_2_6/VDD gf180mcu_as_sc_mcu7t3v3__nand3_2_4/VSS
+ VSS VSS VSS VSS gf180mcu_as_sc_mcu7t3v3__nor2_2_6/VNW VSUBS gf180mcu_as_sc_mcu7t3v3__nand3_2
Xgf180mcu_as_sc_mcu7t3v3__nand3_2_38 gf180mcu_as_sc_mcu7t3v3__nor2_2_7/VDD gf180mcu_as_sc_mcu7t3v3__nand3_2_4/VSS
+ VSS VSS VSS VSS gf180mcu_as_sc_mcu7t3v3__nor2_2_7/VNW VSUBS gf180mcu_as_sc_mcu7t3v3__nand3_2
Xgf180mcu_as_sc_mcu7t3v3__nand3_2_27 gf180mcu_as_sc_mcu7t3v3__nor2_2_7/VDD gf180mcu_as_sc_mcu7t3v3__nand3_2_4/VSS
+ VSS VSS VSS VSS gf180mcu_as_sc_mcu7t3v3__nor2_2_7/VNW VSUBS gf180mcu_as_sc_mcu7t3v3__nand3_2
Xgf180mcu_as_sc_mcu7t3v3__inv_2_170 VSS VSS gf180mcu_as_sc_mcu7t3v3__inv_2_170/Y gf180mcu_as_sc_mcu7t3v3__inv_2_171/Y
+ gf180mcu_as_sc_mcu7t3v3__inv_2_171/VNW VSUBS gf180mcu_as_sc_mcu7t3v3__inv_2
Xgf180mcu_as_sc_mcu7t3v3__inv_2_1636 VSS VSS VSS gf180mcu_as_sc_mcu7t3v3__inv_2_1637/Y
+ gf180mcu_as_sc_mcu7t3v3__inv_2_1638/VNW VSUBS gf180mcu_as_sc_mcu7t3v3__inv_2
Xgf180mcu_as_sc_mcu7t3v3__inv_2_1669 VSS VSS VSS gf180mcu_as_sc_mcu7t3v3__inv_2_1669/A
+ gf180mcu_as_sc_mcu7t3v3__inv_2_1669/VNW VSUBS gf180mcu_as_sc_mcu7t3v3__inv_2
Xgf180mcu_as_sc_mcu7t3v3__inv_2_1614 VSS VSS gf180mcu_as_sc_mcu7t3v3__inv_2_1614/Y
+ gf180mcu_as_sc_mcu7t3v3__inv_2_1614/A gf180mcu_as_sc_mcu7t3v3__inv_2_1614/VNW VSUBS
+ gf180mcu_as_sc_mcu7t3v3__inv_2
Xgf180mcu_as_sc_mcu7t3v3__inv_2_1647 VSS VSS gf180mcu_as_sc_mcu7t3v3__inv_2_1647/Y
+ gf180mcu_as_sc_mcu7t3v3__inv_2_1648/Y gf180mcu_as_sc_mcu7t3v3__inv_2_1648/VNW VSUBS
+ gf180mcu_as_sc_mcu7t3v3__inv_2
Xgf180mcu_as_sc_mcu7t3v3__inv_2_1625 VSS VSS gf180mcu_as_sc_mcu7t3v3__inv_2_1625/Y
+ gf180mcu_as_sc_mcu7t3v3__inv_2_1626/Y gf180mcu_as_sc_mcu7t3v3__inv_2_1626/VNW VSUBS
+ gf180mcu_as_sc_mcu7t3v3__inv_2
Xgf180mcu_as_sc_mcu7t3v3__inv_2_1658 VSS VSS VSS gf180mcu_as_sc_mcu7t3v3__inv_2_1659/Y
+ gf180mcu_as_sc_mcu7t3v3__inv_2_1660/VNW VSUBS gf180mcu_as_sc_mcu7t3v3__inv_2
Xgf180mcu_as_sc_mcu7t3v3__inv_2_1603 VSS VSS gf180mcu_as_sc_mcu7t3v3__inv_2_1691/A
+ gf180mcu_as_sc_mcu7t3v3__inv_2_1603/A gf180mcu_as_sc_mcu7t3v3__inv_2_1691/VNW VSUBS
+ gf180mcu_as_sc_mcu7t3v3__inv_2
Xgf180mcu_as_sc_mcu7t3v3__inv_2_181 VSS VSS VSS gf180mcu_as_sc_mcu7t3v3__inv_2_182/Y
+ gf180mcu_as_sc_mcu7t3v3__inv_2_182/VNW VSUBS gf180mcu_as_sc_mcu7t3v3__inv_2
Xgf180mcu_as_sc_mcu7t3v3__inv_2_192 VSS VSS gf180mcu_as_sc_mcu7t3v3__inv_2_192/Y gf180mcu_as_sc_mcu7t3v3__inv_2_193/Y
+ gf180mcu_as_sc_mcu7t3v3__inv_2_193/VNW VSUBS gf180mcu_as_sc_mcu7t3v3__inv_2
Xu_t015_015 u_t015_015/c0_w0_bl u_t015_015/c0_w0_br u_t015_015/c0_w1_bl u_t015_015/c0_w1_br
+ u_t015_015/c0_r0_rbl u_t015_015/c0_r1_rbl u_t015_015/c1_w0_bl u_t015_015/c1_w0_br
+ u_t015_015/c1_w1_bl u_t015_015/c1_w1_br u_t015_015/c1_r0_rbl u_t015_015/c1_r1_rbl
+ u_t015_015/c2_w0_bl u_t015_015/c2_w0_br u_t015_015/c2_w1_bl u_t015_015/c2_w1_br
+ u_t015_015/c2_r0_rbl u_t015_015/c2_r1_rbl u_t015_015/c3_w0_bl u_t015_015/c3_w0_br
+ u_t015_015/c3_w1_bl u_t015_015/c3_w1_br u_t015_015/c3_r0_rbl u_t015_015/c3_r1_rbl
+ u_t015_015/r0_w0_wl u_t015_015/r0_w1_wl u_t015_015/r0_r0_rwl u_t015_015/r0_r1_rwl
+ u_t015_015/r1_w0_wl u_t015_015/r1_w1_wl u_t015_015/r1_r0_rwl u_t015_015/r1_r1_rwl
+ u_t015_015/r2_w0_wl u_t015_015/r2_w1_wl u_t015_015/r2_r0_rwl u_t015_015/r2_r1_rwl
+ u_t015_015/r3_w0_wl u_t015_015/r3_w1_wl u_t015_015/r3_r0_rwl u_t015_015/r3_r1_rwl
+ VSS VSS u_t015_015/m2_717_1265# u_t015_015/m2_603_2031# u_t015_015/m2_1290_336#
+ u_t015_015/m2_2000_2037# u_t015_015/m2_791_2909# u_t015_015/m2_7_2126# u_t015_015/m2_2154_2081#
+ u_t015_015/m2_1795_2037# u_t015_015/m2_871_303# u_t015_015/m2_431_438# u_t015_015/m2_1290_2898#
+ u_t015_015/m2_1714_1210# u_t015_015/m2_431_1982# u_t015_015/m2_512_1265# u_t015_015/m2_2573_2126#
+ u_t015_015/m2_603_1259# u_t015_015/m2_2074_2909# u_t015_015/m2_7_336# u_t015_015/m2_717_2037#
+ u_t015_015/m2_1886_2031# u_t015_015/m2_2573_336# u_t015_015/m2_7_2898# u_t015_015/m2_2000_1265#
+ u_t015_015/m2_512_2037# u_t015_015/m2_1795_1265# u_t015_015/m2_1714_1982# u_t015_015/m2_1886_1259#
+ u_t015_015/m2_1290_2126# u_t015_015/m2_1714_438# u_t015_015/m2_431_1210# u_t015_015/m2_2573_2898#
+ u_t015_015/m2_2154_303# u_t015_015/m2_871_2081# VSUBS detronyx_12t_2w2r_rc4_4x4_routed_5layer_direct
Xu_t030_007 u_t030_007/c0_w0_bl u_t030_007/c0_w0_br u_t030_007/c0_w1_bl u_t030_007/c0_w1_br
+ u_t030_007/c0_r0_rbl u_t030_007/c0_r1_rbl u_t030_007/c1_w0_bl u_t030_007/c1_w0_br
+ u_t030_007/c1_w1_bl u_t030_007/c1_w1_br u_t030_007/c1_r0_rbl u_t030_007/c1_r1_rbl
+ u_t030_007/c2_w0_bl u_t030_007/c2_w0_br u_t030_007/c2_w1_bl u_t030_007/c2_w1_br
+ u_t030_007/c2_r0_rbl u_t030_007/c2_r1_rbl u_t030_007/c3_w0_bl u_t030_007/c3_w0_br
+ u_t030_007/c3_w1_bl u_t030_007/c3_w1_br u_t030_007/c3_r0_rbl u_t030_007/c3_r1_rbl
+ u_t030_007/r0_w0_wl u_t030_007/r0_w1_wl u_t030_007/r0_r0_rwl u_t030_007/r0_r1_rwl
+ u_t030_007/r1_w0_wl u_t030_007/r1_w1_wl u_t030_007/r1_r0_rwl u_t030_007/r1_r1_rwl
+ u_t030_007/r2_w0_wl u_t030_007/r2_w1_wl u_t030_007/r2_r0_rwl u_t030_007/r2_r1_rwl
+ u_t030_007/r3_w0_wl u_t030_007/r3_w1_wl u_t030_007/r3_r0_rwl u_t030_007/r3_r1_rwl
+ VSS VSS u_t030_007/m2_717_1265# u_t030_007/m2_603_2031# u_t030_007/m2_1290_336#
+ u_t030_007/m2_2000_2037# u_t030_007/m2_791_2909# u_t030_007/m2_7_2126# u_t030_007/m2_2154_2081#
+ u_t030_007/m2_1795_2037# u_t030_007/m2_871_303# u_t030_007/m2_431_438# u_t030_007/m2_1290_2898#
+ u_t030_007/m2_1714_1210# u_t030_007/m2_431_1982# u_t030_007/m2_512_1265# u_t030_007/m2_2573_2126#
+ u_t030_007/m2_603_1259# u_t030_007/m2_2074_2909# u_t030_007/m2_7_336# u_t030_007/m2_717_2037#
+ u_t030_007/m2_1886_2031# u_t030_007/m2_2573_336# u_t030_007/m2_7_2898# u_t030_007/m2_2000_1265#
+ u_t030_007/m2_512_2037# u_t030_007/m2_1795_1265# u_t030_007/m2_1714_1982# u_t030_007/m2_1886_1259#
+ u_t030_007/m2_1290_2126# u_t030_007/m2_1714_438# u_t030_007/m2_431_1210# u_t030_007/m2_2573_2898#
+ u_t030_007/m2_2154_303# u_t030_007/m2_871_2081# VSUBS detronyx_12t_2w2r_rc4_4x4_routed_5layer_direct
Xu_t015_004 u_t015_004/c0_w0_bl u_t015_004/c0_w0_br u_t015_004/c0_w1_bl u_t015_004/c0_w1_br
+ u_t015_004/c0_r0_rbl u_t015_004/c0_r1_rbl u_t015_004/c1_w0_bl u_t015_004/c1_w0_br
+ u_t015_004/c1_w1_bl u_t015_004/c1_w1_br u_t015_004/c1_r0_rbl u_t015_004/c1_r1_rbl
+ u_t015_004/c2_w0_bl u_t015_004/c2_w0_br u_t015_004/c2_w1_bl u_t015_004/c2_w1_br
+ u_t015_004/c2_r0_rbl u_t015_004/c2_r1_rbl u_t015_004/c3_w0_bl u_t015_004/c3_w0_br
+ u_t015_004/c3_w1_bl u_t015_004/c3_w1_br u_t015_004/c3_r0_rbl u_t015_004/c3_r1_rbl
+ u_t015_004/r0_w0_wl u_t015_004/r0_w1_wl u_t015_004/r0_r0_rwl u_t015_004/r0_r1_rwl
+ u_t015_004/r1_w0_wl u_t015_004/r1_w1_wl u_t015_004/r1_r0_rwl u_t015_004/r1_r1_rwl
+ u_t015_004/r2_w0_wl u_t015_004/r2_w1_wl u_t015_004/r2_r0_rwl u_t015_004/r2_r1_rwl
+ u_t015_004/r3_w0_wl u_t015_004/r3_w1_wl u_t015_004/r3_r0_rwl u_t015_004/r3_r1_rwl
+ VSS VSS u_t015_004/m2_717_1265# u_t015_004/m2_603_2031# u_t015_004/m2_1290_336#
+ u_t015_004/m2_2000_2037# u_t015_004/m2_791_2909# u_t015_004/m2_7_2126# u_t015_004/m2_2154_2081#
+ u_t015_004/m2_1795_2037# u_t015_004/m2_871_303# u_t015_004/m2_431_438# u_t015_004/m2_1290_2898#
+ u_t015_004/m2_1714_1210# u_t015_004/m2_431_1982# u_t015_004/m2_512_1265# u_t015_004/m2_2573_2126#
+ u_t015_004/m2_603_1259# u_t015_004/m2_2074_2909# u_t015_004/m2_7_336# u_t015_004/m2_717_2037#
+ u_t015_004/m2_1886_2031# u_t015_004/m2_2573_336# u_t015_004/m2_7_2898# u_t015_004/m2_2000_1265#
+ u_t015_004/m2_512_2037# u_t015_004/m2_1795_1265# u_t015_004/m2_1714_1982# u_t015_004/m2_1886_1259#
+ u_t015_004/m2_1290_2126# u_t015_004/m2_1714_438# u_t015_004/m2_431_1210# u_t015_004/m2_2573_2898#
+ u_t015_004/m2_2154_303# u_t015_004/m2_871_2081# VSUBS detronyx_12t_2w2r_rc4_4x4_routed_5layer_direct
Xgf180mcu_as_sc_mcu7t3v3__nand4_2_419 VSS VSS VSS VSS VSS VSS gf180mcu_as_sc_mcu7t3v3__inv_2_1529/A
+ gf180mcu_as_sc_mcu7t3v3__inv_2_1529/VNW VSUBS gf180mcu_as_sc_mcu7t3v3__nand4_2
Xgf180mcu_as_sc_mcu7t3v3__nand4_2_408 VSS VSS VSS VSS VSS VSS gf180mcu_as_sc_mcu7t3v3__inv_2_1494/A
+ gf180mcu_as_sc_mcu7t3v3__inv_2_1494/VNW VSUBS gf180mcu_as_sc_mcu7t3v3__nand4_2
Xu_t006_015 u_t006_015/c0_w0_bl u_t006_015/c0_w0_br u_t006_015/c0_w1_bl u_t006_015/c0_w1_br
+ u_t006_015/c0_r0_rbl u_t006_015/c0_r1_rbl u_t006_015/c1_w0_bl u_t006_015/c1_w0_br
+ u_t006_015/c1_w1_bl u_t006_015/c1_w1_br u_t006_015/c1_r0_rbl u_t006_015/c1_r1_rbl
+ u_t006_015/c2_w0_bl u_t006_015/c2_w0_br u_t006_015/c2_w1_bl u_t006_015/c2_w1_br
+ u_t006_015/c2_r0_rbl u_t006_015/c2_r1_rbl u_t006_015/c3_w0_bl u_t006_015/c3_w0_br
+ u_t006_015/c3_w1_bl u_t006_015/c3_w1_br u_t006_015/c3_r0_rbl u_t006_015/c3_r1_rbl
+ u_t006_015/r0_w0_wl u_t006_015/r0_w1_wl u_t006_015/r0_r0_rwl u_t006_015/r0_r1_rwl
+ u_t006_015/r1_w0_wl u_t006_015/r1_w1_wl u_t006_015/r1_r0_rwl u_t006_015/r1_r1_rwl
+ u_t006_015/r2_w0_wl u_t006_015/r2_w1_wl u_t006_015/r2_r0_rwl u_t006_015/r2_r1_rwl
+ u_t006_015/r3_w0_wl u_t006_015/r3_w1_wl u_t006_015/r3_r0_rwl u_t006_015/r3_r1_rwl
+ VSS VSS u_t006_015/m2_717_1265# u_t006_015/m2_603_2031# u_t006_015/m2_1290_336#
+ u_t006_015/m2_2000_2037# u_t006_015/m2_791_2909# u_t006_015/m2_7_2126# u_t006_015/m2_2154_2081#
+ u_t006_015/m2_1795_2037# u_t006_015/m2_871_303# u_t006_015/m2_431_438# u_t006_015/m2_1290_2898#
+ u_t006_015/m2_1714_1210# u_t006_015/m2_431_1982# u_t006_015/m2_512_1265# u_t006_015/m2_2573_2126#
+ u_t006_015/m2_603_1259# u_t006_015/m2_2074_2909# u_t006_015/m2_7_336# u_t006_015/m2_717_2037#
+ u_t006_015/m2_1886_2031# u_t006_015/m2_2573_336# u_t006_015/m2_7_2898# u_t006_015/m2_2000_1265#
+ u_t006_015/m2_512_2037# u_t006_015/m2_1795_1265# u_t006_015/m2_1714_1982# u_t006_015/m2_1886_1259#
+ u_t006_015/m2_1290_2126# u_t006_015/m2_1714_438# u_t006_015/m2_431_1210# u_t006_015/m2_2573_2898#
+ u_t006_015/m2_2154_303# u_t006_015/m2_871_2081# VSUBS detronyx_12t_2w2r_rc4_4x4_routed_5layer_direct
Xu_t006_004 u_t006_004/c0_w0_bl u_t006_004/c0_w0_br u_t006_004/c0_w1_bl u_t006_004/c0_w1_br
+ u_t006_004/c0_r0_rbl u_t006_004/c0_r1_rbl u_t006_004/c1_w0_bl u_t006_004/c1_w0_br
+ u_t006_004/c1_w1_bl u_t006_004/c1_w1_br u_t006_004/c1_r0_rbl u_t006_004/c1_r1_rbl
+ u_t006_004/c2_w0_bl u_t006_004/c2_w0_br u_t006_004/c2_w1_bl u_t006_004/c2_w1_br
+ u_t006_004/c2_r0_rbl u_t006_004/c2_r1_rbl u_t006_004/c3_w0_bl u_t006_004/c3_w0_br
+ u_t006_004/c3_w1_bl u_t006_004/c3_w1_br u_t006_004/c3_r0_rbl u_t006_004/c3_r1_rbl
+ u_t006_004/r0_w0_wl u_t006_004/r0_w1_wl u_t006_004/r0_r0_rwl u_t006_004/r0_r1_rwl
+ u_t006_004/r1_w0_wl u_t006_004/r1_w1_wl u_t006_004/r1_r0_rwl u_t006_004/r1_r1_rwl
+ u_t006_004/r2_w0_wl u_t006_004/r2_w1_wl u_t006_004/r2_r0_rwl u_t006_004/r2_r1_rwl
+ u_t006_004/r3_w0_wl u_t006_004/r3_w1_wl u_t006_004/r3_r0_rwl u_t006_004/r3_r1_rwl
+ VSS VSS u_t006_004/m2_717_1265# u_t006_004/m2_603_2031# u_t006_004/m2_1290_336#
+ u_t006_004/m2_2000_2037# u_t006_004/m2_791_2909# u_t006_004/m2_7_2126# u_t006_004/m2_2154_2081#
+ u_t006_004/m2_1795_2037# u_t006_004/m2_871_303# u_t006_004/m2_431_438# u_t006_004/m2_1290_2898#
+ u_t006_004/m2_1714_1210# u_t006_004/m2_431_1982# u_t006_004/m2_512_1265# u_t006_004/m2_2573_2126#
+ u_t006_004/m2_603_1259# u_t006_004/m2_2074_2909# u_t006_004/m2_7_336# u_t006_004/m2_717_2037#
+ u_t006_004/m2_1886_2031# u_t006_004/m2_2573_336# u_t006_004/m2_7_2898# u_t006_004/m2_2000_1265#
+ u_t006_004/m2_512_2037# u_t006_004/m2_1795_1265# u_t006_004/m2_1714_1982# u_t006_004/m2_1886_1259#
+ u_t006_004/m2_1290_2126# u_t006_004/m2_1714_438# u_t006_004/m2_431_1210# u_t006_004/m2_2573_2898#
+ u_t006_004/m2_2154_303# u_t006_004/m2_871_2081# VSUBS detronyx_12t_2w2r_rc4_4x4_routed_5layer_direct
Xgf180mcu_as_sc_mcu7t3v3__inv_2_9 VSS VSS gf180mcu_as_sc_mcu7t3v3__inv_2_9/Y gf180mcu_as_sc_mcu7t3v3__inv_2_9/A
+ gf180mcu_as_sc_mcu7t3v3__inv_2_9/VNW VSUBS gf180mcu_as_sc_mcu7t3v3__inv_2
Xu_t021_007 u_t021_007/c0_w0_bl u_t021_007/c0_w0_br u_t021_007/c0_w1_bl u_t021_007/c0_w1_br
+ u_t021_007/c0_r0_rbl u_t021_007/c0_r1_rbl u_t021_007/c1_w0_bl u_t021_007/c1_w0_br
+ u_t021_007/c1_w1_bl u_t021_007/c1_w1_br u_t021_007/c1_r0_rbl u_t021_007/c1_r1_rbl
+ u_t021_007/c2_w0_bl u_t021_007/c2_w0_br u_t021_007/c2_w1_bl u_t021_007/c2_w1_br
+ u_t021_007/c2_r0_rbl u_t021_007/c2_r1_rbl u_t021_007/c3_w0_bl u_t021_007/c3_w0_br
+ u_t021_007/c3_w1_bl u_t021_007/c3_w1_br u_t021_007/c3_r0_rbl u_t021_007/c3_r1_rbl
+ u_t021_007/r0_w0_wl u_t021_007/r0_w1_wl u_t021_007/r0_r0_rwl u_t021_007/r0_r1_rwl
+ u_t021_007/r1_w0_wl u_t021_007/r1_w1_wl u_t021_007/r1_r0_rwl u_t021_007/r1_r1_rwl
+ u_t021_007/r2_w0_wl u_t021_007/r2_w1_wl u_t021_007/r2_r0_rwl u_t021_007/r2_r1_rwl
+ u_t021_007/r3_w0_wl u_t021_007/r3_w1_wl u_t021_007/r3_r0_rwl u_t021_007/r3_r1_rwl
+ VSS VSS u_t021_007/m2_717_1265# u_t021_007/m2_603_2031# u_t021_007/m2_1290_336#
+ u_t021_007/m2_2000_2037# u_t021_007/m2_791_2909# u_t021_007/m2_7_2126# u_t021_007/m2_2154_2081#
+ u_t021_007/m2_1795_2037# u_t021_007/m2_871_303# u_t021_007/m2_431_438# u_t021_007/m2_1290_2898#
+ u_t021_007/m2_1714_1210# u_t021_007/m2_431_1982# u_t021_007/m2_512_1265# u_t021_007/m2_2573_2126#
+ u_t021_007/m2_603_1259# u_t021_007/m2_2074_2909# u_t021_007/m2_7_336# u_t021_007/m2_717_2037#
+ u_t021_007/m2_1886_2031# u_t021_007/m2_2573_336# u_t021_007/m2_7_2898# u_t021_007/m2_2000_1265#
+ u_t021_007/m2_512_2037# u_t021_007/m2_1795_1265# u_t021_007/m2_1714_1982# u_t021_007/m2_1886_1259#
+ u_t021_007/m2_1290_2126# u_t021_007/m2_1714_438# u_t021_007/m2_431_1210# u_t021_007/m2_2573_2898#
+ u_t021_007/m2_2154_303# u_t021_007/m2_871_2081# VSUBS detronyx_12t_2w2r_rc4_4x4_routed_5layer_direct
Xu_t012_007 u_t012_007/c0_w0_bl u_t012_007/c0_w0_br u_t012_007/c0_w1_bl u_t012_007/c0_w1_br
+ u_t012_007/c0_r0_rbl u_t012_007/c0_r1_rbl u_t012_007/c1_w0_bl u_t012_007/c1_w0_br
+ u_t012_007/c1_w1_bl u_t012_007/c1_w1_br u_t012_007/c1_r0_rbl u_t012_007/c1_r1_rbl
+ u_t012_007/c2_w0_bl u_t012_007/c2_w0_br u_t012_007/c2_w1_bl u_t012_007/c2_w1_br
+ u_t012_007/c2_r0_rbl u_t012_007/c2_r1_rbl u_t012_007/c3_w0_bl u_t012_007/c3_w0_br
+ u_t012_007/c3_w1_bl u_t012_007/c3_w1_br u_t012_007/c3_r0_rbl u_t012_007/c3_r1_rbl
+ u_t012_007/r0_w0_wl u_t012_007/r0_w1_wl u_t012_007/r0_r0_rwl u_t012_007/r0_r1_rwl
+ u_t012_007/r1_w0_wl u_t012_007/r1_w1_wl u_t012_007/r1_r0_rwl u_t012_007/r1_r1_rwl
+ u_t012_007/r2_w0_wl u_t012_007/r2_w1_wl u_t012_007/r2_r0_rwl u_t012_007/r2_r1_rwl
+ u_t012_007/r3_w0_wl u_t012_007/r3_w1_wl u_t012_007/r3_r0_rwl u_t012_007/r3_r1_rwl
+ VSS VSS u_t012_007/m2_717_1265# u_t012_007/m2_603_2031# u_t012_007/m2_1290_336#
+ u_t012_007/m2_2000_2037# u_t012_007/m2_791_2909# u_t012_007/m2_7_2126# u_t012_007/m2_2154_2081#
+ u_t012_007/m2_1795_2037# u_t012_007/m2_871_303# u_t012_007/m2_431_438# u_t012_007/m2_1290_2898#
+ u_t012_007/m2_1714_1210# u_t012_007/m2_431_1982# u_t012_007/m2_512_1265# u_t012_007/m2_2573_2126#
+ u_t012_007/m2_603_1259# u_t012_007/m2_2074_2909# u_t012_007/m2_7_336# u_t012_007/m2_717_2037#
+ u_t012_007/m2_1886_2031# u_t012_007/m2_2573_336# u_t012_007/m2_7_2898# u_t012_007/m2_2000_1265#
+ u_t012_007/m2_512_2037# u_t012_007/m2_1795_1265# u_t012_007/m2_1714_1982# u_t012_007/m2_1886_1259#
+ u_t012_007/m2_1290_2126# u_t012_007/m2_1714_438# u_t012_007/m2_431_1210# u_t012_007/m2_2573_2898#
+ u_t012_007/m2_2154_303# u_t012_007/m2_871_2081# VSUBS detronyx_12t_2w2r_rc4_4x4_routed_5layer_direct
Xgf180mcu_as_sc_mcu7t3v3__inv_2_1466 VSS VSS gf180mcu_as_sc_mcu7t3v3__inv_2_1466/Y
+ gf180mcu_as_sc_mcu7t3v3__inv_2_1467/Y gf180mcu_as_sc_mcu7t3v3__inv_2_1467/VNW VSUBS
+ gf180mcu_as_sc_mcu7t3v3__inv_2
Xgf180mcu_as_sc_mcu7t3v3__inv_2_1400 VSS VSS VSS gf180mcu_as_sc_mcu7t3v3__inv_2_1401/Y
+ gf180mcu_as_sc_mcu7t3v3__inv_2_1402/VNW VSUBS gf180mcu_as_sc_mcu7t3v3__inv_2
Xgf180mcu_as_sc_mcu7t3v3__inv_2_1488 VSS VSS gf180mcu_as_sc_mcu7t3v3__inv_2_1488/Y
+ gf180mcu_as_sc_mcu7t3v3__inv_2_1488/A gf180mcu_as_sc_mcu7t3v3__inv_2_1488/VNW VSUBS
+ gf180mcu_as_sc_mcu7t3v3__inv_2
Xgf180mcu_as_sc_mcu7t3v3__inv_2_1499 VSS VSS gf180mcu_as_sc_mcu7t3v3__inv_2_1499/Y
+ gf180mcu_as_sc_mcu7t3v3__inv_2_1500/Y gf180mcu_as_sc_mcu7t3v3__inv_2_1500/VNW VSUBS
+ gf180mcu_as_sc_mcu7t3v3__inv_2
Xgf180mcu_as_sc_mcu7t3v3__inv_2_1477 VSS VSS gf180mcu_as_sc_mcu7t3v3__inv_2_1508/A
+ gf180mcu_as_sc_mcu7t3v3__inv_2_1477/A gf180mcu_as_sc_mcu7t3v3__inv_2_1508/VNW VSUBS
+ gf180mcu_as_sc_mcu7t3v3__inv_2
Xgf180mcu_as_sc_mcu7t3v3__inv_2_1422 VSS VSS gf180mcu_as_sc_mcu7t3v3__inv_2_1422/Y
+ gf180mcu_as_sc_mcu7t3v3__inv_2_1422/A gf180mcu_as_sc_mcu7t3v3__inv_2_1422/VNW VSUBS
+ gf180mcu_as_sc_mcu7t3v3__inv_2
Xgf180mcu_as_sc_mcu7t3v3__inv_2_1411 VSS VSS VSS gf180mcu_as_sc_mcu7t3v3__inv_2_1412/Y
+ gf180mcu_as_sc_mcu7t3v3__inv_2_1413/VNW VSUBS gf180mcu_as_sc_mcu7t3v3__inv_2
Xgf180mcu_as_sc_mcu7t3v3__inv_2_1455 VSS VSS gf180mcu_as_sc_mcu7t3v3__inv_2_1455/Y
+ gf180mcu_as_sc_mcu7t3v3__inv_2_1455/A gf180mcu_as_sc_mcu7t3v3__inv_2_1455/VNW VSUBS
+ gf180mcu_as_sc_mcu7t3v3__inv_2
Xgf180mcu_as_sc_mcu7t3v3__inv_2_1444 VSS VSS VSS gf180mcu_as_sc_mcu7t3v3__inv_2_1445/Y
+ gf180mcu_as_sc_mcu7t3v3__inv_2_1446/VNW VSUBS gf180mcu_as_sc_mcu7t3v3__inv_2
Xgf180mcu_as_sc_mcu7t3v3__inv_2_1433 VSS VSS gf180mcu_as_sc_mcu7t3v3__inv_2_1433/Y
+ gf180mcu_as_sc_mcu7t3v3__inv_2_1434/Y gf180mcu_as_sc_mcu7t3v3__inv_2_1434/VNW VSUBS
+ gf180mcu_as_sc_mcu7t3v3__inv_2
Xgf180mcu_as_sc_mcu7t3v3__inv_2_917 VSS VSS gf180mcu_as_sc_mcu7t3v3__inv_2_917/Y gf180mcu_as_sc_mcu7t3v3__inv_2_917/A
+ gf180mcu_as_sc_mcu7t3v3__inv_2_946/VNW VSUBS gf180mcu_as_sc_mcu7t3v3__inv_2
Xgf180mcu_as_sc_mcu7t3v3__inv_2_906 VSS VSS gf180mcu_as_sc_mcu7t3v3__inv_2_906/Y gf180mcu_as_sc_mcu7t3v3__inv_2_906/A
+ gf180mcu_as_sc_mcu7t3v3__inv_2_952/VNW VSUBS gf180mcu_as_sc_mcu7t3v3__inv_2
Xgf180mcu_as_sc_mcu7t3v3__inv_2_939 VSS VSS VSS gf180mcu_as_sc_mcu7t3v3__inv_2_939/A
+ gf180mcu_as_sc_mcu7t3v3__inv_2_939/VNW VSUBS gf180mcu_as_sc_mcu7t3v3__inv_2
Xgf180mcu_as_sc_mcu7t3v3__inv_2_928 VSS VSS VSS gf180mcu_as_sc_mcu7t3v3__inv_2_928/A
+ gf180mcu_as_sc_mcu7t3v3__inv_2_928/VNW VSUBS gf180mcu_as_sc_mcu7t3v3__inv_2
Xu_t003_007 u_t003_007/c0_w0_bl u_t003_007/c0_w0_br u_t003_007/c0_w1_bl u_t003_007/c0_w1_br
+ u_t003_007/c0_r0_rbl u_t003_007/c0_r1_rbl u_t003_007/c1_w0_bl u_t003_007/c1_w0_br
+ u_t003_007/c1_w1_bl u_t003_007/c1_w1_br u_t003_007/c1_r0_rbl u_t003_007/c1_r1_rbl
+ u_t003_007/c2_w0_bl u_t003_007/c2_w0_br u_t003_007/c2_w1_bl u_t003_007/c2_w1_br
+ u_t003_007/c2_r0_rbl u_t003_007/c2_r1_rbl u_t003_007/c3_w0_bl u_t003_007/c3_w0_br
+ u_t003_007/c3_w1_bl u_t003_007/c3_w1_br u_t003_007/c3_r0_rbl u_t003_007/c3_r1_rbl
+ u_t003_007/r0_w0_wl u_t003_007/r0_w1_wl u_t003_007/r0_r0_rwl u_t003_007/r0_r1_rwl
+ u_t003_007/r1_w0_wl u_t003_007/r1_w1_wl u_t003_007/r1_r0_rwl u_t003_007/r1_r1_rwl
+ u_t003_007/r2_w0_wl u_t003_007/r2_w1_wl u_t003_007/r2_r0_rwl u_t003_007/r2_r1_rwl
+ u_t003_007/r3_w0_wl u_t003_007/r3_w1_wl u_t003_007/r3_r0_rwl u_t003_007/r3_r1_rwl
+ VSS VSS u_t003_007/m2_717_1265# u_t003_007/m2_603_2031# u_t003_007/m2_1290_336#
+ u_t003_007/m2_2000_2037# u_t003_007/m2_791_2909# u_t003_007/m2_7_2126# u_t003_007/m2_2154_2081#
+ u_t003_007/m2_1795_2037# u_t003_007/m2_871_303# u_t003_007/m2_431_438# u_t003_007/m2_1290_2898#
+ u_t003_007/m2_1714_1210# u_t003_007/m2_431_1982# u_t003_007/m2_512_1265# u_t003_007/m2_2573_2126#
+ u_t003_007/m2_603_1259# u_t003_007/m2_2074_2909# u_t003_007/m2_7_336# u_t003_007/m2_717_2037#
+ u_t003_007/m2_1886_2031# u_t003_007/m2_2573_336# u_t003_007/m2_7_2898# u_t003_007/m2_2000_1265#
+ u_t003_007/m2_512_2037# u_t003_007/m2_1795_1265# u_t003_007/m2_1714_1982# u_t003_007/m2_1886_1259#
+ u_t003_007/m2_1290_2126# u_t003_007/m2_1714_438# u_t003_007/m2_431_1210# u_t003_007/m2_2573_2898#
+ u_t003_007/m2_2154_303# u_t003_007/m2_871_2081# VSUBS detronyx_12t_2w2r_rc4_4x4_routed_5layer_direct
Xgf180mcu_as_sc_mcu7t3v3__nand4_2_249 VSS VSS VSS VSS VSS VSS gf180mcu_as_sc_mcu7t3v3__inv_2_857/A
+ gf180mcu_as_sc_mcu7t3v3__inv_2_857/VNW VSUBS gf180mcu_as_sc_mcu7t3v3__nand4_2
Xgf180mcu_as_sc_mcu7t3v3__nand4_2_227 VSS VSS VSS VSS VSS VSS gf180mcu_as_sc_mcu7t3v3__inv_2_775/A
+ gf180mcu_as_sc_mcu7t3v3__inv_2_826/VNW VSUBS gf180mcu_as_sc_mcu7t3v3__nand4_2
Xgf180mcu_as_sc_mcu7t3v3__nand4_2_205 VSS VSS VSS VSS VSS VSS gf180mcu_as_sc_mcu7t3v3__inv_2_660/A
+ gf180mcu_as_sc_mcu7t3v3__inv_2_660/VNW VSUBS gf180mcu_as_sc_mcu7t3v3__nand4_2
Xgf180mcu_as_sc_mcu7t3v3__nand4_2_216 VSS VSS VSS VSS VSS VSS gf180mcu_as_sc_mcu7t3v3__inv_2_751/A
+ gf180mcu_as_sc_mcu7t3v3__inv_2_830/VNW VSUBS gf180mcu_as_sc_mcu7t3v3__nand4_2
Xgf180mcu_as_sc_mcu7t3v3__nand4_2_238 VSS VSS VSS VSS VSS VSS gf180mcu_as_sc_mcu7t3v3__inv_2_795/A
+ gf180mcu_as_sc_mcu7t3v3__inv_2_845/VNW VSUBS gf180mcu_as_sc_mcu7t3v3__nand4_2
Xgf180mcu_as_sc_mcu7t3v3__inv_2_1230 gf180mcu_as_sc_mcu7t3v3__nor2_2_9/VDD gf180mcu_as_sc_mcu7t3v3__nand3_2_63/VSS
+ VSS VSS gf180mcu_as_sc_mcu7t3v3__nor2_2_9/VNW VSUBS gf180mcu_as_sc_mcu7t3v3__inv_2
Xgf180mcu_as_sc_mcu7t3v3__inv_2_1252 gf180mcu_as_sc_mcu7t3v3__nand3_2_65/VDD gf180mcu_as_sc_mcu7t3v3__nor2_2_9/VSS
+ VSS VSS gf180mcu_as_sc_mcu7t3v3__nand3_2_65/VNW VSUBS gf180mcu_as_sc_mcu7t3v3__inv_2
Xgf180mcu_as_sc_mcu7t3v3__inv_2_1241 gf180mcu_as_sc_mcu7t3v3__nand3_2_65/VDD gf180mcu_as_sc_mcu7t3v3__nand3_2_62/VSS
+ VSS VSS gf180mcu_as_sc_mcu7t3v3__nand3_2_65/VNW VSUBS gf180mcu_as_sc_mcu7t3v3__inv_2
Xgf180mcu_as_sc_mcu7t3v3__inv_2_1274 VSS VSS VSS gf180mcu_as_sc_mcu7t3v3__inv_2_1274/A
+ gf180mcu_as_sc_mcu7t3v3__inv_2_1274/VNW VSUBS gf180mcu_as_sc_mcu7t3v3__inv_2
Xgf180mcu_as_sc_mcu7t3v3__inv_2_1285 VSS VSS gf180mcu_as_sc_mcu7t3v3__inv_2_1285/Y
+ gf180mcu_as_sc_mcu7t3v3__inv_2_1286/Y gf180mcu_as_sc_mcu7t3v3__inv_2_1286/VNW VSUBS
+ gf180mcu_as_sc_mcu7t3v3__inv_2
Xgf180mcu_as_sc_mcu7t3v3__inv_2_1263 VSS VSS VSS gf180mcu_as_sc_mcu7t3v3__inv_2_1263/A
+ gf180mcu_as_sc_mcu7t3v3__inv_2_1263/VNW VSUBS gf180mcu_as_sc_mcu7t3v3__inv_2
Xgf180mcu_as_sc_mcu7t3v3__inv_2_1296 VSS VSS VSS gf180mcu_as_sc_mcu7t3v3__inv_2_1296/A
+ gf180mcu_as_sc_mcu7t3v3__inv_2_1296/VNW VSUBS gf180mcu_as_sc_mcu7t3v3__inv_2
Xgf180mcu_as_sc_mcu7t3v3__inv_2_769 VSS VSS gf180mcu_as_sc_mcu7t3v3__inv_2_824/A gf180mcu_as_sc_mcu7t3v3__inv_2_770/Y
+ gf180mcu_as_sc_mcu7t3v3__inv_2_824/VNW VSUBS gf180mcu_as_sc_mcu7t3v3__inv_2
Xgf180mcu_as_sc_mcu7t3v3__inv_2_758 VSS VSS gf180mcu_as_sc_mcu7t3v3__inv_2_820/A gf180mcu_as_sc_mcu7t3v3__inv_2_759/Y
+ gf180mcu_as_sc_mcu7t3v3__inv_2_820/VNW VSUBS gf180mcu_as_sc_mcu7t3v3__inv_2
Xgf180mcu_as_sc_mcu7t3v3__inv_2_747 VSS VSS gf180mcu_as_sc_mcu7t3v3__inv_2_778/A gf180mcu_as_sc_mcu7t3v3__inv_2_747/A
+ gf180mcu_as_sc_mcu7t3v3__inv_2_834/VNW VSUBS gf180mcu_as_sc_mcu7t3v3__inv_2
Xgf180mcu_as_sc_mcu7t3v3__inv_2_714 VSS VSS VSS gf180mcu_as_sc_mcu7t3v3__inv_2_715/Y
+ gf180mcu_as_sc_mcu7t3v3__inv_2_716/VNW VSUBS gf180mcu_as_sc_mcu7t3v3__inv_2
Xgf180mcu_as_sc_mcu7t3v3__inv_2_703 VSS VSS gf180mcu_as_sc_mcu7t3v3__inv_2_703/Y gf180mcu_as_sc_mcu7t3v3__inv_2_704/Y
+ gf180mcu_as_sc_mcu7t3v3__inv_2_704/VNW VSUBS gf180mcu_as_sc_mcu7t3v3__inv_2
Xgf180mcu_as_sc_mcu7t3v3__inv_2_725 VSS VSS VSS gf180mcu_as_sc_mcu7t3v3__inv_2_729/Y
+ gf180mcu_as_sc_mcu7t3v3__inv_2_731/VNW VSUBS gf180mcu_as_sc_mcu7t3v3__inv_2
Xgf180mcu_as_sc_mcu7t3v3__inv_2_736 VSS VSS gf180mcu_as_sc_mcu7t3v3__inv_2_736/Y gf180mcu_as_sc_mcu7t3v3__inv_2_736/A
+ gf180mcu_as_sc_mcu7t3v3__inv_2_736/VNW VSUBS gf180mcu_as_sc_mcu7t3v3__inv_2
Xgf180mcu_as_sc_mcu7t3v3__inv_2_1071 VSS VSS gf180mcu_as_sc_mcu7t3v3__inv_2_1071/Y
+ gf180mcu_as_sc_mcu7t3v3__inv_2_1071/A gf180mcu_as_sc_mcu7t3v3__inv_2_1071/VNW VSUBS
+ gf180mcu_as_sc_mcu7t3v3__inv_2
Xgf180mcu_as_sc_mcu7t3v3__inv_2_90 VSS VSS gf180mcu_as_sc_mcu7t3v3__inv_2_90/Y gf180mcu_as_sc_mcu7t3v3__inv_2_90/A
+ gf180mcu_as_sc_mcu7t3v3__inv_2_90/VNW VSUBS gf180mcu_as_sc_mcu7t3v3__inv_2
Xgf180mcu_as_sc_mcu7t3v3__inv_2_1060 VSS VSS gf180mcu_as_sc_mcu7t3v3__inv_2_1060/Y
+ gf180mcu_as_sc_mcu7t3v3__inv_2_1061/Y gf180mcu_as_sc_mcu7t3v3__inv_2_1061/VNW VSUBS
+ gf180mcu_as_sc_mcu7t3v3__inv_2
Xgf180mcu_as_sc_mcu7t3v3__inv_2_1082 VSS VSS gf180mcu_as_sc_mcu7t3v3__inv_2_1082/Y
+ gf180mcu_as_sc_mcu7t3v3__inv_2_1083/Y gf180mcu_as_sc_mcu7t3v3__inv_2_1083/VNW VSUBS
+ gf180mcu_as_sc_mcu7t3v3__inv_2
Xgf180mcu_as_sc_mcu7t3v3__inv_2_1093 VSS VSS VSS gf180mcu_as_sc_mcu7t3v3__inv_2_1094/Y
+ gf180mcu_as_sc_mcu7t3v3__inv_2_1095/VNW VSUBS gf180mcu_as_sc_mcu7t3v3__inv_2
Xgf180mcu_as_sc_mcu7t3v3__inv_2_511 VSS VSS gf180mcu_as_sc_mcu7t3v3__inv_2_511/Y gf180mcu_as_sc_mcu7t3v3__inv_2_511/A
+ gf180mcu_as_sc_mcu7t3v3__inv_2_557/VNW VSUBS gf180mcu_as_sc_mcu7t3v3__inv_2
Xgf180mcu_as_sc_mcu7t3v3__nand4_2_5 VSS VSS VSS VSS VSS VSS gf180mcu_as_sc_mcu7t3v3__inv_2_92/A
+ gf180mcu_as_sc_mcu7t3v3__inv_2_92/VNW VSUBS gf180mcu_as_sc_mcu7t3v3__nand4_2
Xgf180mcu_as_sc_mcu7t3v3__inv_2_500 VSS VSS gf180mcu_as_sc_mcu7t3v3__inv_2_556/A gf180mcu_as_sc_mcu7t3v3__inv_2_503/Y
+ gf180mcu_as_sc_mcu7t3v3__inv_2_556/VNW VSUBS gf180mcu_as_sc_mcu7t3v3__inv_2
Xgf180mcu_as_sc_mcu7t3v3__inv_2_566 VSS VSS gf180mcu_as_sc_mcu7t3v3__inv_2_566/Y gf180mcu_as_sc_mcu7t3v3__inv_2_567/Y
+ gf180mcu_as_sc_mcu7t3v3__inv_2_567/VNW VSUBS gf180mcu_as_sc_mcu7t3v3__inv_2
Xgf180mcu_as_sc_mcu7t3v3__inv_2_588 VSS VSS gf180mcu_as_sc_mcu7t3v3__inv_2_588/Y gf180mcu_as_sc_mcu7t3v3__inv_2_588/A
+ gf180mcu_as_sc_mcu7t3v3__inv_2_588/VNW VSUBS gf180mcu_as_sc_mcu7t3v3__inv_2
Xgf180mcu_as_sc_mcu7t3v3__inv_2_544 VSS VSS VSS gf180mcu_as_sc_mcu7t3v3__inv_2_544/A
+ gf180mcu_as_sc_mcu7t3v3__inv_2_544/VNW VSUBS gf180mcu_as_sc_mcu7t3v3__inv_2
Xgf180mcu_as_sc_mcu7t3v3__inv_2_577 VSS VSS VSS gf180mcu_as_sc_mcu7t3v3__inv_2_578/Y
+ gf180mcu_as_sc_mcu7t3v3__inv_2_579/VNW VSUBS gf180mcu_as_sc_mcu7t3v3__inv_2
Xgf180mcu_as_sc_mcu7t3v3__inv_2_522 gf180mcu_as_sc_mcu7t3v3__nor2_2_7/VDD gf180mcu_as_sc_mcu7t3v3__nand3_2_4/VSS
+ VSS VSS gf180mcu_as_sc_mcu7t3v3__nor2_2_7/VNW VSUBS gf180mcu_as_sc_mcu7t3v3__inv_2
Xgf180mcu_as_sc_mcu7t3v3__inv_2_533 gf180mcu_as_sc_mcu7t3v3__nor2_2_7/VDD gf180mcu_as_sc_mcu7t3v3__nor2_2_7/VSS
+ VSS VSS gf180mcu_as_sc_mcu7t3v3__nor2_2_7/VNW VSUBS gf180mcu_as_sc_mcu7t3v3__inv_2
Xgf180mcu_as_sc_mcu7t3v3__inv_2_599 VSS VSS gf180mcu_as_sc_mcu7t3v3__inv_2_599/Y gf180mcu_as_sc_mcu7t3v3__inv_2_603/Y
+ gf180mcu_as_sc_mcu7t3v3__inv_2_603/VNW VSUBS gf180mcu_as_sc_mcu7t3v3__inv_2
Xgf180mcu_as_sc_mcu7t3v3__inv_2_555 VSS VSS VSS gf180mcu_as_sc_mcu7t3v3__inv_2_555/A
+ gf180mcu_as_sc_mcu7t3v3__inv_2_555/VNW VSUBS gf180mcu_as_sc_mcu7t3v3__inv_2
Xgf180mcu_as_sc_mcu7t3v3__inv_2_352 VSS VSS gf180mcu_as_sc_mcu7t3v3__inv_2_352/Y gf180mcu_as_sc_mcu7t3v3__inv_2_353/Y
+ gf180mcu_as_sc_mcu7t3v3__inv_2_353/VNW VSUBS gf180mcu_as_sc_mcu7t3v3__inv_2
Xgf180mcu_as_sc_mcu7t3v3__inv_2_341 VSS VSS gf180mcu_as_sc_mcu7t3v3__inv_2_341/Y gf180mcu_as_sc_mcu7t3v3__inv_2_341/A
+ gf180mcu_as_sc_mcu7t3v3__inv_2_341/VNW VSUBS gf180mcu_as_sc_mcu7t3v3__inv_2
Xgf180mcu_as_sc_mcu7t3v3__inv_2_330 VSS VSS VSS gf180mcu_as_sc_mcu7t3v3__inv_2_331/Y
+ gf180mcu_as_sc_mcu7t3v3__inv_2_332/VNW VSUBS gf180mcu_as_sc_mcu7t3v3__inv_2
Xgf180mcu_as_sc_mcu7t3v3__inv_2_396 gf180mcu_as_sc_mcu7t3v3__nand3_2_9/VDD gf180mcu_as_sc_mcu7t3v3__nor2_2_4/VSS
+ VSS VSS gf180mcu_as_sc_mcu7t3v3__nand3_2_9/VNW VSUBS gf180mcu_as_sc_mcu7t3v3__inv_2
Xgf180mcu_as_sc_mcu7t3v3__inv_2_385 gf180mcu_as_sc_mcu7t3v3__nor2_2_4/VDD gf180mcu_as_sc_mcu7t3v3__nor2_2_4/VSS
+ VSS VSS gf180mcu_as_sc_mcu7t3v3__nor2_2_4/VNW VSUBS gf180mcu_as_sc_mcu7t3v3__inv_2
Xgf180mcu_as_sc_mcu7t3v3__inv_2_374 gf180mcu_as_sc_mcu7t3v3__nand3_2_9/VDD gf180mcu_as_sc_mcu7t3v3__nor2_2_7/VSS
+ gf180mcu_as_sc_mcu7t3v3__inv_2_374/Y VSS gf180mcu_as_sc_mcu7t3v3__nand3_2_9/VNW
+ VSUBS gf180mcu_as_sc_mcu7t3v3__inv_2
Xgf180mcu_as_sc_mcu7t3v3__inv_2_363 VSS VSS VSS gf180mcu_as_sc_mcu7t3v3__inv_2_364/Y
+ gf180mcu_as_sc_mcu7t3v3__inv_2_365/VNW VSUBS gf180mcu_as_sc_mcu7t3v3__inv_2
Xu_t027_013 u_t027_013/c0_w0_bl u_t027_013/c0_w0_br u_t027_013/c0_w1_bl u_t027_013/c0_w1_br
+ u_t027_013/c0_r0_rbl u_t027_013/c0_r1_rbl u_t027_013/c1_w0_bl u_t027_013/c1_w0_br
+ u_t027_013/c1_w1_bl u_t027_013/c1_w1_br u_t027_013/c1_r0_rbl u_t027_013/c1_r1_rbl
+ u_t027_013/c2_w0_bl u_t027_013/c2_w0_br u_t027_013/c2_w1_bl u_t027_013/c2_w1_br
+ u_t027_013/c2_r0_rbl u_t027_013/c2_r1_rbl u_t027_013/c3_w0_bl u_t027_013/c3_w0_br
+ u_t027_013/c3_w1_bl u_t027_013/c3_w1_br u_t027_013/c3_r0_rbl u_t027_013/c3_r1_rbl
+ u_t027_013/r0_w0_wl u_t027_013/r0_w1_wl u_t027_013/r0_r0_rwl u_t027_013/r0_r1_rwl
+ u_t027_013/r1_w0_wl u_t027_013/r1_w1_wl u_t027_013/r1_r0_rwl u_t027_013/r1_r1_rwl
+ u_t027_013/r2_w0_wl u_t027_013/r2_w1_wl u_t027_013/r2_r0_rwl u_t027_013/r2_r1_rwl
+ u_t027_013/r3_w0_wl u_t027_013/r3_w1_wl u_t027_013/r3_r0_rwl u_t027_013/r3_r1_rwl
+ VSS VSS u_t027_013/m2_717_1265# u_t027_013/m2_603_2031# u_t027_013/m2_1290_336#
+ u_t027_013/m2_2000_2037# u_t027_013/m2_791_2909# u_t027_013/m2_7_2126# u_t027_013/m2_2154_2081#
+ u_t027_013/m2_1795_2037# u_t027_013/m2_871_303# u_t027_013/m2_431_438# u_t027_013/m2_1290_2898#
+ u_t027_013/m2_1714_1210# u_t027_013/m2_431_1982# u_t027_013/m2_512_1265# u_t027_013/m2_2573_2126#
+ u_t027_013/m2_603_1259# u_t027_013/m2_2074_2909# u_t027_013/m2_7_336# u_t027_013/m2_717_2037#
+ u_t027_013/m2_1886_2031# u_t027_013/m2_2573_336# u_t027_013/m2_7_2898# u_t027_013/m2_2000_1265#
+ u_t027_013/m2_512_2037# u_t027_013/m2_1795_1265# u_t027_013/m2_1714_1982# u_t027_013/m2_1886_1259#
+ u_t027_013/m2_1290_2126# u_t027_013/m2_1714_438# u_t027_013/m2_431_1210# u_t027_013/m2_2573_2898#
+ u_t027_013/m2_2154_303# u_t027_013/m2_871_2081# VSUBS detronyx_12t_2w2r_rc4_4x4_routed_5layer_direct
Xu_t027_002 u_t027_002/c0_w0_bl u_t027_002/c0_w0_br u_t027_002/c0_w1_bl u_t027_002/c0_w1_br
+ u_t027_002/c0_r0_rbl u_t027_002/c0_r1_rbl u_t027_002/c1_w0_bl u_t027_002/c1_w0_br
+ u_t027_002/c1_w1_bl u_t027_002/c1_w1_br u_t027_002/c1_r0_rbl u_t027_002/c1_r1_rbl
+ u_t027_002/c2_w0_bl u_t027_002/c2_w0_br u_t027_002/c2_w1_bl u_t027_002/c2_w1_br
+ u_t027_002/c2_r0_rbl u_t027_002/c2_r1_rbl u_t027_002/c3_w0_bl u_t027_002/c3_w0_br
+ u_t027_002/c3_w1_bl u_t027_002/c3_w1_br u_t027_002/c3_r0_rbl u_t027_002/c3_r1_rbl
+ u_t027_002/r0_w0_wl u_t027_002/r0_w1_wl u_t027_002/r0_r0_rwl u_t027_002/r0_r1_rwl
+ u_t027_002/r1_w0_wl u_t027_002/r1_w1_wl u_t027_002/r1_r0_rwl u_t027_002/r1_r1_rwl
+ u_t027_002/r2_w0_wl u_t027_002/r2_w1_wl u_t027_002/r2_r0_rwl u_t027_002/r2_r1_rwl
+ u_t027_002/r3_w0_wl u_t027_002/r3_w1_wl u_t027_002/r3_r0_rwl u_t027_002/r3_r1_rwl
+ VSS VSS u_t027_002/m2_717_1265# u_t027_002/m2_603_2031# u_t027_002/m2_1290_336#
+ u_t027_002/m2_2000_2037# u_t027_002/m2_791_2909# u_t027_002/m2_7_2126# u_t027_002/m2_2154_2081#
+ u_t027_002/m2_1795_2037# u_t027_002/m2_871_303# u_t027_002/m2_431_438# u_t027_002/m2_1290_2898#
+ u_t027_002/m2_1714_1210# u_t027_002/m2_431_1982# u_t027_002/m2_512_1265# u_t027_002/m2_2573_2126#
+ u_t027_002/m2_603_1259# u_t027_002/m2_2074_2909# u_t027_002/m2_7_336# u_t027_002/m2_717_2037#
+ u_t027_002/m2_1886_2031# u_t027_002/m2_2573_336# u_t027_002/m2_7_2898# u_t027_002/m2_2000_1265#
+ u_t027_002/m2_512_2037# u_t027_002/m2_1795_1265# u_t027_002/m2_1714_1982# u_t027_002/m2_1886_1259#
+ u_t027_002/m2_1290_2126# u_t027_002/m2_1714_438# u_t027_002/m2_431_1210# u_t027_002/m2_2573_2898#
+ u_t027_002/m2_2154_303# u_t027_002/m2_871_2081# VSUBS detronyx_12t_2w2r_rc4_4x4_routed_5layer_direct
Xu_t018_013 u_t018_013/c0_w0_bl u_t018_013/c0_w0_br u_t018_013/c0_w1_bl u_t018_013/c0_w1_br
+ u_t018_013/c0_r0_rbl u_t018_013/c0_r1_rbl u_t018_013/c1_w0_bl u_t018_013/c1_w0_br
+ u_t018_013/c1_w1_bl u_t018_013/c1_w1_br u_t018_013/c1_r0_rbl u_t018_013/c1_r1_rbl
+ u_t018_013/c2_w0_bl u_t018_013/c2_w0_br u_t018_013/c2_w1_bl u_t018_013/c2_w1_br
+ u_t018_013/c2_r0_rbl u_t018_013/c2_r1_rbl u_t018_013/c3_w0_bl u_t018_013/c3_w0_br
+ u_t018_013/c3_w1_bl u_t018_013/c3_w1_br u_t018_013/c3_r0_rbl u_t018_013/c3_r1_rbl
+ u_t018_013/r0_w0_wl u_t018_013/r0_w1_wl u_t018_013/r0_r0_rwl u_t018_013/r0_r1_rwl
+ u_t018_013/r1_w0_wl u_t018_013/r1_w1_wl u_t018_013/r1_r0_rwl u_t018_013/r1_r1_rwl
+ u_t018_013/r2_w0_wl u_t018_013/r2_w1_wl u_t018_013/r2_r0_rwl u_t018_013/r2_r1_rwl
+ u_t018_013/r3_w0_wl u_t018_013/r3_w1_wl u_t018_013/r3_r0_rwl u_t018_013/r3_r1_rwl
+ VSS VSS u_t018_013/m2_717_1265# u_t018_013/m2_603_2031# u_t018_013/m2_1290_336#
+ u_t018_013/m2_2000_2037# u_t018_013/m2_791_2909# u_t018_013/m2_7_2126# u_t018_013/m2_2154_2081#
+ u_t018_013/m2_1795_2037# u_t018_013/m2_871_303# u_t018_013/m2_431_438# u_t018_013/m2_1290_2898#
+ u_t018_013/m2_1714_1210# u_t018_013/m2_431_1982# u_t018_013/m2_512_1265# u_t018_013/m2_2573_2126#
+ u_t018_013/m2_603_1259# u_t018_013/m2_2074_2909# u_t018_013/m2_7_336# u_t018_013/m2_717_2037#
+ u_t018_013/m2_1886_2031# u_t018_013/m2_2573_336# u_t018_013/m2_7_2898# u_t018_013/m2_2000_1265#
+ u_t018_013/m2_512_2037# u_t018_013/m2_1795_1265# u_t018_013/m2_1714_1982# u_t018_013/m2_1886_1259#
+ u_t018_013/m2_1290_2126# u_t018_013/m2_1714_438# u_t018_013/m2_431_1210# u_t018_013/m2_2573_2898#
+ u_t018_013/m2_2154_303# u_t018_013/m2_871_2081# VSUBS detronyx_12t_2w2r_rc4_4x4_routed_5layer_direct
Xu_t018_002 u_t018_002/c0_w0_bl u_t018_002/c0_w0_br u_t018_002/c0_w1_bl u_t018_002/c0_w1_br
+ u_t018_002/c0_r0_rbl u_t018_002/c0_r1_rbl u_t018_002/c1_w0_bl u_t018_002/c1_w0_br
+ u_t018_002/c1_w1_bl u_t018_002/c1_w1_br u_t018_002/c1_r0_rbl u_t018_002/c1_r1_rbl
+ u_t018_002/c2_w0_bl u_t018_002/c2_w0_br u_t018_002/c2_w1_bl u_t018_002/c2_w1_br
+ u_t018_002/c2_r0_rbl u_t018_002/c2_r1_rbl u_t018_002/c3_w0_bl u_t018_002/c3_w0_br
+ u_t018_002/c3_w1_bl u_t018_002/c3_w1_br u_t018_002/c3_r0_rbl u_t018_002/c3_r1_rbl
+ u_t018_002/r0_w0_wl u_t018_002/r0_w1_wl u_t018_002/r0_r0_rwl u_t018_002/r0_r1_rwl
+ u_t018_002/r1_w0_wl u_t018_002/r1_w1_wl u_t018_002/r1_r0_rwl u_t018_002/r1_r1_rwl
+ u_t018_002/r2_w0_wl u_t018_002/r2_w1_wl u_t018_002/r2_r0_rwl u_t018_002/r2_r1_rwl
+ u_t018_002/r3_w0_wl u_t018_002/r3_w1_wl u_t018_002/r3_r0_rwl u_t018_002/r3_r1_rwl
+ VSS VSS u_t018_002/m2_717_1265# u_t018_002/m2_603_2031# u_t018_002/m2_1290_336#
+ u_t018_002/m2_2000_2037# u_t018_002/m2_791_2909# u_t018_002/m2_7_2126# u_t018_002/m2_2154_2081#
+ u_t018_002/m2_1795_2037# u_t018_002/m2_871_303# u_t018_002/m2_431_438# u_t018_002/m2_1290_2898#
+ u_t018_002/m2_1714_1210# u_t018_002/m2_431_1982# u_t018_002/m2_512_1265# u_t018_002/m2_2573_2126#
+ u_t018_002/m2_603_1259# u_t018_002/m2_2074_2909# u_t018_002/m2_7_336# u_t018_002/m2_717_2037#
+ u_t018_002/m2_1886_2031# u_t018_002/m2_2573_336# u_t018_002/m2_7_2898# u_t018_002/m2_2000_1265#
+ u_t018_002/m2_512_2037# u_t018_002/m2_1795_1265# u_t018_002/m2_1714_1982# u_t018_002/m2_1886_1259#
+ u_t018_002/m2_1290_2126# u_t018_002/m2_1714_438# u_t018_002/m2_431_1210# u_t018_002/m2_2573_2898#
+ u_t018_002/m2_2154_303# u_t018_002/m2_871_2081# VSUBS detronyx_12t_2w2r_rc4_4x4_routed_5layer_direct
Xu_t009_013 u_t009_013/c0_w0_bl u_t009_013/c0_w0_br u_t009_013/c0_w1_bl u_t009_013/c0_w1_br
+ u_t009_013/c0_r0_rbl u_t009_013/c0_r1_rbl u_t009_013/c1_w0_bl u_t009_013/c1_w0_br
+ u_t009_013/c1_w1_bl u_t009_013/c1_w1_br u_t009_013/c1_r0_rbl u_t009_013/c1_r1_rbl
+ u_t009_013/c2_w0_bl u_t009_013/c2_w0_br u_t009_013/c2_w1_bl u_t009_013/c2_w1_br
+ u_t009_013/c2_r0_rbl u_t009_013/c2_r1_rbl u_t009_013/c3_w0_bl u_t009_013/c3_w0_br
+ u_t009_013/c3_w1_bl u_t009_013/c3_w1_br u_t009_013/c3_r0_rbl u_t009_013/c3_r1_rbl
+ u_t009_013/r0_w0_wl u_t009_013/r0_w1_wl u_t009_013/r0_r0_rwl u_t009_013/r0_r1_rwl
+ u_t009_013/r1_w0_wl u_t009_013/r1_w1_wl u_t009_013/r1_r0_rwl u_t009_013/r1_r1_rwl
+ u_t009_013/r2_w0_wl u_t009_013/r2_w1_wl u_t009_013/r2_r0_rwl u_t009_013/r2_r1_rwl
+ u_t009_013/r3_w0_wl u_t009_013/r3_w1_wl u_t009_013/r3_r0_rwl u_t009_013/r3_r1_rwl
+ VSS VSS u_t009_013/m2_717_1265# u_t009_013/m2_603_2031# u_t009_013/m2_1290_336#
+ u_t009_013/m2_2000_2037# u_t009_013/m2_791_2909# u_t009_013/m2_7_2126# u_t009_013/m2_2154_2081#
+ u_t009_013/m2_1795_2037# u_t009_013/m2_871_303# u_t009_013/m2_431_438# u_t009_013/m2_1290_2898#
+ u_t009_013/m2_1714_1210# u_t009_013/m2_431_1982# u_t009_013/m2_512_1265# u_t009_013/m2_2573_2126#
+ u_t009_013/m2_603_1259# u_t009_013/m2_2074_2909# u_t009_013/m2_7_336# u_t009_013/m2_717_2037#
+ u_t009_013/m2_1886_2031# u_t009_013/m2_2573_336# u_t009_013/m2_7_2898# u_t009_013/m2_2000_1265#
+ u_t009_013/m2_512_2037# u_t009_013/m2_1795_1265# u_t009_013/m2_1714_1982# u_t009_013/m2_1886_1259#
+ u_t009_013/m2_1290_2126# u_t009_013/m2_1714_438# u_t009_013/m2_431_1210# u_t009_013/m2_2573_2898#
+ u_t009_013/m2_2154_303# u_t009_013/m2_871_2081# VSUBS detronyx_12t_2w2r_rc4_4x4_routed_5layer_direct
Xu_t009_002 u_t009_002/c0_w0_bl u_t009_002/c0_w0_br u_t009_002/c0_w1_bl u_t009_002/c0_w1_br
+ u_t009_002/c0_r0_rbl u_t009_002/c0_r1_rbl u_t009_002/c1_w0_bl u_t009_002/c1_w0_br
+ u_t009_002/c1_w1_bl u_t009_002/c1_w1_br u_t009_002/c1_r0_rbl u_t009_002/c1_r1_rbl
+ u_t009_002/c2_w0_bl u_t009_002/c2_w0_br u_t009_002/c2_w1_bl u_t009_002/c2_w1_br
+ u_t009_002/c2_r0_rbl u_t009_002/c2_r1_rbl u_t009_002/c3_w0_bl u_t009_002/c3_w0_br
+ u_t009_002/c3_w1_bl u_t009_002/c3_w1_br u_t009_002/c3_r0_rbl u_t009_002/c3_r1_rbl
+ u_t009_002/r0_w0_wl u_t009_002/r0_w1_wl u_t009_002/r0_r0_rwl u_t009_002/r0_r1_rwl
+ u_t009_002/r1_w0_wl u_t009_002/r1_w1_wl u_t009_002/r1_r0_rwl u_t009_002/r1_r1_rwl
+ u_t009_002/r2_w0_wl u_t009_002/r2_w1_wl u_t009_002/r2_r0_rwl u_t009_002/r2_r1_rwl
+ u_t009_002/r3_w0_wl u_t009_002/r3_w1_wl u_t009_002/r3_r0_rwl u_t009_002/r3_r1_rwl
+ VSS VSS u_t009_002/m2_717_1265# u_t009_002/m2_603_2031# u_t009_002/m2_1290_336#
+ u_t009_002/m2_2000_2037# u_t009_002/m2_791_2909# u_t009_002/m2_7_2126# u_t009_002/m2_2154_2081#
+ u_t009_002/m2_1795_2037# u_t009_002/m2_871_303# u_t009_002/m2_431_438# u_t009_002/m2_1290_2898#
+ u_t009_002/m2_1714_1210# u_t009_002/m2_431_1982# u_t009_002/m2_512_1265# u_t009_002/m2_2573_2126#
+ u_t009_002/m2_603_1259# u_t009_002/m2_2074_2909# u_t009_002/m2_7_336# u_t009_002/m2_717_2037#
+ u_t009_002/m2_1886_2031# u_t009_002/m2_2573_336# u_t009_002/m2_7_2898# u_t009_002/m2_2000_1265#
+ u_t009_002/m2_512_2037# u_t009_002/m2_1795_1265# u_t009_002/m2_1714_1982# u_t009_002/m2_1886_1259#
+ u_t009_002/m2_1290_2126# u_t009_002/m2_1714_438# u_t009_002/m2_431_1210# u_t009_002/m2_2573_2898#
+ u_t009_002/m2_2154_303# u_t009_002/m2_871_2081# VSUBS detronyx_12t_2w2r_rc4_4x4_routed_5layer_direct
Xgf180mcu_as_sc_mcu7t3v3__nand3_2_17 gf180mcu_as_sc_mcu7t3v3__nor2_2_6/VDD gf180mcu_as_sc_mcu7t3v3__nor2_2_6/VSS
+ VSS VSS VSS VSS gf180mcu_as_sc_mcu7t3v3__nor2_2_6/VNW VSUBS gf180mcu_as_sc_mcu7t3v3__nand3_2
Xgf180mcu_as_sc_mcu7t3v3__nand3_2_28 gf180mcu_as_sc_mcu7t3v3__nor2_2_7/VDD gf180mcu_as_sc_mcu7t3v3__nor2_2_7/VSS
+ VSS VSS VSS VSS gf180mcu_as_sc_mcu7t3v3__nor2_2_7/VNW VSUBS gf180mcu_as_sc_mcu7t3v3__nand3_2
Xu_t024_005 u_t024_005/c0_w0_bl u_t024_005/c0_w0_br u_t024_005/c0_w1_bl u_t024_005/c0_w1_br
+ u_t024_005/c0_r0_rbl u_t024_005/c0_r1_rbl u_t024_005/c1_w0_bl u_t024_005/c1_w0_br
+ u_t024_005/c1_w1_bl u_t024_005/c1_w1_br u_t024_005/c1_r0_rbl u_t024_005/c1_r1_rbl
+ u_t024_005/c2_w0_bl u_t024_005/c2_w0_br u_t024_005/c2_w1_bl u_t024_005/c2_w1_br
+ u_t024_005/c2_r0_rbl u_t024_005/c2_r1_rbl u_t024_005/c3_w0_bl u_t024_005/c3_w0_br
+ u_t024_005/c3_w1_bl u_t024_005/c3_w1_br u_t024_005/c3_r0_rbl u_t024_005/c3_r1_rbl
+ u_t024_005/r0_w0_wl u_t024_005/r0_w1_wl u_t024_005/r0_r0_rwl u_t024_005/r0_r1_rwl
+ u_t024_005/r1_w0_wl u_t024_005/r1_w1_wl u_t024_005/r1_r0_rwl u_t024_005/r1_r1_rwl
+ u_t024_005/r2_w0_wl u_t024_005/r2_w1_wl u_t024_005/r2_r0_rwl u_t024_005/r2_r1_rwl
+ u_t024_005/r3_w0_wl u_t024_005/r3_w1_wl u_t024_005/r3_r0_rwl u_t024_005/r3_r1_rwl
+ VSS VSS u_t024_005/m2_717_1265# u_t024_005/m2_603_2031# u_t024_005/m2_1290_336#
+ u_t024_005/m2_2000_2037# u_t024_005/m2_791_2909# u_t024_005/m2_7_2126# u_t024_005/m2_2154_2081#
+ u_t024_005/m2_1795_2037# u_t024_005/m2_871_303# u_t024_005/m2_431_438# u_t024_005/m2_1290_2898#
+ u_t024_005/m2_1714_1210# u_t024_005/m2_431_1982# u_t024_005/m2_512_1265# u_t024_005/m2_2573_2126#
+ u_t024_005/m2_603_1259# u_t024_005/m2_2074_2909# u_t024_005/m2_7_336# u_t024_005/m2_717_2037#
+ u_t024_005/m2_1886_2031# u_t024_005/m2_2573_336# u_t024_005/m2_7_2898# u_t024_005/m2_2000_1265#
+ u_t024_005/m2_512_2037# u_t024_005/m2_1795_1265# u_t024_005/m2_1714_1982# u_t024_005/m2_1886_1259#
+ u_t024_005/m2_1290_2126# u_t024_005/m2_1714_438# u_t024_005/m2_431_1210# u_t024_005/m2_2573_2898#
+ u_t024_005/m2_2154_303# u_t024_005/m2_871_2081# VSUBS detronyx_12t_2w2r_rc4_4x4_routed_5layer_direct
Xgf180mcu_as_sc_mcu7t3v3__nand3_2_39 gf180mcu_as_sc_mcu7t3v3__nor2_2_7/VDD gf180mcu_as_sc_mcu7t3v3__nor2_2_7/VSS
+ VSS VSS VSS VSS gf180mcu_as_sc_mcu7t3v3__nor2_2_7/VNW VSUBS gf180mcu_as_sc_mcu7t3v3__nand3_2
Xgf180mcu_as_sc_mcu7t3v3__inv_2_182 VSS VSS gf180mcu_as_sc_mcu7t3v3__inv_2_182/Y gf180mcu_as_sc_mcu7t3v3__inv_2_182/A
+ gf180mcu_as_sc_mcu7t3v3__inv_2_182/VNW VSUBS gf180mcu_as_sc_mcu7t3v3__inv_2
Xgf180mcu_as_sc_mcu7t3v3__inv_2_171 VSS VSS gf180mcu_as_sc_mcu7t3v3__inv_2_171/Y gf180mcu_as_sc_mcu7t3v3__inv_2_171/A
+ gf180mcu_as_sc_mcu7t3v3__inv_2_171/VNW VSUBS gf180mcu_as_sc_mcu7t3v3__inv_2
Xgf180mcu_as_sc_mcu7t3v3__inv_2_193 VSS VSS gf180mcu_as_sc_mcu7t3v3__inv_2_193/Y gf180mcu_as_sc_mcu7t3v3__inv_2_193/A
+ gf180mcu_as_sc_mcu7t3v3__inv_2_193/VNW VSUBS gf180mcu_as_sc_mcu7t3v3__inv_2
Xgf180mcu_as_sc_mcu7t3v3__inv_2_160 VSS VSS gf180mcu_as_sc_mcu7t3v3__inv_2_160/Y gf180mcu_as_sc_mcu7t3v3__inv_2_160/A
+ gf180mcu_as_sc_mcu7t3v3__inv_2_160/VNW VSUBS gf180mcu_as_sc_mcu7t3v3__inv_2
Xgf180mcu_as_sc_mcu7t3v3__inv_2_1637 VSS VSS gf180mcu_as_sc_mcu7t3v3__inv_2_1637/Y
+ gf180mcu_as_sc_mcu7t3v3__inv_2_1638/Y gf180mcu_as_sc_mcu7t3v3__inv_2_1638/VNW VSUBS
+ gf180mcu_as_sc_mcu7t3v3__inv_2
Xgf180mcu_as_sc_mcu7t3v3__inv_2_1615 VSS VSS gf180mcu_as_sc_mcu7t3v3__inv_2_1685/A
+ gf180mcu_as_sc_mcu7t3v3__inv_2_1628/Y gf180mcu_as_sc_mcu7t3v3__inv_2_1685/VNW VSUBS
+ gf180mcu_as_sc_mcu7t3v3__inv_2
Xgf180mcu_as_sc_mcu7t3v3__inv_2_1604 VSS VSS VSS gf180mcu_as_sc_mcu7t3v3__inv_2_1605/Y
+ gf180mcu_as_sc_mcu7t3v3__inv_2_1606/VNW VSUBS gf180mcu_as_sc_mcu7t3v3__inv_2
Xgf180mcu_as_sc_mcu7t3v3__inv_2_1648 VSS VSS gf180mcu_as_sc_mcu7t3v3__inv_2_1648/Y
+ gf180mcu_as_sc_mcu7t3v3__inv_2_1648/A gf180mcu_as_sc_mcu7t3v3__inv_2_1648/VNW VSUBS
+ gf180mcu_as_sc_mcu7t3v3__inv_2
Xgf180mcu_as_sc_mcu7t3v3__inv_2_1626 VSS VSS gf180mcu_as_sc_mcu7t3v3__inv_2_1626/Y
+ gf180mcu_as_sc_mcu7t3v3__inv_2_1626/A gf180mcu_as_sc_mcu7t3v3__inv_2_1626/VNW VSUBS
+ gf180mcu_as_sc_mcu7t3v3__inv_2
Xgf180mcu_as_sc_mcu7t3v3__inv_2_1659 VSS VSS gf180mcu_as_sc_mcu7t3v3__inv_2_1659/Y
+ gf180mcu_as_sc_mcu7t3v3__inv_2_1660/Y gf180mcu_as_sc_mcu7t3v3__inv_2_1660/VNW VSUBS
+ gf180mcu_as_sc_mcu7t3v3__inv_2
Xu_t015_005 u_t015_005/c0_w0_bl u_t015_005/c0_w0_br u_t015_005/c0_w1_bl u_t015_005/c0_w1_br
+ u_t015_005/c0_r0_rbl u_t015_005/c0_r1_rbl u_t015_005/c1_w0_bl u_t015_005/c1_w0_br
+ u_t015_005/c1_w1_bl u_t015_005/c1_w1_br u_t015_005/c1_r0_rbl u_t015_005/c1_r1_rbl
+ u_t015_005/c2_w0_bl u_t015_005/c2_w0_br u_t015_005/c2_w1_bl u_t015_005/c2_w1_br
+ u_t015_005/c2_r0_rbl u_t015_005/c2_r1_rbl u_t015_005/c3_w0_bl u_t015_005/c3_w0_br
+ u_t015_005/c3_w1_bl u_t015_005/c3_w1_br u_t015_005/c3_r0_rbl u_t015_005/c3_r1_rbl
+ u_t015_005/r0_w0_wl u_t015_005/r0_w1_wl u_t015_005/r0_r0_rwl u_t015_005/r0_r1_rwl
+ u_t015_005/r1_w0_wl u_t015_005/r1_w1_wl u_t015_005/r1_r0_rwl u_t015_005/r1_r1_rwl
+ u_t015_005/r2_w0_wl u_t015_005/r2_w1_wl u_t015_005/r2_r0_rwl u_t015_005/r2_r1_rwl
+ u_t015_005/r3_w0_wl u_t015_005/r3_w1_wl u_t015_005/r3_r0_rwl u_t015_005/r3_r1_rwl
+ VSS VSS u_t015_005/m2_717_1265# u_t015_005/m2_603_2031# u_t015_005/m2_1290_336#
+ u_t015_005/m2_2000_2037# u_t015_005/m2_791_2909# u_t015_005/m2_7_2126# u_t015_005/m2_2154_2081#
+ u_t015_005/m2_1795_2037# u_t015_005/m2_871_303# u_t015_005/m2_431_438# u_t015_005/m2_1290_2898#
+ u_t015_005/m2_1714_1210# u_t015_005/m2_431_1982# u_t015_005/m2_512_1265# u_t015_005/m2_2573_2126#
+ u_t015_005/m2_603_1259# u_t015_005/m2_2074_2909# u_t015_005/m2_7_336# u_t015_005/m2_717_2037#
+ u_t015_005/m2_1886_2031# u_t015_005/m2_2573_336# u_t015_005/m2_7_2898# u_t015_005/m2_2000_1265#
+ u_t015_005/m2_512_2037# u_t015_005/m2_1795_1265# u_t015_005/m2_1714_1982# u_t015_005/m2_1886_1259#
+ u_t015_005/m2_1290_2126# u_t015_005/m2_1714_438# u_t015_005/m2_431_1210# u_t015_005/m2_2573_2898#
+ u_t015_005/m2_2154_303# u_t015_005/m2_871_2081# VSUBS detronyx_12t_2w2r_rc4_4x4_routed_5layer_direct
Xu_t030_008 u_t030_008/c0_w0_bl u_t030_008/c0_w0_br u_t030_008/c0_w1_bl u_t030_008/c0_w1_br
+ u_t030_008/c0_r0_rbl u_t030_008/c0_r1_rbl u_t030_008/c1_w0_bl u_t030_008/c1_w0_br
+ u_t030_008/c1_w1_bl u_t030_008/c1_w1_br u_t030_008/c1_r0_rbl u_t030_008/c1_r1_rbl
+ u_t030_008/c2_w0_bl u_t030_008/c2_w0_br u_t030_008/c2_w1_bl u_t030_008/c2_w1_br
+ u_t030_008/c2_r0_rbl u_t030_008/c2_r1_rbl u_t030_008/c3_w0_bl u_t030_008/c3_w0_br
+ u_t030_008/c3_w1_bl u_t030_008/c3_w1_br u_t030_008/c3_r0_rbl u_t030_008/c3_r1_rbl
+ u_t030_008/r0_w0_wl u_t030_008/r0_w1_wl u_t030_008/r0_r0_rwl u_t030_008/r0_r1_rwl
+ u_t030_008/r1_w0_wl u_t030_008/r1_w1_wl u_t030_008/r1_r0_rwl u_t030_008/r1_r1_rwl
+ u_t030_008/r2_w0_wl u_t030_008/r2_w1_wl u_t030_008/r2_r0_rwl u_t030_008/r2_r1_rwl
+ u_t030_008/r3_w0_wl u_t030_008/r3_w1_wl u_t030_008/r3_r0_rwl u_t030_008/r3_r1_rwl
+ VSS VSS u_t030_008/m2_717_1265# u_t030_008/m2_603_2031# u_t030_008/m2_1290_336#
+ u_t030_008/m2_2000_2037# u_t030_008/m2_791_2909# u_t030_008/m2_7_2126# u_t030_008/m2_2154_2081#
+ u_t030_008/m2_1795_2037# u_t030_008/m2_871_303# u_t030_008/m2_431_438# u_t030_008/m2_1290_2898#
+ u_t030_008/m2_1714_1210# u_t030_008/m2_431_1982# u_t030_008/m2_512_1265# u_t030_008/m2_2573_2126#
+ u_t030_008/m2_603_1259# u_t030_008/m2_2074_2909# u_t030_008/m2_7_336# u_t030_008/m2_717_2037#
+ u_t030_008/m2_1886_2031# u_t030_008/m2_2573_336# u_t030_008/m2_7_2898# u_t030_008/m2_2000_1265#
+ u_t030_008/m2_512_2037# u_t030_008/m2_1795_1265# u_t030_008/m2_1714_1982# u_t030_008/m2_1886_1259#
+ u_t030_008/m2_1290_2126# u_t030_008/m2_1714_438# u_t030_008/m2_431_1210# u_t030_008/m2_2573_2898#
+ u_t030_008/m2_2154_303# u_t030_008/m2_871_2081# VSUBS detronyx_12t_2w2r_rc4_4x4_routed_5layer_direct
Xgf180mcu_as_sc_mcu7t3v3__nand4_2_409 VSS VSS VSS VSS VSS VSS gf180mcu_as_sc_mcu7t3v3__inv_2_1497/A
+ gf180mcu_as_sc_mcu7t3v3__inv_2_1497/VNW VSUBS gf180mcu_as_sc_mcu7t3v3__nand4_2
Xu_t021_008 u_t021_008/c0_w0_bl u_t021_008/c0_w0_br u_t021_008/c0_w1_bl u_t021_008/c0_w1_br
+ u_t021_008/c0_r0_rbl u_t021_008/c0_r1_rbl u_t021_008/c1_w0_bl u_t021_008/c1_w0_br
+ u_t021_008/c1_w1_bl u_t021_008/c1_w1_br u_t021_008/c1_r0_rbl u_t021_008/c1_r1_rbl
+ u_t021_008/c2_w0_bl u_t021_008/c2_w0_br u_t021_008/c2_w1_bl u_t021_008/c2_w1_br
+ u_t021_008/c2_r0_rbl u_t021_008/c2_r1_rbl u_t021_008/c3_w0_bl u_t021_008/c3_w0_br
+ u_t021_008/c3_w1_bl u_t021_008/c3_w1_br u_t021_008/c3_r0_rbl u_t021_008/c3_r1_rbl
+ u_t021_008/r0_w0_wl u_t021_008/r0_w1_wl u_t021_008/r0_r0_rwl u_t021_008/r0_r1_rwl
+ u_t021_008/r1_w0_wl u_t021_008/r1_w1_wl u_t021_008/r1_r0_rwl u_t021_008/r1_r1_rwl
+ u_t021_008/r2_w0_wl u_t021_008/r2_w1_wl u_t021_008/r2_r0_rwl u_t021_008/r2_r1_rwl
+ u_t021_008/r3_w0_wl u_t021_008/r3_w1_wl u_t021_008/r3_r0_rwl u_t021_008/r3_r1_rwl
+ VSS VSS u_t021_008/m2_717_1265# u_t021_008/m2_603_2031# u_t021_008/m2_1290_336#
+ u_t021_008/m2_2000_2037# u_t021_008/m2_791_2909# u_t021_008/m2_7_2126# u_t021_008/m2_2154_2081#
+ u_t021_008/m2_1795_2037# u_t021_008/m2_871_303# u_t021_008/m2_431_438# u_t021_008/m2_1290_2898#
+ u_t021_008/m2_1714_1210# u_t021_008/m2_431_1982# u_t021_008/m2_512_1265# u_t021_008/m2_2573_2126#
+ u_t021_008/m2_603_1259# u_t021_008/m2_2074_2909# u_t021_008/m2_7_336# u_t021_008/m2_717_2037#
+ u_t021_008/m2_1886_2031# u_t021_008/m2_2573_336# u_t021_008/m2_7_2898# u_t021_008/m2_2000_1265#
+ u_t021_008/m2_512_2037# u_t021_008/m2_1795_1265# u_t021_008/m2_1714_1982# u_t021_008/m2_1886_1259#
+ u_t021_008/m2_1290_2126# u_t021_008/m2_1714_438# u_t021_008/m2_431_1210# u_t021_008/m2_2573_2898#
+ u_t021_008/m2_2154_303# u_t021_008/m2_871_2081# VSUBS detronyx_12t_2w2r_rc4_4x4_routed_5layer_direct
Xu_t006_005 u_t006_005/c0_w0_bl u_t006_005/c0_w0_br u_t006_005/c0_w1_bl u_t006_005/c0_w1_br
+ u_t006_005/c0_r0_rbl u_t006_005/c0_r1_rbl u_t006_005/c1_w0_bl u_t006_005/c1_w0_br
+ u_t006_005/c1_w1_bl u_t006_005/c1_w1_br u_t006_005/c1_r0_rbl u_t006_005/c1_r1_rbl
+ u_t006_005/c2_w0_bl u_t006_005/c2_w0_br u_t006_005/c2_w1_bl u_t006_005/c2_w1_br
+ u_t006_005/c2_r0_rbl u_t006_005/c2_r1_rbl u_t006_005/c3_w0_bl u_t006_005/c3_w0_br
+ u_t006_005/c3_w1_bl u_t006_005/c3_w1_br u_t006_005/c3_r0_rbl u_t006_005/c3_r1_rbl
+ u_t006_005/r0_w0_wl u_t006_005/r0_w1_wl u_t006_005/r0_r0_rwl u_t006_005/r0_r1_rwl
+ u_t006_005/r1_w0_wl u_t006_005/r1_w1_wl u_t006_005/r1_r0_rwl u_t006_005/r1_r1_rwl
+ u_t006_005/r2_w0_wl u_t006_005/r2_w1_wl u_t006_005/r2_r0_rwl u_t006_005/r2_r1_rwl
+ u_t006_005/r3_w0_wl u_t006_005/r3_w1_wl u_t006_005/r3_r0_rwl u_t006_005/r3_r1_rwl
+ VSS VSS u_t006_005/m2_717_1265# u_t006_005/m2_603_2031# u_t006_005/m2_1290_336#
+ u_t006_005/m2_2000_2037# u_t006_005/m2_791_2909# u_t006_005/m2_7_2126# u_t006_005/m2_2154_2081#
+ u_t006_005/m2_1795_2037# u_t006_005/m2_871_303# u_t006_005/m2_431_438# u_t006_005/m2_1290_2898#
+ u_t006_005/m2_1714_1210# u_t006_005/m2_431_1982# u_t006_005/m2_512_1265# u_t006_005/m2_2573_2126#
+ u_t006_005/m2_603_1259# u_t006_005/m2_2074_2909# u_t006_005/m2_7_336# u_t006_005/m2_717_2037#
+ u_t006_005/m2_1886_2031# u_t006_005/m2_2573_336# u_t006_005/m2_7_2898# u_t006_005/m2_2000_1265#
+ u_t006_005/m2_512_2037# u_t006_005/m2_1795_1265# u_t006_005/m2_1714_1982# u_t006_005/m2_1886_1259#
+ u_t006_005/m2_1290_2126# u_t006_005/m2_1714_438# u_t006_005/m2_431_1210# u_t006_005/m2_2573_2898#
+ u_t006_005/m2_2154_303# u_t006_005/m2_871_2081# VSUBS detronyx_12t_2w2r_rc4_4x4_routed_5layer_direct
Xgf180mcu_as_sc_mcu7t3v3__nand2_2_50 gf180mcu_as_sc_mcu7t3v3__nor2_2_9/VDD gf180mcu_as_sc_mcu7t3v3__nor2_2_9/VSS
+ VSS VSS VSS gf180mcu_as_sc_mcu7t3v3__nor2_2_9/VNW VSUBS gf180mcu_as_sc_mcu7t3v3__nand2_2
Xu_t012_008 u_t012_008/c0_w0_bl u_t012_008/c0_w0_br u_t012_008/c0_w1_bl u_t012_008/c0_w1_br
+ u_t012_008/c0_r0_rbl u_t012_008/c0_r1_rbl u_t012_008/c1_w0_bl u_t012_008/c1_w0_br
+ u_t012_008/c1_w1_bl u_t012_008/c1_w1_br u_t012_008/c1_r0_rbl u_t012_008/c1_r1_rbl
+ u_t012_008/c2_w0_bl u_t012_008/c2_w0_br u_t012_008/c2_w1_bl u_t012_008/c2_w1_br
+ u_t012_008/c2_r0_rbl u_t012_008/c2_r1_rbl u_t012_008/c3_w0_bl u_t012_008/c3_w0_br
+ u_t012_008/c3_w1_bl u_t012_008/c3_w1_br u_t012_008/c3_r0_rbl u_t012_008/c3_r1_rbl
+ u_t012_008/r0_w0_wl u_t012_008/r0_w1_wl u_t012_008/r0_r0_rwl u_t012_008/r0_r1_rwl
+ u_t012_008/r1_w0_wl u_t012_008/r1_w1_wl u_t012_008/r1_r0_rwl u_t012_008/r1_r1_rwl
+ u_t012_008/r2_w0_wl u_t012_008/r2_w1_wl u_t012_008/r2_r0_rwl u_t012_008/r2_r1_rwl
+ u_t012_008/r3_w0_wl u_t012_008/r3_w1_wl u_t012_008/r3_r0_rwl u_t012_008/r3_r1_rwl
+ VSS VSS u_t012_008/m2_717_1265# u_t012_008/m2_603_2031# u_t012_008/m2_1290_336#
+ u_t012_008/m2_2000_2037# u_t012_008/m2_791_2909# u_t012_008/m2_7_2126# u_t012_008/m2_2154_2081#
+ u_t012_008/m2_1795_2037# u_t012_008/m2_871_303# u_t012_008/m2_431_438# u_t012_008/m2_1290_2898#
+ u_t012_008/m2_1714_1210# u_t012_008/m2_431_1982# u_t012_008/m2_512_1265# u_t012_008/m2_2573_2126#
+ u_t012_008/m2_603_1259# u_t012_008/m2_2074_2909# u_t012_008/m2_7_336# u_t012_008/m2_717_2037#
+ u_t012_008/m2_1886_2031# u_t012_008/m2_2573_336# u_t012_008/m2_7_2898# u_t012_008/m2_2000_1265#
+ u_t012_008/m2_512_2037# u_t012_008/m2_1795_1265# u_t012_008/m2_1714_1982# u_t012_008/m2_1886_1259#
+ u_t012_008/m2_1290_2126# u_t012_008/m2_1714_438# u_t012_008/m2_431_1210# u_t012_008/m2_2573_2898#
+ u_t012_008/m2_2154_303# u_t012_008/m2_871_2081# VSUBS detronyx_12t_2w2r_rc4_4x4_routed_5layer_direct
Xgf180mcu_as_sc_mcu7t3v3__inv_2_1401 VSS VSS gf180mcu_as_sc_mcu7t3v3__inv_2_1401/Y
+ gf180mcu_as_sc_mcu7t3v3__inv_2_1402/Y gf180mcu_as_sc_mcu7t3v3__inv_2_1402/VNW VSUBS
+ gf180mcu_as_sc_mcu7t3v3__inv_2
Xgf180mcu_as_sc_mcu7t3v3__inv_2_1467 VSS VSS gf180mcu_as_sc_mcu7t3v3__inv_2_1467/Y
+ gf180mcu_as_sc_mcu7t3v3__inv_2_1467/A gf180mcu_as_sc_mcu7t3v3__inv_2_1467/VNW VSUBS
+ gf180mcu_as_sc_mcu7t3v3__inv_2
Xgf180mcu_as_sc_mcu7t3v3__inv_2_1489 VSS VSS VSS gf180mcu_as_sc_mcu7t3v3__inv_2_1490/Y
+ gf180mcu_as_sc_mcu7t3v3__inv_2_1491/VNW VSUBS gf180mcu_as_sc_mcu7t3v3__inv_2
Xgf180mcu_as_sc_mcu7t3v3__inv_2_1478 VSS VSS VSS gf180mcu_as_sc_mcu7t3v3__inv_2_1479/Y
+ gf180mcu_as_sc_mcu7t3v3__inv_2_1479/VNW VSUBS gf180mcu_as_sc_mcu7t3v3__inv_2
Xgf180mcu_as_sc_mcu7t3v3__inv_2_1412 VSS VSS gf180mcu_as_sc_mcu7t3v3__inv_2_1412/Y
+ gf180mcu_as_sc_mcu7t3v3__inv_2_1413/Y gf180mcu_as_sc_mcu7t3v3__inv_2_1413/VNW VSUBS
+ gf180mcu_as_sc_mcu7t3v3__inv_2
Xgf180mcu_as_sc_mcu7t3v3__inv_2_1456 VSS VSS VSS gf180mcu_as_sc_mcu7t3v3__inv_2_1457/Y
+ gf180mcu_as_sc_mcu7t3v3__inv_2_1457/VNW VSUBS gf180mcu_as_sc_mcu7t3v3__inv_2
Xgf180mcu_as_sc_mcu7t3v3__inv_2_1445 VSS VSS gf180mcu_as_sc_mcu7t3v3__inv_2_1445/Y
+ gf180mcu_as_sc_mcu7t3v3__inv_2_1446/Y gf180mcu_as_sc_mcu7t3v3__inv_2_1446/VNW VSUBS
+ gf180mcu_as_sc_mcu7t3v3__inv_2
Xgf180mcu_as_sc_mcu7t3v3__inv_2_1434 VSS VSS gf180mcu_as_sc_mcu7t3v3__inv_2_1434/Y
+ gf180mcu_as_sc_mcu7t3v3__inv_2_1434/A gf180mcu_as_sc_mcu7t3v3__inv_2_1434/VNW VSUBS
+ gf180mcu_as_sc_mcu7t3v3__inv_2
Xgf180mcu_as_sc_mcu7t3v3__inv_2_1423 VSS VSS VSS gf180mcu_as_sc_mcu7t3v3__inv_2_1424/Y
+ gf180mcu_as_sc_mcu7t3v3__inv_2_1425/VNW VSUBS gf180mcu_as_sc_mcu7t3v3__inv_2
Xu_t003_008 u_t003_008/c0_w0_bl u_t003_008/c0_w0_br u_t003_008/c0_w1_bl u_t003_008/c0_w1_br
+ u_t003_008/c0_r0_rbl u_t003_008/c0_r1_rbl u_t003_008/c1_w0_bl u_t003_008/c1_w0_br
+ u_t003_008/c1_w1_bl u_t003_008/c1_w1_br u_t003_008/c1_r0_rbl u_t003_008/c1_r1_rbl
+ u_t003_008/c2_w0_bl u_t003_008/c2_w0_br u_t003_008/c2_w1_bl u_t003_008/c2_w1_br
+ u_t003_008/c2_r0_rbl u_t003_008/c2_r1_rbl u_t003_008/c3_w0_bl u_t003_008/c3_w0_br
+ u_t003_008/c3_w1_bl u_t003_008/c3_w1_br u_t003_008/c3_r0_rbl u_t003_008/c3_r1_rbl
+ u_t003_008/r0_w0_wl u_t003_008/r0_w1_wl u_t003_008/r0_r0_rwl u_t003_008/r0_r1_rwl
+ u_t003_008/r1_w0_wl u_t003_008/r1_w1_wl u_t003_008/r1_r0_rwl u_t003_008/r1_r1_rwl
+ u_t003_008/r2_w0_wl u_t003_008/r2_w1_wl u_t003_008/r2_r0_rwl u_t003_008/r2_r1_rwl
+ u_t003_008/r3_w0_wl u_t003_008/r3_w1_wl u_t003_008/r3_r0_rwl u_t003_008/r3_r1_rwl
+ VSS VSS u_t003_008/m2_717_1265# u_t003_008/m2_603_2031# u_t003_008/m2_1290_336#
+ u_t003_008/m2_2000_2037# u_t003_008/m2_791_2909# u_t003_008/m2_7_2126# u_t003_008/m2_2154_2081#
+ u_t003_008/m2_1795_2037# u_t003_008/m2_871_303# u_t003_008/m2_431_438# u_t003_008/m2_1290_2898#
+ u_t003_008/m2_1714_1210# u_t003_008/m2_431_1982# u_t003_008/m2_512_1265# u_t003_008/m2_2573_2126#
+ u_t003_008/m2_603_1259# u_t003_008/m2_2074_2909# u_t003_008/m2_7_336# u_t003_008/m2_717_2037#
+ u_t003_008/m2_1886_2031# u_t003_008/m2_2573_336# u_t003_008/m2_7_2898# u_t003_008/m2_2000_1265#
+ u_t003_008/m2_512_2037# u_t003_008/m2_1795_1265# u_t003_008/m2_1714_1982# u_t003_008/m2_1886_1259#
+ u_t003_008/m2_1290_2126# u_t003_008/m2_1714_438# u_t003_008/m2_431_1210# u_t003_008/m2_2573_2898#
+ u_t003_008/m2_2154_303# u_t003_008/m2_871_2081# VSUBS detronyx_12t_2w2r_rc4_4x4_routed_5layer_direct
Xgf180mcu_as_sc_mcu7t3v3__inv_2_907 VSS VSS gf180mcu_as_sc_mcu7t3v3__inv_2_953/A gf180mcu_as_sc_mcu7t3v3__inv_2_908/Y
+ gf180mcu_as_sc_mcu7t3v3__inv_2_953/VNW VSUBS gf180mcu_as_sc_mcu7t3v3__inv_2
Xgf180mcu_as_sc_mcu7t3v3__inv_2_918 VSS VSS gf180mcu_as_sc_mcu7t3v3__inv_2_955/A gf180mcu_as_sc_mcu7t3v3__inv_2_921/Y
+ gf180mcu_as_sc_mcu7t3v3__inv_2_955/VNW VSUBS gf180mcu_as_sc_mcu7t3v3__inv_2
Xgf180mcu_as_sc_mcu7t3v3__inv_2_929 VSS VSS VSS gf180mcu_as_sc_mcu7t3v3__inv_2_929/A
+ gf180mcu_as_sc_mcu7t3v3__inv_2_929/VNW VSUBS gf180mcu_as_sc_mcu7t3v3__inv_2
Xgf180mcu_as_sc_mcu7t3v3__nand4_2_206 VSS VSS VSS VSS VSS VSS gf180mcu_as_sc_mcu7t3v3__inv_2_664/A
+ gf180mcu_as_sc_mcu7t3v3__inv_2_664/VNW VSUBS gf180mcu_as_sc_mcu7t3v3__nand4_2
Xgf180mcu_as_sc_mcu7t3v3__nand4_2_217 VSS VSS VSS VSS VSS VSS gf180mcu_as_sc_mcu7t3v3__inv_2_754/A
+ gf180mcu_as_sc_mcu7t3v3__inv_2_831/VNW VSUBS gf180mcu_as_sc_mcu7t3v3__nand4_2
Xgf180mcu_as_sc_mcu7t3v3__nand4_2_228 VSS VSS VSS VSS VSS VSS gf180mcu_as_sc_mcu7t3v3__inv_2_765/A
+ gf180mcu_as_sc_mcu7t3v3__inv_2_835/VNW VSUBS gf180mcu_as_sc_mcu7t3v3__nand4_2
Xgf180mcu_as_sc_mcu7t3v3__nand4_2_239 VSS VSS VSS VSS VSS VSS gf180mcu_as_sc_mcu7t3v3__inv_2_798/A
+ gf180mcu_as_sc_mcu7t3v3__inv_2_846/VNW VSUBS gf180mcu_as_sc_mcu7t3v3__nand4_2
Xgf180mcu_as_sc_mcu7t3v3__inv_2_1231 gf180mcu_as_sc_mcu7t3v3__nor2_2_9/VDD gf180mcu_as_sc_mcu7t3v3__nor2_2_9/VSS
+ VSS VSS gf180mcu_as_sc_mcu7t3v3__nor2_2_9/VNW VSUBS gf180mcu_as_sc_mcu7t3v3__inv_2
Xgf180mcu_as_sc_mcu7t3v3__inv_2_1253 gf180mcu_as_sc_mcu7t3v3__nor2_2_9/VDD gf180mcu_as_sc_mcu7t3v3__nand3_2_63/VSS
+ VSS VSS gf180mcu_as_sc_mcu7t3v3__nor2_2_9/VNW VSUBS gf180mcu_as_sc_mcu7t3v3__inv_2
Xgf180mcu_as_sc_mcu7t3v3__inv_2_1242 gf180mcu_as_sc_mcu7t3v3__nand3_2_65/VDD gf180mcu_as_sc_mcu7t3v3__nor2_2_9/VSS
+ VSS VSS gf180mcu_as_sc_mcu7t3v3__nand3_2_65/VNW VSUBS gf180mcu_as_sc_mcu7t3v3__inv_2
Xgf180mcu_as_sc_mcu7t3v3__inv_2_1220 VSS VSS gf180mcu_as_sc_mcu7t3v3__inv_2_1275/A
+ gf180mcu_as_sc_mcu7t3v3__inv_2_1221/Y gf180mcu_as_sc_mcu7t3v3__inv_2_1275/VNW VSUBS
+ gf180mcu_as_sc_mcu7t3v3__inv_2
Xgf180mcu_as_sc_mcu7t3v3__inv_2_1264 gf180mcu_as_sc_mcu7t3v3__nor2_2_9/VDD gf180mcu_as_sc_mcu7t3v3__nor2_2_9/VSS
+ VSS VSS gf180mcu_as_sc_mcu7t3v3__nor2_2_9/VNW VSUBS gf180mcu_as_sc_mcu7t3v3__inv_2
Xgf180mcu_as_sc_mcu7t3v3__inv_2_1275 VSS VSS VSS gf180mcu_as_sc_mcu7t3v3__inv_2_1275/A
+ gf180mcu_as_sc_mcu7t3v3__inv_2_1275/VNW VSUBS gf180mcu_as_sc_mcu7t3v3__inv_2
Xgf180mcu_as_sc_mcu7t3v3__inv_2_1286 VSS VSS gf180mcu_as_sc_mcu7t3v3__inv_2_1286/Y
+ gf180mcu_as_sc_mcu7t3v3__inv_2_1286/A gf180mcu_as_sc_mcu7t3v3__inv_2_1286/VNW VSUBS
+ gf180mcu_as_sc_mcu7t3v3__inv_2
Xgf180mcu_as_sc_mcu7t3v3__inv_2_1297 VSS VSS VSS gf180mcu_as_sc_mcu7t3v3__inv_2_1297/A
+ gf180mcu_as_sc_mcu7t3v3__inv_2_1297/VNW VSUBS gf180mcu_as_sc_mcu7t3v3__inv_2
Xgf180mcu_as_sc_mcu7t3v3__inv_2_759 VSS VSS gf180mcu_as_sc_mcu7t3v3__inv_2_759/Y gf180mcu_as_sc_mcu7t3v3__inv_2_759/A
+ gf180mcu_as_sc_mcu7t3v3__inv_2_820/VNW VSUBS gf180mcu_as_sc_mcu7t3v3__inv_2
Xgf180mcu_as_sc_mcu7t3v3__inv_2_748 VSS VSS gf180mcu_as_sc_mcu7t3v3__inv_2_829/A gf180mcu_as_sc_mcu7t3v3__inv_2_749/Y
+ gf180mcu_as_sc_mcu7t3v3__inv_2_829/VNW VSUBS gf180mcu_as_sc_mcu7t3v3__inv_2
Xgf180mcu_as_sc_mcu7t3v3__inv_2_726 VSS VSS VSS gf180mcu_as_sc_mcu7t3v3__inv_2_727/Y
+ gf180mcu_as_sc_mcu7t3v3__inv_2_728/VNW VSUBS gf180mcu_as_sc_mcu7t3v3__inv_2
Xgf180mcu_as_sc_mcu7t3v3__inv_2_715 VSS VSS gf180mcu_as_sc_mcu7t3v3__inv_2_715/Y gf180mcu_as_sc_mcu7t3v3__inv_2_716/Y
+ gf180mcu_as_sc_mcu7t3v3__inv_2_716/VNW VSUBS gf180mcu_as_sc_mcu7t3v3__inv_2
Xgf180mcu_as_sc_mcu7t3v3__inv_2_704 VSS VSS gf180mcu_as_sc_mcu7t3v3__inv_2_704/Y gf180mcu_as_sc_mcu7t3v3__inv_2_704/A
+ gf180mcu_as_sc_mcu7t3v3__inv_2_704/VNW VSUBS gf180mcu_as_sc_mcu7t3v3__inv_2
Xgf180mcu_as_sc_mcu7t3v3__inv_2_737 VSS VSS VSS gf180mcu_as_sc_mcu7t3v3__inv_2_737/A
+ gf180mcu_as_sc_mcu7t3v3__inv_2_737/VNW VSUBS gf180mcu_as_sc_mcu7t3v3__inv_2
Xgf180mcu_as_sc_mcu7t3v3__inv_2_1094 VSS VSS gf180mcu_as_sc_mcu7t3v3__inv_2_1094/Y
+ gf180mcu_as_sc_mcu7t3v3__inv_2_1095/Y gf180mcu_as_sc_mcu7t3v3__inv_2_1095/VNW VSUBS
+ gf180mcu_as_sc_mcu7t3v3__inv_2
Xgf180mcu_as_sc_mcu7t3v3__inv_2_1083 VSS VSS gf180mcu_as_sc_mcu7t3v3__inv_2_1083/Y
+ gf180mcu_as_sc_mcu7t3v3__inv_2_1083/A gf180mcu_as_sc_mcu7t3v3__inv_2_1083/VNW VSUBS
+ gf180mcu_as_sc_mcu7t3v3__inv_2
Xgf180mcu_as_sc_mcu7t3v3__inv_2_1072 VSS VSS VSS gf180mcu_as_sc_mcu7t3v3__inv_2_1076/Y
+ gf180mcu_as_sc_mcu7t3v3__inv_2_1080/VNW VSUBS gf180mcu_as_sc_mcu7t3v3__inv_2
Xgf180mcu_as_sc_mcu7t3v3__inv_2_1050 VSS VSS VSS gf180mcu_as_sc_mcu7t3v3__inv_2_1051/Y
+ gf180mcu_as_sc_mcu7t3v3__inv_2_1052/VNW VSUBS gf180mcu_as_sc_mcu7t3v3__inv_2
Xgf180mcu_as_sc_mcu7t3v3__inv_2_91 VSS VSS VSS gf180mcu_as_sc_mcu7t3v3__inv_2_91/A
+ gf180mcu_as_sc_mcu7t3v3__inv_2_91/VNW VSUBS gf180mcu_as_sc_mcu7t3v3__inv_2
Xgf180mcu_as_sc_mcu7t3v3__inv_2_80 VSS VSS gf180mcu_as_sc_mcu7t3v3__inv_2_80/Y gf180mcu_as_sc_mcu7t3v3__inv_2_81/Y
+ gf180mcu_as_sc_mcu7t3v3__inv_2_81/VNW VSUBS gf180mcu_as_sc_mcu7t3v3__inv_2
Xgf180mcu_as_sc_mcu7t3v3__inv_2_1061 VSS VSS gf180mcu_as_sc_mcu7t3v3__inv_2_1061/Y
+ gf180mcu_as_sc_mcu7t3v3__inv_2_1061/A gf180mcu_as_sc_mcu7t3v3__inv_2_1061/VNW VSUBS
+ gf180mcu_as_sc_mcu7t3v3__inv_2
Xgf180mcu_as_sc_mcu7t3v3__nand4_2_6 VSS VSS VSS VSS VSS VSS gf180mcu_as_sc_mcu7t3v3__inv_2_90/A
+ gf180mcu_as_sc_mcu7t3v3__inv_2_90/VNW VSUBS gf180mcu_as_sc_mcu7t3v3__nand4_2
Xgf180mcu_as_sc_mcu7t3v3__inv_2_545 VSS VSS VSS gf180mcu_as_sc_mcu7t3v3__inv_2_545/A
+ gf180mcu_as_sc_mcu7t3v3__inv_2_545/VNW VSUBS gf180mcu_as_sc_mcu7t3v3__inv_2
Xgf180mcu_as_sc_mcu7t3v3__inv_2_534 gf180mcu_as_sc_mcu7t3v3__nor2_2_6/VDD gf180mcu_as_sc_mcu7t3v3__nor2_2_6/VSS
+ VSS VSS gf180mcu_as_sc_mcu7t3v3__nor2_2_6/VNW VSUBS gf180mcu_as_sc_mcu7t3v3__inv_2
Xgf180mcu_as_sc_mcu7t3v3__inv_2_523 gf180mcu_as_sc_mcu7t3v3__nor2_2_7/VDD gf180mcu_as_sc_mcu7t3v3__nor2_2_7/VSS
+ VSS VSS gf180mcu_as_sc_mcu7t3v3__nor2_2_7/VNW VSUBS gf180mcu_as_sc_mcu7t3v3__inv_2
Xgf180mcu_as_sc_mcu7t3v3__inv_2_501 VSS VSS gf180mcu_as_sc_mcu7t3v3__inv_2_536/A gf180mcu_as_sc_mcu7t3v3__inv_2_502/Y
+ gf180mcu_as_sc_mcu7t3v3__inv_2_536/VNW VSUBS gf180mcu_as_sc_mcu7t3v3__inv_2
Xgf180mcu_as_sc_mcu7t3v3__inv_2_512 VSS VSS gf180mcu_as_sc_mcu7t3v3__inv_2_563/A gf180mcu_as_sc_mcu7t3v3__inv_2_512/A
+ gf180mcu_as_sc_mcu7t3v3__inv_2_563/VNW VSUBS gf180mcu_as_sc_mcu7t3v3__inv_2
Xgf180mcu_as_sc_mcu7t3v3__inv_2_589 VSS VSS VSS gf180mcu_as_sc_mcu7t3v3__inv_2_590/Y
+ gf180mcu_as_sc_mcu7t3v3__inv_2_590/VNW VSUBS gf180mcu_as_sc_mcu7t3v3__inv_2
Xgf180mcu_as_sc_mcu7t3v3__inv_2_567 VSS VSS gf180mcu_as_sc_mcu7t3v3__inv_2_567/Y gf180mcu_as_sc_mcu7t3v3__inv_2_567/A
+ gf180mcu_as_sc_mcu7t3v3__inv_2_567/VNW VSUBS gf180mcu_as_sc_mcu7t3v3__inv_2
Xgf180mcu_as_sc_mcu7t3v3__inv_2_578 VSS VSS gf180mcu_as_sc_mcu7t3v3__inv_2_578/Y gf180mcu_as_sc_mcu7t3v3__inv_2_579/Y
+ gf180mcu_as_sc_mcu7t3v3__inv_2_579/VNW VSUBS gf180mcu_as_sc_mcu7t3v3__inv_2
Xgf180mcu_as_sc_mcu7t3v3__inv_2_556 VSS VSS VSS gf180mcu_as_sc_mcu7t3v3__inv_2_556/A
+ gf180mcu_as_sc_mcu7t3v3__inv_2_556/VNW VSUBS gf180mcu_as_sc_mcu7t3v3__inv_2
Xgf180mcu_as_sc_mcu7t3v3__inv_2_375 gf180mcu_as_sc_mcu7t3v3__nor2_2_4/VDD gf180mcu_as_sc_mcu7t3v3__nor2_2_4/VSS
+ VSS VSS gf180mcu_as_sc_mcu7t3v3__nor2_2_4/VNW VSUBS gf180mcu_as_sc_mcu7t3v3__inv_2
Xgf180mcu_as_sc_mcu7t3v3__inv_2_386 gf180mcu_as_sc_mcu7t3v3__nor2_2_4/VDD gf180mcu_as_sc_mcu7t3v3__nand2_2_3/VSS
+ VSS VSS gf180mcu_as_sc_mcu7t3v3__nor2_2_4/VNW VSUBS gf180mcu_as_sc_mcu7t3v3__inv_2
Xgf180mcu_as_sc_mcu7t3v3__inv_2_364 VSS VSS gf180mcu_as_sc_mcu7t3v3__inv_2_364/Y gf180mcu_as_sc_mcu7t3v3__inv_2_365/Y
+ gf180mcu_as_sc_mcu7t3v3__inv_2_365/VNW VSUBS gf180mcu_as_sc_mcu7t3v3__inv_2
Xgf180mcu_as_sc_mcu7t3v3__inv_2_353 VSS VSS gf180mcu_as_sc_mcu7t3v3__inv_2_353/Y gf180mcu_as_sc_mcu7t3v3__inv_2_353/A
+ gf180mcu_as_sc_mcu7t3v3__inv_2_353/VNW VSUBS gf180mcu_as_sc_mcu7t3v3__inv_2
Xgf180mcu_as_sc_mcu7t3v3__inv_2_342 VSS VSS VSS gf180mcu_as_sc_mcu7t3v3__inv_2_343/Y
+ gf180mcu_as_sc_mcu7t3v3__inv_2_344/VNW VSUBS gf180mcu_as_sc_mcu7t3v3__inv_2
Xgf180mcu_as_sc_mcu7t3v3__inv_2_331 VSS VSS gf180mcu_as_sc_mcu7t3v3__inv_2_331/Y gf180mcu_as_sc_mcu7t3v3__inv_2_332/Y
+ gf180mcu_as_sc_mcu7t3v3__inv_2_332/VNW VSUBS gf180mcu_as_sc_mcu7t3v3__inv_2
Xgf180mcu_as_sc_mcu7t3v3__inv_2_320 VSS VSS gf180mcu_as_sc_mcu7t3v3__inv_2_320/Y gf180mcu_as_sc_mcu7t3v3__inv_2_320/A
+ gf180mcu_as_sc_mcu7t3v3__inv_2_320/VNW VSUBS gf180mcu_as_sc_mcu7t3v3__inv_2
Xgf180mcu_as_sc_mcu7t3v3__inv_2_397 gf180mcu_as_sc_mcu7t3v3__nor2_2_4/VDD gf180mcu_as_sc_mcu7t3v3__nor2_2_4/VSS
+ VSS VSS gf180mcu_as_sc_mcu7t3v3__nor2_2_4/VNW VSUBS gf180mcu_as_sc_mcu7t3v3__inv_2
Xu_t027_014 u_t027_014/c0_w0_bl u_t027_014/c0_w0_br u_t027_014/c0_w1_bl u_t027_014/c0_w1_br
+ u_t027_014/c0_r0_rbl u_t027_014/c0_r1_rbl u_t027_014/c1_w0_bl u_t027_014/c1_w0_br
+ u_t027_014/c1_w1_bl u_t027_014/c1_w1_br u_t027_014/c1_r0_rbl u_t027_014/c1_r1_rbl
+ u_t027_014/c2_w0_bl u_t027_014/c2_w0_br u_t027_014/c2_w1_bl u_t027_014/c2_w1_br
+ u_t027_014/c2_r0_rbl u_t027_014/c2_r1_rbl u_t027_014/c3_w0_bl u_t027_014/c3_w0_br
+ u_t027_014/c3_w1_bl u_t027_014/c3_w1_br u_t027_014/c3_r0_rbl u_t027_014/c3_r1_rbl
+ u_t027_014/r0_w0_wl u_t027_014/r0_w1_wl u_t027_014/r0_r0_rwl u_t027_014/r0_r1_rwl
+ u_t027_014/r1_w0_wl u_t027_014/r1_w1_wl u_t027_014/r1_r0_rwl u_t027_014/r1_r1_rwl
+ u_t027_014/r2_w0_wl u_t027_014/r2_w1_wl u_t027_014/r2_r0_rwl u_t027_014/r2_r1_rwl
+ u_t027_014/r3_w0_wl u_t027_014/r3_w1_wl u_t027_014/r3_r0_rwl u_t027_014/r3_r1_rwl
+ VSS VSS u_t027_014/m2_717_1265# u_t027_014/m2_603_2031# u_t027_014/m2_1290_336#
+ u_t027_014/m2_2000_2037# u_t027_014/m2_791_2909# u_t027_014/m2_7_2126# u_t027_014/m2_2154_2081#
+ u_t027_014/m2_1795_2037# u_t027_014/m2_871_303# u_t027_014/m2_431_438# u_t027_014/m2_1290_2898#
+ u_t027_014/m2_1714_1210# u_t027_014/m2_431_1982# u_t027_014/m2_512_1265# u_t027_014/m2_2573_2126#
+ u_t027_014/m2_603_1259# u_t027_014/m2_2074_2909# u_t027_014/m2_7_336# u_t027_014/m2_717_2037#
+ u_t027_014/m2_1886_2031# u_t027_014/m2_2573_336# u_t027_014/m2_7_2898# u_t027_014/m2_2000_1265#
+ u_t027_014/m2_512_2037# u_t027_014/m2_1795_1265# u_t027_014/m2_1714_1982# u_t027_014/m2_1886_1259#
+ u_t027_014/m2_1290_2126# u_t027_014/m2_1714_438# u_t027_014/m2_431_1210# u_t027_014/m2_2573_2898#
+ u_t027_014/m2_2154_303# u_t027_014/m2_871_2081# VSUBS detronyx_12t_2w2r_rc4_4x4_routed_5layer_direct
Xu_t027_003 u_t027_003/c0_w0_bl u_t027_003/c0_w0_br u_t027_003/c0_w1_bl u_t027_003/c0_w1_br
+ u_t027_003/c0_r0_rbl u_t027_003/c0_r1_rbl u_t027_003/c1_w0_bl u_t027_003/c1_w0_br
+ u_t027_003/c1_w1_bl u_t027_003/c1_w1_br u_t027_003/c1_r0_rbl u_t027_003/c1_r1_rbl
+ u_t027_003/c2_w0_bl u_t027_003/c2_w0_br u_t027_003/c2_w1_bl u_t027_003/c2_w1_br
+ u_t027_003/c2_r0_rbl u_t027_003/c2_r1_rbl u_t027_003/c3_w0_bl u_t027_003/c3_w0_br
+ u_t027_003/c3_w1_bl u_t027_003/c3_w1_br u_t027_003/c3_r0_rbl u_t027_003/c3_r1_rbl
+ u_t027_003/r0_w0_wl u_t027_003/r0_w1_wl u_t027_003/r0_r0_rwl u_t027_003/r0_r1_rwl
+ u_t027_003/r1_w0_wl u_t027_003/r1_w1_wl u_t027_003/r1_r0_rwl u_t027_003/r1_r1_rwl
+ u_t027_003/r2_w0_wl u_t027_003/r2_w1_wl u_t027_003/r2_r0_rwl u_t027_003/r2_r1_rwl
+ u_t027_003/r3_w0_wl u_t027_003/r3_w1_wl u_t027_003/r3_r0_rwl u_t027_003/r3_r1_rwl
+ VSS VSS u_t027_003/m2_717_1265# u_t027_003/m2_603_2031# u_t027_003/m2_1290_336#
+ u_t027_003/m2_2000_2037# u_t027_003/m2_791_2909# u_t027_003/m2_7_2126# u_t027_003/m2_2154_2081#
+ u_t027_003/m2_1795_2037# u_t027_003/m2_871_303# u_t027_003/m2_431_438# u_t027_003/m2_1290_2898#
+ u_t027_003/m2_1714_1210# u_t027_003/m2_431_1982# u_t027_003/m2_512_1265# u_t027_003/m2_2573_2126#
+ u_t027_003/m2_603_1259# u_t027_003/m2_2074_2909# u_t027_003/m2_7_336# u_t027_003/m2_717_2037#
+ u_t027_003/m2_1886_2031# u_t027_003/m2_2573_336# u_t027_003/m2_7_2898# u_t027_003/m2_2000_1265#
+ u_t027_003/m2_512_2037# u_t027_003/m2_1795_1265# u_t027_003/m2_1714_1982# u_t027_003/m2_1886_1259#
+ u_t027_003/m2_1290_2126# u_t027_003/m2_1714_438# u_t027_003/m2_431_1210# u_t027_003/m2_2573_2898#
+ u_t027_003/m2_2154_303# u_t027_003/m2_871_2081# VSUBS detronyx_12t_2w2r_rc4_4x4_routed_5layer_direct
Xu_t018_014 u_t018_014/c0_w0_bl u_t018_014/c0_w0_br u_t018_014/c0_w1_bl u_t018_014/c0_w1_br
+ u_t018_014/c0_r0_rbl u_t018_014/c0_r1_rbl u_t018_014/c1_w0_bl u_t018_014/c1_w0_br
+ u_t018_014/c1_w1_bl u_t018_014/c1_w1_br u_t018_014/c1_r0_rbl u_t018_014/c1_r1_rbl
+ u_t018_014/c2_w0_bl u_t018_014/c2_w0_br u_t018_014/c2_w1_bl u_t018_014/c2_w1_br
+ u_t018_014/c2_r0_rbl u_t018_014/c2_r1_rbl u_t018_014/c3_w0_bl u_t018_014/c3_w0_br
+ u_t018_014/c3_w1_bl u_t018_014/c3_w1_br u_t018_014/c3_r0_rbl u_t018_014/c3_r1_rbl
+ u_t018_014/r0_w0_wl u_t018_014/r0_w1_wl u_t018_014/r0_r0_rwl u_t018_014/r0_r1_rwl
+ u_t018_014/r1_w0_wl u_t018_014/r1_w1_wl u_t018_014/r1_r0_rwl u_t018_014/r1_r1_rwl
+ u_t018_014/r2_w0_wl u_t018_014/r2_w1_wl u_t018_014/r2_r0_rwl u_t018_014/r2_r1_rwl
+ u_t018_014/r3_w0_wl u_t018_014/r3_w1_wl u_t018_014/r3_r0_rwl u_t018_014/r3_r1_rwl
+ VSS VSS u_t018_014/m2_717_1265# u_t018_014/m2_603_2031# u_t018_014/m2_1290_336#
+ u_t018_014/m2_2000_2037# u_t018_014/m2_791_2909# u_t018_014/m2_7_2126# u_t018_014/m2_2154_2081#
+ u_t018_014/m2_1795_2037# u_t018_014/m2_871_303# u_t018_014/m2_431_438# u_t018_014/m2_1290_2898#
+ u_t018_014/m2_1714_1210# u_t018_014/m2_431_1982# u_t018_014/m2_512_1265# u_t018_014/m2_2573_2126#
+ u_t018_014/m2_603_1259# u_t018_014/m2_2074_2909# u_t018_014/m2_7_336# u_t018_014/m2_717_2037#
+ u_t018_014/m2_1886_2031# u_t018_014/m2_2573_336# u_t018_014/m2_7_2898# u_t018_014/m2_2000_1265#
+ u_t018_014/m2_512_2037# u_t018_014/m2_1795_1265# u_t018_014/m2_1714_1982# u_t018_014/m2_1886_1259#
+ u_t018_014/m2_1290_2126# u_t018_014/m2_1714_438# u_t018_014/m2_431_1210# u_t018_014/m2_2573_2898#
+ u_t018_014/m2_2154_303# u_t018_014/m2_871_2081# VSUBS detronyx_12t_2w2r_rc4_4x4_routed_5layer_direct
Xu_t018_003 u_t018_003/c0_w0_bl u_t018_003/c0_w0_br u_t018_003/c0_w1_bl u_t018_003/c0_w1_br
+ u_t018_003/c0_r0_rbl u_t018_003/c0_r1_rbl u_t018_003/c1_w0_bl u_t018_003/c1_w0_br
+ u_t018_003/c1_w1_bl u_t018_003/c1_w1_br u_t018_003/c1_r0_rbl u_t018_003/c1_r1_rbl
+ u_t018_003/c2_w0_bl u_t018_003/c2_w0_br u_t018_003/c2_w1_bl u_t018_003/c2_w1_br
+ u_t018_003/c2_r0_rbl u_t018_003/c2_r1_rbl u_t018_003/c3_w0_bl u_t018_003/c3_w0_br
+ u_t018_003/c3_w1_bl u_t018_003/c3_w1_br u_t018_003/c3_r0_rbl u_t018_003/c3_r1_rbl
+ u_t018_003/r0_w0_wl u_t018_003/r0_w1_wl u_t018_003/r0_r0_rwl u_t018_003/r0_r1_rwl
+ u_t018_003/r1_w0_wl u_t018_003/r1_w1_wl u_t018_003/r1_r0_rwl u_t018_003/r1_r1_rwl
+ u_t018_003/r2_w0_wl u_t018_003/r2_w1_wl u_t018_003/r2_r0_rwl u_t018_003/r2_r1_rwl
+ u_t018_003/r3_w0_wl u_t018_003/r3_w1_wl u_t018_003/r3_r0_rwl u_t018_003/r3_r1_rwl
+ VSS VSS u_t018_003/m2_717_1265# u_t018_003/m2_603_2031# u_t018_003/m2_1290_336#
+ u_t018_003/m2_2000_2037# u_t018_003/m2_791_2909# u_t018_003/m2_7_2126# u_t018_003/m2_2154_2081#
+ u_t018_003/m2_1795_2037# u_t018_003/m2_871_303# u_t018_003/m2_431_438# u_t018_003/m2_1290_2898#
+ u_t018_003/m2_1714_1210# u_t018_003/m2_431_1982# u_t018_003/m2_512_1265# u_t018_003/m2_2573_2126#
+ u_t018_003/m2_603_1259# u_t018_003/m2_2074_2909# u_t018_003/m2_7_336# u_t018_003/m2_717_2037#
+ u_t018_003/m2_1886_2031# u_t018_003/m2_2573_336# u_t018_003/m2_7_2898# u_t018_003/m2_2000_1265#
+ u_t018_003/m2_512_2037# u_t018_003/m2_1795_1265# u_t018_003/m2_1714_1982# u_t018_003/m2_1886_1259#
+ u_t018_003/m2_1290_2126# u_t018_003/m2_1714_438# u_t018_003/m2_431_1210# u_t018_003/m2_2573_2898#
+ u_t018_003/m2_2154_303# u_t018_003/m2_871_2081# VSUBS detronyx_12t_2w2r_rc4_4x4_routed_5layer_direct
Xu_t009_014 u_t009_014/c0_w0_bl u_t009_014/c0_w0_br u_t009_014/c0_w1_bl u_t009_014/c0_w1_br
+ u_t009_014/c0_r0_rbl u_t009_014/c0_r1_rbl u_t009_014/c1_w0_bl u_t009_014/c1_w0_br
+ u_t009_014/c1_w1_bl u_t009_014/c1_w1_br u_t009_014/c1_r0_rbl u_t009_014/c1_r1_rbl
+ u_t009_014/c2_w0_bl u_t009_014/c2_w0_br u_t009_014/c2_w1_bl u_t009_014/c2_w1_br
+ u_t009_014/c2_r0_rbl u_t009_014/c2_r1_rbl u_t009_014/c3_w0_bl u_t009_014/c3_w0_br
+ u_t009_014/c3_w1_bl u_t009_014/c3_w1_br u_t009_014/c3_r0_rbl u_t009_014/c3_r1_rbl
+ u_t009_014/r0_w0_wl u_t009_014/r0_w1_wl u_t009_014/r0_r0_rwl u_t009_014/r0_r1_rwl
+ u_t009_014/r1_w0_wl u_t009_014/r1_w1_wl u_t009_014/r1_r0_rwl u_t009_014/r1_r1_rwl
+ u_t009_014/r2_w0_wl u_t009_014/r2_w1_wl u_t009_014/r2_r0_rwl u_t009_014/r2_r1_rwl
+ u_t009_014/r3_w0_wl u_t009_014/r3_w1_wl u_t009_014/r3_r0_rwl u_t009_014/r3_r1_rwl
+ VSS VSS u_t009_014/m2_717_1265# u_t009_014/m2_603_2031# u_t009_014/m2_1290_336#
+ u_t009_014/m2_2000_2037# u_t009_014/m2_791_2909# u_t009_014/m2_7_2126# u_t009_014/m2_2154_2081#
+ u_t009_014/m2_1795_2037# u_t009_014/m2_871_303# u_t009_014/m2_431_438# u_t009_014/m2_1290_2898#
+ u_t009_014/m2_1714_1210# u_t009_014/m2_431_1982# u_t009_014/m2_512_1265# u_t009_014/m2_2573_2126#
+ u_t009_014/m2_603_1259# u_t009_014/m2_2074_2909# u_t009_014/m2_7_336# u_t009_014/m2_717_2037#
+ u_t009_014/m2_1886_2031# u_t009_014/m2_2573_336# u_t009_014/m2_7_2898# u_t009_014/m2_2000_1265#
+ u_t009_014/m2_512_2037# u_t009_014/m2_1795_1265# u_t009_014/m2_1714_1982# u_t009_014/m2_1886_1259#
+ u_t009_014/m2_1290_2126# u_t009_014/m2_1714_438# u_t009_014/m2_431_1210# u_t009_014/m2_2573_2898#
+ u_t009_014/m2_2154_303# u_t009_014/m2_871_2081# VSUBS detronyx_12t_2w2r_rc4_4x4_routed_5layer_direct
Xu_t009_003 u_t009_003/c0_w0_bl u_t009_003/c0_w0_br u_t009_003/c0_w1_bl u_t009_003/c0_w1_br
+ u_t009_003/c0_r0_rbl u_t009_003/c0_r1_rbl u_t009_003/c1_w0_bl u_t009_003/c1_w0_br
+ u_t009_003/c1_w1_bl u_t009_003/c1_w1_br u_t009_003/c1_r0_rbl u_t009_003/c1_r1_rbl
+ u_t009_003/c2_w0_bl u_t009_003/c2_w0_br u_t009_003/c2_w1_bl u_t009_003/c2_w1_br
+ u_t009_003/c2_r0_rbl u_t009_003/c2_r1_rbl u_t009_003/c3_w0_bl u_t009_003/c3_w0_br
+ u_t009_003/c3_w1_bl u_t009_003/c3_w1_br u_t009_003/c3_r0_rbl u_t009_003/c3_r1_rbl
+ u_t009_003/r0_w0_wl u_t009_003/r0_w1_wl u_t009_003/r0_r0_rwl u_t009_003/r0_r1_rwl
+ u_t009_003/r1_w0_wl u_t009_003/r1_w1_wl u_t009_003/r1_r0_rwl u_t009_003/r1_r1_rwl
+ u_t009_003/r2_w0_wl u_t009_003/r2_w1_wl u_t009_003/r2_r0_rwl u_t009_003/r2_r1_rwl
+ u_t009_003/r3_w0_wl u_t009_003/r3_w1_wl u_t009_003/r3_r0_rwl u_t009_003/r3_r1_rwl
+ VSS VSS u_t009_003/m2_717_1265# u_t009_003/m2_603_2031# u_t009_003/m2_1290_336#
+ u_t009_003/m2_2000_2037# u_t009_003/m2_791_2909# u_t009_003/m2_7_2126# u_t009_003/m2_2154_2081#
+ u_t009_003/m2_1795_2037# u_t009_003/m2_871_303# u_t009_003/m2_431_438# u_t009_003/m2_1290_2898#
+ u_t009_003/m2_1714_1210# u_t009_003/m2_431_1982# u_t009_003/m2_512_1265# u_t009_003/m2_2573_2126#
+ u_t009_003/m2_603_1259# u_t009_003/m2_2074_2909# u_t009_003/m2_7_336# u_t009_003/m2_717_2037#
+ u_t009_003/m2_1886_2031# u_t009_003/m2_2573_336# u_t009_003/m2_7_2898# u_t009_003/m2_2000_1265#
+ u_t009_003/m2_512_2037# u_t009_003/m2_1795_1265# u_t009_003/m2_1714_1982# u_t009_003/m2_1886_1259#
+ u_t009_003/m2_1290_2126# u_t009_003/m2_1714_438# u_t009_003/m2_431_1210# u_t009_003/m2_2573_2898#
+ u_t009_003/m2_2154_303# u_t009_003/m2_871_2081# VSUBS detronyx_12t_2w2r_rc4_4x4_routed_5layer_direct
Xgf180mcu_as_sc_mcu7t3v3__nand3_2_18 gf180mcu_as_sc_mcu7t3v3__nor2_2_6/VDD gf180mcu_as_sc_mcu7t3v3__nand3_2_4/VSS
+ VSS VSS VSS VSS gf180mcu_as_sc_mcu7t3v3__nor2_2_6/VNW VSUBS gf180mcu_as_sc_mcu7t3v3__nand3_2
Xgf180mcu_as_sc_mcu7t3v3__nand3_2_29 gf180mcu_as_sc_mcu7t3v3__nand3_2_9/VDD gf180mcu_as_sc_mcu7t3v3__nor2_2_7/VSS
+ VSS VSS VSS VSS gf180mcu_as_sc_mcu7t3v3__nand3_2_9/VNW VSUBS gf180mcu_as_sc_mcu7t3v3__nand3_2
Xu_t024_006 u_t024_006/c0_w0_bl u_t024_006/c0_w0_br u_t024_006/c0_w1_bl u_t024_006/c0_w1_br
+ u_t024_006/c0_r0_rbl u_t024_006/c0_r1_rbl u_t024_006/c1_w0_bl u_t024_006/c1_w0_br
+ u_t024_006/c1_w1_bl u_t024_006/c1_w1_br u_t024_006/c1_r0_rbl u_t024_006/c1_r1_rbl
+ u_t024_006/c2_w0_bl u_t024_006/c2_w0_br u_t024_006/c2_w1_bl u_t024_006/c2_w1_br
+ u_t024_006/c2_r0_rbl u_t024_006/c2_r1_rbl u_t024_006/c3_w0_bl u_t024_006/c3_w0_br
+ u_t024_006/c3_w1_bl u_t024_006/c3_w1_br u_t024_006/c3_r0_rbl u_t024_006/c3_r1_rbl
+ u_t024_006/r0_w0_wl u_t024_006/r0_w1_wl u_t024_006/r0_r0_rwl u_t024_006/r0_r1_rwl
+ u_t024_006/r1_w0_wl u_t024_006/r1_w1_wl u_t024_006/r1_r0_rwl u_t024_006/r1_r1_rwl
+ u_t024_006/r2_w0_wl u_t024_006/r2_w1_wl u_t024_006/r2_r0_rwl u_t024_006/r2_r1_rwl
+ u_t024_006/r3_w0_wl u_t024_006/r3_w1_wl u_t024_006/r3_r0_rwl u_t024_006/r3_r1_rwl
+ VSS VSS u_t024_006/m2_717_1265# u_t024_006/m2_603_2031# u_t024_006/m2_1290_336#
+ u_t024_006/m2_2000_2037# u_t024_006/m2_791_2909# u_t024_006/m2_7_2126# u_t024_006/m2_2154_2081#
+ u_t024_006/m2_1795_2037# u_t024_006/m2_871_303# u_t024_006/m2_431_438# u_t024_006/m2_1290_2898#
+ u_t024_006/m2_1714_1210# u_t024_006/m2_431_1982# u_t024_006/m2_512_1265# u_t024_006/m2_2573_2126#
+ u_t024_006/m2_603_1259# u_t024_006/m2_2074_2909# u_t024_006/m2_7_336# u_t024_006/m2_717_2037#
+ u_t024_006/m2_1886_2031# u_t024_006/m2_2573_336# u_t024_006/m2_7_2898# u_t024_006/m2_2000_1265#
+ u_t024_006/m2_512_2037# u_t024_006/m2_1795_1265# u_t024_006/m2_1714_1982# u_t024_006/m2_1886_1259#
+ u_t024_006/m2_1290_2126# u_t024_006/m2_1714_438# u_t024_006/m2_431_1210# u_t024_006/m2_2573_2898#
+ u_t024_006/m2_2154_303# u_t024_006/m2_871_2081# VSUBS detronyx_12t_2w2r_rc4_4x4_routed_5layer_direct
Xgf180mcu_as_sc_mcu7t3v3__inv_2_150 VSS VSS VSS gf180mcu_as_sc_mcu7t3v3__inv_2_151/Y
+ gf180mcu_as_sc_mcu7t3v3__inv_2_152/VNW VSUBS gf180mcu_as_sc_mcu7t3v3__inv_2
Xgf180mcu_as_sc_mcu7t3v3__inv_2_172 VSS VSS VSS gf180mcu_as_sc_mcu7t3v3__inv_2_173/Y
+ gf180mcu_as_sc_mcu7t3v3__inv_2_174/VNW VSUBS gf180mcu_as_sc_mcu7t3v3__inv_2
Xgf180mcu_as_sc_mcu7t3v3__inv_2_194 VSS VSS VSS gf180mcu_as_sc_mcu7t3v3__inv_2_195/Y
+ gf180mcu_as_sc_mcu7t3v3__inv_2_196/VNW VSUBS gf180mcu_as_sc_mcu7t3v3__inv_2
Xgf180mcu_as_sc_mcu7t3v3__inv_2_183 VSS VSS VSS gf180mcu_as_sc_mcu7t3v3__inv_2_184/Y
+ gf180mcu_as_sc_mcu7t3v3__inv_2_197/VNW VSUBS gf180mcu_as_sc_mcu7t3v3__inv_2
Xgf180mcu_as_sc_mcu7t3v3__inv_2_161 VSS VSS VSS gf180mcu_as_sc_mcu7t3v3__inv_2_162/Y
+ gf180mcu_as_sc_mcu7t3v3__inv_2_163/VNW VSUBS gf180mcu_as_sc_mcu7t3v3__inv_2
Xgf180mcu_as_sc_mcu7t3v3__inv_2_1638 VSS VSS gf180mcu_as_sc_mcu7t3v3__inv_2_1638/Y
+ gf180mcu_as_sc_mcu7t3v3__inv_2_1638/A gf180mcu_as_sc_mcu7t3v3__inv_2_1638/VNW VSUBS
+ gf180mcu_as_sc_mcu7t3v3__inv_2
Xgf180mcu_as_sc_mcu7t3v3__inv_2_1649 VSS VSS gf180mcu_as_sc_mcu7t3v3__inv_2_1649/Y
+ gf180mcu_as_sc_mcu7t3v3__inv_2_1649/A gf180mcu_as_sc_mcu7t3v3__inv_2_1649/VNW VSUBS
+ gf180mcu_as_sc_mcu7t3v3__inv_2
Xgf180mcu_as_sc_mcu7t3v3__inv_2_1627 VSS VSS gf180mcu_as_sc_mcu7t3v3__inv_2_1627/Y
+ gf180mcu_as_sc_mcu7t3v3__inv_2_1627/A gf180mcu_as_sc_mcu7t3v3__inv_2_1627/VNW VSUBS
+ gf180mcu_as_sc_mcu7t3v3__inv_2
Xgf180mcu_as_sc_mcu7t3v3__inv_2_1605 VSS VSS gf180mcu_as_sc_mcu7t3v3__inv_2_1605/Y
+ gf180mcu_as_sc_mcu7t3v3__inv_2_1606/Y gf180mcu_as_sc_mcu7t3v3__inv_2_1606/VNW VSUBS
+ gf180mcu_as_sc_mcu7t3v3__inv_2
Xgf180mcu_as_sc_mcu7t3v3__inv_2_1616 VSS VSS VSS gf180mcu_as_sc_mcu7t3v3__inv_2_1617/Y
+ gf180mcu_as_sc_mcu7t3v3__inv_2_1618/VNW VSUBS gf180mcu_as_sc_mcu7t3v3__inv_2
Xu_t015_006 u_t015_006/c0_w0_bl u_t015_006/c0_w0_br u_t015_006/c0_w1_bl u_t015_006/c0_w1_br
+ u_t015_006/c0_r0_rbl u_t015_006/c0_r1_rbl u_t015_006/c1_w0_bl u_t015_006/c1_w0_br
+ u_t015_006/c1_w1_bl u_t015_006/c1_w1_br u_t015_006/c1_r0_rbl u_t015_006/c1_r1_rbl
+ u_t015_006/c2_w0_bl u_t015_006/c2_w0_br u_t015_006/c2_w1_bl u_t015_006/c2_w1_br
+ u_t015_006/c2_r0_rbl u_t015_006/c2_r1_rbl u_t015_006/c3_w0_bl u_t015_006/c3_w0_br
+ u_t015_006/c3_w1_bl u_t015_006/c3_w1_br u_t015_006/c3_r0_rbl u_t015_006/c3_r1_rbl
+ u_t015_006/r0_w0_wl u_t015_006/r0_w1_wl u_t015_006/r0_r0_rwl u_t015_006/r0_r1_rwl
+ u_t015_006/r1_w0_wl u_t015_006/r1_w1_wl u_t015_006/r1_r0_rwl u_t015_006/r1_r1_rwl
+ u_t015_006/r2_w0_wl u_t015_006/r2_w1_wl u_t015_006/r2_r0_rwl u_t015_006/r2_r1_rwl
+ u_t015_006/r3_w0_wl u_t015_006/r3_w1_wl u_t015_006/r3_r0_rwl u_t015_006/r3_r1_rwl
+ VSS VSS u_t015_006/m2_717_1265# u_t015_006/m2_603_2031# u_t015_006/m2_1290_336#
+ u_t015_006/m2_2000_2037# u_t015_006/m2_791_2909# u_t015_006/m2_7_2126# u_t015_006/m2_2154_2081#
+ u_t015_006/m2_1795_2037# u_t015_006/m2_871_303# u_t015_006/m2_431_438# u_t015_006/m2_1290_2898#
+ u_t015_006/m2_1714_1210# u_t015_006/m2_431_1982# u_t015_006/m2_512_1265# u_t015_006/m2_2573_2126#
+ u_t015_006/m2_603_1259# u_t015_006/m2_2074_2909# u_t015_006/m2_7_336# u_t015_006/m2_717_2037#
+ u_t015_006/m2_1886_2031# u_t015_006/m2_2573_336# u_t015_006/m2_7_2898# u_t015_006/m2_2000_1265#
+ u_t015_006/m2_512_2037# u_t015_006/m2_1795_1265# u_t015_006/m2_1714_1982# u_t015_006/m2_1886_1259#
+ u_t015_006/m2_1290_2126# u_t015_006/m2_1714_438# u_t015_006/m2_431_1210# u_t015_006/m2_2573_2898#
+ u_t015_006/m2_2154_303# u_t015_006/m2_871_2081# VSUBS detronyx_12t_2w2r_rc4_4x4_routed_5layer_direct
Xu_t030_009 u_t030_009/c0_w0_bl u_t030_009/c0_w0_br u_t030_009/c0_w1_bl u_t030_009/c0_w1_br
+ u_t030_009/c0_r0_rbl u_t030_009/c0_r1_rbl u_t030_009/c1_w0_bl u_t030_009/c1_w0_br
+ u_t030_009/c1_w1_bl u_t030_009/c1_w1_br u_t030_009/c1_r0_rbl u_t030_009/c1_r1_rbl
+ u_t030_009/c2_w0_bl u_t030_009/c2_w0_br u_t030_009/c2_w1_bl u_t030_009/c2_w1_br
+ u_t030_009/c2_r0_rbl u_t030_009/c2_r1_rbl u_t030_009/c3_w0_bl u_t030_009/c3_w0_br
+ u_t030_009/c3_w1_bl u_t030_009/c3_w1_br u_t030_009/c3_r0_rbl u_t030_009/c3_r1_rbl
+ u_t030_009/r0_w0_wl u_t030_009/r0_w1_wl u_t030_009/r0_r0_rwl u_t030_009/r0_r1_rwl
+ u_t030_009/r1_w0_wl u_t030_009/r1_w1_wl u_t030_009/r1_r0_rwl u_t030_009/r1_r1_rwl
+ u_t030_009/r2_w0_wl u_t030_009/r2_w1_wl u_t030_009/r2_r0_rwl u_t030_009/r2_r1_rwl
+ u_t030_009/r3_w0_wl u_t030_009/r3_w1_wl u_t030_009/r3_r0_rwl u_t030_009/r3_r1_rwl
+ VSS VSS u_t030_009/m2_717_1265# u_t030_009/m2_603_2031# u_t030_009/m2_1290_336#
+ u_t030_009/m2_2000_2037# u_t030_009/m2_791_2909# u_t030_009/m2_7_2126# u_t030_009/m2_2154_2081#
+ u_t030_009/m2_1795_2037# u_t030_009/m2_871_303# u_t030_009/m2_431_438# u_t030_009/m2_1290_2898#
+ u_t030_009/m2_1714_1210# u_t030_009/m2_431_1982# u_t030_009/m2_512_1265# u_t030_009/m2_2573_2126#
+ u_t030_009/m2_603_1259# u_t030_009/m2_2074_2909# u_t030_009/m2_7_336# u_t030_009/m2_717_2037#
+ u_t030_009/m2_1886_2031# u_t030_009/m2_2573_336# u_t030_009/m2_7_2898# u_t030_009/m2_2000_1265#
+ u_t030_009/m2_512_2037# u_t030_009/m2_1795_1265# u_t030_009/m2_1714_1982# u_t030_009/m2_1886_1259#
+ u_t030_009/m2_1290_2126# u_t030_009/m2_1714_438# u_t030_009/m2_431_1210# u_t030_009/m2_2573_2898#
+ u_t030_009/m2_2154_303# u_t030_009/m2_871_2081# VSUBS detronyx_12t_2w2r_rc4_4x4_routed_5layer_direct
Xu_t021_009 u_t021_009/c0_w0_bl u_t021_009/c0_w0_br u_t021_009/c0_w1_bl u_t021_009/c0_w1_br
+ u_t021_009/c0_r0_rbl u_t021_009/c0_r1_rbl u_t021_009/c1_w0_bl u_t021_009/c1_w0_br
+ u_t021_009/c1_w1_bl u_t021_009/c1_w1_br u_t021_009/c1_r0_rbl u_t021_009/c1_r1_rbl
+ u_t021_009/c2_w0_bl u_t021_009/c2_w0_br u_t021_009/c2_w1_bl u_t021_009/c2_w1_br
+ u_t021_009/c2_r0_rbl u_t021_009/c2_r1_rbl u_t021_009/c3_w0_bl u_t021_009/c3_w0_br
+ u_t021_009/c3_w1_bl u_t021_009/c3_w1_br u_t021_009/c3_r0_rbl u_t021_009/c3_r1_rbl
+ u_t021_009/r0_w0_wl u_t021_009/r0_w1_wl u_t021_009/r0_r0_rwl u_t021_009/r0_r1_rwl
+ u_t021_009/r1_w0_wl u_t021_009/r1_w1_wl u_t021_009/r1_r0_rwl u_t021_009/r1_r1_rwl
+ u_t021_009/r2_w0_wl u_t021_009/r2_w1_wl u_t021_009/r2_r0_rwl u_t021_009/r2_r1_rwl
+ u_t021_009/r3_w0_wl u_t021_009/r3_w1_wl u_t021_009/r3_r0_rwl u_t021_009/r3_r1_rwl
+ VSS VSS u_t021_009/m2_717_1265# u_t021_009/m2_603_2031# u_t021_009/m2_1290_336#
+ u_t021_009/m2_2000_2037# u_t021_009/m2_791_2909# u_t021_009/m2_7_2126# u_t021_009/m2_2154_2081#
+ u_t021_009/m2_1795_2037# u_t021_009/m2_871_303# u_t021_009/m2_431_438# u_t021_009/m2_1290_2898#
+ u_t021_009/m2_1714_1210# u_t021_009/m2_431_1982# u_t021_009/m2_512_1265# u_t021_009/m2_2573_2126#
+ u_t021_009/m2_603_1259# u_t021_009/m2_2074_2909# u_t021_009/m2_7_336# u_t021_009/m2_717_2037#
+ u_t021_009/m2_1886_2031# u_t021_009/m2_2573_336# u_t021_009/m2_7_2898# u_t021_009/m2_2000_1265#
+ u_t021_009/m2_512_2037# u_t021_009/m2_1795_1265# u_t021_009/m2_1714_1982# u_t021_009/m2_1886_1259#
+ u_t021_009/m2_1290_2126# u_t021_009/m2_1714_438# u_t021_009/m2_431_1210# u_t021_009/m2_2573_2898#
+ u_t021_009/m2_2154_303# u_t021_009/m2_871_2081# VSUBS detronyx_12t_2w2r_rc4_4x4_routed_5layer_direct
Xu_t006_006 u_t006_006/c0_w0_bl u_t006_006/c0_w0_br u_t006_006/c0_w1_bl u_t006_006/c0_w1_br
+ u_t006_006/c0_r0_rbl u_t006_006/c0_r1_rbl u_t006_006/c1_w0_bl u_t006_006/c1_w0_br
+ u_t006_006/c1_w1_bl u_t006_006/c1_w1_br u_t006_006/c1_r0_rbl u_t006_006/c1_r1_rbl
+ u_t006_006/c2_w0_bl u_t006_006/c2_w0_br u_t006_006/c2_w1_bl u_t006_006/c2_w1_br
+ u_t006_006/c2_r0_rbl u_t006_006/c2_r1_rbl u_t006_006/c3_w0_bl u_t006_006/c3_w0_br
+ u_t006_006/c3_w1_bl u_t006_006/c3_w1_br u_t006_006/c3_r0_rbl u_t006_006/c3_r1_rbl
+ u_t006_006/r0_w0_wl u_t006_006/r0_w1_wl u_t006_006/r0_r0_rwl u_t006_006/r0_r1_rwl
+ u_t006_006/r1_w0_wl u_t006_006/r1_w1_wl u_t006_006/r1_r0_rwl u_t006_006/r1_r1_rwl
+ u_t006_006/r2_w0_wl u_t006_006/r2_w1_wl u_t006_006/r2_r0_rwl u_t006_006/r2_r1_rwl
+ u_t006_006/r3_w0_wl u_t006_006/r3_w1_wl u_t006_006/r3_r0_rwl u_t006_006/r3_r1_rwl
+ VSS VSS u_t006_006/m2_717_1265# u_t006_006/m2_603_2031# u_t006_006/m2_1290_336#
+ u_t006_006/m2_2000_2037# u_t006_006/m2_791_2909# u_t006_006/m2_7_2126# u_t006_006/m2_2154_2081#
+ u_t006_006/m2_1795_2037# u_t006_006/m2_871_303# u_t006_006/m2_431_438# u_t006_006/m2_1290_2898#
+ u_t006_006/m2_1714_1210# u_t006_006/m2_431_1982# u_t006_006/m2_512_1265# u_t006_006/m2_2573_2126#
+ u_t006_006/m2_603_1259# u_t006_006/m2_2074_2909# u_t006_006/m2_7_336# u_t006_006/m2_717_2037#
+ u_t006_006/m2_1886_2031# u_t006_006/m2_2573_336# u_t006_006/m2_7_2898# u_t006_006/m2_2000_1265#
+ u_t006_006/m2_512_2037# u_t006_006/m2_1795_1265# u_t006_006/m2_1714_1982# u_t006_006/m2_1886_1259#
+ u_t006_006/m2_1290_2126# u_t006_006/m2_1714_438# u_t006_006/m2_431_1210# u_t006_006/m2_2573_2898#
+ u_t006_006/m2_2154_303# u_t006_006/m2_871_2081# VSUBS detronyx_12t_2w2r_rc4_4x4_routed_5layer_direct
Xgf180mcu_as_sc_mcu7t3v3__nand2_2_51 gf180mcu_as_sc_mcu7t3v3__nand3_2_65/VDD gf180mcu_as_sc_mcu7t3v3__nor2_2_9/VSS
+ VSS VSS VSS gf180mcu_as_sc_mcu7t3v3__nand3_2_65/VNW VSUBS gf180mcu_as_sc_mcu7t3v3__nand2_2
Xgf180mcu_as_sc_mcu7t3v3__nand2_2_40 gf180mcu_as_sc_mcu7t3v3__nand3_2_65/VDD gf180mcu_as_sc_mcu7t3v3__nand3_2_62/VSS
+ VSS VSS VSS gf180mcu_as_sc_mcu7t3v3__nand3_2_65/VNW VSUBS gf180mcu_as_sc_mcu7t3v3__nand2_2
Xu_t012_009 u_t012_009/c0_w0_bl u_t012_009/c0_w0_br u_t012_009/c0_w1_bl u_t012_009/c0_w1_br
+ u_t012_009/c0_r0_rbl u_t012_009/c0_r1_rbl u_t012_009/c1_w0_bl u_t012_009/c1_w0_br
+ u_t012_009/c1_w1_bl u_t012_009/c1_w1_br u_t012_009/c1_r0_rbl u_t012_009/c1_r1_rbl
+ u_t012_009/c2_w0_bl u_t012_009/c2_w0_br u_t012_009/c2_w1_bl u_t012_009/c2_w1_br
+ u_t012_009/c2_r0_rbl u_t012_009/c2_r1_rbl u_t012_009/c3_w0_bl u_t012_009/c3_w0_br
+ u_t012_009/c3_w1_bl u_t012_009/c3_w1_br u_t012_009/c3_r0_rbl u_t012_009/c3_r1_rbl
+ u_t012_009/r0_w0_wl u_t012_009/r0_w1_wl u_t012_009/r0_r0_rwl u_t012_009/r0_r1_rwl
+ u_t012_009/r1_w0_wl u_t012_009/r1_w1_wl u_t012_009/r1_r0_rwl u_t012_009/r1_r1_rwl
+ u_t012_009/r2_w0_wl u_t012_009/r2_w1_wl u_t012_009/r2_r0_rwl u_t012_009/r2_r1_rwl
+ u_t012_009/r3_w0_wl u_t012_009/r3_w1_wl u_t012_009/r3_r0_rwl u_t012_009/r3_r1_rwl
+ VSS VSS u_t012_009/m2_717_1265# u_t012_009/m2_603_2031# u_t012_009/m2_1290_336#
+ u_t012_009/m2_2000_2037# u_t012_009/m2_791_2909# u_t012_009/m2_7_2126# u_t012_009/m2_2154_2081#
+ u_t012_009/m2_1795_2037# u_t012_009/m2_871_303# u_t012_009/m2_431_438# u_t012_009/m2_1290_2898#
+ u_t012_009/m2_1714_1210# u_t012_009/m2_431_1982# u_t012_009/m2_512_1265# u_t012_009/m2_2573_2126#
+ u_t012_009/m2_603_1259# u_t012_009/m2_2074_2909# u_t012_009/m2_7_336# u_t012_009/m2_717_2037#
+ u_t012_009/m2_1886_2031# u_t012_009/m2_2573_336# u_t012_009/m2_7_2898# u_t012_009/m2_2000_1265#
+ u_t012_009/m2_512_2037# u_t012_009/m2_1795_1265# u_t012_009/m2_1714_1982# u_t012_009/m2_1886_1259#
+ u_t012_009/m2_1290_2126# u_t012_009/m2_1714_438# u_t012_009/m2_431_1210# u_t012_009/m2_2573_2898#
+ u_t012_009/m2_2154_303# u_t012_009/m2_871_2081# VSUBS detronyx_12t_2w2r_rc4_4x4_routed_5layer_direct
Xgf180mcu_as_sc_mcu7t3v3__inv_2_1402 VSS VSS gf180mcu_as_sc_mcu7t3v3__inv_2_1402/Y
+ gf180mcu_as_sc_mcu7t3v3__inv_2_1402/A gf180mcu_as_sc_mcu7t3v3__inv_2_1402/VNW VSUBS
+ gf180mcu_as_sc_mcu7t3v3__inv_2
Xgf180mcu_as_sc_mcu7t3v3__inv_2_1413 VSS VSS gf180mcu_as_sc_mcu7t3v3__inv_2_1413/Y
+ gf180mcu_as_sc_mcu7t3v3__inv_2_1413/A gf180mcu_as_sc_mcu7t3v3__inv_2_1413/VNW VSUBS
+ gf180mcu_as_sc_mcu7t3v3__inv_2
Xgf180mcu_as_sc_mcu7t3v3__inv_2_1435 VSS VSS VSS gf180mcu_as_sc_mcu7t3v3__inv_2_1436/Y
+ gf180mcu_as_sc_mcu7t3v3__inv_2_1437/VNW VSUBS gf180mcu_as_sc_mcu7t3v3__inv_2
Xgf180mcu_as_sc_mcu7t3v3__inv_2_1424 VSS VSS gf180mcu_as_sc_mcu7t3v3__inv_2_1424/Y
+ gf180mcu_as_sc_mcu7t3v3__inv_2_1425/Y gf180mcu_as_sc_mcu7t3v3__inv_2_1425/VNW VSUBS
+ gf180mcu_as_sc_mcu7t3v3__inv_2
Xgf180mcu_as_sc_mcu7t3v3__inv_2_1468 VSS VSS VSS gf180mcu_as_sc_mcu7t3v3__inv_2_1469/Y
+ gf180mcu_as_sc_mcu7t3v3__inv_2_1470/VNW VSUBS gf180mcu_as_sc_mcu7t3v3__inv_2
Xgf180mcu_as_sc_mcu7t3v3__inv_2_1457 VSS VSS gf180mcu_as_sc_mcu7t3v3__inv_2_1457/Y
+ gf180mcu_as_sc_mcu7t3v3__inv_2_1457/A gf180mcu_as_sc_mcu7t3v3__inv_2_1457/VNW VSUBS
+ gf180mcu_as_sc_mcu7t3v3__inv_2
Xgf180mcu_as_sc_mcu7t3v3__inv_2_1446 VSS VSS gf180mcu_as_sc_mcu7t3v3__inv_2_1446/Y
+ gf180mcu_as_sc_mcu7t3v3__inv_2_1446/A gf180mcu_as_sc_mcu7t3v3__inv_2_1446/VNW VSUBS
+ gf180mcu_as_sc_mcu7t3v3__inv_2
Xgf180mcu_as_sc_mcu7t3v3__inv_2_1479 VSS VSS gf180mcu_as_sc_mcu7t3v3__inv_2_1479/Y
+ gf180mcu_as_sc_mcu7t3v3__inv_2_1479/A gf180mcu_as_sc_mcu7t3v3__inv_2_1479/VNW VSUBS
+ gf180mcu_as_sc_mcu7t3v3__inv_2
Xu_t003_009 u_t003_009/c0_w0_bl u_t003_009/c0_w0_br u_t003_009/c0_w1_bl u_t003_009/c0_w1_br
+ u_t003_009/c0_r0_rbl u_t003_009/c0_r1_rbl u_t003_009/c1_w0_bl u_t003_009/c1_w0_br
+ u_t003_009/c1_w1_bl u_t003_009/c1_w1_br u_t003_009/c1_r0_rbl u_t003_009/c1_r1_rbl
+ u_t003_009/c2_w0_bl u_t003_009/c2_w0_br u_t003_009/c2_w1_bl u_t003_009/c2_w1_br
+ u_t003_009/c2_r0_rbl u_t003_009/c2_r1_rbl u_t003_009/c3_w0_bl u_t003_009/c3_w0_br
+ u_t003_009/c3_w1_bl u_t003_009/c3_w1_br u_t003_009/c3_r0_rbl u_t003_009/c3_r1_rbl
+ u_t003_009/r0_w0_wl u_t003_009/r0_w1_wl u_t003_009/r0_r0_rwl u_t003_009/r0_r1_rwl
+ u_t003_009/r1_w0_wl u_t003_009/r1_w1_wl u_t003_009/r1_r0_rwl u_t003_009/r1_r1_rwl
+ u_t003_009/r2_w0_wl u_t003_009/r2_w1_wl u_t003_009/r2_r0_rwl u_t003_009/r2_r1_rwl
+ u_t003_009/r3_w0_wl u_t003_009/r3_w1_wl u_t003_009/r3_r0_rwl u_t003_009/r3_r1_rwl
+ VSS VSS u_t003_009/m2_717_1265# u_t003_009/m2_603_2031# u_t003_009/m2_1290_336#
+ u_t003_009/m2_2000_2037# u_t003_009/m2_791_2909# u_t003_009/m2_7_2126# u_t003_009/m2_2154_2081#
+ u_t003_009/m2_1795_2037# u_t003_009/m2_871_303# u_t003_009/m2_431_438# u_t003_009/m2_1290_2898#
+ u_t003_009/m2_1714_1210# u_t003_009/m2_431_1982# u_t003_009/m2_512_1265# u_t003_009/m2_2573_2126#
+ u_t003_009/m2_603_1259# u_t003_009/m2_2074_2909# u_t003_009/m2_7_336# u_t003_009/m2_717_2037#
+ u_t003_009/m2_1886_2031# u_t003_009/m2_2573_336# u_t003_009/m2_7_2898# u_t003_009/m2_2000_1265#
+ u_t003_009/m2_512_2037# u_t003_009/m2_1795_1265# u_t003_009/m2_1714_1982# u_t003_009/m2_1886_1259#
+ u_t003_009/m2_1290_2126# u_t003_009/m2_1714_438# u_t003_009/m2_431_1210# u_t003_009/m2_2573_2898#
+ u_t003_009/m2_2154_303# u_t003_009/m2_871_2081# VSUBS detronyx_12t_2w2r_rc4_4x4_routed_5layer_direct
Xgf180mcu_as_sc_mcu7t3v3__inv_2_919 VSS VSS gf180mcu_as_sc_mcu7t3v3__inv_2_947/A gf180mcu_as_sc_mcu7t3v3__inv_2_920/Y
+ gf180mcu_as_sc_mcu7t3v3__inv_2_947/VNW VSUBS gf180mcu_as_sc_mcu7t3v3__inv_2
Xgf180mcu_as_sc_mcu7t3v3__inv_2_908 VSS VSS gf180mcu_as_sc_mcu7t3v3__inv_2_908/Y gf180mcu_as_sc_mcu7t3v3__inv_2_908/A
+ gf180mcu_as_sc_mcu7t3v3__inv_2_953/VNW VSUBS gf180mcu_as_sc_mcu7t3v3__inv_2
Xgf180mcu_as_sc_mcu7t3v3__nand4_2_218 VSS VSS VSS VSS VSS VSS gf180mcu_as_sc_mcu7t3v3__inv_2_756/A
+ gf180mcu_as_sc_mcu7t3v3__inv_2_836/VNW VSUBS gf180mcu_as_sc_mcu7t3v3__nand4_2
Xgf180mcu_as_sc_mcu7t3v3__nand4_2_207 VSS VSS VSS VSS VSS VSS gf180mcu_as_sc_mcu7t3v3__inv_2_670/A
+ gf180mcu_as_sc_mcu7t3v3__inv_2_670/VNW VSUBS gf180mcu_as_sc_mcu7t3v3__nand4_2
Xgf180mcu_as_sc_mcu7t3v3__nand4_2_229 VSS VSS VSS VSS VSS VSS gf180mcu_as_sc_mcu7t3v3__inv_2_777/A
+ gf180mcu_as_sc_mcu7t3v3__inv_2_827/VNW VSUBS gf180mcu_as_sc_mcu7t3v3__nand4_2
Xgf180mcu_as_sc_mcu7t3v3__inv_2_1243 gf180mcu_as_sc_mcu7t3v3__nor2_2_9/VDD gf180mcu_as_sc_mcu7t3v3__nand3_2_63/VSS
+ VSS VSS gf180mcu_as_sc_mcu7t3v3__nor2_2_9/VNW VSUBS gf180mcu_as_sc_mcu7t3v3__inv_2
Xgf180mcu_as_sc_mcu7t3v3__inv_2_1254 gf180mcu_as_sc_mcu7t3v3__nor2_2_9/VDD gf180mcu_as_sc_mcu7t3v3__nor2_2_9/VSS
+ VSS VSS gf180mcu_as_sc_mcu7t3v3__nor2_2_9/VNW VSUBS gf180mcu_as_sc_mcu7t3v3__inv_2
Xgf180mcu_as_sc_mcu7t3v3__inv_2_1232 gf180mcu_as_sc_mcu7t3v3__nand3_2_65/VDD gf180mcu_as_sc_mcu7t3v3__nand3_2_62/VSS
+ VSS VSS gf180mcu_as_sc_mcu7t3v3__nand3_2_65/VNW VSUBS gf180mcu_as_sc_mcu7t3v3__inv_2
Xgf180mcu_as_sc_mcu7t3v3__inv_2_1265 gf180mcu_as_sc_mcu7t3v3__nand3_2_65/VDD gf180mcu_as_sc_mcu7t3v3__nand3_2_62/VSS
+ VSS VSS gf180mcu_as_sc_mcu7t3v3__nand3_2_65/VNW VSUBS gf180mcu_as_sc_mcu7t3v3__inv_2
Xgf180mcu_as_sc_mcu7t3v3__inv_2_1210 gf180mcu_as_sc_mcu7t3v3__nand3_2_65/VDD gf180mcu_as_sc_mcu7t3v3__nand3_2_62/VSS
+ VSS VSS gf180mcu_as_sc_mcu7t3v3__nand3_2_65/VNW VSUBS gf180mcu_as_sc_mcu7t3v3__inv_2
Xgf180mcu_as_sc_mcu7t3v3__inv_2_1221 VSS VSS gf180mcu_as_sc_mcu7t3v3__inv_2_1221/Y
+ gf180mcu_as_sc_mcu7t3v3__inv_2_1221/A gf180mcu_as_sc_mcu7t3v3__inv_2_1275/VNW VSUBS
+ gf180mcu_as_sc_mcu7t3v3__inv_2
Xgf180mcu_as_sc_mcu7t3v3__inv_2_1276 VSS VSS VSS gf180mcu_as_sc_mcu7t3v3__inv_2_1276/A
+ gf180mcu_as_sc_mcu7t3v3__inv_2_1276/VNW VSUBS gf180mcu_as_sc_mcu7t3v3__inv_2
Xgf180mcu_as_sc_mcu7t3v3__inv_2_1287 VSS VSS VSS gf180mcu_as_sc_mcu7t3v3__inv_2_1287/A
+ gf180mcu_as_sc_mcu7t3v3__inv_2_1287/VNW VSUBS gf180mcu_as_sc_mcu7t3v3__inv_2
Xgf180mcu_as_sc_mcu7t3v3__inv_2_1298 VSS VSS VSS gf180mcu_as_sc_mcu7t3v3__inv_2_1298/A
+ gf180mcu_as_sc_mcu7t3v3__inv_2_1298/VNW VSUBS gf180mcu_as_sc_mcu7t3v3__inv_2
Xgf180mcu_as_sc_mcu7t3v3__inv_2_727 VSS VSS gf180mcu_as_sc_mcu7t3v3__inv_2_727/Y gf180mcu_as_sc_mcu7t3v3__inv_2_728/Y
+ gf180mcu_as_sc_mcu7t3v3__inv_2_728/VNW VSUBS gf180mcu_as_sc_mcu7t3v3__inv_2
Xgf180mcu_as_sc_mcu7t3v3__inv_2_716 VSS VSS gf180mcu_as_sc_mcu7t3v3__inv_2_716/Y gf180mcu_as_sc_mcu7t3v3__inv_2_716/A
+ gf180mcu_as_sc_mcu7t3v3__inv_2_716/VNW VSUBS gf180mcu_as_sc_mcu7t3v3__inv_2
Xgf180mcu_as_sc_mcu7t3v3__inv_2_705 VSS VSS gf180mcu_as_sc_mcu7t3v3__inv_2_705/Y gf180mcu_as_sc_mcu7t3v3__inv_2_705/A
+ gf180mcu_as_sc_mcu7t3v3__inv_2_741/VNW VSUBS gf180mcu_as_sc_mcu7t3v3__inv_2
Xgf180mcu_as_sc_mcu7t3v3__inv_2_749 VSS VSS gf180mcu_as_sc_mcu7t3v3__inv_2_749/Y gf180mcu_as_sc_mcu7t3v3__inv_2_749/A
+ gf180mcu_as_sc_mcu7t3v3__inv_2_829/VNW VSUBS gf180mcu_as_sc_mcu7t3v3__inv_2
Xgf180mcu_as_sc_mcu7t3v3__inv_2_738 VSS VSS VSS gf180mcu_as_sc_mcu7t3v3__inv_2_739/Y
+ gf180mcu_as_sc_mcu7t3v3__inv_2_740/VNW VSUBS gf180mcu_as_sc_mcu7t3v3__inv_2
Xgf180mcu_as_sc_mcu7t3v3__inv_2_70 VSS VSS VSS gf180mcu_as_sc_mcu7t3v3__inv_2_74/Y
+ gf180mcu_as_sc_mcu7t3v3__inv_2_0/VNW VSUBS gf180mcu_as_sc_mcu7t3v3__inv_2
Xgf180mcu_as_sc_mcu7t3v3__inv_2_1084 VSS VSS VSS gf180mcu_as_sc_mcu7t3v3__inv_2_1100/Y
+ gf180mcu_as_sc_mcu7t3v3__inv_2_1100/VNW VSUBS gf180mcu_as_sc_mcu7t3v3__inv_2
Xgf180mcu_as_sc_mcu7t3v3__inv_2_1073 VSS VSS VSS gf180mcu_as_sc_mcu7t3v3__inv_2_1074/Y
+ gf180mcu_as_sc_mcu7t3v3__inv_2_1075/VNW VSUBS gf180mcu_as_sc_mcu7t3v3__inv_2
Xgf180mcu_as_sc_mcu7t3v3__inv_2_1095 VSS VSS gf180mcu_as_sc_mcu7t3v3__inv_2_1095/Y
+ gf180mcu_as_sc_mcu7t3v3__inv_2_1095/A gf180mcu_as_sc_mcu7t3v3__inv_2_1095/VNW VSUBS
+ gf180mcu_as_sc_mcu7t3v3__inv_2
Xgf180mcu_as_sc_mcu7t3v3__inv_2_1062 VSS VSS VSS gf180mcu_as_sc_mcu7t3v3__inv_2_1063/Y
+ gf180mcu_as_sc_mcu7t3v3__inv_2_1064/VNW VSUBS gf180mcu_as_sc_mcu7t3v3__inv_2
Xgf180mcu_as_sc_mcu7t3v3__inv_2_1040 VSS VSS gf180mcu_as_sc_mcu7t3v3__inv_2_1040/Y
+ gf180mcu_as_sc_mcu7t3v3__inv_2_1040/A gf180mcu_as_sc_mcu7t3v3__inv_2_1040/VNW VSUBS
+ gf180mcu_as_sc_mcu7t3v3__inv_2
Xgf180mcu_as_sc_mcu7t3v3__inv_2_1051 VSS VSS gf180mcu_as_sc_mcu7t3v3__inv_2_1051/Y
+ gf180mcu_as_sc_mcu7t3v3__inv_2_1052/Y gf180mcu_as_sc_mcu7t3v3__inv_2_1052/VNW VSUBS
+ gf180mcu_as_sc_mcu7t3v3__inv_2
Xgf180mcu_as_sc_mcu7t3v3__inv_2_81 VSS VSS gf180mcu_as_sc_mcu7t3v3__inv_2_81/Y gf180mcu_as_sc_mcu7t3v3__inv_2_81/A
+ gf180mcu_as_sc_mcu7t3v3__inv_2_81/VNW VSUBS gf180mcu_as_sc_mcu7t3v3__inv_2
Xgf180mcu_as_sc_mcu7t3v3__inv_2_92 VSS VSS gf180mcu_as_sc_mcu7t3v3__inv_2_92/Y gf180mcu_as_sc_mcu7t3v3__inv_2_92/A
+ gf180mcu_as_sc_mcu7t3v3__inv_2_92/VNW VSUBS gf180mcu_as_sc_mcu7t3v3__inv_2
Xgf180mcu_as_sc_mcu7t3v3__nand4_2_7 VSS VSS VSS VSS VSS VSS gf180mcu_as_sc_mcu7t3v3__inv_2_97/A
+ gf180mcu_as_sc_mcu7t3v3__inv_2_97/VNW VSUBS gf180mcu_as_sc_mcu7t3v3__nand4_2
Xgf180mcu_as_sc_mcu7t3v3__inv_2_557 VSS VSS VSS gf180mcu_as_sc_mcu7t3v3__inv_2_557/A
+ gf180mcu_as_sc_mcu7t3v3__inv_2_557/VNW VSUBS gf180mcu_as_sc_mcu7t3v3__inv_2
Xgf180mcu_as_sc_mcu7t3v3__inv_2_513 VSS VSS gf180mcu_as_sc_mcu7t3v3__inv_2_558/A gf180mcu_as_sc_mcu7t3v3__inv_2_514/Y
+ gf180mcu_as_sc_mcu7t3v3__inv_2_558/VNW VSUBS gf180mcu_as_sc_mcu7t3v3__inv_2
Xgf180mcu_as_sc_mcu7t3v3__inv_2_546 VSS VSS VSS gf180mcu_as_sc_mcu7t3v3__inv_2_546/A
+ gf180mcu_as_sc_mcu7t3v3__inv_2_546/VNW VSUBS gf180mcu_as_sc_mcu7t3v3__inv_2
Xgf180mcu_as_sc_mcu7t3v3__inv_2_568 VSS VSS VSS gf180mcu_as_sc_mcu7t3v3__inv_2_569/Y
+ gf180mcu_as_sc_mcu7t3v3__inv_2_570/VNW VSUBS gf180mcu_as_sc_mcu7t3v3__inv_2
Xgf180mcu_as_sc_mcu7t3v3__inv_2_579 VSS VSS gf180mcu_as_sc_mcu7t3v3__inv_2_579/Y gf180mcu_as_sc_mcu7t3v3__inv_2_579/A
+ gf180mcu_as_sc_mcu7t3v3__inv_2_579/VNW VSUBS gf180mcu_as_sc_mcu7t3v3__inv_2
Xgf180mcu_as_sc_mcu7t3v3__inv_2_535 gf180mcu_as_sc_mcu7t3v3__nor2_2_6/VDD gf180mcu_as_sc_mcu7t3v3__nand3_2_4/VSS
+ VSS VSS gf180mcu_as_sc_mcu7t3v3__nor2_2_6/VNW VSUBS gf180mcu_as_sc_mcu7t3v3__inv_2
Xgf180mcu_as_sc_mcu7t3v3__inv_2_524 gf180mcu_as_sc_mcu7t3v3__nand3_2_9/VDD gf180mcu_as_sc_mcu7t3v3__nor2_2_7/VSS
+ VSS VSS gf180mcu_as_sc_mcu7t3v3__nand3_2_9/VNW VSUBS gf180mcu_as_sc_mcu7t3v3__inv_2
Xgf180mcu_as_sc_mcu7t3v3__inv_2_502 VSS VSS gf180mcu_as_sc_mcu7t3v3__inv_2_502/Y gf180mcu_as_sc_mcu7t3v3__inv_2_502/A
+ gf180mcu_as_sc_mcu7t3v3__inv_2_536/VNW VSUBS gf180mcu_as_sc_mcu7t3v3__inv_2
Xgf180mcu_as_sc_mcu7t3v3__nand4_2_390 VSS VSS VSS VSS VSS VSS gf180mcu_as_sc_mcu7t3v3__inv_2_1440/A
+ gf180mcu_as_sc_mcu7t3v3__inv_2_1440/VNW VSUBS gf180mcu_as_sc_mcu7t3v3__nand4_2
Xgf180mcu_as_sc_mcu7t3v3__inv_2_387 gf180mcu_as_sc_mcu7t3v3__nor2_2_7/VDD gf180mcu_as_sc_mcu7t3v3__nand3_2_4/VSS
+ VSS VSS gf180mcu_as_sc_mcu7t3v3__nor2_2_7/VNW VSUBS gf180mcu_as_sc_mcu7t3v3__inv_2
Xgf180mcu_as_sc_mcu7t3v3__inv_2_376 gf180mcu_as_sc_mcu7t3v3__nor2_2_4/VDD gf180mcu_as_sc_mcu7t3v3__nand2_2_3/VSS
+ VSS VSS gf180mcu_as_sc_mcu7t3v3__nor2_2_4/VNW VSUBS gf180mcu_as_sc_mcu7t3v3__inv_2
Xgf180mcu_as_sc_mcu7t3v3__inv_2_398 gf180mcu_as_sc_mcu7t3v3__nor2_2_4/VDD gf180mcu_as_sc_mcu7t3v3__nand2_2_3/VSS
+ VSS VSS gf180mcu_as_sc_mcu7t3v3__nor2_2_4/VNW VSUBS gf180mcu_as_sc_mcu7t3v3__inv_2
Xgf180mcu_as_sc_mcu7t3v3__inv_2_310 VSS VSS gf180mcu_as_sc_mcu7t3v3__inv_2_310/Y gf180mcu_as_sc_mcu7t3v3__inv_2_311/Y
+ gf180mcu_as_sc_mcu7t3v3__inv_2_311/VNW VSUBS gf180mcu_as_sc_mcu7t3v3__inv_2
Xgf180mcu_as_sc_mcu7t3v3__inv_2_365 VSS VSS gf180mcu_as_sc_mcu7t3v3__inv_2_365/Y gf180mcu_as_sc_mcu7t3v3__inv_2_365/A
+ gf180mcu_as_sc_mcu7t3v3__inv_2_365/VNW VSUBS gf180mcu_as_sc_mcu7t3v3__inv_2
Xgf180mcu_as_sc_mcu7t3v3__inv_2_354 VSS VSS VSS gf180mcu_as_sc_mcu7t3v3__inv_2_355/Y
+ gf180mcu_as_sc_mcu7t3v3__inv_2_356/VNW VSUBS gf180mcu_as_sc_mcu7t3v3__inv_2
Xgf180mcu_as_sc_mcu7t3v3__inv_2_343 VSS VSS gf180mcu_as_sc_mcu7t3v3__inv_2_343/Y gf180mcu_as_sc_mcu7t3v3__inv_2_344/Y
+ gf180mcu_as_sc_mcu7t3v3__inv_2_344/VNW VSUBS gf180mcu_as_sc_mcu7t3v3__inv_2
Xgf180mcu_as_sc_mcu7t3v3__inv_2_332 VSS VSS gf180mcu_as_sc_mcu7t3v3__inv_2_332/Y gf180mcu_as_sc_mcu7t3v3__inv_2_332/A
+ gf180mcu_as_sc_mcu7t3v3__inv_2_332/VNW VSUBS gf180mcu_as_sc_mcu7t3v3__inv_2
Xgf180mcu_as_sc_mcu7t3v3__inv_2_321 VSS VSS VSS gf180mcu_as_sc_mcu7t3v3__inv_2_322/Y
+ gf180mcu_as_sc_mcu7t3v3__inv_2_323/VNW VSUBS gf180mcu_as_sc_mcu7t3v3__inv_2
Xu_t027_015 u_t027_015/c0_w0_bl u_t027_015/c0_w0_br u_t027_015/c0_w1_bl u_t027_015/c0_w1_br
+ u_t027_015/c0_r0_rbl u_t027_015/c0_r1_rbl u_t027_015/c1_w0_bl u_t027_015/c1_w0_br
+ u_t027_015/c1_w1_bl u_t027_015/c1_w1_br u_t027_015/c1_r0_rbl u_t027_015/c1_r1_rbl
+ u_t027_015/c2_w0_bl u_t027_015/c2_w0_br u_t027_015/c2_w1_bl u_t027_015/c2_w1_br
+ u_t027_015/c2_r0_rbl u_t027_015/c2_r1_rbl u_t027_015/c3_w0_bl u_t027_015/c3_w0_br
+ u_t027_015/c3_w1_bl u_t027_015/c3_w1_br u_t027_015/c3_r0_rbl u_t027_015/c3_r1_rbl
+ u_t027_015/r0_w0_wl u_t027_015/r0_w1_wl u_t027_015/r0_r0_rwl u_t027_015/r0_r1_rwl
+ u_t027_015/r1_w0_wl u_t027_015/r1_w1_wl u_t027_015/r1_r0_rwl u_t027_015/r1_r1_rwl
+ u_t027_015/r2_w0_wl u_t027_015/r2_w1_wl u_t027_015/r2_r0_rwl u_t027_015/r2_r1_rwl
+ u_t027_015/r3_w0_wl u_t027_015/r3_w1_wl u_t027_015/r3_r0_rwl u_t027_015/r3_r1_rwl
+ VSS VSS u_t027_015/m2_717_1265# u_t027_015/m2_603_2031# u_t027_015/m2_1290_336#
+ u_t027_015/m2_2000_2037# u_t027_015/m2_791_2909# u_t027_015/m2_7_2126# u_t027_015/m2_2154_2081#
+ u_t027_015/m2_1795_2037# u_t027_015/m2_871_303# u_t027_015/m2_431_438# u_t027_015/m2_1290_2898#
+ u_t027_015/m2_1714_1210# u_t027_015/m2_431_1982# u_t027_015/m2_512_1265# u_t027_015/m2_2573_2126#
+ u_t027_015/m2_603_1259# u_t027_015/m2_2074_2909# u_t027_015/m2_7_336# u_t027_015/m2_717_2037#
+ u_t027_015/m2_1886_2031# u_t027_015/m2_2573_336# u_t027_015/m2_7_2898# u_t027_015/m2_2000_1265#
+ u_t027_015/m2_512_2037# u_t027_015/m2_1795_1265# u_t027_015/m2_1714_1982# u_t027_015/m2_1886_1259#
+ u_t027_015/m2_1290_2126# u_t027_015/m2_1714_438# u_t027_015/m2_431_1210# u_t027_015/m2_2573_2898#
+ u_t027_015/m2_2154_303# u_t027_015/m2_871_2081# VSUBS detronyx_12t_2w2r_rc4_4x4_routed_5layer_direct
Xu_t027_004 u_t027_004/c0_w0_bl u_t027_004/c0_w0_br u_t027_004/c0_w1_bl u_t027_004/c0_w1_br
+ u_t027_004/c0_r0_rbl u_t027_004/c0_r1_rbl u_t027_004/c1_w0_bl u_t027_004/c1_w0_br
+ u_t027_004/c1_w1_bl u_t027_004/c1_w1_br u_t027_004/c1_r0_rbl u_t027_004/c1_r1_rbl
+ u_t027_004/c2_w0_bl u_t027_004/c2_w0_br u_t027_004/c2_w1_bl u_t027_004/c2_w1_br
+ u_t027_004/c2_r0_rbl u_t027_004/c2_r1_rbl u_t027_004/c3_w0_bl u_t027_004/c3_w0_br
+ u_t027_004/c3_w1_bl u_t027_004/c3_w1_br u_t027_004/c3_r0_rbl u_t027_004/c3_r1_rbl
+ u_t027_004/r0_w0_wl u_t027_004/r0_w1_wl u_t027_004/r0_r0_rwl u_t027_004/r0_r1_rwl
+ u_t027_004/r1_w0_wl u_t027_004/r1_w1_wl u_t027_004/r1_r0_rwl u_t027_004/r1_r1_rwl
+ u_t027_004/r2_w0_wl u_t027_004/r2_w1_wl u_t027_004/r2_r0_rwl u_t027_004/r2_r1_rwl
+ u_t027_004/r3_w0_wl u_t027_004/r3_w1_wl u_t027_004/r3_r0_rwl u_t027_004/r3_r1_rwl
+ VSS VSS u_t027_004/m2_717_1265# u_t027_004/m2_603_2031# u_t027_004/m2_1290_336#
+ u_t027_004/m2_2000_2037# u_t027_004/m2_791_2909# u_t027_004/m2_7_2126# u_t027_004/m2_2154_2081#
+ u_t027_004/m2_1795_2037# u_t027_004/m2_871_303# u_t027_004/m2_431_438# u_t027_004/m2_1290_2898#
+ u_t027_004/m2_1714_1210# u_t027_004/m2_431_1982# u_t027_004/m2_512_1265# u_t027_004/m2_2573_2126#
+ u_t027_004/m2_603_1259# u_t027_004/m2_2074_2909# u_t027_004/m2_7_336# u_t027_004/m2_717_2037#
+ u_t027_004/m2_1886_2031# u_t027_004/m2_2573_336# u_t027_004/m2_7_2898# u_t027_004/m2_2000_1265#
+ u_t027_004/m2_512_2037# u_t027_004/m2_1795_1265# u_t027_004/m2_1714_1982# u_t027_004/m2_1886_1259#
+ u_t027_004/m2_1290_2126# u_t027_004/m2_1714_438# u_t027_004/m2_431_1210# u_t027_004/m2_2573_2898#
+ u_t027_004/m2_2154_303# u_t027_004/m2_871_2081# VSUBS detronyx_12t_2w2r_rc4_4x4_routed_5layer_direct
Xu_t018_015 u_t018_015/c0_w0_bl u_t018_015/c0_w0_br u_t018_015/c0_w1_bl u_t018_015/c0_w1_br
+ u_t018_015/c0_r0_rbl u_t018_015/c0_r1_rbl u_t018_015/c1_w0_bl u_t018_015/c1_w0_br
+ u_t018_015/c1_w1_bl u_t018_015/c1_w1_br u_t018_015/c1_r0_rbl u_t018_015/c1_r1_rbl
+ u_t018_015/c2_w0_bl u_t018_015/c2_w0_br u_t018_015/c2_w1_bl u_t018_015/c2_w1_br
+ u_t018_015/c2_r0_rbl u_t018_015/c2_r1_rbl u_t018_015/c3_w0_bl u_t018_015/c3_w0_br
+ u_t018_015/c3_w1_bl u_t018_015/c3_w1_br u_t018_015/c3_r0_rbl u_t018_015/c3_r1_rbl
+ u_t018_015/r0_w0_wl u_t018_015/r0_w1_wl u_t018_015/r0_r0_rwl u_t018_015/r0_r1_rwl
+ u_t018_015/r1_w0_wl u_t018_015/r1_w1_wl u_t018_015/r1_r0_rwl u_t018_015/r1_r1_rwl
+ u_t018_015/r2_w0_wl u_t018_015/r2_w1_wl u_t018_015/r2_r0_rwl u_t018_015/r2_r1_rwl
+ u_t018_015/r3_w0_wl u_t018_015/r3_w1_wl u_t018_015/r3_r0_rwl u_t018_015/r3_r1_rwl
+ VSS VSS u_t018_015/m2_717_1265# u_t018_015/m2_603_2031# u_t018_015/m2_1290_336#
+ u_t018_015/m2_2000_2037# u_t018_015/m2_791_2909# u_t018_015/m2_7_2126# u_t018_015/m2_2154_2081#
+ u_t018_015/m2_1795_2037# u_t018_015/m2_871_303# u_t018_015/m2_431_438# u_t018_015/m2_1290_2898#
+ u_t018_015/m2_1714_1210# u_t018_015/m2_431_1982# u_t018_015/m2_512_1265# u_t018_015/m2_2573_2126#
+ u_t018_015/m2_603_1259# u_t018_015/m2_2074_2909# u_t018_015/m2_7_336# u_t018_015/m2_717_2037#
+ u_t018_015/m2_1886_2031# u_t018_015/m2_2573_336# u_t018_015/m2_7_2898# u_t018_015/m2_2000_1265#
+ u_t018_015/m2_512_2037# u_t018_015/m2_1795_1265# u_t018_015/m2_1714_1982# u_t018_015/m2_1886_1259#
+ u_t018_015/m2_1290_2126# u_t018_015/m2_1714_438# u_t018_015/m2_431_1210# u_t018_015/m2_2573_2898#
+ u_t018_015/m2_2154_303# u_t018_015/m2_871_2081# VSUBS detronyx_12t_2w2r_rc4_4x4_routed_5layer_direct
Xu_t018_004 u_t018_004/c0_w0_bl u_t018_004/c0_w0_br u_t018_004/c0_w1_bl u_t018_004/c0_w1_br
+ u_t018_004/c0_r0_rbl u_t018_004/c0_r1_rbl u_t018_004/c1_w0_bl u_t018_004/c1_w0_br
+ u_t018_004/c1_w1_bl u_t018_004/c1_w1_br u_t018_004/c1_r0_rbl u_t018_004/c1_r1_rbl
+ u_t018_004/c2_w0_bl u_t018_004/c2_w0_br u_t018_004/c2_w1_bl u_t018_004/c2_w1_br
+ u_t018_004/c2_r0_rbl u_t018_004/c2_r1_rbl u_t018_004/c3_w0_bl u_t018_004/c3_w0_br
+ u_t018_004/c3_w1_bl u_t018_004/c3_w1_br u_t018_004/c3_r0_rbl u_t018_004/c3_r1_rbl
+ u_t018_004/r0_w0_wl u_t018_004/r0_w1_wl u_t018_004/r0_r0_rwl u_t018_004/r0_r1_rwl
+ u_t018_004/r1_w0_wl u_t018_004/r1_w1_wl u_t018_004/r1_r0_rwl u_t018_004/r1_r1_rwl
+ u_t018_004/r2_w0_wl u_t018_004/r2_w1_wl u_t018_004/r2_r0_rwl u_t018_004/r2_r1_rwl
+ u_t018_004/r3_w0_wl u_t018_004/r3_w1_wl u_t018_004/r3_r0_rwl u_t018_004/r3_r1_rwl
+ VSS VSS u_t018_004/m2_717_1265# u_t018_004/m2_603_2031# u_t018_004/m2_1290_336#
+ u_t018_004/m2_2000_2037# u_t018_004/m2_791_2909# u_t018_004/m2_7_2126# u_t018_004/m2_2154_2081#
+ u_t018_004/m2_1795_2037# u_t018_004/m2_871_303# u_t018_004/m2_431_438# u_t018_004/m2_1290_2898#
+ u_t018_004/m2_1714_1210# u_t018_004/m2_431_1982# u_t018_004/m2_512_1265# u_t018_004/m2_2573_2126#
+ u_t018_004/m2_603_1259# u_t018_004/m2_2074_2909# u_t018_004/m2_7_336# u_t018_004/m2_717_2037#
+ u_t018_004/m2_1886_2031# u_t018_004/m2_2573_336# u_t018_004/m2_7_2898# u_t018_004/m2_2000_1265#
+ u_t018_004/m2_512_2037# u_t018_004/m2_1795_1265# u_t018_004/m2_1714_1982# u_t018_004/m2_1886_1259#
+ u_t018_004/m2_1290_2126# u_t018_004/m2_1714_438# u_t018_004/m2_431_1210# u_t018_004/m2_2573_2898#
+ u_t018_004/m2_2154_303# u_t018_004/m2_871_2081# VSUBS detronyx_12t_2w2r_rc4_4x4_routed_5layer_direct
Xu_t009_015 u_t009_015/c0_w0_bl u_t009_015/c0_w0_br u_t009_015/c0_w1_bl u_t009_015/c0_w1_br
+ u_t009_015/c0_r0_rbl u_t009_015/c0_r1_rbl u_t009_015/c1_w0_bl u_t009_015/c1_w0_br
+ u_t009_015/c1_w1_bl u_t009_015/c1_w1_br u_t009_015/c1_r0_rbl u_t009_015/c1_r1_rbl
+ u_t009_015/c2_w0_bl u_t009_015/c2_w0_br u_t009_015/c2_w1_bl u_t009_015/c2_w1_br
+ u_t009_015/c2_r0_rbl u_t009_015/c2_r1_rbl u_t009_015/c3_w0_bl u_t009_015/c3_w0_br
+ u_t009_015/c3_w1_bl u_t009_015/c3_w1_br u_t009_015/c3_r0_rbl u_t009_015/c3_r1_rbl
+ u_t009_015/r0_w0_wl u_t009_015/r0_w1_wl u_t009_015/r0_r0_rwl u_t009_015/r0_r1_rwl
+ u_t009_015/r1_w0_wl u_t009_015/r1_w1_wl u_t009_015/r1_r0_rwl u_t009_015/r1_r1_rwl
+ u_t009_015/r2_w0_wl u_t009_015/r2_w1_wl u_t009_015/r2_r0_rwl u_t009_015/r2_r1_rwl
+ u_t009_015/r3_w0_wl u_t009_015/r3_w1_wl u_t009_015/r3_r0_rwl u_t009_015/r3_r1_rwl
+ VSS VSS u_t009_015/m2_717_1265# u_t009_015/m2_603_2031# u_t009_015/m2_1290_336#
+ u_t009_015/m2_2000_2037# u_t009_015/m2_791_2909# u_t009_015/m2_7_2126# u_t009_015/m2_2154_2081#
+ u_t009_015/m2_1795_2037# u_t009_015/m2_871_303# u_t009_015/m2_431_438# u_t009_015/m2_1290_2898#
+ u_t009_015/m2_1714_1210# u_t009_015/m2_431_1982# u_t009_015/m2_512_1265# u_t009_015/m2_2573_2126#
+ u_t009_015/m2_603_1259# u_t009_015/m2_2074_2909# u_t009_015/m2_7_336# u_t009_015/m2_717_2037#
+ u_t009_015/m2_1886_2031# u_t009_015/m2_2573_336# u_t009_015/m2_7_2898# u_t009_015/m2_2000_1265#
+ u_t009_015/m2_512_2037# u_t009_015/m2_1795_1265# u_t009_015/m2_1714_1982# u_t009_015/m2_1886_1259#
+ u_t009_015/m2_1290_2126# u_t009_015/m2_1714_438# u_t009_015/m2_431_1210# u_t009_015/m2_2573_2898#
+ u_t009_015/m2_2154_303# u_t009_015/m2_871_2081# VSUBS detronyx_12t_2w2r_rc4_4x4_routed_5layer_direct
Xu_t024_007 u_t024_007/c0_w0_bl u_t024_007/c0_w0_br u_t024_007/c0_w1_bl u_t024_007/c0_w1_br
+ u_t024_007/c0_r0_rbl u_t024_007/c0_r1_rbl u_t024_007/c1_w0_bl u_t024_007/c1_w0_br
+ u_t024_007/c1_w1_bl u_t024_007/c1_w1_br u_t024_007/c1_r0_rbl u_t024_007/c1_r1_rbl
+ u_t024_007/c2_w0_bl u_t024_007/c2_w0_br u_t024_007/c2_w1_bl u_t024_007/c2_w1_br
+ u_t024_007/c2_r0_rbl u_t024_007/c2_r1_rbl u_t024_007/c3_w0_bl u_t024_007/c3_w0_br
+ u_t024_007/c3_w1_bl u_t024_007/c3_w1_br u_t024_007/c3_r0_rbl u_t024_007/c3_r1_rbl
+ u_t024_007/r0_w0_wl u_t024_007/r0_w1_wl u_t024_007/r0_r0_rwl u_t024_007/r0_r1_rwl
+ u_t024_007/r1_w0_wl u_t024_007/r1_w1_wl u_t024_007/r1_r0_rwl u_t024_007/r1_r1_rwl
+ u_t024_007/r2_w0_wl u_t024_007/r2_w1_wl u_t024_007/r2_r0_rwl u_t024_007/r2_r1_rwl
+ u_t024_007/r3_w0_wl u_t024_007/r3_w1_wl u_t024_007/r3_r0_rwl u_t024_007/r3_r1_rwl
+ VSS VSS u_t024_007/m2_717_1265# u_t024_007/m2_603_2031# u_t024_007/m2_1290_336#
+ u_t024_007/m2_2000_2037# u_t024_007/m2_791_2909# u_t024_007/m2_7_2126# u_t024_007/m2_2154_2081#
+ u_t024_007/m2_1795_2037# u_t024_007/m2_871_303# u_t024_007/m2_431_438# u_t024_007/m2_1290_2898#
+ u_t024_007/m2_1714_1210# u_t024_007/m2_431_1982# u_t024_007/m2_512_1265# u_t024_007/m2_2573_2126#
+ u_t024_007/m2_603_1259# u_t024_007/m2_2074_2909# u_t024_007/m2_7_336# u_t024_007/m2_717_2037#
+ u_t024_007/m2_1886_2031# u_t024_007/m2_2573_336# u_t024_007/m2_7_2898# u_t024_007/m2_2000_1265#
+ u_t024_007/m2_512_2037# u_t024_007/m2_1795_1265# u_t024_007/m2_1714_1982# u_t024_007/m2_1886_1259#
+ u_t024_007/m2_1290_2126# u_t024_007/m2_1714_438# u_t024_007/m2_431_1210# u_t024_007/m2_2573_2898#
+ u_t024_007/m2_2154_303# u_t024_007/m2_871_2081# VSUBS detronyx_12t_2w2r_rc4_4x4_routed_5layer_direct
Xu_t009_004 u_t009_004/c0_w0_bl u_t009_004/c0_w0_br u_t009_004/c0_w1_bl u_t009_004/c0_w1_br
+ u_t009_004/c0_r0_rbl u_t009_004/c0_r1_rbl u_t009_004/c1_w0_bl u_t009_004/c1_w0_br
+ u_t009_004/c1_w1_bl u_t009_004/c1_w1_br u_t009_004/c1_r0_rbl u_t009_004/c1_r1_rbl
+ u_t009_004/c2_w0_bl u_t009_004/c2_w0_br u_t009_004/c2_w1_bl u_t009_004/c2_w1_br
+ u_t009_004/c2_r0_rbl u_t009_004/c2_r1_rbl u_t009_004/c3_w0_bl u_t009_004/c3_w0_br
+ u_t009_004/c3_w1_bl u_t009_004/c3_w1_br u_t009_004/c3_r0_rbl u_t009_004/c3_r1_rbl
+ u_t009_004/r0_w0_wl u_t009_004/r0_w1_wl u_t009_004/r0_r0_rwl u_t009_004/r0_r1_rwl
+ u_t009_004/r1_w0_wl u_t009_004/r1_w1_wl u_t009_004/r1_r0_rwl u_t009_004/r1_r1_rwl
+ u_t009_004/r2_w0_wl u_t009_004/r2_w1_wl u_t009_004/r2_r0_rwl u_t009_004/r2_r1_rwl
+ u_t009_004/r3_w0_wl u_t009_004/r3_w1_wl u_t009_004/r3_r0_rwl u_t009_004/r3_r1_rwl
+ VSS VSS u_t009_004/m2_717_1265# u_t009_004/m2_603_2031# u_t009_004/m2_1290_336#
+ u_t009_004/m2_2000_2037# u_t009_004/m2_791_2909# u_t009_004/m2_7_2126# u_t009_004/m2_2154_2081#
+ u_t009_004/m2_1795_2037# u_t009_004/m2_871_303# u_t009_004/m2_431_438# u_t009_004/m2_1290_2898#
+ u_t009_004/m2_1714_1210# u_t009_004/m2_431_1982# u_t009_004/m2_512_1265# u_t009_004/m2_2573_2126#
+ u_t009_004/m2_603_1259# u_t009_004/m2_2074_2909# u_t009_004/m2_7_336# u_t009_004/m2_717_2037#
+ u_t009_004/m2_1886_2031# u_t009_004/m2_2573_336# u_t009_004/m2_7_2898# u_t009_004/m2_2000_1265#
+ u_t009_004/m2_512_2037# u_t009_004/m2_1795_1265# u_t009_004/m2_1714_1982# u_t009_004/m2_1886_1259#
+ u_t009_004/m2_1290_2126# u_t009_004/m2_1714_438# u_t009_004/m2_431_1210# u_t009_004/m2_2573_2898#
+ u_t009_004/m2_2154_303# u_t009_004/m2_871_2081# VSUBS detronyx_12t_2w2r_rc4_4x4_routed_5layer_direct
Xgf180mcu_as_sc_mcu7t3v3__nand3_2_19 gf180mcu_as_sc_mcu7t3v3__nor2_2_4/VDD gf180mcu_as_sc_mcu7t3v3__nor2_2_4/VSS
+ VSS VSS VSS VSS gf180mcu_as_sc_mcu7t3v3__nor2_2_4/VNW VSUBS gf180mcu_as_sc_mcu7t3v3__nand3_2
Xgf180mcu_as_sc_mcu7t3v3__inv_2_1606 VSS VSS gf180mcu_as_sc_mcu7t3v3__inv_2_1606/Y
+ gf180mcu_as_sc_mcu7t3v3__inv_2_1606/A gf180mcu_as_sc_mcu7t3v3__inv_2_1606/VNW VSUBS
+ gf180mcu_as_sc_mcu7t3v3__inv_2
Xgf180mcu_as_sc_mcu7t3v3__inv_2_1617 VSS VSS gf180mcu_as_sc_mcu7t3v3__inv_2_1617/Y
+ gf180mcu_as_sc_mcu7t3v3__inv_2_1618/Y gf180mcu_as_sc_mcu7t3v3__inv_2_1618/VNW VSUBS
+ gf180mcu_as_sc_mcu7t3v3__inv_2
Xgf180mcu_as_sc_mcu7t3v3__inv_2_151 VSS VSS gf180mcu_as_sc_mcu7t3v3__inv_2_151/Y gf180mcu_as_sc_mcu7t3v3__inv_2_152/Y
+ gf180mcu_as_sc_mcu7t3v3__inv_2_152/VNW VSUBS gf180mcu_as_sc_mcu7t3v3__inv_2
Xgf180mcu_as_sc_mcu7t3v3__inv_2_140 VSS VSS gf180mcu_as_sc_mcu7t3v3__inv_2_140/Y gf180mcu_as_sc_mcu7t3v3__inv_2_140/A
+ gf180mcu_as_sc_mcu7t3v3__inv_2_140/VNW VSUBS gf180mcu_as_sc_mcu7t3v3__inv_2
Xgf180mcu_as_sc_mcu7t3v3__inv_2_173 VSS VSS gf180mcu_as_sc_mcu7t3v3__inv_2_173/Y gf180mcu_as_sc_mcu7t3v3__inv_2_174/Y
+ gf180mcu_as_sc_mcu7t3v3__inv_2_174/VNW VSUBS gf180mcu_as_sc_mcu7t3v3__inv_2
Xgf180mcu_as_sc_mcu7t3v3__inv_2_184 VSS VSS gf180mcu_as_sc_mcu7t3v3__inv_2_184/Y gf180mcu_as_sc_mcu7t3v3__inv_2_197/Y
+ gf180mcu_as_sc_mcu7t3v3__inv_2_197/VNW VSUBS gf180mcu_as_sc_mcu7t3v3__inv_2
Xgf180mcu_as_sc_mcu7t3v3__inv_2_195 VSS VSS gf180mcu_as_sc_mcu7t3v3__inv_2_195/Y gf180mcu_as_sc_mcu7t3v3__inv_2_196/Y
+ gf180mcu_as_sc_mcu7t3v3__inv_2_196/VNW VSUBS gf180mcu_as_sc_mcu7t3v3__inv_2
Xgf180mcu_as_sc_mcu7t3v3__inv_2_162 VSS VSS gf180mcu_as_sc_mcu7t3v3__inv_2_162/Y gf180mcu_as_sc_mcu7t3v3__inv_2_163/Y
+ gf180mcu_as_sc_mcu7t3v3__inv_2_163/VNW VSUBS gf180mcu_as_sc_mcu7t3v3__inv_2
Xgf180mcu_as_sc_mcu7t3v3__inv_2_1639 VSS VSS VSS gf180mcu_as_sc_mcu7t3v3__inv_2_1643/Y
+ gf180mcu_as_sc_mcu7t3v3__inv_2_1653/VNW VSUBS gf180mcu_as_sc_mcu7t3v3__inv_2
Xgf180mcu_as_sc_mcu7t3v3__inv_2_1628 VSS VSS gf180mcu_as_sc_mcu7t3v3__inv_2_1628/Y
+ gf180mcu_as_sc_mcu7t3v3__inv_2_1628/A gf180mcu_as_sc_mcu7t3v3__inv_2_1685/VNW VSUBS
+ gf180mcu_as_sc_mcu7t3v3__inv_2
Xu_t015_007 u_t015_007/c0_w0_bl u_t015_007/c0_w0_br u_t015_007/c0_w1_bl u_t015_007/c0_w1_br
+ u_t015_007/c0_r0_rbl u_t015_007/c0_r1_rbl u_t015_007/c1_w0_bl u_t015_007/c1_w0_br
+ u_t015_007/c1_w1_bl u_t015_007/c1_w1_br u_t015_007/c1_r0_rbl u_t015_007/c1_r1_rbl
+ u_t015_007/c2_w0_bl u_t015_007/c2_w0_br u_t015_007/c2_w1_bl u_t015_007/c2_w1_br
+ u_t015_007/c2_r0_rbl u_t015_007/c2_r1_rbl u_t015_007/c3_w0_bl u_t015_007/c3_w0_br
+ u_t015_007/c3_w1_bl u_t015_007/c3_w1_br u_t015_007/c3_r0_rbl u_t015_007/c3_r1_rbl
+ u_t015_007/r0_w0_wl u_t015_007/r0_w1_wl u_t015_007/r0_r0_rwl u_t015_007/r0_r1_rwl
+ u_t015_007/r1_w0_wl u_t015_007/r1_w1_wl u_t015_007/r1_r0_rwl u_t015_007/r1_r1_rwl
+ u_t015_007/r2_w0_wl u_t015_007/r2_w1_wl u_t015_007/r2_r0_rwl u_t015_007/r2_r1_rwl
+ u_t015_007/r3_w0_wl u_t015_007/r3_w1_wl u_t015_007/r3_r0_rwl u_t015_007/r3_r1_rwl
+ VSS VSS u_t015_007/m2_717_1265# u_t015_007/m2_603_2031# u_t015_007/m2_1290_336#
+ u_t015_007/m2_2000_2037# u_t015_007/m2_791_2909# u_t015_007/m2_7_2126# u_t015_007/m2_2154_2081#
+ u_t015_007/m2_1795_2037# u_t015_007/m2_871_303# u_t015_007/m2_431_438# u_t015_007/m2_1290_2898#
+ u_t015_007/m2_1714_1210# u_t015_007/m2_431_1982# u_t015_007/m2_512_1265# u_t015_007/m2_2573_2126#
+ u_t015_007/m2_603_1259# u_t015_007/m2_2074_2909# u_t015_007/m2_7_336# u_t015_007/m2_717_2037#
+ u_t015_007/m2_1886_2031# u_t015_007/m2_2573_336# u_t015_007/m2_7_2898# u_t015_007/m2_2000_1265#
+ u_t015_007/m2_512_2037# u_t015_007/m2_1795_1265# u_t015_007/m2_1714_1982# u_t015_007/m2_1886_1259#
+ u_t015_007/m2_1290_2126# u_t015_007/m2_1714_438# u_t015_007/m2_431_1210# u_t015_007/m2_2573_2898#
+ u_t015_007/m2_2154_303# u_t015_007/m2_871_2081# VSUBS detronyx_12t_2w2r_rc4_4x4_routed_5layer_direct
Xu_t006_007 u_t006_007/c0_w0_bl u_t006_007/c0_w0_br u_t006_007/c0_w1_bl u_t006_007/c0_w1_br
+ u_t006_007/c0_r0_rbl u_t006_007/c0_r1_rbl u_t006_007/c1_w0_bl u_t006_007/c1_w0_br
+ u_t006_007/c1_w1_bl u_t006_007/c1_w1_br u_t006_007/c1_r0_rbl u_t006_007/c1_r1_rbl
+ u_t006_007/c2_w0_bl u_t006_007/c2_w0_br u_t006_007/c2_w1_bl u_t006_007/c2_w1_br
+ u_t006_007/c2_r0_rbl u_t006_007/c2_r1_rbl u_t006_007/c3_w0_bl u_t006_007/c3_w0_br
+ u_t006_007/c3_w1_bl u_t006_007/c3_w1_br u_t006_007/c3_r0_rbl u_t006_007/c3_r1_rbl
+ u_t006_007/r0_w0_wl u_t006_007/r0_w1_wl u_t006_007/r0_r0_rwl u_t006_007/r0_r1_rwl
+ u_t006_007/r1_w0_wl u_t006_007/r1_w1_wl u_t006_007/r1_r0_rwl u_t006_007/r1_r1_rwl
+ u_t006_007/r2_w0_wl u_t006_007/r2_w1_wl u_t006_007/r2_r0_rwl u_t006_007/r2_r1_rwl
+ u_t006_007/r3_w0_wl u_t006_007/r3_w1_wl u_t006_007/r3_r0_rwl u_t006_007/r3_r1_rwl
+ VSS VSS u_t006_007/m2_717_1265# u_t006_007/m2_603_2031# u_t006_007/m2_1290_336#
+ u_t006_007/m2_2000_2037# u_t006_007/m2_791_2909# u_t006_007/m2_7_2126# u_t006_007/m2_2154_2081#
+ u_t006_007/m2_1795_2037# u_t006_007/m2_871_303# u_t006_007/m2_431_438# u_t006_007/m2_1290_2898#
+ u_t006_007/m2_1714_1210# u_t006_007/m2_431_1982# u_t006_007/m2_512_1265# u_t006_007/m2_2573_2126#
+ u_t006_007/m2_603_1259# u_t006_007/m2_2074_2909# u_t006_007/m2_7_336# u_t006_007/m2_717_2037#
+ u_t006_007/m2_1886_2031# u_t006_007/m2_2573_336# u_t006_007/m2_7_2898# u_t006_007/m2_2000_1265#
+ u_t006_007/m2_512_2037# u_t006_007/m2_1795_1265# u_t006_007/m2_1714_1982# u_t006_007/m2_1886_1259#
+ u_t006_007/m2_1290_2126# u_t006_007/m2_1714_438# u_t006_007/m2_431_1210# u_t006_007/m2_2573_2898#
+ u_t006_007/m2_2154_303# u_t006_007/m2_871_2081# VSUBS detronyx_12t_2w2r_rc4_4x4_routed_5layer_direct
Xgf180mcu_as_sc_mcu7t3v3__nand2_2_41 gf180mcu_as_sc_mcu7t3v3__nor2_2_9/VDD gf180mcu_as_sc_mcu7t3v3__nand3_2_63/VSS
+ VSS VSS VSS gf180mcu_as_sc_mcu7t3v3__nor2_2_9/VNW VSUBS gf180mcu_as_sc_mcu7t3v3__nand2_2
Xgf180mcu_as_sc_mcu7t3v3__nand2_2_30 gf180mcu_as_sc_mcu7t3v3__nand3_2_9/VDD gf180mcu_as_sc_mcu7t3v3__nor2_2_4/VSS
+ VSS VSS VSS gf180mcu_as_sc_mcu7t3v3__nand3_2_9/VNW VSUBS gf180mcu_as_sc_mcu7t3v3__nand2_2
Xgf180mcu_as_sc_mcu7t3v3__nand2_2_52 gf180mcu_as_sc_mcu7t3v3__nand3_2_65/VDD gf180mcu_as_sc_mcu7t3v3__nand3_2_62/VSS
+ VSS VSS VSS gf180mcu_as_sc_mcu7t3v3__nand3_2_65/VNW VSUBS gf180mcu_as_sc_mcu7t3v3__nand2_2
Xu_t020_010 u_t020_010/c0_w0_bl u_t020_010/c0_w0_br u_t020_010/c0_w1_bl u_t020_010/c0_w1_br
+ u_t020_010/c0_r0_rbl u_t020_010/c0_r1_rbl u_t020_010/c1_w0_bl u_t020_010/c1_w0_br
+ u_t020_010/c1_w1_bl u_t020_010/c1_w1_br u_t020_010/c1_r0_rbl u_t020_010/c1_r1_rbl
+ u_t020_010/c2_w0_bl u_t020_010/c2_w0_br u_t020_010/c2_w1_bl u_t020_010/c2_w1_br
+ u_t020_010/c2_r0_rbl u_t020_010/c2_r1_rbl u_t020_010/c3_w0_bl u_t020_010/c3_w0_br
+ u_t020_010/c3_w1_bl u_t020_010/c3_w1_br u_t020_010/c3_r0_rbl u_t020_010/c3_r1_rbl
+ u_t020_010/r0_w0_wl u_t020_010/r0_w1_wl u_t020_010/r0_r0_rwl u_t020_010/r0_r1_rwl
+ u_t020_010/r1_w0_wl u_t020_010/r1_w1_wl u_t020_010/r1_r0_rwl u_t020_010/r1_r1_rwl
+ u_t020_010/r2_w0_wl u_t020_010/r2_w1_wl u_t020_010/r2_r0_rwl u_t020_010/r2_r1_rwl
+ u_t020_010/r3_w0_wl u_t020_010/r3_w1_wl u_t020_010/r3_r0_rwl u_t020_010/r3_r1_rwl
+ VSS VSS u_t020_010/m2_717_1265# u_t020_010/m2_603_2031# u_t020_010/m2_1290_336#
+ u_t020_010/m2_2000_2037# u_t020_010/m2_791_2909# u_t020_010/m2_7_2126# u_t020_010/m2_2154_2081#
+ u_t020_010/m2_1795_2037# u_t020_010/m2_871_303# u_t020_010/m2_431_438# u_t020_010/m2_1290_2898#
+ u_t020_010/m2_1714_1210# u_t020_010/m2_431_1982# u_t020_010/m2_512_1265# u_t020_010/m2_2573_2126#
+ u_t020_010/m2_603_1259# u_t020_010/m2_2074_2909# u_t020_010/m2_7_336# u_t020_010/m2_717_2037#
+ u_t020_010/m2_1886_2031# u_t020_010/m2_2573_336# u_t020_010/m2_7_2898# u_t020_010/m2_2000_1265#
+ u_t020_010/m2_512_2037# u_t020_010/m2_1795_1265# u_t020_010/m2_1714_1982# u_t020_010/m2_1886_1259#
+ u_t020_010/m2_1290_2126# u_t020_010/m2_1714_438# u_t020_010/m2_431_1210# u_t020_010/m2_2573_2898#
+ u_t020_010/m2_2154_303# u_t020_010/m2_871_2081# VSUBS detronyx_12t_2w2r_rc4_4x4_routed_5layer_direct
Xgf180mcu_as_sc_mcu7t3v3__inv_2_1469 VSS VSS gf180mcu_as_sc_mcu7t3v3__inv_2_1469/Y
+ gf180mcu_as_sc_mcu7t3v3__inv_2_1470/Y gf180mcu_as_sc_mcu7t3v3__inv_2_1470/VNW VSUBS
+ gf180mcu_as_sc_mcu7t3v3__inv_2
Xgf180mcu_as_sc_mcu7t3v3__inv_2_1403 VSS VSS gf180mcu_as_sc_mcu7t3v3__inv_2_1403/Y
+ gf180mcu_as_sc_mcu7t3v3__inv_2_1403/A gf180mcu_as_sc_mcu7t3v3__inv_2_1403/VNW VSUBS
+ gf180mcu_as_sc_mcu7t3v3__inv_2
Xgf180mcu_as_sc_mcu7t3v3__inv_2_1414 VSS VSS VSS gf180mcu_as_sc_mcu7t3v3__inv_2_1415/Y
+ gf180mcu_as_sc_mcu7t3v3__inv_2_1416/VNW VSUBS gf180mcu_as_sc_mcu7t3v3__inv_2
Xgf180mcu_as_sc_mcu7t3v3__inv_2_1447 VSS VSS VSS gf180mcu_as_sc_mcu7t3v3__inv_2_1448/Y
+ gf180mcu_as_sc_mcu7t3v3__inv_2_1449/VNW VSUBS gf180mcu_as_sc_mcu7t3v3__inv_2
Xgf180mcu_as_sc_mcu7t3v3__inv_2_1436 VSS VSS gf180mcu_as_sc_mcu7t3v3__inv_2_1436/Y
+ gf180mcu_as_sc_mcu7t3v3__inv_2_1437/Y gf180mcu_as_sc_mcu7t3v3__inv_2_1437/VNW VSUBS
+ gf180mcu_as_sc_mcu7t3v3__inv_2
Xgf180mcu_as_sc_mcu7t3v3__inv_2_1425 VSS VSS gf180mcu_as_sc_mcu7t3v3__inv_2_1425/Y
+ gf180mcu_as_sc_mcu7t3v3__inv_2_1425/A gf180mcu_as_sc_mcu7t3v3__inv_2_1425/VNW VSUBS
+ gf180mcu_as_sc_mcu7t3v3__inv_2
Xgf180mcu_as_sc_mcu7t3v3__inv_2_1458 VSS VSS gf180mcu_as_sc_mcu7t3v3__inv_2_1479/A
+ gf180mcu_as_sc_mcu7t3v3__inv_2_1458/A gf180mcu_as_sc_mcu7t3v3__inv_2_1479/VNW VSUBS
+ gf180mcu_as_sc_mcu7t3v3__inv_2
Xgf180mcu_as_sc_mcu7t3v3__inv_2_909 VSS VSS gf180mcu_as_sc_mcu7t3v3__inv_2_954/A gf180mcu_as_sc_mcu7t3v3__inv_2_910/Y
+ gf180mcu_as_sc_mcu7t3v3__inv_2_954/VNW VSUBS gf180mcu_as_sc_mcu7t3v3__inv_2
Xu_t011_010 u_t011_010/c0_w0_bl u_t011_010/c0_w0_br u_t011_010/c0_w1_bl u_t011_010/c0_w1_br
+ u_t011_010/c0_r0_rbl u_t011_010/c0_r1_rbl u_t011_010/c1_w0_bl u_t011_010/c1_w0_br
+ u_t011_010/c1_w1_bl u_t011_010/c1_w1_br u_t011_010/c1_r0_rbl u_t011_010/c1_r1_rbl
+ u_t011_010/c2_w0_bl u_t011_010/c2_w0_br u_t011_010/c2_w1_bl u_t011_010/c2_w1_br
+ u_t011_010/c2_r0_rbl u_t011_010/c2_r1_rbl u_t011_010/c3_w0_bl u_t011_010/c3_w0_br
+ u_t011_010/c3_w1_bl u_t011_010/c3_w1_br u_t011_010/c3_r0_rbl u_t011_010/c3_r1_rbl
+ u_t011_010/r0_w0_wl u_t011_010/r0_w1_wl u_t011_010/r0_r0_rwl u_t011_010/r0_r1_rwl
+ u_t011_010/r1_w0_wl u_t011_010/r1_w1_wl u_t011_010/r1_r0_rwl u_t011_010/r1_r1_rwl
+ u_t011_010/r2_w0_wl u_t011_010/r2_w1_wl u_t011_010/r2_r0_rwl u_t011_010/r2_r1_rwl
+ u_t011_010/r3_w0_wl u_t011_010/r3_w1_wl u_t011_010/r3_r0_rwl u_t011_010/r3_r1_rwl
+ VSS VSS u_t011_010/m2_717_1265# u_t011_010/m2_603_2031# u_t011_010/m2_1290_336#
+ u_t011_010/m2_2000_2037# u_t011_010/m2_791_2909# u_t011_010/m2_7_2126# u_t011_010/m2_2154_2081#
+ u_t011_010/m2_1795_2037# u_t011_010/m2_871_303# u_t011_010/m2_431_438# u_t011_010/m2_1290_2898#
+ u_t011_010/m2_1714_1210# u_t011_010/m2_431_1982# u_t011_010/m2_512_1265# u_t011_010/m2_2573_2126#
+ u_t011_010/m2_603_1259# u_t011_010/m2_2074_2909# u_t011_010/m2_7_336# u_t011_010/m2_717_2037#
+ u_t011_010/m2_1886_2031# u_t011_010/m2_2573_336# u_t011_010/m2_7_2898# u_t011_010/m2_2000_1265#
+ u_t011_010/m2_512_2037# u_t011_010/m2_1795_1265# u_t011_010/m2_1714_1982# u_t011_010/m2_1886_1259#
+ u_t011_010/m2_1290_2126# u_t011_010/m2_1714_438# u_t011_010/m2_431_1210# u_t011_010/m2_2573_2898#
+ u_t011_010/m2_2154_303# u_t011_010/m2_871_2081# VSUBS detronyx_12t_2w2r_rc4_4x4_routed_5layer_direct
Xgf180mcu_as_sc_mcu7t3v3__nand4_2_219 VSS VSS VSS VSS VSS VSS gf180mcu_as_sc_mcu7t3v3__inv_2_759/A
+ gf180mcu_as_sc_mcu7t3v3__inv_2_820/VNW VSUBS gf180mcu_as_sc_mcu7t3v3__nand4_2
Xgf180mcu_as_sc_mcu7t3v3__nand4_2_208 VSS VSS VSS VSS VSS VSS gf180mcu_as_sc_mcu7t3v3__inv_2_674/A
+ gf180mcu_as_sc_mcu7t3v3__inv_2_674/VNW VSUBS gf180mcu_as_sc_mcu7t3v3__nand4_2
Xu_t002_010 u_t002_010/c0_w0_bl u_t002_010/c0_w0_br u_t002_010/c0_w1_bl u_t002_010/c0_w1_br
+ u_t002_010/c0_r0_rbl u_t002_010/c0_r1_rbl u_t002_010/c1_w0_bl u_t002_010/c1_w0_br
+ u_t002_010/c1_w1_bl u_t002_010/c1_w1_br u_t002_010/c1_r0_rbl u_t002_010/c1_r1_rbl
+ u_t002_010/c2_w0_bl u_t002_010/c2_w0_br u_t002_010/c2_w1_bl u_t002_010/c2_w1_br
+ u_t002_010/c2_r0_rbl u_t002_010/c2_r1_rbl u_t002_010/c3_w0_bl u_t002_010/c3_w0_br
+ u_t002_010/c3_w1_bl u_t002_010/c3_w1_br u_t002_010/c3_r0_rbl u_t002_010/c3_r1_rbl
+ u_t002_010/r0_w0_wl u_t002_010/r0_w1_wl u_t002_010/r0_r0_rwl u_t002_010/r0_r1_rwl
+ u_t002_010/r1_w0_wl u_t002_010/r1_w1_wl u_t002_010/r1_r0_rwl u_t002_010/r1_r1_rwl
+ u_t002_010/r2_w0_wl u_t002_010/r2_w1_wl u_t002_010/r2_r0_rwl u_t002_010/r2_r1_rwl
+ u_t002_010/r3_w0_wl u_t002_010/r3_w1_wl u_t002_010/r3_r0_rwl u_t002_010/r3_r1_rwl
+ VSS VSS u_t002_010/m2_717_1265# u_t002_010/m2_603_2031# u_t002_010/m2_1290_336#
+ u_t002_010/m2_2000_2037# u_t002_010/m2_791_2909# u_t002_010/m2_7_2126# u_t002_010/m2_2154_2081#
+ u_t002_010/m2_1795_2037# u_t002_010/m2_871_303# u_t002_010/m2_431_438# u_t002_010/m2_1290_2898#
+ u_t002_010/m2_1714_1210# u_t002_010/m2_431_1982# u_t002_010/m2_512_1265# u_t002_010/m2_2573_2126#
+ u_t002_010/m2_603_1259# u_t002_010/m2_2074_2909# u_t002_010/m2_7_336# u_t002_010/m2_717_2037#
+ u_t002_010/m2_1886_2031# u_t002_010/m2_2573_336# u_t002_010/m2_7_2898# u_t002_010/m2_2000_1265#
+ u_t002_010/m2_512_2037# u_t002_010/m2_1795_1265# u_t002_010/m2_1714_1982# u_t002_010/m2_1886_1259#
+ u_t002_010/m2_1290_2126# u_t002_010/m2_1714_438# u_t002_010/m2_431_1210# u_t002_010/m2_2573_2898#
+ u_t002_010/m2_2154_303# u_t002_010/m2_871_2081# VSUBS detronyx_12t_2w2r_rc4_4x4_routed_5layer_direct
Xgf180mcu_as_sc_mcu7t3v3__inv_2_1244 gf180mcu_as_sc_mcu7t3v3__nand3_2_65/VDD gf180mcu_as_sc_mcu7t3v3__nor2_2_9/VSS
+ VSS VSS gf180mcu_as_sc_mcu7t3v3__nand3_2_65/VNW VSUBS gf180mcu_as_sc_mcu7t3v3__inv_2
Xgf180mcu_as_sc_mcu7t3v3__inv_2_1233 gf180mcu_as_sc_mcu7t3v3__nand3_2_65/VDD gf180mcu_as_sc_mcu7t3v3__nor2_2_9/VSS
+ VSS VSS gf180mcu_as_sc_mcu7t3v3__nand3_2_65/VNW VSUBS gf180mcu_as_sc_mcu7t3v3__inv_2
Xgf180mcu_as_sc_mcu7t3v3__inv_2_1266 gf180mcu_as_sc_mcu7t3v3__nand3_2_65/VDD gf180mcu_as_sc_mcu7t3v3__nor2_2_9/VSS
+ VSS VSS gf180mcu_as_sc_mcu7t3v3__nand3_2_65/VNW VSUBS gf180mcu_as_sc_mcu7t3v3__inv_2
Xgf180mcu_as_sc_mcu7t3v3__inv_2_1211 gf180mcu_as_sc_mcu7t3v3__nand3_2_65/VDD gf180mcu_as_sc_mcu7t3v3__nor2_2_9/VSS
+ gf180mcu_as_sc_mcu7t3v3__inv_2_1211/Y VSS gf180mcu_as_sc_mcu7t3v3__nand3_2_65/VNW
+ VSUBS gf180mcu_as_sc_mcu7t3v3__inv_2
Xgf180mcu_as_sc_mcu7t3v3__inv_2_1255 gf180mcu_as_sc_mcu7t3v3__nand3_2_65/VDD gf180mcu_as_sc_mcu7t3v3__nand3_2_62/VSS
+ VSS VSS gf180mcu_as_sc_mcu7t3v3__nand3_2_65/VNW VSUBS gf180mcu_as_sc_mcu7t3v3__inv_2
Xgf180mcu_as_sc_mcu7t3v3__inv_2_1277 VSS VSS VSS gf180mcu_as_sc_mcu7t3v3__inv_2_1277/A
+ gf180mcu_as_sc_mcu7t3v3__inv_2_1277/VNW VSUBS gf180mcu_as_sc_mcu7t3v3__inv_2
Xgf180mcu_as_sc_mcu7t3v3__inv_2_1222 VSS VSS gf180mcu_as_sc_mcu7t3v3__inv_2_1222/Y
+ gf180mcu_as_sc_mcu7t3v3__inv_2_1222/A gf180mcu_as_sc_mcu7t3v3__inv_2_1283/VNW VSUBS
+ gf180mcu_as_sc_mcu7t3v3__inv_2
Xgf180mcu_as_sc_mcu7t3v3__inv_2_1200 VSS VSS gf180mcu_as_sc_mcu7t3v3__inv_2_1200/Y
+ gf180mcu_as_sc_mcu7t3v3__inv_2_1200/A gf180mcu_as_sc_mcu7t3v3__inv_2_1272/VNW VSUBS
+ gf180mcu_as_sc_mcu7t3v3__inv_2
Xgf180mcu_as_sc_mcu7t3v3__inv_2_1299 VSS VSS VSS gf180mcu_as_sc_mcu7t3v3__inv_2_1299/A
+ gf180mcu_as_sc_mcu7t3v3__inv_2_1299/VNW VSUBS gf180mcu_as_sc_mcu7t3v3__inv_2
Xgf180mcu_as_sc_mcu7t3v3__inv_2_1288 VSS VSS VSS gf180mcu_as_sc_mcu7t3v3__inv_2_1288/A
+ gf180mcu_as_sc_mcu7t3v3__inv_2_1288/VNW VSUBS gf180mcu_as_sc_mcu7t3v3__inv_2
Xgf180mcu_as_sc_mcu7t3v3__inv_2_728 VSS VSS gf180mcu_as_sc_mcu7t3v3__inv_2_728/Y gf180mcu_as_sc_mcu7t3v3__inv_2_728/A
+ gf180mcu_as_sc_mcu7t3v3__inv_2_728/VNW VSUBS gf180mcu_as_sc_mcu7t3v3__inv_2
Xgf180mcu_as_sc_mcu7t3v3__inv_2_706 VSS VSS VSS gf180mcu_as_sc_mcu7t3v3__inv_2_707/Y
+ gf180mcu_as_sc_mcu7t3v3__inv_2_730/VNW VSUBS gf180mcu_as_sc_mcu7t3v3__inv_2
Xgf180mcu_as_sc_mcu7t3v3__inv_2_717 VSS VSS gf180mcu_as_sc_mcu7t3v3__inv_2_717/Y gf180mcu_as_sc_mcu7t3v3__inv_2_717/A
+ gf180mcu_as_sc_mcu7t3v3__inv_2_717/VNW VSUBS gf180mcu_as_sc_mcu7t3v3__inv_2
Xgf180mcu_as_sc_mcu7t3v3__inv_2_739 VSS VSS gf180mcu_as_sc_mcu7t3v3__inv_2_739/Y gf180mcu_as_sc_mcu7t3v3__inv_2_740/Y
+ gf180mcu_as_sc_mcu7t3v3__inv_2_740/VNW VSUBS gf180mcu_as_sc_mcu7t3v3__inv_2
Xgf180mcu_as_sc_mcu7t3v3__inv_2_82 VSS VSS VSS gf180mcu_as_sc_mcu7t3v3__inv_2_83/Y
+ gf180mcu_as_sc_mcu7t3v3__inv_2_92/VNW VSUBS gf180mcu_as_sc_mcu7t3v3__inv_2
Xgf180mcu_as_sc_mcu7t3v3__inv_2_93 VSS VSS VSS gf180mcu_as_sc_mcu7t3v3__inv_2_94/Y
+ gf180mcu_as_sc_mcu7t3v3__inv_2_94/VNW VSUBS gf180mcu_as_sc_mcu7t3v3__inv_2
Xgf180mcu_as_sc_mcu7t3v3__inv_2_71 VSS VSS VSS gf180mcu_as_sc_mcu7t3v3__inv_2_72/Y
+ gf180mcu_as_sc_mcu7t3v3__inv_2_73/VNW VSUBS gf180mcu_as_sc_mcu7t3v3__inv_2
Xgf180mcu_as_sc_mcu7t3v3__inv_2_60 VSS VSS gf180mcu_as_sc_mcu7t3v3__inv_2_60/Y gf180mcu_as_sc_mcu7t3v3__inv_2_61/Y
+ gf180mcu_as_sc_mcu7t3v3__inv_2_61/VNW VSUBS gf180mcu_as_sc_mcu7t3v3__inv_2
Xgf180mcu_as_sc_mcu7t3v3__inv_2_1074 VSS VSS gf180mcu_as_sc_mcu7t3v3__inv_2_1074/Y
+ gf180mcu_as_sc_mcu7t3v3__inv_2_1075/Y gf180mcu_as_sc_mcu7t3v3__inv_2_1075/VNW VSUBS
+ gf180mcu_as_sc_mcu7t3v3__inv_2
Xgf180mcu_as_sc_mcu7t3v3__inv_2_1085 VSS VSS VSS gf180mcu_as_sc_mcu7t3v3__inv_2_1086/Y
+ gf180mcu_as_sc_mcu7t3v3__inv_2_1087/VNW VSUBS gf180mcu_as_sc_mcu7t3v3__inv_2
Xgf180mcu_as_sc_mcu7t3v3__inv_2_1063 VSS VSS gf180mcu_as_sc_mcu7t3v3__inv_2_1063/Y
+ gf180mcu_as_sc_mcu7t3v3__inv_2_1064/Y gf180mcu_as_sc_mcu7t3v3__inv_2_1064/VNW VSUBS
+ gf180mcu_as_sc_mcu7t3v3__inv_2
Xgf180mcu_as_sc_mcu7t3v3__inv_2_1096 VSS VSS gf180mcu_as_sc_mcu7t3v3__inv_2_1096/Y
+ gf180mcu_as_sc_mcu7t3v3__inv_2_1096/A gf180mcu_as_sc_mcu7t3v3__inv_2_1096/VNW VSUBS
+ gf180mcu_as_sc_mcu7t3v3__inv_2
Xgf180mcu_as_sc_mcu7t3v3__inv_2_1030 VSS VSS VSS gf180mcu_as_sc_mcu7t3v3__inv_2_1031/Y
+ gf180mcu_as_sc_mcu7t3v3__inv_2_1032/VNW VSUBS gf180mcu_as_sc_mcu7t3v3__inv_2
Xgf180mcu_as_sc_mcu7t3v3__inv_2_1041 VSS VSS VSS gf180mcu_as_sc_mcu7t3v3__inv_2_1045/Y
+ gf180mcu_as_sc_mcu7t3v3__inv_2_1049/VNW VSUBS gf180mcu_as_sc_mcu7t3v3__inv_2
Xgf180mcu_as_sc_mcu7t3v3__inv_2_1052 VSS VSS gf180mcu_as_sc_mcu7t3v3__inv_2_1052/Y
+ gf180mcu_as_sc_mcu7t3v3__inv_2_1052/A gf180mcu_as_sc_mcu7t3v3__inv_2_1052/VNW VSUBS
+ gf180mcu_as_sc_mcu7t3v3__inv_2
Xgf180mcu_as_sc_mcu7t3v3__nand4_2_8 VSS VSS VSS VSS VSS VSS gf180mcu_as_sc_mcu7t3v3__inv_2_85/A
+ gf180mcu_as_sc_mcu7t3v3__inv_2_91/VNW VSUBS gf180mcu_as_sc_mcu7t3v3__nand4_2
Xgf180mcu_as_sc_mcu7t3v3__inv_2_558 VSS VSS VSS gf180mcu_as_sc_mcu7t3v3__inv_2_558/A
+ gf180mcu_as_sc_mcu7t3v3__inv_2_558/VNW VSUBS gf180mcu_as_sc_mcu7t3v3__inv_2
Xgf180mcu_as_sc_mcu7t3v3__inv_2_514 VSS VSS gf180mcu_as_sc_mcu7t3v3__inv_2_514/Y gf180mcu_as_sc_mcu7t3v3__inv_2_514/A
+ gf180mcu_as_sc_mcu7t3v3__inv_2_558/VNW VSUBS gf180mcu_as_sc_mcu7t3v3__inv_2
Xgf180mcu_as_sc_mcu7t3v3__inv_2_547 VSS VSS VSS gf180mcu_as_sc_mcu7t3v3__inv_2_547/A
+ gf180mcu_as_sc_mcu7t3v3__inv_2_547/VNW VSUBS gf180mcu_as_sc_mcu7t3v3__inv_2
Xgf180mcu_as_sc_mcu7t3v3__inv_2_569 VSS VSS gf180mcu_as_sc_mcu7t3v3__inv_2_569/Y gf180mcu_as_sc_mcu7t3v3__inv_2_570/Y
+ gf180mcu_as_sc_mcu7t3v3__inv_2_570/VNW VSUBS gf180mcu_as_sc_mcu7t3v3__inv_2
Xgf180mcu_as_sc_mcu7t3v3__inv_2_525 gf180mcu_as_sc_mcu7t3v3__nand3_2_9/VDD gf180mcu_as_sc_mcu7t3v3__nor2_2_4/VSS
+ VSS VSS gf180mcu_as_sc_mcu7t3v3__nand3_2_9/VNW VSUBS gf180mcu_as_sc_mcu7t3v3__inv_2
Xgf180mcu_as_sc_mcu7t3v3__inv_2_503 VSS VSS gf180mcu_as_sc_mcu7t3v3__inv_2_503/Y gf180mcu_as_sc_mcu7t3v3__inv_2_503/A
+ gf180mcu_as_sc_mcu7t3v3__inv_2_556/VNW VSUBS gf180mcu_as_sc_mcu7t3v3__inv_2
Xgf180mcu_as_sc_mcu7t3v3__inv_2_536 VSS VSS VSS gf180mcu_as_sc_mcu7t3v3__inv_2_536/A
+ gf180mcu_as_sc_mcu7t3v3__inv_2_536/VNW VSUBS gf180mcu_as_sc_mcu7t3v3__inv_2
Xgf180mcu_as_sc_mcu7t3v3__nand4_2_380 VSS VSS VSS VSS VSS VSS gf180mcu_as_sc_mcu7t3v3__inv_2_1410/A
+ gf180mcu_as_sc_mcu7t3v3__inv_2_1457/VNW VSUBS gf180mcu_as_sc_mcu7t3v3__nand4_2
Xgf180mcu_as_sc_mcu7t3v3__nand4_2_391 VSS VSS VSS VSS VSS VSS gf180mcu_as_sc_mcu7t3v3__inv_2_1443/A
+ gf180mcu_as_sc_mcu7t3v3__inv_2_1443/VNW VSUBS gf180mcu_as_sc_mcu7t3v3__nand4_2
Xgf180mcu_as_sc_mcu7t3v3__inv_2_300 VSS VSS gf180mcu_as_sc_mcu7t3v3__inv_2_300/Y gf180mcu_as_sc_mcu7t3v3__inv_2_300/A
+ gf180mcu_as_sc_mcu7t3v3__inv_2_303/VNW VSUBS gf180mcu_as_sc_mcu7t3v3__inv_2
Xgf180mcu_as_sc_mcu7t3v3__inv_2_311 VSS VSS gf180mcu_as_sc_mcu7t3v3__inv_2_311/Y gf180mcu_as_sc_mcu7t3v3__inv_2_311/A
+ gf180mcu_as_sc_mcu7t3v3__inv_2_311/VNW VSUBS gf180mcu_as_sc_mcu7t3v3__inv_2
Xgf180mcu_as_sc_mcu7t3v3__inv_2_377 gf180mcu_as_sc_mcu7t3v3__nor2_2_6/VDD gf180mcu_as_sc_mcu7t3v3__nor2_2_6/VSS
+ VSS VSS gf180mcu_as_sc_mcu7t3v3__nor2_2_6/VNW VSUBS gf180mcu_as_sc_mcu7t3v3__inv_2
Xgf180mcu_as_sc_mcu7t3v3__inv_2_388 gf180mcu_as_sc_mcu7t3v3__nor2_2_7/VDD gf180mcu_as_sc_mcu7t3v3__nor2_2_7/VSS
+ VSS VSS gf180mcu_as_sc_mcu7t3v3__nor2_2_7/VNW VSUBS gf180mcu_as_sc_mcu7t3v3__inv_2
Xgf180mcu_as_sc_mcu7t3v3__inv_2_399 gf180mcu_as_sc_mcu7t3v3__nor2_2_4/VDD gf180mcu_as_sc_mcu7t3v3__nor2_2_4/VSS
+ VSS VSS gf180mcu_as_sc_mcu7t3v3__nor2_2_4/VNW VSUBS gf180mcu_as_sc_mcu7t3v3__inv_2
Xgf180mcu_as_sc_mcu7t3v3__inv_2_366 VSS VSS VSS gf180mcu_as_sc_mcu7t3v3__inv_2_367/Y
+ gf180mcu_as_sc_mcu7t3v3__inv_2_368/VNW VSUBS gf180mcu_as_sc_mcu7t3v3__inv_2
Xgf180mcu_as_sc_mcu7t3v3__inv_2_355 VSS VSS gf180mcu_as_sc_mcu7t3v3__inv_2_355/Y gf180mcu_as_sc_mcu7t3v3__inv_2_356/Y
+ gf180mcu_as_sc_mcu7t3v3__inv_2_356/VNW VSUBS gf180mcu_as_sc_mcu7t3v3__inv_2
Xgf180mcu_as_sc_mcu7t3v3__inv_2_344 VSS VSS gf180mcu_as_sc_mcu7t3v3__inv_2_344/Y gf180mcu_as_sc_mcu7t3v3__inv_2_344/A
+ gf180mcu_as_sc_mcu7t3v3__inv_2_344/VNW VSUBS gf180mcu_as_sc_mcu7t3v3__inv_2
Xgf180mcu_as_sc_mcu7t3v3__inv_2_333 VSS VSS VSS gf180mcu_as_sc_mcu7t3v3__inv_2_334/Y
+ gf180mcu_as_sc_mcu7t3v3__inv_2_335/VNW VSUBS gf180mcu_as_sc_mcu7t3v3__inv_2
Xgf180mcu_as_sc_mcu7t3v3__inv_2_322 VSS VSS gf180mcu_as_sc_mcu7t3v3__inv_2_322/Y gf180mcu_as_sc_mcu7t3v3__inv_2_323/Y
+ gf180mcu_as_sc_mcu7t3v3__inv_2_323/VNW VSUBS gf180mcu_as_sc_mcu7t3v3__inv_2
Xu_t027_005 u_t027_005/c0_w0_bl u_t027_005/c0_w0_br u_t027_005/c0_w1_bl u_t027_005/c0_w1_br
+ u_t027_005/c0_r0_rbl u_t027_005/c0_r1_rbl u_t027_005/c1_w0_bl u_t027_005/c1_w0_br
+ u_t027_005/c1_w1_bl u_t027_005/c1_w1_br u_t027_005/c1_r0_rbl u_t027_005/c1_r1_rbl
+ u_t027_005/c2_w0_bl u_t027_005/c2_w0_br u_t027_005/c2_w1_bl u_t027_005/c2_w1_br
+ u_t027_005/c2_r0_rbl u_t027_005/c2_r1_rbl u_t027_005/c3_w0_bl u_t027_005/c3_w0_br
+ u_t027_005/c3_w1_bl u_t027_005/c3_w1_br u_t027_005/c3_r0_rbl u_t027_005/c3_r1_rbl
+ u_t027_005/r0_w0_wl u_t027_005/r0_w1_wl u_t027_005/r0_r0_rwl u_t027_005/r0_r1_rwl
+ u_t027_005/r1_w0_wl u_t027_005/r1_w1_wl u_t027_005/r1_r0_rwl u_t027_005/r1_r1_rwl
+ u_t027_005/r2_w0_wl u_t027_005/r2_w1_wl u_t027_005/r2_r0_rwl u_t027_005/r2_r1_rwl
+ u_t027_005/r3_w0_wl u_t027_005/r3_w1_wl u_t027_005/r3_r0_rwl u_t027_005/r3_r1_rwl
+ VSS VSS u_t027_005/m2_717_1265# u_t027_005/m2_603_2031# u_t027_005/m2_1290_336#
+ u_t027_005/m2_2000_2037# u_t027_005/m2_791_2909# u_t027_005/m2_7_2126# u_t027_005/m2_2154_2081#
+ u_t027_005/m2_1795_2037# u_t027_005/m2_871_303# u_t027_005/m2_431_438# u_t027_005/m2_1290_2898#
+ u_t027_005/m2_1714_1210# u_t027_005/m2_431_1982# u_t027_005/m2_512_1265# u_t027_005/m2_2573_2126#
+ u_t027_005/m2_603_1259# u_t027_005/m2_2074_2909# u_t027_005/m2_7_336# u_t027_005/m2_717_2037#
+ u_t027_005/m2_1886_2031# u_t027_005/m2_2573_336# u_t027_005/m2_7_2898# u_t027_005/m2_2000_1265#
+ u_t027_005/m2_512_2037# u_t027_005/m2_1795_1265# u_t027_005/m2_1714_1982# u_t027_005/m2_1886_1259#
+ u_t027_005/m2_1290_2126# u_t027_005/m2_1714_438# u_t027_005/m2_431_1210# u_t027_005/m2_2573_2898#
+ u_t027_005/m2_2154_303# u_t027_005/m2_871_2081# VSUBS detronyx_12t_2w2r_rc4_4x4_routed_5layer_direct
Xu_t018_005 u_t018_005/c0_w0_bl u_t018_005/c0_w0_br u_t018_005/c0_w1_bl u_t018_005/c0_w1_br
+ u_t018_005/c0_r0_rbl u_t018_005/c0_r1_rbl u_t018_005/c1_w0_bl u_t018_005/c1_w0_br
+ u_t018_005/c1_w1_bl u_t018_005/c1_w1_br u_t018_005/c1_r0_rbl u_t018_005/c1_r1_rbl
+ u_t018_005/c2_w0_bl u_t018_005/c2_w0_br u_t018_005/c2_w1_bl u_t018_005/c2_w1_br
+ u_t018_005/c2_r0_rbl u_t018_005/c2_r1_rbl u_t018_005/c3_w0_bl u_t018_005/c3_w0_br
+ u_t018_005/c3_w1_bl u_t018_005/c3_w1_br u_t018_005/c3_r0_rbl u_t018_005/c3_r1_rbl
+ u_t018_005/r0_w0_wl u_t018_005/r0_w1_wl u_t018_005/r0_r0_rwl u_t018_005/r0_r1_rwl
+ u_t018_005/r1_w0_wl u_t018_005/r1_w1_wl u_t018_005/r1_r0_rwl u_t018_005/r1_r1_rwl
+ u_t018_005/r2_w0_wl u_t018_005/r2_w1_wl u_t018_005/r2_r0_rwl u_t018_005/r2_r1_rwl
+ u_t018_005/r3_w0_wl u_t018_005/r3_w1_wl u_t018_005/r3_r0_rwl u_t018_005/r3_r1_rwl
+ VSS VSS u_t018_005/m2_717_1265# u_t018_005/m2_603_2031# u_t018_005/m2_1290_336#
+ u_t018_005/m2_2000_2037# u_t018_005/m2_791_2909# u_t018_005/m2_7_2126# u_t018_005/m2_2154_2081#
+ u_t018_005/m2_1795_2037# u_t018_005/m2_871_303# u_t018_005/m2_431_438# u_t018_005/m2_1290_2898#
+ u_t018_005/m2_1714_1210# u_t018_005/m2_431_1982# u_t018_005/m2_512_1265# u_t018_005/m2_2573_2126#
+ u_t018_005/m2_603_1259# u_t018_005/m2_2074_2909# u_t018_005/m2_7_336# u_t018_005/m2_717_2037#
+ u_t018_005/m2_1886_2031# u_t018_005/m2_2573_336# u_t018_005/m2_7_2898# u_t018_005/m2_2000_1265#
+ u_t018_005/m2_512_2037# u_t018_005/m2_1795_1265# u_t018_005/m2_1714_1982# u_t018_005/m2_1886_1259#
+ u_t018_005/m2_1290_2126# u_t018_005/m2_1714_438# u_t018_005/m2_431_1210# u_t018_005/m2_2573_2898#
+ u_t018_005/m2_2154_303# u_t018_005/m2_871_2081# VSUBS detronyx_12t_2w2r_rc4_4x4_routed_5layer_direct
Xu_t024_008 u_t024_008/c0_w0_bl u_t024_008/c0_w0_br u_t024_008/c0_w1_bl u_t024_008/c0_w1_br
+ u_t024_008/c0_r0_rbl u_t024_008/c0_r1_rbl u_t024_008/c1_w0_bl u_t024_008/c1_w0_br
+ u_t024_008/c1_w1_bl u_t024_008/c1_w1_br u_t024_008/c1_r0_rbl u_t024_008/c1_r1_rbl
+ u_t024_008/c2_w0_bl u_t024_008/c2_w0_br u_t024_008/c2_w1_bl u_t024_008/c2_w1_br
+ u_t024_008/c2_r0_rbl u_t024_008/c2_r1_rbl u_t024_008/c3_w0_bl u_t024_008/c3_w0_br
+ u_t024_008/c3_w1_bl u_t024_008/c3_w1_br u_t024_008/c3_r0_rbl u_t024_008/c3_r1_rbl
+ u_t024_008/r0_w0_wl u_t024_008/r0_w1_wl u_t024_008/r0_r0_rwl u_t024_008/r0_r1_rwl
+ u_t024_008/r1_w0_wl u_t024_008/r1_w1_wl u_t024_008/r1_r0_rwl u_t024_008/r1_r1_rwl
+ u_t024_008/r2_w0_wl u_t024_008/r2_w1_wl u_t024_008/r2_r0_rwl u_t024_008/r2_r1_rwl
+ u_t024_008/r3_w0_wl u_t024_008/r3_w1_wl u_t024_008/r3_r0_rwl u_t024_008/r3_r1_rwl
+ VSS VSS u_t024_008/m2_717_1265# u_t024_008/m2_603_2031# u_t024_008/m2_1290_336#
+ u_t024_008/m2_2000_2037# u_t024_008/m2_791_2909# u_t024_008/m2_7_2126# u_t024_008/m2_2154_2081#
+ u_t024_008/m2_1795_2037# u_t024_008/m2_871_303# u_t024_008/m2_431_438# u_t024_008/m2_1290_2898#
+ u_t024_008/m2_1714_1210# u_t024_008/m2_431_1982# u_t024_008/m2_512_1265# u_t024_008/m2_2573_2126#
+ u_t024_008/m2_603_1259# u_t024_008/m2_2074_2909# u_t024_008/m2_7_336# u_t024_008/m2_717_2037#
+ u_t024_008/m2_1886_2031# u_t024_008/m2_2573_336# u_t024_008/m2_7_2898# u_t024_008/m2_2000_1265#
+ u_t024_008/m2_512_2037# u_t024_008/m2_1795_1265# u_t024_008/m2_1714_1982# u_t024_008/m2_1886_1259#
+ u_t024_008/m2_1290_2126# u_t024_008/m2_1714_438# u_t024_008/m2_431_1210# u_t024_008/m2_2573_2898#
+ u_t024_008/m2_2154_303# u_t024_008/m2_871_2081# VSUBS detronyx_12t_2w2r_rc4_4x4_routed_5layer_direct
Xu_t009_005 u_t009_005/c0_w0_bl u_t009_005/c0_w0_br u_t009_005/c0_w1_bl u_t009_005/c0_w1_br
+ u_t009_005/c0_r0_rbl u_t009_005/c0_r1_rbl u_t009_005/c1_w0_bl u_t009_005/c1_w0_br
+ u_t009_005/c1_w1_bl u_t009_005/c1_w1_br u_t009_005/c1_r0_rbl u_t009_005/c1_r1_rbl
+ u_t009_005/c2_w0_bl u_t009_005/c2_w0_br u_t009_005/c2_w1_bl u_t009_005/c2_w1_br
+ u_t009_005/c2_r0_rbl u_t009_005/c2_r1_rbl u_t009_005/c3_w0_bl u_t009_005/c3_w0_br
+ u_t009_005/c3_w1_bl u_t009_005/c3_w1_br u_t009_005/c3_r0_rbl u_t009_005/c3_r1_rbl
+ u_t009_005/r0_w0_wl u_t009_005/r0_w1_wl u_t009_005/r0_r0_rwl u_t009_005/r0_r1_rwl
+ u_t009_005/r1_w0_wl u_t009_005/r1_w1_wl u_t009_005/r1_r0_rwl u_t009_005/r1_r1_rwl
+ u_t009_005/r2_w0_wl u_t009_005/r2_w1_wl u_t009_005/r2_r0_rwl u_t009_005/r2_r1_rwl
+ u_t009_005/r3_w0_wl u_t009_005/r3_w1_wl u_t009_005/r3_r0_rwl u_t009_005/r3_r1_rwl
+ VSS VSS u_t009_005/m2_717_1265# u_t009_005/m2_603_2031# u_t009_005/m2_1290_336#
+ u_t009_005/m2_2000_2037# u_t009_005/m2_791_2909# u_t009_005/m2_7_2126# u_t009_005/m2_2154_2081#
+ u_t009_005/m2_1795_2037# u_t009_005/m2_871_303# u_t009_005/m2_431_438# u_t009_005/m2_1290_2898#
+ u_t009_005/m2_1714_1210# u_t009_005/m2_431_1982# u_t009_005/m2_512_1265# u_t009_005/m2_2573_2126#
+ u_t009_005/m2_603_1259# u_t009_005/m2_2074_2909# u_t009_005/m2_7_336# u_t009_005/m2_717_2037#
+ u_t009_005/m2_1886_2031# u_t009_005/m2_2573_336# u_t009_005/m2_7_2898# u_t009_005/m2_2000_1265#
+ u_t009_005/m2_512_2037# u_t009_005/m2_1795_1265# u_t009_005/m2_1714_1982# u_t009_005/m2_1886_1259#
+ u_t009_005/m2_1290_2126# u_t009_005/m2_1714_438# u_t009_005/m2_431_1210# u_t009_005/m2_2573_2898#
+ u_t009_005/m2_2154_303# u_t009_005/m2_871_2081# VSUBS detronyx_12t_2w2r_rc4_4x4_routed_5layer_direct
Xgf180mcu_as_sc_mcu7t3v3__inv_2_152 VSS VSS gf180mcu_as_sc_mcu7t3v3__inv_2_152/Y gf180mcu_as_sc_mcu7t3v3__inv_2_152/A
+ gf180mcu_as_sc_mcu7t3v3__inv_2_152/VNW VSUBS gf180mcu_as_sc_mcu7t3v3__inv_2
Xgf180mcu_as_sc_mcu7t3v3__inv_2_141 VSS VSS VSS gf180mcu_as_sc_mcu7t3v3__inv_2_142/Y
+ gf180mcu_as_sc_mcu7t3v3__inv_2_143/VNW VSUBS gf180mcu_as_sc_mcu7t3v3__inv_2
Xgf180mcu_as_sc_mcu7t3v3__inv_2_130 VSS VSS gf180mcu_as_sc_mcu7t3v3__inv_2_130/Y gf180mcu_as_sc_mcu7t3v3__inv_2_131/Y
+ gf180mcu_as_sc_mcu7t3v3__inv_2_131/VNW VSUBS gf180mcu_as_sc_mcu7t3v3__inv_2
Xgf180mcu_as_sc_mcu7t3v3__inv_2_1607 VSS VSS gf180mcu_as_sc_mcu7t3v3__inv_2_1689/A
+ gf180mcu_as_sc_mcu7t3v3__inv_2_1611/Y gf180mcu_as_sc_mcu7t3v3__inv_2_1689/VNW VSUBS
+ gf180mcu_as_sc_mcu7t3v3__inv_2
Xgf180mcu_as_sc_mcu7t3v3__inv_2_1629 VSS VSS VSS gf180mcu_as_sc_mcu7t3v3__inv_2_1630/Y
+ gf180mcu_as_sc_mcu7t3v3__inv_2_1631/VNW VSUBS gf180mcu_as_sc_mcu7t3v3__inv_2
Xgf180mcu_as_sc_mcu7t3v3__inv_2_1618 VSS VSS gf180mcu_as_sc_mcu7t3v3__inv_2_1618/Y
+ gf180mcu_as_sc_mcu7t3v3__inv_2_1618/A gf180mcu_as_sc_mcu7t3v3__inv_2_1618/VNW VSUBS
+ gf180mcu_as_sc_mcu7t3v3__inv_2
Xgf180mcu_as_sc_mcu7t3v3__inv_2_174 VSS VSS gf180mcu_as_sc_mcu7t3v3__inv_2_174/Y gf180mcu_as_sc_mcu7t3v3__inv_2_174/A
+ gf180mcu_as_sc_mcu7t3v3__inv_2_174/VNW VSUBS gf180mcu_as_sc_mcu7t3v3__inv_2
Xgf180mcu_as_sc_mcu7t3v3__inv_2_196 VSS VSS gf180mcu_as_sc_mcu7t3v3__inv_2_196/Y gf180mcu_as_sc_mcu7t3v3__inv_2_196/A
+ gf180mcu_as_sc_mcu7t3v3__inv_2_196/VNW VSUBS gf180mcu_as_sc_mcu7t3v3__inv_2
Xgf180mcu_as_sc_mcu7t3v3__inv_2_163 VSS VSS gf180mcu_as_sc_mcu7t3v3__inv_2_163/Y gf180mcu_as_sc_mcu7t3v3__inv_2_163/A
+ gf180mcu_as_sc_mcu7t3v3__inv_2_163/VNW VSUBS gf180mcu_as_sc_mcu7t3v3__inv_2
Xgf180mcu_as_sc_mcu7t3v3__inv_2_185 VSS VSS VSS gf180mcu_as_sc_mcu7t3v3__inv_2_186/Y
+ gf180mcu_as_sc_mcu7t3v3__inv_2_187/VNW VSUBS gf180mcu_as_sc_mcu7t3v3__inv_2
Xu_t015_008 u_t015_008/c0_w0_bl u_t015_008/c0_w0_br u_t015_008/c0_w1_bl u_t015_008/c0_w1_br
+ u_t015_008/c0_r0_rbl u_t015_008/c0_r1_rbl u_t015_008/c1_w0_bl u_t015_008/c1_w0_br
+ u_t015_008/c1_w1_bl u_t015_008/c1_w1_br u_t015_008/c1_r0_rbl u_t015_008/c1_r1_rbl
+ u_t015_008/c2_w0_bl u_t015_008/c2_w0_br u_t015_008/c2_w1_bl u_t015_008/c2_w1_br
+ u_t015_008/c2_r0_rbl u_t015_008/c2_r1_rbl u_t015_008/c3_w0_bl u_t015_008/c3_w0_br
+ u_t015_008/c3_w1_bl u_t015_008/c3_w1_br u_t015_008/c3_r0_rbl u_t015_008/c3_r1_rbl
+ u_t015_008/r0_w0_wl u_t015_008/r0_w1_wl u_t015_008/r0_r0_rwl u_t015_008/r0_r1_rwl
+ u_t015_008/r1_w0_wl u_t015_008/r1_w1_wl u_t015_008/r1_r0_rwl u_t015_008/r1_r1_rwl
+ u_t015_008/r2_w0_wl u_t015_008/r2_w1_wl u_t015_008/r2_r0_rwl u_t015_008/r2_r1_rwl
+ u_t015_008/r3_w0_wl u_t015_008/r3_w1_wl u_t015_008/r3_r0_rwl u_t015_008/r3_r1_rwl
+ VSS VSS u_t015_008/m2_717_1265# u_t015_008/m2_603_2031# u_t015_008/m2_1290_336#
+ u_t015_008/m2_2000_2037# u_t015_008/m2_791_2909# u_t015_008/m2_7_2126# u_t015_008/m2_2154_2081#
+ u_t015_008/m2_1795_2037# u_t015_008/m2_871_303# u_t015_008/m2_431_438# u_t015_008/m2_1290_2898#
+ u_t015_008/m2_1714_1210# u_t015_008/m2_431_1982# u_t015_008/m2_512_1265# u_t015_008/m2_2573_2126#
+ u_t015_008/m2_603_1259# u_t015_008/m2_2074_2909# u_t015_008/m2_7_336# u_t015_008/m2_717_2037#
+ u_t015_008/m2_1886_2031# u_t015_008/m2_2573_336# u_t015_008/m2_7_2898# u_t015_008/m2_2000_1265#
+ u_t015_008/m2_512_2037# u_t015_008/m2_1795_1265# u_t015_008/m2_1714_1982# u_t015_008/m2_1886_1259#
+ u_t015_008/m2_1290_2126# u_t015_008/m2_1714_438# u_t015_008/m2_431_1210# u_t015_008/m2_2573_2898#
+ u_t015_008/m2_2154_303# u_t015_008/m2_871_2081# VSUBS detronyx_12t_2w2r_rc4_4x4_routed_5layer_direct
Xu_t006_008 u_t006_008/c0_w0_bl u_t006_008/c0_w0_br u_t006_008/c0_w1_bl u_t006_008/c0_w1_br
+ u_t006_008/c0_r0_rbl u_t006_008/c0_r1_rbl u_t006_008/c1_w0_bl u_t006_008/c1_w0_br
+ u_t006_008/c1_w1_bl u_t006_008/c1_w1_br u_t006_008/c1_r0_rbl u_t006_008/c1_r1_rbl
+ u_t006_008/c2_w0_bl u_t006_008/c2_w0_br u_t006_008/c2_w1_bl u_t006_008/c2_w1_br
+ u_t006_008/c2_r0_rbl u_t006_008/c2_r1_rbl u_t006_008/c3_w0_bl u_t006_008/c3_w0_br
+ u_t006_008/c3_w1_bl u_t006_008/c3_w1_br u_t006_008/c3_r0_rbl u_t006_008/c3_r1_rbl
+ u_t006_008/r0_w0_wl u_t006_008/r0_w1_wl u_t006_008/r0_r0_rwl u_t006_008/r0_r1_rwl
+ u_t006_008/r1_w0_wl u_t006_008/r1_w1_wl u_t006_008/r1_r0_rwl u_t006_008/r1_r1_rwl
+ u_t006_008/r2_w0_wl u_t006_008/r2_w1_wl u_t006_008/r2_r0_rwl u_t006_008/r2_r1_rwl
+ u_t006_008/r3_w0_wl u_t006_008/r3_w1_wl u_t006_008/r3_r0_rwl u_t006_008/r3_r1_rwl
+ VSS VSS u_t006_008/m2_717_1265# u_t006_008/m2_603_2031# u_t006_008/m2_1290_336#
+ u_t006_008/m2_2000_2037# u_t006_008/m2_791_2909# u_t006_008/m2_7_2126# u_t006_008/m2_2154_2081#
+ u_t006_008/m2_1795_2037# u_t006_008/m2_871_303# u_t006_008/m2_431_438# u_t006_008/m2_1290_2898#
+ u_t006_008/m2_1714_1210# u_t006_008/m2_431_1982# u_t006_008/m2_512_1265# u_t006_008/m2_2573_2126#
+ u_t006_008/m2_603_1259# u_t006_008/m2_2074_2909# u_t006_008/m2_7_336# u_t006_008/m2_717_2037#
+ u_t006_008/m2_1886_2031# u_t006_008/m2_2573_336# u_t006_008/m2_7_2898# u_t006_008/m2_2000_1265#
+ u_t006_008/m2_512_2037# u_t006_008/m2_1795_1265# u_t006_008/m2_1714_1982# u_t006_008/m2_1886_1259#
+ u_t006_008/m2_1290_2126# u_t006_008/m2_1714_438# u_t006_008/m2_431_1210# u_t006_008/m2_2573_2898#
+ u_t006_008/m2_2154_303# u_t006_008/m2_871_2081# VSUBS detronyx_12t_2w2r_rc4_4x4_routed_5layer_direct
Xgf180mcu_as_sc_mcu7t3v3__nand2_2_42 gf180mcu_as_sc_mcu7t3v3__nand3_2_65/VDD gf180mcu_as_sc_mcu7t3v3__nor2_2_9/VSS
+ VSS VSS VSS gf180mcu_as_sc_mcu7t3v3__nand3_2_65/VNW VSUBS gf180mcu_as_sc_mcu7t3v3__nand2_2
Xgf180mcu_as_sc_mcu7t3v3__nand2_2_20 gf180mcu_as_sc_mcu7t3v3__nor2_2_4/VDD gf180mcu_as_sc_mcu7t3v3__nor2_2_4/VSS
+ VSS VSS VSS gf180mcu_as_sc_mcu7t3v3__nor2_2_4/VNW VSUBS gf180mcu_as_sc_mcu7t3v3__nand2_2
Xgf180mcu_as_sc_mcu7t3v3__nand2_2_31 gf180mcu_as_sc_mcu7t3v3__nand3_2_9/VDD gf180mcu_as_sc_mcu7t3v3__nor2_2_4/VSS
+ VSS VSS VSS gf180mcu_as_sc_mcu7t3v3__nand3_2_9/VNW VSUBS gf180mcu_as_sc_mcu7t3v3__nand2_2
Xu_t020_000 VSS u_t020_000/c0_w0_br VSS u_t020_000/c0_w1_br u_t020_000/c0_r0_rbl u_t020_000/c0_r1_rbl
+ VSS VSS VSS VSS VSS VSS u_t020_000/c2_w0_bl u_t020_000/c2_w0_br u_t020_000/c2_w1_bl
+ u_t020_000/c2_w1_br u_t020_000/c2_r0_rbl u_t020_000/c2_r1_rbl u_t020_000/c3_w0_bl
+ u_t020_000/c3_w0_br u_t020_000/c3_w1_bl u_t020_000/c3_w1_br u_t020_000/c3_r0_rbl
+ u_t020_000/c3_r1_rbl VSS VSS VSS VSS VSS VSS VSS VSS VSS VSS VSS VSS VSS VSS VSS
+ VSS VSS VSS VSS VSS VSS VSS VSS VSS VSS VSS VSS VSS VSS VSS VSS VSS u_t020_000/m2_2573_2126#
+ VSS VSS VSS VSS VSS u_t020_000/m2_2573_336# VSS VSS VSS VSS VSS VSS VSS VSS VSS
+ u_t020_000/m2_2573_2898# VSS VSS VSUBS detronyx_12t_2w2r_rc4_4x4_routed_5layer_direct
Xu_t020_011 u_t020_011/c0_w0_bl u_t020_011/c0_w0_br u_t020_011/c0_w1_bl u_t020_011/c0_w1_br
+ u_t020_011/c0_r0_rbl u_t020_011/c0_r1_rbl u_t020_011/c1_w0_bl u_t020_011/c1_w0_br
+ u_t020_011/c1_w1_bl u_t020_011/c1_w1_br u_t020_011/c1_r0_rbl u_t020_011/c1_r1_rbl
+ u_t020_011/c2_w0_bl u_t020_011/c2_w0_br u_t020_011/c2_w1_bl u_t020_011/c2_w1_br
+ u_t020_011/c2_r0_rbl u_t020_011/c2_r1_rbl u_t020_011/c3_w0_bl u_t020_011/c3_w0_br
+ u_t020_011/c3_w1_bl u_t020_011/c3_w1_br u_t020_011/c3_r0_rbl u_t020_011/c3_r1_rbl
+ u_t020_011/r0_w0_wl u_t020_011/r0_w1_wl u_t020_011/r0_r0_rwl u_t020_011/r0_r1_rwl
+ u_t020_011/r1_w0_wl u_t020_011/r1_w1_wl u_t020_011/r1_r0_rwl u_t020_011/r1_r1_rwl
+ u_t020_011/r2_w0_wl u_t020_011/r2_w1_wl u_t020_011/r2_r0_rwl u_t020_011/r2_r1_rwl
+ u_t020_011/r3_w0_wl u_t020_011/r3_w1_wl u_t020_011/r3_r0_rwl u_t020_011/r3_r1_rwl
+ VSS VSS u_t020_011/m2_717_1265# u_t020_011/m2_603_2031# u_t020_011/m2_1290_336#
+ u_t020_011/m2_2000_2037# u_t020_011/m2_791_2909# u_t020_011/m2_7_2126# u_t020_011/m2_2154_2081#
+ u_t020_011/m2_1795_2037# u_t020_011/m2_871_303# u_t020_011/m2_431_438# u_t020_011/m2_1290_2898#
+ u_t020_011/m2_1714_1210# u_t020_011/m2_431_1982# u_t020_011/m2_512_1265# u_t020_011/m2_2573_2126#
+ u_t020_011/m2_603_1259# u_t020_011/m2_2074_2909# u_t020_011/m2_7_336# u_t020_011/m2_717_2037#
+ u_t020_011/m2_1886_2031# u_t020_011/m2_2573_336# u_t020_011/m2_7_2898# u_t020_011/m2_2000_1265#
+ u_t020_011/m2_512_2037# u_t020_011/m2_1795_1265# u_t020_011/m2_1714_1982# u_t020_011/m2_1886_1259#
+ u_t020_011/m2_1290_2126# u_t020_011/m2_1714_438# u_t020_011/m2_431_1210# u_t020_011/m2_2573_2898#
+ u_t020_011/m2_2154_303# u_t020_011/m2_871_2081# VSUBS detronyx_12t_2w2r_rc4_4x4_routed_5layer_direct
Xgf180mcu_as_sc_mcu7t3v3__inv_2_1404 VSS VSS VSS gf180mcu_as_sc_mcu7t3v3__inv_2_1405/Y
+ gf180mcu_as_sc_mcu7t3v3__inv_2_1406/VNW VSUBS gf180mcu_as_sc_mcu7t3v3__inv_2
Xgf180mcu_as_sc_mcu7t3v3__inv_2_1459 VSS VSS VSS gf180mcu_as_sc_mcu7t3v3__inv_2_1460/Y
+ gf180mcu_as_sc_mcu7t3v3__inv_2_1461/VNW VSUBS gf180mcu_as_sc_mcu7t3v3__inv_2
Xgf180mcu_as_sc_mcu7t3v3__inv_2_1415 VSS VSS gf180mcu_as_sc_mcu7t3v3__inv_2_1415/Y
+ gf180mcu_as_sc_mcu7t3v3__inv_2_1416/Y gf180mcu_as_sc_mcu7t3v3__inv_2_1416/VNW VSUBS
+ gf180mcu_as_sc_mcu7t3v3__inv_2
Xgf180mcu_as_sc_mcu7t3v3__inv_2_1448 VSS VSS gf180mcu_as_sc_mcu7t3v3__inv_2_1448/Y
+ gf180mcu_as_sc_mcu7t3v3__inv_2_1449/Y gf180mcu_as_sc_mcu7t3v3__inv_2_1449/VNW VSUBS
+ gf180mcu_as_sc_mcu7t3v3__inv_2
Xgf180mcu_as_sc_mcu7t3v3__inv_2_1437 VSS VSS gf180mcu_as_sc_mcu7t3v3__inv_2_1437/Y
+ gf180mcu_as_sc_mcu7t3v3__inv_2_1437/A gf180mcu_as_sc_mcu7t3v3__inv_2_1437/VNW VSUBS
+ gf180mcu_as_sc_mcu7t3v3__inv_2
Xgf180mcu_as_sc_mcu7t3v3__inv_2_1426 VSS VSS VSS gf180mcu_as_sc_mcu7t3v3__inv_2_1427/Y
+ gf180mcu_as_sc_mcu7t3v3__inv_2_1428/VNW VSUBS gf180mcu_as_sc_mcu7t3v3__inv_2
Xu_t011_011 u_t011_011/c0_w0_bl u_t011_011/c0_w0_br u_t011_011/c0_w1_bl u_t011_011/c0_w1_br
+ u_t011_011/c0_r0_rbl u_t011_011/c0_r1_rbl u_t011_011/c1_w0_bl u_t011_011/c1_w0_br
+ u_t011_011/c1_w1_bl u_t011_011/c1_w1_br u_t011_011/c1_r0_rbl u_t011_011/c1_r1_rbl
+ u_t011_011/c2_w0_bl u_t011_011/c2_w0_br u_t011_011/c2_w1_bl u_t011_011/c2_w1_br
+ u_t011_011/c2_r0_rbl u_t011_011/c2_r1_rbl u_t011_011/c3_w0_bl u_t011_011/c3_w0_br
+ u_t011_011/c3_w1_bl u_t011_011/c3_w1_br u_t011_011/c3_r0_rbl u_t011_011/c3_r1_rbl
+ u_t011_011/r0_w0_wl u_t011_011/r0_w1_wl u_t011_011/r0_r0_rwl u_t011_011/r0_r1_rwl
+ u_t011_011/r1_w0_wl u_t011_011/r1_w1_wl u_t011_011/r1_r0_rwl u_t011_011/r1_r1_rwl
+ u_t011_011/r2_w0_wl u_t011_011/r2_w1_wl u_t011_011/r2_r0_rwl u_t011_011/r2_r1_rwl
+ u_t011_011/r3_w0_wl u_t011_011/r3_w1_wl u_t011_011/r3_r0_rwl u_t011_011/r3_r1_rwl
+ VSS VSS u_t011_011/m2_717_1265# u_t011_011/m2_603_2031# u_t011_011/m2_1290_336#
+ u_t011_011/m2_2000_2037# u_t011_011/m2_791_2909# u_t011_011/m2_7_2126# u_t011_011/m2_2154_2081#
+ u_t011_011/m2_1795_2037# u_t011_011/m2_871_303# u_t011_011/m2_431_438# u_t011_011/m2_1290_2898#
+ u_t011_011/m2_1714_1210# u_t011_011/m2_431_1982# u_t011_011/m2_512_1265# u_t011_011/m2_2573_2126#
+ u_t011_011/m2_603_1259# u_t011_011/m2_2074_2909# u_t011_011/m2_7_336# u_t011_011/m2_717_2037#
+ u_t011_011/m2_1886_2031# u_t011_011/m2_2573_336# u_t011_011/m2_7_2898# u_t011_011/m2_2000_1265#
+ u_t011_011/m2_512_2037# u_t011_011/m2_1795_1265# u_t011_011/m2_1714_1982# u_t011_011/m2_1886_1259#
+ u_t011_011/m2_1290_2126# u_t011_011/m2_1714_438# u_t011_011/m2_431_1210# u_t011_011/m2_2573_2898#
+ u_t011_011/m2_2154_303# u_t011_011/m2_871_2081# VSUBS detronyx_12t_2w2r_rc4_4x4_routed_5layer_direct
Xu_t011_000 VSS u_t011_000/c0_w0_br VSS u_t011_000/c0_w1_br u_t011_000/c0_r0_rbl u_t011_000/c0_r1_rbl
+ VSS VSS VSS VSS VSS VSS u_t011_000/c2_w0_bl u_t011_000/c2_w0_br u_t011_000/c2_w1_bl
+ u_t011_000/c2_w1_br u_t011_000/c2_r0_rbl u_t011_000/c2_r1_rbl u_t011_000/c3_w0_bl
+ u_t011_000/c3_w0_br u_t011_000/c3_w1_bl u_t011_000/c3_w1_br u_t011_000/c3_r0_rbl
+ u_t011_000/c3_r1_rbl VSS VSS VSS VSS VSS VSS VSS VSS VSS VSS VSS VSS VSS VSS VSS
+ VSS VSS VSS u_t011_000/m2_717_1265# u_t011_000/m2_603_2031# u_t011_000/m2_1290_336#
+ u_t011_000/m2_2000_2037# u_t011_000/m2_791_2909# u_t011_000/m2_7_2126# u_t011_000/m2_2154_2081#
+ u_t011_000/m2_1795_2037# u_t011_000/m2_871_303# u_t011_000/m2_431_438# u_t011_000/m2_1290_2898#
+ u_t011_000/m2_1714_1210# u_t011_000/m2_431_1982# u_t011_000/m2_512_1265# u_t011_000/m2_2573_2126#
+ u_t011_000/m2_603_1259# u_t011_000/m2_2074_2909# u_t011_000/m2_7_336# u_t011_000/m2_717_2037#
+ u_t011_000/m2_1886_2031# u_t011_000/m2_2573_336# u_t011_000/m2_7_2898# u_t011_000/m2_2000_1265#
+ u_t011_000/m2_512_2037# u_t011_000/m2_1795_1265# u_t011_000/m2_1714_1982# u_t011_000/m2_1886_1259#
+ u_t011_000/m2_1290_2126# u_t011_000/m2_1714_438# u_t011_000/m2_431_1210# u_t011_000/m2_2573_2898#
+ u_t011_000/m2_2154_303# u_t011_000/m2_871_2081# VSUBS detronyx_12t_2w2r_rc4_4x4_routed_5layer_direct
Xgf180mcu_as_sc_mcu7t3v3__nand4_2_209 VSS VSS VSS VSS VSS VSS gf180mcu_as_sc_mcu7t3v3__inv_2_678/A
+ gf180mcu_as_sc_mcu7t3v3__inv_2_678/VNW VSUBS gf180mcu_as_sc_mcu7t3v3__nand4_2
Xu_t002_011 u_t002_011/c0_w0_bl u_t002_011/c0_w0_br u_t002_011/c0_w1_bl u_t002_011/c0_w1_br
+ u_t002_011/c0_r0_rbl u_t002_011/c0_r1_rbl u_t002_011/c1_w0_bl u_t002_011/c1_w0_br
+ u_t002_011/c1_w1_bl u_t002_011/c1_w1_br u_t002_011/c1_r0_rbl u_t002_011/c1_r1_rbl
+ u_t002_011/c2_w0_bl u_t002_011/c2_w0_br u_t002_011/c2_w1_bl u_t002_011/c2_w1_br
+ u_t002_011/c2_r0_rbl u_t002_011/c2_r1_rbl u_t002_011/c3_w0_bl u_t002_011/c3_w0_br
+ u_t002_011/c3_w1_bl u_t002_011/c3_w1_br u_t002_011/c3_r0_rbl u_t002_011/c3_r1_rbl
+ u_t002_011/r0_w0_wl u_t002_011/r0_w1_wl u_t002_011/r0_r0_rwl u_t002_011/r0_r1_rwl
+ u_t002_011/r1_w0_wl u_t002_011/r1_w1_wl u_t002_011/r1_r0_rwl u_t002_011/r1_r1_rwl
+ u_t002_011/r2_w0_wl u_t002_011/r2_w1_wl u_t002_011/r2_r0_rwl u_t002_011/r2_r1_rwl
+ u_t002_011/r3_w0_wl u_t002_011/r3_w1_wl u_t002_011/r3_r0_rwl u_t002_011/r3_r1_rwl
+ VSS VSS u_t002_011/m2_717_1265# u_t002_011/m2_603_2031# u_t002_011/m2_1290_336#
+ u_t002_011/m2_2000_2037# u_t002_011/m2_791_2909# u_t002_011/m2_7_2126# u_t002_011/m2_2154_2081#
+ u_t002_011/m2_1795_2037# u_t002_011/m2_871_303# u_t002_011/m2_431_438# u_t002_011/m2_1290_2898#
+ u_t002_011/m2_1714_1210# u_t002_011/m2_431_1982# u_t002_011/m2_512_1265# u_t002_011/m2_2573_2126#
+ u_t002_011/m2_603_1259# u_t002_011/m2_2074_2909# u_t002_011/m2_7_336# u_t002_011/m2_717_2037#
+ u_t002_011/m2_1886_2031# u_t002_011/m2_2573_336# u_t002_011/m2_7_2898# u_t002_011/m2_2000_1265#
+ u_t002_011/m2_512_2037# u_t002_011/m2_1795_1265# u_t002_011/m2_1714_1982# u_t002_011/m2_1886_1259#
+ u_t002_011/m2_1290_2126# u_t002_011/m2_1714_438# u_t002_011/m2_431_1210# u_t002_011/m2_2573_2898#
+ u_t002_011/m2_2154_303# u_t002_011/m2_871_2081# VSUBS detronyx_12t_2w2r_rc4_4x4_routed_5layer_direct
Xu_t002_000 VSS u_t002_000/c0_w0_br VSS u_t002_000/c0_w1_br u_t002_000/c0_r0_rbl u_t002_000/c0_r1_rbl
+ VSS VSS VSS VSS VSS VSS u_t002_000/c2_w0_bl u_t002_000/c2_w0_br u_t002_000/c2_w1_bl
+ u_t002_000/c2_w1_br u_t002_000/c2_r0_rbl u_t002_000/c2_r1_rbl u_t002_000/c3_w0_bl
+ u_t002_000/c3_w0_br u_t002_000/c3_w1_bl u_t002_000/c3_w1_br u_t002_000/c3_r0_rbl
+ u_t002_000/c3_r1_rbl VSS VSS VSS VSS VSS VSS VSS VSS VSS VSS VSS VSS VSS VSS VSS
+ VSS VSS VSS u_t002_000/m2_717_1265# u_t002_000/m2_603_2031# u_t002_000/m2_1290_336#
+ u_t002_000/m2_2000_2037# u_t002_000/m2_791_2909# u_t002_000/m2_7_2126# u_t002_000/m2_2154_2081#
+ u_t002_000/m2_1795_2037# u_t002_000/m2_871_303# u_t002_000/m2_431_438# u_t002_000/m2_1290_2898#
+ u_t002_000/m2_1714_1210# u_t002_000/m2_431_1982# u_t002_000/m2_512_1265# u_t002_000/m2_2573_2126#
+ u_t002_000/m2_603_1259# u_t002_000/m2_2074_2909# u_t002_000/m2_7_336# u_t002_000/m2_717_2037#
+ u_t002_000/m2_1886_2031# u_t002_000/m2_2573_336# u_t002_000/m2_7_2898# u_t002_000/m2_2000_1265#
+ u_t002_000/m2_512_2037# u_t002_000/m2_1795_1265# u_t002_000/m2_1714_1982# u_t002_000/m2_1886_1259#
+ u_t002_000/m2_1290_2126# u_t002_000/m2_1714_438# u_t002_000/m2_431_1210# u_t002_000/m2_2573_2898#
+ u_t002_000/m2_2154_303# u_t002_000/m2_871_2081# VSUBS detronyx_12t_2w2r_rc4_4x4_routed_5layer_direct
Xgf180mcu_as_sc_mcu7t3v3__inv_2_1201 gf180mcu_as_sc_mcu7t3v3__nor2_2_9/VDD gf180mcu_as_sc_mcu7t3v3__nor2_2_9/VSS
+ gf180mcu_as_sc_mcu7t3v3__inv_2_1201/Y VSS gf180mcu_as_sc_mcu7t3v3__nor2_2_9/VNW
+ VSUBS gf180mcu_as_sc_mcu7t3v3__inv_2
Xgf180mcu_as_sc_mcu7t3v3__inv_2_1245 gf180mcu_as_sc_mcu7t3v3__nor2_2_9/VDD gf180mcu_as_sc_mcu7t3v3__nand3_2_63/VSS
+ VSS VSS gf180mcu_as_sc_mcu7t3v3__nor2_2_9/VNW VSUBS gf180mcu_as_sc_mcu7t3v3__inv_2
Xgf180mcu_as_sc_mcu7t3v3__inv_2_1234 gf180mcu_as_sc_mcu7t3v3__nor2_2_9/VDD gf180mcu_as_sc_mcu7t3v3__nand3_2_63/VSS
+ VSS VSS gf180mcu_as_sc_mcu7t3v3__nor2_2_9/VNW VSUBS gf180mcu_as_sc_mcu7t3v3__inv_2
Xgf180mcu_as_sc_mcu7t3v3__inv_2_1267 gf180mcu_as_sc_mcu7t3v3__nor2_2_9/VDD gf180mcu_as_sc_mcu7t3v3__nand3_2_63/VSS
+ VSS VSS gf180mcu_as_sc_mcu7t3v3__nor2_2_9/VNW VSUBS gf180mcu_as_sc_mcu7t3v3__inv_2
Xgf180mcu_as_sc_mcu7t3v3__inv_2_1212 gf180mcu_as_sc_mcu7t3v3__nor2_2_9/VDD gf180mcu_as_sc_mcu7t3v3__nand3_2_63/VSS
+ gf180mcu_as_sc_mcu7t3v3__inv_2_1212/Y VSS gf180mcu_as_sc_mcu7t3v3__nor2_2_9/VNW
+ VSUBS gf180mcu_as_sc_mcu7t3v3__inv_2
Xgf180mcu_as_sc_mcu7t3v3__inv_2_1256 gf180mcu_as_sc_mcu7t3v3__nor2_2_9/VDD gf180mcu_as_sc_mcu7t3v3__nor2_2_9/VSS
+ gf180mcu_as_sc_mcu7t3v3__inv_2_1256/Y VSS gf180mcu_as_sc_mcu7t3v3__nor2_2_9/VNW
+ VSUBS gf180mcu_as_sc_mcu7t3v3__inv_2
Xgf180mcu_as_sc_mcu7t3v3__inv_2_1223 VSS VSS gf180mcu_as_sc_mcu7t3v3__inv_2_1276/A
+ gf180mcu_as_sc_mcu7t3v3__inv_2_1224/Y gf180mcu_as_sc_mcu7t3v3__inv_2_1276/VNW VSUBS
+ gf180mcu_as_sc_mcu7t3v3__inv_2
Xgf180mcu_as_sc_mcu7t3v3__inv_2_1278 VSS VSS VSS gf180mcu_as_sc_mcu7t3v3__inv_2_1278/A
+ gf180mcu_as_sc_mcu7t3v3__inv_2_1278/VNW VSUBS gf180mcu_as_sc_mcu7t3v3__inv_2
Xgf180mcu_as_sc_mcu7t3v3__inv_2_1289 VSS VSS VSS gf180mcu_as_sc_mcu7t3v3__inv_2_1289/A
+ gf180mcu_as_sc_mcu7t3v3__inv_2_1289/VNW VSUBS gf180mcu_as_sc_mcu7t3v3__inv_2
Xgf180mcu_as_sc_mcu7t3v3__inv_2_718 VSS VSS VSS gf180mcu_as_sc_mcu7t3v3__inv_2_719/Y
+ gf180mcu_as_sc_mcu7t3v3__inv_2_720/VNW VSUBS gf180mcu_as_sc_mcu7t3v3__inv_2
Xgf180mcu_as_sc_mcu7t3v3__inv_2_707 VSS VSS gf180mcu_as_sc_mcu7t3v3__inv_2_707/Y gf180mcu_as_sc_mcu7t3v3__inv_2_730/Y
+ gf180mcu_as_sc_mcu7t3v3__inv_2_730/VNW VSUBS gf180mcu_as_sc_mcu7t3v3__inv_2
Xgf180mcu_as_sc_mcu7t3v3__inv_2_729 VSS VSS gf180mcu_as_sc_mcu7t3v3__inv_2_729/Y gf180mcu_as_sc_mcu7t3v3__inv_2_731/Y
+ gf180mcu_as_sc_mcu7t3v3__inv_2_731/VNW VSUBS gf180mcu_as_sc_mcu7t3v3__inv_2
Xgf180mcu_as_sc_mcu7t3v3__inv_2_1031 VSS VSS gf180mcu_as_sc_mcu7t3v3__inv_2_1031/Y
+ gf180mcu_as_sc_mcu7t3v3__inv_2_1032/Y gf180mcu_as_sc_mcu7t3v3__inv_2_1032/VNW VSUBS
+ gf180mcu_as_sc_mcu7t3v3__inv_2
Xgf180mcu_as_sc_mcu7t3v3__inv_2_1042 VSS VSS VSS gf180mcu_as_sc_mcu7t3v3__inv_2_1043/Y
+ gf180mcu_as_sc_mcu7t3v3__inv_2_1044/VNW VSUBS gf180mcu_as_sc_mcu7t3v3__inv_2
Xgf180mcu_as_sc_mcu7t3v3__inv_2_1053 VSS VSS gf180mcu_as_sc_mcu7t3v3__inv_2_1053/Y
+ gf180mcu_as_sc_mcu7t3v3__inv_2_1053/A gf180mcu_as_sc_mcu7t3v3__inv_2_1053/VNW VSUBS
+ gf180mcu_as_sc_mcu7t3v3__inv_2
Xgf180mcu_as_sc_mcu7t3v3__inv_2_83 VSS VSS gf180mcu_as_sc_mcu7t3v3__inv_2_83/Y gf180mcu_as_sc_mcu7t3v3__inv_2_92/Y
+ gf180mcu_as_sc_mcu7t3v3__inv_2_92/VNW VSUBS gf180mcu_as_sc_mcu7t3v3__inv_2
Xgf180mcu_as_sc_mcu7t3v3__inv_2_94 VSS VSS gf180mcu_as_sc_mcu7t3v3__inv_2_94/Y gf180mcu_as_sc_mcu7t3v3__inv_2_94/A
+ gf180mcu_as_sc_mcu7t3v3__inv_2_94/VNW VSUBS gf180mcu_as_sc_mcu7t3v3__inv_2
Xgf180mcu_as_sc_mcu7t3v3__inv_2_50 VSS VSS gf180mcu_as_sc_mcu7t3v3__inv_2_50/Y gf180mcu_as_sc_mcu7t3v3__inv_2_66/Y
+ gf180mcu_as_sc_mcu7t3v3__inv_2_66/VNW VSUBS gf180mcu_as_sc_mcu7t3v3__inv_2
Xgf180mcu_as_sc_mcu7t3v3__inv_2_72 VSS VSS gf180mcu_as_sc_mcu7t3v3__inv_2_72/Y gf180mcu_as_sc_mcu7t3v3__inv_2_73/Y
+ gf180mcu_as_sc_mcu7t3v3__inv_2_73/VNW VSUBS gf180mcu_as_sc_mcu7t3v3__inv_2
Xgf180mcu_as_sc_mcu7t3v3__inv_2_61 VSS VSS gf180mcu_as_sc_mcu7t3v3__inv_2_61/Y gf180mcu_as_sc_mcu7t3v3__inv_2_61/A
+ gf180mcu_as_sc_mcu7t3v3__inv_2_61/VNW VSUBS gf180mcu_as_sc_mcu7t3v3__inv_2
Xgf180mcu_as_sc_mcu7t3v3__inv_2_1020 VSS VSS gf180mcu_as_sc_mcu7t3v3__inv_2_1020/Y
+ gf180mcu_as_sc_mcu7t3v3__inv_2_1020/A gf180mcu_as_sc_mcu7t3v3__inv_2_1020/VNW VSUBS
+ gf180mcu_as_sc_mcu7t3v3__inv_2
Xgf180mcu_as_sc_mcu7t3v3__inv_2_1075 VSS VSS gf180mcu_as_sc_mcu7t3v3__inv_2_1075/Y
+ gf180mcu_as_sc_mcu7t3v3__inv_2_1075/A gf180mcu_as_sc_mcu7t3v3__inv_2_1075/VNW VSUBS
+ gf180mcu_as_sc_mcu7t3v3__inv_2
Xgf180mcu_as_sc_mcu7t3v3__inv_2_1086 VSS VSS gf180mcu_as_sc_mcu7t3v3__inv_2_1086/Y
+ gf180mcu_as_sc_mcu7t3v3__inv_2_1087/Y gf180mcu_as_sc_mcu7t3v3__inv_2_1087/VNW VSUBS
+ gf180mcu_as_sc_mcu7t3v3__inv_2
Xgf180mcu_as_sc_mcu7t3v3__inv_2_1097 VSS VSS VSS gf180mcu_as_sc_mcu7t3v3__inv_2_1098/Y
+ gf180mcu_as_sc_mcu7t3v3__inv_2_1099/VNW VSUBS gf180mcu_as_sc_mcu7t3v3__inv_2
Xgf180mcu_as_sc_mcu7t3v3__inv_2_1064 VSS VSS gf180mcu_as_sc_mcu7t3v3__inv_2_1064/Y
+ gf180mcu_as_sc_mcu7t3v3__inv_2_1064/A gf180mcu_as_sc_mcu7t3v3__inv_2_1064/VNW VSUBS
+ gf180mcu_as_sc_mcu7t3v3__inv_2
Xgf180mcu_as_sc_mcu7t3v3__nand4_2_9 VSS VSS VSS VSS VSS VSS gf180mcu_as_sc_mcu7t3v3__nand4_2_9/Y
+ gf180mcu_as_sc_mcu7t3v3__nand4_2_9/VNW VSUBS gf180mcu_as_sc_mcu7t3v3__nand4_2
Xgf180mcu_as_sc_mcu7t3v3__inv_2_548 VSS VSS VSS gf180mcu_as_sc_mcu7t3v3__inv_2_548/A
+ gf180mcu_as_sc_mcu7t3v3__inv_2_548/VNW VSUBS gf180mcu_as_sc_mcu7t3v3__inv_2
Xgf180mcu_as_sc_mcu7t3v3__inv_2_526 gf180mcu_as_sc_mcu7t3v3__nor2_2_4/VDD gf180mcu_as_sc_mcu7t3v3__nor2_2_4/VSS
+ VSS VSS gf180mcu_as_sc_mcu7t3v3__nor2_2_4/VNW VSUBS gf180mcu_as_sc_mcu7t3v3__inv_2
Xgf180mcu_as_sc_mcu7t3v3__inv_2_559 VSS VSS VSS gf180mcu_as_sc_mcu7t3v3__inv_2_559/A
+ gf180mcu_as_sc_mcu7t3v3__inv_2_559/VNW VSUBS gf180mcu_as_sc_mcu7t3v3__inv_2
Xgf180mcu_as_sc_mcu7t3v3__inv_2_504 VSS VSS gf180mcu_as_sc_mcu7t3v3__inv_2_537/A gf180mcu_as_sc_mcu7t3v3__inv_2_505/Y
+ gf180mcu_as_sc_mcu7t3v3__inv_2_537/VNW VSUBS gf180mcu_as_sc_mcu7t3v3__inv_2
Xgf180mcu_as_sc_mcu7t3v3__inv_2_537 VSS VSS VSS gf180mcu_as_sc_mcu7t3v3__inv_2_537/A
+ gf180mcu_as_sc_mcu7t3v3__inv_2_537/VNW VSUBS gf180mcu_as_sc_mcu7t3v3__inv_2
Xgf180mcu_as_sc_mcu7t3v3__inv_2_515 VSS VSS gf180mcu_as_sc_mcu7t3v3__inv_2_562/A gf180mcu_as_sc_mcu7t3v3__inv_2_518/Y
+ gf180mcu_as_sc_mcu7t3v3__inv_2_562/VNW VSUBS gf180mcu_as_sc_mcu7t3v3__inv_2
Xgf180mcu_as_sc_mcu7t3v3__nand4_2_370 VSS VSS VSS VSS VSS VSS gf180mcu_as_sc_mcu7t3v3__inv_2_1198/A
+ gf180mcu_as_sc_mcu7t3v3__inv_2_1280/VNW VSUBS gf180mcu_as_sc_mcu7t3v3__nand4_2
Xgf180mcu_as_sc_mcu7t3v3__nand4_2_381 VSS VSS VSS VSS VSS VSS gf180mcu_as_sc_mcu7t3v3__inv_2_1413/A
+ gf180mcu_as_sc_mcu7t3v3__inv_2_1413/VNW VSUBS gf180mcu_as_sc_mcu7t3v3__nand4_2
Xgf180mcu_as_sc_mcu7t3v3__nand4_2_392 VSS VSS VSS VSS VSS VSS gf180mcu_as_sc_mcu7t3v3__inv_2_1446/A
+ gf180mcu_as_sc_mcu7t3v3__inv_2_1446/VNW VSUBS gf180mcu_as_sc_mcu7t3v3__nand4_2
Xgf180mcu_as_sc_mcu7t3v3__inv_2_301 VSS VSS gf180mcu_as_sc_mcu7t3v3__inv_2_301/Y gf180mcu_as_sc_mcu7t3v3__inv_2_301/A
+ gf180mcu_as_sc_mcu7t3v3__inv_2_301/VNW VSUBS gf180mcu_as_sc_mcu7t3v3__inv_2
Xgf180mcu_as_sc_mcu7t3v3__inv_2_334 VSS VSS gf180mcu_as_sc_mcu7t3v3__inv_2_334/Y gf180mcu_as_sc_mcu7t3v3__inv_2_335/Y
+ gf180mcu_as_sc_mcu7t3v3__inv_2_335/VNW VSUBS gf180mcu_as_sc_mcu7t3v3__inv_2
Xgf180mcu_as_sc_mcu7t3v3__inv_2_323 VSS VSS gf180mcu_as_sc_mcu7t3v3__inv_2_323/Y gf180mcu_as_sc_mcu7t3v3__inv_2_323/A
+ gf180mcu_as_sc_mcu7t3v3__inv_2_323/VNW VSUBS gf180mcu_as_sc_mcu7t3v3__inv_2
Xgf180mcu_as_sc_mcu7t3v3__inv_2_312 VSS VSS VSS gf180mcu_as_sc_mcu7t3v3__inv_2_313/Y
+ gf180mcu_as_sc_mcu7t3v3__inv_2_314/VNW VSUBS gf180mcu_as_sc_mcu7t3v3__inv_2
Xgf180mcu_as_sc_mcu7t3v3__inv_2_378 gf180mcu_as_sc_mcu7t3v3__nor2_2_6/VDD gf180mcu_as_sc_mcu7t3v3__nand3_2_4/VSS
+ VSS VSS gf180mcu_as_sc_mcu7t3v3__nor2_2_6/VNW VSUBS gf180mcu_as_sc_mcu7t3v3__inv_2
Xgf180mcu_as_sc_mcu7t3v3__inv_2_389 gf180mcu_as_sc_mcu7t3v3__nand3_2_9/VDD gf180mcu_as_sc_mcu7t3v3__nor2_2_7/VSS
+ VSS VSS gf180mcu_as_sc_mcu7t3v3__nand3_2_9/VNW VSUBS gf180mcu_as_sc_mcu7t3v3__inv_2
Xgf180mcu_as_sc_mcu7t3v3__inv_2_367 VSS VSS gf180mcu_as_sc_mcu7t3v3__inv_2_367/Y gf180mcu_as_sc_mcu7t3v3__inv_2_368/Y
+ gf180mcu_as_sc_mcu7t3v3__inv_2_368/VNW VSUBS gf180mcu_as_sc_mcu7t3v3__inv_2
Xgf180mcu_as_sc_mcu7t3v3__inv_2_356 VSS VSS gf180mcu_as_sc_mcu7t3v3__inv_2_356/Y gf180mcu_as_sc_mcu7t3v3__inv_2_356/A
+ gf180mcu_as_sc_mcu7t3v3__inv_2_356/VNW VSUBS gf180mcu_as_sc_mcu7t3v3__inv_2
Xgf180mcu_as_sc_mcu7t3v3__inv_2_345 VSS VSS VSS gf180mcu_as_sc_mcu7t3v3__inv_2_346/Y
+ gf180mcu_as_sc_mcu7t3v3__inv_2_347/VNW VSUBS gf180mcu_as_sc_mcu7t3v3__inv_2
Xu_t027_006 u_t027_006/c0_w0_bl u_t027_006/c0_w0_br u_t027_006/c0_w1_bl u_t027_006/c0_w1_br
+ u_t027_006/c0_r0_rbl u_t027_006/c0_r1_rbl u_t027_006/c1_w0_bl u_t027_006/c1_w0_br
+ u_t027_006/c1_w1_bl u_t027_006/c1_w1_br u_t027_006/c1_r0_rbl u_t027_006/c1_r1_rbl
+ u_t027_006/c2_w0_bl u_t027_006/c2_w0_br u_t027_006/c2_w1_bl u_t027_006/c2_w1_br
+ u_t027_006/c2_r0_rbl u_t027_006/c2_r1_rbl u_t027_006/c3_w0_bl u_t027_006/c3_w0_br
+ u_t027_006/c3_w1_bl u_t027_006/c3_w1_br u_t027_006/c3_r0_rbl u_t027_006/c3_r1_rbl
+ u_t027_006/r0_w0_wl u_t027_006/r0_w1_wl u_t027_006/r0_r0_rwl u_t027_006/r0_r1_rwl
+ u_t027_006/r1_w0_wl u_t027_006/r1_w1_wl u_t027_006/r1_r0_rwl u_t027_006/r1_r1_rwl
+ u_t027_006/r2_w0_wl u_t027_006/r2_w1_wl u_t027_006/r2_r0_rwl u_t027_006/r2_r1_rwl
+ u_t027_006/r3_w0_wl u_t027_006/r3_w1_wl u_t027_006/r3_r0_rwl u_t027_006/r3_r1_rwl
+ VSS VSS u_t027_006/m2_717_1265# u_t027_006/m2_603_2031# u_t027_006/m2_1290_336#
+ u_t027_006/m2_2000_2037# u_t027_006/m2_791_2909# u_t027_006/m2_7_2126# u_t027_006/m2_2154_2081#
+ u_t027_006/m2_1795_2037# u_t027_006/m2_871_303# u_t027_006/m2_431_438# u_t027_006/m2_1290_2898#
+ u_t027_006/m2_1714_1210# u_t027_006/m2_431_1982# u_t027_006/m2_512_1265# u_t027_006/m2_2573_2126#
+ u_t027_006/m2_603_1259# u_t027_006/m2_2074_2909# u_t027_006/m2_7_336# u_t027_006/m2_717_2037#
+ u_t027_006/m2_1886_2031# u_t027_006/m2_2573_336# u_t027_006/m2_7_2898# u_t027_006/m2_2000_1265#
+ u_t027_006/m2_512_2037# u_t027_006/m2_1795_1265# u_t027_006/m2_1714_1982# u_t027_006/m2_1886_1259#
+ u_t027_006/m2_1290_2126# u_t027_006/m2_1714_438# u_t027_006/m2_431_1210# u_t027_006/m2_2573_2898#
+ u_t027_006/m2_2154_303# u_t027_006/m2_871_2081# VSUBS detronyx_12t_2w2r_rc4_4x4_routed_5layer_direct
Xgf180mcu_as_sc_mcu7t3v3__inv_2_890 VSS VSS gf180mcu_as_sc_mcu7t3v3__inv_2_949/A gf180mcu_as_sc_mcu7t3v3__inv_2_891/Y
+ gf180mcu_as_sc_mcu7t3v3__inv_2_949/VNW VSUBS gf180mcu_as_sc_mcu7t3v3__inv_2
Xu_t018_006 u_t018_006/c0_w0_bl u_t018_006/c0_w0_br u_t018_006/c0_w1_bl u_t018_006/c0_w1_br
+ u_t018_006/c0_r0_rbl u_t018_006/c0_r1_rbl u_t018_006/c1_w0_bl u_t018_006/c1_w0_br
+ u_t018_006/c1_w1_bl u_t018_006/c1_w1_br u_t018_006/c1_r0_rbl u_t018_006/c1_r1_rbl
+ u_t018_006/c2_w0_bl u_t018_006/c2_w0_br u_t018_006/c2_w1_bl u_t018_006/c2_w1_br
+ u_t018_006/c2_r0_rbl u_t018_006/c2_r1_rbl u_t018_006/c3_w0_bl u_t018_006/c3_w0_br
+ u_t018_006/c3_w1_bl u_t018_006/c3_w1_br u_t018_006/c3_r0_rbl u_t018_006/c3_r1_rbl
+ u_t018_006/r0_w0_wl u_t018_006/r0_w1_wl u_t018_006/r0_r0_rwl u_t018_006/r0_r1_rwl
+ u_t018_006/r1_w0_wl u_t018_006/r1_w1_wl u_t018_006/r1_r0_rwl u_t018_006/r1_r1_rwl
+ u_t018_006/r2_w0_wl u_t018_006/r2_w1_wl u_t018_006/r2_r0_rwl u_t018_006/r2_r1_rwl
+ u_t018_006/r3_w0_wl u_t018_006/r3_w1_wl u_t018_006/r3_r0_rwl u_t018_006/r3_r1_rwl
+ VSS VSS u_t018_006/m2_717_1265# u_t018_006/m2_603_2031# u_t018_006/m2_1290_336#
+ u_t018_006/m2_2000_2037# u_t018_006/m2_791_2909# u_t018_006/m2_7_2126# u_t018_006/m2_2154_2081#
+ u_t018_006/m2_1795_2037# u_t018_006/m2_871_303# u_t018_006/m2_431_438# u_t018_006/m2_1290_2898#
+ u_t018_006/m2_1714_1210# u_t018_006/m2_431_1982# u_t018_006/m2_512_1265# u_t018_006/m2_2573_2126#
+ u_t018_006/m2_603_1259# u_t018_006/m2_2074_2909# u_t018_006/m2_7_336# u_t018_006/m2_717_2037#
+ u_t018_006/m2_1886_2031# u_t018_006/m2_2573_336# u_t018_006/m2_7_2898# u_t018_006/m2_2000_1265#
+ u_t018_006/m2_512_2037# u_t018_006/m2_1795_1265# u_t018_006/m2_1714_1982# u_t018_006/m2_1886_1259#
+ u_t018_006/m2_1290_2126# u_t018_006/m2_1714_438# u_t018_006/m2_431_1210# u_t018_006/m2_2573_2898#
+ u_t018_006/m2_2154_303# u_t018_006/m2_871_2081# VSUBS detronyx_12t_2w2r_rc4_4x4_routed_5layer_direct
Xu_t009_006 u_t009_006/c0_w0_bl u_t009_006/c0_w0_br u_t009_006/c0_w1_bl u_t009_006/c0_w1_br
+ u_t009_006/c0_r0_rbl u_t009_006/c0_r1_rbl u_t009_006/c1_w0_bl u_t009_006/c1_w0_br
+ u_t009_006/c1_w1_bl u_t009_006/c1_w1_br u_t009_006/c1_r0_rbl u_t009_006/c1_r1_rbl
+ u_t009_006/c2_w0_bl u_t009_006/c2_w0_br u_t009_006/c2_w1_bl u_t009_006/c2_w1_br
+ u_t009_006/c2_r0_rbl u_t009_006/c2_r1_rbl u_t009_006/c3_w0_bl u_t009_006/c3_w0_br
+ u_t009_006/c3_w1_bl u_t009_006/c3_w1_br u_t009_006/c3_r0_rbl u_t009_006/c3_r1_rbl
+ u_t009_006/r0_w0_wl u_t009_006/r0_w1_wl u_t009_006/r0_r0_rwl u_t009_006/r0_r1_rwl
+ u_t009_006/r1_w0_wl u_t009_006/r1_w1_wl u_t009_006/r1_r0_rwl u_t009_006/r1_r1_rwl
+ u_t009_006/r2_w0_wl u_t009_006/r2_w1_wl u_t009_006/r2_r0_rwl u_t009_006/r2_r1_rwl
+ u_t009_006/r3_w0_wl u_t009_006/r3_w1_wl u_t009_006/r3_r0_rwl u_t009_006/r3_r1_rwl
+ VSS VSS u_t009_006/m2_717_1265# u_t009_006/m2_603_2031# u_t009_006/m2_1290_336#
+ u_t009_006/m2_2000_2037# u_t009_006/m2_791_2909# u_t009_006/m2_7_2126# u_t009_006/m2_2154_2081#
+ u_t009_006/m2_1795_2037# u_t009_006/m2_871_303# u_t009_006/m2_431_438# u_t009_006/m2_1290_2898#
+ u_t009_006/m2_1714_1210# u_t009_006/m2_431_1982# u_t009_006/m2_512_1265# u_t009_006/m2_2573_2126#
+ u_t009_006/m2_603_1259# u_t009_006/m2_2074_2909# u_t009_006/m2_7_336# u_t009_006/m2_717_2037#
+ u_t009_006/m2_1886_2031# u_t009_006/m2_2573_336# u_t009_006/m2_7_2898# u_t009_006/m2_2000_1265#
+ u_t009_006/m2_512_2037# u_t009_006/m2_1795_1265# u_t009_006/m2_1714_1982# u_t009_006/m2_1886_1259#
+ u_t009_006/m2_1290_2126# u_t009_006/m2_1714_438# u_t009_006/m2_431_1210# u_t009_006/m2_2573_2898#
+ u_t009_006/m2_2154_303# u_t009_006/m2_871_2081# VSUBS detronyx_12t_2w2r_rc4_4x4_routed_5layer_direct
Xu_t024_009 u_t024_009/c0_w0_bl u_t024_009/c0_w0_br u_t024_009/c0_w1_bl u_t024_009/c0_w1_br
+ u_t024_009/c0_r0_rbl u_t024_009/c0_r1_rbl u_t024_009/c1_w0_bl u_t024_009/c1_w0_br
+ u_t024_009/c1_w1_bl u_t024_009/c1_w1_br u_t024_009/c1_r0_rbl u_t024_009/c1_r1_rbl
+ u_t024_009/c2_w0_bl u_t024_009/c2_w0_br u_t024_009/c2_w1_bl u_t024_009/c2_w1_br
+ u_t024_009/c2_r0_rbl u_t024_009/c2_r1_rbl u_t024_009/c3_w0_bl u_t024_009/c3_w0_br
+ u_t024_009/c3_w1_bl u_t024_009/c3_w1_br u_t024_009/c3_r0_rbl u_t024_009/c3_r1_rbl
+ u_t024_009/r0_w0_wl u_t024_009/r0_w1_wl u_t024_009/r0_r0_rwl u_t024_009/r0_r1_rwl
+ u_t024_009/r1_w0_wl u_t024_009/r1_w1_wl u_t024_009/r1_r0_rwl u_t024_009/r1_r1_rwl
+ u_t024_009/r2_w0_wl u_t024_009/r2_w1_wl u_t024_009/r2_r0_rwl u_t024_009/r2_r1_rwl
+ u_t024_009/r3_w0_wl u_t024_009/r3_w1_wl u_t024_009/r3_r0_rwl u_t024_009/r3_r1_rwl
+ VSS VSS u_t024_009/m2_717_1265# u_t024_009/m2_603_2031# u_t024_009/m2_1290_336#
+ u_t024_009/m2_2000_2037# u_t024_009/m2_791_2909# u_t024_009/m2_7_2126# u_t024_009/m2_2154_2081#
+ u_t024_009/m2_1795_2037# u_t024_009/m2_871_303# u_t024_009/m2_431_438# u_t024_009/m2_1290_2898#
+ u_t024_009/m2_1714_1210# u_t024_009/m2_431_1982# u_t024_009/m2_512_1265# u_t024_009/m2_2573_2126#
+ u_t024_009/m2_603_1259# u_t024_009/m2_2074_2909# u_t024_009/m2_7_336# u_t024_009/m2_717_2037#
+ u_t024_009/m2_1886_2031# u_t024_009/m2_2573_336# u_t024_009/m2_7_2898# u_t024_009/m2_2000_1265#
+ u_t024_009/m2_512_2037# u_t024_009/m2_1795_1265# u_t024_009/m2_1714_1982# u_t024_009/m2_1886_1259#
+ u_t024_009/m2_1290_2126# u_t024_009/m2_1714_438# u_t024_009/m2_431_1210# u_t024_009/m2_2573_2898#
+ u_t024_009/m2_2154_303# u_t024_009/m2_871_2081# VSUBS detronyx_12t_2w2r_rc4_4x4_routed_5layer_direct
Xgf180mcu_as_sc_mcu7t3v3__inv_2_153 VSS VSS VSS gf180mcu_as_sc_mcu7t3v3__inv_2_154/Y
+ gf180mcu_as_sc_mcu7t3v3__inv_2_155/VNW VSUBS gf180mcu_as_sc_mcu7t3v3__inv_2
Xgf180mcu_as_sc_mcu7t3v3__inv_2_142 VSS VSS gf180mcu_as_sc_mcu7t3v3__inv_2_142/Y gf180mcu_as_sc_mcu7t3v3__inv_2_143/Y
+ gf180mcu_as_sc_mcu7t3v3__inv_2_143/VNW VSUBS gf180mcu_as_sc_mcu7t3v3__inv_2
Xgf180mcu_as_sc_mcu7t3v3__inv_2_131 VSS VSS gf180mcu_as_sc_mcu7t3v3__inv_2_131/Y gf180mcu_as_sc_mcu7t3v3__inv_2_131/A
+ gf180mcu_as_sc_mcu7t3v3__inv_2_131/VNW VSUBS gf180mcu_as_sc_mcu7t3v3__inv_2
Xgf180mcu_as_sc_mcu7t3v3__inv_2_120 VSS VSS VSS gf180mcu_as_sc_mcu7t3v3__inv_2_121/Y
+ gf180mcu_as_sc_mcu7t3v3__inv_2_122/VNW VSUBS gf180mcu_as_sc_mcu7t3v3__inv_2
Xgf180mcu_as_sc_mcu7t3v3__inv_2_175 VSS VSS gf180mcu_as_sc_mcu7t3v3__inv_2_182/A gf180mcu_as_sc_mcu7t3v3__inv_2_175/A
+ gf180mcu_as_sc_mcu7t3v3__inv_2_182/VNW VSUBS gf180mcu_as_sc_mcu7t3v3__inv_2
Xgf180mcu_as_sc_mcu7t3v3__inv_2_186 VSS VSS gf180mcu_as_sc_mcu7t3v3__inv_2_186/Y gf180mcu_as_sc_mcu7t3v3__inv_2_187/Y
+ gf180mcu_as_sc_mcu7t3v3__inv_2_187/VNW VSUBS gf180mcu_as_sc_mcu7t3v3__inv_2
Xgf180mcu_as_sc_mcu7t3v3__inv_2_164 VSS VSS gf180mcu_as_sc_mcu7t3v3__inv_2_164/Y gf180mcu_as_sc_mcu7t3v3__inv_2_165/Y
+ gf180mcu_as_sc_mcu7t3v3__inv_2_165/VNW VSUBS gf180mcu_as_sc_mcu7t3v3__inv_2
Xgf180mcu_as_sc_mcu7t3v3__inv_2_1619 VSS VSS VSS gf180mcu_as_sc_mcu7t3v3__inv_2_1623/Y
+ gf180mcu_as_sc_mcu7t3v3__inv_2_1627/VNW VSUBS gf180mcu_as_sc_mcu7t3v3__inv_2
Xgf180mcu_as_sc_mcu7t3v3__inv_2_1608 VSS VSS VSS gf180mcu_as_sc_mcu7t3v3__inv_2_1609/Y
+ gf180mcu_as_sc_mcu7t3v3__inv_2_1610/VNW VSUBS gf180mcu_as_sc_mcu7t3v3__inv_2
Xgf180mcu_as_sc_mcu7t3v3__inv_2_197 VSS VSS gf180mcu_as_sc_mcu7t3v3__inv_2_197/Y gf180mcu_as_sc_mcu7t3v3__inv_2_197/A
+ gf180mcu_as_sc_mcu7t3v3__inv_2_197/VNW VSUBS gf180mcu_as_sc_mcu7t3v3__inv_2
Xu_t015_009 u_t015_009/c0_w0_bl u_t015_009/c0_w0_br u_t015_009/c0_w1_bl u_t015_009/c0_w1_br
+ u_t015_009/c0_r0_rbl u_t015_009/c0_r1_rbl u_t015_009/c1_w0_bl u_t015_009/c1_w0_br
+ u_t015_009/c1_w1_bl u_t015_009/c1_w1_br u_t015_009/c1_r0_rbl u_t015_009/c1_r1_rbl
+ u_t015_009/c2_w0_bl u_t015_009/c2_w0_br u_t015_009/c2_w1_bl u_t015_009/c2_w1_br
+ u_t015_009/c2_r0_rbl u_t015_009/c2_r1_rbl u_t015_009/c3_w0_bl u_t015_009/c3_w0_br
+ u_t015_009/c3_w1_bl u_t015_009/c3_w1_br u_t015_009/c3_r0_rbl u_t015_009/c3_r1_rbl
+ u_t015_009/r0_w0_wl u_t015_009/r0_w1_wl u_t015_009/r0_r0_rwl u_t015_009/r0_r1_rwl
+ u_t015_009/r1_w0_wl u_t015_009/r1_w1_wl u_t015_009/r1_r0_rwl u_t015_009/r1_r1_rwl
+ u_t015_009/r2_w0_wl u_t015_009/r2_w1_wl u_t015_009/r2_r0_rwl u_t015_009/r2_r1_rwl
+ u_t015_009/r3_w0_wl u_t015_009/r3_w1_wl u_t015_009/r3_r0_rwl u_t015_009/r3_r1_rwl
+ VSS VSS u_t015_009/m2_717_1265# u_t015_009/m2_603_2031# u_t015_009/m2_1290_336#
+ u_t015_009/m2_2000_2037# u_t015_009/m2_791_2909# u_t015_009/m2_7_2126# u_t015_009/m2_2154_2081#
+ u_t015_009/m2_1795_2037# u_t015_009/m2_871_303# u_t015_009/m2_431_438# u_t015_009/m2_1290_2898#
+ u_t015_009/m2_1714_1210# u_t015_009/m2_431_1982# u_t015_009/m2_512_1265# u_t015_009/m2_2573_2126#
+ u_t015_009/m2_603_1259# u_t015_009/m2_2074_2909# u_t015_009/m2_7_336# u_t015_009/m2_717_2037#
+ u_t015_009/m2_1886_2031# u_t015_009/m2_2573_336# u_t015_009/m2_7_2898# u_t015_009/m2_2000_1265#
+ u_t015_009/m2_512_2037# u_t015_009/m2_1795_1265# u_t015_009/m2_1714_1982# u_t015_009/m2_1886_1259#
+ u_t015_009/m2_1290_2126# u_t015_009/m2_1714_438# u_t015_009/m2_431_1210# u_t015_009/m2_2573_2898#
+ u_t015_009/m2_2154_303# u_t015_009/m2_871_2081# VSUBS detronyx_12t_2w2r_rc4_4x4_routed_5layer_direct
Xu_t006_009 u_t006_009/c0_w0_bl u_t006_009/c0_w0_br u_t006_009/c0_w1_bl u_t006_009/c0_w1_br
+ u_t006_009/c0_r0_rbl u_t006_009/c0_r1_rbl u_t006_009/c1_w0_bl u_t006_009/c1_w0_br
+ u_t006_009/c1_w1_bl u_t006_009/c1_w1_br u_t006_009/c1_r0_rbl u_t006_009/c1_r1_rbl
+ u_t006_009/c2_w0_bl u_t006_009/c2_w0_br u_t006_009/c2_w1_bl u_t006_009/c2_w1_br
+ u_t006_009/c2_r0_rbl u_t006_009/c2_r1_rbl u_t006_009/c3_w0_bl u_t006_009/c3_w0_br
+ u_t006_009/c3_w1_bl u_t006_009/c3_w1_br u_t006_009/c3_r0_rbl u_t006_009/c3_r1_rbl
+ u_t006_009/r0_w0_wl u_t006_009/r0_w1_wl u_t006_009/r0_r0_rwl u_t006_009/r0_r1_rwl
+ u_t006_009/r1_w0_wl u_t006_009/r1_w1_wl u_t006_009/r1_r0_rwl u_t006_009/r1_r1_rwl
+ u_t006_009/r2_w0_wl u_t006_009/r2_w1_wl u_t006_009/r2_r0_rwl u_t006_009/r2_r1_rwl
+ u_t006_009/r3_w0_wl u_t006_009/r3_w1_wl u_t006_009/r3_r0_rwl u_t006_009/r3_r1_rwl
+ VSS VSS u_t006_009/m2_717_1265# u_t006_009/m2_603_2031# u_t006_009/m2_1290_336#
+ u_t006_009/m2_2000_2037# u_t006_009/m2_791_2909# u_t006_009/m2_7_2126# u_t006_009/m2_2154_2081#
+ u_t006_009/m2_1795_2037# u_t006_009/m2_871_303# u_t006_009/m2_431_438# u_t006_009/m2_1290_2898#
+ u_t006_009/m2_1714_1210# u_t006_009/m2_431_1982# u_t006_009/m2_512_1265# u_t006_009/m2_2573_2126#
+ u_t006_009/m2_603_1259# u_t006_009/m2_2074_2909# u_t006_009/m2_7_336# u_t006_009/m2_717_2037#
+ u_t006_009/m2_1886_2031# u_t006_009/m2_2573_336# u_t006_009/m2_7_2898# u_t006_009/m2_2000_1265#
+ u_t006_009/m2_512_2037# u_t006_009/m2_1795_1265# u_t006_009/m2_1714_1982# u_t006_009/m2_1886_1259#
+ u_t006_009/m2_1290_2126# u_t006_009/m2_1714_438# u_t006_009/m2_431_1210# u_t006_009/m2_2573_2898#
+ u_t006_009/m2_2154_303# u_t006_009/m2_871_2081# VSUBS detronyx_12t_2w2r_rc4_4x4_routed_5layer_direct
Xgf180mcu_as_sc_mcu7t3v3__nand2_2_43 gf180mcu_as_sc_mcu7t3v3__nand3_2_65/VDD gf180mcu_as_sc_mcu7t3v3__nand3_2_62/VSS
+ VSS VSS VSS gf180mcu_as_sc_mcu7t3v3__nand3_2_65/VNW VSUBS gf180mcu_as_sc_mcu7t3v3__nand2_2
Xgf180mcu_as_sc_mcu7t3v3__nand2_2_10 gf180mcu_as_sc_mcu7t3v3__nor2_2_4/VDD gf180mcu_as_sc_mcu7t3v3__nor2_2_4/VSS
+ VSS VSS VSS gf180mcu_as_sc_mcu7t3v3__nor2_2_4/VNW VSUBS gf180mcu_as_sc_mcu7t3v3__nand2_2
Xgf180mcu_as_sc_mcu7t3v3__nand2_2_21 gf180mcu_as_sc_mcu7t3v3__nor2_2_4/VDD gf180mcu_as_sc_mcu7t3v3__nand2_2_3/VSS
+ VSS VSS VSS gf180mcu_as_sc_mcu7t3v3__nor2_2_4/VNW VSUBS gf180mcu_as_sc_mcu7t3v3__nand2_2
Xgf180mcu_as_sc_mcu7t3v3__nand2_2_32 gf180mcu_as_sc_mcu7t3v3__nor2_2_4/VDD gf180mcu_as_sc_mcu7t3v3__nor2_2_4/VSS
+ VSS VSS VSS gf180mcu_as_sc_mcu7t3v3__nor2_2_4/VNW VSUBS gf180mcu_as_sc_mcu7t3v3__nand2_2
Xu_t020_012 u_t020_012/c0_w0_bl u_t020_012/c0_w0_br u_t020_012/c0_w1_bl u_t020_012/c0_w1_br
+ u_t020_012/c0_r0_rbl u_t020_012/c0_r1_rbl u_t020_012/c1_w0_bl u_t020_012/c1_w0_br
+ u_t020_012/c1_w1_bl u_t020_012/c1_w1_br u_t020_012/c1_r0_rbl u_t020_012/c1_r1_rbl
+ u_t020_012/c2_w0_bl u_t020_012/c2_w0_br u_t020_012/c2_w1_bl u_t020_012/c2_w1_br
+ u_t020_012/c2_r0_rbl u_t020_012/c2_r1_rbl u_t020_012/c3_w0_bl u_t020_012/c3_w0_br
+ u_t020_012/c3_w1_bl u_t020_012/c3_w1_br u_t020_012/c3_r0_rbl u_t020_012/c3_r1_rbl
+ u_t020_012/r0_w0_wl u_t020_012/r0_w1_wl u_t020_012/r0_r0_rwl u_t020_012/r0_r1_rwl
+ u_t020_012/r1_w0_wl u_t020_012/r1_w1_wl u_t020_012/r1_r0_rwl u_t020_012/r1_r1_rwl
+ u_t020_012/r2_w0_wl u_t020_012/r2_w1_wl u_t020_012/r2_r0_rwl u_t020_012/r2_r1_rwl
+ u_t020_012/r3_w0_wl u_t020_012/r3_w1_wl u_t020_012/r3_r0_rwl u_t020_012/r3_r1_rwl
+ VSS VSS u_t020_012/m2_717_1265# u_t020_012/m2_603_2031# u_t020_012/m2_1290_336#
+ u_t020_012/m2_2000_2037# u_t020_012/m2_791_2909# u_t020_012/m2_7_2126# u_t020_012/m2_2154_2081#
+ u_t020_012/m2_1795_2037# u_t020_012/m2_871_303# u_t020_012/m2_431_438# u_t020_012/m2_1290_2898#
+ u_t020_012/m2_1714_1210# u_t020_012/m2_431_1982# u_t020_012/m2_512_1265# u_t020_012/m2_2573_2126#
+ u_t020_012/m2_603_1259# u_t020_012/m2_2074_2909# u_t020_012/m2_7_336# u_t020_012/m2_717_2037#
+ u_t020_012/m2_1886_2031# u_t020_012/m2_2573_336# u_t020_012/m2_7_2898# u_t020_012/m2_2000_1265#
+ u_t020_012/m2_512_2037# u_t020_012/m2_1795_1265# u_t020_012/m2_1714_1982# u_t020_012/m2_1886_1259#
+ u_t020_012/m2_1290_2126# u_t020_012/m2_1714_438# u_t020_012/m2_431_1210# u_t020_012/m2_2573_2898#
+ u_t020_012/m2_2154_303# u_t020_012/m2_871_2081# VSUBS detronyx_12t_2w2r_rc4_4x4_routed_5layer_direct
Xu_t020_001 u_t020_001/c0_w0_bl u_t020_001/c0_w0_br u_t020_001/c0_w1_bl u_t020_001/c0_w1_br
+ u_t020_001/c0_r0_rbl u_t020_001/c0_r1_rbl u_t020_001/c1_w0_bl u_t020_001/c1_w0_br
+ u_t020_001/c1_w1_bl u_t020_001/c1_w1_br u_t020_001/c1_r0_rbl u_t020_001/c1_r1_rbl
+ u_t020_001/c2_w0_bl u_t020_001/c2_w0_br u_t020_001/c2_w1_bl u_t020_001/c2_w1_br
+ u_t020_001/c2_r0_rbl u_t020_001/c2_r1_rbl u_t020_001/c3_w0_bl u_t020_001/c3_w0_br
+ u_t020_001/c3_w1_bl u_t020_001/c3_w1_br u_t020_001/c3_r0_rbl u_t020_001/c3_r1_rbl
+ u_t020_001/r0_w0_wl u_t020_001/r0_w1_wl u_t020_001/r0_r0_rwl u_t020_001/r0_r1_rwl
+ u_t020_001/r1_w0_wl u_t020_001/r1_w1_wl u_t020_001/r1_r0_rwl u_t020_001/r1_r1_rwl
+ u_t020_001/r2_w0_wl u_t020_001/r2_w1_wl u_t020_001/r2_r0_rwl u_t020_001/r2_r1_rwl
+ u_t020_001/r3_w0_wl u_t020_001/r3_w1_wl u_t020_001/r3_r0_rwl u_t020_001/r3_r1_rwl
+ VSS VSS u_t020_001/m2_717_1265# u_t020_001/m2_603_2031# u_t020_001/m2_1290_336#
+ u_t020_001/m2_2000_2037# u_t020_001/m2_791_2909# u_t020_001/m2_7_2126# u_t020_001/m2_2154_2081#
+ u_t020_001/m2_1795_2037# u_t020_001/m2_871_303# u_t020_001/m2_431_438# u_t020_001/m2_1290_2898#
+ u_t020_001/m2_1714_1210# u_t020_001/m2_431_1982# u_t020_001/m2_512_1265# u_t020_001/m2_2573_2126#
+ u_t020_001/m2_603_1259# u_t020_001/m2_2074_2909# u_t020_001/m2_7_336# u_t020_001/m2_717_2037#
+ u_t020_001/m2_1886_2031# u_t020_001/m2_2573_336# u_t020_001/m2_7_2898# u_t020_001/m2_2000_1265#
+ u_t020_001/m2_512_2037# u_t020_001/m2_1795_1265# u_t020_001/m2_1714_1982# u_t020_001/m2_1886_1259#
+ u_t020_001/m2_1290_2126# u_t020_001/m2_1714_438# u_t020_001/m2_431_1210# u_t020_001/m2_2573_2898#
+ u_t020_001/m2_2154_303# u_t020_001/m2_871_2081# VSUBS detronyx_12t_2w2r_rc4_4x4_routed_5layer_direct
Xgf180mcu_as_sc_mcu7t3v3__inv_2_1405 VSS VSS gf180mcu_as_sc_mcu7t3v3__inv_2_1405/Y
+ gf180mcu_as_sc_mcu7t3v3__inv_2_1406/Y gf180mcu_as_sc_mcu7t3v3__inv_2_1406/VNW VSUBS
+ gf180mcu_as_sc_mcu7t3v3__inv_2
Xgf180mcu_as_sc_mcu7t3v3__inv_2_1416 VSS VSS gf180mcu_as_sc_mcu7t3v3__inv_2_1416/Y
+ gf180mcu_as_sc_mcu7t3v3__inv_2_1416/A gf180mcu_as_sc_mcu7t3v3__inv_2_1416/VNW VSUBS
+ gf180mcu_as_sc_mcu7t3v3__inv_2
Xgf180mcu_as_sc_mcu7t3v3__inv_2_1449 VSS VSS gf180mcu_as_sc_mcu7t3v3__inv_2_1449/Y
+ gf180mcu_as_sc_mcu7t3v3__inv_2_1449/A gf180mcu_as_sc_mcu7t3v3__inv_2_1449/VNW VSUBS
+ gf180mcu_as_sc_mcu7t3v3__inv_2
Xgf180mcu_as_sc_mcu7t3v3__inv_2_1438 VSS VSS VSS gf180mcu_as_sc_mcu7t3v3__inv_2_1439/Y
+ gf180mcu_as_sc_mcu7t3v3__inv_2_1440/VNW VSUBS gf180mcu_as_sc_mcu7t3v3__inv_2
Xgf180mcu_as_sc_mcu7t3v3__inv_2_1427 VSS VSS gf180mcu_as_sc_mcu7t3v3__inv_2_1427/Y
+ gf180mcu_as_sc_mcu7t3v3__inv_2_1428/Y gf180mcu_as_sc_mcu7t3v3__inv_2_1428/VNW VSUBS
+ gf180mcu_as_sc_mcu7t3v3__inv_2
Xu_t011_012 u_t011_012/c0_w0_bl u_t011_012/c0_w0_br u_t011_012/c0_w1_bl u_t011_012/c0_w1_br
+ u_t011_012/c0_r0_rbl u_t011_012/c0_r1_rbl u_t011_012/c1_w0_bl u_t011_012/c1_w0_br
+ u_t011_012/c1_w1_bl u_t011_012/c1_w1_br u_t011_012/c1_r0_rbl u_t011_012/c1_r1_rbl
+ u_t011_012/c2_w0_bl u_t011_012/c2_w0_br u_t011_012/c2_w1_bl u_t011_012/c2_w1_br
+ u_t011_012/c2_r0_rbl u_t011_012/c2_r1_rbl u_t011_012/c3_w0_bl u_t011_012/c3_w0_br
+ u_t011_012/c3_w1_bl u_t011_012/c3_w1_br u_t011_012/c3_r0_rbl u_t011_012/c3_r1_rbl
+ u_t011_012/r0_w0_wl u_t011_012/r0_w1_wl u_t011_012/r0_r0_rwl u_t011_012/r0_r1_rwl
+ u_t011_012/r1_w0_wl u_t011_012/r1_w1_wl u_t011_012/r1_r0_rwl u_t011_012/r1_r1_rwl
+ u_t011_012/r2_w0_wl u_t011_012/r2_w1_wl u_t011_012/r2_r0_rwl u_t011_012/r2_r1_rwl
+ u_t011_012/r3_w0_wl u_t011_012/r3_w1_wl u_t011_012/r3_r0_rwl u_t011_012/r3_r1_rwl
+ VSS VSS u_t011_012/m2_717_1265# u_t011_012/m2_603_2031# u_t011_012/m2_1290_336#
+ u_t011_012/m2_2000_2037# u_t011_012/m2_791_2909# u_t011_012/m2_7_2126# u_t011_012/m2_2154_2081#
+ u_t011_012/m2_1795_2037# u_t011_012/m2_871_303# u_t011_012/m2_431_438# u_t011_012/m2_1290_2898#
+ u_t011_012/m2_1714_1210# u_t011_012/m2_431_1982# u_t011_012/m2_512_1265# u_t011_012/m2_2573_2126#
+ u_t011_012/m2_603_1259# u_t011_012/m2_2074_2909# u_t011_012/m2_7_336# u_t011_012/m2_717_2037#
+ u_t011_012/m2_1886_2031# u_t011_012/m2_2573_336# u_t011_012/m2_7_2898# u_t011_012/m2_2000_1265#
+ u_t011_012/m2_512_2037# u_t011_012/m2_1795_1265# u_t011_012/m2_1714_1982# u_t011_012/m2_1886_1259#
+ u_t011_012/m2_1290_2126# u_t011_012/m2_1714_438# u_t011_012/m2_431_1210# u_t011_012/m2_2573_2898#
+ u_t011_012/m2_2154_303# u_t011_012/m2_871_2081# VSUBS detronyx_12t_2w2r_rc4_4x4_routed_5layer_direct
Xu_t011_001 u_t011_001/c0_w0_bl u_t011_001/c0_w0_br u_t011_001/c0_w1_bl u_t011_001/c0_w1_br
+ u_t011_001/c0_r0_rbl u_t011_001/c0_r1_rbl u_t011_001/c1_w0_bl u_t011_001/c1_w0_br
+ u_t011_001/c1_w1_bl u_t011_001/c1_w1_br u_t011_001/c1_r0_rbl u_t011_001/c1_r1_rbl
+ u_t011_001/c2_w0_bl u_t011_001/c2_w0_br u_t011_001/c2_w1_bl u_t011_001/c2_w1_br
+ u_t011_001/c2_r0_rbl u_t011_001/c2_r1_rbl u_t011_001/c3_w0_bl u_t011_001/c3_w0_br
+ u_t011_001/c3_w1_bl u_t011_001/c3_w1_br u_t011_001/c3_r0_rbl u_t011_001/c3_r1_rbl
+ u_t011_001/r0_w0_wl u_t011_001/r0_w1_wl u_t011_001/r0_r0_rwl u_t011_001/r0_r1_rwl
+ u_t011_001/r1_w0_wl u_t011_001/r1_w1_wl u_t011_001/r1_r0_rwl u_t011_001/r1_r1_rwl
+ u_t011_001/r2_w0_wl u_t011_001/r2_w1_wl u_t011_001/r2_r0_rwl u_t011_001/r2_r1_rwl
+ u_t011_001/r3_w0_wl u_t011_001/r3_w1_wl u_t011_001/r3_r0_rwl u_t011_001/r3_r1_rwl
+ VSS VSS u_t011_001/m2_717_1265# u_t011_001/m2_603_2031# u_t011_001/m2_1290_336#
+ u_t011_001/m2_2000_2037# u_t011_001/m2_791_2909# u_t011_001/m2_7_2126# u_t011_001/m2_2154_2081#
+ u_t011_001/m2_1795_2037# u_t011_001/m2_871_303# u_t011_001/m2_431_438# u_t011_001/m2_1290_2898#
+ u_t011_001/m2_1714_1210# u_t011_001/m2_431_1982# u_t011_001/m2_512_1265# u_t011_001/m2_2573_2126#
+ u_t011_001/m2_603_1259# u_t011_001/m2_2074_2909# u_t011_001/m2_7_336# u_t011_001/m2_717_2037#
+ u_t011_001/m2_1886_2031# u_t011_001/m2_2573_336# u_t011_001/m2_7_2898# u_t011_001/m2_2000_1265#
+ u_t011_001/m2_512_2037# u_t011_001/m2_1795_1265# u_t011_001/m2_1714_1982# u_t011_001/m2_1886_1259#
+ u_t011_001/m2_1290_2126# u_t011_001/m2_1714_438# u_t011_001/m2_431_1210# u_t011_001/m2_2573_2898#
+ u_t011_001/m2_2154_303# u_t011_001/m2_871_2081# VSUBS detronyx_12t_2w2r_rc4_4x4_routed_5layer_direct
Xu_t002_012 u_t002_012/c0_w0_bl u_t002_012/c0_w0_br u_t002_012/c0_w1_bl u_t002_012/c0_w1_br
+ u_t002_012/c0_r0_rbl u_t002_012/c0_r1_rbl u_t002_012/c1_w0_bl u_t002_012/c1_w0_br
+ u_t002_012/c1_w1_bl u_t002_012/c1_w1_br u_t002_012/c1_r0_rbl u_t002_012/c1_r1_rbl
+ u_t002_012/c2_w0_bl u_t002_012/c2_w0_br u_t002_012/c2_w1_bl u_t002_012/c2_w1_br
+ u_t002_012/c2_r0_rbl u_t002_012/c2_r1_rbl u_t002_012/c3_w0_bl u_t002_012/c3_w0_br
+ u_t002_012/c3_w1_bl u_t002_012/c3_w1_br u_t002_012/c3_r0_rbl u_t002_012/c3_r1_rbl
+ u_t002_012/r0_w0_wl u_t002_012/r0_w1_wl u_t002_012/r0_r0_rwl u_t002_012/r0_r1_rwl
+ u_t002_012/r1_w0_wl u_t002_012/r1_w1_wl u_t002_012/r1_r0_rwl u_t002_012/r1_r1_rwl
+ u_t002_012/r2_w0_wl u_t002_012/r2_w1_wl u_t002_012/r2_r0_rwl u_t002_012/r2_r1_rwl
+ u_t002_012/r3_w0_wl u_t002_012/r3_w1_wl u_t002_012/r3_r0_rwl u_t002_012/r3_r1_rwl
+ VSS VSS u_t002_012/m2_717_1265# u_t002_012/m2_603_2031# u_t002_012/m2_1290_336#
+ u_t002_012/m2_2000_2037# u_t002_012/m2_791_2909# u_t002_012/m2_7_2126# u_t002_012/m2_2154_2081#
+ u_t002_012/m2_1795_2037# u_t002_012/m2_871_303# u_t002_012/m2_431_438# u_t002_012/m2_1290_2898#
+ u_t002_012/m2_1714_1210# u_t002_012/m2_431_1982# u_t002_012/m2_512_1265# u_t002_012/m2_2573_2126#
+ u_t002_012/m2_603_1259# u_t002_012/m2_2074_2909# u_t002_012/m2_7_336# u_t002_012/m2_717_2037#
+ u_t002_012/m2_1886_2031# u_t002_012/m2_2573_336# u_t002_012/m2_7_2898# u_t002_012/m2_2000_1265#
+ u_t002_012/m2_512_2037# u_t002_012/m2_1795_1265# u_t002_012/m2_1714_1982# u_t002_012/m2_1886_1259#
+ u_t002_012/m2_1290_2126# u_t002_012/m2_1714_438# u_t002_012/m2_431_1210# u_t002_012/m2_2573_2898#
+ u_t002_012/m2_2154_303# u_t002_012/m2_871_2081# VSUBS detronyx_12t_2w2r_rc4_4x4_routed_5layer_direct
Xu_t002_001 u_t002_001/c0_w0_bl u_t002_001/c0_w0_br u_t002_001/c0_w1_bl u_t002_001/c0_w1_br
+ u_t002_001/c0_r0_rbl u_t002_001/c0_r1_rbl u_t002_001/c1_w0_bl u_t002_001/c1_w0_br
+ u_t002_001/c1_w1_bl u_t002_001/c1_w1_br u_t002_001/c1_r0_rbl u_t002_001/c1_r1_rbl
+ u_t002_001/c2_w0_bl u_t002_001/c2_w0_br u_t002_001/c2_w1_bl u_t002_001/c2_w1_br
+ u_t002_001/c2_r0_rbl u_t002_001/c2_r1_rbl u_t002_001/c3_w0_bl u_t002_001/c3_w0_br
+ u_t002_001/c3_w1_bl u_t002_001/c3_w1_br u_t002_001/c3_r0_rbl u_t002_001/c3_r1_rbl
+ u_t002_001/r0_w0_wl u_t002_001/r0_w1_wl u_t002_001/r0_r0_rwl u_t002_001/r0_r1_rwl
+ u_t002_001/r1_w0_wl u_t002_001/r1_w1_wl u_t002_001/r1_r0_rwl u_t002_001/r1_r1_rwl
+ u_t002_001/r2_w0_wl u_t002_001/r2_w1_wl u_t002_001/r2_r0_rwl u_t002_001/r2_r1_rwl
+ u_t002_001/r3_w0_wl u_t002_001/r3_w1_wl u_t002_001/r3_r0_rwl u_t002_001/r3_r1_rwl
+ VSS VSS u_t002_001/m2_717_1265# u_t002_001/m2_603_2031# u_t002_001/m2_1290_336#
+ u_t002_001/m2_2000_2037# u_t002_001/m2_791_2909# u_t002_001/m2_7_2126# u_t002_001/m2_2154_2081#
+ u_t002_001/m2_1795_2037# u_t002_001/m2_871_303# u_t002_001/m2_431_438# u_t002_001/m2_1290_2898#
+ u_t002_001/m2_1714_1210# u_t002_001/m2_431_1982# u_t002_001/m2_512_1265# u_t002_001/m2_2573_2126#
+ u_t002_001/m2_603_1259# u_t002_001/m2_2074_2909# u_t002_001/m2_7_336# u_t002_001/m2_717_2037#
+ u_t002_001/m2_1886_2031# u_t002_001/m2_2573_336# u_t002_001/m2_7_2898# u_t002_001/m2_2000_1265#
+ u_t002_001/m2_512_2037# u_t002_001/m2_1795_1265# u_t002_001/m2_1714_1982# u_t002_001/m2_1886_1259#
+ u_t002_001/m2_1290_2126# u_t002_001/m2_1714_438# u_t002_001/m2_431_1210# u_t002_001/m2_2573_2898#
+ u_t002_001/m2_2154_303# u_t002_001/m2_871_2081# VSUBS detronyx_12t_2w2r_rc4_4x4_routed_5layer_direct
Xgf180mcu_as_sc_mcu7t3v3__inv_2_1235 gf180mcu_as_sc_mcu7t3v3__nor2_2_9/VDD gf180mcu_as_sc_mcu7t3v3__nor2_2_9/VSS
+ VSS VSS gf180mcu_as_sc_mcu7t3v3__nor2_2_9/VNW VSUBS gf180mcu_as_sc_mcu7t3v3__inv_2
Xgf180mcu_as_sc_mcu7t3v3__inv_2_1213 gf180mcu_as_sc_mcu7t3v3__nor2_2_9/VDD gf180mcu_as_sc_mcu7t3v3__nor2_2_9/VSS
+ gf180mcu_as_sc_mcu7t3v3__inv_2_1213/Y VSS gf180mcu_as_sc_mcu7t3v3__nor2_2_9/VNW
+ VSUBS gf180mcu_as_sc_mcu7t3v3__inv_2
Xgf180mcu_as_sc_mcu7t3v3__inv_2_1202 gf180mcu_as_sc_mcu7t3v3__nand3_2_65/VDD gf180mcu_as_sc_mcu7t3v3__nand3_2_62/VSS
+ gf180mcu_as_sc_mcu7t3v3__inv_2_1202/Y VSS gf180mcu_as_sc_mcu7t3v3__nand3_2_65/VNW
+ VSUBS gf180mcu_as_sc_mcu7t3v3__inv_2
Xgf180mcu_as_sc_mcu7t3v3__inv_2_1224 VSS VSS gf180mcu_as_sc_mcu7t3v3__inv_2_1224/Y
+ gf180mcu_as_sc_mcu7t3v3__inv_2_1224/A gf180mcu_as_sc_mcu7t3v3__inv_2_1276/VNW VSUBS
+ gf180mcu_as_sc_mcu7t3v3__inv_2
Xgf180mcu_as_sc_mcu7t3v3__inv_2_1246 gf180mcu_as_sc_mcu7t3v3__nor2_2_9/VDD gf180mcu_as_sc_mcu7t3v3__nor2_2_9/VSS
+ VSS VSS gf180mcu_as_sc_mcu7t3v3__nor2_2_9/VNW VSUBS gf180mcu_as_sc_mcu7t3v3__inv_2
Xgf180mcu_as_sc_mcu7t3v3__inv_2_1257 gf180mcu_as_sc_mcu7t3v3__nand3_2_65/VDD gf180mcu_as_sc_mcu7t3v3__nand3_2_62/VSS
+ gf180mcu_as_sc_mcu7t3v3__inv_2_1257/Y VSS gf180mcu_as_sc_mcu7t3v3__nand3_2_65/VNW
+ VSUBS gf180mcu_as_sc_mcu7t3v3__inv_2
Xgf180mcu_as_sc_mcu7t3v3__inv_2_1279 VSS VSS VSS gf180mcu_as_sc_mcu7t3v3__inv_2_1279/A
+ gf180mcu_as_sc_mcu7t3v3__inv_2_1279/VNW VSUBS gf180mcu_as_sc_mcu7t3v3__inv_2
Xgf180mcu_as_sc_mcu7t3v3__inv_2_1268 VSS VSS VSS gf180mcu_as_sc_mcu7t3v3__inv_2_1268/A
+ gf180mcu_as_sc_mcu7t3v3__inv_2_1268/VNW VSUBS gf180mcu_as_sc_mcu7t3v3__inv_2
Xgf180mcu_as_sc_mcu7t3v3__inv_2_719 VSS VSS gf180mcu_as_sc_mcu7t3v3__inv_2_719/Y gf180mcu_as_sc_mcu7t3v3__inv_2_720/Y
+ gf180mcu_as_sc_mcu7t3v3__inv_2_720/VNW VSUBS gf180mcu_as_sc_mcu7t3v3__inv_2
Xgf180mcu_as_sc_mcu7t3v3__inv_2_708 VSS VSS gf180mcu_as_sc_mcu7t3v3__inv_2_708/Y gf180mcu_as_sc_mcu7t3v3__inv_2_708/A
+ gf180mcu_as_sc_mcu7t3v3__inv_2_708/VNW VSUBS gf180mcu_as_sc_mcu7t3v3__inv_2
Xgf180mcu_as_sc_mcu7t3v3__inv_2_1065 VSS VSS VSS gf180mcu_as_sc_mcu7t3v3__inv_2_1066/Y
+ gf180mcu_as_sc_mcu7t3v3__inv_2_1067/VNW VSUBS gf180mcu_as_sc_mcu7t3v3__inv_2
Xgf180mcu_as_sc_mcu7t3v3__inv_2_1076 VSS VSS gf180mcu_as_sc_mcu7t3v3__inv_2_1076/Y
+ gf180mcu_as_sc_mcu7t3v3__inv_2_1080/Y gf180mcu_as_sc_mcu7t3v3__inv_2_1080/VNW VSUBS
+ gf180mcu_as_sc_mcu7t3v3__inv_2
Xgf180mcu_as_sc_mcu7t3v3__inv_2_1010 VSS VSS VSS gf180mcu_as_sc_mcu7t3v3__inv_2_1011/Y
+ gf180mcu_as_sc_mcu7t3v3__inv_2_1012/VNW VSUBS gf180mcu_as_sc_mcu7t3v3__inv_2
Xgf180mcu_as_sc_mcu7t3v3__inv_2_1032 VSS VSS gf180mcu_as_sc_mcu7t3v3__inv_2_1032/Y
+ gf180mcu_as_sc_mcu7t3v3__inv_2_1032/A gf180mcu_as_sc_mcu7t3v3__inv_2_1032/VNW VSUBS
+ gf180mcu_as_sc_mcu7t3v3__inv_2
Xgf180mcu_as_sc_mcu7t3v3__inv_2_1021 VSS VSS gf180mcu_as_sc_mcu7t3v3__inv_2_1021/Y
+ gf180mcu_as_sc_mcu7t3v3__inv_2_1021/A gf180mcu_as_sc_mcu7t3v3__inv_2_1057/VNW VSUBS
+ gf180mcu_as_sc_mcu7t3v3__inv_2
Xgf180mcu_as_sc_mcu7t3v3__inv_2_1043 VSS VSS gf180mcu_as_sc_mcu7t3v3__inv_2_1043/Y
+ gf180mcu_as_sc_mcu7t3v3__inv_2_1044/Y gf180mcu_as_sc_mcu7t3v3__inv_2_1044/VNW VSUBS
+ gf180mcu_as_sc_mcu7t3v3__inv_2
Xgf180mcu_as_sc_mcu7t3v3__inv_2_1054 VSS VSS VSS gf180mcu_as_sc_mcu7t3v3__inv_2_1055/Y
+ gf180mcu_as_sc_mcu7t3v3__inv_2_1056/VNW VSUBS gf180mcu_as_sc_mcu7t3v3__inv_2
Xgf180mcu_as_sc_mcu7t3v3__inv_2_84 VSS VSS gf180mcu_as_sc_mcu7t3v3__inv_2_91/A gf180mcu_as_sc_mcu7t3v3__inv_2_85/Y
+ gf180mcu_as_sc_mcu7t3v3__inv_2_91/VNW VSUBS gf180mcu_as_sc_mcu7t3v3__inv_2
Xgf180mcu_as_sc_mcu7t3v3__inv_2_95 VSS VSS VSS gf180mcu_as_sc_mcu7t3v3__inv_2_96/Y
+ gf180mcu_as_sc_mcu7t3v3__inv_2_97/VNW VSUBS gf180mcu_as_sc_mcu7t3v3__inv_2
Xgf180mcu_as_sc_mcu7t3v3__inv_2_62 VSS VSS gf180mcu_as_sc_mcu7t3v3__inv_2_62/Y gf180mcu_as_sc_mcu7t3v3__inv_2_62/A
+ gf180mcu_as_sc_mcu7t3v3__inv_2_62/VNW VSUBS gf180mcu_as_sc_mcu7t3v3__inv_2
Xgf180mcu_as_sc_mcu7t3v3__inv_2_40 VSS VSS VSS gf180mcu_as_sc_mcu7t3v3__inv_2_41/Y
+ gf180mcu_as_sc_mcu7t3v3__inv_2_42/VNW VSUBS gf180mcu_as_sc_mcu7t3v3__inv_2
Xgf180mcu_as_sc_mcu7t3v3__inv_2_73 VSS VSS gf180mcu_as_sc_mcu7t3v3__inv_2_73/Y gf180mcu_as_sc_mcu7t3v3__inv_2_73/A
+ gf180mcu_as_sc_mcu7t3v3__inv_2_73/VNW VSUBS gf180mcu_as_sc_mcu7t3v3__inv_2
Xgf180mcu_as_sc_mcu7t3v3__inv_2_51 VSS VSS VSS gf180mcu_as_sc_mcu7t3v3__inv_2_52/Y
+ gf180mcu_as_sc_mcu7t3v3__inv_2_53/VNW VSUBS gf180mcu_as_sc_mcu7t3v3__inv_2
Xgf180mcu_as_sc_mcu7t3v3__inv_2_1087 VSS VSS gf180mcu_as_sc_mcu7t3v3__inv_2_1087/Y
+ gf180mcu_as_sc_mcu7t3v3__inv_2_1087/A gf180mcu_as_sc_mcu7t3v3__inv_2_1087/VNW VSUBS
+ gf180mcu_as_sc_mcu7t3v3__inv_2
Xgf180mcu_as_sc_mcu7t3v3__inv_2_1098 VSS VSS gf180mcu_as_sc_mcu7t3v3__inv_2_1098/Y
+ gf180mcu_as_sc_mcu7t3v3__inv_2_1099/Y gf180mcu_as_sc_mcu7t3v3__inv_2_1099/VNW VSUBS
+ gf180mcu_as_sc_mcu7t3v3__inv_2
Xgf180mcu_as_sc_mcu7t3v3__inv_2_527 gf180mcu_as_sc_mcu7t3v3__nor2_2_4/VDD gf180mcu_as_sc_mcu7t3v3__nand2_2_3/VSS
+ VSS VSS gf180mcu_as_sc_mcu7t3v3__nor2_2_4/VNW VSUBS gf180mcu_as_sc_mcu7t3v3__inv_2
Xgf180mcu_as_sc_mcu7t3v3__inv_2_516 VSS VSS gf180mcu_as_sc_mcu7t3v3__inv_2_559/A gf180mcu_as_sc_mcu7t3v3__inv_2_517/Y
+ gf180mcu_as_sc_mcu7t3v3__inv_2_559/VNW VSUBS gf180mcu_as_sc_mcu7t3v3__inv_2
Xgf180mcu_as_sc_mcu7t3v3__inv_2_505 VSS VSS gf180mcu_as_sc_mcu7t3v3__inv_2_505/Y gf180mcu_as_sc_mcu7t3v3__inv_2_505/A
+ gf180mcu_as_sc_mcu7t3v3__inv_2_537/VNW VSUBS gf180mcu_as_sc_mcu7t3v3__inv_2
Xgf180mcu_as_sc_mcu7t3v3__inv_2_549 VSS VSS VSS gf180mcu_as_sc_mcu7t3v3__inv_2_549/A
+ gf180mcu_as_sc_mcu7t3v3__inv_2_549/VNW VSUBS gf180mcu_as_sc_mcu7t3v3__inv_2
Xgf180mcu_as_sc_mcu7t3v3__inv_2_538 VSS VSS VSS gf180mcu_as_sc_mcu7t3v3__inv_2_538/A
+ gf180mcu_as_sc_mcu7t3v3__inv_2_538/VNW VSUBS gf180mcu_as_sc_mcu7t3v3__inv_2
Xgf180mcu_as_sc_mcu7t3v3__nand4_2_371 VSS VSS VSS VSS VSS VSS gf180mcu_as_sc_mcu7t3v3__inv_2_1200/A
+ gf180mcu_as_sc_mcu7t3v3__inv_2_1272/VNW VSUBS gf180mcu_as_sc_mcu7t3v3__nand4_2
Xgf180mcu_as_sc_mcu7t3v3__nand4_2_360 VSS VSS VSS VSS VSS VSS gf180mcu_as_sc_mcu7t3v3__inv_2_1174/A
+ gf180mcu_as_sc_mcu7t3v3__inv_2_1295/VNW VSUBS gf180mcu_as_sc_mcu7t3v3__nand4_2
Xgf180mcu_as_sc_mcu7t3v3__nand4_2_382 VSS VSS VSS VSS VSS VSS gf180mcu_as_sc_mcu7t3v3__inv_2_1416/A
+ gf180mcu_as_sc_mcu7t3v3__inv_2_1416/VNW VSUBS gf180mcu_as_sc_mcu7t3v3__nand4_2
Xgf180mcu_as_sc_mcu7t3v3__nand4_2_393 VSS VSS VSS VSS VSS VSS gf180mcu_as_sc_mcu7t3v3__inv_2_1449/A
+ gf180mcu_as_sc_mcu7t3v3__inv_2_1449/VNW VSUBS gf180mcu_as_sc_mcu7t3v3__nand4_2
Xgf180mcu_as_sc_mcu7t3v3__inv_2_368 VSS VSS gf180mcu_as_sc_mcu7t3v3__inv_2_368/Y gf180mcu_as_sc_mcu7t3v3__inv_2_368/A
+ gf180mcu_as_sc_mcu7t3v3__inv_2_368/VNW VSUBS gf180mcu_as_sc_mcu7t3v3__inv_2
Xgf180mcu_as_sc_mcu7t3v3__inv_2_302 VSS VSS gf180mcu_as_sc_mcu7t3v3__inv_2_302/Y gf180mcu_as_sc_mcu7t3v3__inv_2_302/A
+ gf180mcu_as_sc_mcu7t3v3__inv_2_302/VNW VSUBS gf180mcu_as_sc_mcu7t3v3__inv_2
Xgf180mcu_as_sc_mcu7t3v3__inv_2_357 VSS VSS VSS gf180mcu_as_sc_mcu7t3v3__inv_2_358/Y
+ gf180mcu_as_sc_mcu7t3v3__inv_2_359/VNW VSUBS gf180mcu_as_sc_mcu7t3v3__inv_2
Xgf180mcu_as_sc_mcu7t3v3__inv_2_346 VSS VSS gf180mcu_as_sc_mcu7t3v3__inv_2_346/Y gf180mcu_as_sc_mcu7t3v3__inv_2_347/Y
+ gf180mcu_as_sc_mcu7t3v3__inv_2_347/VNW VSUBS gf180mcu_as_sc_mcu7t3v3__inv_2
Xgf180mcu_as_sc_mcu7t3v3__inv_2_335 VSS VSS gf180mcu_as_sc_mcu7t3v3__inv_2_335/Y gf180mcu_as_sc_mcu7t3v3__inv_2_335/A
+ gf180mcu_as_sc_mcu7t3v3__inv_2_335/VNW VSUBS gf180mcu_as_sc_mcu7t3v3__inv_2
Xgf180mcu_as_sc_mcu7t3v3__inv_2_324 VSS VSS VSS gf180mcu_as_sc_mcu7t3v3__inv_2_325/Y
+ gf180mcu_as_sc_mcu7t3v3__inv_2_326/VNW VSUBS gf180mcu_as_sc_mcu7t3v3__inv_2
Xgf180mcu_as_sc_mcu7t3v3__inv_2_313 VSS VSS gf180mcu_as_sc_mcu7t3v3__inv_2_313/Y gf180mcu_as_sc_mcu7t3v3__inv_2_314/Y
+ gf180mcu_as_sc_mcu7t3v3__inv_2_314/VNW VSUBS gf180mcu_as_sc_mcu7t3v3__inv_2
Xgf180mcu_as_sc_mcu7t3v3__inv_2_379 gf180mcu_as_sc_mcu7t3v3__nor2_2_6/VDD gf180mcu_as_sc_mcu7t3v3__nor2_2_6/VSS
+ VSS VSS gf180mcu_as_sc_mcu7t3v3__nor2_2_6/VNW VSUBS gf180mcu_as_sc_mcu7t3v3__inv_2
Xu_t027_007 u_t027_007/c0_w0_bl u_t027_007/c0_w0_br u_t027_007/c0_w1_bl u_t027_007/c0_w1_br
+ u_t027_007/c0_r0_rbl u_t027_007/c0_r1_rbl u_t027_007/c1_w0_bl u_t027_007/c1_w0_br
+ u_t027_007/c1_w1_bl u_t027_007/c1_w1_br u_t027_007/c1_r0_rbl u_t027_007/c1_r1_rbl
+ u_t027_007/c2_w0_bl u_t027_007/c2_w0_br u_t027_007/c2_w1_bl u_t027_007/c2_w1_br
+ u_t027_007/c2_r0_rbl u_t027_007/c2_r1_rbl u_t027_007/c3_w0_bl u_t027_007/c3_w0_br
+ u_t027_007/c3_w1_bl u_t027_007/c3_w1_br u_t027_007/c3_r0_rbl u_t027_007/c3_r1_rbl
+ u_t027_007/r0_w0_wl u_t027_007/r0_w1_wl u_t027_007/r0_r0_rwl u_t027_007/r0_r1_rwl
+ u_t027_007/r1_w0_wl u_t027_007/r1_w1_wl u_t027_007/r1_r0_rwl u_t027_007/r1_r1_rwl
+ u_t027_007/r2_w0_wl u_t027_007/r2_w1_wl u_t027_007/r2_r0_rwl u_t027_007/r2_r1_rwl
+ u_t027_007/r3_w0_wl u_t027_007/r3_w1_wl u_t027_007/r3_r0_rwl u_t027_007/r3_r1_rwl
+ VSS VSS u_t027_007/m2_717_1265# u_t027_007/m2_603_2031# u_t027_007/m2_1290_336#
+ u_t027_007/m2_2000_2037# u_t027_007/m2_791_2909# u_t027_007/m2_7_2126# u_t027_007/m2_2154_2081#
+ u_t027_007/m2_1795_2037# u_t027_007/m2_871_303# u_t027_007/m2_431_438# u_t027_007/m2_1290_2898#
+ u_t027_007/m2_1714_1210# u_t027_007/m2_431_1982# u_t027_007/m2_512_1265# u_t027_007/m2_2573_2126#
+ u_t027_007/m2_603_1259# u_t027_007/m2_2074_2909# u_t027_007/m2_7_336# u_t027_007/m2_717_2037#
+ u_t027_007/m2_1886_2031# u_t027_007/m2_2573_336# u_t027_007/m2_7_2898# u_t027_007/m2_2000_1265#
+ u_t027_007/m2_512_2037# u_t027_007/m2_1795_1265# u_t027_007/m2_1714_1982# u_t027_007/m2_1886_1259#
+ u_t027_007/m2_1290_2126# u_t027_007/m2_1714_438# u_t027_007/m2_431_1210# u_t027_007/m2_2573_2898#
+ u_t027_007/m2_2154_303# u_t027_007/m2_871_2081# VSUBS detronyx_12t_2w2r_rc4_4x4_routed_5layer_direct
Xgf180mcu_as_sc_mcu7t3v3__inv_2_891 VSS VSS gf180mcu_as_sc_mcu7t3v3__inv_2_891/Y gf180mcu_as_sc_mcu7t3v3__inv_2_891/A
+ gf180mcu_as_sc_mcu7t3v3__inv_2_949/VNW VSUBS gf180mcu_as_sc_mcu7t3v3__inv_2
Xgf180mcu_as_sc_mcu7t3v3__inv_2_880 VSS VSS gf180mcu_as_sc_mcu7t3v3__inv_2_941/A gf180mcu_as_sc_mcu7t3v3__inv_2_883/Y
+ gf180mcu_as_sc_mcu7t3v3__inv_2_941/VNW VSUBS gf180mcu_as_sc_mcu7t3v3__inv_2
Xu_t018_007 u_t018_007/c0_w0_bl u_t018_007/c0_w0_br u_t018_007/c0_w1_bl u_t018_007/c0_w1_br
+ u_t018_007/c0_r0_rbl u_t018_007/c0_r1_rbl u_t018_007/c1_w0_bl u_t018_007/c1_w0_br
+ u_t018_007/c1_w1_bl u_t018_007/c1_w1_br u_t018_007/c1_r0_rbl u_t018_007/c1_r1_rbl
+ u_t018_007/c2_w0_bl u_t018_007/c2_w0_br u_t018_007/c2_w1_bl u_t018_007/c2_w1_br
+ u_t018_007/c2_r0_rbl u_t018_007/c2_r1_rbl u_t018_007/c3_w0_bl u_t018_007/c3_w0_br
+ u_t018_007/c3_w1_bl u_t018_007/c3_w1_br u_t018_007/c3_r0_rbl u_t018_007/c3_r1_rbl
+ u_t018_007/r0_w0_wl u_t018_007/r0_w1_wl u_t018_007/r0_r0_rwl u_t018_007/r0_r1_rwl
+ u_t018_007/r1_w0_wl u_t018_007/r1_w1_wl u_t018_007/r1_r0_rwl u_t018_007/r1_r1_rwl
+ u_t018_007/r2_w0_wl u_t018_007/r2_w1_wl u_t018_007/r2_r0_rwl u_t018_007/r2_r1_rwl
+ u_t018_007/r3_w0_wl u_t018_007/r3_w1_wl u_t018_007/r3_r0_rwl u_t018_007/r3_r1_rwl
+ VSS VSS u_t018_007/m2_717_1265# u_t018_007/m2_603_2031# u_t018_007/m2_1290_336#
+ u_t018_007/m2_2000_2037# u_t018_007/m2_791_2909# u_t018_007/m2_7_2126# u_t018_007/m2_2154_2081#
+ u_t018_007/m2_1795_2037# u_t018_007/m2_871_303# u_t018_007/m2_431_438# u_t018_007/m2_1290_2898#
+ u_t018_007/m2_1714_1210# u_t018_007/m2_431_1982# u_t018_007/m2_512_1265# u_t018_007/m2_2573_2126#
+ u_t018_007/m2_603_1259# u_t018_007/m2_2074_2909# u_t018_007/m2_7_336# u_t018_007/m2_717_2037#
+ u_t018_007/m2_1886_2031# u_t018_007/m2_2573_336# u_t018_007/m2_7_2898# u_t018_007/m2_2000_1265#
+ u_t018_007/m2_512_2037# u_t018_007/m2_1795_1265# u_t018_007/m2_1714_1982# u_t018_007/m2_1886_1259#
+ u_t018_007/m2_1290_2126# u_t018_007/m2_1714_438# u_t018_007/m2_431_1210# u_t018_007/m2_2573_2898#
+ u_t018_007/m2_2154_303# u_t018_007/m2_871_2081# VSUBS detronyx_12t_2w2r_rc4_4x4_routed_5layer_direct
Xgf180mcu_as_sc_mcu7t3v3__nand4_2_190 VSS VSS VSS VSS VSS VSS gf180mcu_as_sc_mcu7t3v3__inv_2_730/A
+ gf180mcu_as_sc_mcu7t3v3__inv_2_730/VNW VSUBS gf180mcu_as_sc_mcu7t3v3__nand4_2
Xu_t009_007 u_t009_007/c0_w0_bl u_t009_007/c0_w0_br u_t009_007/c0_w1_bl u_t009_007/c0_w1_br
+ u_t009_007/c0_r0_rbl u_t009_007/c0_r1_rbl u_t009_007/c1_w0_bl u_t009_007/c1_w0_br
+ u_t009_007/c1_w1_bl u_t009_007/c1_w1_br u_t009_007/c1_r0_rbl u_t009_007/c1_r1_rbl
+ u_t009_007/c2_w0_bl u_t009_007/c2_w0_br u_t009_007/c2_w1_bl u_t009_007/c2_w1_br
+ u_t009_007/c2_r0_rbl u_t009_007/c2_r1_rbl u_t009_007/c3_w0_bl u_t009_007/c3_w0_br
+ u_t009_007/c3_w1_bl u_t009_007/c3_w1_br u_t009_007/c3_r0_rbl u_t009_007/c3_r1_rbl
+ u_t009_007/r0_w0_wl u_t009_007/r0_w1_wl u_t009_007/r0_r0_rwl u_t009_007/r0_r1_rwl
+ u_t009_007/r1_w0_wl u_t009_007/r1_w1_wl u_t009_007/r1_r0_rwl u_t009_007/r1_r1_rwl
+ u_t009_007/r2_w0_wl u_t009_007/r2_w1_wl u_t009_007/r2_r0_rwl u_t009_007/r2_r1_rwl
+ u_t009_007/r3_w0_wl u_t009_007/r3_w1_wl u_t009_007/r3_r0_rwl u_t009_007/r3_r1_rwl
+ VSS VSS u_t009_007/m2_717_1265# u_t009_007/m2_603_2031# u_t009_007/m2_1290_336#
+ u_t009_007/m2_2000_2037# u_t009_007/m2_791_2909# u_t009_007/m2_7_2126# u_t009_007/m2_2154_2081#
+ u_t009_007/m2_1795_2037# u_t009_007/m2_871_303# u_t009_007/m2_431_438# u_t009_007/m2_1290_2898#
+ u_t009_007/m2_1714_1210# u_t009_007/m2_431_1982# u_t009_007/m2_512_1265# u_t009_007/m2_2573_2126#
+ u_t009_007/m2_603_1259# u_t009_007/m2_2074_2909# u_t009_007/m2_7_336# u_t009_007/m2_717_2037#
+ u_t009_007/m2_1886_2031# u_t009_007/m2_2573_336# u_t009_007/m2_7_2898# u_t009_007/m2_2000_1265#
+ u_t009_007/m2_512_2037# u_t009_007/m2_1795_1265# u_t009_007/m2_1714_1982# u_t009_007/m2_1886_1259#
+ u_t009_007/m2_1290_2126# u_t009_007/m2_1714_438# u_t009_007/m2_431_1210# u_t009_007/m2_2573_2898#
+ u_t009_007/m2_2154_303# u_t009_007/m2_871_2081# VSUBS detronyx_12t_2w2r_rc4_4x4_routed_5layer_direct
Xgf180mcu_as_sc_mcu7t3v3__inv_2_154 VSS VSS gf180mcu_as_sc_mcu7t3v3__inv_2_154/Y gf180mcu_as_sc_mcu7t3v3__inv_2_155/Y
+ gf180mcu_as_sc_mcu7t3v3__inv_2_155/VNW VSUBS gf180mcu_as_sc_mcu7t3v3__inv_2
Xgf180mcu_as_sc_mcu7t3v3__inv_2_143 VSS VSS gf180mcu_as_sc_mcu7t3v3__inv_2_143/Y gf180mcu_as_sc_mcu7t3v3__inv_2_143/A
+ gf180mcu_as_sc_mcu7t3v3__inv_2_143/VNW VSUBS gf180mcu_as_sc_mcu7t3v3__inv_2
Xgf180mcu_as_sc_mcu7t3v3__inv_2_132 VSS VSS VSS gf180mcu_as_sc_mcu7t3v3__inv_2_133/Y
+ gf180mcu_as_sc_mcu7t3v3__inv_2_134/VNW VSUBS gf180mcu_as_sc_mcu7t3v3__inv_2
Xgf180mcu_as_sc_mcu7t3v3__inv_2_121 VSS VSS gf180mcu_as_sc_mcu7t3v3__inv_2_121/Y gf180mcu_as_sc_mcu7t3v3__inv_2_122/Y
+ gf180mcu_as_sc_mcu7t3v3__inv_2_122/VNW VSUBS gf180mcu_as_sc_mcu7t3v3__inv_2
Xgf180mcu_as_sc_mcu7t3v3__inv_2_110 VSS VSS gf180mcu_as_sc_mcu7t3v3__inv_2_110/Y gf180mcu_as_sc_mcu7t3v3__inv_2_110/A
+ gf180mcu_as_sc_mcu7t3v3__inv_2_110/VNW VSUBS gf180mcu_as_sc_mcu7t3v3__inv_2
Xgf180mcu_as_sc_mcu7t3v3__inv_2_198 VSS VSS VSS gf180mcu_as_sc_mcu7t3v3__inv_2_199/Y
+ gf180mcu_as_sc_mcu7t3v3__inv_2_200/VNW VSUBS gf180mcu_as_sc_mcu7t3v3__inv_2
Xgf180mcu_as_sc_mcu7t3v3__inv_2_187 VSS VSS gf180mcu_as_sc_mcu7t3v3__inv_2_187/Y gf180mcu_as_sc_mcu7t3v3__inv_2_187/A
+ gf180mcu_as_sc_mcu7t3v3__inv_2_187/VNW VSUBS gf180mcu_as_sc_mcu7t3v3__inv_2
Xgf180mcu_as_sc_mcu7t3v3__inv_2_165 VSS VSS gf180mcu_as_sc_mcu7t3v3__inv_2_165/Y gf180mcu_as_sc_mcu7t3v3__inv_2_165/A
+ gf180mcu_as_sc_mcu7t3v3__inv_2_165/VNW VSUBS gf180mcu_as_sc_mcu7t3v3__inv_2
Xgf180mcu_as_sc_mcu7t3v3__inv_2_176 VSS VSS VSS gf180mcu_as_sc_mcu7t3v3__inv_2_177/Y
+ gf180mcu_as_sc_mcu7t3v3__inv_2_177/VNW VSUBS gf180mcu_as_sc_mcu7t3v3__inv_2
Xgf180mcu_as_sc_mcu7t3v3__inv_2_1609 VSS VSS gf180mcu_as_sc_mcu7t3v3__inv_2_1609/Y
+ gf180mcu_as_sc_mcu7t3v3__inv_2_1610/Y gf180mcu_as_sc_mcu7t3v3__inv_2_1610/VNW VSUBS
+ gf180mcu_as_sc_mcu7t3v3__inv_2
Xu_t023_010 u_t023_010/c0_w0_bl u_t023_010/c0_w0_br u_t023_010/c0_w1_bl u_t023_010/c0_w1_br
+ u_t023_010/c0_r0_rbl u_t023_010/c0_r1_rbl u_t023_010/c1_w0_bl u_t023_010/c1_w0_br
+ u_t023_010/c1_w1_bl u_t023_010/c1_w1_br u_t023_010/c1_r0_rbl u_t023_010/c1_r1_rbl
+ u_t023_010/c2_w0_bl u_t023_010/c2_w0_br u_t023_010/c2_w1_bl u_t023_010/c2_w1_br
+ u_t023_010/c2_r0_rbl u_t023_010/c2_r1_rbl u_t023_010/c3_w0_bl u_t023_010/c3_w0_br
+ u_t023_010/c3_w1_bl u_t023_010/c3_w1_br u_t023_010/c3_r0_rbl u_t023_010/c3_r1_rbl
+ u_t023_010/r0_w0_wl u_t023_010/r0_w1_wl u_t023_010/r0_r0_rwl u_t023_010/r0_r1_rwl
+ u_t023_010/r1_w0_wl u_t023_010/r1_w1_wl u_t023_010/r1_r0_rwl u_t023_010/r1_r1_rwl
+ u_t023_010/r2_w0_wl u_t023_010/r2_w1_wl u_t023_010/r2_r0_rwl u_t023_010/r2_r1_rwl
+ u_t023_010/r3_w0_wl u_t023_010/r3_w1_wl u_t023_010/r3_r0_rwl u_t023_010/r3_r1_rwl
+ VSS VSS u_t023_010/m2_717_1265# u_t023_010/m2_603_2031# u_t023_010/m2_1290_336#
+ u_t023_010/m2_2000_2037# u_t023_010/m2_791_2909# u_t023_010/m2_7_2126# u_t023_010/m2_2154_2081#
+ u_t023_010/m2_1795_2037# u_t023_010/m2_871_303# u_t023_010/m2_431_438# u_t023_010/m2_1290_2898#
+ u_t023_010/m2_1714_1210# u_t023_010/m2_431_1982# u_t023_010/m2_512_1265# u_t023_010/m2_2573_2126#
+ u_t023_010/m2_603_1259# u_t023_010/m2_2074_2909# u_t023_010/m2_7_336# u_t023_010/m2_717_2037#
+ u_t023_010/m2_1886_2031# u_t023_010/m2_2573_336# u_t023_010/m2_7_2898# u_t023_010/m2_2000_1265#
+ u_t023_010/m2_512_2037# u_t023_010/m2_1795_1265# u_t023_010/m2_1714_1982# u_t023_010/m2_1886_1259#
+ u_t023_010/m2_1290_2126# u_t023_010/m2_1714_438# u_t023_010/m2_431_1210# u_t023_010/m2_2573_2898#
+ u_t023_010/m2_2154_303# u_t023_010/m2_871_2081# VSUBS detronyx_12t_2w2r_rc4_4x4_routed_5layer_direct
Xu_t014_010 u_t014_010/c0_w0_bl u_t014_010/c0_w0_br u_t014_010/c0_w1_bl u_t014_010/c0_w1_br
+ u_t014_010/c0_r0_rbl u_t014_010/c0_r1_rbl u_t014_010/c1_w0_bl u_t014_010/c1_w0_br
+ u_t014_010/c1_w1_bl u_t014_010/c1_w1_br u_t014_010/c1_r0_rbl u_t014_010/c1_r1_rbl
+ u_t014_010/c2_w0_bl u_t014_010/c2_w0_br u_t014_010/c2_w1_bl u_t014_010/c2_w1_br
+ u_t014_010/c2_r0_rbl u_t014_010/c2_r1_rbl u_t014_010/c3_w0_bl u_t014_010/c3_w0_br
+ u_t014_010/c3_w1_bl u_t014_010/c3_w1_br u_t014_010/c3_r0_rbl u_t014_010/c3_r1_rbl
+ u_t014_010/r0_w0_wl u_t014_010/r0_w1_wl u_t014_010/r0_r0_rwl u_t014_010/r0_r1_rwl
+ u_t014_010/r1_w0_wl u_t014_010/r1_w1_wl u_t014_010/r1_r0_rwl u_t014_010/r1_r1_rwl
+ u_t014_010/r2_w0_wl u_t014_010/r2_w1_wl u_t014_010/r2_r0_rwl u_t014_010/r2_r1_rwl
+ u_t014_010/r3_w0_wl u_t014_010/r3_w1_wl u_t014_010/r3_r0_rwl u_t014_010/r3_r1_rwl
+ VSS VSS u_t014_010/m2_717_1265# u_t014_010/m2_603_2031# u_t014_010/m2_1290_336#
+ u_t014_010/m2_2000_2037# u_t014_010/m2_791_2909# u_t014_010/m2_7_2126# u_t014_010/m2_2154_2081#
+ u_t014_010/m2_1795_2037# u_t014_010/m2_871_303# u_t014_010/m2_431_438# u_t014_010/m2_1290_2898#
+ u_t014_010/m2_1714_1210# u_t014_010/m2_431_1982# u_t014_010/m2_512_1265# u_t014_010/m2_2573_2126#
+ u_t014_010/m2_603_1259# u_t014_010/m2_2074_2909# u_t014_010/m2_7_336# u_t014_010/m2_717_2037#
+ u_t014_010/m2_1886_2031# u_t014_010/m2_2573_336# u_t014_010/m2_7_2898# u_t014_010/m2_2000_1265#
+ u_t014_010/m2_512_2037# u_t014_010/m2_1795_1265# u_t014_010/m2_1714_1982# u_t014_010/m2_1886_1259#
+ u_t014_010/m2_1290_2126# u_t014_010/m2_1714_438# u_t014_010/m2_431_1210# u_t014_010/m2_2573_2898#
+ u_t014_010/m2_2154_303# u_t014_010/m2_871_2081# VSUBS detronyx_12t_2w2r_rc4_4x4_routed_5layer_direct
Xgf180mcu_as_sc_mcu7t3v3__nand2_2_44 gf180mcu_as_sc_mcu7t3v3__nor2_2_9/VDD gf180mcu_as_sc_mcu7t3v3__nand3_2_63/VSS
+ VSS VSS VSS gf180mcu_as_sc_mcu7t3v3__nor2_2_9/VNW VSUBS gf180mcu_as_sc_mcu7t3v3__nand2_2
Xgf180mcu_as_sc_mcu7t3v3__nand2_2_22 gf180mcu_as_sc_mcu7t3v3__nor2_2_6/VDD gf180mcu_as_sc_mcu7t3v3__nand3_2_4/VSS
+ VSS VSS VSS gf180mcu_as_sc_mcu7t3v3__nor2_2_6/VNW VSUBS gf180mcu_as_sc_mcu7t3v3__nand2_2
Xgf180mcu_as_sc_mcu7t3v3__nand2_2_11 gf180mcu_as_sc_mcu7t3v3__nor2_2_4/VDD gf180mcu_as_sc_mcu7t3v3__nand2_2_3/VSS
+ VSS VSS VSS gf180mcu_as_sc_mcu7t3v3__nor2_2_4/VNW VSUBS gf180mcu_as_sc_mcu7t3v3__nand2_2
Xgf180mcu_as_sc_mcu7t3v3__nand2_2_33 gf180mcu_as_sc_mcu7t3v3__nor2_2_4/VDD gf180mcu_as_sc_mcu7t3v3__nand2_2_3/VSS
+ VSS VSS VSS gf180mcu_as_sc_mcu7t3v3__nor2_2_4/VNW VSUBS gf180mcu_as_sc_mcu7t3v3__nand2_2
Xu_t020_013 u_t020_013/c0_w0_bl u_t020_013/c0_w0_br u_t020_013/c0_w1_bl u_t020_013/c0_w1_br
+ u_t020_013/c0_r0_rbl u_t020_013/c0_r1_rbl u_t020_013/c1_w0_bl u_t020_013/c1_w0_br
+ u_t020_013/c1_w1_bl u_t020_013/c1_w1_br u_t020_013/c1_r0_rbl u_t020_013/c1_r1_rbl
+ u_t020_013/c2_w0_bl u_t020_013/c2_w0_br u_t020_013/c2_w1_bl u_t020_013/c2_w1_br
+ u_t020_013/c2_r0_rbl u_t020_013/c2_r1_rbl u_t020_013/c3_w0_bl u_t020_013/c3_w0_br
+ u_t020_013/c3_w1_bl u_t020_013/c3_w1_br u_t020_013/c3_r0_rbl u_t020_013/c3_r1_rbl
+ u_t020_013/r0_w0_wl u_t020_013/r0_w1_wl u_t020_013/r0_r0_rwl u_t020_013/r0_r1_rwl
+ u_t020_013/r1_w0_wl u_t020_013/r1_w1_wl u_t020_013/r1_r0_rwl u_t020_013/r1_r1_rwl
+ u_t020_013/r2_w0_wl u_t020_013/r2_w1_wl u_t020_013/r2_r0_rwl u_t020_013/r2_r1_rwl
+ u_t020_013/r3_w0_wl u_t020_013/r3_w1_wl u_t020_013/r3_r0_rwl u_t020_013/r3_r1_rwl
+ VSS VSS u_t020_013/m2_717_1265# u_t020_013/m2_603_2031# u_t020_013/m2_1290_336#
+ u_t020_013/m2_2000_2037# u_t020_013/m2_791_2909# u_t020_013/m2_7_2126# u_t020_013/m2_2154_2081#
+ u_t020_013/m2_1795_2037# u_t020_013/m2_871_303# u_t020_013/m2_431_438# u_t020_013/m2_1290_2898#
+ u_t020_013/m2_1714_1210# u_t020_013/m2_431_1982# u_t020_013/m2_512_1265# u_t020_013/m2_2573_2126#
+ u_t020_013/m2_603_1259# u_t020_013/m2_2074_2909# u_t020_013/m2_7_336# u_t020_013/m2_717_2037#
+ u_t020_013/m2_1886_2031# u_t020_013/m2_2573_336# u_t020_013/m2_7_2898# u_t020_013/m2_2000_1265#
+ u_t020_013/m2_512_2037# u_t020_013/m2_1795_1265# u_t020_013/m2_1714_1982# u_t020_013/m2_1886_1259#
+ u_t020_013/m2_1290_2126# u_t020_013/m2_1714_438# u_t020_013/m2_431_1210# u_t020_013/m2_2573_2898#
+ u_t020_013/m2_2154_303# u_t020_013/m2_871_2081# VSUBS detronyx_12t_2w2r_rc4_4x4_routed_5layer_direct
Xu_t005_010 u_t005_010/c0_w0_bl u_t005_010/c0_w0_br u_t005_010/c0_w1_bl u_t005_010/c0_w1_br
+ u_t005_010/c0_r0_rbl u_t005_010/c0_r1_rbl u_t005_010/c1_w0_bl u_t005_010/c1_w0_br
+ u_t005_010/c1_w1_bl u_t005_010/c1_w1_br u_t005_010/c1_r0_rbl u_t005_010/c1_r1_rbl
+ u_t005_010/c2_w0_bl u_t005_010/c2_w0_br u_t005_010/c2_w1_bl u_t005_010/c2_w1_br
+ u_t005_010/c2_r0_rbl u_t005_010/c2_r1_rbl u_t005_010/c3_w0_bl u_t005_010/c3_w0_br
+ u_t005_010/c3_w1_bl u_t005_010/c3_w1_br u_t005_010/c3_r0_rbl u_t005_010/c3_r1_rbl
+ u_t005_010/r0_w0_wl u_t005_010/r0_w1_wl u_t005_010/r0_r0_rwl u_t005_010/r0_r1_rwl
+ u_t005_010/r1_w0_wl u_t005_010/r1_w1_wl u_t005_010/r1_r0_rwl u_t005_010/r1_r1_rwl
+ u_t005_010/r2_w0_wl u_t005_010/r2_w1_wl u_t005_010/r2_r0_rwl u_t005_010/r2_r1_rwl
+ u_t005_010/r3_w0_wl u_t005_010/r3_w1_wl u_t005_010/r3_r0_rwl u_t005_010/r3_r1_rwl
+ VSS VSS u_t005_010/m2_717_1265# u_t005_010/m2_603_2031# u_t005_010/m2_1290_336#
+ u_t005_010/m2_2000_2037# u_t005_010/m2_791_2909# u_t005_010/m2_7_2126# u_t005_010/m2_2154_2081#
+ u_t005_010/m2_1795_2037# u_t005_010/m2_871_303# u_t005_010/m2_431_438# u_t005_010/m2_1290_2898#
+ u_t005_010/m2_1714_1210# u_t005_010/m2_431_1982# u_t005_010/m2_512_1265# u_t005_010/m2_2573_2126#
+ u_t005_010/m2_603_1259# u_t005_010/m2_2074_2909# u_t005_010/m2_7_336# u_t005_010/m2_717_2037#
+ u_t005_010/m2_1886_2031# u_t005_010/m2_2573_336# u_t005_010/m2_7_2898# u_t005_010/m2_2000_1265#
+ u_t005_010/m2_512_2037# u_t005_010/m2_1795_1265# u_t005_010/m2_1714_1982# u_t005_010/m2_1886_1259#
+ u_t005_010/m2_1290_2126# u_t005_010/m2_1714_438# u_t005_010/m2_431_1210# u_t005_010/m2_2573_2898#
+ u_t005_010/m2_2154_303# u_t005_010/m2_871_2081# VSUBS detronyx_12t_2w2r_rc4_4x4_routed_5layer_direct
Xu_t020_002 u_t020_002/c0_w0_bl u_t020_002/c0_w0_br u_t020_002/c0_w1_bl u_t020_002/c0_w1_br
+ u_t020_002/c0_r0_rbl u_t020_002/c0_r1_rbl u_t020_002/c1_w0_bl u_t020_002/c1_w0_br
+ u_t020_002/c1_w1_bl u_t020_002/c1_w1_br u_t020_002/c1_r0_rbl u_t020_002/c1_r1_rbl
+ u_t020_002/c2_w0_bl u_t020_002/c2_w0_br u_t020_002/c2_w1_bl u_t020_002/c2_w1_br
+ u_t020_002/c2_r0_rbl u_t020_002/c2_r1_rbl u_t020_002/c3_w0_bl u_t020_002/c3_w0_br
+ u_t020_002/c3_w1_bl u_t020_002/c3_w1_br u_t020_002/c3_r0_rbl u_t020_002/c3_r1_rbl
+ u_t020_002/r0_w0_wl u_t020_002/r0_w1_wl u_t020_002/r0_r0_rwl u_t020_002/r0_r1_rwl
+ u_t020_002/r1_w0_wl u_t020_002/r1_w1_wl u_t020_002/r1_r0_rwl u_t020_002/r1_r1_rwl
+ u_t020_002/r2_w0_wl u_t020_002/r2_w1_wl u_t020_002/r2_r0_rwl u_t020_002/r2_r1_rwl
+ u_t020_002/r3_w0_wl u_t020_002/r3_w1_wl u_t020_002/r3_r0_rwl u_t020_002/r3_r1_rwl
+ VSS VSS u_t020_002/m2_717_1265# u_t020_002/m2_603_2031# u_t020_002/m2_1290_336#
+ u_t020_002/m2_2000_2037# u_t020_002/m2_791_2909# u_t020_002/m2_7_2126# u_t020_002/m2_2154_2081#
+ u_t020_002/m2_1795_2037# u_t020_002/m2_871_303# u_t020_002/m2_431_438# u_t020_002/m2_1290_2898#
+ u_t020_002/m2_1714_1210# u_t020_002/m2_431_1982# u_t020_002/m2_512_1265# u_t020_002/m2_2573_2126#
+ u_t020_002/m2_603_1259# u_t020_002/m2_2074_2909# u_t020_002/m2_7_336# u_t020_002/m2_717_2037#
+ u_t020_002/m2_1886_2031# u_t020_002/m2_2573_336# u_t020_002/m2_7_2898# u_t020_002/m2_2000_1265#
+ u_t020_002/m2_512_2037# u_t020_002/m2_1795_1265# u_t020_002/m2_1714_1982# u_t020_002/m2_1886_1259#
+ u_t020_002/m2_1290_2126# u_t020_002/m2_1714_438# u_t020_002/m2_431_1210# u_t020_002/m2_2573_2898#
+ u_t020_002/m2_2154_303# u_t020_002/m2_871_2081# VSUBS detronyx_12t_2w2r_rc4_4x4_routed_5layer_direct
Xgf180mcu_as_sc_mcu7t3v3__inv_2_1406 VSS VSS gf180mcu_as_sc_mcu7t3v3__inv_2_1406/Y
+ gf180mcu_as_sc_mcu7t3v3__inv_2_1406/A gf180mcu_as_sc_mcu7t3v3__inv_2_1406/VNW VSUBS
+ gf180mcu_as_sc_mcu7t3v3__inv_2
Xgf180mcu_as_sc_mcu7t3v3__inv_2_1417 VSS VSS VSS gf180mcu_as_sc_mcu7t3v3__inv_2_1418/Y
+ gf180mcu_as_sc_mcu7t3v3__inv_2_1419/VNW VSUBS gf180mcu_as_sc_mcu7t3v3__inv_2
Xgf180mcu_as_sc_mcu7t3v3__inv_2_1439 VSS VSS gf180mcu_as_sc_mcu7t3v3__inv_2_1439/Y
+ gf180mcu_as_sc_mcu7t3v3__inv_2_1440/Y gf180mcu_as_sc_mcu7t3v3__inv_2_1440/VNW VSUBS
+ gf180mcu_as_sc_mcu7t3v3__inv_2
Xgf180mcu_as_sc_mcu7t3v3__inv_2_1428 VSS VSS gf180mcu_as_sc_mcu7t3v3__inv_2_1428/Y
+ gf180mcu_as_sc_mcu7t3v3__inv_2_1428/A gf180mcu_as_sc_mcu7t3v3__inv_2_1428/VNW VSUBS
+ gf180mcu_as_sc_mcu7t3v3__inv_2
Xu_t011_013 u_t011_013/c0_w0_bl u_t011_013/c0_w0_br u_t011_013/c0_w1_bl u_t011_013/c0_w1_br
+ u_t011_013/c0_r0_rbl u_t011_013/c0_r1_rbl u_t011_013/c1_w0_bl u_t011_013/c1_w0_br
+ u_t011_013/c1_w1_bl u_t011_013/c1_w1_br u_t011_013/c1_r0_rbl u_t011_013/c1_r1_rbl
+ u_t011_013/c2_w0_bl u_t011_013/c2_w0_br u_t011_013/c2_w1_bl u_t011_013/c2_w1_br
+ u_t011_013/c2_r0_rbl u_t011_013/c2_r1_rbl u_t011_013/c3_w0_bl u_t011_013/c3_w0_br
+ u_t011_013/c3_w1_bl u_t011_013/c3_w1_br u_t011_013/c3_r0_rbl u_t011_013/c3_r1_rbl
+ u_t011_013/r0_w0_wl u_t011_013/r0_w1_wl u_t011_013/r0_r0_rwl u_t011_013/r0_r1_rwl
+ u_t011_013/r1_w0_wl u_t011_013/r1_w1_wl u_t011_013/r1_r0_rwl u_t011_013/r1_r1_rwl
+ u_t011_013/r2_w0_wl u_t011_013/r2_w1_wl u_t011_013/r2_r0_rwl u_t011_013/r2_r1_rwl
+ u_t011_013/r3_w0_wl u_t011_013/r3_w1_wl u_t011_013/r3_r0_rwl u_t011_013/r3_r1_rwl
+ VSS VSS u_t011_013/m2_717_1265# u_t011_013/m2_603_2031# u_t011_013/m2_1290_336#
+ u_t011_013/m2_2000_2037# u_t011_013/m2_791_2909# u_t011_013/m2_7_2126# u_t011_013/m2_2154_2081#
+ u_t011_013/m2_1795_2037# u_t011_013/m2_871_303# u_t011_013/m2_431_438# u_t011_013/m2_1290_2898#
+ u_t011_013/m2_1714_1210# u_t011_013/m2_431_1982# u_t011_013/m2_512_1265# u_t011_013/m2_2573_2126#
+ u_t011_013/m2_603_1259# u_t011_013/m2_2074_2909# u_t011_013/m2_7_336# u_t011_013/m2_717_2037#
+ u_t011_013/m2_1886_2031# u_t011_013/m2_2573_336# u_t011_013/m2_7_2898# u_t011_013/m2_2000_1265#
+ u_t011_013/m2_512_2037# u_t011_013/m2_1795_1265# u_t011_013/m2_1714_1982# u_t011_013/m2_1886_1259#
+ u_t011_013/m2_1290_2126# u_t011_013/m2_1714_438# u_t011_013/m2_431_1210# u_t011_013/m2_2573_2898#
+ u_t011_013/m2_2154_303# u_t011_013/m2_871_2081# VSUBS detronyx_12t_2w2r_rc4_4x4_routed_5layer_direct
Xu_t011_002 u_t011_002/c0_w0_bl u_t011_002/c0_w0_br u_t011_002/c0_w1_bl u_t011_002/c0_w1_br
+ u_t011_002/c0_r0_rbl u_t011_002/c0_r1_rbl u_t011_002/c1_w0_bl u_t011_002/c1_w0_br
+ u_t011_002/c1_w1_bl u_t011_002/c1_w1_br u_t011_002/c1_r0_rbl u_t011_002/c1_r1_rbl
+ u_t011_002/c2_w0_bl u_t011_002/c2_w0_br u_t011_002/c2_w1_bl u_t011_002/c2_w1_br
+ u_t011_002/c2_r0_rbl u_t011_002/c2_r1_rbl u_t011_002/c3_w0_bl u_t011_002/c3_w0_br
+ u_t011_002/c3_w1_bl u_t011_002/c3_w1_br u_t011_002/c3_r0_rbl u_t011_002/c3_r1_rbl
+ u_t011_002/r0_w0_wl u_t011_002/r0_w1_wl u_t011_002/r0_r0_rwl u_t011_002/r0_r1_rwl
+ u_t011_002/r1_w0_wl u_t011_002/r1_w1_wl u_t011_002/r1_r0_rwl u_t011_002/r1_r1_rwl
+ u_t011_002/r2_w0_wl u_t011_002/r2_w1_wl u_t011_002/r2_r0_rwl u_t011_002/r2_r1_rwl
+ u_t011_002/r3_w0_wl u_t011_002/r3_w1_wl u_t011_002/r3_r0_rwl u_t011_002/r3_r1_rwl
+ VSS VSS u_t011_002/m2_717_1265# u_t011_002/m2_603_2031# u_t011_002/m2_1290_336#
+ u_t011_002/m2_2000_2037# u_t011_002/m2_791_2909# u_t011_002/m2_7_2126# u_t011_002/m2_2154_2081#
+ u_t011_002/m2_1795_2037# u_t011_002/m2_871_303# u_t011_002/m2_431_438# u_t011_002/m2_1290_2898#
+ u_t011_002/m2_1714_1210# u_t011_002/m2_431_1982# u_t011_002/m2_512_1265# u_t011_002/m2_2573_2126#
+ u_t011_002/m2_603_1259# u_t011_002/m2_2074_2909# u_t011_002/m2_7_336# u_t011_002/m2_717_2037#
+ u_t011_002/m2_1886_2031# u_t011_002/m2_2573_336# u_t011_002/m2_7_2898# u_t011_002/m2_2000_1265#
+ u_t011_002/m2_512_2037# u_t011_002/m2_1795_1265# u_t011_002/m2_1714_1982# u_t011_002/m2_1886_1259#
+ u_t011_002/m2_1290_2126# u_t011_002/m2_1714_438# u_t011_002/m2_431_1210# u_t011_002/m2_2573_2898#
+ u_t011_002/m2_2154_303# u_t011_002/m2_871_2081# VSUBS detronyx_12t_2w2r_rc4_4x4_routed_5layer_direct
Xu_t002_013 u_t002_013/c0_w0_bl u_t002_013/c0_w0_br u_t002_013/c0_w1_bl u_t002_013/c0_w1_br
+ u_t002_013/c0_r0_rbl u_t002_013/c0_r1_rbl u_t002_013/c1_w0_bl u_t002_013/c1_w0_br
+ u_t002_013/c1_w1_bl u_t002_013/c1_w1_br u_t002_013/c1_r0_rbl u_t002_013/c1_r1_rbl
+ u_t002_013/c2_w0_bl u_t002_013/c2_w0_br u_t002_013/c2_w1_bl u_t002_013/c2_w1_br
+ u_t002_013/c2_r0_rbl u_t002_013/c2_r1_rbl u_t002_013/c3_w0_bl u_t002_013/c3_w0_br
+ u_t002_013/c3_w1_bl u_t002_013/c3_w1_br u_t002_013/c3_r0_rbl u_t002_013/c3_r1_rbl
+ u_t002_013/r0_w0_wl u_t002_013/r0_w1_wl u_t002_013/r0_r0_rwl u_t002_013/r0_r1_rwl
+ u_t002_013/r1_w0_wl u_t002_013/r1_w1_wl u_t002_013/r1_r0_rwl u_t002_013/r1_r1_rwl
+ u_t002_013/r2_w0_wl u_t002_013/r2_w1_wl u_t002_013/r2_r0_rwl u_t002_013/r2_r1_rwl
+ u_t002_013/r3_w0_wl u_t002_013/r3_w1_wl u_t002_013/r3_r0_rwl u_t002_013/r3_r1_rwl
+ VSS VSS u_t002_013/m2_717_1265# u_t002_013/m2_603_2031# u_t002_013/m2_1290_336#
+ u_t002_013/m2_2000_2037# u_t002_013/m2_791_2909# u_t002_013/m2_7_2126# u_t002_013/m2_2154_2081#
+ u_t002_013/m2_1795_2037# u_t002_013/m2_871_303# u_t002_013/m2_431_438# u_t002_013/m2_1290_2898#
+ u_t002_013/m2_1714_1210# u_t002_013/m2_431_1982# u_t002_013/m2_512_1265# u_t002_013/m2_2573_2126#
+ u_t002_013/m2_603_1259# u_t002_013/m2_2074_2909# u_t002_013/m2_7_336# u_t002_013/m2_717_2037#
+ u_t002_013/m2_1886_2031# u_t002_013/m2_2573_336# u_t002_013/m2_7_2898# u_t002_013/m2_2000_1265#
+ u_t002_013/m2_512_2037# u_t002_013/m2_1795_1265# u_t002_013/m2_1714_1982# u_t002_013/m2_1886_1259#
+ u_t002_013/m2_1290_2126# u_t002_013/m2_1714_438# u_t002_013/m2_431_1210# u_t002_013/m2_2573_2898#
+ u_t002_013/m2_2154_303# u_t002_013/m2_871_2081# VSUBS detronyx_12t_2w2r_rc4_4x4_routed_5layer_direct
Xu_t002_002 u_t002_002/c0_w0_bl u_t002_002/c0_w0_br u_t002_002/c0_w1_bl u_t002_002/c0_w1_br
+ u_t002_002/c0_r0_rbl u_t002_002/c0_r1_rbl u_t002_002/c1_w0_bl u_t002_002/c1_w0_br
+ u_t002_002/c1_w1_bl u_t002_002/c1_w1_br u_t002_002/c1_r0_rbl u_t002_002/c1_r1_rbl
+ u_t002_002/c2_w0_bl u_t002_002/c2_w0_br u_t002_002/c2_w1_bl u_t002_002/c2_w1_br
+ u_t002_002/c2_r0_rbl u_t002_002/c2_r1_rbl u_t002_002/c3_w0_bl u_t002_002/c3_w0_br
+ u_t002_002/c3_w1_bl u_t002_002/c3_w1_br u_t002_002/c3_r0_rbl u_t002_002/c3_r1_rbl
+ u_t002_002/r0_w0_wl u_t002_002/r0_w1_wl u_t002_002/r0_r0_rwl u_t002_002/r0_r1_rwl
+ u_t002_002/r1_w0_wl u_t002_002/r1_w1_wl u_t002_002/r1_r0_rwl u_t002_002/r1_r1_rwl
+ u_t002_002/r2_w0_wl u_t002_002/r2_w1_wl u_t002_002/r2_r0_rwl u_t002_002/r2_r1_rwl
+ u_t002_002/r3_w0_wl u_t002_002/r3_w1_wl u_t002_002/r3_r0_rwl u_t002_002/r3_r1_rwl
+ VSS VSS u_t002_002/m2_717_1265# u_t002_002/m2_603_2031# u_t002_002/m2_1290_336#
+ u_t002_002/m2_2000_2037# u_t002_002/m2_791_2909# u_t002_002/m2_7_2126# u_t002_002/m2_2154_2081#
+ u_t002_002/m2_1795_2037# u_t002_002/m2_871_303# u_t002_002/m2_431_438# u_t002_002/m2_1290_2898#
+ u_t002_002/m2_1714_1210# u_t002_002/m2_431_1982# u_t002_002/m2_512_1265# u_t002_002/m2_2573_2126#
+ u_t002_002/m2_603_1259# u_t002_002/m2_2074_2909# u_t002_002/m2_7_336# u_t002_002/m2_717_2037#
+ u_t002_002/m2_1886_2031# u_t002_002/m2_2573_336# u_t002_002/m2_7_2898# u_t002_002/m2_2000_1265#
+ u_t002_002/m2_512_2037# u_t002_002/m2_1795_1265# u_t002_002/m2_1714_1982# u_t002_002/m2_1886_1259#
+ u_t002_002/m2_1290_2126# u_t002_002/m2_1714_438# u_t002_002/m2_431_1210# u_t002_002/m2_2573_2898#
+ u_t002_002/m2_2154_303# u_t002_002/m2_871_2081# VSUBS detronyx_12t_2w2r_rc4_4x4_routed_5layer_direct
Xgf180mcu_as_sc_mcu7t3v3__inv_2_1269 gf180mcu_as_sc_mcu7t3v3__nor2_2_9/VDD gf180mcu_as_sc_mcu7t3v3__nor2_2_9/VSS
+ VSS VSS gf180mcu_as_sc_mcu7t3v3__nor2_2_9/VNW VSUBS gf180mcu_as_sc_mcu7t3v3__inv_2
Xgf180mcu_as_sc_mcu7t3v3__inv_2_1258 gf180mcu_as_sc_mcu7t3v3__nand3_2_65/VDD gf180mcu_as_sc_mcu7t3v3__nor2_2_9/VSS
+ VSS VSS gf180mcu_as_sc_mcu7t3v3__nand3_2_65/VNW VSUBS gf180mcu_as_sc_mcu7t3v3__inv_2
Xgf180mcu_as_sc_mcu7t3v3__inv_2_1203 gf180mcu_as_sc_mcu7t3v3__nand3_2_65/VDD gf180mcu_as_sc_mcu7t3v3__nor2_2_9/VSS
+ VSS VSS gf180mcu_as_sc_mcu7t3v3__nand3_2_65/VNW VSUBS gf180mcu_as_sc_mcu7t3v3__inv_2
Xgf180mcu_as_sc_mcu7t3v3__inv_2_1247 gf180mcu_as_sc_mcu7t3v3__nand3_2_65/VDD gf180mcu_as_sc_mcu7t3v3__nand3_2_62/VSS
+ VSS VSS gf180mcu_as_sc_mcu7t3v3__nand3_2_65/VNW VSUBS gf180mcu_as_sc_mcu7t3v3__inv_2
Xgf180mcu_as_sc_mcu7t3v3__inv_2_1236 gf180mcu_as_sc_mcu7t3v3__nand3_2_65/VDD gf180mcu_as_sc_mcu7t3v3__nand3_2_62/VSS
+ VSS VSS gf180mcu_as_sc_mcu7t3v3__nand3_2_65/VNW VSUBS gf180mcu_as_sc_mcu7t3v3__inv_2
Xgf180mcu_as_sc_mcu7t3v3__inv_2_1225 VSS VSS gf180mcu_as_sc_mcu7t3v3__inv_2_1282/A
+ gf180mcu_as_sc_mcu7t3v3__inv_2_1228/Y gf180mcu_as_sc_mcu7t3v3__inv_2_1282/VNW VSUBS
+ gf180mcu_as_sc_mcu7t3v3__inv_2
Xgf180mcu_as_sc_mcu7t3v3__inv_2_1214 VSS VSS gf180mcu_as_sc_mcu7t3v3__inv_2_1283/A
+ gf180mcu_as_sc_mcu7t3v3__inv_2_1222/Y gf180mcu_as_sc_mcu7t3v3__inv_2_1283/VNW VSUBS
+ gf180mcu_as_sc_mcu7t3v3__inv_2
Xgf180mcu_as_sc_mcu7t3v3__inv_2_709 VSS VSS VSS gf180mcu_as_sc_mcu7t3v3__inv_2_713/Y
+ gf180mcu_as_sc_mcu7t3v3__inv_2_717/VNW VSUBS gf180mcu_as_sc_mcu7t3v3__inv_2
Xgf180mcu_as_sc_mcu7t3v3__inv_2_30 VSS VSS VSS gf180mcu_as_sc_mcu7t3v3__inv_2_31/Y
+ gf180mcu_as_sc_mcu7t3v3__inv_2_32/VNW VSUBS gf180mcu_as_sc_mcu7t3v3__inv_2
Xgf180mcu_as_sc_mcu7t3v3__inv_2_41 VSS VSS gf180mcu_as_sc_mcu7t3v3__inv_2_41/Y gf180mcu_as_sc_mcu7t3v3__inv_2_42/Y
+ gf180mcu_as_sc_mcu7t3v3__inv_2_42/VNW VSUBS gf180mcu_as_sc_mcu7t3v3__inv_2
Xgf180mcu_as_sc_mcu7t3v3__inv_2_52 VSS VSS gf180mcu_as_sc_mcu7t3v3__inv_2_52/Y gf180mcu_as_sc_mcu7t3v3__inv_2_53/Y
+ gf180mcu_as_sc_mcu7t3v3__inv_2_53/VNW VSUBS gf180mcu_as_sc_mcu7t3v3__inv_2
Xgf180mcu_as_sc_mcu7t3v3__inv_2_1066 VSS VSS gf180mcu_as_sc_mcu7t3v3__inv_2_1066/Y
+ gf180mcu_as_sc_mcu7t3v3__inv_2_1067/Y gf180mcu_as_sc_mcu7t3v3__inv_2_1067/VNW VSUBS
+ gf180mcu_as_sc_mcu7t3v3__inv_2
Xgf180mcu_as_sc_mcu7t3v3__inv_2_1077 VSS VSS VSS gf180mcu_as_sc_mcu7t3v3__inv_2_1078/Y
+ gf180mcu_as_sc_mcu7t3v3__inv_2_1079/VNW VSUBS gf180mcu_as_sc_mcu7t3v3__inv_2
Xgf180mcu_as_sc_mcu7t3v3__inv_2_1099 VSS VSS gf180mcu_as_sc_mcu7t3v3__inv_2_1099/Y
+ gf180mcu_as_sc_mcu7t3v3__inv_2_1099/A gf180mcu_as_sc_mcu7t3v3__inv_2_1099/VNW VSUBS
+ gf180mcu_as_sc_mcu7t3v3__inv_2
Xgf180mcu_as_sc_mcu7t3v3__inv_2_1088 VSS VSS VSS gf180mcu_as_sc_mcu7t3v3__inv_2_1092/Y
+ gf180mcu_as_sc_mcu7t3v3__inv_2_1096/VNW VSUBS gf180mcu_as_sc_mcu7t3v3__inv_2
Xgf180mcu_as_sc_mcu7t3v3__inv_2_1011 VSS VSS gf180mcu_as_sc_mcu7t3v3__inv_2_1011/Y
+ gf180mcu_as_sc_mcu7t3v3__inv_2_1012/Y gf180mcu_as_sc_mcu7t3v3__inv_2_1012/VNW VSUBS
+ gf180mcu_as_sc_mcu7t3v3__inv_2
Xgf180mcu_as_sc_mcu7t3v3__inv_2_1033 VSS VSS gf180mcu_as_sc_mcu7t3v3__inv_2_1033/Y
+ gf180mcu_as_sc_mcu7t3v3__inv_2_1037/Y gf180mcu_as_sc_mcu7t3v3__inv_2_1037/VNW VSUBS
+ gf180mcu_as_sc_mcu7t3v3__inv_2
Xgf180mcu_as_sc_mcu7t3v3__inv_2_1044 VSS VSS gf180mcu_as_sc_mcu7t3v3__inv_2_1044/Y
+ gf180mcu_as_sc_mcu7t3v3__inv_2_1044/A gf180mcu_as_sc_mcu7t3v3__inv_2_1044/VNW VSUBS
+ gf180mcu_as_sc_mcu7t3v3__inv_2
Xgf180mcu_as_sc_mcu7t3v3__inv_2_1055 VSS VSS gf180mcu_as_sc_mcu7t3v3__inv_2_1055/Y
+ gf180mcu_as_sc_mcu7t3v3__inv_2_1056/Y gf180mcu_as_sc_mcu7t3v3__inv_2_1056/VNW VSUBS
+ gf180mcu_as_sc_mcu7t3v3__inv_2
Xgf180mcu_as_sc_mcu7t3v3__inv_2_85 VSS VSS gf180mcu_as_sc_mcu7t3v3__inv_2_85/Y gf180mcu_as_sc_mcu7t3v3__inv_2_85/A
+ gf180mcu_as_sc_mcu7t3v3__inv_2_91/VNW VSUBS gf180mcu_as_sc_mcu7t3v3__inv_2
Xgf180mcu_as_sc_mcu7t3v3__inv_2_96 VSS VSS gf180mcu_as_sc_mcu7t3v3__inv_2_96/Y gf180mcu_as_sc_mcu7t3v3__inv_2_97/Y
+ gf180mcu_as_sc_mcu7t3v3__inv_2_97/VNW VSUBS gf180mcu_as_sc_mcu7t3v3__inv_2
Xgf180mcu_as_sc_mcu7t3v3__inv_2_74 VSS VSS gf180mcu_as_sc_mcu7t3v3__inv_2_74/Y gf180mcu_as_sc_mcu7t3v3__inv_2_0/Y
+ gf180mcu_as_sc_mcu7t3v3__inv_2_0/VNW VSUBS gf180mcu_as_sc_mcu7t3v3__inv_2
Xgf180mcu_as_sc_mcu7t3v3__inv_2_63 VSS VSS VSS gf180mcu_as_sc_mcu7t3v3__inv_2_64/Y
+ gf180mcu_as_sc_mcu7t3v3__inv_2_65/VNW VSUBS gf180mcu_as_sc_mcu7t3v3__inv_2
Xgf180mcu_as_sc_mcu7t3v3__inv_2_1000 VSS VSS gf180mcu_as_sc_mcu7t3v3__inv_2_999/A
+ gf180mcu_as_sc_mcu7t3v3__inv_2_1000/A gf180mcu_as_sc_mcu7t3v3__inv_2_999/VNW VSUBS
+ gf180mcu_as_sc_mcu7t3v3__inv_2
Xgf180mcu_as_sc_mcu7t3v3__inv_2_1022 VSS VSS VSS gf180mcu_as_sc_mcu7t3v3__inv_2_1023/Y
+ gf180mcu_as_sc_mcu7t3v3__inv_2_1024/VNW VSUBS gf180mcu_as_sc_mcu7t3v3__inv_2
Xgf180mcu_as_sc_mcu7t3v3__inv_2_528 gf180mcu_as_sc_mcu7t3v3__nand3_2_9/VDD gf180mcu_as_sc_mcu7t3v3__nor2_2_7/VSS
+ VSS VSS gf180mcu_as_sc_mcu7t3v3__nand3_2_9/VNW VSUBS gf180mcu_as_sc_mcu7t3v3__inv_2
Xgf180mcu_as_sc_mcu7t3v3__inv_2_517 VSS VSS gf180mcu_as_sc_mcu7t3v3__inv_2_517/Y gf180mcu_as_sc_mcu7t3v3__inv_2_517/A
+ gf180mcu_as_sc_mcu7t3v3__inv_2_559/VNW VSUBS gf180mcu_as_sc_mcu7t3v3__inv_2
Xgf180mcu_as_sc_mcu7t3v3__inv_2_539 VSS VSS VSS gf180mcu_as_sc_mcu7t3v3__inv_2_539/A
+ gf180mcu_as_sc_mcu7t3v3__inv_2_539/VNW VSUBS gf180mcu_as_sc_mcu7t3v3__inv_2
Xgf180mcu_as_sc_mcu7t3v3__inv_2_506 VSS VSS gf180mcu_as_sc_mcu7t3v3__inv_2_538/A gf180mcu_as_sc_mcu7t3v3__inv_2_507/Y
+ gf180mcu_as_sc_mcu7t3v3__inv_2_538/VNW VSUBS gf180mcu_as_sc_mcu7t3v3__inv_2
Xgf180mcu_as_sc_mcu7t3v3__nand3_2_0 gf180mcu_as_sc_mcu7t3v3__nor2_2_6/VDD gf180mcu_as_sc_mcu7t3v3__nand3_2_4/VSS
+ VSS VSS VSS VSS gf180mcu_as_sc_mcu7t3v3__nor2_2_6/VNW VSUBS gf180mcu_as_sc_mcu7t3v3__nand3_2
Xgf180mcu_as_sc_mcu7t3v3__nand4_2_372 VSS VSS VSS VSS VSS VSS gf180mcu_as_sc_mcu7t3v3__inv_2_1219/A
+ gf180mcu_as_sc_mcu7t3v3__inv_2_1274/VNW VSUBS gf180mcu_as_sc_mcu7t3v3__nand4_2
Xgf180mcu_as_sc_mcu7t3v3__nand4_2_361 VSS VSS VSS VSS VSS VSS gf180mcu_as_sc_mcu7t3v3__inv_2_1177/A
+ gf180mcu_as_sc_mcu7t3v3__inv_2_1296/VNW VSUBS gf180mcu_as_sc_mcu7t3v3__nand4_2
Xgf180mcu_as_sc_mcu7t3v3__nand4_2_350 VSS VSS VSS VSS VSS VSS gf180mcu_as_sc_mcu7t3v3__inv_2_1155/A
+ gf180mcu_as_sc_mcu7t3v3__inv_2_1298/VNW VSUBS gf180mcu_as_sc_mcu7t3v3__nand4_2
Xgf180mcu_as_sc_mcu7t3v3__nand4_2_383 VSS VSS VSS VSS VSS VSS gf180mcu_as_sc_mcu7t3v3__inv_2_1419/A
+ gf180mcu_as_sc_mcu7t3v3__inv_2_1419/VNW VSUBS gf180mcu_as_sc_mcu7t3v3__nand4_2
Xgf180mcu_as_sc_mcu7t3v3__nand4_2_394 VSS VSS VSS VSS VSS VSS gf180mcu_as_sc_mcu7t3v3__inv_2_1452/A
+ gf180mcu_as_sc_mcu7t3v3__inv_2_1452/VNW VSUBS gf180mcu_as_sc_mcu7t3v3__nand4_2
Xgf180mcu_as_sc_mcu7t3v3__inv_2_369 VSS VSS VSS gf180mcu_as_sc_mcu7t3v3__inv_2_370/Y
+ gf180mcu_as_sc_mcu7t3v3__inv_2_371/VNW VSUBS gf180mcu_as_sc_mcu7t3v3__inv_2
Xgf180mcu_as_sc_mcu7t3v3__inv_2_303 VSS VSS VSS gf180mcu_as_sc_mcu7t3v3__inv_2_303/A
+ gf180mcu_as_sc_mcu7t3v3__inv_2_303/VNW VSUBS gf180mcu_as_sc_mcu7t3v3__inv_2
Xgf180mcu_as_sc_mcu7t3v3__inv_2_358 VSS VSS gf180mcu_as_sc_mcu7t3v3__inv_2_358/Y gf180mcu_as_sc_mcu7t3v3__inv_2_359/Y
+ gf180mcu_as_sc_mcu7t3v3__inv_2_359/VNW VSUBS gf180mcu_as_sc_mcu7t3v3__inv_2
Xgf180mcu_as_sc_mcu7t3v3__inv_2_347 VSS VSS gf180mcu_as_sc_mcu7t3v3__inv_2_347/Y gf180mcu_as_sc_mcu7t3v3__inv_2_347/A
+ gf180mcu_as_sc_mcu7t3v3__inv_2_347/VNW VSUBS gf180mcu_as_sc_mcu7t3v3__inv_2
Xgf180mcu_as_sc_mcu7t3v3__inv_2_336 VSS VSS VSS gf180mcu_as_sc_mcu7t3v3__inv_2_337/Y
+ gf180mcu_as_sc_mcu7t3v3__inv_2_338/VNW VSUBS gf180mcu_as_sc_mcu7t3v3__inv_2
Xgf180mcu_as_sc_mcu7t3v3__inv_2_325 VSS VSS gf180mcu_as_sc_mcu7t3v3__inv_2_325/Y gf180mcu_as_sc_mcu7t3v3__inv_2_326/Y
+ gf180mcu_as_sc_mcu7t3v3__inv_2_326/VNW VSUBS gf180mcu_as_sc_mcu7t3v3__inv_2
Xgf180mcu_as_sc_mcu7t3v3__inv_2_314 VSS VSS gf180mcu_as_sc_mcu7t3v3__inv_2_314/Y gf180mcu_as_sc_mcu7t3v3__inv_2_314/A
+ gf180mcu_as_sc_mcu7t3v3__inv_2_314/VNW VSUBS gf180mcu_as_sc_mcu7t3v3__inv_2
Xu_t027_008 u_t027_008/c0_w0_bl u_t027_008/c0_w0_br u_t027_008/c0_w1_bl u_t027_008/c0_w1_br
+ u_t027_008/c0_r0_rbl u_t027_008/c0_r1_rbl u_t027_008/c1_w0_bl u_t027_008/c1_w0_br
+ u_t027_008/c1_w1_bl u_t027_008/c1_w1_br u_t027_008/c1_r0_rbl u_t027_008/c1_r1_rbl
+ u_t027_008/c2_w0_bl u_t027_008/c2_w0_br u_t027_008/c2_w1_bl u_t027_008/c2_w1_br
+ u_t027_008/c2_r0_rbl u_t027_008/c2_r1_rbl u_t027_008/c3_w0_bl u_t027_008/c3_w0_br
+ u_t027_008/c3_w1_bl u_t027_008/c3_w1_br u_t027_008/c3_r0_rbl u_t027_008/c3_r1_rbl
+ u_t027_008/r0_w0_wl u_t027_008/r0_w1_wl u_t027_008/r0_r0_rwl u_t027_008/r0_r1_rwl
+ u_t027_008/r1_w0_wl u_t027_008/r1_w1_wl u_t027_008/r1_r0_rwl u_t027_008/r1_r1_rwl
+ u_t027_008/r2_w0_wl u_t027_008/r2_w1_wl u_t027_008/r2_r0_rwl u_t027_008/r2_r1_rwl
+ u_t027_008/r3_w0_wl u_t027_008/r3_w1_wl u_t027_008/r3_r0_rwl u_t027_008/r3_r1_rwl
+ VSS VSS u_t027_008/m2_717_1265# u_t027_008/m2_603_2031# u_t027_008/m2_1290_336#
+ u_t027_008/m2_2000_2037# u_t027_008/m2_791_2909# u_t027_008/m2_7_2126# u_t027_008/m2_2154_2081#
+ u_t027_008/m2_1795_2037# u_t027_008/m2_871_303# u_t027_008/m2_431_438# u_t027_008/m2_1290_2898#
+ u_t027_008/m2_1714_1210# u_t027_008/m2_431_1982# u_t027_008/m2_512_1265# u_t027_008/m2_2573_2126#
+ u_t027_008/m2_603_1259# u_t027_008/m2_2074_2909# u_t027_008/m2_7_336# u_t027_008/m2_717_2037#
+ u_t027_008/m2_1886_2031# u_t027_008/m2_2573_336# u_t027_008/m2_7_2898# u_t027_008/m2_2000_1265#
+ u_t027_008/m2_512_2037# u_t027_008/m2_1795_1265# u_t027_008/m2_1714_1982# u_t027_008/m2_1886_1259#
+ u_t027_008/m2_1290_2126# u_t027_008/m2_1714_438# u_t027_008/m2_431_1210# u_t027_008/m2_2573_2898#
+ u_t027_008/m2_2154_303# u_t027_008/m2_871_2081# VSUBS detronyx_12t_2w2r_rc4_4x4_routed_5layer_direct
Xgf180mcu_as_sc_mcu7t3v3__inv_2_881 VSS VSS gf180mcu_as_sc_mcu7t3v3__inv_2_933/A gf180mcu_as_sc_mcu7t3v3__inv_2_882/Y
+ gf180mcu_as_sc_mcu7t3v3__inv_2_933/VNW VSUBS gf180mcu_as_sc_mcu7t3v3__inv_2
Xgf180mcu_as_sc_mcu7t3v3__inv_2_870 VSS VSS gf180mcu_as_sc_mcu7t3v3__inv_2_929/A gf180mcu_as_sc_mcu7t3v3__inv_2_871/Y
+ gf180mcu_as_sc_mcu7t3v3__inv_2_929/VNW VSUBS gf180mcu_as_sc_mcu7t3v3__inv_2
Xgf180mcu_as_sc_mcu7t3v3__inv_2_892 VSS VSS gf180mcu_as_sc_mcu7t3v3__inv_2_925/A gf180mcu_as_sc_mcu7t3v3__inv_2_893/Y
+ gf180mcu_as_sc_mcu7t3v3__inv_2_925/VNW VSUBS gf180mcu_as_sc_mcu7t3v3__inv_2
Xu_t018_008 u_t018_008/c0_w0_bl u_t018_008/c0_w0_br u_t018_008/c0_w1_bl u_t018_008/c0_w1_br
+ u_t018_008/c0_r0_rbl u_t018_008/c0_r1_rbl u_t018_008/c1_w0_bl u_t018_008/c1_w0_br
+ u_t018_008/c1_w1_bl u_t018_008/c1_w1_br u_t018_008/c1_r0_rbl u_t018_008/c1_r1_rbl
+ u_t018_008/c2_w0_bl u_t018_008/c2_w0_br u_t018_008/c2_w1_bl u_t018_008/c2_w1_br
+ u_t018_008/c2_r0_rbl u_t018_008/c2_r1_rbl u_t018_008/c3_w0_bl u_t018_008/c3_w0_br
+ u_t018_008/c3_w1_bl u_t018_008/c3_w1_br u_t018_008/c3_r0_rbl u_t018_008/c3_r1_rbl
+ u_t018_008/r0_w0_wl u_t018_008/r0_w1_wl u_t018_008/r0_r0_rwl u_t018_008/r0_r1_rwl
+ u_t018_008/r1_w0_wl u_t018_008/r1_w1_wl u_t018_008/r1_r0_rwl u_t018_008/r1_r1_rwl
+ u_t018_008/r2_w0_wl u_t018_008/r2_w1_wl u_t018_008/r2_r0_rwl u_t018_008/r2_r1_rwl
+ u_t018_008/r3_w0_wl u_t018_008/r3_w1_wl u_t018_008/r3_r0_rwl u_t018_008/r3_r1_rwl
+ VSS VSS u_t018_008/m2_717_1265# u_t018_008/m2_603_2031# u_t018_008/m2_1290_336#
+ u_t018_008/m2_2000_2037# u_t018_008/m2_791_2909# u_t018_008/m2_7_2126# u_t018_008/m2_2154_2081#
+ u_t018_008/m2_1795_2037# u_t018_008/m2_871_303# u_t018_008/m2_431_438# u_t018_008/m2_1290_2898#
+ u_t018_008/m2_1714_1210# u_t018_008/m2_431_1982# u_t018_008/m2_512_1265# u_t018_008/m2_2573_2126#
+ u_t018_008/m2_603_1259# u_t018_008/m2_2074_2909# u_t018_008/m2_7_336# u_t018_008/m2_717_2037#
+ u_t018_008/m2_1886_2031# u_t018_008/m2_2573_336# u_t018_008/m2_7_2898# u_t018_008/m2_2000_1265#
+ u_t018_008/m2_512_2037# u_t018_008/m2_1795_1265# u_t018_008/m2_1714_1982# u_t018_008/m2_1886_1259#
+ u_t018_008/m2_1290_2126# u_t018_008/m2_1714_438# u_t018_008/m2_431_1210# u_t018_008/m2_2573_2898#
+ u_t018_008/m2_2154_303# u_t018_008/m2_871_2081# VSUBS detronyx_12t_2w2r_rc4_4x4_routed_5layer_direct
Xgf180mcu_as_sc_mcu7t3v3__nand4_2_180 VSS VSS VSS VSS VSS VSS gf180mcu_as_sc_mcu7t3v3__inv_2_650/A
+ gf180mcu_as_sc_mcu7t3v3__inv_2_650/VNW VSUBS gf180mcu_as_sc_mcu7t3v3__nand4_2
Xgf180mcu_as_sc_mcu7t3v3__nand4_2_191 VSS VSS VSS VSS VSS VSS gf180mcu_as_sc_mcu7t3v3__inv_2_736/A
+ gf180mcu_as_sc_mcu7t3v3__inv_2_736/VNW VSUBS gf180mcu_as_sc_mcu7t3v3__nand4_2
Xu_t009_008 u_t009_008/c0_w0_bl u_t009_008/c0_w0_br u_t009_008/c0_w1_bl u_t009_008/c0_w1_br
+ u_t009_008/c0_r0_rbl u_t009_008/c0_r1_rbl u_t009_008/c1_w0_bl u_t009_008/c1_w0_br
+ u_t009_008/c1_w1_bl u_t009_008/c1_w1_br u_t009_008/c1_r0_rbl u_t009_008/c1_r1_rbl
+ u_t009_008/c2_w0_bl u_t009_008/c2_w0_br u_t009_008/c2_w1_bl u_t009_008/c2_w1_br
+ u_t009_008/c2_r0_rbl u_t009_008/c2_r1_rbl u_t009_008/c3_w0_bl u_t009_008/c3_w0_br
+ u_t009_008/c3_w1_bl u_t009_008/c3_w1_br u_t009_008/c3_r0_rbl u_t009_008/c3_r1_rbl
+ u_t009_008/r0_w0_wl u_t009_008/r0_w1_wl u_t009_008/r0_r0_rwl u_t009_008/r0_r1_rwl
+ u_t009_008/r1_w0_wl u_t009_008/r1_w1_wl u_t009_008/r1_r0_rwl u_t009_008/r1_r1_rwl
+ u_t009_008/r2_w0_wl u_t009_008/r2_w1_wl u_t009_008/r2_r0_rwl u_t009_008/r2_r1_rwl
+ u_t009_008/r3_w0_wl u_t009_008/r3_w1_wl u_t009_008/r3_r0_rwl u_t009_008/r3_r1_rwl
+ VSS VSS u_t009_008/m2_717_1265# u_t009_008/m2_603_2031# u_t009_008/m2_1290_336#
+ u_t009_008/m2_2000_2037# u_t009_008/m2_791_2909# u_t009_008/m2_7_2126# u_t009_008/m2_2154_2081#
+ u_t009_008/m2_1795_2037# u_t009_008/m2_871_303# u_t009_008/m2_431_438# u_t009_008/m2_1290_2898#
+ u_t009_008/m2_1714_1210# u_t009_008/m2_431_1982# u_t009_008/m2_512_1265# u_t009_008/m2_2573_2126#
+ u_t009_008/m2_603_1259# u_t009_008/m2_2074_2909# u_t009_008/m2_7_336# u_t009_008/m2_717_2037#
+ u_t009_008/m2_1886_2031# u_t009_008/m2_2573_336# u_t009_008/m2_7_2898# u_t009_008/m2_2000_1265#
+ u_t009_008/m2_512_2037# u_t009_008/m2_1795_1265# u_t009_008/m2_1714_1982# u_t009_008/m2_1886_1259#
+ u_t009_008/m2_1290_2126# u_t009_008/m2_1714_438# u_t009_008/m2_431_1210# u_t009_008/m2_2573_2898#
+ u_t009_008/m2_2154_303# u_t009_008/m2_871_2081# VSUBS detronyx_12t_2w2r_rc4_4x4_routed_5layer_direct
Xgf180mcu_as_sc_mcu7t3v3__inv_2_100 VSS VSS gf180mcu_as_sc_mcu7t3v3__inv_2_99/A gf180mcu_as_sc_mcu7t3v3__inv_2_104/Y
+ gf180mcu_as_sc_mcu7t3v3__inv_2_99/VNW VSUBS gf180mcu_as_sc_mcu7t3v3__inv_2
Xgf180mcu_as_sc_mcu7t3v3__inv_2_155 VSS VSS gf180mcu_as_sc_mcu7t3v3__inv_2_155/Y gf180mcu_as_sc_mcu7t3v3__inv_2_155/A
+ gf180mcu_as_sc_mcu7t3v3__inv_2_155/VNW VSUBS gf180mcu_as_sc_mcu7t3v3__inv_2
Xgf180mcu_as_sc_mcu7t3v3__inv_2_144 VSS VSS VSS gf180mcu_as_sc_mcu7t3v3__inv_2_145/Y
+ gf180mcu_as_sc_mcu7t3v3__inv_2_146/VNW VSUBS gf180mcu_as_sc_mcu7t3v3__inv_2
Xgf180mcu_as_sc_mcu7t3v3__inv_2_133 VSS VSS gf180mcu_as_sc_mcu7t3v3__inv_2_133/Y gf180mcu_as_sc_mcu7t3v3__inv_2_134/Y
+ gf180mcu_as_sc_mcu7t3v3__inv_2_134/VNW VSUBS gf180mcu_as_sc_mcu7t3v3__inv_2
Xgf180mcu_as_sc_mcu7t3v3__inv_2_122 VSS VSS gf180mcu_as_sc_mcu7t3v3__inv_2_122/Y gf180mcu_as_sc_mcu7t3v3__inv_2_122/A
+ gf180mcu_as_sc_mcu7t3v3__inv_2_122/VNW VSUBS gf180mcu_as_sc_mcu7t3v3__inv_2
Xgf180mcu_as_sc_mcu7t3v3__inv_2_111 VSS VSS VSS gf180mcu_as_sc_mcu7t3v3__inv_2_112/Y
+ gf180mcu_as_sc_mcu7t3v3__inv_2_113/VNW VSUBS gf180mcu_as_sc_mcu7t3v3__inv_2
Xgf180mcu_as_sc_mcu7t3v3__inv_2_166 VSS VSS VSS gf180mcu_as_sc_mcu7t3v3__inv_2_167/Y
+ gf180mcu_as_sc_mcu7t3v3__inv_2_168/VNW VSUBS gf180mcu_as_sc_mcu7t3v3__inv_2
Xgf180mcu_as_sc_mcu7t3v3__inv_2_199 VSS VSS gf180mcu_as_sc_mcu7t3v3__inv_2_199/Y gf180mcu_as_sc_mcu7t3v3__inv_2_200/Y
+ gf180mcu_as_sc_mcu7t3v3__inv_2_200/VNW VSUBS gf180mcu_as_sc_mcu7t3v3__inv_2
Xgf180mcu_as_sc_mcu7t3v3__inv_2_188 VSS VSS VSS gf180mcu_as_sc_mcu7t3v3__inv_2_189/Y
+ gf180mcu_as_sc_mcu7t3v3__inv_2_190/VNW VSUBS gf180mcu_as_sc_mcu7t3v3__inv_2
Xgf180mcu_as_sc_mcu7t3v3__inv_2_177 VSS VSS gf180mcu_as_sc_mcu7t3v3__inv_2_177/Y gf180mcu_as_sc_mcu7t3v3__inv_2_177/A
+ gf180mcu_as_sc_mcu7t3v3__inv_2_177/VNW VSUBS gf180mcu_as_sc_mcu7t3v3__inv_2
Xu_t023_011 u_t023_011/c0_w0_bl u_t023_011/c0_w0_br u_t023_011/c0_w1_bl u_t023_011/c0_w1_br
+ u_t023_011/c0_r0_rbl u_t023_011/c0_r1_rbl u_t023_011/c1_w0_bl u_t023_011/c1_w0_br
+ u_t023_011/c1_w1_bl u_t023_011/c1_w1_br u_t023_011/c1_r0_rbl u_t023_011/c1_r1_rbl
+ u_t023_011/c2_w0_bl u_t023_011/c2_w0_br u_t023_011/c2_w1_bl u_t023_011/c2_w1_br
+ u_t023_011/c2_r0_rbl u_t023_011/c2_r1_rbl u_t023_011/c3_w0_bl u_t023_011/c3_w0_br
+ u_t023_011/c3_w1_bl u_t023_011/c3_w1_br u_t023_011/c3_r0_rbl u_t023_011/c3_r1_rbl
+ u_t023_011/r0_w0_wl u_t023_011/r0_w1_wl u_t023_011/r0_r0_rwl u_t023_011/r0_r1_rwl
+ u_t023_011/r1_w0_wl u_t023_011/r1_w1_wl u_t023_011/r1_r0_rwl u_t023_011/r1_r1_rwl
+ u_t023_011/r2_w0_wl u_t023_011/r2_w1_wl u_t023_011/r2_r0_rwl u_t023_011/r2_r1_rwl
+ u_t023_011/r3_w0_wl u_t023_011/r3_w1_wl u_t023_011/r3_r0_rwl u_t023_011/r3_r1_rwl
+ VSS VSS u_t023_011/m2_717_1265# u_t023_011/m2_603_2031# u_t023_011/m2_1290_336#
+ u_t023_011/m2_2000_2037# u_t023_011/m2_791_2909# u_t023_011/m2_7_2126# u_t023_011/m2_2154_2081#
+ u_t023_011/m2_1795_2037# u_t023_011/m2_871_303# u_t023_011/m2_431_438# u_t023_011/m2_1290_2898#
+ u_t023_011/m2_1714_1210# u_t023_011/m2_431_1982# u_t023_011/m2_512_1265# u_t023_011/m2_2573_2126#
+ u_t023_011/m2_603_1259# u_t023_011/m2_2074_2909# u_t023_011/m2_7_336# u_t023_011/m2_717_2037#
+ u_t023_011/m2_1886_2031# u_t023_011/m2_2573_336# u_t023_011/m2_7_2898# u_t023_011/m2_2000_1265#
+ u_t023_011/m2_512_2037# u_t023_011/m2_1795_1265# u_t023_011/m2_1714_1982# u_t023_011/m2_1886_1259#
+ u_t023_011/m2_1290_2126# u_t023_011/m2_1714_438# u_t023_011/m2_431_1210# u_t023_011/m2_2573_2898#
+ u_t023_011/m2_2154_303# u_t023_011/m2_871_2081# VSUBS detronyx_12t_2w2r_rc4_4x4_routed_5layer_direct
Xu_t023_000 VSS u_t023_000/c0_w0_br VSS u_t023_000/c0_w1_br u_t023_000/c0_r0_rbl u_t023_000/c0_r1_rbl
+ VSS VSS VSS VSS VSS VSS u_t023_000/c2_w0_bl u_t023_000/c2_w0_br u_t023_000/c2_w1_bl
+ u_t023_000/c2_w1_br u_t023_000/c2_r0_rbl u_t023_000/c2_r1_rbl u_t023_000/c3_w0_bl
+ u_t023_000/c3_w0_br u_t023_000/c3_w1_bl u_t023_000/c3_w1_br u_t023_000/c3_r0_rbl
+ u_t023_000/c3_r1_rbl VSS VSS VSS VSS VSS VSS VSS VSS VSS VSS VSS VSS VSS VSS VSS
+ VSS VSS VSS u_t023_000/m2_717_1265# VSS VSS VSS VSS VSS VSS VSS VSS VSS VSS VSS
+ VSS u_t023_000/m2_512_1265# u_t023_000/m2_2573_2126# VSS VSS VSS VSS VSS u_t023_000/m2_2573_336#
+ VSS u_t023_000/m2_2000_1265# VSS u_t023_000/m2_1795_1265# VSS VSS VSS VSS VSS u_t023_000/m2_2573_2898#
+ VSS VSS VSUBS detronyx_12t_2w2r_rc4_4x4_routed_5layer_direct
Xgf180mcu_as_sc_mcu7t3v3__nand2_2_23 gf180mcu_as_sc_mcu7t3v3__nor2_2_7/VDD gf180mcu_as_sc_mcu7t3v3__nand3_2_4/VSS
+ VSS VSS VSS gf180mcu_as_sc_mcu7t3v3__nor2_2_7/VNW VSUBS gf180mcu_as_sc_mcu7t3v3__nand2_2
Xgf180mcu_as_sc_mcu7t3v3__nand2_2_12 gf180mcu_as_sc_mcu7t3v3__nor2_2_4/VDD gf180mcu_as_sc_mcu7t3v3__nor2_2_4/VSS
+ VSS VSS VSS gf180mcu_as_sc_mcu7t3v3__nor2_2_4/VNW VSUBS gf180mcu_as_sc_mcu7t3v3__nand2_2
Xu_t014_011 u_t014_011/c0_w0_bl u_t014_011/c0_w0_br u_t014_011/c0_w1_bl u_t014_011/c0_w1_br
+ u_t014_011/c0_r0_rbl u_t014_011/c0_r1_rbl u_t014_011/c1_w0_bl u_t014_011/c1_w0_br
+ u_t014_011/c1_w1_bl u_t014_011/c1_w1_br u_t014_011/c1_r0_rbl u_t014_011/c1_r1_rbl
+ u_t014_011/c2_w0_bl u_t014_011/c2_w0_br u_t014_011/c2_w1_bl u_t014_011/c2_w1_br
+ u_t014_011/c2_r0_rbl u_t014_011/c2_r1_rbl u_t014_011/c3_w0_bl u_t014_011/c3_w0_br
+ u_t014_011/c3_w1_bl u_t014_011/c3_w1_br u_t014_011/c3_r0_rbl u_t014_011/c3_r1_rbl
+ u_t014_011/r0_w0_wl u_t014_011/r0_w1_wl u_t014_011/r0_r0_rwl u_t014_011/r0_r1_rwl
+ u_t014_011/r1_w0_wl u_t014_011/r1_w1_wl u_t014_011/r1_r0_rwl u_t014_011/r1_r1_rwl
+ u_t014_011/r2_w0_wl u_t014_011/r2_w1_wl u_t014_011/r2_r0_rwl u_t014_011/r2_r1_rwl
+ u_t014_011/r3_w0_wl u_t014_011/r3_w1_wl u_t014_011/r3_r0_rwl u_t014_011/r3_r1_rwl
+ VSS VSS u_t014_011/m2_717_1265# u_t014_011/m2_603_2031# u_t014_011/m2_1290_336#
+ u_t014_011/m2_2000_2037# u_t014_011/m2_791_2909# u_t014_011/m2_7_2126# u_t014_011/m2_2154_2081#
+ u_t014_011/m2_1795_2037# u_t014_011/m2_871_303# u_t014_011/m2_431_438# u_t014_011/m2_1290_2898#
+ u_t014_011/m2_1714_1210# u_t014_011/m2_431_1982# u_t014_011/m2_512_1265# u_t014_011/m2_2573_2126#
+ u_t014_011/m2_603_1259# u_t014_011/m2_2074_2909# u_t014_011/m2_7_336# u_t014_011/m2_717_2037#
+ u_t014_011/m2_1886_2031# u_t014_011/m2_2573_336# u_t014_011/m2_7_2898# u_t014_011/m2_2000_1265#
+ u_t014_011/m2_512_2037# u_t014_011/m2_1795_1265# u_t014_011/m2_1714_1982# u_t014_011/m2_1886_1259#
+ u_t014_011/m2_1290_2126# u_t014_011/m2_1714_438# u_t014_011/m2_431_1210# u_t014_011/m2_2573_2898#
+ u_t014_011/m2_2154_303# u_t014_011/m2_871_2081# VSUBS detronyx_12t_2w2r_rc4_4x4_routed_5layer_direct
Xgf180mcu_as_sc_mcu7t3v3__nand2_2_34 gf180mcu_as_sc_mcu7t3v3__nor2_2_9/VDD gf180mcu_as_sc_mcu7t3v3__nand3_2_63/VSS
+ VSS VSS VSS gf180mcu_as_sc_mcu7t3v3__nor2_2_9/VNW VSUBS gf180mcu_as_sc_mcu7t3v3__nand2_2
Xgf180mcu_as_sc_mcu7t3v3__nand2_2_45 gf180mcu_as_sc_mcu7t3v3__nand3_2_65/VDD gf180mcu_as_sc_mcu7t3v3__nand3_2_62/VSS
+ VSS VSS VSS gf180mcu_as_sc_mcu7t3v3__nand3_2_65/VNW VSUBS gf180mcu_as_sc_mcu7t3v3__nand2_2
Xu_t014_000 VSS u_t014_000/c0_w0_br VSS u_t014_000/c0_w1_br u_t014_000/c0_r0_rbl u_t014_000/c0_r1_rbl
+ VSS VSS VSS VSS VSS VSS u_t014_000/c2_w0_bl u_t014_000/c2_w0_br u_t014_000/c2_w1_bl
+ u_t014_000/c2_w1_br u_t014_000/c2_r0_rbl u_t014_000/c2_r1_rbl u_t014_000/c3_w0_bl
+ u_t014_000/c3_w0_br u_t014_000/c3_w1_bl u_t014_000/c3_w1_br u_t014_000/c3_r0_rbl
+ u_t014_000/c3_r1_rbl VSS VSS VSS VSS VSS VSS VSS VSS VSS VSS VSS VSS VSS VSS VSS
+ VSS VSS VSS u_t014_000/m2_717_1265# u_t014_000/m2_603_2031# u_t014_000/m2_1290_336#
+ u_t014_000/m2_2000_2037# u_t014_000/m2_791_2909# u_t014_000/m2_7_2126# u_t014_000/m2_2154_2081#
+ u_t014_000/m2_1795_2037# u_t014_000/m2_871_303# u_t014_000/m2_431_438# u_t014_000/m2_1290_2898#
+ u_t014_000/m2_1714_1210# u_t014_000/m2_431_1982# u_t014_000/m2_512_1265# u_t014_000/m2_2573_2126#
+ u_t014_000/m2_603_1259# u_t014_000/m2_2074_2909# u_t014_000/m2_7_336# u_t014_000/m2_717_2037#
+ u_t014_000/m2_1886_2031# u_t014_000/m2_2573_336# u_t014_000/m2_7_2898# u_t014_000/m2_2000_1265#
+ u_t014_000/m2_512_2037# u_t014_000/m2_1795_1265# u_t014_000/m2_1714_1982# u_t014_000/m2_1886_1259#
+ u_t014_000/m2_1290_2126# u_t014_000/m2_1714_438# u_t014_000/m2_431_1210# u_t014_000/m2_2573_2898#
+ u_t014_000/m2_2154_303# u_t014_000/m2_871_2081# VSUBS detronyx_12t_2w2r_rc4_4x4_routed_5layer_direct
Xu_t005_011 u_t005_011/c0_w0_bl u_t005_011/c0_w0_br u_t005_011/c0_w1_bl u_t005_011/c0_w1_br
+ u_t005_011/c0_r0_rbl u_t005_011/c0_r1_rbl u_t005_011/c1_w0_bl u_t005_011/c1_w0_br
+ u_t005_011/c1_w1_bl u_t005_011/c1_w1_br u_t005_011/c1_r0_rbl u_t005_011/c1_r1_rbl
+ u_t005_011/c2_w0_bl u_t005_011/c2_w0_br u_t005_011/c2_w1_bl u_t005_011/c2_w1_br
+ u_t005_011/c2_r0_rbl u_t005_011/c2_r1_rbl u_t005_011/c3_w0_bl u_t005_011/c3_w0_br
+ u_t005_011/c3_w1_bl u_t005_011/c3_w1_br u_t005_011/c3_r0_rbl u_t005_011/c3_r1_rbl
+ u_t005_011/r0_w0_wl u_t005_011/r0_w1_wl u_t005_011/r0_r0_rwl u_t005_011/r0_r1_rwl
+ u_t005_011/r1_w0_wl u_t005_011/r1_w1_wl u_t005_011/r1_r0_rwl u_t005_011/r1_r1_rwl
+ u_t005_011/r2_w0_wl u_t005_011/r2_w1_wl u_t005_011/r2_r0_rwl u_t005_011/r2_r1_rwl
+ u_t005_011/r3_w0_wl u_t005_011/r3_w1_wl u_t005_011/r3_r0_rwl u_t005_011/r3_r1_rwl
+ VSS VSS u_t005_011/m2_717_1265# u_t005_011/m2_603_2031# u_t005_011/m2_1290_336#
+ u_t005_011/m2_2000_2037# u_t005_011/m2_791_2909# u_t005_011/m2_7_2126# u_t005_011/m2_2154_2081#
+ u_t005_011/m2_1795_2037# u_t005_011/m2_871_303# u_t005_011/m2_431_438# u_t005_011/m2_1290_2898#
+ u_t005_011/m2_1714_1210# u_t005_011/m2_431_1982# u_t005_011/m2_512_1265# u_t005_011/m2_2573_2126#
+ u_t005_011/m2_603_1259# u_t005_011/m2_2074_2909# u_t005_011/m2_7_336# u_t005_011/m2_717_2037#
+ u_t005_011/m2_1886_2031# u_t005_011/m2_2573_336# u_t005_011/m2_7_2898# u_t005_011/m2_2000_1265#
+ u_t005_011/m2_512_2037# u_t005_011/m2_1795_1265# u_t005_011/m2_1714_1982# u_t005_011/m2_1886_1259#
+ u_t005_011/m2_1290_2126# u_t005_011/m2_1714_438# u_t005_011/m2_431_1210# u_t005_011/m2_2573_2898#
+ u_t005_011/m2_2154_303# u_t005_011/m2_871_2081# VSUBS detronyx_12t_2w2r_rc4_4x4_routed_5layer_direct
Xu_t005_000 VSS u_t005_000/c0_w0_br VSS u_t005_000/c0_w1_br u_t005_000/c0_r0_rbl u_t005_000/c0_r1_rbl
+ VSS VSS VSS VSS VSS VSS u_t005_000/c2_w0_bl u_t005_000/c2_w0_br u_t005_000/c2_w1_bl
+ u_t005_000/c2_w1_br u_t005_000/c2_r0_rbl u_t005_000/c2_r1_rbl u_t005_000/c3_w0_bl
+ u_t005_000/c3_w0_br u_t005_000/c3_w1_bl u_t005_000/c3_w1_br u_t005_000/c3_r0_rbl
+ u_t005_000/c3_r1_rbl VSS VSS VSS VSS VSS VSS VSS VSS VSS VSS VSS VSS VSS VSS VSS
+ VSS VSS VSS u_t005_000/m2_717_1265# u_t005_000/m2_603_2031# u_t005_000/m2_1290_336#
+ u_t005_000/m2_2000_2037# u_t005_000/m2_791_2909# u_t005_000/m2_7_2126# u_t005_000/m2_2154_2081#
+ u_t005_000/m2_1795_2037# u_t005_000/m2_871_303# u_t005_000/m2_431_438# u_t005_000/m2_1290_2898#
+ u_t005_000/m2_1714_1210# u_t005_000/m2_431_1982# u_t005_000/m2_512_1265# u_t005_000/m2_2573_2126#
+ u_t005_000/m2_603_1259# u_t005_000/m2_2074_2909# u_t005_000/m2_7_336# u_t005_000/m2_717_2037#
+ u_t005_000/m2_1886_2031# u_t005_000/m2_2573_336# u_t005_000/m2_7_2898# u_t005_000/m2_2000_1265#
+ u_t005_000/m2_512_2037# u_t005_000/m2_1795_1265# u_t005_000/m2_1714_1982# u_t005_000/m2_1886_1259#
+ u_t005_000/m2_1290_2126# u_t005_000/m2_1714_438# u_t005_000/m2_431_1210# u_t005_000/m2_2573_2898#
+ u_t005_000/m2_2154_303# u_t005_000/m2_871_2081# VSUBS detronyx_12t_2w2r_rc4_4x4_routed_5layer_direct
Xu_t020_014 u_t020_014/c0_w0_bl u_t020_014/c0_w0_br u_t020_014/c0_w1_bl u_t020_014/c0_w1_br
+ u_t020_014/c0_r0_rbl u_t020_014/c0_r1_rbl u_t020_014/c1_w0_bl u_t020_014/c1_w0_br
+ u_t020_014/c1_w1_bl u_t020_014/c1_w1_br u_t020_014/c1_r0_rbl u_t020_014/c1_r1_rbl
+ u_t020_014/c2_w0_bl u_t020_014/c2_w0_br u_t020_014/c2_w1_bl u_t020_014/c2_w1_br
+ u_t020_014/c2_r0_rbl u_t020_014/c2_r1_rbl u_t020_014/c3_w0_bl u_t020_014/c3_w0_br
+ u_t020_014/c3_w1_bl u_t020_014/c3_w1_br u_t020_014/c3_r0_rbl u_t020_014/c3_r1_rbl
+ u_t020_014/r0_w0_wl u_t020_014/r0_w1_wl u_t020_014/r0_r0_rwl u_t020_014/r0_r1_rwl
+ u_t020_014/r1_w0_wl u_t020_014/r1_w1_wl u_t020_014/r1_r0_rwl u_t020_014/r1_r1_rwl
+ u_t020_014/r2_w0_wl u_t020_014/r2_w1_wl u_t020_014/r2_r0_rwl u_t020_014/r2_r1_rwl
+ u_t020_014/r3_w0_wl u_t020_014/r3_w1_wl u_t020_014/r3_r0_rwl u_t020_014/r3_r1_rwl
+ VSS VSS u_t020_014/m2_717_1265# u_t020_014/m2_603_2031# u_t020_014/m2_1290_336#
+ u_t020_014/m2_2000_2037# u_t020_014/m2_791_2909# u_t020_014/m2_7_2126# u_t020_014/m2_2154_2081#
+ u_t020_014/m2_1795_2037# u_t020_014/m2_871_303# u_t020_014/m2_431_438# u_t020_014/m2_1290_2898#
+ u_t020_014/m2_1714_1210# u_t020_014/m2_431_1982# u_t020_014/m2_512_1265# u_t020_014/m2_2573_2126#
+ u_t020_014/m2_603_1259# u_t020_014/m2_2074_2909# u_t020_014/m2_7_336# u_t020_014/m2_717_2037#
+ u_t020_014/m2_1886_2031# u_t020_014/m2_2573_336# u_t020_014/m2_7_2898# u_t020_014/m2_2000_1265#
+ u_t020_014/m2_512_2037# u_t020_014/m2_1795_1265# u_t020_014/m2_1714_1982# u_t020_014/m2_1886_1259#
+ u_t020_014/m2_1290_2126# u_t020_014/m2_1714_438# u_t020_014/m2_431_1210# u_t020_014/m2_2573_2898#
+ u_t020_014/m2_2154_303# u_t020_014/m2_871_2081# VSUBS detronyx_12t_2w2r_rc4_4x4_routed_5layer_direct
Xu_t020_003 u_t020_003/c0_w0_bl u_t020_003/c0_w0_br u_t020_003/c0_w1_bl u_t020_003/c0_w1_br
+ u_t020_003/c0_r0_rbl u_t020_003/c0_r1_rbl u_t020_003/c1_w0_bl u_t020_003/c1_w0_br
+ u_t020_003/c1_w1_bl u_t020_003/c1_w1_br u_t020_003/c1_r0_rbl u_t020_003/c1_r1_rbl
+ u_t020_003/c2_w0_bl u_t020_003/c2_w0_br u_t020_003/c2_w1_bl u_t020_003/c2_w1_br
+ u_t020_003/c2_r0_rbl u_t020_003/c2_r1_rbl u_t020_003/c3_w0_bl u_t020_003/c3_w0_br
+ u_t020_003/c3_w1_bl u_t020_003/c3_w1_br u_t020_003/c3_r0_rbl u_t020_003/c3_r1_rbl
+ u_t020_003/r0_w0_wl u_t020_003/r0_w1_wl u_t020_003/r0_r0_rwl u_t020_003/r0_r1_rwl
+ u_t020_003/r1_w0_wl u_t020_003/r1_w1_wl u_t020_003/r1_r0_rwl u_t020_003/r1_r1_rwl
+ u_t020_003/r2_w0_wl u_t020_003/r2_w1_wl u_t020_003/r2_r0_rwl u_t020_003/r2_r1_rwl
+ u_t020_003/r3_w0_wl u_t020_003/r3_w1_wl u_t020_003/r3_r0_rwl u_t020_003/r3_r1_rwl
+ VSS VSS u_t020_003/m2_717_1265# u_t020_003/m2_603_2031# u_t020_003/m2_1290_336#
+ u_t020_003/m2_2000_2037# u_t020_003/m2_791_2909# u_t020_003/m2_7_2126# u_t020_003/m2_2154_2081#
+ u_t020_003/m2_1795_2037# u_t020_003/m2_871_303# u_t020_003/m2_431_438# u_t020_003/m2_1290_2898#
+ u_t020_003/m2_1714_1210# u_t020_003/m2_431_1982# u_t020_003/m2_512_1265# u_t020_003/m2_2573_2126#
+ u_t020_003/m2_603_1259# u_t020_003/m2_2074_2909# u_t020_003/m2_7_336# u_t020_003/m2_717_2037#
+ u_t020_003/m2_1886_2031# u_t020_003/m2_2573_336# u_t020_003/m2_7_2898# u_t020_003/m2_2000_1265#
+ u_t020_003/m2_512_2037# u_t020_003/m2_1795_1265# u_t020_003/m2_1714_1982# u_t020_003/m2_1886_1259#
+ u_t020_003/m2_1290_2126# u_t020_003/m2_1714_438# u_t020_003/m2_431_1210# u_t020_003/m2_2573_2898#
+ u_t020_003/m2_2154_303# u_t020_003/m2_871_2081# VSUBS detronyx_12t_2w2r_rc4_4x4_routed_5layer_direct
Xgf180mcu_as_sc_mcu7t3v3__inv_2_1407 VSS VSS gf180mcu_as_sc_mcu7t3v3__inv_2_1409/A
+ gf180mcu_as_sc_mcu7t3v3__inv_2_1408/Y gf180mcu_as_sc_mcu7t3v3__inv_2_1409/VNW VSUBS
+ gf180mcu_as_sc_mcu7t3v3__inv_2
Xgf180mcu_as_sc_mcu7t3v3__inv_2_1418 VSS VSS gf180mcu_as_sc_mcu7t3v3__inv_2_1418/Y
+ gf180mcu_as_sc_mcu7t3v3__inv_2_1419/Y gf180mcu_as_sc_mcu7t3v3__inv_2_1419/VNW VSUBS
+ gf180mcu_as_sc_mcu7t3v3__inv_2
Xgf180mcu_as_sc_mcu7t3v3__inv_2_1429 VSS VSS VSS gf180mcu_as_sc_mcu7t3v3__inv_2_1430/Y
+ gf180mcu_as_sc_mcu7t3v3__inv_2_1431/VNW VSUBS gf180mcu_as_sc_mcu7t3v3__inv_2
Xu_t011_014 u_t011_014/c0_w0_bl u_t011_014/c0_w0_br u_t011_014/c0_w1_bl u_t011_014/c0_w1_br
+ u_t011_014/c0_r0_rbl u_t011_014/c0_r1_rbl u_t011_014/c1_w0_bl u_t011_014/c1_w0_br
+ u_t011_014/c1_w1_bl u_t011_014/c1_w1_br u_t011_014/c1_r0_rbl u_t011_014/c1_r1_rbl
+ u_t011_014/c2_w0_bl u_t011_014/c2_w0_br u_t011_014/c2_w1_bl u_t011_014/c2_w1_br
+ u_t011_014/c2_r0_rbl u_t011_014/c2_r1_rbl u_t011_014/c3_w0_bl u_t011_014/c3_w0_br
+ u_t011_014/c3_w1_bl u_t011_014/c3_w1_br u_t011_014/c3_r0_rbl u_t011_014/c3_r1_rbl
+ u_t011_014/r0_w0_wl u_t011_014/r0_w1_wl u_t011_014/r0_r0_rwl u_t011_014/r0_r1_rwl
+ u_t011_014/r1_w0_wl u_t011_014/r1_w1_wl u_t011_014/r1_r0_rwl u_t011_014/r1_r1_rwl
+ u_t011_014/r2_w0_wl u_t011_014/r2_w1_wl u_t011_014/r2_r0_rwl u_t011_014/r2_r1_rwl
+ u_t011_014/r3_w0_wl u_t011_014/r3_w1_wl u_t011_014/r3_r0_rwl u_t011_014/r3_r1_rwl
+ VSS VSS u_t011_014/m2_717_1265# u_t011_014/m2_603_2031# u_t011_014/m2_1290_336#
+ u_t011_014/m2_2000_2037# u_t011_014/m2_791_2909# u_t011_014/m2_7_2126# u_t011_014/m2_2154_2081#
+ u_t011_014/m2_1795_2037# u_t011_014/m2_871_303# u_t011_014/m2_431_438# u_t011_014/m2_1290_2898#
+ u_t011_014/m2_1714_1210# u_t011_014/m2_431_1982# u_t011_014/m2_512_1265# u_t011_014/m2_2573_2126#
+ u_t011_014/m2_603_1259# u_t011_014/m2_2074_2909# u_t011_014/m2_7_336# u_t011_014/m2_717_2037#
+ u_t011_014/m2_1886_2031# u_t011_014/m2_2573_336# u_t011_014/m2_7_2898# u_t011_014/m2_2000_1265#
+ u_t011_014/m2_512_2037# u_t011_014/m2_1795_1265# u_t011_014/m2_1714_1982# u_t011_014/m2_1886_1259#
+ u_t011_014/m2_1290_2126# u_t011_014/m2_1714_438# u_t011_014/m2_431_1210# u_t011_014/m2_2573_2898#
+ u_t011_014/m2_2154_303# u_t011_014/m2_871_2081# VSUBS detronyx_12t_2w2r_rc4_4x4_routed_5layer_direct
Xu_t011_003 u_t011_003/c0_w0_bl u_t011_003/c0_w0_br u_t011_003/c0_w1_bl u_t011_003/c0_w1_br
+ u_t011_003/c0_r0_rbl u_t011_003/c0_r1_rbl u_t011_003/c1_w0_bl u_t011_003/c1_w0_br
+ u_t011_003/c1_w1_bl u_t011_003/c1_w1_br u_t011_003/c1_r0_rbl u_t011_003/c1_r1_rbl
+ u_t011_003/c2_w0_bl u_t011_003/c2_w0_br u_t011_003/c2_w1_bl u_t011_003/c2_w1_br
+ u_t011_003/c2_r0_rbl u_t011_003/c2_r1_rbl u_t011_003/c3_w0_bl u_t011_003/c3_w0_br
+ u_t011_003/c3_w1_bl u_t011_003/c3_w1_br u_t011_003/c3_r0_rbl u_t011_003/c3_r1_rbl
+ u_t011_003/r0_w0_wl u_t011_003/r0_w1_wl u_t011_003/r0_r0_rwl u_t011_003/r0_r1_rwl
+ u_t011_003/r1_w0_wl u_t011_003/r1_w1_wl u_t011_003/r1_r0_rwl u_t011_003/r1_r1_rwl
+ u_t011_003/r2_w0_wl u_t011_003/r2_w1_wl u_t011_003/r2_r0_rwl u_t011_003/r2_r1_rwl
+ u_t011_003/r3_w0_wl u_t011_003/r3_w1_wl u_t011_003/r3_r0_rwl u_t011_003/r3_r1_rwl
+ VSS VSS u_t011_003/m2_717_1265# u_t011_003/m2_603_2031# u_t011_003/m2_1290_336#
+ u_t011_003/m2_2000_2037# u_t011_003/m2_791_2909# u_t011_003/m2_7_2126# u_t011_003/m2_2154_2081#
+ u_t011_003/m2_1795_2037# u_t011_003/m2_871_303# u_t011_003/m2_431_438# u_t011_003/m2_1290_2898#
+ u_t011_003/m2_1714_1210# u_t011_003/m2_431_1982# u_t011_003/m2_512_1265# u_t011_003/m2_2573_2126#
+ u_t011_003/m2_603_1259# u_t011_003/m2_2074_2909# u_t011_003/m2_7_336# u_t011_003/m2_717_2037#
+ u_t011_003/m2_1886_2031# u_t011_003/m2_2573_336# u_t011_003/m2_7_2898# u_t011_003/m2_2000_1265#
+ u_t011_003/m2_512_2037# u_t011_003/m2_1795_1265# u_t011_003/m2_1714_1982# u_t011_003/m2_1886_1259#
+ u_t011_003/m2_1290_2126# u_t011_003/m2_1714_438# u_t011_003/m2_431_1210# u_t011_003/m2_2573_2898#
+ u_t011_003/m2_2154_303# u_t011_003/m2_871_2081# VSUBS detronyx_12t_2w2r_rc4_4x4_routed_5layer_direct
Xu_t002_014 u_t002_014/c0_w0_bl u_t002_014/c0_w0_br u_t002_014/c0_w1_bl u_t002_014/c0_w1_br
+ u_t002_014/c0_r0_rbl u_t002_014/c0_r1_rbl u_t002_014/c1_w0_bl u_t002_014/c1_w0_br
+ u_t002_014/c1_w1_bl u_t002_014/c1_w1_br u_t002_014/c1_r0_rbl u_t002_014/c1_r1_rbl
+ u_t002_014/c2_w0_bl u_t002_014/c2_w0_br u_t002_014/c2_w1_bl u_t002_014/c2_w1_br
+ u_t002_014/c2_r0_rbl u_t002_014/c2_r1_rbl u_t002_014/c3_w0_bl u_t002_014/c3_w0_br
+ u_t002_014/c3_w1_bl u_t002_014/c3_w1_br u_t002_014/c3_r0_rbl u_t002_014/c3_r1_rbl
+ u_t002_014/r0_w0_wl u_t002_014/r0_w1_wl u_t002_014/r0_r0_rwl u_t002_014/r0_r1_rwl
+ u_t002_014/r1_w0_wl u_t002_014/r1_w1_wl u_t002_014/r1_r0_rwl u_t002_014/r1_r1_rwl
+ u_t002_014/r2_w0_wl u_t002_014/r2_w1_wl u_t002_014/r2_r0_rwl u_t002_014/r2_r1_rwl
+ u_t002_014/r3_w0_wl u_t002_014/r3_w1_wl u_t002_014/r3_r0_rwl u_t002_014/r3_r1_rwl
+ VSS VSS u_t002_014/m2_717_1265# u_t002_014/m2_603_2031# u_t002_014/m2_1290_336#
+ u_t002_014/m2_2000_2037# u_t002_014/m2_791_2909# u_t002_014/m2_7_2126# u_t002_014/m2_2154_2081#
+ u_t002_014/m2_1795_2037# u_t002_014/m2_871_303# u_t002_014/m2_431_438# u_t002_014/m2_1290_2898#
+ u_t002_014/m2_1714_1210# u_t002_014/m2_431_1982# u_t002_014/m2_512_1265# u_t002_014/m2_2573_2126#
+ u_t002_014/m2_603_1259# u_t002_014/m2_2074_2909# u_t002_014/m2_7_336# u_t002_014/m2_717_2037#
+ u_t002_014/m2_1886_2031# u_t002_014/m2_2573_336# u_t002_014/m2_7_2898# u_t002_014/m2_2000_1265#
+ u_t002_014/m2_512_2037# u_t002_014/m2_1795_1265# u_t002_014/m2_1714_1982# u_t002_014/m2_1886_1259#
+ u_t002_014/m2_1290_2126# u_t002_014/m2_1714_438# u_t002_014/m2_431_1210# u_t002_014/m2_2573_2898#
+ u_t002_014/m2_2154_303# u_t002_014/m2_871_2081# VSUBS detronyx_12t_2w2r_rc4_4x4_routed_5layer_direct
Xu_t002_003 u_t002_003/c0_w0_bl u_t002_003/c0_w0_br u_t002_003/c0_w1_bl u_t002_003/c0_w1_br
+ u_t002_003/c0_r0_rbl u_t002_003/c0_r1_rbl u_t002_003/c1_w0_bl u_t002_003/c1_w0_br
+ u_t002_003/c1_w1_bl u_t002_003/c1_w1_br u_t002_003/c1_r0_rbl u_t002_003/c1_r1_rbl
+ u_t002_003/c2_w0_bl u_t002_003/c2_w0_br u_t002_003/c2_w1_bl u_t002_003/c2_w1_br
+ u_t002_003/c2_r0_rbl u_t002_003/c2_r1_rbl u_t002_003/c3_w0_bl u_t002_003/c3_w0_br
+ u_t002_003/c3_w1_bl u_t002_003/c3_w1_br u_t002_003/c3_r0_rbl u_t002_003/c3_r1_rbl
+ u_t002_003/r0_w0_wl u_t002_003/r0_w1_wl u_t002_003/r0_r0_rwl u_t002_003/r0_r1_rwl
+ u_t002_003/r1_w0_wl u_t002_003/r1_w1_wl u_t002_003/r1_r0_rwl u_t002_003/r1_r1_rwl
+ u_t002_003/r2_w0_wl u_t002_003/r2_w1_wl u_t002_003/r2_r0_rwl u_t002_003/r2_r1_rwl
+ u_t002_003/r3_w0_wl u_t002_003/r3_w1_wl u_t002_003/r3_r0_rwl u_t002_003/r3_r1_rwl
+ VSS VSS u_t002_003/m2_717_1265# u_t002_003/m2_603_2031# u_t002_003/m2_1290_336#
+ u_t002_003/m2_2000_2037# u_t002_003/m2_791_2909# u_t002_003/m2_7_2126# u_t002_003/m2_2154_2081#
+ u_t002_003/m2_1795_2037# u_t002_003/m2_871_303# u_t002_003/m2_431_438# u_t002_003/m2_1290_2898#
+ u_t002_003/m2_1714_1210# u_t002_003/m2_431_1982# u_t002_003/m2_512_1265# u_t002_003/m2_2573_2126#
+ u_t002_003/m2_603_1259# u_t002_003/m2_2074_2909# u_t002_003/m2_7_336# u_t002_003/m2_717_2037#
+ u_t002_003/m2_1886_2031# u_t002_003/m2_2573_336# u_t002_003/m2_7_2898# u_t002_003/m2_2000_1265#
+ u_t002_003/m2_512_2037# u_t002_003/m2_1795_1265# u_t002_003/m2_1714_1982# u_t002_003/m2_1886_1259#
+ u_t002_003/m2_1290_2126# u_t002_003/m2_1714_438# u_t002_003/m2_431_1210# u_t002_003/m2_2573_2898#
+ u_t002_003/m2_2154_303# u_t002_003/m2_871_2081# VSUBS detronyx_12t_2w2r_rc4_4x4_routed_5layer_direct
Xgf180mcu_as_sc_mcu7t3v3__inv_2_1259 gf180mcu_as_sc_mcu7t3v3__nor2_2_9/VDD gf180mcu_as_sc_mcu7t3v3__nand3_2_63/VSS
+ VSS VSS gf180mcu_as_sc_mcu7t3v3__nor2_2_9/VNW VSUBS gf180mcu_as_sc_mcu7t3v3__inv_2
Xgf180mcu_as_sc_mcu7t3v3__inv_2_1248 gf180mcu_as_sc_mcu7t3v3__nand3_2_65/VDD gf180mcu_as_sc_mcu7t3v3__nor2_2_9/VSS
+ VSS VSS gf180mcu_as_sc_mcu7t3v3__nand3_2_65/VNW VSUBS gf180mcu_as_sc_mcu7t3v3__inv_2
Xgf180mcu_as_sc_mcu7t3v3__inv_2_1204 gf180mcu_as_sc_mcu7t3v3__nor2_2_9/VDD gf180mcu_as_sc_mcu7t3v3__nand3_2_63/VSS
+ VSS VSS gf180mcu_as_sc_mcu7t3v3__nor2_2_9/VNW VSUBS gf180mcu_as_sc_mcu7t3v3__inv_2
Xgf180mcu_as_sc_mcu7t3v3__inv_2_1237 gf180mcu_as_sc_mcu7t3v3__nand3_2_65/VDD gf180mcu_as_sc_mcu7t3v3__nor2_2_9/VSS
+ VSS VSS gf180mcu_as_sc_mcu7t3v3__nand3_2_65/VNW VSUBS gf180mcu_as_sc_mcu7t3v3__inv_2
Xgf180mcu_as_sc_mcu7t3v3__inv_2_1226 VSS VSS gf180mcu_as_sc_mcu7t3v3__inv_2_1277/A
+ gf180mcu_as_sc_mcu7t3v3__inv_2_1227/Y gf180mcu_as_sc_mcu7t3v3__inv_2_1277/VNW VSUBS
+ gf180mcu_as_sc_mcu7t3v3__inv_2
Xgf180mcu_as_sc_mcu7t3v3__inv_2_1215 VSS VSS gf180mcu_as_sc_mcu7t3v3__inv_2_1281/A
+ gf180mcu_as_sc_mcu7t3v3__inv_2_1217/Y gf180mcu_as_sc_mcu7t3v3__inv_2_1281/VNW VSUBS
+ gf180mcu_as_sc_mcu7t3v3__inv_2
Xgf180mcu_as_sc_mcu7t3v3__nand4_2_510 VSS VSS VSS VSS VSS VSS gf180mcu_as_sc_mcu7t3v3__inv_2_1717/A
+ gf180mcu_as_sc_mcu7t3v3__inv_2_1717/VNW VSUBS gf180mcu_as_sc_mcu7t3v3__nand4_2
Xgf180mcu_as_sc_mcu7t3v3__inv_2_31 VSS VSS gf180mcu_as_sc_mcu7t3v3__inv_2_31/Y gf180mcu_as_sc_mcu7t3v3__inv_2_32/Y
+ gf180mcu_as_sc_mcu7t3v3__inv_2_32/VNW VSUBS gf180mcu_as_sc_mcu7t3v3__inv_2
Xgf180mcu_as_sc_mcu7t3v3__inv_2_20 VSS VSS gf180mcu_as_sc_mcu7t3v3__inv_2_20/Y gf180mcu_as_sc_mcu7t3v3__inv_2_20/A
+ gf180mcu_as_sc_mcu7t3v3__inv_2_20/VNW VSUBS gf180mcu_as_sc_mcu7t3v3__inv_2
Xgf180mcu_as_sc_mcu7t3v3__inv_2_86 VSS VSS gf180mcu_as_sc_mcu7t3v3__inv_2_98/A gf180mcu_as_sc_mcu7t3v3__inv_2_87/Y
+ gf180mcu_as_sc_mcu7t3v3__inv_2_98/VNW VSUBS gf180mcu_as_sc_mcu7t3v3__inv_2
Xgf180mcu_as_sc_mcu7t3v3__inv_2_42 VSS VSS gf180mcu_as_sc_mcu7t3v3__inv_2_42/Y gf180mcu_as_sc_mcu7t3v3__inv_2_42/A
+ gf180mcu_as_sc_mcu7t3v3__inv_2_42/VNW VSUBS gf180mcu_as_sc_mcu7t3v3__inv_2
Xgf180mcu_as_sc_mcu7t3v3__inv_2_75 VSS VSS VSS gf180mcu_as_sc_mcu7t3v3__inv_2_76/Y
+ gf180mcu_as_sc_mcu7t3v3__inv_2_77/VNW VSUBS gf180mcu_as_sc_mcu7t3v3__inv_2
Xgf180mcu_as_sc_mcu7t3v3__inv_2_64 VSS VSS gf180mcu_as_sc_mcu7t3v3__inv_2_64/Y gf180mcu_as_sc_mcu7t3v3__inv_2_65/Y
+ gf180mcu_as_sc_mcu7t3v3__inv_2_65/VNW VSUBS gf180mcu_as_sc_mcu7t3v3__inv_2
Xgf180mcu_as_sc_mcu7t3v3__inv_2_53 VSS VSS gf180mcu_as_sc_mcu7t3v3__inv_2_53/Y gf180mcu_as_sc_mcu7t3v3__inv_2_53/A
+ gf180mcu_as_sc_mcu7t3v3__inv_2_53/VNW VSUBS gf180mcu_as_sc_mcu7t3v3__inv_2
Xgf180mcu_as_sc_mcu7t3v3__inv_2_1001 VSS VSS gf180mcu_as_sc_mcu7t3v3__inv_2_997/A
+ gf180mcu_as_sc_mcu7t3v3__inv_2_1001/A gf180mcu_as_sc_mcu7t3v3__inv_2_997/VNW VSUBS
+ gf180mcu_as_sc_mcu7t3v3__inv_2
Xgf180mcu_as_sc_mcu7t3v3__inv_2_1078 VSS VSS gf180mcu_as_sc_mcu7t3v3__inv_2_1078/Y
+ gf180mcu_as_sc_mcu7t3v3__inv_2_1079/Y gf180mcu_as_sc_mcu7t3v3__inv_2_1079/VNW VSUBS
+ gf180mcu_as_sc_mcu7t3v3__inv_2
Xgf180mcu_as_sc_mcu7t3v3__inv_2_1067 VSS VSS gf180mcu_as_sc_mcu7t3v3__inv_2_1067/Y
+ gf180mcu_as_sc_mcu7t3v3__inv_2_1067/A gf180mcu_as_sc_mcu7t3v3__inv_2_1067/VNW VSUBS
+ gf180mcu_as_sc_mcu7t3v3__inv_2
Xgf180mcu_as_sc_mcu7t3v3__inv_2_1089 VSS VSS VSS gf180mcu_as_sc_mcu7t3v3__inv_2_1090/Y
+ gf180mcu_as_sc_mcu7t3v3__inv_2_1091/VNW VSUBS gf180mcu_as_sc_mcu7t3v3__inv_2
Xgf180mcu_as_sc_mcu7t3v3__inv_2_1034 VSS VSS VSS gf180mcu_as_sc_mcu7t3v3__inv_2_1035/Y
+ gf180mcu_as_sc_mcu7t3v3__inv_2_1036/VNW VSUBS gf180mcu_as_sc_mcu7t3v3__inv_2
Xgf180mcu_as_sc_mcu7t3v3__inv_2_1012 VSS VSS gf180mcu_as_sc_mcu7t3v3__inv_2_1012/Y
+ gf180mcu_as_sc_mcu7t3v3__inv_2_1012/A gf180mcu_as_sc_mcu7t3v3__inv_2_1012/VNW VSUBS
+ gf180mcu_as_sc_mcu7t3v3__inv_2
Xgf180mcu_as_sc_mcu7t3v3__inv_2_1045 VSS VSS gf180mcu_as_sc_mcu7t3v3__inv_2_1045/Y
+ gf180mcu_as_sc_mcu7t3v3__inv_2_1049/Y gf180mcu_as_sc_mcu7t3v3__inv_2_1049/VNW VSUBS
+ gf180mcu_as_sc_mcu7t3v3__inv_2
Xgf180mcu_as_sc_mcu7t3v3__inv_2_1056 VSS VSS gf180mcu_as_sc_mcu7t3v3__inv_2_1056/Y
+ gf180mcu_as_sc_mcu7t3v3__inv_2_1056/A gf180mcu_as_sc_mcu7t3v3__inv_2_1056/VNW VSUBS
+ gf180mcu_as_sc_mcu7t3v3__inv_2
Xgf180mcu_as_sc_mcu7t3v3__inv_2_97 VSS VSS gf180mcu_as_sc_mcu7t3v3__inv_2_97/Y gf180mcu_as_sc_mcu7t3v3__inv_2_97/A
+ gf180mcu_as_sc_mcu7t3v3__inv_2_97/VNW VSUBS gf180mcu_as_sc_mcu7t3v3__inv_2
Xgf180mcu_as_sc_mcu7t3v3__inv_2_1023 VSS VSS gf180mcu_as_sc_mcu7t3v3__inv_2_1023/Y
+ gf180mcu_as_sc_mcu7t3v3__inv_2_1024/Y gf180mcu_as_sc_mcu7t3v3__inv_2_1024/VNW VSUBS
+ gf180mcu_as_sc_mcu7t3v3__inv_2
Xgf180mcu_as_sc_mcu7t3v3__inv_2_529 gf180mcu_as_sc_mcu7t3v3__nand3_2_9/VDD gf180mcu_as_sc_mcu7t3v3__nor2_2_4/VSS
+ VSS VSS gf180mcu_as_sc_mcu7t3v3__nand3_2_9/VNW VSUBS gf180mcu_as_sc_mcu7t3v3__inv_2
Xgf180mcu_as_sc_mcu7t3v3__inv_2_507 VSS VSS gf180mcu_as_sc_mcu7t3v3__inv_2_507/Y gf180mcu_as_sc_mcu7t3v3__inv_2_507/A
+ gf180mcu_as_sc_mcu7t3v3__inv_2_538/VNW VSUBS gf180mcu_as_sc_mcu7t3v3__inv_2
Xgf180mcu_as_sc_mcu7t3v3__inv_2_518 VSS VSS gf180mcu_as_sc_mcu7t3v3__inv_2_518/Y gf180mcu_as_sc_mcu7t3v3__inv_2_518/A
+ gf180mcu_as_sc_mcu7t3v3__inv_2_562/VNW VSUBS gf180mcu_as_sc_mcu7t3v3__inv_2
Xgf180mcu_as_sc_mcu7t3v3__inv_2_1590 VSS VSS gf180mcu_as_sc_mcu7t3v3__inv_2_1590/Y
+ gf180mcu_as_sc_mcu7t3v3__inv_2_1591/Y gf180mcu_as_sc_mcu7t3v3__inv_2_1591/VNW VSUBS
+ gf180mcu_as_sc_mcu7t3v3__inv_2
Xgf180mcu_as_sc_mcu7t3v3__nand3_2_1 gf180mcu_as_sc_mcu7t3v3__nor2_2_6/VDD gf180mcu_as_sc_mcu7t3v3__nor2_2_6/VSS
+ VSS VSS VSS VSS gf180mcu_as_sc_mcu7t3v3__nor2_2_6/VNW VSUBS gf180mcu_as_sc_mcu7t3v3__nand3_2
Xgf180mcu_as_sc_mcu7t3v3__nand4_2_340 VSS VSS VSS VSS VSS VSS gf180mcu_as_sc_mcu7t3v3__inv_2_1145/A
+ gf180mcu_as_sc_mcu7t3v3__inv_2_1145/VNW VSUBS gf180mcu_as_sc_mcu7t3v3__nand4_2
Xgf180mcu_as_sc_mcu7t3v3__nand4_2_351 VSS VSS VSS VSS VSS VSS gf180mcu_as_sc_mcu7t3v3__inv_2_1159/A
+ gf180mcu_as_sc_mcu7t3v3__inv_2_1291/VNW VSUBS gf180mcu_as_sc_mcu7t3v3__nand4_2
Xgf180mcu_as_sc_mcu7t3v3__nand4_2_362 VSS VSS VSS VSS VSS VSS gf180mcu_as_sc_mcu7t3v3__inv_2_1179/A
+ gf180mcu_as_sc_mcu7t3v3__inv_2_1288/VNW VSUBS gf180mcu_as_sc_mcu7t3v3__nand4_2
Xgf180mcu_as_sc_mcu7t3v3__nand4_2_373 VSS VSS VSS VSS VSS VSS gf180mcu_as_sc_mcu7t3v3__inv_2_1217/A
+ gf180mcu_as_sc_mcu7t3v3__inv_2_1281/VNW VSUBS gf180mcu_as_sc_mcu7t3v3__nand4_2
Xgf180mcu_as_sc_mcu7t3v3__nand4_2_384 VSS VSS VSS VSS VSS VSS gf180mcu_as_sc_mcu7t3v3__inv_2_1422/A
+ gf180mcu_as_sc_mcu7t3v3__inv_2_1422/VNW VSUBS gf180mcu_as_sc_mcu7t3v3__nand4_2
Xgf180mcu_as_sc_mcu7t3v3__nand4_2_395 VSS VSS VSS VSS VSS VSS gf180mcu_as_sc_mcu7t3v3__inv_2_1455/A
+ gf180mcu_as_sc_mcu7t3v3__inv_2_1455/VNW VSUBS gf180mcu_as_sc_mcu7t3v3__nand4_2
Xgf180mcu_as_sc_mcu7t3v3__inv_2_304 VSS VSS gf180mcu_as_sc_mcu7t3v3__inv_2_304/Y gf180mcu_as_sc_mcu7t3v3__inv_2_304/A
+ gf180mcu_as_sc_mcu7t3v3__inv_2_304/VNW VSUBS gf180mcu_as_sc_mcu7t3v3__inv_2
Xgf180mcu_as_sc_mcu7t3v3__inv_2_359 VSS VSS gf180mcu_as_sc_mcu7t3v3__inv_2_359/Y gf180mcu_as_sc_mcu7t3v3__inv_2_359/A
+ gf180mcu_as_sc_mcu7t3v3__inv_2_359/VNW VSUBS gf180mcu_as_sc_mcu7t3v3__inv_2
Xgf180mcu_as_sc_mcu7t3v3__inv_2_348 VSS VSS VSS gf180mcu_as_sc_mcu7t3v3__inv_2_349/Y
+ gf180mcu_as_sc_mcu7t3v3__inv_2_350/VNW VSUBS gf180mcu_as_sc_mcu7t3v3__inv_2
Xgf180mcu_as_sc_mcu7t3v3__inv_2_337 VSS VSS gf180mcu_as_sc_mcu7t3v3__inv_2_337/Y gf180mcu_as_sc_mcu7t3v3__inv_2_338/Y
+ gf180mcu_as_sc_mcu7t3v3__inv_2_338/VNW VSUBS gf180mcu_as_sc_mcu7t3v3__inv_2
Xgf180mcu_as_sc_mcu7t3v3__inv_2_326 VSS VSS gf180mcu_as_sc_mcu7t3v3__inv_2_326/Y gf180mcu_as_sc_mcu7t3v3__inv_2_326/A
+ gf180mcu_as_sc_mcu7t3v3__inv_2_326/VNW VSUBS gf180mcu_as_sc_mcu7t3v3__inv_2
Xgf180mcu_as_sc_mcu7t3v3__inv_2_315 VSS VSS VSS gf180mcu_as_sc_mcu7t3v3__inv_2_316/Y
+ gf180mcu_as_sc_mcu7t3v3__inv_2_317/VNW VSUBS gf180mcu_as_sc_mcu7t3v3__inv_2
Xu_t027_009 u_t027_009/c0_w0_bl u_t027_009/c0_w0_br u_t027_009/c0_w1_bl u_t027_009/c0_w1_br
+ u_t027_009/c0_r0_rbl u_t027_009/c0_r1_rbl u_t027_009/c1_w0_bl u_t027_009/c1_w0_br
+ u_t027_009/c1_w1_bl u_t027_009/c1_w1_br u_t027_009/c1_r0_rbl u_t027_009/c1_r1_rbl
+ u_t027_009/c2_w0_bl u_t027_009/c2_w0_br u_t027_009/c2_w1_bl u_t027_009/c2_w1_br
+ u_t027_009/c2_r0_rbl u_t027_009/c2_r1_rbl u_t027_009/c3_w0_bl u_t027_009/c3_w0_br
+ u_t027_009/c3_w1_bl u_t027_009/c3_w1_br u_t027_009/c3_r0_rbl u_t027_009/c3_r1_rbl
+ u_t027_009/r0_w0_wl u_t027_009/r0_w1_wl u_t027_009/r0_r0_rwl u_t027_009/r0_r1_rwl
+ u_t027_009/r1_w0_wl u_t027_009/r1_w1_wl u_t027_009/r1_r0_rwl u_t027_009/r1_r1_rwl
+ u_t027_009/r2_w0_wl u_t027_009/r2_w1_wl u_t027_009/r2_r0_rwl u_t027_009/r2_r1_rwl
+ u_t027_009/r3_w0_wl u_t027_009/r3_w1_wl u_t027_009/r3_r0_rwl u_t027_009/r3_r1_rwl
+ VSS VSS u_t027_009/m2_717_1265# u_t027_009/m2_603_2031# u_t027_009/m2_1290_336#
+ u_t027_009/m2_2000_2037# u_t027_009/m2_791_2909# u_t027_009/m2_7_2126# u_t027_009/m2_2154_2081#
+ u_t027_009/m2_1795_2037# u_t027_009/m2_871_303# u_t027_009/m2_431_438# u_t027_009/m2_1290_2898#
+ u_t027_009/m2_1714_1210# u_t027_009/m2_431_1982# u_t027_009/m2_512_1265# u_t027_009/m2_2573_2126#
+ u_t027_009/m2_603_1259# u_t027_009/m2_2074_2909# u_t027_009/m2_7_336# u_t027_009/m2_717_2037#
+ u_t027_009/m2_1886_2031# u_t027_009/m2_2573_336# u_t027_009/m2_7_2898# u_t027_009/m2_2000_1265#
+ u_t027_009/m2_512_2037# u_t027_009/m2_1795_1265# u_t027_009/m2_1714_1982# u_t027_009/m2_1886_1259#
+ u_t027_009/m2_1290_2126# u_t027_009/m2_1714_438# u_t027_009/m2_431_1210# u_t027_009/m2_2573_2898#
+ u_t027_009/m2_2154_303# u_t027_009/m2_871_2081# VSUBS detronyx_12t_2w2r_rc4_4x4_routed_5layer_direct
Xgf180mcu_as_sc_mcu7t3v3__inv_2_860 VSS VSS gf180mcu_as_sc_mcu7t3v3__inv_2_937/A gf180mcu_as_sc_mcu7t3v3__inv_2_861/Y
+ gf180mcu_as_sc_mcu7t3v3__inv_2_937/VNW VSUBS gf180mcu_as_sc_mcu7t3v3__inv_2
Xgf180mcu_as_sc_mcu7t3v3__inv_2_882 VSS VSS gf180mcu_as_sc_mcu7t3v3__inv_2_882/Y gf180mcu_as_sc_mcu7t3v3__inv_2_882/A
+ gf180mcu_as_sc_mcu7t3v3__inv_2_933/VNW VSUBS gf180mcu_as_sc_mcu7t3v3__inv_2
Xgf180mcu_as_sc_mcu7t3v3__inv_2_871 VSS VSS gf180mcu_as_sc_mcu7t3v3__inv_2_871/Y gf180mcu_as_sc_mcu7t3v3__inv_2_871/A
+ gf180mcu_as_sc_mcu7t3v3__inv_2_929/VNW VSUBS gf180mcu_as_sc_mcu7t3v3__inv_2
Xgf180mcu_as_sc_mcu7t3v3__inv_2_893 VSS VSS gf180mcu_as_sc_mcu7t3v3__inv_2_893/Y gf180mcu_as_sc_mcu7t3v3__inv_2_893/A
+ gf180mcu_as_sc_mcu7t3v3__inv_2_925/VNW VSUBS gf180mcu_as_sc_mcu7t3v3__inv_2
Xu_t018_009 u_t018_009/c0_w0_bl u_t018_009/c0_w0_br u_t018_009/c0_w1_bl u_t018_009/c0_w1_br
+ u_t018_009/c0_r0_rbl u_t018_009/c0_r1_rbl u_t018_009/c1_w0_bl u_t018_009/c1_w0_br
+ u_t018_009/c1_w1_bl u_t018_009/c1_w1_br u_t018_009/c1_r0_rbl u_t018_009/c1_r1_rbl
+ u_t018_009/c2_w0_bl u_t018_009/c2_w0_br u_t018_009/c2_w1_bl u_t018_009/c2_w1_br
+ u_t018_009/c2_r0_rbl u_t018_009/c2_r1_rbl u_t018_009/c3_w0_bl u_t018_009/c3_w0_br
+ u_t018_009/c3_w1_bl u_t018_009/c3_w1_br u_t018_009/c3_r0_rbl u_t018_009/c3_r1_rbl
+ u_t018_009/r0_w0_wl u_t018_009/r0_w1_wl u_t018_009/r0_r0_rwl u_t018_009/r0_r1_rwl
+ u_t018_009/r1_w0_wl u_t018_009/r1_w1_wl u_t018_009/r1_r0_rwl u_t018_009/r1_r1_rwl
+ u_t018_009/r2_w0_wl u_t018_009/r2_w1_wl u_t018_009/r2_r0_rwl u_t018_009/r2_r1_rwl
+ u_t018_009/r3_w0_wl u_t018_009/r3_w1_wl u_t018_009/r3_r0_rwl u_t018_009/r3_r1_rwl
+ VSS VSS u_t018_009/m2_717_1265# u_t018_009/m2_603_2031# u_t018_009/m2_1290_336#
+ u_t018_009/m2_2000_2037# u_t018_009/m2_791_2909# u_t018_009/m2_7_2126# u_t018_009/m2_2154_2081#
+ u_t018_009/m2_1795_2037# u_t018_009/m2_871_303# u_t018_009/m2_431_438# u_t018_009/m2_1290_2898#
+ u_t018_009/m2_1714_1210# u_t018_009/m2_431_1982# u_t018_009/m2_512_1265# u_t018_009/m2_2573_2126#
+ u_t018_009/m2_603_1259# u_t018_009/m2_2074_2909# u_t018_009/m2_7_336# u_t018_009/m2_717_2037#
+ u_t018_009/m2_1886_2031# u_t018_009/m2_2573_336# u_t018_009/m2_7_2898# u_t018_009/m2_2000_1265#
+ u_t018_009/m2_512_2037# u_t018_009/m2_1795_1265# u_t018_009/m2_1714_1982# u_t018_009/m2_1886_1259#
+ u_t018_009/m2_1290_2126# u_t018_009/m2_1714_438# u_t018_009/m2_431_1210# u_t018_009/m2_2573_2898#
+ u_t018_009/m2_2154_303# u_t018_009/m2_871_2081# VSUBS detronyx_12t_2w2r_rc4_4x4_routed_5layer_direct
Xgf180mcu_as_sc_mcu7t3v3__nand4_2_170 VSS VSS VSS VSS VSS VSS gf180mcu_as_sc_mcu7t3v3__inv_2_602/A
+ gf180mcu_as_sc_mcu7t3v3__inv_2_602/VNW VSUBS gf180mcu_as_sc_mcu7t3v3__nand4_2
Xgf180mcu_as_sc_mcu7t3v3__nand4_2_181 VSS VSS VSS VSS VSS VSS gf180mcu_as_sc_mcu7t3v3__inv_2_696/A
+ gf180mcu_as_sc_mcu7t3v3__inv_2_733/VNW VSUBS gf180mcu_as_sc_mcu7t3v3__nand4_2
Xgf180mcu_as_sc_mcu7t3v3__nand4_2_192 VSS VSS VSS VSS VSS VSS gf180mcu_as_sc_mcu7t3v3__inv_2_740/A
+ gf180mcu_as_sc_mcu7t3v3__inv_2_740/VNW VSUBS gf180mcu_as_sc_mcu7t3v3__nand4_2
Xu_t009_009 u_t009_009/c0_w0_bl u_t009_009/c0_w0_br u_t009_009/c0_w1_bl u_t009_009/c0_w1_br
+ u_t009_009/c0_r0_rbl u_t009_009/c0_r1_rbl u_t009_009/c1_w0_bl u_t009_009/c1_w0_br
+ u_t009_009/c1_w1_bl u_t009_009/c1_w1_br u_t009_009/c1_r0_rbl u_t009_009/c1_r1_rbl
+ u_t009_009/c2_w0_bl u_t009_009/c2_w0_br u_t009_009/c2_w1_bl u_t009_009/c2_w1_br
+ u_t009_009/c2_r0_rbl u_t009_009/c2_r1_rbl u_t009_009/c3_w0_bl u_t009_009/c3_w0_br
+ u_t009_009/c3_w1_bl u_t009_009/c3_w1_br u_t009_009/c3_r0_rbl u_t009_009/c3_r1_rbl
+ u_t009_009/r0_w0_wl u_t009_009/r0_w1_wl u_t009_009/r0_r0_rwl u_t009_009/r0_r1_rwl
+ u_t009_009/r1_w0_wl u_t009_009/r1_w1_wl u_t009_009/r1_r0_rwl u_t009_009/r1_r1_rwl
+ u_t009_009/r2_w0_wl u_t009_009/r2_w1_wl u_t009_009/r2_r0_rwl u_t009_009/r2_r1_rwl
+ u_t009_009/r3_w0_wl u_t009_009/r3_w1_wl u_t009_009/r3_r0_rwl u_t009_009/r3_r1_rwl
+ VSS VSS u_t009_009/m2_717_1265# u_t009_009/m2_603_2031# u_t009_009/m2_1290_336#
+ u_t009_009/m2_2000_2037# u_t009_009/m2_791_2909# u_t009_009/m2_7_2126# u_t009_009/m2_2154_2081#
+ u_t009_009/m2_1795_2037# u_t009_009/m2_871_303# u_t009_009/m2_431_438# u_t009_009/m2_1290_2898#
+ u_t009_009/m2_1714_1210# u_t009_009/m2_431_1982# u_t009_009/m2_512_1265# u_t009_009/m2_2573_2126#
+ u_t009_009/m2_603_1259# u_t009_009/m2_2074_2909# u_t009_009/m2_7_336# u_t009_009/m2_717_2037#
+ u_t009_009/m2_1886_2031# u_t009_009/m2_2573_336# u_t009_009/m2_7_2898# u_t009_009/m2_2000_1265#
+ u_t009_009/m2_512_2037# u_t009_009/m2_1795_1265# u_t009_009/m2_1714_1982# u_t009_009/m2_1886_1259#
+ u_t009_009/m2_1290_2126# u_t009_009/m2_1714_438# u_t009_009/m2_431_1210# u_t009_009/m2_2573_2898#
+ u_t009_009/m2_2154_303# u_t009_009/m2_871_2081# VSUBS detronyx_12t_2w2r_rc4_4x4_routed_5layer_direct
Xgf180mcu_as_sc_mcu7t3v3__inv_2_101 VSS VSS VSS gf180mcu_as_sc_mcu7t3v3__inv_2_102/Y
+ gf180mcu_as_sc_mcu7t3v3__nand4_2_3/VNW VSUBS gf180mcu_as_sc_mcu7t3v3__inv_2
Xgf180mcu_as_sc_mcu7t3v3__inv_2_134 VSS VSS gf180mcu_as_sc_mcu7t3v3__inv_2_134/Y gf180mcu_as_sc_mcu7t3v3__inv_2_134/A
+ gf180mcu_as_sc_mcu7t3v3__inv_2_134/VNW VSUBS gf180mcu_as_sc_mcu7t3v3__inv_2
Xgf180mcu_as_sc_mcu7t3v3__inv_2_123 VSS VSS VSS gf180mcu_as_sc_mcu7t3v3__inv_2_124/Y
+ gf180mcu_as_sc_mcu7t3v3__inv_2_125/VNW VSUBS gf180mcu_as_sc_mcu7t3v3__inv_2
Xgf180mcu_as_sc_mcu7t3v3__inv_2_112 VSS VSS gf180mcu_as_sc_mcu7t3v3__inv_2_112/Y gf180mcu_as_sc_mcu7t3v3__inv_2_113/Y
+ gf180mcu_as_sc_mcu7t3v3__inv_2_113/VNW VSUBS gf180mcu_as_sc_mcu7t3v3__inv_2
Xgf180mcu_as_sc_mcu7t3v3__inv_2_145 VSS VSS gf180mcu_as_sc_mcu7t3v3__inv_2_145/Y gf180mcu_as_sc_mcu7t3v3__inv_2_146/Y
+ gf180mcu_as_sc_mcu7t3v3__inv_2_146/VNW VSUBS gf180mcu_as_sc_mcu7t3v3__inv_2
Xgf180mcu_as_sc_mcu7t3v3__inv_2_167 VSS VSS gf180mcu_as_sc_mcu7t3v3__inv_2_167/Y gf180mcu_as_sc_mcu7t3v3__inv_2_168/Y
+ gf180mcu_as_sc_mcu7t3v3__inv_2_168/VNW VSUBS gf180mcu_as_sc_mcu7t3v3__inv_2
Xgf180mcu_as_sc_mcu7t3v3__inv_2_178 VSS VSS VSS gf180mcu_as_sc_mcu7t3v3__inv_2_179/Y
+ gf180mcu_as_sc_mcu7t3v3__inv_2_180/VNW VSUBS gf180mcu_as_sc_mcu7t3v3__inv_2
Xgf180mcu_as_sc_mcu7t3v3__inv_2_189 VSS VSS gf180mcu_as_sc_mcu7t3v3__inv_2_189/Y gf180mcu_as_sc_mcu7t3v3__inv_2_190/Y
+ gf180mcu_as_sc_mcu7t3v3__inv_2_190/VNW VSUBS gf180mcu_as_sc_mcu7t3v3__inv_2
Xgf180mcu_as_sc_mcu7t3v3__inv_2_156 VSS VSS VSS gf180mcu_as_sc_mcu7t3v3__inv_2_164/Y
+ gf180mcu_as_sc_mcu7t3v3__inv_2_165/VNW VSUBS gf180mcu_as_sc_mcu7t3v3__inv_2
Xu_t023_012 u_t023_012/c0_w0_bl u_t023_012/c0_w0_br u_t023_012/c0_w1_bl u_t023_012/c0_w1_br
+ u_t023_012/c0_r0_rbl u_t023_012/c0_r1_rbl u_t023_012/c1_w0_bl u_t023_012/c1_w0_br
+ u_t023_012/c1_w1_bl u_t023_012/c1_w1_br u_t023_012/c1_r0_rbl u_t023_012/c1_r1_rbl
+ u_t023_012/c2_w0_bl u_t023_012/c2_w0_br u_t023_012/c2_w1_bl u_t023_012/c2_w1_br
+ u_t023_012/c2_r0_rbl u_t023_012/c2_r1_rbl u_t023_012/c3_w0_bl u_t023_012/c3_w0_br
+ u_t023_012/c3_w1_bl u_t023_012/c3_w1_br u_t023_012/c3_r0_rbl u_t023_012/c3_r1_rbl
+ u_t023_012/r0_w0_wl u_t023_012/r0_w1_wl u_t023_012/r0_r0_rwl u_t023_012/r0_r1_rwl
+ u_t023_012/r1_w0_wl u_t023_012/r1_w1_wl u_t023_012/r1_r0_rwl u_t023_012/r1_r1_rwl
+ u_t023_012/r2_w0_wl u_t023_012/r2_w1_wl u_t023_012/r2_r0_rwl u_t023_012/r2_r1_rwl
+ u_t023_012/r3_w0_wl u_t023_012/r3_w1_wl u_t023_012/r3_r0_rwl u_t023_012/r3_r1_rwl
+ VSS VSS u_t023_012/m2_717_1265# u_t023_012/m2_603_2031# u_t023_012/m2_1290_336#
+ u_t023_012/m2_2000_2037# u_t023_012/m2_791_2909# u_t023_012/m2_7_2126# u_t023_012/m2_2154_2081#
+ u_t023_012/m2_1795_2037# u_t023_012/m2_871_303# u_t023_012/m2_431_438# u_t023_012/m2_1290_2898#
+ u_t023_012/m2_1714_1210# u_t023_012/m2_431_1982# u_t023_012/m2_512_1265# u_t023_012/m2_2573_2126#
+ u_t023_012/m2_603_1259# u_t023_012/m2_2074_2909# u_t023_012/m2_7_336# u_t023_012/m2_717_2037#
+ u_t023_012/m2_1886_2031# u_t023_012/m2_2573_336# u_t023_012/m2_7_2898# u_t023_012/m2_2000_1265#
+ u_t023_012/m2_512_2037# u_t023_012/m2_1795_1265# u_t023_012/m2_1714_1982# u_t023_012/m2_1886_1259#
+ u_t023_012/m2_1290_2126# u_t023_012/m2_1714_438# u_t023_012/m2_431_1210# u_t023_012/m2_2573_2898#
+ u_t023_012/m2_2154_303# u_t023_012/m2_871_2081# VSUBS detronyx_12t_2w2r_rc4_4x4_routed_5layer_direct
Xu_t023_001 u_t023_001/c0_w0_bl u_t023_001/c0_w0_br u_t023_001/c0_w1_bl u_t023_001/c0_w1_br
+ u_t023_001/c0_r0_rbl u_t023_001/c0_r1_rbl u_t023_001/c1_w0_bl u_t023_001/c1_w0_br
+ u_t023_001/c1_w1_bl u_t023_001/c1_w1_br u_t023_001/c1_r0_rbl u_t023_001/c1_r1_rbl
+ u_t023_001/c2_w0_bl u_t023_001/c2_w0_br u_t023_001/c2_w1_bl u_t023_001/c2_w1_br
+ u_t023_001/c2_r0_rbl u_t023_001/c2_r1_rbl u_t023_001/c3_w0_bl u_t023_001/c3_w0_br
+ u_t023_001/c3_w1_bl u_t023_001/c3_w1_br u_t023_001/c3_r0_rbl u_t023_001/c3_r1_rbl
+ u_t023_001/r0_w0_wl u_t023_001/r0_w1_wl u_t023_001/r0_r0_rwl u_t023_001/r0_r1_rwl
+ u_t023_001/r1_w0_wl u_t023_001/r1_w1_wl u_t023_001/r1_r0_rwl u_t023_001/r1_r1_rwl
+ u_t023_001/r2_w0_wl u_t023_001/r2_w1_wl u_t023_001/r2_r0_rwl u_t023_001/r2_r1_rwl
+ u_t023_001/r3_w0_wl u_t023_001/r3_w1_wl u_t023_001/r3_r0_rwl u_t023_001/r3_r1_rwl
+ VSS VSS u_t023_001/m2_717_1265# u_t023_001/m2_603_2031# u_t023_001/m2_1290_336#
+ u_t023_001/m2_2000_2037# u_t023_001/m2_791_2909# u_t023_001/m2_7_2126# u_t023_001/m2_2154_2081#
+ u_t023_001/m2_1795_2037# u_t023_001/m2_871_303# u_t023_001/m2_431_438# u_t023_001/m2_1290_2898#
+ u_t023_001/m2_1714_1210# u_t023_001/m2_431_1982# u_t023_001/m2_512_1265# u_t023_001/m2_2573_2126#
+ u_t023_001/m2_603_1259# u_t023_001/m2_2074_2909# u_t023_001/m2_7_336# u_t023_001/m2_717_2037#
+ u_t023_001/m2_1886_2031# u_t023_001/m2_2573_336# u_t023_001/m2_7_2898# u_t023_001/m2_2000_1265#
+ u_t023_001/m2_512_2037# u_t023_001/m2_1795_1265# u_t023_001/m2_1714_1982# u_t023_001/m2_1886_1259#
+ u_t023_001/m2_1290_2126# u_t023_001/m2_1714_438# u_t023_001/m2_431_1210# u_t023_001/m2_2573_2898#
+ u_t023_001/m2_2154_303# u_t023_001/m2_871_2081# VSUBS detronyx_12t_2w2r_rc4_4x4_routed_5layer_direct
Xgf180mcu_as_sc_mcu7t3v3__inv_2_690 VSS VSS VSS gf180mcu_as_sc_mcu7t3v3__inv_2_691/Y
+ gf180mcu_as_sc_mcu7t3v3__inv_2_692/VNW VSUBS gf180mcu_as_sc_mcu7t3v3__inv_2
Xgf180mcu_as_sc_mcu7t3v3__nand2_2_46 gf180mcu_as_sc_mcu7t3v3__nor2_2_9/VDD gf180mcu_as_sc_mcu7t3v3__nand3_2_63/VSS
+ VSS VSS VSS gf180mcu_as_sc_mcu7t3v3__nor2_2_9/VNW VSUBS gf180mcu_as_sc_mcu7t3v3__nand2_2
Xgf180mcu_as_sc_mcu7t3v3__nand2_2_35 gf180mcu_as_sc_mcu7t3v3__nor2_2_9/VDD gf180mcu_as_sc_mcu7t3v3__nor2_2_9/VSS
+ VSS VSS VSS gf180mcu_as_sc_mcu7t3v3__nor2_2_9/VNW VSUBS gf180mcu_as_sc_mcu7t3v3__nand2_2
Xgf180mcu_as_sc_mcu7t3v3__nand2_2_13 gf180mcu_as_sc_mcu7t3v3__nor2_2_4/VDD gf180mcu_as_sc_mcu7t3v3__nand2_2_3/VSS
+ VSS VSS VSS gf180mcu_as_sc_mcu7t3v3__nor2_2_4/VNW VSUBS gf180mcu_as_sc_mcu7t3v3__nand2_2
Xgf180mcu_as_sc_mcu7t3v3__nand2_2_24 gf180mcu_as_sc_mcu7t3v3__nand3_2_9/VDD gf180mcu_as_sc_mcu7t3v3__nor2_2_7/VSS
+ VSS VSS VSS gf180mcu_as_sc_mcu7t3v3__nand3_2_9/VNW VSUBS gf180mcu_as_sc_mcu7t3v3__nand2_2
Xu_t014_012 u_t014_012/c0_w0_bl u_t014_012/c0_w0_br u_t014_012/c0_w1_bl u_t014_012/c0_w1_br
+ u_t014_012/c0_r0_rbl u_t014_012/c0_r1_rbl u_t014_012/c1_w0_bl u_t014_012/c1_w0_br
+ u_t014_012/c1_w1_bl u_t014_012/c1_w1_br u_t014_012/c1_r0_rbl u_t014_012/c1_r1_rbl
+ u_t014_012/c2_w0_bl u_t014_012/c2_w0_br u_t014_012/c2_w1_bl u_t014_012/c2_w1_br
+ u_t014_012/c2_r0_rbl u_t014_012/c2_r1_rbl u_t014_012/c3_w0_bl u_t014_012/c3_w0_br
+ u_t014_012/c3_w1_bl u_t014_012/c3_w1_br u_t014_012/c3_r0_rbl u_t014_012/c3_r1_rbl
+ u_t014_012/r0_w0_wl u_t014_012/r0_w1_wl u_t014_012/r0_r0_rwl u_t014_012/r0_r1_rwl
+ u_t014_012/r1_w0_wl u_t014_012/r1_w1_wl u_t014_012/r1_r0_rwl u_t014_012/r1_r1_rwl
+ u_t014_012/r2_w0_wl u_t014_012/r2_w1_wl u_t014_012/r2_r0_rwl u_t014_012/r2_r1_rwl
+ u_t014_012/r3_w0_wl u_t014_012/r3_w1_wl u_t014_012/r3_r0_rwl u_t014_012/r3_r1_rwl
+ VSS VSS u_t014_012/m2_717_1265# u_t014_012/m2_603_2031# u_t014_012/m2_1290_336#
+ u_t014_012/m2_2000_2037# u_t014_012/m2_791_2909# u_t014_012/m2_7_2126# u_t014_012/m2_2154_2081#
+ u_t014_012/m2_1795_2037# u_t014_012/m2_871_303# u_t014_012/m2_431_438# u_t014_012/m2_1290_2898#
+ u_t014_012/m2_1714_1210# u_t014_012/m2_431_1982# u_t014_012/m2_512_1265# u_t014_012/m2_2573_2126#
+ u_t014_012/m2_603_1259# u_t014_012/m2_2074_2909# u_t014_012/m2_7_336# u_t014_012/m2_717_2037#
+ u_t014_012/m2_1886_2031# u_t014_012/m2_2573_336# u_t014_012/m2_7_2898# u_t014_012/m2_2000_1265#
+ u_t014_012/m2_512_2037# u_t014_012/m2_1795_1265# u_t014_012/m2_1714_1982# u_t014_012/m2_1886_1259#
+ u_t014_012/m2_1290_2126# u_t014_012/m2_1714_438# u_t014_012/m2_431_1210# u_t014_012/m2_2573_2898#
+ u_t014_012/m2_2154_303# u_t014_012/m2_871_2081# VSUBS detronyx_12t_2w2r_rc4_4x4_routed_5layer_direct
Xu_t014_001 u_t014_001/c0_w0_bl u_t014_001/c0_w0_br u_t014_001/c0_w1_bl u_t014_001/c0_w1_br
+ u_t014_001/c0_r0_rbl u_t014_001/c0_r1_rbl u_t014_001/c1_w0_bl u_t014_001/c1_w0_br
+ u_t014_001/c1_w1_bl u_t014_001/c1_w1_br u_t014_001/c1_r0_rbl u_t014_001/c1_r1_rbl
+ u_t014_001/c2_w0_bl u_t014_001/c2_w0_br u_t014_001/c2_w1_bl u_t014_001/c2_w1_br
+ u_t014_001/c2_r0_rbl u_t014_001/c2_r1_rbl u_t014_001/c3_w0_bl u_t014_001/c3_w0_br
+ u_t014_001/c3_w1_bl u_t014_001/c3_w1_br u_t014_001/c3_r0_rbl u_t014_001/c3_r1_rbl
+ u_t014_001/r0_w0_wl u_t014_001/r0_w1_wl u_t014_001/r0_r0_rwl u_t014_001/r0_r1_rwl
+ u_t014_001/r1_w0_wl u_t014_001/r1_w1_wl u_t014_001/r1_r0_rwl u_t014_001/r1_r1_rwl
+ u_t014_001/r2_w0_wl u_t014_001/r2_w1_wl u_t014_001/r2_r0_rwl u_t014_001/r2_r1_rwl
+ u_t014_001/r3_w0_wl u_t014_001/r3_w1_wl u_t014_001/r3_r0_rwl u_t014_001/r3_r1_rwl
+ VSS VSS u_t014_001/m2_717_1265# u_t014_001/m2_603_2031# u_t014_001/m2_1290_336#
+ u_t014_001/m2_2000_2037# u_t014_001/m2_791_2909# u_t014_001/m2_7_2126# u_t014_001/m2_2154_2081#
+ u_t014_001/m2_1795_2037# u_t014_001/m2_871_303# u_t014_001/m2_431_438# u_t014_001/m2_1290_2898#
+ u_t014_001/m2_1714_1210# u_t014_001/m2_431_1982# u_t014_001/m2_512_1265# u_t014_001/m2_2573_2126#
+ u_t014_001/m2_603_1259# u_t014_001/m2_2074_2909# u_t014_001/m2_7_336# u_t014_001/m2_717_2037#
+ u_t014_001/m2_1886_2031# u_t014_001/m2_2573_336# u_t014_001/m2_7_2898# u_t014_001/m2_2000_1265#
+ u_t014_001/m2_512_2037# u_t014_001/m2_1795_1265# u_t014_001/m2_1714_1982# u_t014_001/m2_1886_1259#
+ u_t014_001/m2_1290_2126# u_t014_001/m2_1714_438# u_t014_001/m2_431_1210# u_t014_001/m2_2573_2898#
+ u_t014_001/m2_2154_303# u_t014_001/m2_871_2081# VSUBS detronyx_12t_2w2r_rc4_4x4_routed_5layer_direct
Xu_t005_012 u_t005_012/c0_w0_bl u_t005_012/c0_w0_br u_t005_012/c0_w1_bl u_t005_012/c0_w1_br
+ u_t005_012/c0_r0_rbl u_t005_012/c0_r1_rbl u_t005_012/c1_w0_bl u_t005_012/c1_w0_br
+ u_t005_012/c1_w1_bl u_t005_012/c1_w1_br u_t005_012/c1_r0_rbl u_t005_012/c1_r1_rbl
+ u_t005_012/c2_w0_bl u_t005_012/c2_w0_br u_t005_012/c2_w1_bl u_t005_012/c2_w1_br
+ u_t005_012/c2_r0_rbl u_t005_012/c2_r1_rbl u_t005_012/c3_w0_bl u_t005_012/c3_w0_br
+ u_t005_012/c3_w1_bl u_t005_012/c3_w1_br u_t005_012/c3_r0_rbl u_t005_012/c3_r1_rbl
+ u_t005_012/r0_w0_wl u_t005_012/r0_w1_wl u_t005_012/r0_r0_rwl u_t005_012/r0_r1_rwl
+ u_t005_012/r1_w0_wl u_t005_012/r1_w1_wl u_t005_012/r1_r0_rwl u_t005_012/r1_r1_rwl
+ u_t005_012/r2_w0_wl u_t005_012/r2_w1_wl u_t005_012/r2_r0_rwl u_t005_012/r2_r1_rwl
+ u_t005_012/r3_w0_wl u_t005_012/r3_w1_wl u_t005_012/r3_r0_rwl u_t005_012/r3_r1_rwl
+ VSS VSS u_t005_012/m2_717_1265# u_t005_012/m2_603_2031# u_t005_012/m2_1290_336#
+ u_t005_012/m2_2000_2037# u_t005_012/m2_791_2909# u_t005_012/m2_7_2126# u_t005_012/m2_2154_2081#
+ u_t005_012/m2_1795_2037# u_t005_012/m2_871_303# u_t005_012/m2_431_438# u_t005_012/m2_1290_2898#
+ u_t005_012/m2_1714_1210# u_t005_012/m2_431_1982# u_t005_012/m2_512_1265# u_t005_012/m2_2573_2126#
+ u_t005_012/m2_603_1259# u_t005_012/m2_2074_2909# u_t005_012/m2_7_336# u_t005_012/m2_717_2037#
+ u_t005_012/m2_1886_2031# u_t005_012/m2_2573_336# u_t005_012/m2_7_2898# u_t005_012/m2_2000_1265#
+ u_t005_012/m2_512_2037# u_t005_012/m2_1795_1265# u_t005_012/m2_1714_1982# u_t005_012/m2_1886_1259#
+ u_t005_012/m2_1290_2126# u_t005_012/m2_1714_438# u_t005_012/m2_431_1210# u_t005_012/m2_2573_2898#
+ u_t005_012/m2_2154_303# u_t005_012/m2_871_2081# VSUBS detronyx_12t_2w2r_rc4_4x4_routed_5layer_direct
Xu_t005_001 u_t005_001/c0_w0_bl u_t005_001/c0_w0_br u_t005_001/c0_w1_bl u_t005_001/c0_w1_br
+ u_t005_001/c0_r0_rbl u_t005_001/c0_r1_rbl u_t005_001/c1_w0_bl u_t005_001/c1_w0_br
+ u_t005_001/c1_w1_bl u_t005_001/c1_w1_br u_t005_001/c1_r0_rbl u_t005_001/c1_r1_rbl
+ u_t005_001/c2_w0_bl u_t005_001/c2_w0_br u_t005_001/c2_w1_bl u_t005_001/c2_w1_br
+ u_t005_001/c2_r0_rbl u_t005_001/c2_r1_rbl u_t005_001/c3_w0_bl u_t005_001/c3_w0_br
+ u_t005_001/c3_w1_bl u_t005_001/c3_w1_br u_t005_001/c3_r0_rbl u_t005_001/c3_r1_rbl
+ u_t005_001/r0_w0_wl u_t005_001/r0_w1_wl u_t005_001/r0_r0_rwl u_t005_001/r0_r1_rwl
+ u_t005_001/r1_w0_wl u_t005_001/r1_w1_wl u_t005_001/r1_r0_rwl u_t005_001/r1_r1_rwl
+ u_t005_001/r2_w0_wl u_t005_001/r2_w1_wl u_t005_001/r2_r0_rwl u_t005_001/r2_r1_rwl
+ u_t005_001/r3_w0_wl u_t005_001/r3_w1_wl u_t005_001/r3_r0_rwl u_t005_001/r3_r1_rwl
+ VSS VSS u_t005_001/m2_717_1265# u_t005_001/m2_603_2031# u_t005_001/m2_1290_336#
+ u_t005_001/m2_2000_2037# u_t005_001/m2_791_2909# u_t005_001/m2_7_2126# u_t005_001/m2_2154_2081#
+ u_t005_001/m2_1795_2037# u_t005_001/m2_871_303# u_t005_001/m2_431_438# u_t005_001/m2_1290_2898#
+ u_t005_001/m2_1714_1210# u_t005_001/m2_431_1982# u_t005_001/m2_512_1265# u_t005_001/m2_2573_2126#
+ u_t005_001/m2_603_1259# u_t005_001/m2_2074_2909# u_t005_001/m2_7_336# u_t005_001/m2_717_2037#
+ u_t005_001/m2_1886_2031# u_t005_001/m2_2573_336# u_t005_001/m2_7_2898# u_t005_001/m2_2000_1265#
+ u_t005_001/m2_512_2037# u_t005_001/m2_1795_1265# u_t005_001/m2_1714_1982# u_t005_001/m2_1886_1259#
+ u_t005_001/m2_1290_2126# u_t005_001/m2_1714_438# u_t005_001/m2_431_1210# u_t005_001/m2_2573_2898#
+ u_t005_001/m2_2154_303# u_t005_001/m2_871_2081# VSUBS detronyx_12t_2w2r_rc4_4x4_routed_5layer_direct
Xu_t020_015 u_t020_015/c0_w0_bl u_t020_015/c0_w0_br u_t020_015/c0_w1_bl u_t020_015/c0_w1_br
+ u_t020_015/c0_r0_rbl u_t020_015/c0_r1_rbl u_t020_015/c1_w0_bl u_t020_015/c1_w0_br
+ u_t020_015/c1_w1_bl u_t020_015/c1_w1_br u_t020_015/c1_r0_rbl u_t020_015/c1_r1_rbl
+ u_t020_015/c2_w0_bl u_t020_015/c2_w0_br u_t020_015/c2_w1_bl u_t020_015/c2_w1_br
+ u_t020_015/c2_r0_rbl u_t020_015/c2_r1_rbl u_t020_015/c3_w0_bl u_t020_015/c3_w0_br
+ u_t020_015/c3_w1_bl u_t020_015/c3_w1_br u_t020_015/c3_r0_rbl u_t020_015/c3_r1_rbl
+ u_t020_015/r0_w0_wl u_t020_015/r0_w1_wl u_t020_015/r0_r0_rwl u_t020_015/r0_r1_rwl
+ u_t020_015/r1_w0_wl u_t020_015/r1_w1_wl u_t020_015/r1_r0_rwl u_t020_015/r1_r1_rwl
+ u_t020_015/r2_w0_wl u_t020_015/r2_w1_wl u_t020_015/r2_r0_rwl u_t020_015/r2_r1_rwl
+ u_t020_015/r3_w0_wl u_t020_015/r3_w1_wl u_t020_015/r3_r0_rwl u_t020_015/r3_r1_rwl
+ VSS VSS u_t020_015/m2_717_1265# u_t020_015/m2_603_2031# u_t020_015/m2_1290_336#
+ u_t020_015/m2_2000_2037# u_t020_015/m2_791_2909# u_t020_015/m2_7_2126# u_t020_015/m2_2154_2081#
+ u_t020_015/m2_1795_2037# u_t020_015/m2_871_303# u_t020_015/m2_431_438# u_t020_015/m2_1290_2898#
+ u_t020_015/m2_1714_1210# u_t020_015/m2_431_1982# u_t020_015/m2_512_1265# u_t020_015/m2_2573_2126#
+ u_t020_015/m2_603_1259# u_t020_015/m2_2074_2909# u_t020_015/m2_7_336# u_t020_015/m2_717_2037#
+ u_t020_015/m2_1886_2031# u_t020_015/m2_2573_336# u_t020_015/m2_7_2898# u_t020_015/m2_2000_1265#
+ u_t020_015/m2_512_2037# u_t020_015/m2_1795_1265# u_t020_015/m2_1714_1982# u_t020_015/m2_1886_1259#
+ u_t020_015/m2_1290_2126# u_t020_015/m2_1714_438# u_t020_015/m2_431_1210# u_t020_015/m2_2573_2898#
+ u_t020_015/m2_2154_303# u_t020_015/m2_871_2081# VSUBS detronyx_12t_2w2r_rc4_4x4_routed_5layer_direct
Xu_t020_004 u_t020_004/c0_w0_bl u_t020_004/c0_w0_br u_t020_004/c0_w1_bl u_t020_004/c0_w1_br
+ u_t020_004/c0_r0_rbl u_t020_004/c0_r1_rbl u_t020_004/c1_w0_bl u_t020_004/c1_w0_br
+ u_t020_004/c1_w1_bl u_t020_004/c1_w1_br u_t020_004/c1_r0_rbl u_t020_004/c1_r1_rbl
+ u_t020_004/c2_w0_bl u_t020_004/c2_w0_br u_t020_004/c2_w1_bl u_t020_004/c2_w1_br
+ u_t020_004/c2_r0_rbl u_t020_004/c2_r1_rbl u_t020_004/c3_w0_bl u_t020_004/c3_w0_br
+ u_t020_004/c3_w1_bl u_t020_004/c3_w1_br u_t020_004/c3_r0_rbl u_t020_004/c3_r1_rbl
+ u_t020_004/r0_w0_wl u_t020_004/r0_w1_wl u_t020_004/r0_r0_rwl u_t020_004/r0_r1_rwl
+ u_t020_004/r1_w0_wl u_t020_004/r1_w1_wl u_t020_004/r1_r0_rwl u_t020_004/r1_r1_rwl
+ u_t020_004/r2_w0_wl u_t020_004/r2_w1_wl u_t020_004/r2_r0_rwl u_t020_004/r2_r1_rwl
+ u_t020_004/r3_w0_wl u_t020_004/r3_w1_wl u_t020_004/r3_r0_rwl u_t020_004/r3_r1_rwl
+ VSS VSS u_t020_004/m2_717_1265# u_t020_004/m2_603_2031# u_t020_004/m2_1290_336#
+ u_t020_004/m2_2000_2037# u_t020_004/m2_791_2909# u_t020_004/m2_7_2126# u_t020_004/m2_2154_2081#
+ u_t020_004/m2_1795_2037# u_t020_004/m2_871_303# u_t020_004/m2_431_438# u_t020_004/m2_1290_2898#
+ u_t020_004/m2_1714_1210# u_t020_004/m2_431_1982# u_t020_004/m2_512_1265# u_t020_004/m2_2573_2126#
+ u_t020_004/m2_603_1259# u_t020_004/m2_2074_2909# u_t020_004/m2_7_336# u_t020_004/m2_717_2037#
+ u_t020_004/m2_1886_2031# u_t020_004/m2_2573_336# u_t020_004/m2_7_2898# u_t020_004/m2_2000_1265#
+ u_t020_004/m2_512_2037# u_t020_004/m2_1795_1265# u_t020_004/m2_1714_1982# u_t020_004/m2_1886_1259#
+ u_t020_004/m2_1290_2126# u_t020_004/m2_1714_438# u_t020_004/m2_431_1210# u_t020_004/m2_2573_2898#
+ u_t020_004/m2_2154_303# u_t020_004/m2_871_2081# VSUBS detronyx_12t_2w2r_rc4_4x4_routed_5layer_direct
Xgf180mcu_as_sc_mcu7t3v3__inv_2_1408 VSS VSS gf180mcu_as_sc_mcu7t3v3__inv_2_1408/Y
+ gf180mcu_as_sc_mcu7t3v3__inv_2_1408/A gf180mcu_as_sc_mcu7t3v3__inv_2_1409/VNW VSUBS
+ gf180mcu_as_sc_mcu7t3v3__inv_2
Xgf180mcu_as_sc_mcu7t3v3__inv_2_1419 VSS VSS gf180mcu_as_sc_mcu7t3v3__inv_2_1419/Y
+ gf180mcu_as_sc_mcu7t3v3__inv_2_1419/A gf180mcu_as_sc_mcu7t3v3__inv_2_1419/VNW VSUBS
+ gf180mcu_as_sc_mcu7t3v3__inv_2
Xu_t011_015 u_t011_015/c0_w0_bl u_t011_015/c0_w0_br u_t011_015/c0_w1_bl u_t011_015/c0_w1_br
+ u_t011_015/c0_r0_rbl u_t011_015/c0_r1_rbl u_t011_015/c1_w0_bl u_t011_015/c1_w0_br
+ u_t011_015/c1_w1_bl u_t011_015/c1_w1_br u_t011_015/c1_r0_rbl u_t011_015/c1_r1_rbl
+ u_t011_015/c2_w0_bl u_t011_015/c2_w0_br u_t011_015/c2_w1_bl u_t011_015/c2_w1_br
+ u_t011_015/c2_r0_rbl u_t011_015/c2_r1_rbl u_t011_015/c3_w0_bl u_t011_015/c3_w0_br
+ u_t011_015/c3_w1_bl u_t011_015/c3_w1_br u_t011_015/c3_r0_rbl u_t011_015/c3_r1_rbl
+ u_t011_015/r0_w0_wl u_t011_015/r0_w1_wl u_t011_015/r0_r0_rwl u_t011_015/r0_r1_rwl
+ u_t011_015/r1_w0_wl u_t011_015/r1_w1_wl u_t011_015/r1_r0_rwl u_t011_015/r1_r1_rwl
+ u_t011_015/r2_w0_wl u_t011_015/r2_w1_wl u_t011_015/r2_r0_rwl u_t011_015/r2_r1_rwl
+ u_t011_015/r3_w0_wl u_t011_015/r3_w1_wl u_t011_015/r3_r0_rwl u_t011_015/r3_r1_rwl
+ VSS VSS u_t011_015/m2_717_1265# u_t011_015/m2_603_2031# u_t011_015/m2_1290_336#
+ u_t011_015/m2_2000_2037# u_t011_015/m2_791_2909# u_t011_015/m2_7_2126# u_t011_015/m2_2154_2081#
+ u_t011_015/m2_1795_2037# u_t011_015/m2_871_303# u_t011_015/m2_431_438# u_t011_015/m2_1290_2898#
+ u_t011_015/m2_1714_1210# u_t011_015/m2_431_1982# u_t011_015/m2_512_1265# u_t011_015/m2_2573_2126#
+ u_t011_015/m2_603_1259# u_t011_015/m2_2074_2909# u_t011_015/m2_7_336# u_t011_015/m2_717_2037#
+ u_t011_015/m2_1886_2031# u_t011_015/m2_2573_336# u_t011_015/m2_7_2898# u_t011_015/m2_2000_1265#
+ u_t011_015/m2_512_2037# u_t011_015/m2_1795_1265# u_t011_015/m2_1714_1982# u_t011_015/m2_1886_1259#
+ u_t011_015/m2_1290_2126# u_t011_015/m2_1714_438# u_t011_015/m2_431_1210# u_t011_015/m2_2573_2898#
+ u_t011_015/m2_2154_303# u_t011_015/m2_871_2081# VSUBS detronyx_12t_2w2r_rc4_4x4_routed_5layer_direct
Xu_t011_004 u_t011_004/c0_w0_bl u_t011_004/c0_w0_br u_t011_004/c0_w1_bl u_t011_004/c0_w1_br
+ u_t011_004/c0_r0_rbl u_t011_004/c0_r1_rbl u_t011_004/c1_w0_bl u_t011_004/c1_w0_br
+ u_t011_004/c1_w1_bl u_t011_004/c1_w1_br u_t011_004/c1_r0_rbl u_t011_004/c1_r1_rbl
+ u_t011_004/c2_w0_bl u_t011_004/c2_w0_br u_t011_004/c2_w1_bl u_t011_004/c2_w1_br
+ u_t011_004/c2_r0_rbl u_t011_004/c2_r1_rbl u_t011_004/c3_w0_bl u_t011_004/c3_w0_br
+ u_t011_004/c3_w1_bl u_t011_004/c3_w1_br u_t011_004/c3_r0_rbl u_t011_004/c3_r1_rbl
+ u_t011_004/r0_w0_wl u_t011_004/r0_w1_wl u_t011_004/r0_r0_rwl u_t011_004/r0_r1_rwl
+ u_t011_004/r1_w0_wl u_t011_004/r1_w1_wl u_t011_004/r1_r0_rwl u_t011_004/r1_r1_rwl
+ u_t011_004/r2_w0_wl u_t011_004/r2_w1_wl u_t011_004/r2_r0_rwl u_t011_004/r2_r1_rwl
+ u_t011_004/r3_w0_wl u_t011_004/r3_w1_wl u_t011_004/r3_r0_rwl u_t011_004/r3_r1_rwl
+ VSS VSS u_t011_004/m2_717_1265# u_t011_004/m2_603_2031# u_t011_004/m2_1290_336#
+ u_t011_004/m2_2000_2037# u_t011_004/m2_791_2909# u_t011_004/m2_7_2126# u_t011_004/m2_2154_2081#
+ u_t011_004/m2_1795_2037# u_t011_004/m2_871_303# u_t011_004/m2_431_438# u_t011_004/m2_1290_2898#
+ u_t011_004/m2_1714_1210# u_t011_004/m2_431_1982# u_t011_004/m2_512_1265# u_t011_004/m2_2573_2126#
+ u_t011_004/m2_603_1259# u_t011_004/m2_2074_2909# u_t011_004/m2_7_336# u_t011_004/m2_717_2037#
+ u_t011_004/m2_1886_2031# u_t011_004/m2_2573_336# u_t011_004/m2_7_2898# u_t011_004/m2_2000_1265#
+ u_t011_004/m2_512_2037# u_t011_004/m2_1795_1265# u_t011_004/m2_1714_1982# u_t011_004/m2_1886_1259#
+ u_t011_004/m2_1290_2126# u_t011_004/m2_1714_438# u_t011_004/m2_431_1210# u_t011_004/m2_2573_2898#
+ u_t011_004/m2_2154_303# u_t011_004/m2_871_2081# VSUBS detronyx_12t_2w2r_rc4_4x4_routed_5layer_direct
Xu_t002_015 u_t002_015/c0_w0_bl u_t002_015/c0_w0_br u_t002_015/c0_w1_bl u_t002_015/c0_w1_br
+ u_t002_015/c0_r0_rbl u_t002_015/c0_r1_rbl u_t002_015/c1_w0_bl u_t002_015/c1_w0_br
+ u_t002_015/c1_w1_bl u_t002_015/c1_w1_br u_t002_015/c1_r0_rbl u_t002_015/c1_r1_rbl
+ u_t002_015/c2_w0_bl u_t002_015/c2_w0_br u_t002_015/c2_w1_bl u_t002_015/c2_w1_br
+ u_t002_015/c2_r0_rbl u_t002_015/c2_r1_rbl u_t002_015/c3_w0_bl u_t002_015/c3_w0_br
+ u_t002_015/c3_w1_bl u_t002_015/c3_w1_br u_t002_015/c3_r0_rbl u_t002_015/c3_r1_rbl
+ u_t002_015/r0_w0_wl u_t002_015/r0_w1_wl u_t002_015/r0_r0_rwl u_t002_015/r0_r1_rwl
+ u_t002_015/r1_w0_wl u_t002_015/r1_w1_wl u_t002_015/r1_r0_rwl u_t002_015/r1_r1_rwl
+ u_t002_015/r2_w0_wl u_t002_015/r2_w1_wl u_t002_015/r2_r0_rwl u_t002_015/r2_r1_rwl
+ u_t002_015/r3_w0_wl u_t002_015/r3_w1_wl u_t002_015/r3_r0_rwl u_t002_015/r3_r1_rwl
+ VSS VSS u_t002_015/m2_717_1265# u_t002_015/m2_603_2031# u_t002_015/m2_1290_336#
+ u_t002_015/m2_2000_2037# u_t002_015/m2_791_2909# u_t002_015/m2_7_2126# u_t002_015/m2_2154_2081#
+ u_t002_015/m2_1795_2037# u_t002_015/m2_871_303# u_t002_015/m2_431_438# u_t002_015/m2_1290_2898#
+ u_t002_015/m2_1714_1210# u_t002_015/m2_431_1982# u_t002_015/m2_512_1265# u_t002_015/m2_2573_2126#
+ u_t002_015/m2_603_1259# u_t002_015/m2_2074_2909# u_t002_015/m2_7_336# u_t002_015/m2_717_2037#
+ u_t002_015/m2_1886_2031# u_t002_015/m2_2573_336# u_t002_015/m2_7_2898# u_t002_015/m2_2000_1265#
+ u_t002_015/m2_512_2037# u_t002_015/m2_1795_1265# u_t002_015/m2_1714_1982# u_t002_015/m2_1886_1259#
+ u_t002_015/m2_1290_2126# u_t002_015/m2_1714_438# u_t002_015/m2_431_1210# u_t002_015/m2_2573_2898#
+ u_t002_015/m2_2154_303# u_t002_015/m2_871_2081# VSUBS detronyx_12t_2w2r_rc4_4x4_routed_5layer_direct
Xu_t002_004 u_t002_004/c0_w0_bl u_t002_004/c0_w0_br u_t002_004/c0_w1_bl u_t002_004/c0_w1_br
+ u_t002_004/c0_r0_rbl u_t002_004/c0_r1_rbl u_t002_004/c1_w0_bl u_t002_004/c1_w0_br
+ u_t002_004/c1_w1_bl u_t002_004/c1_w1_br u_t002_004/c1_r0_rbl u_t002_004/c1_r1_rbl
+ u_t002_004/c2_w0_bl u_t002_004/c2_w0_br u_t002_004/c2_w1_bl u_t002_004/c2_w1_br
+ u_t002_004/c2_r0_rbl u_t002_004/c2_r1_rbl u_t002_004/c3_w0_bl u_t002_004/c3_w0_br
+ u_t002_004/c3_w1_bl u_t002_004/c3_w1_br u_t002_004/c3_r0_rbl u_t002_004/c3_r1_rbl
+ u_t002_004/r0_w0_wl u_t002_004/r0_w1_wl u_t002_004/r0_r0_rwl u_t002_004/r0_r1_rwl
+ u_t002_004/r1_w0_wl u_t002_004/r1_w1_wl u_t002_004/r1_r0_rwl u_t002_004/r1_r1_rwl
+ u_t002_004/r2_w0_wl u_t002_004/r2_w1_wl u_t002_004/r2_r0_rwl u_t002_004/r2_r1_rwl
+ u_t002_004/r3_w0_wl u_t002_004/r3_w1_wl u_t002_004/r3_r0_rwl u_t002_004/r3_r1_rwl
+ VSS VSS u_t002_004/m2_717_1265# u_t002_004/m2_603_2031# u_t002_004/m2_1290_336#
+ u_t002_004/m2_2000_2037# u_t002_004/m2_791_2909# u_t002_004/m2_7_2126# u_t002_004/m2_2154_2081#
+ u_t002_004/m2_1795_2037# u_t002_004/m2_871_303# u_t002_004/m2_431_438# u_t002_004/m2_1290_2898#
+ u_t002_004/m2_1714_1210# u_t002_004/m2_431_1982# u_t002_004/m2_512_1265# u_t002_004/m2_2573_2126#
+ u_t002_004/m2_603_1259# u_t002_004/m2_2074_2909# u_t002_004/m2_7_336# u_t002_004/m2_717_2037#
+ u_t002_004/m2_1886_2031# u_t002_004/m2_2573_336# u_t002_004/m2_7_2898# u_t002_004/m2_2000_1265#
+ u_t002_004/m2_512_2037# u_t002_004/m2_1795_1265# u_t002_004/m2_1714_1982# u_t002_004/m2_1886_1259#
+ u_t002_004/m2_1290_2126# u_t002_004/m2_1714_438# u_t002_004/m2_431_1210# u_t002_004/m2_2573_2898#
+ u_t002_004/m2_2154_303# u_t002_004/m2_871_2081# VSUBS detronyx_12t_2w2r_rc4_4x4_routed_5layer_direct
Xgf180mcu_as_sc_mcu7t3v3__inv_2_1249 gf180mcu_as_sc_mcu7t3v3__nor2_2_9/VDD gf180mcu_as_sc_mcu7t3v3__nand3_2_63/VSS
+ VSS VSS gf180mcu_as_sc_mcu7t3v3__nor2_2_9/VNW VSUBS gf180mcu_as_sc_mcu7t3v3__inv_2
Xgf180mcu_as_sc_mcu7t3v3__inv_2_1238 gf180mcu_as_sc_mcu7t3v3__nor2_2_9/VDD gf180mcu_as_sc_mcu7t3v3__nand3_2_63/VSS
+ VSS VSS gf180mcu_as_sc_mcu7t3v3__nor2_2_9/VNW VSUBS gf180mcu_as_sc_mcu7t3v3__inv_2
Xgf180mcu_as_sc_mcu7t3v3__inv_2_1205 gf180mcu_as_sc_mcu7t3v3__nor2_2_9/VDD gf180mcu_as_sc_mcu7t3v3__nor2_2_9/VSS
+ VSS VSS gf180mcu_as_sc_mcu7t3v3__nor2_2_9/VNW VSUBS gf180mcu_as_sc_mcu7t3v3__inv_2
Xgf180mcu_as_sc_mcu7t3v3__inv_2_1216 gf180mcu_as_sc_mcu7t3v3__nand3_2_65/VDD gf180mcu_as_sc_mcu7t3v3__nor2_2_9/VSS
+ VSS VSS gf180mcu_as_sc_mcu7t3v3__nand3_2_65/VNW VSUBS gf180mcu_as_sc_mcu7t3v3__inv_2
Xgf180mcu_as_sc_mcu7t3v3__inv_2_1227 VSS VSS gf180mcu_as_sc_mcu7t3v3__inv_2_1227/Y
+ gf180mcu_as_sc_mcu7t3v3__inv_2_1227/A gf180mcu_as_sc_mcu7t3v3__inv_2_1277/VNW VSUBS
+ gf180mcu_as_sc_mcu7t3v3__inv_2
Xgf180mcu_as_sc_mcu7t3v3__nand4_2_500 VSS VSS VSS VSS VSS VSS gf180mcu_as_sc_mcu7t3v3__inv_2_1638/A
+ gf180mcu_as_sc_mcu7t3v3__inv_2_1638/VNW VSUBS gf180mcu_as_sc_mcu7t3v3__nand4_2
Xgf180mcu_as_sc_mcu7t3v3__nand4_2_511 VSS VSS VSS VSS VSS VSS gf180mcu_as_sc_mcu7t3v3__inv_2_1720/A
+ gf180mcu_as_sc_mcu7t3v3__inv_2_1720/VNW VSUBS gf180mcu_as_sc_mcu7t3v3__nand4_2
Xgf180mcu_as_sc_mcu7t3v3__inv_2_1013 VSS VSS gf180mcu_as_sc_mcu7t3v3__inv_2_1013/Y
+ gf180mcu_as_sc_mcu7t3v3__inv_2_1013/A gf180mcu_as_sc_mcu7t3v3__inv_2_1058/VNW VSUBS
+ gf180mcu_as_sc_mcu7t3v3__inv_2
Xgf180mcu_as_sc_mcu7t3v3__inv_2_32 VSS VSS gf180mcu_as_sc_mcu7t3v3__inv_2_32/Y gf180mcu_as_sc_mcu7t3v3__inv_2_32/A
+ gf180mcu_as_sc_mcu7t3v3__inv_2_32/VNW VSUBS gf180mcu_as_sc_mcu7t3v3__inv_2
Xgf180mcu_as_sc_mcu7t3v3__inv_2_10 VSS VSS VSS gf180mcu_as_sc_mcu7t3v3__inv_2_11/Y
+ gf180mcu_as_sc_mcu7t3v3__inv_2_12/VNW VSUBS gf180mcu_as_sc_mcu7t3v3__inv_2
Xgf180mcu_as_sc_mcu7t3v3__inv_2_98 VSS VSS VSS gf180mcu_as_sc_mcu7t3v3__inv_2_98/A
+ gf180mcu_as_sc_mcu7t3v3__inv_2_98/VNW VSUBS gf180mcu_as_sc_mcu7t3v3__inv_2
Xgf180mcu_as_sc_mcu7t3v3__inv_2_87 VSS VSS gf180mcu_as_sc_mcu7t3v3__inv_2_87/Y gf180mcu_as_sc_mcu7t3v3__inv_2_87/A
+ gf180mcu_as_sc_mcu7t3v3__inv_2_98/VNW VSUBS gf180mcu_as_sc_mcu7t3v3__inv_2
Xgf180mcu_as_sc_mcu7t3v3__inv_2_43 VSS VSS gf180mcu_as_sc_mcu7t3v3__inv_2_43/Y gf180mcu_as_sc_mcu7t3v3__inv_2_43/A
+ gf180mcu_as_sc_mcu7t3v3__inv_2_43/VNW VSUBS gf180mcu_as_sc_mcu7t3v3__inv_2
Xgf180mcu_as_sc_mcu7t3v3__inv_2_54 VSS VSS VSS gf180mcu_as_sc_mcu7t3v3__inv_2_58/Y
+ gf180mcu_as_sc_mcu7t3v3__inv_2_62/VNW VSUBS gf180mcu_as_sc_mcu7t3v3__inv_2
Xgf180mcu_as_sc_mcu7t3v3__inv_2_21 VSS VSS gf180mcu_as_sc_mcu7t3v3__inv_2_21/Y gf180mcu_as_sc_mcu7t3v3__inv_2_25/Y
+ gf180mcu_as_sc_mcu7t3v3__inv_2_25/VNW VSUBS gf180mcu_as_sc_mcu7t3v3__inv_2
Xgf180mcu_as_sc_mcu7t3v3__inv_2_76 VSS VSS gf180mcu_as_sc_mcu7t3v3__inv_2_76/Y gf180mcu_as_sc_mcu7t3v3__inv_2_77/Y
+ gf180mcu_as_sc_mcu7t3v3__inv_2_77/VNW VSUBS gf180mcu_as_sc_mcu7t3v3__inv_2
Xgf180mcu_as_sc_mcu7t3v3__inv_2_65 VSS VSS gf180mcu_as_sc_mcu7t3v3__inv_2_65/Y gf180mcu_as_sc_mcu7t3v3__inv_2_65/A
+ gf180mcu_as_sc_mcu7t3v3__inv_2_65/VNW VSUBS gf180mcu_as_sc_mcu7t3v3__inv_2
Xgf180mcu_as_sc_mcu7t3v3__inv_2_1002 VSS VSS VSS gf180mcu_as_sc_mcu7t3v3__inv_2_1003/Y
+ gf180mcu_as_sc_mcu7t3v3__inv_2_1004/VNW VSUBS gf180mcu_as_sc_mcu7t3v3__inv_2
Xgf180mcu_as_sc_mcu7t3v3__inv_2_1024 VSS VSS gf180mcu_as_sc_mcu7t3v3__inv_2_1024/Y
+ gf180mcu_as_sc_mcu7t3v3__inv_2_1024/A gf180mcu_as_sc_mcu7t3v3__inv_2_1024/VNW VSUBS
+ gf180mcu_as_sc_mcu7t3v3__inv_2
Xgf180mcu_as_sc_mcu7t3v3__inv_2_1068 VSS VSS gf180mcu_as_sc_mcu7t3v3__inv_2_1100/A
+ gf180mcu_as_sc_mcu7t3v3__inv_2_1068/A gf180mcu_as_sc_mcu7t3v3__inv_2_1100/VNW VSUBS
+ gf180mcu_as_sc_mcu7t3v3__inv_2
Xgf180mcu_as_sc_mcu7t3v3__inv_2_1079 VSS VSS gf180mcu_as_sc_mcu7t3v3__inv_2_1079/Y
+ gf180mcu_as_sc_mcu7t3v3__inv_2_1079/A gf180mcu_as_sc_mcu7t3v3__inv_2_1079/VNW VSUBS
+ gf180mcu_as_sc_mcu7t3v3__inv_2
Xgf180mcu_as_sc_mcu7t3v3__inv_2_1035 VSS VSS gf180mcu_as_sc_mcu7t3v3__inv_2_1035/Y
+ gf180mcu_as_sc_mcu7t3v3__inv_2_1036/Y gf180mcu_as_sc_mcu7t3v3__inv_2_1036/VNW VSUBS
+ gf180mcu_as_sc_mcu7t3v3__inv_2
Xgf180mcu_as_sc_mcu7t3v3__inv_2_1057 VSS VSS VSS gf180mcu_as_sc_mcu7t3v3__inv_2_1057/A
+ gf180mcu_as_sc_mcu7t3v3__inv_2_1057/VNW VSUBS gf180mcu_as_sc_mcu7t3v3__inv_2
Xgf180mcu_as_sc_mcu7t3v3__inv_2_1046 VSS VSS VSS gf180mcu_as_sc_mcu7t3v3__inv_2_1047/Y
+ gf180mcu_as_sc_mcu7t3v3__inv_2_1048/VNW VSUBS gf180mcu_as_sc_mcu7t3v3__inv_2
Xgf180mcu_as_sc_mcu7t3v3__inv_2_519 VSS VSS gf180mcu_as_sc_mcu7t3v3__inv_2_560/A gf180mcu_as_sc_mcu7t3v3__inv_2_519/A
+ gf180mcu_as_sc_mcu7t3v3__inv_2_560/VNW VSUBS gf180mcu_as_sc_mcu7t3v3__inv_2
Xgf180mcu_as_sc_mcu7t3v3__inv_2_508 VSS VSS gf180mcu_as_sc_mcu7t3v3__inv_2_539/A gf180mcu_as_sc_mcu7t3v3__inv_2_509/Y
+ gf180mcu_as_sc_mcu7t3v3__inv_2_539/VNW VSUBS gf180mcu_as_sc_mcu7t3v3__inv_2
Xgf180mcu_as_sc_mcu7t3v3__inv_2_1580 VSS VSS VSS gf180mcu_as_sc_mcu7t3v3__inv_2_1581/Y
+ gf180mcu_as_sc_mcu7t3v3__inv_2_1582/VNW VSUBS gf180mcu_as_sc_mcu7t3v3__inv_2
Xgf180mcu_as_sc_mcu7t3v3__inv_2_1591 VSS VSS gf180mcu_as_sc_mcu7t3v3__inv_2_1591/Y
+ gf180mcu_as_sc_mcu7t3v3__inv_2_1591/A gf180mcu_as_sc_mcu7t3v3__inv_2_1591/VNW VSUBS
+ gf180mcu_as_sc_mcu7t3v3__inv_2
Xgf180mcu_as_sc_mcu7t3v3__nand3_2_2 gf180mcu_as_sc_mcu7t3v3__nor2_2_7/VDD gf180mcu_as_sc_mcu7t3v3__nand3_2_4/VSS
+ VSS VSS VSS VSS gf180mcu_as_sc_mcu7t3v3__nor2_2_7/VNW VSUBS gf180mcu_as_sc_mcu7t3v3__nand3_2
Xgf180mcu_as_sc_mcu7t3v3__nand4_2_374 VSS VSS VSS VSS VSS VSS gf180mcu_as_sc_mcu7t3v3__inv_2_1221/A
+ gf180mcu_as_sc_mcu7t3v3__inv_2_1275/VNW VSUBS gf180mcu_as_sc_mcu7t3v3__nand4_2
Xgf180mcu_as_sc_mcu7t3v3__nand4_2_341 VSS VSS VSS VSS VSS VSS gf180mcu_as_sc_mcu7t3v3__inv_2_1148/A
+ gf180mcu_as_sc_mcu7t3v3__inv_2_1148/VNW VSUBS gf180mcu_as_sc_mcu7t3v3__nand4_2
Xgf180mcu_as_sc_mcu7t3v3__nand4_2_363 VSS VSS VSS VSS VSS VSS gf180mcu_as_sc_mcu7t3v3__inv_2_1182/A
+ gf180mcu_as_sc_mcu7t3v3__inv_2_1297/VNW VSUBS gf180mcu_as_sc_mcu7t3v3__nand4_2
Xgf180mcu_as_sc_mcu7t3v3__nand4_2_352 VSS VSS VSS VSS VSS VSS gf180mcu_as_sc_mcu7t3v3__inv_2_1183/A
+ gf180mcu_as_sc_mcu7t3v3__inv_2_1300/VNW VSUBS gf180mcu_as_sc_mcu7t3v3__nand4_2
Xgf180mcu_as_sc_mcu7t3v3__nand4_2_330 VSS VSS VSS VSS VSS VSS gf180mcu_as_sc_mcu7t3v3__inv_2_1064/A
+ gf180mcu_as_sc_mcu7t3v3__inv_2_1064/VNW VSUBS gf180mcu_as_sc_mcu7t3v3__nand4_2
Xgf180mcu_as_sc_mcu7t3v3__nand4_2_385 VSS VSS VSS VSS VSS VSS gf180mcu_as_sc_mcu7t3v3__inv_2_1425/A
+ gf180mcu_as_sc_mcu7t3v3__inv_2_1425/VNW VSUBS gf180mcu_as_sc_mcu7t3v3__nand4_2
Xgf180mcu_as_sc_mcu7t3v3__nand4_2_396 VSS VSS VSS VSS VSS VSS gf180mcu_as_sc_mcu7t3v3__inv_2_1458/A
+ gf180mcu_as_sc_mcu7t3v3__inv_2_1479/VNW VSUBS gf180mcu_as_sc_mcu7t3v3__nand4_2
Xgf180mcu_as_sc_mcu7t3v3__inv_2_305 VSS VSS VSS gf180mcu_as_sc_mcu7t3v3__inv_2_306/Y
+ gf180mcu_as_sc_mcu7t3v3__inv_2_307/VNW VSUBS gf180mcu_as_sc_mcu7t3v3__inv_2
Xgf180mcu_as_sc_mcu7t3v3__inv_2_316 VSS VSS gf180mcu_as_sc_mcu7t3v3__inv_2_316/Y gf180mcu_as_sc_mcu7t3v3__inv_2_317/Y
+ gf180mcu_as_sc_mcu7t3v3__inv_2_317/VNW VSUBS gf180mcu_as_sc_mcu7t3v3__inv_2
Xgf180mcu_as_sc_mcu7t3v3__inv_2_349 VSS VSS gf180mcu_as_sc_mcu7t3v3__inv_2_349/Y gf180mcu_as_sc_mcu7t3v3__inv_2_350/Y
+ gf180mcu_as_sc_mcu7t3v3__inv_2_350/VNW VSUBS gf180mcu_as_sc_mcu7t3v3__inv_2
Xgf180mcu_as_sc_mcu7t3v3__inv_2_338 VSS VSS gf180mcu_as_sc_mcu7t3v3__inv_2_338/Y gf180mcu_as_sc_mcu7t3v3__inv_2_338/A
+ gf180mcu_as_sc_mcu7t3v3__inv_2_338/VNW VSUBS gf180mcu_as_sc_mcu7t3v3__inv_2
Xgf180mcu_as_sc_mcu7t3v3__inv_2_327 VSS VSS VSS gf180mcu_as_sc_mcu7t3v3__inv_2_328/Y
+ gf180mcu_as_sc_mcu7t3v3__inv_2_329/VNW VSUBS gf180mcu_as_sc_mcu7t3v3__inv_2
Xgf180mcu_as_sc_mcu7t3v3__inv_2_850 VSS VSS VSS gf180mcu_as_sc_mcu7t3v3__inv_2_850/A
+ gf180mcu_as_sc_mcu7t3v3__inv_2_850/VNW VSUBS gf180mcu_as_sc_mcu7t3v3__inv_2
Xgf180mcu_as_sc_mcu7t3v3__inv_2_872 VSS VSS gf180mcu_as_sc_mcu7t3v3__inv_2_872/Y gf180mcu_as_sc_mcu7t3v3__inv_2_872/A
+ gf180mcu_as_sc_mcu7t3v3__inv_2_940/VNW VSUBS gf180mcu_as_sc_mcu7t3v3__inv_2
Xgf180mcu_as_sc_mcu7t3v3__inv_2_861 VSS VSS gf180mcu_as_sc_mcu7t3v3__inv_2_861/Y gf180mcu_as_sc_mcu7t3v3__inv_2_861/A
+ gf180mcu_as_sc_mcu7t3v3__inv_2_937/VNW VSUBS gf180mcu_as_sc_mcu7t3v3__inv_2
Xgf180mcu_as_sc_mcu7t3v3__inv_2_883 VSS VSS gf180mcu_as_sc_mcu7t3v3__inv_2_883/Y gf180mcu_as_sc_mcu7t3v3__inv_2_883/A
+ gf180mcu_as_sc_mcu7t3v3__inv_2_941/VNW VSUBS gf180mcu_as_sc_mcu7t3v3__inv_2
Xgf180mcu_as_sc_mcu7t3v3__inv_2_894 VSS VSS gf180mcu_as_sc_mcu7t3v3__inv_2_915/A gf180mcu_as_sc_mcu7t3v3__inv_2_894/A
+ gf180mcu_as_sc_mcu7t3v3__inv_2_957/VNW VSUBS gf180mcu_as_sc_mcu7t3v3__inv_2
Xu_t026_010 u_t026_010/c0_w0_bl u_t026_010/c0_w0_br u_t026_010/c0_w1_bl u_t026_010/c0_w1_br
+ u_t026_010/c0_r0_rbl u_t026_010/c0_r1_rbl u_t026_010/c1_w0_bl u_t026_010/c1_w0_br
+ u_t026_010/c1_w1_bl u_t026_010/c1_w1_br u_t026_010/c1_r0_rbl u_t026_010/c1_r1_rbl
+ u_t026_010/c2_w0_bl u_t026_010/c2_w0_br u_t026_010/c2_w1_bl u_t026_010/c2_w1_br
+ u_t026_010/c2_r0_rbl u_t026_010/c2_r1_rbl u_t026_010/c3_w0_bl u_t026_010/c3_w0_br
+ u_t026_010/c3_w1_bl u_t026_010/c3_w1_br u_t026_010/c3_r0_rbl u_t026_010/c3_r1_rbl
+ u_t026_010/r0_w0_wl u_t026_010/r0_w1_wl u_t026_010/r0_r0_rwl u_t026_010/r0_r1_rwl
+ u_t026_010/r1_w0_wl u_t026_010/r1_w1_wl u_t026_010/r1_r0_rwl u_t026_010/r1_r1_rwl
+ u_t026_010/r2_w0_wl u_t026_010/r2_w1_wl u_t026_010/r2_r0_rwl u_t026_010/r2_r1_rwl
+ u_t026_010/r3_w0_wl u_t026_010/r3_w1_wl u_t026_010/r3_r0_rwl u_t026_010/r3_r1_rwl
+ VSS VSS u_t026_010/m2_717_1265# u_t026_010/m2_603_2031# u_t026_010/m2_1290_336#
+ u_t026_010/m2_2000_2037# u_t026_010/m2_791_2909# u_t026_010/m2_7_2126# u_t026_010/m2_2154_2081#
+ u_t026_010/m2_1795_2037# u_t026_010/m2_871_303# u_t026_010/m2_431_438# u_t026_010/m2_1290_2898#
+ u_t026_010/m2_1714_1210# u_t026_010/m2_431_1982# u_t026_010/m2_512_1265# u_t026_010/m2_2573_2126#
+ u_t026_010/m2_603_1259# u_t026_010/m2_2074_2909# u_t026_010/m2_7_336# u_t026_010/m2_717_2037#
+ u_t026_010/m2_1886_2031# u_t026_010/m2_2573_336# u_t026_010/m2_7_2898# u_t026_010/m2_2000_1265#
+ u_t026_010/m2_512_2037# u_t026_010/m2_1795_1265# u_t026_010/m2_1714_1982# u_t026_010/m2_1886_1259#
+ u_t026_010/m2_1290_2126# u_t026_010/m2_1714_438# u_t026_010/m2_431_1210# u_t026_010/m2_2573_2898#
+ u_t026_010/m2_2154_303# u_t026_010/m2_871_2081# VSUBS detronyx_12t_2w2r_rc4_4x4_routed_5layer_direct
Xgf180mcu_as_sc_mcu7t3v3__nand4_2_160 VSS VSS VSS VSS VSS VSS gf180mcu_as_sc_mcu7t3v3__inv_2_579/A
+ gf180mcu_as_sc_mcu7t3v3__inv_2_579/VNW VSUBS gf180mcu_as_sc_mcu7t3v3__nand4_2
Xgf180mcu_as_sc_mcu7t3v3__nand4_2_171 VSS VSS VSS VSS VSS VSS gf180mcu_as_sc_mcu7t3v3__inv_2_606/A
+ gf180mcu_as_sc_mcu7t3v3__inv_2_606/VNW VSUBS gf180mcu_as_sc_mcu7t3v3__nand4_2
Xgf180mcu_as_sc_mcu7t3v3__nand4_2_182 VSS VSS VSS VSS VSS VSS gf180mcu_as_sc_mcu7t3v3__inv_2_700/A
+ gf180mcu_as_sc_mcu7t3v3__inv_2_737/VNW VSUBS gf180mcu_as_sc_mcu7t3v3__nand4_2
Xgf180mcu_as_sc_mcu7t3v3__nand4_2_193 VSS VSS VSS VSS VSS VSS gf180mcu_as_sc_mcu7t3v3__inv_2_693/A
+ gf180mcu_as_sc_mcu7t3v3__inv_2_743/VNW VSUBS gf180mcu_as_sc_mcu7t3v3__nand4_2
Xu_t017_010 u_t017_010/c0_w0_bl u_t017_010/c0_w0_br u_t017_010/c0_w1_bl u_t017_010/c0_w1_br
+ u_t017_010/c0_r0_rbl u_t017_010/c0_r1_rbl u_t017_010/c1_w0_bl u_t017_010/c1_w0_br
+ u_t017_010/c1_w1_bl u_t017_010/c1_w1_br u_t017_010/c1_r0_rbl u_t017_010/c1_r1_rbl
+ u_t017_010/c2_w0_bl u_t017_010/c2_w0_br u_t017_010/c2_w1_bl u_t017_010/c2_w1_br
+ u_t017_010/c2_r0_rbl u_t017_010/c2_r1_rbl u_t017_010/c3_w0_bl u_t017_010/c3_w0_br
+ u_t017_010/c3_w1_bl u_t017_010/c3_w1_br u_t017_010/c3_r0_rbl u_t017_010/c3_r1_rbl
+ u_t017_010/r0_w0_wl u_t017_010/r0_w1_wl u_t017_010/r0_r0_rwl u_t017_010/r0_r1_rwl
+ u_t017_010/r1_w0_wl u_t017_010/r1_w1_wl u_t017_010/r1_r0_rwl u_t017_010/r1_r1_rwl
+ u_t017_010/r2_w0_wl u_t017_010/r2_w1_wl u_t017_010/r2_r0_rwl u_t017_010/r2_r1_rwl
+ u_t017_010/r3_w0_wl u_t017_010/r3_w1_wl u_t017_010/r3_r0_rwl u_t017_010/r3_r1_rwl
+ VSS VSS u_t017_010/m2_717_1265# u_t017_010/m2_603_2031# u_t017_010/m2_1290_336#
+ u_t017_010/m2_2000_2037# u_t017_010/m2_791_2909# u_t017_010/m2_7_2126# u_t017_010/m2_2154_2081#
+ u_t017_010/m2_1795_2037# u_t017_010/m2_871_303# u_t017_010/m2_431_438# u_t017_010/m2_1290_2898#
+ u_t017_010/m2_1714_1210# u_t017_010/m2_431_1982# u_t017_010/m2_512_1265# u_t017_010/m2_2573_2126#
+ u_t017_010/m2_603_1259# u_t017_010/m2_2074_2909# u_t017_010/m2_7_336# u_t017_010/m2_717_2037#
+ u_t017_010/m2_1886_2031# u_t017_010/m2_2573_336# u_t017_010/m2_7_2898# u_t017_010/m2_2000_1265#
+ u_t017_010/m2_512_2037# u_t017_010/m2_1795_1265# u_t017_010/m2_1714_1982# u_t017_010/m2_1886_1259#
+ u_t017_010/m2_1290_2126# u_t017_010/m2_1714_438# u_t017_010/m2_431_1210# u_t017_010/m2_2573_2898#
+ u_t017_010/m2_2154_303# u_t017_010/m2_871_2081# VSUBS detronyx_12t_2w2r_rc4_4x4_routed_5layer_direct
Xgf180mcu_as_sc_mcu7t3v3__inv_2_102 VSS VSS gf180mcu_as_sc_mcu7t3v3__inv_2_102/Y gf180mcu_as_sc_mcu7t3v3__inv_2_103/Y
+ gf180mcu_as_sc_mcu7t3v3__nand4_2_3/VNW VSUBS gf180mcu_as_sc_mcu7t3v3__inv_2
Xgf180mcu_as_sc_mcu7t3v3__inv_2_146 VSS VSS gf180mcu_as_sc_mcu7t3v3__inv_2_146/Y gf180mcu_as_sc_mcu7t3v3__inv_2_146/A
+ gf180mcu_as_sc_mcu7t3v3__inv_2_146/VNW VSUBS gf180mcu_as_sc_mcu7t3v3__inv_2
Xgf180mcu_as_sc_mcu7t3v3__inv_2_135 VSS VSS VSS gf180mcu_as_sc_mcu7t3v3__inv_2_136/Y
+ gf180mcu_as_sc_mcu7t3v3__inv_2_137/VNW VSUBS gf180mcu_as_sc_mcu7t3v3__inv_2
Xgf180mcu_as_sc_mcu7t3v3__inv_2_124 VSS VSS gf180mcu_as_sc_mcu7t3v3__inv_2_124/Y gf180mcu_as_sc_mcu7t3v3__inv_2_125/Y
+ gf180mcu_as_sc_mcu7t3v3__inv_2_125/VNW VSUBS gf180mcu_as_sc_mcu7t3v3__inv_2
Xgf180mcu_as_sc_mcu7t3v3__inv_2_113 VSS VSS gf180mcu_as_sc_mcu7t3v3__inv_2_113/Y gf180mcu_as_sc_mcu7t3v3__inv_2_113/A
+ gf180mcu_as_sc_mcu7t3v3__inv_2_113/VNW VSUBS gf180mcu_as_sc_mcu7t3v3__inv_2
Xgf180mcu_as_sc_mcu7t3v3__inv_2_168 VSS VSS gf180mcu_as_sc_mcu7t3v3__inv_2_168/Y gf180mcu_as_sc_mcu7t3v3__inv_2_168/A
+ gf180mcu_as_sc_mcu7t3v3__inv_2_168/VNW VSUBS gf180mcu_as_sc_mcu7t3v3__inv_2
Xgf180mcu_as_sc_mcu7t3v3__inv_2_157 VSS VSS gf180mcu_as_sc_mcu7t3v3__inv_2_177/A gf180mcu_as_sc_mcu7t3v3__inv_2_157/A
+ gf180mcu_as_sc_mcu7t3v3__inv_2_177/VNW VSUBS gf180mcu_as_sc_mcu7t3v3__inv_2
Xgf180mcu_as_sc_mcu7t3v3__inv_2_179 VSS VSS gf180mcu_as_sc_mcu7t3v3__inv_2_179/Y gf180mcu_as_sc_mcu7t3v3__inv_2_180/Y
+ gf180mcu_as_sc_mcu7t3v3__inv_2_180/VNW VSUBS gf180mcu_as_sc_mcu7t3v3__inv_2
Xu_t008_010 u_t008_010/c0_w0_bl u_t008_010/c0_w0_br u_t008_010/c0_w1_bl u_t008_010/c0_w1_br
+ u_t008_010/c0_r0_rbl u_t008_010/c0_r1_rbl u_t008_010/c1_w0_bl u_t008_010/c1_w0_br
+ u_t008_010/c1_w1_bl u_t008_010/c1_w1_br u_t008_010/c1_r0_rbl u_t008_010/c1_r1_rbl
+ u_t008_010/c2_w0_bl u_t008_010/c2_w0_br u_t008_010/c2_w1_bl u_t008_010/c2_w1_br
+ u_t008_010/c2_r0_rbl u_t008_010/c2_r1_rbl u_t008_010/c3_w0_bl u_t008_010/c3_w0_br
+ u_t008_010/c3_w1_bl u_t008_010/c3_w1_br u_t008_010/c3_r0_rbl u_t008_010/c3_r1_rbl
+ u_t008_010/r0_w0_wl u_t008_010/r0_w1_wl u_t008_010/r0_r0_rwl u_t008_010/r0_r1_rwl
+ u_t008_010/r1_w0_wl u_t008_010/r1_w1_wl u_t008_010/r1_r0_rwl u_t008_010/r1_r1_rwl
+ u_t008_010/r2_w0_wl u_t008_010/r2_w1_wl u_t008_010/r2_r0_rwl u_t008_010/r2_r1_rwl
+ u_t008_010/r3_w0_wl u_t008_010/r3_w1_wl u_t008_010/r3_r0_rwl u_t008_010/r3_r1_rwl
+ VSS VSS u_t008_010/m2_717_1265# u_t008_010/m2_603_2031# u_t008_010/m2_1290_336#
+ u_t008_010/m2_2000_2037# u_t008_010/m2_791_2909# u_t008_010/m2_7_2126# u_t008_010/m2_2154_2081#
+ u_t008_010/m2_1795_2037# u_t008_010/m2_871_303# u_t008_010/m2_431_438# u_t008_010/m2_1290_2898#
+ u_t008_010/m2_1714_1210# u_t008_010/m2_431_1982# u_t008_010/m2_512_1265# u_t008_010/m2_2573_2126#
+ u_t008_010/m2_603_1259# u_t008_010/m2_2074_2909# u_t008_010/m2_7_336# u_t008_010/m2_717_2037#
+ u_t008_010/m2_1886_2031# u_t008_010/m2_2573_336# u_t008_010/m2_7_2898# u_t008_010/m2_2000_1265#
+ u_t008_010/m2_512_2037# u_t008_010/m2_1795_1265# u_t008_010/m2_1714_1982# u_t008_010/m2_1886_1259#
+ u_t008_010/m2_1290_2126# u_t008_010/m2_1714_438# u_t008_010/m2_431_1210# u_t008_010/m2_2573_2898#
+ u_t008_010/m2_2154_303# u_t008_010/m2_871_2081# VSUBS detronyx_12t_2w2r_rc4_4x4_routed_5layer_direct
Xu_t023_013 u_t023_013/c0_w0_bl u_t023_013/c0_w0_br u_t023_013/c0_w1_bl u_t023_013/c0_w1_br
+ u_t023_013/c0_r0_rbl u_t023_013/c0_r1_rbl u_t023_013/c1_w0_bl u_t023_013/c1_w0_br
+ u_t023_013/c1_w1_bl u_t023_013/c1_w1_br u_t023_013/c1_r0_rbl u_t023_013/c1_r1_rbl
+ u_t023_013/c2_w0_bl u_t023_013/c2_w0_br u_t023_013/c2_w1_bl u_t023_013/c2_w1_br
+ u_t023_013/c2_r0_rbl u_t023_013/c2_r1_rbl u_t023_013/c3_w0_bl u_t023_013/c3_w0_br
+ u_t023_013/c3_w1_bl u_t023_013/c3_w1_br u_t023_013/c3_r0_rbl u_t023_013/c3_r1_rbl
+ u_t023_013/r0_w0_wl u_t023_013/r0_w1_wl u_t023_013/r0_r0_rwl u_t023_013/r0_r1_rwl
+ u_t023_013/r1_w0_wl u_t023_013/r1_w1_wl u_t023_013/r1_r0_rwl u_t023_013/r1_r1_rwl
+ u_t023_013/r2_w0_wl u_t023_013/r2_w1_wl u_t023_013/r2_r0_rwl u_t023_013/r2_r1_rwl
+ u_t023_013/r3_w0_wl u_t023_013/r3_w1_wl u_t023_013/r3_r0_rwl u_t023_013/r3_r1_rwl
+ VSS VSS u_t023_013/m2_717_1265# u_t023_013/m2_603_2031# u_t023_013/m2_1290_336#
+ u_t023_013/m2_2000_2037# u_t023_013/m2_791_2909# u_t023_013/m2_7_2126# u_t023_013/m2_2154_2081#
+ u_t023_013/m2_1795_2037# u_t023_013/m2_871_303# u_t023_013/m2_431_438# u_t023_013/m2_1290_2898#
+ u_t023_013/m2_1714_1210# u_t023_013/m2_431_1982# u_t023_013/m2_512_1265# u_t023_013/m2_2573_2126#
+ u_t023_013/m2_603_1259# u_t023_013/m2_2074_2909# u_t023_013/m2_7_336# u_t023_013/m2_717_2037#
+ u_t023_013/m2_1886_2031# u_t023_013/m2_2573_336# u_t023_013/m2_7_2898# u_t023_013/m2_2000_1265#
+ u_t023_013/m2_512_2037# u_t023_013/m2_1795_1265# u_t023_013/m2_1714_1982# u_t023_013/m2_1886_1259#
+ u_t023_013/m2_1290_2126# u_t023_013/m2_1714_438# u_t023_013/m2_431_1210# u_t023_013/m2_2573_2898#
+ u_t023_013/m2_2154_303# u_t023_013/m2_871_2081# VSUBS detronyx_12t_2w2r_rc4_4x4_routed_5layer_direct
Xu_t023_002 u_t023_002/c0_w0_bl u_t023_002/c0_w0_br u_t023_002/c0_w1_bl u_t023_002/c0_w1_br
+ u_t023_002/c0_r0_rbl u_t023_002/c0_r1_rbl u_t023_002/c1_w0_bl u_t023_002/c1_w0_br
+ u_t023_002/c1_w1_bl u_t023_002/c1_w1_br u_t023_002/c1_r0_rbl u_t023_002/c1_r1_rbl
+ u_t023_002/c2_w0_bl u_t023_002/c2_w0_br u_t023_002/c2_w1_bl u_t023_002/c2_w1_br
+ u_t023_002/c2_r0_rbl u_t023_002/c2_r1_rbl u_t023_002/c3_w0_bl u_t023_002/c3_w0_br
+ u_t023_002/c3_w1_bl u_t023_002/c3_w1_br u_t023_002/c3_r0_rbl u_t023_002/c3_r1_rbl
+ u_t023_002/r0_w0_wl u_t023_002/r0_w1_wl u_t023_002/r0_r0_rwl u_t023_002/r0_r1_rwl
+ u_t023_002/r1_w0_wl u_t023_002/r1_w1_wl u_t023_002/r1_r0_rwl u_t023_002/r1_r1_rwl
+ u_t023_002/r2_w0_wl u_t023_002/r2_w1_wl u_t023_002/r2_r0_rwl u_t023_002/r2_r1_rwl
+ u_t023_002/r3_w0_wl u_t023_002/r3_w1_wl u_t023_002/r3_r0_rwl u_t023_002/r3_r1_rwl
+ VSS VSS u_t023_002/m2_717_1265# u_t023_002/m2_603_2031# u_t023_002/m2_1290_336#
+ u_t023_002/m2_2000_2037# u_t023_002/m2_791_2909# u_t023_002/m2_7_2126# u_t023_002/m2_2154_2081#
+ u_t023_002/m2_1795_2037# u_t023_002/m2_871_303# u_t023_002/m2_431_438# u_t023_002/m2_1290_2898#
+ u_t023_002/m2_1714_1210# u_t023_002/m2_431_1982# u_t023_002/m2_512_1265# u_t023_002/m2_2573_2126#
+ u_t023_002/m2_603_1259# u_t023_002/m2_2074_2909# u_t023_002/m2_7_336# u_t023_002/m2_717_2037#
+ u_t023_002/m2_1886_2031# u_t023_002/m2_2573_336# u_t023_002/m2_7_2898# u_t023_002/m2_2000_1265#
+ u_t023_002/m2_512_2037# u_t023_002/m2_1795_1265# u_t023_002/m2_1714_1982# u_t023_002/m2_1886_1259#
+ u_t023_002/m2_1290_2126# u_t023_002/m2_1714_438# u_t023_002/m2_431_1210# u_t023_002/m2_2573_2898#
+ u_t023_002/m2_2154_303# u_t023_002/m2_871_2081# VSUBS detronyx_12t_2w2r_rc4_4x4_routed_5layer_direct
Xgf180mcu_as_sc_mcu7t3v3__inv_2_691 VSS VSS gf180mcu_as_sc_mcu7t3v3__inv_2_691/Y gf180mcu_as_sc_mcu7t3v3__inv_2_692/Y
+ gf180mcu_as_sc_mcu7t3v3__inv_2_692/VNW VSUBS gf180mcu_as_sc_mcu7t3v3__inv_2
Xgf180mcu_as_sc_mcu7t3v3__inv_2_680 VSS VSS gf180mcu_as_sc_mcu7t3v3__inv_2_680/Y gf180mcu_as_sc_mcu7t3v3__inv_2_680/A
+ gf180mcu_as_sc_mcu7t3v3__inv_2_680/VNW VSUBS gf180mcu_as_sc_mcu7t3v3__inv_2
Xu_t014_013 u_t014_013/c0_w0_bl u_t014_013/c0_w0_br u_t014_013/c0_w1_bl u_t014_013/c0_w1_br
+ u_t014_013/c0_r0_rbl u_t014_013/c0_r1_rbl u_t014_013/c1_w0_bl u_t014_013/c1_w0_br
+ u_t014_013/c1_w1_bl u_t014_013/c1_w1_br u_t014_013/c1_r0_rbl u_t014_013/c1_r1_rbl
+ u_t014_013/c2_w0_bl u_t014_013/c2_w0_br u_t014_013/c2_w1_bl u_t014_013/c2_w1_br
+ u_t014_013/c2_r0_rbl u_t014_013/c2_r1_rbl u_t014_013/c3_w0_bl u_t014_013/c3_w0_br
+ u_t014_013/c3_w1_bl u_t014_013/c3_w1_br u_t014_013/c3_r0_rbl u_t014_013/c3_r1_rbl
+ u_t014_013/r0_w0_wl u_t014_013/r0_w1_wl u_t014_013/r0_r0_rwl u_t014_013/r0_r1_rwl
+ u_t014_013/r1_w0_wl u_t014_013/r1_w1_wl u_t014_013/r1_r0_rwl u_t014_013/r1_r1_rwl
+ u_t014_013/r2_w0_wl u_t014_013/r2_w1_wl u_t014_013/r2_r0_rwl u_t014_013/r2_r1_rwl
+ u_t014_013/r3_w0_wl u_t014_013/r3_w1_wl u_t014_013/r3_r0_rwl u_t014_013/r3_r1_rwl
+ VSS VSS u_t014_013/m2_717_1265# u_t014_013/m2_603_2031# u_t014_013/m2_1290_336#
+ u_t014_013/m2_2000_2037# u_t014_013/m2_791_2909# u_t014_013/m2_7_2126# u_t014_013/m2_2154_2081#
+ u_t014_013/m2_1795_2037# u_t014_013/m2_871_303# u_t014_013/m2_431_438# u_t014_013/m2_1290_2898#
+ u_t014_013/m2_1714_1210# u_t014_013/m2_431_1982# u_t014_013/m2_512_1265# u_t014_013/m2_2573_2126#
+ u_t014_013/m2_603_1259# u_t014_013/m2_2074_2909# u_t014_013/m2_7_336# u_t014_013/m2_717_2037#
+ u_t014_013/m2_1886_2031# u_t014_013/m2_2573_336# u_t014_013/m2_7_2898# u_t014_013/m2_2000_1265#
+ u_t014_013/m2_512_2037# u_t014_013/m2_1795_1265# u_t014_013/m2_1714_1982# u_t014_013/m2_1886_1259#
+ u_t014_013/m2_1290_2126# u_t014_013/m2_1714_438# u_t014_013/m2_431_1210# u_t014_013/m2_2573_2898#
+ u_t014_013/m2_2154_303# u_t014_013/m2_871_2081# VSUBS detronyx_12t_2w2r_rc4_4x4_routed_5layer_direct
Xu_t014_002 u_t014_002/c0_w0_bl u_t014_002/c0_w0_br u_t014_002/c0_w1_bl u_t014_002/c0_w1_br
+ u_t014_002/c0_r0_rbl u_t014_002/c0_r1_rbl u_t014_002/c1_w0_bl u_t014_002/c1_w0_br
+ u_t014_002/c1_w1_bl u_t014_002/c1_w1_br u_t014_002/c1_r0_rbl u_t014_002/c1_r1_rbl
+ u_t014_002/c2_w0_bl u_t014_002/c2_w0_br u_t014_002/c2_w1_bl u_t014_002/c2_w1_br
+ u_t014_002/c2_r0_rbl u_t014_002/c2_r1_rbl u_t014_002/c3_w0_bl u_t014_002/c3_w0_br
+ u_t014_002/c3_w1_bl u_t014_002/c3_w1_br u_t014_002/c3_r0_rbl u_t014_002/c3_r1_rbl
+ u_t014_002/r0_w0_wl u_t014_002/r0_w1_wl u_t014_002/r0_r0_rwl u_t014_002/r0_r1_rwl
+ u_t014_002/r1_w0_wl u_t014_002/r1_w1_wl u_t014_002/r1_r0_rwl u_t014_002/r1_r1_rwl
+ u_t014_002/r2_w0_wl u_t014_002/r2_w1_wl u_t014_002/r2_r0_rwl u_t014_002/r2_r1_rwl
+ u_t014_002/r3_w0_wl u_t014_002/r3_w1_wl u_t014_002/r3_r0_rwl u_t014_002/r3_r1_rwl
+ VSS VSS u_t014_002/m2_717_1265# u_t014_002/m2_603_2031# u_t014_002/m2_1290_336#
+ u_t014_002/m2_2000_2037# u_t014_002/m2_791_2909# u_t014_002/m2_7_2126# u_t014_002/m2_2154_2081#
+ u_t014_002/m2_1795_2037# u_t014_002/m2_871_303# u_t014_002/m2_431_438# u_t014_002/m2_1290_2898#
+ u_t014_002/m2_1714_1210# u_t014_002/m2_431_1982# u_t014_002/m2_512_1265# u_t014_002/m2_2573_2126#
+ u_t014_002/m2_603_1259# u_t014_002/m2_2074_2909# u_t014_002/m2_7_336# u_t014_002/m2_717_2037#
+ u_t014_002/m2_1886_2031# u_t014_002/m2_2573_336# u_t014_002/m2_7_2898# u_t014_002/m2_2000_1265#
+ u_t014_002/m2_512_2037# u_t014_002/m2_1795_1265# u_t014_002/m2_1714_1982# u_t014_002/m2_1886_1259#
+ u_t014_002/m2_1290_2126# u_t014_002/m2_1714_438# u_t014_002/m2_431_1210# u_t014_002/m2_2573_2898#
+ u_t014_002/m2_2154_303# u_t014_002/m2_871_2081# VSUBS detronyx_12t_2w2r_rc4_4x4_routed_5layer_direct
Xgf180mcu_as_sc_mcu7t3v3__nand2_2_36 gf180mcu_as_sc_mcu7t3v3__nor2_2_9/VDD gf180mcu_as_sc_mcu7t3v3__nor2_2_9/VSS
+ VSS VSS VSS gf180mcu_as_sc_mcu7t3v3__nor2_2_9/VNW VSUBS gf180mcu_as_sc_mcu7t3v3__nand2_2
Xgf180mcu_as_sc_mcu7t3v3__nand2_2_47 gf180mcu_as_sc_mcu7t3v3__nand3_2_65/VDD gf180mcu_as_sc_mcu7t3v3__nor2_2_9/VSS
+ VSS VSS VSS gf180mcu_as_sc_mcu7t3v3__nand3_2_65/VNW VSUBS gf180mcu_as_sc_mcu7t3v3__nand2_2
Xgf180mcu_as_sc_mcu7t3v3__nand2_2_25 gf180mcu_as_sc_mcu7t3v3__nor2_2_6/VDD gf180mcu_as_sc_mcu7t3v3__nor2_2_6/VSS
+ VSS VSS VSS gf180mcu_as_sc_mcu7t3v3__nor2_2_6/VNW VSUBS gf180mcu_as_sc_mcu7t3v3__nand2_2
Xgf180mcu_as_sc_mcu7t3v3__nand2_2_14 gf180mcu_as_sc_mcu7t3v3__nor2_2_6/VDD gf180mcu_as_sc_mcu7t3v3__nor2_2_6/VSS
+ VSS VSS VSS gf180mcu_as_sc_mcu7t3v3__nor2_2_6/VNW VSUBS gf180mcu_as_sc_mcu7t3v3__nand2_2
Xu_t005_013 u_t005_013/c0_w0_bl u_t005_013/c0_w0_br u_t005_013/c0_w1_bl u_t005_013/c0_w1_br
+ u_t005_013/c0_r0_rbl u_t005_013/c0_r1_rbl u_t005_013/c1_w0_bl u_t005_013/c1_w0_br
+ u_t005_013/c1_w1_bl u_t005_013/c1_w1_br u_t005_013/c1_r0_rbl u_t005_013/c1_r1_rbl
+ u_t005_013/c2_w0_bl u_t005_013/c2_w0_br u_t005_013/c2_w1_bl u_t005_013/c2_w1_br
+ u_t005_013/c2_r0_rbl u_t005_013/c2_r1_rbl u_t005_013/c3_w0_bl u_t005_013/c3_w0_br
+ u_t005_013/c3_w1_bl u_t005_013/c3_w1_br u_t005_013/c3_r0_rbl u_t005_013/c3_r1_rbl
+ u_t005_013/r0_w0_wl u_t005_013/r0_w1_wl u_t005_013/r0_r0_rwl u_t005_013/r0_r1_rwl
+ u_t005_013/r1_w0_wl u_t005_013/r1_w1_wl u_t005_013/r1_r0_rwl u_t005_013/r1_r1_rwl
+ u_t005_013/r2_w0_wl u_t005_013/r2_w1_wl u_t005_013/r2_r0_rwl u_t005_013/r2_r1_rwl
+ u_t005_013/r3_w0_wl u_t005_013/r3_w1_wl u_t005_013/r3_r0_rwl u_t005_013/r3_r1_rwl
+ VSS VSS u_t005_013/m2_717_1265# u_t005_013/m2_603_2031# u_t005_013/m2_1290_336#
+ u_t005_013/m2_2000_2037# u_t005_013/m2_791_2909# u_t005_013/m2_7_2126# u_t005_013/m2_2154_2081#
+ u_t005_013/m2_1795_2037# u_t005_013/m2_871_303# u_t005_013/m2_431_438# u_t005_013/m2_1290_2898#
+ u_t005_013/m2_1714_1210# u_t005_013/m2_431_1982# u_t005_013/m2_512_1265# u_t005_013/m2_2573_2126#
+ u_t005_013/m2_603_1259# u_t005_013/m2_2074_2909# u_t005_013/m2_7_336# u_t005_013/m2_717_2037#
+ u_t005_013/m2_1886_2031# u_t005_013/m2_2573_336# u_t005_013/m2_7_2898# u_t005_013/m2_2000_1265#
+ u_t005_013/m2_512_2037# u_t005_013/m2_1795_1265# u_t005_013/m2_1714_1982# u_t005_013/m2_1886_1259#
+ u_t005_013/m2_1290_2126# u_t005_013/m2_1714_438# u_t005_013/m2_431_1210# u_t005_013/m2_2573_2898#
+ u_t005_013/m2_2154_303# u_t005_013/m2_871_2081# VSUBS detronyx_12t_2w2r_rc4_4x4_routed_5layer_direct
Xu_t020_005 u_t020_005/c0_w0_bl u_t020_005/c0_w0_br u_t020_005/c0_w1_bl u_t020_005/c0_w1_br
+ u_t020_005/c0_r0_rbl u_t020_005/c0_r1_rbl u_t020_005/c1_w0_bl u_t020_005/c1_w0_br
+ u_t020_005/c1_w1_bl u_t020_005/c1_w1_br u_t020_005/c1_r0_rbl u_t020_005/c1_r1_rbl
+ u_t020_005/c2_w0_bl u_t020_005/c2_w0_br u_t020_005/c2_w1_bl u_t020_005/c2_w1_br
+ u_t020_005/c2_r0_rbl u_t020_005/c2_r1_rbl u_t020_005/c3_w0_bl u_t020_005/c3_w0_br
+ u_t020_005/c3_w1_bl u_t020_005/c3_w1_br u_t020_005/c3_r0_rbl u_t020_005/c3_r1_rbl
+ u_t020_005/r0_w0_wl u_t020_005/r0_w1_wl u_t020_005/r0_r0_rwl u_t020_005/r0_r1_rwl
+ u_t020_005/r1_w0_wl u_t020_005/r1_w1_wl u_t020_005/r1_r0_rwl u_t020_005/r1_r1_rwl
+ u_t020_005/r2_w0_wl u_t020_005/r2_w1_wl u_t020_005/r2_r0_rwl u_t020_005/r2_r1_rwl
+ u_t020_005/r3_w0_wl u_t020_005/r3_w1_wl u_t020_005/r3_r0_rwl u_t020_005/r3_r1_rwl
+ VSS VSS u_t020_005/m2_717_1265# u_t020_005/m2_603_2031# u_t020_005/m2_1290_336#
+ u_t020_005/m2_2000_2037# u_t020_005/m2_791_2909# u_t020_005/m2_7_2126# u_t020_005/m2_2154_2081#
+ u_t020_005/m2_1795_2037# u_t020_005/m2_871_303# u_t020_005/m2_431_438# u_t020_005/m2_1290_2898#
+ u_t020_005/m2_1714_1210# u_t020_005/m2_431_1982# u_t020_005/m2_512_1265# u_t020_005/m2_2573_2126#
+ u_t020_005/m2_603_1259# u_t020_005/m2_2074_2909# u_t020_005/m2_7_336# u_t020_005/m2_717_2037#
+ u_t020_005/m2_1886_2031# u_t020_005/m2_2573_336# u_t020_005/m2_7_2898# u_t020_005/m2_2000_1265#
+ u_t020_005/m2_512_2037# u_t020_005/m2_1795_1265# u_t020_005/m2_1714_1982# u_t020_005/m2_1886_1259#
+ u_t020_005/m2_1290_2126# u_t020_005/m2_1714_438# u_t020_005/m2_431_1210# u_t020_005/m2_2573_2898#
+ u_t020_005/m2_2154_303# u_t020_005/m2_871_2081# VSUBS detronyx_12t_2w2r_rc4_4x4_routed_5layer_direct
Xu_t005_002 u_t005_002/c0_w0_bl u_t005_002/c0_w0_br u_t005_002/c0_w1_bl u_t005_002/c0_w1_br
+ u_t005_002/c0_r0_rbl u_t005_002/c0_r1_rbl u_t005_002/c1_w0_bl u_t005_002/c1_w0_br
+ u_t005_002/c1_w1_bl u_t005_002/c1_w1_br u_t005_002/c1_r0_rbl u_t005_002/c1_r1_rbl
+ u_t005_002/c2_w0_bl u_t005_002/c2_w0_br u_t005_002/c2_w1_bl u_t005_002/c2_w1_br
+ u_t005_002/c2_r0_rbl u_t005_002/c2_r1_rbl u_t005_002/c3_w0_bl u_t005_002/c3_w0_br
+ u_t005_002/c3_w1_bl u_t005_002/c3_w1_br u_t005_002/c3_r0_rbl u_t005_002/c3_r1_rbl
+ u_t005_002/r0_w0_wl u_t005_002/r0_w1_wl u_t005_002/r0_r0_rwl u_t005_002/r0_r1_rwl
+ u_t005_002/r1_w0_wl u_t005_002/r1_w1_wl u_t005_002/r1_r0_rwl u_t005_002/r1_r1_rwl
+ u_t005_002/r2_w0_wl u_t005_002/r2_w1_wl u_t005_002/r2_r0_rwl u_t005_002/r2_r1_rwl
+ u_t005_002/r3_w0_wl u_t005_002/r3_w1_wl u_t005_002/r3_r0_rwl u_t005_002/r3_r1_rwl
+ VSS VSS u_t005_002/m2_717_1265# u_t005_002/m2_603_2031# u_t005_002/m2_1290_336#
+ u_t005_002/m2_2000_2037# u_t005_002/m2_791_2909# u_t005_002/m2_7_2126# u_t005_002/m2_2154_2081#
+ u_t005_002/m2_1795_2037# u_t005_002/m2_871_303# u_t005_002/m2_431_438# u_t005_002/m2_1290_2898#
+ u_t005_002/m2_1714_1210# u_t005_002/m2_431_1982# u_t005_002/m2_512_1265# u_t005_002/m2_2573_2126#
+ u_t005_002/m2_603_1259# u_t005_002/m2_2074_2909# u_t005_002/m2_7_336# u_t005_002/m2_717_2037#
+ u_t005_002/m2_1886_2031# u_t005_002/m2_2573_336# u_t005_002/m2_7_2898# u_t005_002/m2_2000_1265#
+ u_t005_002/m2_512_2037# u_t005_002/m2_1795_1265# u_t005_002/m2_1714_1982# u_t005_002/m2_1886_1259#
+ u_t005_002/m2_1290_2126# u_t005_002/m2_1714_438# u_t005_002/m2_431_1210# u_t005_002/m2_2573_2898#
+ u_t005_002/m2_2154_303# u_t005_002/m2_871_2081# VSUBS detronyx_12t_2w2r_rc4_4x4_routed_5layer_direct
Xgf180mcu_as_sc_mcu7t3v3__inv_2_1409 VSS VSS VSS gf180mcu_as_sc_mcu7t3v3__inv_2_1409/A
+ gf180mcu_as_sc_mcu7t3v3__inv_2_1409/VNW VSUBS gf180mcu_as_sc_mcu7t3v3__inv_2
Xu_t011_005 u_t011_005/c0_w0_bl u_t011_005/c0_w0_br u_t011_005/c0_w1_bl u_t011_005/c0_w1_br
+ u_t011_005/c0_r0_rbl u_t011_005/c0_r1_rbl u_t011_005/c1_w0_bl u_t011_005/c1_w0_br
+ u_t011_005/c1_w1_bl u_t011_005/c1_w1_br u_t011_005/c1_r0_rbl u_t011_005/c1_r1_rbl
+ u_t011_005/c2_w0_bl u_t011_005/c2_w0_br u_t011_005/c2_w1_bl u_t011_005/c2_w1_br
+ u_t011_005/c2_r0_rbl u_t011_005/c2_r1_rbl u_t011_005/c3_w0_bl u_t011_005/c3_w0_br
+ u_t011_005/c3_w1_bl u_t011_005/c3_w1_br u_t011_005/c3_r0_rbl u_t011_005/c3_r1_rbl
+ u_t011_005/r0_w0_wl u_t011_005/r0_w1_wl u_t011_005/r0_r0_rwl u_t011_005/r0_r1_rwl
+ u_t011_005/r1_w0_wl u_t011_005/r1_w1_wl u_t011_005/r1_r0_rwl u_t011_005/r1_r1_rwl
+ u_t011_005/r2_w0_wl u_t011_005/r2_w1_wl u_t011_005/r2_r0_rwl u_t011_005/r2_r1_rwl
+ u_t011_005/r3_w0_wl u_t011_005/r3_w1_wl u_t011_005/r3_r0_rwl u_t011_005/r3_r1_rwl
+ VSS VSS u_t011_005/m2_717_1265# u_t011_005/m2_603_2031# u_t011_005/m2_1290_336#
+ u_t011_005/m2_2000_2037# u_t011_005/m2_791_2909# u_t011_005/m2_7_2126# u_t011_005/m2_2154_2081#
+ u_t011_005/m2_1795_2037# u_t011_005/m2_871_303# u_t011_005/m2_431_438# u_t011_005/m2_1290_2898#
+ u_t011_005/m2_1714_1210# u_t011_005/m2_431_1982# u_t011_005/m2_512_1265# u_t011_005/m2_2573_2126#
+ u_t011_005/m2_603_1259# u_t011_005/m2_2074_2909# u_t011_005/m2_7_336# u_t011_005/m2_717_2037#
+ u_t011_005/m2_1886_2031# u_t011_005/m2_2573_336# u_t011_005/m2_7_2898# u_t011_005/m2_2000_1265#
+ u_t011_005/m2_512_2037# u_t011_005/m2_1795_1265# u_t011_005/m2_1714_1982# u_t011_005/m2_1886_1259#
+ u_t011_005/m2_1290_2126# u_t011_005/m2_1714_438# u_t011_005/m2_431_1210# u_t011_005/m2_2573_2898#
+ u_t011_005/m2_2154_303# u_t011_005/m2_871_2081# VSUBS detronyx_12t_2w2r_rc4_4x4_routed_5layer_direct
Xu_t002_005 u_t002_005/c0_w0_bl u_t002_005/c0_w0_br u_t002_005/c0_w1_bl u_t002_005/c0_w1_br
+ u_t002_005/c0_r0_rbl u_t002_005/c0_r1_rbl u_t002_005/c1_w0_bl u_t002_005/c1_w0_br
+ u_t002_005/c1_w1_bl u_t002_005/c1_w1_br u_t002_005/c1_r0_rbl u_t002_005/c1_r1_rbl
+ u_t002_005/c2_w0_bl u_t002_005/c2_w0_br u_t002_005/c2_w1_bl u_t002_005/c2_w1_br
+ u_t002_005/c2_r0_rbl u_t002_005/c2_r1_rbl u_t002_005/c3_w0_bl u_t002_005/c3_w0_br
+ u_t002_005/c3_w1_bl u_t002_005/c3_w1_br u_t002_005/c3_r0_rbl u_t002_005/c3_r1_rbl
+ u_t002_005/r0_w0_wl u_t002_005/r0_w1_wl u_t002_005/r0_r0_rwl u_t002_005/r0_r1_rwl
+ u_t002_005/r1_w0_wl u_t002_005/r1_w1_wl u_t002_005/r1_r0_rwl u_t002_005/r1_r1_rwl
+ u_t002_005/r2_w0_wl u_t002_005/r2_w1_wl u_t002_005/r2_r0_rwl u_t002_005/r2_r1_rwl
+ u_t002_005/r3_w0_wl u_t002_005/r3_w1_wl u_t002_005/r3_r0_rwl u_t002_005/r3_r1_rwl
+ VSS VSS u_t002_005/m2_717_1265# u_t002_005/m2_603_2031# u_t002_005/m2_1290_336#
+ u_t002_005/m2_2000_2037# u_t002_005/m2_791_2909# u_t002_005/m2_7_2126# u_t002_005/m2_2154_2081#
+ u_t002_005/m2_1795_2037# u_t002_005/m2_871_303# u_t002_005/m2_431_438# u_t002_005/m2_1290_2898#
+ u_t002_005/m2_1714_1210# u_t002_005/m2_431_1982# u_t002_005/m2_512_1265# u_t002_005/m2_2573_2126#
+ u_t002_005/m2_603_1259# u_t002_005/m2_2074_2909# u_t002_005/m2_7_336# u_t002_005/m2_717_2037#
+ u_t002_005/m2_1886_2031# u_t002_005/m2_2573_336# u_t002_005/m2_7_2898# u_t002_005/m2_2000_1265#
+ u_t002_005/m2_512_2037# u_t002_005/m2_1795_1265# u_t002_005/m2_1714_1982# u_t002_005/m2_1886_1259#
+ u_t002_005/m2_1290_2126# u_t002_005/m2_1714_438# u_t002_005/m2_431_1210# u_t002_005/m2_2573_2898#
+ u_t002_005/m2_2154_303# u_t002_005/m2_871_2081# VSUBS detronyx_12t_2w2r_rc4_4x4_routed_5layer_direct
Xgf180mcu_as_sc_mcu7t3v3__inv_2_1206 gf180mcu_as_sc_mcu7t3v3__nand3_2_65/VDD gf180mcu_as_sc_mcu7t3v3__nand3_2_62/VSS
+ VSS VSS gf180mcu_as_sc_mcu7t3v3__nand3_2_65/VNW VSUBS gf180mcu_as_sc_mcu7t3v3__inv_2
Xgf180mcu_as_sc_mcu7t3v3__inv_2_1217 VSS VSS gf180mcu_as_sc_mcu7t3v3__inv_2_1217/Y
+ gf180mcu_as_sc_mcu7t3v3__inv_2_1217/A gf180mcu_as_sc_mcu7t3v3__inv_2_1281/VNW VSUBS
+ gf180mcu_as_sc_mcu7t3v3__inv_2
Xgf180mcu_as_sc_mcu7t3v3__inv_2_1239 gf180mcu_as_sc_mcu7t3v3__nor2_2_9/VDD gf180mcu_as_sc_mcu7t3v3__nor2_2_9/VSS
+ VSS VSS gf180mcu_as_sc_mcu7t3v3__nor2_2_9/VNW VSUBS gf180mcu_as_sc_mcu7t3v3__inv_2
Xgf180mcu_as_sc_mcu7t3v3__inv_2_1228 VSS VSS gf180mcu_as_sc_mcu7t3v3__inv_2_1228/Y
+ gf180mcu_as_sc_mcu7t3v3__inv_2_1228/A gf180mcu_as_sc_mcu7t3v3__inv_2_1282/VNW VSUBS
+ gf180mcu_as_sc_mcu7t3v3__inv_2
Xgf180mcu_as_sc_mcu7t3v3__nand4_2_501 VSS VSS VSS VSS VSS VSS gf180mcu_as_sc_mcu7t3v3__inv_2_1642/A
+ gf180mcu_as_sc_mcu7t3v3__inv_2_1642/VNW VSUBS gf180mcu_as_sc_mcu7t3v3__nand4_2
Xgf180mcu_as_sc_mcu7t3v3__nand4_2_512 VSS VSS VSS VSS VSS VSS gf180mcu_as_sc_mcu7t3v3__inv_2_1723/A
+ gf180mcu_as_sc_mcu7t3v3__inv_2_1723/VNW VSUBS gf180mcu_as_sc_mcu7t3v3__nand4_2
Xgf180mcu_as_sc_mcu7t3v3__inv_2_1036 VSS VSS gf180mcu_as_sc_mcu7t3v3__inv_2_1036/Y
+ gf180mcu_as_sc_mcu7t3v3__inv_2_1036/A gf180mcu_as_sc_mcu7t3v3__inv_2_1036/VNW VSUBS
+ gf180mcu_as_sc_mcu7t3v3__inv_2
Xgf180mcu_as_sc_mcu7t3v3__inv_2_1014 VSS VSS VSS gf180mcu_as_sc_mcu7t3v3__inv_2_1015/Y
+ gf180mcu_as_sc_mcu7t3v3__inv_2_1016/VNW VSUBS gf180mcu_as_sc_mcu7t3v3__inv_2
Xgf180mcu_as_sc_mcu7t3v3__inv_2_1025 VSS VSS VSS gf180mcu_as_sc_mcu7t3v3__inv_2_1053/Y
+ gf180mcu_as_sc_mcu7t3v3__inv_2_1053/VNW VSUBS gf180mcu_as_sc_mcu7t3v3__inv_2
Xgf180mcu_as_sc_mcu7t3v3__inv_2_1047 VSS VSS gf180mcu_as_sc_mcu7t3v3__inv_2_1047/Y
+ gf180mcu_as_sc_mcu7t3v3__inv_2_1048/Y gf180mcu_as_sc_mcu7t3v3__inv_2_1048/VNW VSUBS
+ gf180mcu_as_sc_mcu7t3v3__inv_2
Xgf180mcu_as_sc_mcu7t3v3__inv_2_1058 VSS VSS VSS gf180mcu_as_sc_mcu7t3v3__inv_2_1058/A
+ gf180mcu_as_sc_mcu7t3v3__inv_2_1058/VNW VSUBS gf180mcu_as_sc_mcu7t3v3__inv_2
Xgf180mcu_as_sc_mcu7t3v3__inv_2_11 VSS VSS gf180mcu_as_sc_mcu7t3v3__inv_2_11/Y gf180mcu_as_sc_mcu7t3v3__inv_2_12/Y
+ gf180mcu_as_sc_mcu7t3v3__inv_2_12/VNW VSUBS gf180mcu_as_sc_mcu7t3v3__inv_2
Xgf180mcu_as_sc_mcu7t3v3__inv_2_22 VSS VSS VSS gf180mcu_as_sc_mcu7t3v3__inv_2_23/Y
+ gf180mcu_as_sc_mcu7t3v3__inv_2_24/VNW VSUBS gf180mcu_as_sc_mcu7t3v3__inv_2
Xgf180mcu_as_sc_mcu7t3v3__inv_2_88 VSS VSS VSS gf180mcu_as_sc_mcu7t3v3__inv_2_89/Y
+ gf180mcu_as_sc_mcu7t3v3__inv_2_90/VNW VSUBS gf180mcu_as_sc_mcu7t3v3__inv_2
Xgf180mcu_as_sc_mcu7t3v3__inv_2_99 VSS VSS VSS gf180mcu_as_sc_mcu7t3v3__inv_2_99/A
+ gf180mcu_as_sc_mcu7t3v3__inv_2_99/VNW VSUBS gf180mcu_as_sc_mcu7t3v3__inv_2
Xgf180mcu_as_sc_mcu7t3v3__inv_2_66 VSS VSS gf180mcu_as_sc_mcu7t3v3__inv_2_66/Y gf180mcu_as_sc_mcu7t3v3__inv_2_66/A
+ gf180mcu_as_sc_mcu7t3v3__inv_2_66/VNW VSUBS gf180mcu_as_sc_mcu7t3v3__inv_2
Xgf180mcu_as_sc_mcu7t3v3__inv_2_44 VSS VSS VSS gf180mcu_as_sc_mcu7t3v3__inv_2_45/Y
+ gf180mcu_as_sc_mcu7t3v3__inv_2_46/VNW VSUBS gf180mcu_as_sc_mcu7t3v3__inv_2
Xgf180mcu_as_sc_mcu7t3v3__inv_2_33 VSS VSS VSS gf180mcu_as_sc_mcu7t3v3__inv_2_37/Y
+ gf180mcu_as_sc_mcu7t3v3__inv_2_38/VNW VSUBS gf180mcu_as_sc_mcu7t3v3__inv_2
Xgf180mcu_as_sc_mcu7t3v3__inv_2_77 VSS VSS gf180mcu_as_sc_mcu7t3v3__inv_2_77/Y gf180mcu_as_sc_mcu7t3v3__inv_2_77/A
+ gf180mcu_as_sc_mcu7t3v3__inv_2_77/VNW VSUBS gf180mcu_as_sc_mcu7t3v3__inv_2
Xgf180mcu_as_sc_mcu7t3v3__inv_2_55 VSS VSS VSS gf180mcu_as_sc_mcu7t3v3__inv_2_56/Y
+ gf180mcu_as_sc_mcu7t3v3__inv_2_57/VNW VSUBS gf180mcu_as_sc_mcu7t3v3__inv_2
Xgf180mcu_as_sc_mcu7t3v3__inv_2_1003 VSS VSS gf180mcu_as_sc_mcu7t3v3__inv_2_1003/Y
+ gf180mcu_as_sc_mcu7t3v3__inv_2_1004/Y gf180mcu_as_sc_mcu7t3v3__inv_2_1004/VNW VSUBS
+ gf180mcu_as_sc_mcu7t3v3__inv_2
Xgf180mcu_as_sc_mcu7t3v3__inv_2_1069 VSS VSS VSS gf180mcu_as_sc_mcu7t3v3__inv_2_1070/Y
+ gf180mcu_as_sc_mcu7t3v3__inv_2_1071/VNW VSUBS gf180mcu_as_sc_mcu7t3v3__inv_2
Xgf180mcu_as_sc_mcu7t3v3__inv_2_509 VSS VSS gf180mcu_as_sc_mcu7t3v3__inv_2_509/Y gf180mcu_as_sc_mcu7t3v3__inv_2_509/A
+ gf180mcu_as_sc_mcu7t3v3__inv_2_539/VNW VSUBS gf180mcu_as_sc_mcu7t3v3__inv_2
Xgf180mcu_as_sc_mcu7t3v3__inv_2_1592 VSS VSS VSS gf180mcu_as_sc_mcu7t3v3__inv_2_1593/Y
+ gf180mcu_as_sc_mcu7t3v3__inv_2_1594/VNW VSUBS gf180mcu_as_sc_mcu7t3v3__inv_2
Xgf180mcu_as_sc_mcu7t3v3__inv_2_1570 VSS VSS gf180mcu_as_sc_mcu7t3v3__inv_2_1570/Y
+ gf180mcu_as_sc_mcu7t3v3__inv_2_1570/A gf180mcu_as_sc_mcu7t3v3__inv_2_1570/VNW VSUBS
+ gf180mcu_as_sc_mcu7t3v3__inv_2
Xgf180mcu_as_sc_mcu7t3v3__inv_2_1581 VSS VSS gf180mcu_as_sc_mcu7t3v3__inv_2_1581/Y
+ gf180mcu_as_sc_mcu7t3v3__inv_2_1582/Y gf180mcu_as_sc_mcu7t3v3__inv_2_1582/VNW VSUBS
+ gf180mcu_as_sc_mcu7t3v3__inv_2
Xgf180mcu_as_sc_mcu7t3v3__nand3_2_3 gf180mcu_as_sc_mcu7t3v3__nor2_2_6/VDD gf180mcu_as_sc_mcu7t3v3__nand3_2_4/VSS
+ VSS VSS VSS VSS gf180mcu_as_sc_mcu7t3v3__nor2_2_6/VNW VSUBS gf180mcu_as_sc_mcu7t3v3__nand3_2
Xgf180mcu_as_sc_mcu7t3v3__nand4_2_375 VSS VSS VSS VSS VSS VSS gf180mcu_as_sc_mcu7t3v3__inv_2_1224/A
+ gf180mcu_as_sc_mcu7t3v3__inv_2_1276/VNW VSUBS gf180mcu_as_sc_mcu7t3v3__nand4_2
Xgf180mcu_as_sc_mcu7t3v3__nand4_2_342 VSS VSS VSS VSS VSS VSS gf180mcu_as_sc_mcu7t3v3__inv_2_1115/A
+ gf180mcu_as_sc_mcu7t3v3__inv_2_1115/VNW VSUBS gf180mcu_as_sc_mcu7t3v3__nand4_2
Xgf180mcu_as_sc_mcu7t3v3__nand4_2_364 VSS VSS VSS VSS VSS VSS gf180mcu_as_sc_mcu7t3v3__inv_2_1154/A
+ gf180mcu_as_sc_mcu7t3v3__inv_2_1263/VNW VSUBS gf180mcu_as_sc_mcu7t3v3__nand4_2
Xgf180mcu_as_sc_mcu7t3v3__nand4_2_353 VSS VSS VSS VSS VSS VSS gf180mcu_as_sc_mcu7t3v3__inv_2_1161/A
+ gf180mcu_as_sc_mcu7t3v3__inv_2_1292/VNW VSUBS gf180mcu_as_sc_mcu7t3v3__nand4_2
Xgf180mcu_as_sc_mcu7t3v3__nand4_2_320 VSS VSS VSS VSS VSS VSS gf180mcu_as_sc_mcu7t3v3__inv_2_1075/A
+ gf180mcu_as_sc_mcu7t3v3__inv_2_1075/VNW VSUBS gf180mcu_as_sc_mcu7t3v3__nand4_2
Xgf180mcu_as_sc_mcu7t3v3__nand4_2_331 VSS VSS VSS VSS VSS VSS gf180mcu_as_sc_mcu7t3v3__inv_2_1080/A
+ gf180mcu_as_sc_mcu7t3v3__inv_2_1080/VNW VSUBS gf180mcu_as_sc_mcu7t3v3__nand4_2
Xgf180mcu_as_sc_mcu7t3v3__nand4_2_386 VSS VSS VSS VSS VSS VSS gf180mcu_as_sc_mcu7t3v3__inv_2_1428/A
+ gf180mcu_as_sc_mcu7t3v3__inv_2_1428/VNW VSUBS gf180mcu_as_sc_mcu7t3v3__nand4_2
Xgf180mcu_as_sc_mcu7t3v3__nand4_2_397 VSS VSS VSS VSS VSS VSS gf180mcu_as_sc_mcu7t3v3__inv_2_1461/A
+ gf180mcu_as_sc_mcu7t3v3__inv_2_1461/VNW VSUBS gf180mcu_as_sc_mcu7t3v3__nand4_2
Xgf180mcu_as_sc_mcu7t3v3__inv_2_306 VSS VSS gf180mcu_as_sc_mcu7t3v3__inv_2_306/Y gf180mcu_as_sc_mcu7t3v3__inv_2_307/Y
+ gf180mcu_as_sc_mcu7t3v3__inv_2_307/VNW VSUBS gf180mcu_as_sc_mcu7t3v3__inv_2
Xgf180mcu_as_sc_mcu7t3v3__inv_2_339 VSS VSS VSS gf180mcu_as_sc_mcu7t3v3__inv_2_340/Y
+ gf180mcu_as_sc_mcu7t3v3__inv_2_341/VNW VSUBS gf180mcu_as_sc_mcu7t3v3__inv_2
Xgf180mcu_as_sc_mcu7t3v3__inv_2_328 VSS VSS gf180mcu_as_sc_mcu7t3v3__inv_2_328/Y gf180mcu_as_sc_mcu7t3v3__inv_2_329/Y
+ gf180mcu_as_sc_mcu7t3v3__inv_2_329/VNW VSUBS gf180mcu_as_sc_mcu7t3v3__inv_2
Xgf180mcu_as_sc_mcu7t3v3__inv_2_317 VSS VSS gf180mcu_as_sc_mcu7t3v3__inv_2_317/Y gf180mcu_as_sc_mcu7t3v3__inv_2_317/A
+ gf180mcu_as_sc_mcu7t3v3__inv_2_317/VNW VSUBS gf180mcu_as_sc_mcu7t3v3__inv_2
Xgf180mcu_as_sc_mcu7t3v3__inv_2_895 VSS VSS gf180mcu_as_sc_mcu7t3v3__inv_2_926/A gf180mcu_as_sc_mcu7t3v3__inv_2_896/Y
+ gf180mcu_as_sc_mcu7t3v3__inv_2_926/VNW VSUBS gf180mcu_as_sc_mcu7t3v3__inv_2
Xgf180mcu_as_sc_mcu7t3v3__inv_2_851 VSS VSS VSS gf180mcu_as_sc_mcu7t3v3__inv_2_851/A
+ gf180mcu_as_sc_mcu7t3v3__inv_2_851/VNW VSUBS gf180mcu_as_sc_mcu7t3v3__inv_2
Xgf180mcu_as_sc_mcu7t3v3__inv_2_840 VSS VSS VSS gf180mcu_as_sc_mcu7t3v3__inv_2_840/A
+ gf180mcu_as_sc_mcu7t3v3__inv_2_840/VNW VSUBS gf180mcu_as_sc_mcu7t3v3__inv_2
Xgf180mcu_as_sc_mcu7t3v3__inv_2_884 VSS VSS gf180mcu_as_sc_mcu7t3v3__inv_2_934/A gf180mcu_as_sc_mcu7t3v3__inv_2_885/Y
+ gf180mcu_as_sc_mcu7t3v3__inv_2_934/VNW VSUBS gf180mcu_as_sc_mcu7t3v3__inv_2
Xgf180mcu_as_sc_mcu7t3v3__inv_2_873 VSS VSS gf180mcu_as_sc_mcu7t3v3__inv_2_930/A gf180mcu_as_sc_mcu7t3v3__inv_2_874/Y
+ gf180mcu_as_sc_mcu7t3v3__inv_2_930/VNW VSUBS gf180mcu_as_sc_mcu7t3v3__inv_2
Xgf180mcu_as_sc_mcu7t3v3__inv_2_862 VSS VSS gf180mcu_as_sc_mcu7t3v3__inv_2_862/Y gf180mcu_as_sc_mcu7t3v3__inv_2_862/A
+ gf180mcu_as_sc_mcu7t3v3__inv_2_942/VNW VSUBS gf180mcu_as_sc_mcu7t3v3__inv_2
Xu_t026_011 u_t026_011/c0_w0_bl u_t026_011/c0_w0_br u_t026_011/c0_w1_bl u_t026_011/c0_w1_br
+ u_t026_011/c0_r0_rbl u_t026_011/c0_r1_rbl u_t026_011/c1_w0_bl u_t026_011/c1_w0_br
+ u_t026_011/c1_w1_bl u_t026_011/c1_w1_br u_t026_011/c1_r0_rbl u_t026_011/c1_r1_rbl
+ u_t026_011/c2_w0_bl u_t026_011/c2_w0_br u_t026_011/c2_w1_bl u_t026_011/c2_w1_br
+ u_t026_011/c2_r0_rbl u_t026_011/c2_r1_rbl u_t026_011/c3_w0_bl u_t026_011/c3_w0_br
+ u_t026_011/c3_w1_bl u_t026_011/c3_w1_br u_t026_011/c3_r0_rbl u_t026_011/c3_r1_rbl
+ u_t026_011/r0_w0_wl u_t026_011/r0_w1_wl u_t026_011/r0_r0_rwl u_t026_011/r0_r1_rwl
+ u_t026_011/r1_w0_wl u_t026_011/r1_w1_wl u_t026_011/r1_r0_rwl u_t026_011/r1_r1_rwl
+ u_t026_011/r2_w0_wl u_t026_011/r2_w1_wl u_t026_011/r2_r0_rwl u_t026_011/r2_r1_rwl
+ u_t026_011/r3_w0_wl u_t026_011/r3_w1_wl u_t026_011/r3_r0_rwl u_t026_011/r3_r1_rwl
+ VSS VSS u_t026_011/m2_717_1265# u_t026_011/m2_603_2031# u_t026_011/m2_1290_336#
+ u_t026_011/m2_2000_2037# u_t026_011/m2_791_2909# u_t026_011/m2_7_2126# u_t026_011/m2_2154_2081#
+ u_t026_011/m2_1795_2037# u_t026_011/m2_871_303# u_t026_011/m2_431_438# u_t026_011/m2_1290_2898#
+ u_t026_011/m2_1714_1210# u_t026_011/m2_431_1982# u_t026_011/m2_512_1265# u_t026_011/m2_2573_2126#
+ u_t026_011/m2_603_1259# u_t026_011/m2_2074_2909# u_t026_011/m2_7_336# u_t026_011/m2_717_2037#
+ u_t026_011/m2_1886_2031# u_t026_011/m2_2573_336# u_t026_011/m2_7_2898# u_t026_011/m2_2000_1265#
+ u_t026_011/m2_512_2037# u_t026_011/m2_1795_1265# u_t026_011/m2_1714_1982# u_t026_011/m2_1886_1259#
+ u_t026_011/m2_1290_2126# u_t026_011/m2_1714_438# u_t026_011/m2_431_1210# u_t026_011/m2_2573_2898#
+ u_t026_011/m2_2154_303# u_t026_011/m2_871_2081# VSUBS detronyx_12t_2w2r_rc4_4x4_routed_5layer_direct
Xu_t026_000 VSS u_t026_000/c0_w0_br VSS u_t026_000/c0_w1_br u_t026_000/c0_r0_rbl u_t026_000/c0_r1_rbl
+ VSS VSS VSS VSS VSS VSS u_t026_000/c2_w0_bl u_t026_000/c2_w0_br u_t026_000/c2_w1_bl
+ u_t026_000/c2_w1_br u_t026_000/c2_r0_rbl u_t026_000/c2_r1_rbl u_t026_000/c3_w0_bl
+ u_t026_000/c3_w0_br u_t026_000/c3_w1_bl u_t026_000/c3_w1_br u_t026_000/c3_r0_rbl
+ u_t026_000/c3_r1_rbl VSS VSS VSS VSS VSS VSS VSS VSS VSS VSS VSS VSS VSS VSS VSS
+ VSS VSS VSS u_t026_000/m2_717_1265# VSS VSS VSS VSS u_t026_000/m2_7_2126# VSS VSS
+ VSS VSS VSS VSS VSS u_t026_000/m2_512_1265# u_t026_000/m2_2573_2126# u_t026_000/m2_603_1259#
+ VSS VSS VSS VSS u_t026_000/m2_2573_336# VSS u_t026_000/m2_2000_1265# VSS u_t026_000/m2_1795_1265#
+ VSS u_t026_000/m2_1886_1259# u_t026_000/m2_1290_2126# VSS VSS u_t026_000/m2_2573_2898#
+ VSS VSS VSUBS detronyx_12t_2w2r_rc4_4x4_routed_5layer_direct
Xgf180mcu_as_sc_mcu7t3v3__nand4_2_161 VSS VSS VSS VSS VSS VSS gf180mcu_as_sc_mcu7t3v3__inv_2_584/A
+ gf180mcu_as_sc_mcu7t3v3__inv_2_584/VNW VSUBS gf180mcu_as_sc_mcu7t3v3__nand4_2
Xgf180mcu_as_sc_mcu7t3v3__nand4_2_150 gf180mcu_as_sc_mcu7t3v3__nor2_2_4/VDD gf180mcu_as_sc_mcu7t3v3__nor2_2_4/VSS
+ VSS VSS VSS VSS VSS gf180mcu_as_sc_mcu7t3v3__nor2_2_4/VNW VSUBS gf180mcu_as_sc_mcu7t3v3__nand4_2
Xgf180mcu_as_sc_mcu7t3v3__nand4_2_172 VSS VSS VSS VSS VSS VSS gf180mcu_as_sc_mcu7t3v3__inv_2_610/A
+ gf180mcu_as_sc_mcu7t3v3__inv_2_610/VNW VSUBS gf180mcu_as_sc_mcu7t3v3__nand4_2
Xgf180mcu_as_sc_mcu7t3v3__nand4_2_183 VSS VSS VSS VSS VSS VSS gf180mcu_as_sc_mcu7t3v3__inv_2_704/A
+ gf180mcu_as_sc_mcu7t3v3__inv_2_704/VNW VSUBS gf180mcu_as_sc_mcu7t3v3__nand4_2
Xgf180mcu_as_sc_mcu7t3v3__nand4_2_194 VSS VSS VSS VSS VSS VSS gf180mcu_as_sc_mcu7t3v3__inv_2_701/A
+ gf180mcu_as_sc_mcu7t3v3__inv_2_701/VNW VSUBS gf180mcu_as_sc_mcu7t3v3__nand4_2
Xu_t017_011 u_t017_011/c0_w0_bl u_t017_011/c0_w0_br u_t017_011/c0_w1_bl u_t017_011/c0_w1_br
+ u_t017_011/c0_r0_rbl u_t017_011/c0_r1_rbl u_t017_011/c1_w0_bl u_t017_011/c1_w0_br
+ u_t017_011/c1_w1_bl u_t017_011/c1_w1_br u_t017_011/c1_r0_rbl u_t017_011/c1_r1_rbl
+ u_t017_011/c2_w0_bl u_t017_011/c2_w0_br u_t017_011/c2_w1_bl u_t017_011/c2_w1_br
+ u_t017_011/c2_r0_rbl u_t017_011/c2_r1_rbl u_t017_011/c3_w0_bl u_t017_011/c3_w0_br
+ u_t017_011/c3_w1_bl u_t017_011/c3_w1_br u_t017_011/c3_r0_rbl u_t017_011/c3_r1_rbl
+ u_t017_011/r0_w0_wl u_t017_011/r0_w1_wl u_t017_011/r0_r0_rwl u_t017_011/r0_r1_rwl
+ u_t017_011/r1_w0_wl u_t017_011/r1_w1_wl u_t017_011/r1_r0_rwl u_t017_011/r1_r1_rwl
+ u_t017_011/r2_w0_wl u_t017_011/r2_w1_wl u_t017_011/r2_r0_rwl u_t017_011/r2_r1_rwl
+ u_t017_011/r3_w0_wl u_t017_011/r3_w1_wl u_t017_011/r3_r0_rwl u_t017_011/r3_r1_rwl
+ VSS VSS u_t017_011/m2_717_1265# u_t017_011/m2_603_2031# u_t017_011/m2_1290_336#
+ u_t017_011/m2_2000_2037# u_t017_011/m2_791_2909# u_t017_011/m2_7_2126# u_t017_011/m2_2154_2081#
+ u_t017_011/m2_1795_2037# u_t017_011/m2_871_303# u_t017_011/m2_431_438# u_t017_011/m2_1290_2898#
+ u_t017_011/m2_1714_1210# u_t017_011/m2_431_1982# u_t017_011/m2_512_1265# u_t017_011/m2_2573_2126#
+ u_t017_011/m2_603_1259# u_t017_011/m2_2074_2909# u_t017_011/m2_7_336# u_t017_011/m2_717_2037#
+ u_t017_011/m2_1886_2031# u_t017_011/m2_2573_336# u_t017_011/m2_7_2898# u_t017_011/m2_2000_1265#
+ u_t017_011/m2_512_2037# u_t017_011/m2_1795_1265# u_t017_011/m2_1714_1982# u_t017_011/m2_1886_1259#
+ u_t017_011/m2_1290_2126# u_t017_011/m2_1714_438# u_t017_011/m2_431_1210# u_t017_011/m2_2573_2898#
+ u_t017_011/m2_2154_303# u_t017_011/m2_871_2081# VSUBS detronyx_12t_2w2r_rc4_4x4_routed_5layer_direct
Xgf180mcu_as_sc_mcu7t3v3__inv_2_103 VSS VSS gf180mcu_as_sc_mcu7t3v3__inv_2_103/Y gf180mcu_as_sc_mcu7t3v3__nand4_2_3/Y
+ gf180mcu_as_sc_mcu7t3v3__nand4_2_3/VNW VSUBS gf180mcu_as_sc_mcu7t3v3__inv_2
Xgf180mcu_as_sc_mcu7t3v3__inv_2_147 VSS VSS VSS gf180mcu_as_sc_mcu7t3v3__inv_2_148/Y
+ gf180mcu_as_sc_mcu7t3v3__inv_2_149/VNW VSUBS gf180mcu_as_sc_mcu7t3v3__inv_2
Xgf180mcu_as_sc_mcu7t3v3__inv_2_136 VSS VSS gf180mcu_as_sc_mcu7t3v3__inv_2_136/Y gf180mcu_as_sc_mcu7t3v3__inv_2_137/Y
+ gf180mcu_as_sc_mcu7t3v3__inv_2_137/VNW VSUBS gf180mcu_as_sc_mcu7t3v3__inv_2
Xgf180mcu_as_sc_mcu7t3v3__inv_2_125 VSS VSS gf180mcu_as_sc_mcu7t3v3__inv_2_125/Y gf180mcu_as_sc_mcu7t3v3__inv_2_125/A
+ gf180mcu_as_sc_mcu7t3v3__inv_2_125/VNW VSUBS gf180mcu_as_sc_mcu7t3v3__inv_2
Xgf180mcu_as_sc_mcu7t3v3__inv_2_114 VSS VSS VSS gf180mcu_as_sc_mcu7t3v3__inv_2_115/Y
+ gf180mcu_as_sc_mcu7t3v3__inv_2_116/VNW VSUBS gf180mcu_as_sc_mcu7t3v3__inv_2
Xgf180mcu_as_sc_mcu7t3v3__inv_2_169 VSS VSS VSS gf180mcu_as_sc_mcu7t3v3__inv_2_170/Y
+ gf180mcu_as_sc_mcu7t3v3__inv_2_171/VNW VSUBS gf180mcu_as_sc_mcu7t3v3__inv_2
Xgf180mcu_as_sc_mcu7t3v3__inv_2_158 VSS VSS VSS gf180mcu_as_sc_mcu7t3v3__inv_2_159/Y
+ gf180mcu_as_sc_mcu7t3v3__inv_2_160/VNW VSUBS gf180mcu_as_sc_mcu7t3v3__inv_2
Xu_t017_000 VSS u_t017_000/c0_w0_br VSS u_t017_000/c0_w1_br u_t017_000/c0_r0_rbl u_t017_000/c0_r1_rbl
+ VSS VSS VSS VSS VSS VSS u_t017_000/c2_w0_bl u_t017_000/c2_w0_br u_t017_000/c2_w1_bl
+ u_t017_000/c2_w1_br u_t017_000/c2_r0_rbl u_t017_000/c2_r1_rbl u_t017_000/c3_w0_bl
+ u_t017_000/c3_w0_br u_t017_000/c3_w1_bl u_t017_000/c3_w1_br u_t017_000/c3_r0_rbl
+ u_t017_000/c3_r1_rbl VSS VSS VSS VSS VSS VSS VSS VSS VSS VSS VSS VSS VSS VSS VSS
+ VSS VSS VSS VSS VSS VSS VSS VSS VSS VSS VSS VSS VSS u_t017_000/m2_1290_2898# VSS
+ VSS VSS u_t017_000/m2_2573_2126# VSS VSS VSS VSS VSS u_t017_000/m2_2573_336# u_t017_000/m2_7_2898#
+ VSS VSS VSS u_t017_000/m2_1714_1982# VSS VSS u_t017_000/m2_1714_438# VSS u_t017_000/m2_2573_2898#
+ VSS VSS VSUBS detronyx_12t_2w2r_rc4_4x4_routed_5layer_direct
Xu_t008_011 u_t008_011/c0_w0_bl u_t008_011/c0_w0_br u_t008_011/c0_w1_bl u_t008_011/c0_w1_br
+ u_t008_011/c0_r0_rbl u_t008_011/c0_r1_rbl u_t008_011/c1_w0_bl u_t008_011/c1_w0_br
+ u_t008_011/c1_w1_bl u_t008_011/c1_w1_br u_t008_011/c1_r0_rbl u_t008_011/c1_r1_rbl
+ u_t008_011/c2_w0_bl u_t008_011/c2_w0_br u_t008_011/c2_w1_bl u_t008_011/c2_w1_br
+ u_t008_011/c2_r0_rbl u_t008_011/c2_r1_rbl u_t008_011/c3_w0_bl u_t008_011/c3_w0_br
+ u_t008_011/c3_w1_bl u_t008_011/c3_w1_br u_t008_011/c3_r0_rbl u_t008_011/c3_r1_rbl
+ u_t008_011/r0_w0_wl u_t008_011/r0_w1_wl u_t008_011/r0_r0_rwl u_t008_011/r0_r1_rwl
+ u_t008_011/r1_w0_wl u_t008_011/r1_w1_wl u_t008_011/r1_r0_rwl u_t008_011/r1_r1_rwl
+ u_t008_011/r2_w0_wl u_t008_011/r2_w1_wl u_t008_011/r2_r0_rwl u_t008_011/r2_r1_rwl
+ u_t008_011/r3_w0_wl u_t008_011/r3_w1_wl u_t008_011/r3_r0_rwl u_t008_011/r3_r1_rwl
+ VSS VSS u_t008_011/m2_717_1265# u_t008_011/m2_603_2031# u_t008_011/m2_1290_336#
+ u_t008_011/m2_2000_2037# u_t008_011/m2_791_2909# u_t008_011/m2_7_2126# u_t008_011/m2_2154_2081#
+ u_t008_011/m2_1795_2037# u_t008_011/m2_871_303# u_t008_011/m2_431_438# u_t008_011/m2_1290_2898#
+ u_t008_011/m2_1714_1210# u_t008_011/m2_431_1982# u_t008_011/m2_512_1265# u_t008_011/m2_2573_2126#
+ u_t008_011/m2_603_1259# u_t008_011/m2_2074_2909# u_t008_011/m2_7_336# u_t008_011/m2_717_2037#
+ u_t008_011/m2_1886_2031# u_t008_011/m2_2573_336# u_t008_011/m2_7_2898# u_t008_011/m2_2000_1265#
+ u_t008_011/m2_512_2037# u_t008_011/m2_1795_1265# u_t008_011/m2_1714_1982# u_t008_011/m2_1886_1259#
+ u_t008_011/m2_1290_2126# u_t008_011/m2_1714_438# u_t008_011/m2_431_1210# u_t008_011/m2_2573_2898#
+ u_t008_011/m2_2154_303# u_t008_011/m2_871_2081# VSUBS detronyx_12t_2w2r_rc4_4x4_routed_5layer_direct
Xu_t008_000 VSS u_t008_000/c0_w0_br VSS u_t008_000/c0_w1_br u_t008_000/c0_r0_rbl u_t008_000/c0_r1_rbl
+ VSS VSS VSS VSS VSS VSS u_t008_000/c2_w0_bl u_t008_000/c2_w0_br u_t008_000/c2_w1_bl
+ u_t008_000/c2_w1_br u_t008_000/c2_r0_rbl u_t008_000/c2_r1_rbl u_t008_000/c3_w0_bl
+ u_t008_000/c3_w0_br u_t008_000/c3_w1_bl u_t008_000/c3_w1_br u_t008_000/c3_r0_rbl
+ u_t008_000/c3_r1_rbl VSS VSS VSS VSS VSS VSS VSS VSS VSS VSS VSS VSS VSS VSS VSS
+ VSS VSS VSS u_t008_000/m2_717_1265# u_t008_000/m2_603_2031# u_t008_000/m2_1290_336#
+ u_t008_000/m2_2000_2037# u_t008_000/m2_791_2909# u_t008_000/m2_7_2126# u_t008_000/m2_2154_2081#
+ u_t008_000/m2_1795_2037# u_t008_000/m2_871_303# u_t008_000/m2_431_438# u_t008_000/m2_1290_2898#
+ u_t008_000/m2_1714_1210# u_t008_000/m2_431_1982# u_t008_000/m2_512_1265# u_t008_000/m2_2573_2126#
+ u_t008_000/m2_603_1259# u_t008_000/m2_2074_2909# u_t008_000/m2_7_336# u_t008_000/m2_717_2037#
+ u_t008_000/m2_1886_2031# u_t008_000/m2_2573_336# u_t008_000/m2_7_2898# u_t008_000/m2_2000_1265#
+ u_t008_000/m2_512_2037# u_t008_000/m2_1795_1265# u_t008_000/m2_1714_1982# u_t008_000/m2_1886_1259#
+ u_t008_000/m2_1290_2126# u_t008_000/m2_1714_438# u_t008_000/m2_431_1210# u_t008_000/m2_2573_2898#
+ u_t008_000/m2_2154_303# u_t008_000/m2_871_2081# VSUBS detronyx_12t_2w2r_rc4_4x4_routed_5layer_direct
Xu_t023_014 u_t023_014/c0_w0_bl u_t023_014/c0_w0_br u_t023_014/c0_w1_bl u_t023_014/c0_w1_br
+ u_t023_014/c0_r0_rbl u_t023_014/c0_r1_rbl u_t023_014/c1_w0_bl u_t023_014/c1_w0_br
+ u_t023_014/c1_w1_bl u_t023_014/c1_w1_br u_t023_014/c1_r0_rbl u_t023_014/c1_r1_rbl
+ u_t023_014/c2_w0_bl u_t023_014/c2_w0_br u_t023_014/c2_w1_bl u_t023_014/c2_w1_br
+ u_t023_014/c2_r0_rbl u_t023_014/c2_r1_rbl u_t023_014/c3_w0_bl u_t023_014/c3_w0_br
+ u_t023_014/c3_w1_bl u_t023_014/c3_w1_br u_t023_014/c3_r0_rbl u_t023_014/c3_r1_rbl
+ u_t023_014/r0_w0_wl u_t023_014/r0_w1_wl u_t023_014/r0_r0_rwl u_t023_014/r0_r1_rwl
+ u_t023_014/r1_w0_wl u_t023_014/r1_w1_wl u_t023_014/r1_r0_rwl u_t023_014/r1_r1_rwl
+ u_t023_014/r2_w0_wl u_t023_014/r2_w1_wl u_t023_014/r2_r0_rwl u_t023_014/r2_r1_rwl
+ u_t023_014/r3_w0_wl u_t023_014/r3_w1_wl u_t023_014/r3_r0_rwl u_t023_014/r3_r1_rwl
+ VSS VSS u_t023_014/m2_717_1265# u_t023_014/m2_603_2031# u_t023_014/m2_1290_336#
+ u_t023_014/m2_2000_2037# u_t023_014/m2_791_2909# u_t023_014/m2_7_2126# u_t023_014/m2_2154_2081#
+ u_t023_014/m2_1795_2037# u_t023_014/m2_871_303# u_t023_014/m2_431_438# u_t023_014/m2_1290_2898#
+ u_t023_014/m2_1714_1210# u_t023_014/m2_431_1982# u_t023_014/m2_512_1265# u_t023_014/m2_2573_2126#
+ u_t023_014/m2_603_1259# u_t023_014/m2_2074_2909# u_t023_014/m2_7_336# u_t023_014/m2_717_2037#
+ u_t023_014/m2_1886_2031# u_t023_014/m2_2573_336# u_t023_014/m2_7_2898# u_t023_014/m2_2000_1265#
+ u_t023_014/m2_512_2037# u_t023_014/m2_1795_1265# u_t023_014/m2_1714_1982# u_t023_014/m2_1886_1259#
+ u_t023_014/m2_1290_2126# u_t023_014/m2_1714_438# u_t023_014/m2_431_1210# u_t023_014/m2_2573_2898#
+ u_t023_014/m2_2154_303# u_t023_014/m2_871_2081# VSUBS detronyx_12t_2w2r_rc4_4x4_routed_5layer_direct
Xu_t023_003 u_t023_003/c0_w0_bl u_t023_003/c0_w0_br u_t023_003/c0_w1_bl u_t023_003/c0_w1_br
+ u_t023_003/c0_r0_rbl u_t023_003/c0_r1_rbl u_t023_003/c1_w0_bl u_t023_003/c1_w0_br
+ u_t023_003/c1_w1_bl u_t023_003/c1_w1_br u_t023_003/c1_r0_rbl u_t023_003/c1_r1_rbl
+ u_t023_003/c2_w0_bl u_t023_003/c2_w0_br u_t023_003/c2_w1_bl u_t023_003/c2_w1_br
+ u_t023_003/c2_r0_rbl u_t023_003/c2_r1_rbl u_t023_003/c3_w0_bl u_t023_003/c3_w0_br
+ u_t023_003/c3_w1_bl u_t023_003/c3_w1_br u_t023_003/c3_r0_rbl u_t023_003/c3_r1_rbl
+ u_t023_003/r0_w0_wl u_t023_003/r0_w1_wl u_t023_003/r0_r0_rwl u_t023_003/r0_r1_rwl
+ u_t023_003/r1_w0_wl u_t023_003/r1_w1_wl u_t023_003/r1_r0_rwl u_t023_003/r1_r1_rwl
+ u_t023_003/r2_w0_wl u_t023_003/r2_w1_wl u_t023_003/r2_r0_rwl u_t023_003/r2_r1_rwl
+ u_t023_003/r3_w0_wl u_t023_003/r3_w1_wl u_t023_003/r3_r0_rwl u_t023_003/r3_r1_rwl
+ VSS VSS u_t023_003/m2_717_1265# u_t023_003/m2_603_2031# u_t023_003/m2_1290_336#
+ u_t023_003/m2_2000_2037# u_t023_003/m2_791_2909# u_t023_003/m2_7_2126# u_t023_003/m2_2154_2081#
+ u_t023_003/m2_1795_2037# u_t023_003/m2_871_303# u_t023_003/m2_431_438# u_t023_003/m2_1290_2898#
+ u_t023_003/m2_1714_1210# u_t023_003/m2_431_1982# u_t023_003/m2_512_1265# u_t023_003/m2_2573_2126#
+ u_t023_003/m2_603_1259# u_t023_003/m2_2074_2909# u_t023_003/m2_7_336# u_t023_003/m2_717_2037#
+ u_t023_003/m2_1886_2031# u_t023_003/m2_2573_336# u_t023_003/m2_7_2898# u_t023_003/m2_2000_1265#
+ u_t023_003/m2_512_2037# u_t023_003/m2_1795_1265# u_t023_003/m2_1714_1982# u_t023_003/m2_1886_1259#
+ u_t023_003/m2_1290_2126# u_t023_003/m2_1714_438# u_t023_003/m2_431_1210# u_t023_003/m2_2573_2898#
+ u_t023_003/m2_2154_303# u_t023_003/m2_871_2081# VSUBS detronyx_12t_2w2r_rc4_4x4_routed_5layer_direct
Xgf180mcu_as_sc_mcu7t3v3__inv_2_692 VSS VSS gf180mcu_as_sc_mcu7t3v3__inv_2_692/Y gf180mcu_as_sc_mcu7t3v3__inv_2_692/A
+ gf180mcu_as_sc_mcu7t3v3__inv_2_692/VNW VSUBS gf180mcu_as_sc_mcu7t3v3__inv_2
Xgf180mcu_as_sc_mcu7t3v3__inv_2_670 VSS VSS gf180mcu_as_sc_mcu7t3v3__inv_2_670/Y gf180mcu_as_sc_mcu7t3v3__inv_2_670/A
+ gf180mcu_as_sc_mcu7t3v3__inv_2_670/VNW VSUBS gf180mcu_as_sc_mcu7t3v3__inv_2
Xgf180mcu_as_sc_mcu7t3v3__inv_2_681 VSS VSS VSS gf180mcu_as_sc_mcu7t3v3__inv_2_685/Y
+ gf180mcu_as_sc_mcu7t3v3__inv_2_689/VNW VSUBS gf180mcu_as_sc_mcu7t3v3__inv_2
Xu_t014_014 u_t014_014/c0_w0_bl u_t014_014/c0_w0_br u_t014_014/c0_w1_bl u_t014_014/c0_w1_br
+ u_t014_014/c0_r0_rbl u_t014_014/c0_r1_rbl u_t014_014/c1_w0_bl u_t014_014/c1_w0_br
+ u_t014_014/c1_w1_bl u_t014_014/c1_w1_br u_t014_014/c1_r0_rbl u_t014_014/c1_r1_rbl
+ u_t014_014/c2_w0_bl u_t014_014/c2_w0_br u_t014_014/c2_w1_bl u_t014_014/c2_w1_br
+ u_t014_014/c2_r0_rbl u_t014_014/c2_r1_rbl u_t014_014/c3_w0_bl u_t014_014/c3_w0_br
+ u_t014_014/c3_w1_bl u_t014_014/c3_w1_br u_t014_014/c3_r0_rbl u_t014_014/c3_r1_rbl
+ u_t014_014/r0_w0_wl u_t014_014/r0_w1_wl u_t014_014/r0_r0_rwl u_t014_014/r0_r1_rwl
+ u_t014_014/r1_w0_wl u_t014_014/r1_w1_wl u_t014_014/r1_r0_rwl u_t014_014/r1_r1_rwl
+ u_t014_014/r2_w0_wl u_t014_014/r2_w1_wl u_t014_014/r2_r0_rwl u_t014_014/r2_r1_rwl
+ u_t014_014/r3_w0_wl u_t014_014/r3_w1_wl u_t014_014/r3_r0_rwl u_t014_014/r3_r1_rwl
+ VSS VSS u_t014_014/m2_717_1265# u_t014_014/m2_603_2031# u_t014_014/m2_1290_336#
+ u_t014_014/m2_2000_2037# u_t014_014/m2_791_2909# u_t014_014/m2_7_2126# u_t014_014/m2_2154_2081#
+ u_t014_014/m2_1795_2037# u_t014_014/m2_871_303# u_t014_014/m2_431_438# u_t014_014/m2_1290_2898#
+ u_t014_014/m2_1714_1210# u_t014_014/m2_431_1982# u_t014_014/m2_512_1265# u_t014_014/m2_2573_2126#
+ u_t014_014/m2_603_1259# u_t014_014/m2_2074_2909# u_t014_014/m2_7_336# u_t014_014/m2_717_2037#
+ u_t014_014/m2_1886_2031# u_t014_014/m2_2573_336# u_t014_014/m2_7_2898# u_t014_014/m2_2000_1265#
+ u_t014_014/m2_512_2037# u_t014_014/m2_1795_1265# u_t014_014/m2_1714_1982# u_t014_014/m2_1886_1259#
+ u_t014_014/m2_1290_2126# u_t014_014/m2_1714_438# u_t014_014/m2_431_1210# u_t014_014/m2_2573_2898#
+ u_t014_014/m2_2154_303# u_t014_014/m2_871_2081# VSUBS detronyx_12t_2w2r_rc4_4x4_routed_5layer_direct
Xu_t014_003 u_t014_003/c0_w0_bl u_t014_003/c0_w0_br u_t014_003/c0_w1_bl u_t014_003/c0_w1_br
+ u_t014_003/c0_r0_rbl u_t014_003/c0_r1_rbl u_t014_003/c1_w0_bl u_t014_003/c1_w0_br
+ u_t014_003/c1_w1_bl u_t014_003/c1_w1_br u_t014_003/c1_r0_rbl u_t014_003/c1_r1_rbl
+ u_t014_003/c2_w0_bl u_t014_003/c2_w0_br u_t014_003/c2_w1_bl u_t014_003/c2_w1_br
+ u_t014_003/c2_r0_rbl u_t014_003/c2_r1_rbl u_t014_003/c3_w0_bl u_t014_003/c3_w0_br
+ u_t014_003/c3_w1_bl u_t014_003/c3_w1_br u_t014_003/c3_r0_rbl u_t014_003/c3_r1_rbl
+ u_t014_003/r0_w0_wl u_t014_003/r0_w1_wl u_t014_003/r0_r0_rwl u_t014_003/r0_r1_rwl
+ u_t014_003/r1_w0_wl u_t014_003/r1_w1_wl u_t014_003/r1_r0_rwl u_t014_003/r1_r1_rwl
+ u_t014_003/r2_w0_wl u_t014_003/r2_w1_wl u_t014_003/r2_r0_rwl u_t014_003/r2_r1_rwl
+ u_t014_003/r3_w0_wl u_t014_003/r3_w1_wl u_t014_003/r3_r0_rwl u_t014_003/r3_r1_rwl
+ VSS VSS u_t014_003/m2_717_1265# u_t014_003/m2_603_2031# u_t014_003/m2_1290_336#
+ u_t014_003/m2_2000_2037# u_t014_003/m2_791_2909# u_t014_003/m2_7_2126# u_t014_003/m2_2154_2081#
+ u_t014_003/m2_1795_2037# u_t014_003/m2_871_303# u_t014_003/m2_431_438# u_t014_003/m2_1290_2898#
+ u_t014_003/m2_1714_1210# u_t014_003/m2_431_1982# u_t014_003/m2_512_1265# u_t014_003/m2_2573_2126#
+ u_t014_003/m2_603_1259# u_t014_003/m2_2074_2909# u_t014_003/m2_7_336# u_t014_003/m2_717_2037#
+ u_t014_003/m2_1886_2031# u_t014_003/m2_2573_336# u_t014_003/m2_7_2898# u_t014_003/m2_2000_1265#
+ u_t014_003/m2_512_2037# u_t014_003/m2_1795_1265# u_t014_003/m2_1714_1982# u_t014_003/m2_1886_1259#
+ u_t014_003/m2_1290_2126# u_t014_003/m2_1714_438# u_t014_003/m2_431_1210# u_t014_003/m2_2573_2898#
+ u_t014_003/m2_2154_303# u_t014_003/m2_871_2081# VSUBS detronyx_12t_2w2r_rc4_4x4_routed_5layer_direct
Xgf180mcu_as_sc_mcu7t3v3__nand2_2_37 gf180mcu_as_sc_mcu7t3v3__nand3_2_65/VDD gf180mcu_as_sc_mcu7t3v3__nor2_2_9/VSS
+ VSS VSS VSS gf180mcu_as_sc_mcu7t3v3__nand3_2_65/VNW VSUBS gf180mcu_as_sc_mcu7t3v3__nand2_2
Xgf180mcu_as_sc_mcu7t3v3__nand2_2_48 gf180mcu_as_sc_mcu7t3v3__nand3_2_65/VDD gf180mcu_as_sc_mcu7t3v3__nand3_2_62/VSS
+ VSS VSS VSS gf180mcu_as_sc_mcu7t3v3__nand3_2_65/VNW VSUBS gf180mcu_as_sc_mcu7t3v3__nand2_2
Xgf180mcu_as_sc_mcu7t3v3__nand2_2_26 gf180mcu_as_sc_mcu7t3v3__nor2_2_6/VDD gf180mcu_as_sc_mcu7t3v3__nand3_2_4/VSS
+ VSS VSS VSS gf180mcu_as_sc_mcu7t3v3__nor2_2_6/VNW VSUBS gf180mcu_as_sc_mcu7t3v3__nand2_2
Xgf180mcu_as_sc_mcu7t3v3__nand2_2_15 gf180mcu_as_sc_mcu7t3v3__nor2_2_6/VDD gf180mcu_as_sc_mcu7t3v3__nand3_2_4/VSS
+ VSS VSS VSS gf180mcu_as_sc_mcu7t3v3__nor2_2_6/VNW VSUBS gf180mcu_as_sc_mcu7t3v3__nand2_2
Xu_t005_014 u_t005_014/c0_w0_bl u_t005_014/c0_w0_br u_t005_014/c0_w1_bl u_t005_014/c0_w1_br
+ u_t005_014/c0_r0_rbl u_t005_014/c0_r1_rbl u_t005_014/c1_w0_bl u_t005_014/c1_w0_br
+ u_t005_014/c1_w1_bl u_t005_014/c1_w1_br u_t005_014/c1_r0_rbl u_t005_014/c1_r1_rbl
+ u_t005_014/c2_w0_bl u_t005_014/c2_w0_br u_t005_014/c2_w1_bl u_t005_014/c2_w1_br
+ u_t005_014/c2_r0_rbl u_t005_014/c2_r1_rbl u_t005_014/c3_w0_bl u_t005_014/c3_w0_br
+ u_t005_014/c3_w1_bl u_t005_014/c3_w1_br u_t005_014/c3_r0_rbl u_t005_014/c3_r1_rbl
+ u_t005_014/r0_w0_wl u_t005_014/r0_w1_wl u_t005_014/r0_r0_rwl u_t005_014/r0_r1_rwl
+ u_t005_014/r1_w0_wl u_t005_014/r1_w1_wl u_t005_014/r1_r0_rwl u_t005_014/r1_r1_rwl
+ u_t005_014/r2_w0_wl u_t005_014/r2_w1_wl u_t005_014/r2_r0_rwl u_t005_014/r2_r1_rwl
+ u_t005_014/r3_w0_wl u_t005_014/r3_w1_wl u_t005_014/r3_r0_rwl u_t005_014/r3_r1_rwl
+ VSS VSS u_t005_014/m2_717_1265# u_t005_014/m2_603_2031# u_t005_014/m2_1290_336#
+ u_t005_014/m2_2000_2037# u_t005_014/m2_791_2909# u_t005_014/m2_7_2126# u_t005_014/m2_2154_2081#
+ u_t005_014/m2_1795_2037# u_t005_014/m2_871_303# u_t005_014/m2_431_438# u_t005_014/m2_1290_2898#
+ u_t005_014/m2_1714_1210# u_t005_014/m2_431_1982# u_t005_014/m2_512_1265# u_t005_014/m2_2573_2126#
+ u_t005_014/m2_603_1259# u_t005_014/m2_2074_2909# u_t005_014/m2_7_336# u_t005_014/m2_717_2037#
+ u_t005_014/m2_1886_2031# u_t005_014/m2_2573_336# u_t005_014/m2_7_2898# u_t005_014/m2_2000_1265#
+ u_t005_014/m2_512_2037# u_t005_014/m2_1795_1265# u_t005_014/m2_1714_1982# u_t005_014/m2_1886_1259#
+ u_t005_014/m2_1290_2126# u_t005_014/m2_1714_438# u_t005_014/m2_431_1210# u_t005_014/m2_2573_2898#
+ u_t005_014/m2_2154_303# u_t005_014/m2_871_2081# VSUBS detronyx_12t_2w2r_rc4_4x4_routed_5layer_direct
Xu_t020_006 u_t020_006/c0_w0_bl u_t020_006/c0_w0_br u_t020_006/c0_w1_bl u_t020_006/c0_w1_br
+ u_t020_006/c0_r0_rbl u_t020_006/c0_r1_rbl u_t020_006/c1_w0_bl u_t020_006/c1_w0_br
+ u_t020_006/c1_w1_bl u_t020_006/c1_w1_br u_t020_006/c1_r0_rbl u_t020_006/c1_r1_rbl
+ u_t020_006/c2_w0_bl u_t020_006/c2_w0_br u_t020_006/c2_w1_bl u_t020_006/c2_w1_br
+ u_t020_006/c2_r0_rbl u_t020_006/c2_r1_rbl u_t020_006/c3_w0_bl u_t020_006/c3_w0_br
+ u_t020_006/c3_w1_bl u_t020_006/c3_w1_br u_t020_006/c3_r0_rbl u_t020_006/c3_r1_rbl
+ u_t020_006/r0_w0_wl u_t020_006/r0_w1_wl u_t020_006/r0_r0_rwl u_t020_006/r0_r1_rwl
+ u_t020_006/r1_w0_wl u_t020_006/r1_w1_wl u_t020_006/r1_r0_rwl u_t020_006/r1_r1_rwl
+ u_t020_006/r2_w0_wl u_t020_006/r2_w1_wl u_t020_006/r2_r0_rwl u_t020_006/r2_r1_rwl
+ u_t020_006/r3_w0_wl u_t020_006/r3_w1_wl u_t020_006/r3_r0_rwl u_t020_006/r3_r1_rwl
+ VSS VSS u_t020_006/m2_717_1265# u_t020_006/m2_603_2031# u_t020_006/m2_1290_336#
+ u_t020_006/m2_2000_2037# u_t020_006/m2_791_2909# u_t020_006/m2_7_2126# u_t020_006/m2_2154_2081#
+ u_t020_006/m2_1795_2037# u_t020_006/m2_871_303# u_t020_006/m2_431_438# u_t020_006/m2_1290_2898#
+ u_t020_006/m2_1714_1210# u_t020_006/m2_431_1982# u_t020_006/m2_512_1265# u_t020_006/m2_2573_2126#
+ u_t020_006/m2_603_1259# u_t020_006/m2_2074_2909# u_t020_006/m2_7_336# u_t020_006/m2_717_2037#
+ u_t020_006/m2_1886_2031# u_t020_006/m2_2573_336# u_t020_006/m2_7_2898# u_t020_006/m2_2000_1265#
+ u_t020_006/m2_512_2037# u_t020_006/m2_1795_1265# u_t020_006/m2_1714_1982# u_t020_006/m2_1886_1259#
+ u_t020_006/m2_1290_2126# u_t020_006/m2_1714_438# u_t020_006/m2_431_1210# u_t020_006/m2_2573_2898#
+ u_t020_006/m2_2154_303# u_t020_006/m2_871_2081# VSUBS detronyx_12t_2w2r_rc4_4x4_routed_5layer_direct
Xu_t005_003 u_t005_003/c0_w0_bl u_t005_003/c0_w0_br u_t005_003/c0_w1_bl u_t005_003/c0_w1_br
+ u_t005_003/c0_r0_rbl u_t005_003/c0_r1_rbl u_t005_003/c1_w0_bl u_t005_003/c1_w0_br
+ u_t005_003/c1_w1_bl u_t005_003/c1_w1_br u_t005_003/c1_r0_rbl u_t005_003/c1_r1_rbl
+ u_t005_003/c2_w0_bl u_t005_003/c2_w0_br u_t005_003/c2_w1_bl u_t005_003/c2_w1_br
+ u_t005_003/c2_r0_rbl u_t005_003/c2_r1_rbl u_t005_003/c3_w0_bl u_t005_003/c3_w0_br
+ u_t005_003/c3_w1_bl u_t005_003/c3_w1_br u_t005_003/c3_r0_rbl u_t005_003/c3_r1_rbl
+ u_t005_003/r0_w0_wl u_t005_003/r0_w1_wl u_t005_003/r0_r0_rwl u_t005_003/r0_r1_rwl
+ u_t005_003/r1_w0_wl u_t005_003/r1_w1_wl u_t005_003/r1_r0_rwl u_t005_003/r1_r1_rwl
+ u_t005_003/r2_w0_wl u_t005_003/r2_w1_wl u_t005_003/r2_r0_rwl u_t005_003/r2_r1_rwl
+ u_t005_003/r3_w0_wl u_t005_003/r3_w1_wl u_t005_003/r3_r0_rwl u_t005_003/r3_r1_rwl
+ VSS VSS u_t005_003/m2_717_1265# u_t005_003/m2_603_2031# u_t005_003/m2_1290_336#
+ u_t005_003/m2_2000_2037# u_t005_003/m2_791_2909# u_t005_003/m2_7_2126# u_t005_003/m2_2154_2081#
+ u_t005_003/m2_1795_2037# u_t005_003/m2_871_303# u_t005_003/m2_431_438# u_t005_003/m2_1290_2898#
+ u_t005_003/m2_1714_1210# u_t005_003/m2_431_1982# u_t005_003/m2_512_1265# u_t005_003/m2_2573_2126#
+ u_t005_003/m2_603_1259# u_t005_003/m2_2074_2909# u_t005_003/m2_7_336# u_t005_003/m2_717_2037#
+ u_t005_003/m2_1886_2031# u_t005_003/m2_2573_336# u_t005_003/m2_7_2898# u_t005_003/m2_2000_1265#
+ u_t005_003/m2_512_2037# u_t005_003/m2_1795_1265# u_t005_003/m2_1714_1982# u_t005_003/m2_1886_1259#
+ u_t005_003/m2_1290_2126# u_t005_003/m2_1714_438# u_t005_003/m2_431_1210# u_t005_003/m2_2573_2898#
+ u_t005_003/m2_2154_303# u_t005_003/m2_871_2081# VSUBS detronyx_12t_2w2r_rc4_4x4_routed_5layer_direct
Xu_t011_006 u_t011_006/c0_w0_bl u_t011_006/c0_w0_br u_t011_006/c0_w1_bl u_t011_006/c0_w1_br
+ u_t011_006/c0_r0_rbl u_t011_006/c0_r1_rbl u_t011_006/c1_w0_bl u_t011_006/c1_w0_br
+ u_t011_006/c1_w1_bl u_t011_006/c1_w1_br u_t011_006/c1_r0_rbl u_t011_006/c1_r1_rbl
+ u_t011_006/c2_w0_bl u_t011_006/c2_w0_br u_t011_006/c2_w1_bl u_t011_006/c2_w1_br
+ u_t011_006/c2_r0_rbl u_t011_006/c2_r1_rbl u_t011_006/c3_w0_bl u_t011_006/c3_w0_br
+ u_t011_006/c3_w1_bl u_t011_006/c3_w1_br u_t011_006/c3_r0_rbl u_t011_006/c3_r1_rbl
+ u_t011_006/r0_w0_wl u_t011_006/r0_w1_wl u_t011_006/r0_r0_rwl u_t011_006/r0_r1_rwl
+ u_t011_006/r1_w0_wl u_t011_006/r1_w1_wl u_t011_006/r1_r0_rwl u_t011_006/r1_r1_rwl
+ u_t011_006/r2_w0_wl u_t011_006/r2_w1_wl u_t011_006/r2_r0_rwl u_t011_006/r2_r1_rwl
+ u_t011_006/r3_w0_wl u_t011_006/r3_w1_wl u_t011_006/r3_r0_rwl u_t011_006/r3_r1_rwl
+ VSS VSS u_t011_006/m2_717_1265# u_t011_006/m2_603_2031# u_t011_006/m2_1290_336#
+ u_t011_006/m2_2000_2037# u_t011_006/m2_791_2909# u_t011_006/m2_7_2126# u_t011_006/m2_2154_2081#
+ u_t011_006/m2_1795_2037# u_t011_006/m2_871_303# u_t011_006/m2_431_438# u_t011_006/m2_1290_2898#
+ u_t011_006/m2_1714_1210# u_t011_006/m2_431_1982# u_t011_006/m2_512_1265# u_t011_006/m2_2573_2126#
+ u_t011_006/m2_603_1259# u_t011_006/m2_2074_2909# u_t011_006/m2_7_336# u_t011_006/m2_717_2037#
+ u_t011_006/m2_1886_2031# u_t011_006/m2_2573_336# u_t011_006/m2_7_2898# u_t011_006/m2_2000_1265#
+ u_t011_006/m2_512_2037# u_t011_006/m2_1795_1265# u_t011_006/m2_1714_1982# u_t011_006/m2_1886_1259#
+ u_t011_006/m2_1290_2126# u_t011_006/m2_1714_438# u_t011_006/m2_431_1210# u_t011_006/m2_2573_2898#
+ u_t011_006/m2_2154_303# u_t011_006/m2_871_2081# VSUBS detronyx_12t_2w2r_rc4_4x4_routed_5layer_direct
Xu_t002_006 u_t002_006/c0_w0_bl u_t002_006/c0_w0_br u_t002_006/c0_w1_bl u_t002_006/c0_w1_br
+ u_t002_006/c0_r0_rbl u_t002_006/c0_r1_rbl u_t002_006/c1_w0_bl u_t002_006/c1_w0_br
+ u_t002_006/c1_w1_bl u_t002_006/c1_w1_br u_t002_006/c1_r0_rbl u_t002_006/c1_r1_rbl
+ u_t002_006/c2_w0_bl u_t002_006/c2_w0_br u_t002_006/c2_w1_bl u_t002_006/c2_w1_br
+ u_t002_006/c2_r0_rbl u_t002_006/c2_r1_rbl u_t002_006/c3_w0_bl u_t002_006/c3_w0_br
+ u_t002_006/c3_w1_bl u_t002_006/c3_w1_br u_t002_006/c3_r0_rbl u_t002_006/c3_r1_rbl
+ u_t002_006/r0_w0_wl u_t002_006/r0_w1_wl u_t002_006/r0_r0_rwl u_t002_006/r0_r1_rwl
+ u_t002_006/r1_w0_wl u_t002_006/r1_w1_wl u_t002_006/r1_r0_rwl u_t002_006/r1_r1_rwl
+ u_t002_006/r2_w0_wl u_t002_006/r2_w1_wl u_t002_006/r2_r0_rwl u_t002_006/r2_r1_rwl
+ u_t002_006/r3_w0_wl u_t002_006/r3_w1_wl u_t002_006/r3_r0_rwl u_t002_006/r3_r1_rwl
+ VSS VSS u_t002_006/m2_717_1265# u_t002_006/m2_603_2031# u_t002_006/m2_1290_336#
+ u_t002_006/m2_2000_2037# u_t002_006/m2_791_2909# u_t002_006/m2_7_2126# u_t002_006/m2_2154_2081#
+ u_t002_006/m2_1795_2037# u_t002_006/m2_871_303# u_t002_006/m2_431_438# u_t002_006/m2_1290_2898#
+ u_t002_006/m2_1714_1210# u_t002_006/m2_431_1982# u_t002_006/m2_512_1265# u_t002_006/m2_2573_2126#
+ u_t002_006/m2_603_1259# u_t002_006/m2_2074_2909# u_t002_006/m2_7_336# u_t002_006/m2_717_2037#
+ u_t002_006/m2_1886_2031# u_t002_006/m2_2573_336# u_t002_006/m2_7_2898# u_t002_006/m2_2000_1265#
+ u_t002_006/m2_512_2037# u_t002_006/m2_1795_1265# u_t002_006/m2_1714_1982# u_t002_006/m2_1886_1259#
+ u_t002_006/m2_1290_2126# u_t002_006/m2_1714_438# u_t002_006/m2_431_1210# u_t002_006/m2_2573_2898#
+ u_t002_006/m2_2154_303# u_t002_006/m2_871_2081# VSUBS detronyx_12t_2w2r_rc4_4x4_routed_5layer_direct
Xgf180mcu_as_sc_mcu7t3v3__inv_2_1207 gf180mcu_as_sc_mcu7t3v3__nand3_2_65/VDD gf180mcu_as_sc_mcu7t3v3__nor2_2_9/VSS
+ VSS VSS gf180mcu_as_sc_mcu7t3v3__nand3_2_65/VNW VSUBS gf180mcu_as_sc_mcu7t3v3__inv_2
Xgf180mcu_as_sc_mcu7t3v3__inv_2_1218 VSS VSS gf180mcu_as_sc_mcu7t3v3__inv_2_1274/A
+ gf180mcu_as_sc_mcu7t3v3__inv_2_1219/Y gf180mcu_as_sc_mcu7t3v3__inv_2_1274/VNW VSUBS
+ gf180mcu_as_sc_mcu7t3v3__inv_2
Xgf180mcu_as_sc_mcu7t3v3__inv_2_1229 VSS VSS gf180mcu_as_sc_mcu7t3v3__inv_2_1278/A
+ gf180mcu_as_sc_mcu7t3v3__inv_2_1229/A gf180mcu_as_sc_mcu7t3v3__inv_2_1278/VNW VSUBS
+ gf180mcu_as_sc_mcu7t3v3__inv_2
Xgf180mcu_as_sc_mcu7t3v3__nand4_2_502 VSS VSS VSS VSS VSS VSS gf180mcu_as_sc_mcu7t3v3__inv_2_1649/A
+ gf180mcu_as_sc_mcu7t3v3__inv_2_1649/VNW VSUBS gf180mcu_as_sc_mcu7t3v3__nand4_2
Xgf180mcu_as_sc_mcu7t3v3__nand4_2_513 VSS VSS VSS VSS VSS VSS gf180mcu_as_sc_mcu7t3v3__inv_2_1726/A
+ gf180mcu_as_sc_mcu7t3v3__inv_2_1726/VNW VSUBS gf180mcu_as_sc_mcu7t3v3__nand4_2
Xgf180mcu_as_sc_mcu7t3v3__inv_2_34 VSS VSS VSS gf180mcu_as_sc_mcu7t3v3__inv_2_35/Y
+ gf180mcu_as_sc_mcu7t3v3__inv_2_36/VNW VSUBS gf180mcu_as_sc_mcu7t3v3__inv_2
Xgf180mcu_as_sc_mcu7t3v3__inv_2_12 VSS VSS gf180mcu_as_sc_mcu7t3v3__inv_2_12/Y gf180mcu_as_sc_mcu7t3v3__inv_2_12/A
+ gf180mcu_as_sc_mcu7t3v3__inv_2_12/VNW VSUBS gf180mcu_as_sc_mcu7t3v3__inv_2
Xgf180mcu_as_sc_mcu7t3v3__inv_2_23 VSS VSS gf180mcu_as_sc_mcu7t3v3__inv_2_23/Y gf180mcu_as_sc_mcu7t3v3__inv_2_24/Y
+ gf180mcu_as_sc_mcu7t3v3__inv_2_24/VNW VSUBS gf180mcu_as_sc_mcu7t3v3__inv_2
Xgf180mcu_as_sc_mcu7t3v3__inv_2_1015 VSS VSS gf180mcu_as_sc_mcu7t3v3__inv_2_1015/Y
+ gf180mcu_as_sc_mcu7t3v3__inv_2_1016/Y gf180mcu_as_sc_mcu7t3v3__inv_2_1016/VNW VSUBS
+ gf180mcu_as_sc_mcu7t3v3__inv_2
Xgf180mcu_as_sc_mcu7t3v3__inv_2_1026 VSS VSS VSS gf180mcu_as_sc_mcu7t3v3__inv_2_1027/Y
+ gf180mcu_as_sc_mcu7t3v3__inv_2_1028/VNW VSUBS gf180mcu_as_sc_mcu7t3v3__inv_2
Xgf180mcu_as_sc_mcu7t3v3__inv_2_1037 VSS VSS gf180mcu_as_sc_mcu7t3v3__inv_2_1037/Y
+ gf180mcu_as_sc_mcu7t3v3__inv_2_1037/A gf180mcu_as_sc_mcu7t3v3__inv_2_1037/VNW VSUBS
+ gf180mcu_as_sc_mcu7t3v3__inv_2
Xgf180mcu_as_sc_mcu7t3v3__inv_2_1048 VSS VSS gf180mcu_as_sc_mcu7t3v3__inv_2_1048/Y
+ gf180mcu_as_sc_mcu7t3v3__inv_2_1048/A gf180mcu_as_sc_mcu7t3v3__inv_2_1048/VNW VSUBS
+ gf180mcu_as_sc_mcu7t3v3__inv_2
Xgf180mcu_as_sc_mcu7t3v3__inv_2_78 VSS VSS gf180mcu_as_sc_mcu7t3v3__inv_2_94/A gf180mcu_as_sc_mcu7t3v3__inv_2_78/A
+ gf180mcu_as_sc_mcu7t3v3__inv_2_94/VNW VSUBS gf180mcu_as_sc_mcu7t3v3__inv_2
Xgf180mcu_as_sc_mcu7t3v3__inv_2_89 VSS VSS gf180mcu_as_sc_mcu7t3v3__inv_2_89/Y gf180mcu_as_sc_mcu7t3v3__inv_2_90/Y
+ gf180mcu_as_sc_mcu7t3v3__inv_2_90/VNW VSUBS gf180mcu_as_sc_mcu7t3v3__inv_2
Xgf180mcu_as_sc_mcu7t3v3__inv_2_45 VSS VSS gf180mcu_as_sc_mcu7t3v3__inv_2_45/Y gf180mcu_as_sc_mcu7t3v3__inv_2_46/Y
+ gf180mcu_as_sc_mcu7t3v3__inv_2_46/VNW VSUBS gf180mcu_as_sc_mcu7t3v3__inv_2
Xgf180mcu_as_sc_mcu7t3v3__inv_2_67 VSS VSS VSS gf180mcu_as_sc_mcu7t3v3__inv_2_68/Y
+ gf180mcu_as_sc_mcu7t3v3__inv_2_69/VNW VSUBS gf180mcu_as_sc_mcu7t3v3__inv_2
Xgf180mcu_as_sc_mcu7t3v3__inv_2_56 VSS VSS gf180mcu_as_sc_mcu7t3v3__inv_2_56/Y gf180mcu_as_sc_mcu7t3v3__inv_2_57/Y
+ gf180mcu_as_sc_mcu7t3v3__inv_2_57/VNW VSUBS gf180mcu_as_sc_mcu7t3v3__inv_2
Xgf180mcu_as_sc_mcu7t3v3__inv_2_1004 VSS VSS gf180mcu_as_sc_mcu7t3v3__inv_2_1004/Y
+ gf180mcu_as_sc_mcu7t3v3__inv_2_1004/A gf180mcu_as_sc_mcu7t3v3__inv_2_1004/VNW VSUBS
+ gf180mcu_as_sc_mcu7t3v3__inv_2
Xgf180mcu_as_sc_mcu7t3v3__inv_2_1059 VSS VSS VSS gf180mcu_as_sc_mcu7t3v3__inv_2_1060/Y
+ gf180mcu_as_sc_mcu7t3v3__inv_2_1061/VNW VSUBS gf180mcu_as_sc_mcu7t3v3__inv_2
Xgf180mcu_as_sc_mcu7t3v3__inv_2_1593 VSS VSS gf180mcu_as_sc_mcu7t3v3__inv_2_1593/Y
+ gf180mcu_as_sc_mcu7t3v3__inv_2_1594/Y gf180mcu_as_sc_mcu7t3v3__inv_2_1594/VNW VSUBS
+ gf180mcu_as_sc_mcu7t3v3__inv_2
Xgf180mcu_as_sc_mcu7t3v3__inv_2_1571 VSS VSS VSS gf180mcu_as_sc_mcu7t3v3__inv_2_1572/Y
+ gf180mcu_as_sc_mcu7t3v3__inv_2_1573/VNW VSUBS gf180mcu_as_sc_mcu7t3v3__inv_2
Xgf180mcu_as_sc_mcu7t3v3__inv_2_1582 VSS VSS gf180mcu_as_sc_mcu7t3v3__inv_2_1582/Y
+ gf180mcu_as_sc_mcu7t3v3__inv_2_1582/A gf180mcu_as_sc_mcu7t3v3__inv_2_1582/VNW VSUBS
+ gf180mcu_as_sc_mcu7t3v3__inv_2
Xgf180mcu_as_sc_mcu7t3v3__inv_2_1560 VSS VSS VSS gf180mcu_as_sc_mcu7t3v3__inv_2_1561/Y
+ gf180mcu_as_sc_mcu7t3v3__inv_2_1562/VNW VSUBS gf180mcu_as_sc_mcu7t3v3__inv_2
Xgf180mcu_as_sc_mcu7t3v3__nand3_2_4 gf180mcu_as_sc_mcu7t3v3__nor2_2_7/VDD gf180mcu_as_sc_mcu7t3v3__nand3_2_4/VSS
+ VSS VSS VSS VSS gf180mcu_as_sc_mcu7t3v3__nor2_2_7/VNW VSUBS gf180mcu_as_sc_mcu7t3v3__nand3_2
Xgf180mcu_as_sc_mcu7t3v3__nand4_2_310 VSS VSS VSS VSS VSS VSS gf180mcu_as_sc_mcu7t3v3__inv_2_1020/A
+ gf180mcu_as_sc_mcu7t3v3__inv_2_1020/VNW VSUBS gf180mcu_as_sc_mcu7t3v3__nand4_2
Xgf180mcu_as_sc_mcu7t3v3__nand4_2_376 VSS VSS VSS VSS VSS VSS gf180mcu_as_sc_mcu7t3v3__inv_2_1227/A
+ gf180mcu_as_sc_mcu7t3v3__inv_2_1277/VNW VSUBS gf180mcu_as_sc_mcu7t3v3__nand4_2
Xgf180mcu_as_sc_mcu7t3v3__nand4_2_365 VSS VSS VSS VSS VSS VSS gf180mcu_as_sc_mcu7t3v3__inv_2_1186/A
+ gf180mcu_as_sc_mcu7t3v3__inv_2_1278/VNW VSUBS gf180mcu_as_sc_mcu7t3v3__nand4_2
Xgf180mcu_as_sc_mcu7t3v3__nand4_2_343 VSS VSS VSS VSS VSS VSS gf180mcu_as_sc_mcu7t3v3__inv_2_1118/A
+ gf180mcu_as_sc_mcu7t3v3__inv_2_1118/VNW VSUBS gf180mcu_as_sc_mcu7t3v3__nand4_2
Xgf180mcu_as_sc_mcu7t3v3__nand4_2_321 VSS VSS VSS VSS VSS VSS gf180mcu_as_sc_mcu7t3v3__inv_2_1079/A
+ gf180mcu_as_sc_mcu7t3v3__inv_2_1079/VNW VSUBS gf180mcu_as_sc_mcu7t3v3__nand4_2
Xgf180mcu_as_sc_mcu7t3v3__nand4_2_354 VSS VSS VSS VSS VSS VSS gf180mcu_as_sc_mcu7t3v3__inv_2_1164/A
+ gf180mcu_as_sc_mcu7t3v3__inv_2_1293/VNW VSUBS gf180mcu_as_sc_mcu7t3v3__nand4_2
Xgf180mcu_as_sc_mcu7t3v3__nand4_2_332 VSS VSS VSS VSS VSS VSS gf180mcu_as_sc_mcu7t3v3__inv_2_1096/A
+ gf180mcu_as_sc_mcu7t3v3__inv_2_1096/VNW VSUBS gf180mcu_as_sc_mcu7t3v3__nand4_2
Xgf180mcu_as_sc_mcu7t3v3__nand4_2_398 VSS VSS VSS VSS VSS VSS gf180mcu_as_sc_mcu7t3v3__inv_2_1464/A
+ gf180mcu_as_sc_mcu7t3v3__inv_2_1464/VNW VSUBS gf180mcu_as_sc_mcu7t3v3__nand4_2
Xgf180mcu_as_sc_mcu7t3v3__nand4_2_387 VSS VSS VSS VSS VSS VSS gf180mcu_as_sc_mcu7t3v3__inv_2_1431/A
+ gf180mcu_as_sc_mcu7t3v3__inv_2_1431/VNW VSUBS gf180mcu_as_sc_mcu7t3v3__nand4_2
Xgf180mcu_as_sc_mcu7t3v3__inv_2_307 VSS VSS gf180mcu_as_sc_mcu7t3v3__inv_2_307/Y gf180mcu_as_sc_mcu7t3v3__inv_2_307/A
+ gf180mcu_as_sc_mcu7t3v3__inv_2_307/VNW VSUBS gf180mcu_as_sc_mcu7t3v3__inv_2
Xgf180mcu_as_sc_mcu7t3v3__inv_2_329 VSS VSS gf180mcu_as_sc_mcu7t3v3__inv_2_329/Y gf180mcu_as_sc_mcu7t3v3__inv_2_329/A
+ gf180mcu_as_sc_mcu7t3v3__inv_2_329/VNW VSUBS gf180mcu_as_sc_mcu7t3v3__inv_2
Xgf180mcu_as_sc_mcu7t3v3__inv_2_318 VSS VSS VSS gf180mcu_as_sc_mcu7t3v3__inv_2_319/Y
+ gf180mcu_as_sc_mcu7t3v3__inv_2_320/VNW VSUBS gf180mcu_as_sc_mcu7t3v3__inv_2
Xgf180mcu_as_sc_mcu7t3v3__inv_2_1390 VSS VSS gf180mcu_as_sc_mcu7t3v3__inv_2_1390/Y
+ gf180mcu_as_sc_mcu7t3v3__inv_2_1390/A gf180mcu_as_sc_mcu7t3v3__inv_2_1390/VNW VSUBS
+ gf180mcu_as_sc_mcu7t3v3__inv_2
Xgf180mcu_as_sc_mcu7t3v3__inv_2_896 VSS VSS gf180mcu_as_sc_mcu7t3v3__inv_2_896/Y gf180mcu_as_sc_mcu7t3v3__inv_2_896/A
+ gf180mcu_as_sc_mcu7t3v3__inv_2_926/VNW VSUBS gf180mcu_as_sc_mcu7t3v3__inv_2
Xgf180mcu_as_sc_mcu7t3v3__inv_2_852 VSS VSS VSS gf180mcu_as_sc_mcu7t3v3__inv_2_853/Y
+ gf180mcu_as_sc_mcu7t3v3__inv_2_854/VNW VSUBS gf180mcu_as_sc_mcu7t3v3__inv_2
Xgf180mcu_as_sc_mcu7t3v3__inv_2_830 VSS VSS VSS gf180mcu_as_sc_mcu7t3v3__inv_2_830/A
+ gf180mcu_as_sc_mcu7t3v3__inv_2_830/VNW VSUBS gf180mcu_as_sc_mcu7t3v3__inv_2
Xgf180mcu_as_sc_mcu7t3v3__inv_2_841 VSS VSS VSS gf180mcu_as_sc_mcu7t3v3__inv_2_841/A
+ gf180mcu_as_sc_mcu7t3v3__inv_2_841/VNW VSUBS gf180mcu_as_sc_mcu7t3v3__inv_2
Xgf180mcu_as_sc_mcu7t3v3__inv_2_863 VSS VSS gf180mcu_as_sc_mcu7t3v3__inv_2_938/A gf180mcu_as_sc_mcu7t3v3__inv_2_864/Y
+ gf180mcu_as_sc_mcu7t3v3__inv_2_938/VNW VSUBS gf180mcu_as_sc_mcu7t3v3__inv_2
Xgf180mcu_as_sc_mcu7t3v3__inv_2_885 VSS VSS gf180mcu_as_sc_mcu7t3v3__inv_2_885/Y gf180mcu_as_sc_mcu7t3v3__inv_2_885/A
+ gf180mcu_as_sc_mcu7t3v3__inv_2_934/VNW VSUBS gf180mcu_as_sc_mcu7t3v3__inv_2
Xgf180mcu_as_sc_mcu7t3v3__inv_2_874 VSS VSS gf180mcu_as_sc_mcu7t3v3__inv_2_874/Y gf180mcu_as_sc_mcu7t3v3__inv_2_874/A
+ gf180mcu_as_sc_mcu7t3v3__inv_2_930/VNW VSUBS gf180mcu_as_sc_mcu7t3v3__inv_2
Xgf180mcu_as_sc_mcu7t3v3__nand4_2_151 gf180mcu_as_sc_mcu7t3v3__nor2_2_4/VDD gf180mcu_as_sc_mcu7t3v3__nand2_2_3/VSS
+ VSS VSS VSS VSS VSS gf180mcu_as_sc_mcu7t3v3__nor2_2_4/VNW VSUBS gf180mcu_as_sc_mcu7t3v3__nand4_2
Xgf180mcu_as_sc_mcu7t3v3__nand4_2_140 VSS VSS VSS VSS VSS VSS gf180mcu_as_sc_mcu7t3v3__inv_2_505/A
+ gf180mcu_as_sc_mcu7t3v3__inv_2_537/VNW VSUBS gf180mcu_as_sc_mcu7t3v3__nand4_2
Xgf180mcu_as_sc_mcu7t3v3__nand4_2_162 VSS VSS VSS VSS VSS VSS gf180mcu_as_sc_mcu7t3v3__inv_2_616/A
+ gf180mcu_as_sc_mcu7t3v3__inv_2_616/VNW VSUBS gf180mcu_as_sc_mcu7t3v3__nand4_2
Xu_t026_012 u_t026_012/c0_w0_bl u_t026_012/c0_w0_br u_t026_012/c0_w1_bl u_t026_012/c0_w1_br
+ u_t026_012/c0_r0_rbl u_t026_012/c0_r1_rbl u_t026_012/c1_w0_bl u_t026_012/c1_w0_br
+ u_t026_012/c1_w1_bl u_t026_012/c1_w1_br u_t026_012/c1_r0_rbl u_t026_012/c1_r1_rbl
+ u_t026_012/c2_w0_bl u_t026_012/c2_w0_br u_t026_012/c2_w1_bl u_t026_012/c2_w1_br
+ u_t026_012/c2_r0_rbl u_t026_012/c2_r1_rbl u_t026_012/c3_w0_bl u_t026_012/c3_w0_br
+ u_t026_012/c3_w1_bl u_t026_012/c3_w1_br u_t026_012/c3_r0_rbl u_t026_012/c3_r1_rbl
+ u_t026_012/r0_w0_wl u_t026_012/r0_w1_wl u_t026_012/r0_r0_rwl u_t026_012/r0_r1_rwl
+ u_t026_012/r1_w0_wl u_t026_012/r1_w1_wl u_t026_012/r1_r0_rwl u_t026_012/r1_r1_rwl
+ u_t026_012/r2_w0_wl u_t026_012/r2_w1_wl u_t026_012/r2_r0_rwl u_t026_012/r2_r1_rwl
+ u_t026_012/r3_w0_wl u_t026_012/r3_w1_wl u_t026_012/r3_r0_rwl u_t026_012/r3_r1_rwl
+ VSS VSS u_t026_012/m2_717_1265# u_t026_012/m2_603_2031# u_t026_012/m2_1290_336#
+ u_t026_012/m2_2000_2037# u_t026_012/m2_791_2909# u_t026_012/m2_7_2126# u_t026_012/m2_2154_2081#
+ u_t026_012/m2_1795_2037# u_t026_012/m2_871_303# u_t026_012/m2_431_438# u_t026_012/m2_1290_2898#
+ u_t026_012/m2_1714_1210# u_t026_012/m2_431_1982# u_t026_012/m2_512_1265# u_t026_012/m2_2573_2126#
+ u_t026_012/m2_603_1259# u_t026_012/m2_2074_2909# u_t026_012/m2_7_336# u_t026_012/m2_717_2037#
+ u_t026_012/m2_1886_2031# u_t026_012/m2_2573_336# u_t026_012/m2_7_2898# u_t026_012/m2_2000_1265#
+ u_t026_012/m2_512_2037# u_t026_012/m2_1795_1265# u_t026_012/m2_1714_1982# u_t026_012/m2_1886_1259#
+ u_t026_012/m2_1290_2126# u_t026_012/m2_1714_438# u_t026_012/m2_431_1210# u_t026_012/m2_2573_2898#
+ u_t026_012/m2_2154_303# u_t026_012/m2_871_2081# VSUBS detronyx_12t_2w2r_rc4_4x4_routed_5layer_direct
Xu_t026_001 u_t026_001/c0_w0_bl u_t026_001/c0_w0_br u_t026_001/c0_w1_bl u_t026_001/c0_w1_br
+ u_t026_001/c0_r0_rbl u_t026_001/c0_r1_rbl u_t026_001/c1_w0_bl u_t026_001/c1_w0_br
+ u_t026_001/c1_w1_bl u_t026_001/c1_w1_br u_t026_001/c1_r0_rbl u_t026_001/c1_r1_rbl
+ u_t026_001/c2_w0_bl u_t026_001/c2_w0_br u_t026_001/c2_w1_bl u_t026_001/c2_w1_br
+ u_t026_001/c2_r0_rbl u_t026_001/c2_r1_rbl u_t026_001/c3_w0_bl u_t026_001/c3_w0_br
+ u_t026_001/c3_w1_bl u_t026_001/c3_w1_br u_t026_001/c3_r0_rbl u_t026_001/c3_r1_rbl
+ u_t026_001/r0_w0_wl u_t026_001/r0_w1_wl u_t026_001/r0_r0_rwl u_t026_001/r0_r1_rwl
+ u_t026_001/r1_w0_wl u_t026_001/r1_w1_wl u_t026_001/r1_r0_rwl u_t026_001/r1_r1_rwl
+ u_t026_001/r2_w0_wl u_t026_001/r2_w1_wl u_t026_001/r2_r0_rwl u_t026_001/r2_r1_rwl
+ u_t026_001/r3_w0_wl u_t026_001/r3_w1_wl u_t026_001/r3_r0_rwl u_t026_001/r3_r1_rwl
+ VSS VSS u_t026_001/m2_717_1265# u_t026_001/m2_603_2031# u_t026_001/m2_1290_336#
+ u_t026_001/m2_2000_2037# u_t026_001/m2_791_2909# u_t026_001/m2_7_2126# u_t026_001/m2_2154_2081#
+ u_t026_001/m2_1795_2037# u_t026_001/m2_871_303# u_t026_001/m2_431_438# u_t026_001/m2_1290_2898#
+ u_t026_001/m2_1714_1210# u_t026_001/m2_431_1982# u_t026_001/m2_512_1265# u_t026_001/m2_2573_2126#
+ u_t026_001/m2_603_1259# u_t026_001/m2_2074_2909# u_t026_001/m2_7_336# u_t026_001/m2_717_2037#
+ u_t026_001/m2_1886_2031# u_t026_001/m2_2573_336# u_t026_001/m2_7_2898# u_t026_001/m2_2000_1265#
+ u_t026_001/m2_512_2037# u_t026_001/m2_1795_1265# u_t026_001/m2_1714_1982# u_t026_001/m2_1886_1259#
+ u_t026_001/m2_1290_2126# u_t026_001/m2_1714_438# u_t026_001/m2_431_1210# u_t026_001/m2_2573_2898#
+ u_t026_001/m2_2154_303# u_t026_001/m2_871_2081# VSUBS detronyx_12t_2w2r_rc4_4x4_routed_5layer_direct
Xgf180mcu_as_sc_mcu7t3v3__nand4_2_173 VSS VSS VSS VSS VSS VSS gf180mcu_as_sc_mcu7t3v3__inv_2_617/A
+ gf180mcu_as_sc_mcu7t3v3__inv_2_617/VNW VSUBS gf180mcu_as_sc_mcu7t3v3__nand4_2
Xgf180mcu_as_sc_mcu7t3v3__nand4_2_90 VSS VSS VSS VSS VSS VSS gf180mcu_as_sc_mcu7t3v3__inv_2_42/A
+ gf180mcu_as_sc_mcu7t3v3__inv_2_42/VNW VSUBS gf180mcu_as_sc_mcu7t3v3__nand4_2
Xgf180mcu_as_sc_mcu7t3v3__nand4_2_184 VSS VSS VSS VSS VSS VSS gf180mcu_as_sc_mcu7t3v3__inv_2_708/A
+ gf180mcu_as_sc_mcu7t3v3__inv_2_708/VNW VSUBS gf180mcu_as_sc_mcu7t3v3__nand4_2
Xgf180mcu_as_sc_mcu7t3v3__nand4_2_195 VSS VSS VSS VSS VSS VSS gf180mcu_as_sc_mcu7t3v3__inv_2_717/A
+ gf180mcu_as_sc_mcu7t3v3__inv_2_717/VNW VSUBS gf180mcu_as_sc_mcu7t3v3__nand4_2
Xu_t017_012 u_t017_012/c0_w0_bl u_t017_012/c0_w0_br u_t017_012/c0_w1_bl u_t017_012/c0_w1_br
+ u_t017_012/c0_r0_rbl u_t017_012/c0_r1_rbl u_t017_012/c1_w0_bl u_t017_012/c1_w0_br
+ u_t017_012/c1_w1_bl u_t017_012/c1_w1_br u_t017_012/c1_r0_rbl u_t017_012/c1_r1_rbl
+ u_t017_012/c2_w0_bl u_t017_012/c2_w0_br u_t017_012/c2_w1_bl u_t017_012/c2_w1_br
+ u_t017_012/c2_r0_rbl u_t017_012/c2_r1_rbl u_t017_012/c3_w0_bl u_t017_012/c3_w0_br
+ u_t017_012/c3_w1_bl u_t017_012/c3_w1_br u_t017_012/c3_r0_rbl u_t017_012/c3_r1_rbl
+ u_t017_012/r0_w0_wl u_t017_012/r0_w1_wl u_t017_012/r0_r0_rwl u_t017_012/r0_r1_rwl
+ u_t017_012/r1_w0_wl u_t017_012/r1_w1_wl u_t017_012/r1_r0_rwl u_t017_012/r1_r1_rwl
+ u_t017_012/r2_w0_wl u_t017_012/r2_w1_wl u_t017_012/r2_r0_rwl u_t017_012/r2_r1_rwl
+ u_t017_012/r3_w0_wl u_t017_012/r3_w1_wl u_t017_012/r3_r0_rwl u_t017_012/r3_r1_rwl
+ VSS VSS u_t017_012/m2_717_1265# u_t017_012/m2_603_2031# u_t017_012/m2_1290_336#
+ u_t017_012/m2_2000_2037# u_t017_012/m2_791_2909# u_t017_012/m2_7_2126# u_t017_012/m2_2154_2081#
+ u_t017_012/m2_1795_2037# u_t017_012/m2_871_303# u_t017_012/m2_431_438# u_t017_012/m2_1290_2898#
+ u_t017_012/m2_1714_1210# u_t017_012/m2_431_1982# u_t017_012/m2_512_1265# u_t017_012/m2_2573_2126#
+ u_t017_012/m2_603_1259# u_t017_012/m2_2074_2909# u_t017_012/m2_7_336# u_t017_012/m2_717_2037#
+ u_t017_012/m2_1886_2031# u_t017_012/m2_2573_336# u_t017_012/m2_7_2898# u_t017_012/m2_2000_1265#
+ u_t017_012/m2_512_2037# u_t017_012/m2_1795_1265# u_t017_012/m2_1714_1982# u_t017_012/m2_1886_1259#
+ u_t017_012/m2_1290_2126# u_t017_012/m2_1714_438# u_t017_012/m2_431_1210# u_t017_012/m2_2573_2898#
+ u_t017_012/m2_2154_303# u_t017_012/m2_871_2081# VSUBS detronyx_12t_2w2r_rc4_4x4_routed_5layer_direct
Xu_t017_001 u_t017_001/c0_w0_bl u_t017_001/c0_w0_br u_t017_001/c0_w1_bl u_t017_001/c0_w1_br
+ u_t017_001/c0_r0_rbl u_t017_001/c0_r1_rbl u_t017_001/c1_w0_bl u_t017_001/c1_w0_br
+ u_t017_001/c1_w1_bl u_t017_001/c1_w1_br u_t017_001/c1_r0_rbl u_t017_001/c1_r1_rbl
+ u_t017_001/c2_w0_bl u_t017_001/c2_w0_br u_t017_001/c2_w1_bl u_t017_001/c2_w1_br
+ u_t017_001/c2_r0_rbl u_t017_001/c2_r1_rbl u_t017_001/c3_w0_bl u_t017_001/c3_w0_br
+ u_t017_001/c3_w1_bl u_t017_001/c3_w1_br u_t017_001/c3_r0_rbl u_t017_001/c3_r1_rbl
+ u_t017_001/r0_w0_wl u_t017_001/r0_w1_wl u_t017_001/r0_r0_rwl u_t017_001/r0_r1_rwl
+ u_t017_001/r1_w0_wl u_t017_001/r1_w1_wl u_t017_001/r1_r0_rwl u_t017_001/r1_r1_rwl
+ u_t017_001/r2_w0_wl u_t017_001/r2_w1_wl u_t017_001/r2_r0_rwl u_t017_001/r2_r1_rwl
+ u_t017_001/r3_w0_wl u_t017_001/r3_w1_wl u_t017_001/r3_r0_rwl u_t017_001/r3_r1_rwl
+ VSS VSS u_t017_001/m2_717_1265# u_t017_001/m2_603_2031# u_t017_001/m2_1290_336#
+ u_t017_001/m2_2000_2037# u_t017_001/m2_791_2909# u_t017_001/m2_7_2126# u_t017_001/m2_2154_2081#
+ u_t017_001/m2_1795_2037# u_t017_001/m2_871_303# u_t017_001/m2_431_438# u_t017_001/m2_1290_2898#
+ u_t017_001/m2_1714_1210# u_t017_001/m2_431_1982# u_t017_001/m2_512_1265# u_t017_001/m2_2573_2126#
+ u_t017_001/m2_603_1259# u_t017_001/m2_2074_2909# u_t017_001/m2_7_336# u_t017_001/m2_717_2037#
+ u_t017_001/m2_1886_2031# u_t017_001/m2_2573_336# u_t017_001/m2_7_2898# u_t017_001/m2_2000_1265#
+ u_t017_001/m2_512_2037# u_t017_001/m2_1795_1265# u_t017_001/m2_1714_1982# u_t017_001/m2_1886_1259#
+ u_t017_001/m2_1290_2126# u_t017_001/m2_1714_438# u_t017_001/m2_431_1210# u_t017_001/m2_2573_2898#
+ u_t017_001/m2_2154_303# u_t017_001/m2_871_2081# VSUBS detronyx_12t_2w2r_rc4_4x4_routed_5layer_direct
Xgf180mcu_as_sc_mcu7t3v3__inv_2_104 VSS VSS gf180mcu_as_sc_mcu7t3v3__inv_2_104/Y gf180mcu_as_sc_mcu7t3v3__nand4_2_0/Y
+ gf180mcu_as_sc_mcu7t3v3__inv_2_99/VNW VSUBS gf180mcu_as_sc_mcu7t3v3__inv_2
Xgf180mcu_as_sc_mcu7t3v3__inv_2_148 VSS VSS gf180mcu_as_sc_mcu7t3v3__inv_2_148/Y gf180mcu_as_sc_mcu7t3v3__inv_2_149/Y
+ gf180mcu_as_sc_mcu7t3v3__inv_2_149/VNW VSUBS gf180mcu_as_sc_mcu7t3v3__inv_2
Xgf180mcu_as_sc_mcu7t3v3__inv_2_137 VSS VSS gf180mcu_as_sc_mcu7t3v3__inv_2_137/Y gf180mcu_as_sc_mcu7t3v3__inv_2_137/A
+ gf180mcu_as_sc_mcu7t3v3__inv_2_137/VNW VSUBS gf180mcu_as_sc_mcu7t3v3__inv_2
Xgf180mcu_as_sc_mcu7t3v3__inv_2_126 VSS VSS VSS gf180mcu_as_sc_mcu7t3v3__inv_2_127/Y
+ gf180mcu_as_sc_mcu7t3v3__inv_2_128/VNW VSUBS gf180mcu_as_sc_mcu7t3v3__inv_2
Xgf180mcu_as_sc_mcu7t3v3__inv_2_115 VSS VSS gf180mcu_as_sc_mcu7t3v3__inv_2_115/Y gf180mcu_as_sc_mcu7t3v3__inv_2_116/Y
+ gf180mcu_as_sc_mcu7t3v3__inv_2_116/VNW VSUBS gf180mcu_as_sc_mcu7t3v3__inv_2
Xgf180mcu_as_sc_mcu7t3v3__inv_2_159 VSS VSS gf180mcu_as_sc_mcu7t3v3__inv_2_159/Y gf180mcu_as_sc_mcu7t3v3__inv_2_160/Y
+ gf180mcu_as_sc_mcu7t3v3__inv_2_160/VNW VSUBS gf180mcu_as_sc_mcu7t3v3__inv_2
Xu_t008_012 u_t008_012/c0_w0_bl u_t008_012/c0_w0_br u_t008_012/c0_w1_bl u_t008_012/c0_w1_br
+ u_t008_012/c0_r0_rbl u_t008_012/c0_r1_rbl u_t008_012/c1_w0_bl u_t008_012/c1_w0_br
+ u_t008_012/c1_w1_bl u_t008_012/c1_w1_br u_t008_012/c1_r0_rbl u_t008_012/c1_r1_rbl
+ u_t008_012/c2_w0_bl u_t008_012/c2_w0_br u_t008_012/c2_w1_bl u_t008_012/c2_w1_br
+ u_t008_012/c2_r0_rbl u_t008_012/c2_r1_rbl u_t008_012/c3_w0_bl u_t008_012/c3_w0_br
+ u_t008_012/c3_w1_bl u_t008_012/c3_w1_br u_t008_012/c3_r0_rbl u_t008_012/c3_r1_rbl
+ u_t008_012/r0_w0_wl u_t008_012/r0_w1_wl u_t008_012/r0_r0_rwl u_t008_012/r0_r1_rwl
+ u_t008_012/r1_w0_wl u_t008_012/r1_w1_wl u_t008_012/r1_r0_rwl u_t008_012/r1_r1_rwl
+ u_t008_012/r2_w0_wl u_t008_012/r2_w1_wl u_t008_012/r2_r0_rwl u_t008_012/r2_r1_rwl
+ u_t008_012/r3_w0_wl u_t008_012/r3_w1_wl u_t008_012/r3_r0_rwl u_t008_012/r3_r1_rwl
+ VSS VSS u_t008_012/m2_717_1265# u_t008_012/m2_603_2031# u_t008_012/m2_1290_336#
+ u_t008_012/m2_2000_2037# u_t008_012/m2_791_2909# u_t008_012/m2_7_2126# u_t008_012/m2_2154_2081#
+ u_t008_012/m2_1795_2037# u_t008_012/m2_871_303# u_t008_012/m2_431_438# u_t008_012/m2_1290_2898#
+ u_t008_012/m2_1714_1210# u_t008_012/m2_431_1982# u_t008_012/m2_512_1265# u_t008_012/m2_2573_2126#
+ u_t008_012/m2_603_1259# u_t008_012/m2_2074_2909# u_t008_012/m2_7_336# u_t008_012/m2_717_2037#
+ u_t008_012/m2_1886_2031# u_t008_012/m2_2573_336# u_t008_012/m2_7_2898# u_t008_012/m2_2000_1265#
+ u_t008_012/m2_512_2037# u_t008_012/m2_1795_1265# u_t008_012/m2_1714_1982# u_t008_012/m2_1886_1259#
+ u_t008_012/m2_1290_2126# u_t008_012/m2_1714_438# u_t008_012/m2_431_1210# u_t008_012/m2_2573_2898#
+ u_t008_012/m2_2154_303# u_t008_012/m2_871_2081# VSUBS detronyx_12t_2w2r_rc4_4x4_routed_5layer_direct
Xu_t023_004 u_t023_004/c0_w0_bl u_t023_004/c0_w0_br u_t023_004/c0_w1_bl u_t023_004/c0_w1_br
+ u_t023_004/c0_r0_rbl u_t023_004/c0_r1_rbl u_t023_004/c1_w0_bl u_t023_004/c1_w0_br
+ u_t023_004/c1_w1_bl u_t023_004/c1_w1_br u_t023_004/c1_r0_rbl u_t023_004/c1_r1_rbl
+ u_t023_004/c2_w0_bl u_t023_004/c2_w0_br u_t023_004/c2_w1_bl u_t023_004/c2_w1_br
+ u_t023_004/c2_r0_rbl u_t023_004/c2_r1_rbl u_t023_004/c3_w0_bl u_t023_004/c3_w0_br
+ u_t023_004/c3_w1_bl u_t023_004/c3_w1_br u_t023_004/c3_r0_rbl u_t023_004/c3_r1_rbl
+ u_t023_004/r0_w0_wl u_t023_004/r0_w1_wl u_t023_004/r0_r0_rwl u_t023_004/r0_r1_rwl
+ u_t023_004/r1_w0_wl u_t023_004/r1_w1_wl u_t023_004/r1_r0_rwl u_t023_004/r1_r1_rwl
+ u_t023_004/r2_w0_wl u_t023_004/r2_w1_wl u_t023_004/r2_r0_rwl u_t023_004/r2_r1_rwl
+ u_t023_004/r3_w0_wl u_t023_004/r3_w1_wl u_t023_004/r3_r0_rwl u_t023_004/r3_r1_rwl
+ VSS VSS u_t023_004/m2_717_1265# u_t023_004/m2_603_2031# u_t023_004/m2_1290_336#
+ u_t023_004/m2_2000_2037# u_t023_004/m2_791_2909# u_t023_004/m2_7_2126# u_t023_004/m2_2154_2081#
+ u_t023_004/m2_1795_2037# u_t023_004/m2_871_303# u_t023_004/m2_431_438# u_t023_004/m2_1290_2898#
+ u_t023_004/m2_1714_1210# u_t023_004/m2_431_1982# u_t023_004/m2_512_1265# u_t023_004/m2_2573_2126#
+ u_t023_004/m2_603_1259# u_t023_004/m2_2074_2909# u_t023_004/m2_7_336# u_t023_004/m2_717_2037#
+ u_t023_004/m2_1886_2031# u_t023_004/m2_2573_336# u_t023_004/m2_7_2898# u_t023_004/m2_2000_1265#
+ u_t023_004/m2_512_2037# u_t023_004/m2_1795_1265# u_t023_004/m2_1714_1982# u_t023_004/m2_1886_1259#
+ u_t023_004/m2_1290_2126# u_t023_004/m2_1714_438# u_t023_004/m2_431_1210# u_t023_004/m2_2573_2898#
+ u_t023_004/m2_2154_303# u_t023_004/m2_871_2081# VSUBS detronyx_12t_2w2r_rc4_4x4_routed_5layer_direct
Xu_t008_001 u_t008_001/c0_w0_bl u_t008_001/c0_w0_br u_t008_001/c0_w1_bl u_t008_001/c0_w1_br
+ u_t008_001/c0_r0_rbl u_t008_001/c0_r1_rbl u_t008_001/c1_w0_bl u_t008_001/c1_w0_br
+ u_t008_001/c1_w1_bl u_t008_001/c1_w1_br u_t008_001/c1_r0_rbl u_t008_001/c1_r1_rbl
+ u_t008_001/c2_w0_bl u_t008_001/c2_w0_br u_t008_001/c2_w1_bl u_t008_001/c2_w1_br
+ u_t008_001/c2_r0_rbl u_t008_001/c2_r1_rbl u_t008_001/c3_w0_bl u_t008_001/c3_w0_br
+ u_t008_001/c3_w1_bl u_t008_001/c3_w1_br u_t008_001/c3_r0_rbl u_t008_001/c3_r1_rbl
+ u_t008_001/r0_w0_wl u_t008_001/r0_w1_wl u_t008_001/r0_r0_rwl u_t008_001/r0_r1_rwl
+ u_t008_001/r1_w0_wl u_t008_001/r1_w1_wl u_t008_001/r1_r0_rwl u_t008_001/r1_r1_rwl
+ u_t008_001/r2_w0_wl u_t008_001/r2_w1_wl u_t008_001/r2_r0_rwl u_t008_001/r2_r1_rwl
+ u_t008_001/r3_w0_wl u_t008_001/r3_w1_wl u_t008_001/r3_r0_rwl u_t008_001/r3_r1_rwl
+ VSS VSS u_t008_001/m2_717_1265# u_t008_001/m2_603_2031# u_t008_001/m2_1290_336#
+ u_t008_001/m2_2000_2037# u_t008_001/m2_791_2909# u_t008_001/m2_7_2126# u_t008_001/m2_2154_2081#
+ u_t008_001/m2_1795_2037# u_t008_001/m2_871_303# u_t008_001/m2_431_438# u_t008_001/m2_1290_2898#
+ u_t008_001/m2_1714_1210# u_t008_001/m2_431_1982# u_t008_001/m2_512_1265# u_t008_001/m2_2573_2126#
+ u_t008_001/m2_603_1259# u_t008_001/m2_2074_2909# u_t008_001/m2_7_336# u_t008_001/m2_717_2037#
+ u_t008_001/m2_1886_2031# u_t008_001/m2_2573_336# u_t008_001/m2_7_2898# u_t008_001/m2_2000_1265#
+ u_t008_001/m2_512_2037# u_t008_001/m2_1795_1265# u_t008_001/m2_1714_1982# u_t008_001/m2_1886_1259#
+ u_t008_001/m2_1290_2126# u_t008_001/m2_1714_438# u_t008_001/m2_431_1210# u_t008_001/m2_2573_2898#
+ u_t008_001/m2_2154_303# u_t008_001/m2_871_2081# VSUBS detronyx_12t_2w2r_rc4_4x4_routed_5layer_direct
Xu_t023_015 u_t023_015/c0_w0_bl u_t023_015/c0_w0_br u_t023_015/c0_w1_bl u_t023_015/c0_w1_br
+ u_t023_015/c0_r0_rbl u_t023_015/c0_r1_rbl u_t023_015/c1_w0_bl u_t023_015/c1_w0_br
+ u_t023_015/c1_w1_bl u_t023_015/c1_w1_br u_t023_015/c1_r0_rbl u_t023_015/c1_r1_rbl
+ u_t023_015/c2_w0_bl u_t023_015/c2_w0_br u_t023_015/c2_w1_bl u_t023_015/c2_w1_br
+ u_t023_015/c2_r0_rbl u_t023_015/c2_r1_rbl u_t023_015/c3_w0_bl u_t023_015/c3_w0_br
+ u_t023_015/c3_w1_bl u_t023_015/c3_w1_br u_t023_015/c3_r0_rbl u_t023_015/c3_r1_rbl
+ u_t023_015/r0_w0_wl u_t023_015/r0_w1_wl u_t023_015/r0_r0_rwl u_t023_015/r0_r1_rwl
+ u_t023_015/r1_w0_wl u_t023_015/r1_w1_wl u_t023_015/r1_r0_rwl u_t023_015/r1_r1_rwl
+ u_t023_015/r2_w0_wl u_t023_015/r2_w1_wl u_t023_015/r2_r0_rwl u_t023_015/r2_r1_rwl
+ u_t023_015/r3_w0_wl u_t023_015/r3_w1_wl u_t023_015/r3_r0_rwl u_t023_015/r3_r1_rwl
+ VSS VSS u_t023_015/m2_717_1265# u_t023_015/m2_603_2031# u_t023_015/m2_1290_336#
+ u_t023_015/m2_2000_2037# u_t023_015/m2_791_2909# u_t023_015/m2_7_2126# u_t023_015/m2_2154_2081#
+ u_t023_015/m2_1795_2037# u_t023_015/m2_871_303# u_t023_015/m2_431_438# u_t023_015/m2_1290_2898#
+ u_t023_015/m2_1714_1210# u_t023_015/m2_431_1982# u_t023_015/m2_512_1265# u_t023_015/m2_2573_2126#
+ u_t023_015/m2_603_1259# u_t023_015/m2_2074_2909# u_t023_015/m2_7_336# u_t023_015/m2_717_2037#
+ u_t023_015/m2_1886_2031# u_t023_015/m2_2573_336# u_t023_015/m2_7_2898# u_t023_015/m2_2000_1265#
+ u_t023_015/m2_512_2037# u_t023_015/m2_1795_1265# u_t023_015/m2_1714_1982# u_t023_015/m2_1886_1259#
+ u_t023_015/m2_1290_2126# u_t023_015/m2_1714_438# u_t023_015/m2_431_1210# u_t023_015/m2_2573_2898#
+ u_t023_015/m2_2154_303# u_t023_015/m2_871_2081# VSUBS detronyx_12t_2w2r_rc4_4x4_routed_5layer_direct
Xgf180mcu_as_sc_mcu7t3v3__inv_2_682 VSS VSS VSS gf180mcu_as_sc_mcu7t3v3__inv_2_683/Y
+ gf180mcu_as_sc_mcu7t3v3__inv_2_684/VNW VSUBS gf180mcu_as_sc_mcu7t3v3__inv_2
Xgf180mcu_as_sc_mcu7t3v3__inv_2_660 VSS VSS gf180mcu_as_sc_mcu7t3v3__inv_2_660/Y gf180mcu_as_sc_mcu7t3v3__inv_2_660/A
+ gf180mcu_as_sc_mcu7t3v3__inv_2_660/VNW VSUBS gf180mcu_as_sc_mcu7t3v3__inv_2
Xgf180mcu_as_sc_mcu7t3v3__inv_2_671 VSS VSS VSS gf180mcu_as_sc_mcu7t3v3__inv_2_675/Y
+ gf180mcu_as_sc_mcu7t3v3__inv_2_679/VNW VSUBS gf180mcu_as_sc_mcu7t3v3__inv_2
Xgf180mcu_as_sc_mcu7t3v3__inv_2_693 VSS VSS gf180mcu_as_sc_mcu7t3v3__inv_2_743/A gf180mcu_as_sc_mcu7t3v3__inv_2_693/A
+ gf180mcu_as_sc_mcu7t3v3__inv_2_743/VNW VSUBS gf180mcu_as_sc_mcu7t3v3__inv_2
Xu_t014_015 u_t014_015/c0_w0_bl u_t014_015/c0_w0_br u_t014_015/c0_w1_bl u_t014_015/c0_w1_br
+ u_t014_015/c0_r0_rbl u_t014_015/c0_r1_rbl u_t014_015/c1_w0_bl u_t014_015/c1_w0_br
+ u_t014_015/c1_w1_bl u_t014_015/c1_w1_br u_t014_015/c1_r0_rbl u_t014_015/c1_r1_rbl
+ u_t014_015/c2_w0_bl u_t014_015/c2_w0_br u_t014_015/c2_w1_bl u_t014_015/c2_w1_br
+ u_t014_015/c2_r0_rbl u_t014_015/c2_r1_rbl u_t014_015/c3_w0_bl u_t014_015/c3_w0_br
+ u_t014_015/c3_w1_bl u_t014_015/c3_w1_br u_t014_015/c3_r0_rbl u_t014_015/c3_r1_rbl
+ u_t014_015/r0_w0_wl u_t014_015/r0_w1_wl u_t014_015/r0_r0_rwl u_t014_015/r0_r1_rwl
+ u_t014_015/r1_w0_wl u_t014_015/r1_w1_wl u_t014_015/r1_r0_rwl u_t014_015/r1_r1_rwl
+ u_t014_015/r2_w0_wl u_t014_015/r2_w1_wl u_t014_015/r2_r0_rwl u_t014_015/r2_r1_rwl
+ u_t014_015/r3_w0_wl u_t014_015/r3_w1_wl u_t014_015/r3_r0_rwl u_t014_015/r3_r1_rwl
+ VSS VSS u_t014_015/m2_717_1265# u_t014_015/m2_603_2031# u_t014_015/m2_1290_336#
+ u_t014_015/m2_2000_2037# u_t014_015/m2_791_2909# u_t014_015/m2_7_2126# u_t014_015/m2_2154_2081#
+ u_t014_015/m2_1795_2037# u_t014_015/m2_871_303# u_t014_015/m2_431_438# u_t014_015/m2_1290_2898#
+ u_t014_015/m2_1714_1210# u_t014_015/m2_431_1982# u_t014_015/m2_512_1265# u_t014_015/m2_2573_2126#
+ u_t014_015/m2_603_1259# u_t014_015/m2_2074_2909# u_t014_015/m2_7_336# u_t014_015/m2_717_2037#
+ u_t014_015/m2_1886_2031# u_t014_015/m2_2573_336# u_t014_015/m2_7_2898# u_t014_015/m2_2000_1265#
+ u_t014_015/m2_512_2037# u_t014_015/m2_1795_1265# u_t014_015/m2_1714_1982# u_t014_015/m2_1886_1259#
+ u_t014_015/m2_1290_2126# u_t014_015/m2_1714_438# u_t014_015/m2_431_1210# u_t014_015/m2_2573_2898#
+ u_t014_015/m2_2154_303# u_t014_015/m2_871_2081# VSUBS detronyx_12t_2w2r_rc4_4x4_routed_5layer_direct
Xu_t014_004 u_t014_004/c0_w0_bl u_t014_004/c0_w0_br u_t014_004/c0_w1_bl u_t014_004/c0_w1_br
+ u_t014_004/c0_r0_rbl u_t014_004/c0_r1_rbl u_t014_004/c1_w0_bl u_t014_004/c1_w0_br
+ u_t014_004/c1_w1_bl u_t014_004/c1_w1_br u_t014_004/c1_r0_rbl u_t014_004/c1_r1_rbl
+ u_t014_004/c2_w0_bl u_t014_004/c2_w0_br u_t014_004/c2_w1_bl u_t014_004/c2_w1_br
+ u_t014_004/c2_r0_rbl u_t014_004/c2_r1_rbl u_t014_004/c3_w0_bl u_t014_004/c3_w0_br
+ u_t014_004/c3_w1_bl u_t014_004/c3_w1_br u_t014_004/c3_r0_rbl u_t014_004/c3_r1_rbl
+ u_t014_004/r0_w0_wl u_t014_004/r0_w1_wl u_t014_004/r0_r0_rwl u_t014_004/r0_r1_rwl
+ u_t014_004/r1_w0_wl u_t014_004/r1_w1_wl u_t014_004/r1_r0_rwl u_t014_004/r1_r1_rwl
+ u_t014_004/r2_w0_wl u_t014_004/r2_w1_wl u_t014_004/r2_r0_rwl u_t014_004/r2_r1_rwl
+ u_t014_004/r3_w0_wl u_t014_004/r3_w1_wl u_t014_004/r3_r0_rwl u_t014_004/r3_r1_rwl
+ VSS VSS u_t014_004/m2_717_1265# u_t014_004/m2_603_2031# u_t014_004/m2_1290_336#
+ u_t014_004/m2_2000_2037# u_t014_004/m2_791_2909# u_t014_004/m2_7_2126# u_t014_004/m2_2154_2081#
+ u_t014_004/m2_1795_2037# u_t014_004/m2_871_303# u_t014_004/m2_431_438# u_t014_004/m2_1290_2898#
+ u_t014_004/m2_1714_1210# u_t014_004/m2_431_1982# u_t014_004/m2_512_1265# u_t014_004/m2_2573_2126#
+ u_t014_004/m2_603_1259# u_t014_004/m2_2074_2909# u_t014_004/m2_7_336# u_t014_004/m2_717_2037#
+ u_t014_004/m2_1886_2031# u_t014_004/m2_2573_336# u_t014_004/m2_7_2898# u_t014_004/m2_2000_1265#
+ u_t014_004/m2_512_2037# u_t014_004/m2_1795_1265# u_t014_004/m2_1714_1982# u_t014_004/m2_1886_1259#
+ u_t014_004/m2_1290_2126# u_t014_004/m2_1714_438# u_t014_004/m2_431_1210# u_t014_004/m2_2573_2898#
+ u_t014_004/m2_2154_303# u_t014_004/m2_871_2081# VSUBS detronyx_12t_2w2r_rc4_4x4_routed_5layer_direct
Xgf180mcu_as_sc_mcu7t3v3__nand2_2_49 gf180mcu_as_sc_mcu7t3v3__nor2_2_9/VDD gf180mcu_as_sc_mcu7t3v3__nand3_2_63/VSS
+ VSS VSS VSS gf180mcu_as_sc_mcu7t3v3__nor2_2_9/VNW VSUBS gf180mcu_as_sc_mcu7t3v3__nand2_2
Xgf180mcu_as_sc_mcu7t3v3__nand2_2_38 gf180mcu_as_sc_mcu7t3v3__nor2_2_9/VDD gf180mcu_as_sc_mcu7t3v3__nand3_2_63/VSS
+ VSS VSS VSS gf180mcu_as_sc_mcu7t3v3__nor2_2_9/VNW VSUBS gf180mcu_as_sc_mcu7t3v3__nand2_2
Xgf180mcu_as_sc_mcu7t3v3__nand2_2_27 gf180mcu_as_sc_mcu7t3v3__nor2_2_7/VDD gf180mcu_as_sc_mcu7t3v3__nand3_2_4/VSS
+ VSS VSS VSS gf180mcu_as_sc_mcu7t3v3__nor2_2_7/VNW VSUBS gf180mcu_as_sc_mcu7t3v3__nand2_2
Xgf180mcu_as_sc_mcu7t3v3__nand2_2_16 gf180mcu_as_sc_mcu7t3v3__nor2_2_7/VDD gf180mcu_as_sc_mcu7t3v3__nand3_2_4/VSS
+ VSS VSS VSS gf180mcu_as_sc_mcu7t3v3__nor2_2_7/VNW VSUBS gf180mcu_as_sc_mcu7t3v3__nand2_2
Xu_t005_004 u_t005_004/c0_w0_bl u_t005_004/c0_w0_br u_t005_004/c0_w1_bl u_t005_004/c0_w1_br
+ u_t005_004/c0_r0_rbl u_t005_004/c0_r1_rbl u_t005_004/c1_w0_bl u_t005_004/c1_w0_br
+ u_t005_004/c1_w1_bl u_t005_004/c1_w1_br u_t005_004/c1_r0_rbl u_t005_004/c1_r1_rbl
+ u_t005_004/c2_w0_bl u_t005_004/c2_w0_br u_t005_004/c2_w1_bl u_t005_004/c2_w1_br
+ u_t005_004/c2_r0_rbl u_t005_004/c2_r1_rbl u_t005_004/c3_w0_bl u_t005_004/c3_w0_br
+ u_t005_004/c3_w1_bl u_t005_004/c3_w1_br u_t005_004/c3_r0_rbl u_t005_004/c3_r1_rbl
+ u_t005_004/r0_w0_wl u_t005_004/r0_w1_wl u_t005_004/r0_r0_rwl u_t005_004/r0_r1_rwl
+ u_t005_004/r1_w0_wl u_t005_004/r1_w1_wl u_t005_004/r1_r0_rwl u_t005_004/r1_r1_rwl
+ u_t005_004/r2_w0_wl u_t005_004/r2_w1_wl u_t005_004/r2_r0_rwl u_t005_004/r2_r1_rwl
+ u_t005_004/r3_w0_wl u_t005_004/r3_w1_wl u_t005_004/r3_r0_rwl u_t005_004/r3_r1_rwl
+ VSS VSS u_t005_004/m2_717_1265# u_t005_004/m2_603_2031# u_t005_004/m2_1290_336#
+ u_t005_004/m2_2000_2037# u_t005_004/m2_791_2909# u_t005_004/m2_7_2126# u_t005_004/m2_2154_2081#
+ u_t005_004/m2_1795_2037# u_t005_004/m2_871_303# u_t005_004/m2_431_438# u_t005_004/m2_1290_2898#
+ u_t005_004/m2_1714_1210# u_t005_004/m2_431_1982# u_t005_004/m2_512_1265# u_t005_004/m2_2573_2126#
+ u_t005_004/m2_603_1259# u_t005_004/m2_2074_2909# u_t005_004/m2_7_336# u_t005_004/m2_717_2037#
+ u_t005_004/m2_1886_2031# u_t005_004/m2_2573_336# u_t005_004/m2_7_2898# u_t005_004/m2_2000_1265#
+ u_t005_004/m2_512_2037# u_t005_004/m2_1795_1265# u_t005_004/m2_1714_1982# u_t005_004/m2_1886_1259#
+ u_t005_004/m2_1290_2126# u_t005_004/m2_1714_438# u_t005_004/m2_431_1210# u_t005_004/m2_2573_2898#
+ u_t005_004/m2_2154_303# u_t005_004/m2_871_2081# VSUBS detronyx_12t_2w2r_rc4_4x4_routed_5layer_direct
Xu_t005_015 u_t005_015/c0_w0_bl u_t005_015/c0_w0_br u_t005_015/c0_w1_bl u_t005_015/c0_w1_br
+ u_t005_015/c0_r0_rbl u_t005_015/c0_r1_rbl u_t005_015/c1_w0_bl u_t005_015/c1_w0_br
+ u_t005_015/c1_w1_bl u_t005_015/c1_w1_br u_t005_015/c1_r0_rbl u_t005_015/c1_r1_rbl
+ u_t005_015/c2_w0_bl u_t005_015/c2_w0_br u_t005_015/c2_w1_bl u_t005_015/c2_w1_br
+ u_t005_015/c2_r0_rbl u_t005_015/c2_r1_rbl u_t005_015/c3_w0_bl u_t005_015/c3_w0_br
+ u_t005_015/c3_w1_bl u_t005_015/c3_w1_br u_t005_015/c3_r0_rbl u_t005_015/c3_r1_rbl
+ u_t005_015/r0_w0_wl u_t005_015/r0_w1_wl u_t005_015/r0_r0_rwl u_t005_015/r0_r1_rwl
+ u_t005_015/r1_w0_wl u_t005_015/r1_w1_wl u_t005_015/r1_r0_rwl u_t005_015/r1_r1_rwl
+ u_t005_015/r2_w0_wl u_t005_015/r2_w1_wl u_t005_015/r2_r0_rwl u_t005_015/r2_r1_rwl
+ u_t005_015/r3_w0_wl u_t005_015/r3_w1_wl u_t005_015/r3_r0_rwl u_t005_015/r3_r1_rwl
+ VSS VSS u_t005_015/m2_717_1265# u_t005_015/m2_603_2031# u_t005_015/m2_1290_336#
+ u_t005_015/m2_2000_2037# u_t005_015/m2_791_2909# u_t005_015/m2_7_2126# u_t005_015/m2_2154_2081#
+ u_t005_015/m2_1795_2037# u_t005_015/m2_871_303# u_t005_015/m2_431_438# u_t005_015/m2_1290_2898#
+ u_t005_015/m2_1714_1210# u_t005_015/m2_431_1982# u_t005_015/m2_512_1265# u_t005_015/m2_2573_2126#
+ u_t005_015/m2_603_1259# u_t005_015/m2_2074_2909# u_t005_015/m2_7_336# u_t005_015/m2_717_2037#
+ u_t005_015/m2_1886_2031# u_t005_015/m2_2573_336# u_t005_015/m2_7_2898# u_t005_015/m2_2000_1265#
+ u_t005_015/m2_512_2037# u_t005_015/m2_1795_1265# u_t005_015/m2_1714_1982# u_t005_015/m2_1886_1259#
+ u_t005_015/m2_1290_2126# u_t005_015/m2_1714_438# u_t005_015/m2_431_1210# u_t005_015/m2_2573_2898#
+ u_t005_015/m2_2154_303# u_t005_015/m2_871_2081# VSUBS detronyx_12t_2w2r_rc4_4x4_routed_5layer_direct
Xu_t020_007 u_t020_007/c0_w0_bl u_t020_007/c0_w0_br u_t020_007/c0_w1_bl u_t020_007/c0_w1_br
+ u_t020_007/c0_r0_rbl u_t020_007/c0_r1_rbl u_t020_007/c1_w0_bl u_t020_007/c1_w0_br
+ u_t020_007/c1_w1_bl u_t020_007/c1_w1_br u_t020_007/c1_r0_rbl u_t020_007/c1_r1_rbl
+ u_t020_007/c2_w0_bl u_t020_007/c2_w0_br u_t020_007/c2_w1_bl u_t020_007/c2_w1_br
+ u_t020_007/c2_r0_rbl u_t020_007/c2_r1_rbl u_t020_007/c3_w0_bl u_t020_007/c3_w0_br
+ u_t020_007/c3_w1_bl u_t020_007/c3_w1_br u_t020_007/c3_r0_rbl u_t020_007/c3_r1_rbl
+ u_t020_007/r0_w0_wl u_t020_007/r0_w1_wl u_t020_007/r0_r0_rwl u_t020_007/r0_r1_rwl
+ u_t020_007/r1_w0_wl u_t020_007/r1_w1_wl u_t020_007/r1_r0_rwl u_t020_007/r1_r1_rwl
+ u_t020_007/r2_w0_wl u_t020_007/r2_w1_wl u_t020_007/r2_r0_rwl u_t020_007/r2_r1_rwl
+ u_t020_007/r3_w0_wl u_t020_007/r3_w1_wl u_t020_007/r3_r0_rwl u_t020_007/r3_r1_rwl
+ VSS VSS u_t020_007/m2_717_1265# u_t020_007/m2_603_2031# u_t020_007/m2_1290_336#
+ u_t020_007/m2_2000_2037# u_t020_007/m2_791_2909# u_t020_007/m2_7_2126# u_t020_007/m2_2154_2081#
+ u_t020_007/m2_1795_2037# u_t020_007/m2_871_303# u_t020_007/m2_431_438# u_t020_007/m2_1290_2898#
+ u_t020_007/m2_1714_1210# u_t020_007/m2_431_1982# u_t020_007/m2_512_1265# u_t020_007/m2_2573_2126#
+ u_t020_007/m2_603_1259# u_t020_007/m2_2074_2909# u_t020_007/m2_7_336# u_t020_007/m2_717_2037#
+ u_t020_007/m2_1886_2031# u_t020_007/m2_2573_336# u_t020_007/m2_7_2898# u_t020_007/m2_2000_1265#
+ u_t020_007/m2_512_2037# u_t020_007/m2_1795_1265# u_t020_007/m2_1714_1982# u_t020_007/m2_1886_1259#
+ u_t020_007/m2_1290_2126# u_t020_007/m2_1714_438# u_t020_007/m2_431_1210# u_t020_007/m2_2573_2898#
+ u_t020_007/m2_2154_303# u_t020_007/m2_871_2081# VSUBS detronyx_12t_2w2r_rc4_4x4_routed_5layer_direct
Xgf180mcu_as_sc_mcu7t3v3__inv_2_490 VSS VSS gf180mcu_as_sc_mcu7t3v3__inv_2_519/A gf180mcu_as_sc_mcu7t3v3__inv_2_490/A
+ gf180mcu_as_sc_mcu7t3v3__inv_2_560/VNW VSUBS gf180mcu_as_sc_mcu7t3v3__inv_2
Xu_t011_007 u_t011_007/c0_w0_bl u_t011_007/c0_w0_br u_t011_007/c0_w1_bl u_t011_007/c0_w1_br
+ u_t011_007/c0_r0_rbl u_t011_007/c0_r1_rbl u_t011_007/c1_w0_bl u_t011_007/c1_w0_br
+ u_t011_007/c1_w1_bl u_t011_007/c1_w1_br u_t011_007/c1_r0_rbl u_t011_007/c1_r1_rbl
+ u_t011_007/c2_w0_bl u_t011_007/c2_w0_br u_t011_007/c2_w1_bl u_t011_007/c2_w1_br
+ u_t011_007/c2_r0_rbl u_t011_007/c2_r1_rbl u_t011_007/c3_w0_bl u_t011_007/c3_w0_br
+ u_t011_007/c3_w1_bl u_t011_007/c3_w1_br u_t011_007/c3_r0_rbl u_t011_007/c3_r1_rbl
+ u_t011_007/r0_w0_wl u_t011_007/r0_w1_wl u_t011_007/r0_r0_rwl u_t011_007/r0_r1_rwl
+ u_t011_007/r1_w0_wl u_t011_007/r1_w1_wl u_t011_007/r1_r0_rwl u_t011_007/r1_r1_rwl
+ u_t011_007/r2_w0_wl u_t011_007/r2_w1_wl u_t011_007/r2_r0_rwl u_t011_007/r2_r1_rwl
+ u_t011_007/r3_w0_wl u_t011_007/r3_w1_wl u_t011_007/r3_r0_rwl u_t011_007/r3_r1_rwl
+ VSS VSS u_t011_007/m2_717_1265# u_t011_007/m2_603_2031# u_t011_007/m2_1290_336#
+ u_t011_007/m2_2000_2037# u_t011_007/m2_791_2909# u_t011_007/m2_7_2126# u_t011_007/m2_2154_2081#
+ u_t011_007/m2_1795_2037# u_t011_007/m2_871_303# u_t011_007/m2_431_438# u_t011_007/m2_1290_2898#
+ u_t011_007/m2_1714_1210# u_t011_007/m2_431_1982# u_t011_007/m2_512_1265# u_t011_007/m2_2573_2126#
+ u_t011_007/m2_603_1259# u_t011_007/m2_2074_2909# u_t011_007/m2_7_336# u_t011_007/m2_717_2037#
+ u_t011_007/m2_1886_2031# u_t011_007/m2_2573_336# u_t011_007/m2_7_2898# u_t011_007/m2_2000_1265#
+ u_t011_007/m2_512_2037# u_t011_007/m2_1795_1265# u_t011_007/m2_1714_1982# u_t011_007/m2_1886_1259#
+ u_t011_007/m2_1290_2126# u_t011_007/m2_1714_438# u_t011_007/m2_431_1210# u_t011_007/m2_2573_2898#
+ u_t011_007/m2_2154_303# u_t011_007/m2_871_2081# VSUBS detronyx_12t_2w2r_rc4_4x4_routed_5layer_direct
Xu_t002_007 u_t002_007/c0_w0_bl u_t002_007/c0_w0_br u_t002_007/c0_w1_bl u_t002_007/c0_w1_br
+ u_t002_007/c0_r0_rbl u_t002_007/c0_r1_rbl u_t002_007/c1_w0_bl u_t002_007/c1_w0_br
+ u_t002_007/c1_w1_bl u_t002_007/c1_w1_br u_t002_007/c1_r0_rbl u_t002_007/c1_r1_rbl
+ u_t002_007/c2_w0_bl u_t002_007/c2_w0_br u_t002_007/c2_w1_bl u_t002_007/c2_w1_br
+ u_t002_007/c2_r0_rbl u_t002_007/c2_r1_rbl u_t002_007/c3_w0_bl u_t002_007/c3_w0_br
+ u_t002_007/c3_w1_bl u_t002_007/c3_w1_br u_t002_007/c3_r0_rbl u_t002_007/c3_r1_rbl
+ u_t002_007/r0_w0_wl u_t002_007/r0_w1_wl u_t002_007/r0_r0_rwl u_t002_007/r0_r1_rwl
+ u_t002_007/r1_w0_wl u_t002_007/r1_w1_wl u_t002_007/r1_r0_rwl u_t002_007/r1_r1_rwl
+ u_t002_007/r2_w0_wl u_t002_007/r2_w1_wl u_t002_007/r2_r0_rwl u_t002_007/r2_r1_rwl
+ u_t002_007/r3_w0_wl u_t002_007/r3_w1_wl u_t002_007/r3_r0_rwl u_t002_007/r3_r1_rwl
+ VSS VSS u_t002_007/m2_717_1265# u_t002_007/m2_603_2031# u_t002_007/m2_1290_336#
+ u_t002_007/m2_2000_2037# u_t002_007/m2_791_2909# u_t002_007/m2_7_2126# u_t002_007/m2_2154_2081#
+ u_t002_007/m2_1795_2037# u_t002_007/m2_871_303# u_t002_007/m2_431_438# u_t002_007/m2_1290_2898#
+ u_t002_007/m2_1714_1210# u_t002_007/m2_431_1982# u_t002_007/m2_512_1265# u_t002_007/m2_2573_2126#
+ u_t002_007/m2_603_1259# u_t002_007/m2_2074_2909# u_t002_007/m2_7_336# u_t002_007/m2_717_2037#
+ u_t002_007/m2_1886_2031# u_t002_007/m2_2573_336# u_t002_007/m2_7_2898# u_t002_007/m2_2000_1265#
+ u_t002_007/m2_512_2037# u_t002_007/m2_1795_1265# u_t002_007/m2_1714_1982# u_t002_007/m2_1886_1259#
+ u_t002_007/m2_1290_2126# u_t002_007/m2_1714_438# u_t002_007/m2_431_1210# u_t002_007/m2_2573_2898#
+ u_t002_007/m2_2154_303# u_t002_007/m2_871_2081# VSUBS detronyx_12t_2w2r_rc4_4x4_routed_5layer_direct
Xgf180mcu_as_sc_mcu7t3v3__inv_2_1208 gf180mcu_as_sc_mcu7t3v3__nor2_2_9/VDD gf180mcu_as_sc_mcu7t3v3__nand3_2_63/VSS
+ VSS VSS gf180mcu_as_sc_mcu7t3v3__nor2_2_9/VNW VSUBS gf180mcu_as_sc_mcu7t3v3__inv_2
Xgf180mcu_as_sc_mcu7t3v3__inv_2_1219 VSS VSS gf180mcu_as_sc_mcu7t3v3__inv_2_1219/Y
+ gf180mcu_as_sc_mcu7t3v3__inv_2_1219/A gf180mcu_as_sc_mcu7t3v3__inv_2_1274/VNW VSUBS
+ gf180mcu_as_sc_mcu7t3v3__inv_2
Xgf180mcu_as_sc_mcu7t3v3__inv_2_1720 VSS VSS gf180mcu_as_sc_mcu7t3v3__inv_2_1720/Y
+ gf180mcu_as_sc_mcu7t3v3__inv_2_1720/A gf180mcu_as_sc_mcu7t3v3__inv_2_1720/VNW VSUBS
+ gf180mcu_as_sc_mcu7t3v3__inv_2
Xgf180mcu_as_sc_mcu7t3v3__nand4_2_503 VSS VSS VSS VSS VSS VSS gf180mcu_as_sc_mcu7t3v3__inv_2_1665/A
+ gf180mcu_as_sc_mcu7t3v3__inv_2_1665/VNW VSUBS gf180mcu_as_sc_mcu7t3v3__nand4_2
Xgf180mcu_as_sc_mcu7t3v3__inv_2_35 VSS VSS gf180mcu_as_sc_mcu7t3v3__inv_2_35/Y gf180mcu_as_sc_mcu7t3v3__inv_2_36/Y
+ gf180mcu_as_sc_mcu7t3v3__inv_2_36/VNW VSUBS gf180mcu_as_sc_mcu7t3v3__inv_2
Xgf180mcu_as_sc_mcu7t3v3__inv_2_24 VSS VSS gf180mcu_as_sc_mcu7t3v3__inv_2_24/Y gf180mcu_as_sc_mcu7t3v3__inv_2_24/A
+ gf180mcu_as_sc_mcu7t3v3__inv_2_24/VNW VSUBS gf180mcu_as_sc_mcu7t3v3__inv_2
Xgf180mcu_as_sc_mcu7t3v3__inv_2_13 VSS VSS VSS gf180mcu_as_sc_mcu7t3v3__inv_2_50/Y
+ gf180mcu_as_sc_mcu7t3v3__inv_2_66/VNW VSUBS gf180mcu_as_sc_mcu7t3v3__inv_2
Xgf180mcu_as_sc_mcu7t3v3__inv_2_46 VSS VSS gf180mcu_as_sc_mcu7t3v3__inv_2_46/Y gf180mcu_as_sc_mcu7t3v3__inv_2_46/A
+ gf180mcu_as_sc_mcu7t3v3__inv_2_46/VNW VSUBS gf180mcu_as_sc_mcu7t3v3__inv_2
Xgf180mcu_as_sc_mcu7t3v3__inv_2_68 VSS VSS gf180mcu_as_sc_mcu7t3v3__inv_2_68/Y gf180mcu_as_sc_mcu7t3v3__inv_2_69/Y
+ gf180mcu_as_sc_mcu7t3v3__inv_2_69/VNW VSUBS gf180mcu_as_sc_mcu7t3v3__inv_2
Xgf180mcu_as_sc_mcu7t3v3__inv_2_57 VSS VSS gf180mcu_as_sc_mcu7t3v3__inv_2_57/Y gf180mcu_as_sc_mcu7t3v3__inv_2_57/A
+ gf180mcu_as_sc_mcu7t3v3__inv_2_57/VNW VSUBS gf180mcu_as_sc_mcu7t3v3__inv_2
Xgf180mcu_as_sc_mcu7t3v3__inv_2_1027 VSS VSS gf180mcu_as_sc_mcu7t3v3__inv_2_1027/Y
+ gf180mcu_as_sc_mcu7t3v3__inv_2_1028/Y gf180mcu_as_sc_mcu7t3v3__inv_2_1028/VNW VSUBS
+ gf180mcu_as_sc_mcu7t3v3__inv_2
Xgf180mcu_as_sc_mcu7t3v3__inv_2_1016 VSS VSS gf180mcu_as_sc_mcu7t3v3__inv_2_1016/Y
+ gf180mcu_as_sc_mcu7t3v3__inv_2_1016/A gf180mcu_as_sc_mcu7t3v3__inv_2_1016/VNW VSUBS
+ gf180mcu_as_sc_mcu7t3v3__inv_2
Xgf180mcu_as_sc_mcu7t3v3__inv_2_1049 VSS VSS gf180mcu_as_sc_mcu7t3v3__inv_2_1049/Y
+ gf180mcu_as_sc_mcu7t3v3__inv_2_1049/A gf180mcu_as_sc_mcu7t3v3__inv_2_1049/VNW VSUBS
+ gf180mcu_as_sc_mcu7t3v3__inv_2
Xgf180mcu_as_sc_mcu7t3v3__inv_2_1038 VSS VSS VSS gf180mcu_as_sc_mcu7t3v3__inv_2_1039/Y
+ gf180mcu_as_sc_mcu7t3v3__inv_2_1040/VNW VSUBS gf180mcu_as_sc_mcu7t3v3__inv_2
Xgf180mcu_as_sc_mcu7t3v3__inv_2_79 VSS VSS VSS gf180mcu_as_sc_mcu7t3v3__inv_2_80/Y
+ gf180mcu_as_sc_mcu7t3v3__inv_2_81/VNW VSUBS gf180mcu_as_sc_mcu7t3v3__inv_2
Xgf180mcu_as_sc_mcu7t3v3__inv_2_1005 VSS VSS gf180mcu_as_sc_mcu7t3v3__inv_2_989/A
+ gf180mcu_as_sc_mcu7t3v3__inv_2_973/Y gf180mcu_as_sc_mcu7t3v3__inv_2_989/VNW VSUBS
+ gf180mcu_as_sc_mcu7t3v3__inv_2
Xgf180mcu_as_sc_mcu7t3v3__inv_2_1594 VSS VSS gf180mcu_as_sc_mcu7t3v3__inv_2_1594/Y
+ gf180mcu_as_sc_mcu7t3v3__inv_2_1594/A gf180mcu_as_sc_mcu7t3v3__inv_2_1594/VNW VSUBS
+ gf180mcu_as_sc_mcu7t3v3__inv_2
Xgf180mcu_as_sc_mcu7t3v3__inv_2_1572 VSS VSS gf180mcu_as_sc_mcu7t3v3__inv_2_1572/Y
+ gf180mcu_as_sc_mcu7t3v3__inv_2_1573/Y gf180mcu_as_sc_mcu7t3v3__inv_2_1573/VNW VSUBS
+ gf180mcu_as_sc_mcu7t3v3__inv_2
Xgf180mcu_as_sc_mcu7t3v3__inv_2_1583 VSS VSS VSS gf180mcu_as_sc_mcu7t3v3__inv_2_1584/Y
+ gf180mcu_as_sc_mcu7t3v3__inv_2_1585/VNW VSUBS gf180mcu_as_sc_mcu7t3v3__inv_2
Xgf180mcu_as_sc_mcu7t3v3__inv_2_1550 VSS VSS gf180mcu_as_sc_mcu7t3v3__inv_2_1550/Y
+ gf180mcu_as_sc_mcu7t3v3__inv_2_1550/A gf180mcu_as_sc_mcu7t3v3__inv_2_1550/VNW VSUBS
+ gf180mcu_as_sc_mcu7t3v3__inv_2
Xgf180mcu_as_sc_mcu7t3v3__inv_2_1561 VSS VSS gf180mcu_as_sc_mcu7t3v3__inv_2_1561/Y
+ gf180mcu_as_sc_mcu7t3v3__inv_2_1562/Y gf180mcu_as_sc_mcu7t3v3__inv_2_1562/VNW VSUBS
+ gf180mcu_as_sc_mcu7t3v3__inv_2
Xgf180mcu_as_sc_mcu7t3v3__nand3_2_5 gf180mcu_as_sc_mcu7t3v3__nor2_2_7/VDD gf180mcu_as_sc_mcu7t3v3__nor2_2_7/VSS
+ VSS VSS VSS VSS gf180mcu_as_sc_mcu7t3v3__nor2_2_7/VNW VSUBS gf180mcu_as_sc_mcu7t3v3__nand3_2
Xgf180mcu_as_sc_mcu7t3v3__nand4_2_344 VSS VSS VSS VSS VSS VSS gf180mcu_as_sc_mcu7t3v3__inv_2_1121/A
+ gf180mcu_as_sc_mcu7t3v3__inv_2_1121/VNW VSUBS gf180mcu_as_sc_mcu7t3v3__nand4_2
Xgf180mcu_as_sc_mcu7t3v3__nand4_2_322 VSS VSS VSS VSS VSS VSS gf180mcu_as_sc_mcu7t3v3__inv_2_1083/A
+ gf180mcu_as_sc_mcu7t3v3__inv_2_1083/VNW VSUBS gf180mcu_as_sc_mcu7t3v3__nand4_2
Xgf180mcu_as_sc_mcu7t3v3__nand4_2_333 VSS VSS VSS VSS VSS VSS gf180mcu_as_sc_mcu7t3v3__inv_2_1112/A
+ gf180mcu_as_sc_mcu7t3v3__inv_2_1112/VNW VSUBS gf180mcu_as_sc_mcu7t3v3__nand4_2
Xgf180mcu_as_sc_mcu7t3v3__nand4_2_300 VSS VSS VSS VSS VSS VSS gf180mcu_as_sc_mcu7t3v3__inv_2_985/A
+ gf180mcu_as_sc_mcu7t3v3__inv_2_985/VNW VSUBS gf180mcu_as_sc_mcu7t3v3__nand4_2
Xgf180mcu_as_sc_mcu7t3v3__nand4_2_311 VSS VSS VSS VSS VSS VSS gf180mcu_as_sc_mcu7t3v3__inv_2_1024/A
+ gf180mcu_as_sc_mcu7t3v3__inv_2_1024/VNW VSUBS gf180mcu_as_sc_mcu7t3v3__nand4_2
Xgf180mcu_as_sc_mcu7t3v3__nand4_2_366 VSS VSS VSS VSS VSS VSS gf180mcu_as_sc_mcu7t3v3__inv_2_1228/A
+ gf180mcu_as_sc_mcu7t3v3__inv_2_1282/VNW VSUBS gf180mcu_as_sc_mcu7t3v3__nand4_2
Xgf180mcu_as_sc_mcu7t3v3__nand4_2_377 VSS VSS VSS VSS VSS VSS gf180mcu_as_sc_mcu7t3v3__inv_2_1286/A
+ gf180mcu_as_sc_mcu7t3v3__inv_2_1286/VNW VSUBS gf180mcu_as_sc_mcu7t3v3__nand4_2
Xgf180mcu_as_sc_mcu7t3v3__nand4_2_355 VSS VSS VSS VSS VSS VSS gf180mcu_as_sc_mcu7t3v3__inv_2_1168/A
+ gf180mcu_as_sc_mcu7t3v3__inv_2_1301/VNW VSUBS gf180mcu_as_sc_mcu7t3v3__nand4_2
Xgf180mcu_as_sc_mcu7t3v3__nand4_2_399 VSS VSS VSS VSS VSS VSS gf180mcu_as_sc_mcu7t3v3__inv_2_1467/A
+ gf180mcu_as_sc_mcu7t3v3__inv_2_1467/VNW VSUBS gf180mcu_as_sc_mcu7t3v3__nand4_2
Xgf180mcu_as_sc_mcu7t3v3__nand4_2_388 VSS VSS VSS VSS VSS VSS gf180mcu_as_sc_mcu7t3v3__inv_2_1434/A
+ gf180mcu_as_sc_mcu7t3v3__inv_2_1434/VNW VSUBS gf180mcu_as_sc_mcu7t3v3__nand4_2
Xu_t029_010 u_t029_010/c0_w0_bl u_t029_010/c0_w0_br u_t029_010/c0_w1_bl u_t029_010/c0_w1_br
+ u_t029_010/c0_r0_rbl u_t029_010/c0_r1_rbl u_t029_010/c1_w0_bl u_t029_010/c1_w0_br
+ u_t029_010/c1_w1_bl u_t029_010/c1_w1_br u_t029_010/c1_r0_rbl u_t029_010/c1_r1_rbl
+ u_t029_010/c2_w0_bl u_t029_010/c2_w0_br u_t029_010/c2_w1_bl u_t029_010/c2_w1_br
+ u_t029_010/c2_r0_rbl u_t029_010/c2_r1_rbl u_t029_010/c3_w0_bl u_t029_010/c3_w0_br
+ u_t029_010/c3_w1_bl u_t029_010/c3_w1_br u_t029_010/c3_r0_rbl u_t029_010/c3_r1_rbl
+ u_t029_010/r0_w0_wl u_t029_010/r0_w1_wl u_t029_010/r0_r0_rwl u_t029_010/r0_r1_rwl
+ u_t029_010/r1_w0_wl u_t029_010/r1_w1_wl u_t029_010/r1_r0_rwl u_t029_010/r1_r1_rwl
+ u_t029_010/r2_w0_wl u_t029_010/r2_w1_wl u_t029_010/r2_r0_rwl u_t029_010/r2_r1_rwl
+ u_t029_010/r3_w0_wl u_t029_010/r3_w1_wl u_t029_010/r3_r0_rwl u_t029_010/r3_r1_rwl
+ VSS VSS u_t029_010/m2_717_1265# u_t029_010/m2_603_2031# u_t029_010/m2_1290_336#
+ u_t029_010/m2_2000_2037# u_t029_010/m2_791_2909# u_t029_010/m2_7_2126# u_t029_010/m2_2154_2081#
+ u_t029_010/m2_1795_2037# u_t029_010/m2_871_303# u_t029_010/m2_431_438# u_t029_010/m2_1290_2898#
+ u_t029_010/m2_1714_1210# u_t029_010/m2_431_1982# u_t029_010/m2_512_1265# u_t029_010/m2_2573_2126#
+ u_t029_010/m2_603_1259# u_t029_010/m2_2074_2909# u_t029_010/m2_7_336# u_t029_010/m2_717_2037#
+ u_t029_010/m2_1886_2031# u_t029_010/m2_2573_336# u_t029_010/m2_7_2898# u_t029_010/m2_2000_1265#
+ u_t029_010/m2_512_2037# u_t029_010/m2_1795_1265# u_t029_010/m2_1714_1982# u_t029_010/m2_1886_1259#
+ u_t029_010/m2_1290_2126# u_t029_010/m2_1714_438# u_t029_010/m2_431_1210# u_t029_010/m2_2573_2898#
+ u_t029_010/m2_2154_303# u_t029_010/m2_871_2081# VSUBS detronyx_12t_2w2r_rc4_4x4_routed_5layer_direct
Xgf180mcu_as_sc_mcu7t3v3__inv_2_308 VSS VSS VSS gf180mcu_as_sc_mcu7t3v3__inv_2_308/A
+ gf180mcu_as_sc_mcu7t3v3__inv_2_308/VNW VSUBS gf180mcu_as_sc_mcu7t3v3__inv_2
Xgf180mcu_as_sc_mcu7t3v3__inv_2_319 VSS VSS gf180mcu_as_sc_mcu7t3v3__inv_2_319/Y gf180mcu_as_sc_mcu7t3v3__inv_2_320/Y
+ gf180mcu_as_sc_mcu7t3v3__inv_2_320/VNW VSUBS gf180mcu_as_sc_mcu7t3v3__inv_2
Xgf180mcu_as_sc_mcu7t3v3__inv_2_1380 VSS VSS VSS gf180mcu_as_sc_mcu7t3v3__inv_2_1381/Y
+ gf180mcu_as_sc_mcu7t3v3__inv_2_1382/VNW VSUBS gf180mcu_as_sc_mcu7t3v3__inv_2
Xgf180mcu_as_sc_mcu7t3v3__inv_2_1391 VSS VSS gf180mcu_as_sc_mcu7t3v3__inv_2_1391/Y
+ gf180mcu_as_sc_mcu7t3v3__inv_2_1391/A gf180mcu_as_sc_mcu7t3v3__inv_2_1391/VNW VSUBS
+ gf180mcu_as_sc_mcu7t3v3__inv_2
Xgf180mcu_as_sc_mcu7t3v3__inv_2_820 VSS VSS VSS gf180mcu_as_sc_mcu7t3v3__inv_2_820/A
+ gf180mcu_as_sc_mcu7t3v3__inv_2_820/VNW VSUBS gf180mcu_as_sc_mcu7t3v3__inv_2
Xgf180mcu_as_sc_mcu7t3v3__inv_2_897 VSS VSS gf180mcu_as_sc_mcu7t3v3__inv_2_950/A gf180mcu_as_sc_mcu7t3v3__inv_2_900/Y
+ gf180mcu_as_sc_mcu7t3v3__inv_2_950/VNW VSUBS gf180mcu_as_sc_mcu7t3v3__inv_2
Xgf180mcu_as_sc_mcu7t3v3__inv_2_853 VSS VSS gf180mcu_as_sc_mcu7t3v3__inv_2_853/Y gf180mcu_as_sc_mcu7t3v3__inv_2_854/Y
+ gf180mcu_as_sc_mcu7t3v3__inv_2_854/VNW VSUBS gf180mcu_as_sc_mcu7t3v3__inv_2
Xgf180mcu_as_sc_mcu7t3v3__inv_2_831 VSS VSS VSS gf180mcu_as_sc_mcu7t3v3__inv_2_831/A
+ gf180mcu_as_sc_mcu7t3v3__inv_2_831/VNW VSUBS gf180mcu_as_sc_mcu7t3v3__inv_2
Xgf180mcu_as_sc_mcu7t3v3__inv_2_842 VSS VSS VSS gf180mcu_as_sc_mcu7t3v3__inv_2_842/A
+ gf180mcu_as_sc_mcu7t3v3__inv_2_842/VNW VSUBS gf180mcu_as_sc_mcu7t3v3__inv_2
Xgf180mcu_as_sc_mcu7t3v3__inv_2_864 VSS VSS gf180mcu_as_sc_mcu7t3v3__inv_2_864/Y gf180mcu_as_sc_mcu7t3v3__inv_2_864/A
+ gf180mcu_as_sc_mcu7t3v3__inv_2_938/VNW VSUBS gf180mcu_as_sc_mcu7t3v3__inv_2
Xgf180mcu_as_sc_mcu7t3v3__inv_2_886 VSS VSS gf180mcu_as_sc_mcu7t3v3__inv_2_935/A gf180mcu_as_sc_mcu7t3v3__inv_2_887/Y
+ gf180mcu_as_sc_mcu7t3v3__inv_2_935/VNW VSUBS gf180mcu_as_sc_mcu7t3v3__inv_2
Xgf180mcu_as_sc_mcu7t3v3__inv_2_875 VSS VSS gf180mcu_as_sc_mcu7t3v3__inv_2_931/A gf180mcu_as_sc_mcu7t3v3__inv_2_876/Y
+ gf180mcu_as_sc_mcu7t3v3__inv_2_931/VNW VSUBS gf180mcu_as_sc_mcu7t3v3__inv_2
Xgf180mcu_as_sc_mcu7t3v3__nand4_2_152 VSS VSS VSS VSS VSS VSS gf180mcu_as_sc_mcu7t3v3__inv_2_641/A
+ gf180mcu_as_sc_mcu7t3v3__inv_2_641/VNW VSUBS gf180mcu_as_sc_mcu7t3v3__nand4_2
Xgf180mcu_as_sc_mcu7t3v3__nand4_2_130 VSS VSS VSS VSS VSS VSS gf180mcu_as_sc_mcu7t3v3__inv_2_487/A
+ gf180mcu_as_sc_mcu7t3v3__inv_2_550/VNW VSUBS gf180mcu_as_sc_mcu7t3v3__nand4_2
Xgf180mcu_as_sc_mcu7t3v3__nand4_2_174 VSS VSS VSS VSS VSS VSS gf180mcu_as_sc_mcu7t3v3__inv_2_633/A
+ gf180mcu_as_sc_mcu7t3v3__inv_2_633/VNW VSUBS gf180mcu_as_sc_mcu7t3v3__nand4_2
Xgf180mcu_as_sc_mcu7t3v3__nand4_2_141 VSS VSS VSS VSS VSS VSS gf180mcu_as_sc_mcu7t3v3__inv_2_503/A
+ gf180mcu_as_sc_mcu7t3v3__inv_2_556/VNW VSUBS gf180mcu_as_sc_mcu7t3v3__nand4_2
Xgf180mcu_as_sc_mcu7t3v3__nand4_2_163 VSS VSS VSS VSS VSS VSS gf180mcu_as_sc_mcu7t3v3__inv_2_620/A
+ gf180mcu_as_sc_mcu7t3v3__inv_2_620/VNW VSUBS gf180mcu_as_sc_mcu7t3v3__nand4_2
Xgf180mcu_as_sc_mcu7t3v3__nand4_2_185 VSS VSS VSS VSS VSS VSS gf180mcu_as_sc_mcu7t3v3__inv_2_712/A
+ gf180mcu_as_sc_mcu7t3v3__inv_2_712/VNW VSUBS gf180mcu_as_sc_mcu7t3v3__nand4_2
Xgf180mcu_as_sc_mcu7t3v3__nand4_2_196 VSS VSS VSS VSS VSS VSS gf180mcu_as_sc_mcu7t3v3__inv_2_731/A
+ gf180mcu_as_sc_mcu7t3v3__inv_2_731/VNW VSUBS gf180mcu_as_sc_mcu7t3v3__nand4_2
Xu_t026_013 u_t026_013/c0_w0_bl u_t026_013/c0_w0_br u_t026_013/c0_w1_bl u_t026_013/c0_w1_br
+ u_t026_013/c0_r0_rbl u_t026_013/c0_r1_rbl u_t026_013/c1_w0_bl u_t026_013/c1_w0_br
+ u_t026_013/c1_w1_bl u_t026_013/c1_w1_br u_t026_013/c1_r0_rbl u_t026_013/c1_r1_rbl
+ u_t026_013/c2_w0_bl u_t026_013/c2_w0_br u_t026_013/c2_w1_bl u_t026_013/c2_w1_br
+ u_t026_013/c2_r0_rbl u_t026_013/c2_r1_rbl u_t026_013/c3_w0_bl u_t026_013/c3_w0_br
+ u_t026_013/c3_w1_bl u_t026_013/c3_w1_br u_t026_013/c3_r0_rbl u_t026_013/c3_r1_rbl
+ u_t026_013/r0_w0_wl u_t026_013/r0_w1_wl u_t026_013/r0_r0_rwl u_t026_013/r0_r1_rwl
+ u_t026_013/r1_w0_wl u_t026_013/r1_w1_wl u_t026_013/r1_r0_rwl u_t026_013/r1_r1_rwl
+ u_t026_013/r2_w0_wl u_t026_013/r2_w1_wl u_t026_013/r2_r0_rwl u_t026_013/r2_r1_rwl
+ u_t026_013/r3_w0_wl u_t026_013/r3_w1_wl u_t026_013/r3_r0_rwl u_t026_013/r3_r1_rwl
+ VSS VSS u_t026_013/m2_717_1265# u_t026_013/m2_603_2031# u_t026_013/m2_1290_336#
+ u_t026_013/m2_2000_2037# u_t026_013/m2_791_2909# u_t026_013/m2_7_2126# u_t026_013/m2_2154_2081#
+ u_t026_013/m2_1795_2037# u_t026_013/m2_871_303# u_t026_013/m2_431_438# u_t026_013/m2_1290_2898#
+ u_t026_013/m2_1714_1210# u_t026_013/m2_431_1982# u_t026_013/m2_512_1265# u_t026_013/m2_2573_2126#
+ u_t026_013/m2_603_1259# u_t026_013/m2_2074_2909# u_t026_013/m2_7_336# u_t026_013/m2_717_2037#
+ u_t026_013/m2_1886_2031# u_t026_013/m2_2573_336# u_t026_013/m2_7_2898# u_t026_013/m2_2000_1265#
+ u_t026_013/m2_512_2037# u_t026_013/m2_1795_1265# u_t026_013/m2_1714_1982# u_t026_013/m2_1886_1259#
+ u_t026_013/m2_1290_2126# u_t026_013/m2_1714_438# u_t026_013/m2_431_1210# u_t026_013/m2_2573_2898#
+ u_t026_013/m2_2154_303# u_t026_013/m2_871_2081# VSUBS detronyx_12t_2w2r_rc4_4x4_routed_5layer_direct
Xu_t026_002 u_t026_002/c0_w0_bl u_t026_002/c0_w0_br u_t026_002/c0_w1_bl u_t026_002/c0_w1_br
+ u_t026_002/c0_r0_rbl u_t026_002/c0_r1_rbl u_t026_002/c1_w0_bl u_t026_002/c1_w0_br
+ u_t026_002/c1_w1_bl u_t026_002/c1_w1_br u_t026_002/c1_r0_rbl u_t026_002/c1_r1_rbl
+ u_t026_002/c2_w0_bl u_t026_002/c2_w0_br u_t026_002/c2_w1_bl u_t026_002/c2_w1_br
+ u_t026_002/c2_r0_rbl u_t026_002/c2_r1_rbl u_t026_002/c3_w0_bl u_t026_002/c3_w0_br
+ u_t026_002/c3_w1_bl u_t026_002/c3_w1_br u_t026_002/c3_r0_rbl u_t026_002/c3_r1_rbl
+ u_t026_002/r0_w0_wl u_t026_002/r0_w1_wl u_t026_002/r0_r0_rwl u_t026_002/r0_r1_rwl
+ u_t026_002/r1_w0_wl u_t026_002/r1_w1_wl u_t026_002/r1_r0_rwl u_t026_002/r1_r1_rwl
+ u_t026_002/r2_w0_wl u_t026_002/r2_w1_wl u_t026_002/r2_r0_rwl u_t026_002/r2_r1_rwl
+ u_t026_002/r3_w0_wl u_t026_002/r3_w1_wl u_t026_002/r3_r0_rwl u_t026_002/r3_r1_rwl
+ VSS VSS u_t026_002/m2_717_1265# u_t026_002/m2_603_2031# u_t026_002/m2_1290_336#
+ u_t026_002/m2_2000_2037# u_t026_002/m2_791_2909# u_t026_002/m2_7_2126# u_t026_002/m2_2154_2081#
+ u_t026_002/m2_1795_2037# u_t026_002/m2_871_303# u_t026_002/m2_431_438# u_t026_002/m2_1290_2898#
+ u_t026_002/m2_1714_1210# u_t026_002/m2_431_1982# u_t026_002/m2_512_1265# u_t026_002/m2_2573_2126#
+ u_t026_002/m2_603_1259# u_t026_002/m2_2074_2909# u_t026_002/m2_7_336# u_t026_002/m2_717_2037#
+ u_t026_002/m2_1886_2031# u_t026_002/m2_2573_336# u_t026_002/m2_7_2898# u_t026_002/m2_2000_1265#
+ u_t026_002/m2_512_2037# u_t026_002/m2_1795_1265# u_t026_002/m2_1714_1982# u_t026_002/m2_1886_1259#
+ u_t026_002/m2_1290_2126# u_t026_002/m2_1714_438# u_t026_002/m2_431_1210# u_t026_002/m2_2573_2898#
+ u_t026_002/m2_2154_303# u_t026_002/m2_871_2081# VSUBS detronyx_12t_2w2r_rc4_4x4_routed_5layer_direct
Xgf180mcu_as_sc_mcu7t3v3__nand4_2_91 VSS VSS VSS VSS VSS VSS gf180mcu_as_sc_mcu7t3v3__inv_2_46/A
+ gf180mcu_as_sc_mcu7t3v3__inv_2_46/VNW VSUBS gf180mcu_as_sc_mcu7t3v3__nand4_2
Xgf180mcu_as_sc_mcu7t3v3__nand4_2_80 VSS VSS VSS VSS VSS VSS gf180mcu_as_sc_mcu7t3v3__inv_2_53/A
+ gf180mcu_as_sc_mcu7t3v3__inv_2_53/VNW VSUBS gf180mcu_as_sc_mcu7t3v3__nand4_2
Xu_t017_013 u_t017_013/c0_w0_bl u_t017_013/c0_w0_br u_t017_013/c0_w1_bl u_t017_013/c0_w1_br
+ u_t017_013/c0_r0_rbl u_t017_013/c0_r1_rbl u_t017_013/c1_w0_bl u_t017_013/c1_w0_br
+ u_t017_013/c1_w1_bl u_t017_013/c1_w1_br u_t017_013/c1_r0_rbl u_t017_013/c1_r1_rbl
+ u_t017_013/c2_w0_bl u_t017_013/c2_w0_br u_t017_013/c2_w1_bl u_t017_013/c2_w1_br
+ u_t017_013/c2_r0_rbl u_t017_013/c2_r1_rbl u_t017_013/c3_w0_bl u_t017_013/c3_w0_br
+ u_t017_013/c3_w1_bl u_t017_013/c3_w1_br u_t017_013/c3_r0_rbl u_t017_013/c3_r1_rbl
+ u_t017_013/r0_w0_wl u_t017_013/r0_w1_wl u_t017_013/r0_r0_rwl u_t017_013/r0_r1_rwl
+ u_t017_013/r1_w0_wl u_t017_013/r1_w1_wl u_t017_013/r1_r0_rwl u_t017_013/r1_r1_rwl
+ u_t017_013/r2_w0_wl u_t017_013/r2_w1_wl u_t017_013/r2_r0_rwl u_t017_013/r2_r1_rwl
+ u_t017_013/r3_w0_wl u_t017_013/r3_w1_wl u_t017_013/r3_r0_rwl u_t017_013/r3_r1_rwl
+ VSS VSS u_t017_013/m2_717_1265# u_t017_013/m2_603_2031# u_t017_013/m2_1290_336#
+ u_t017_013/m2_2000_2037# u_t017_013/m2_791_2909# u_t017_013/m2_7_2126# u_t017_013/m2_2154_2081#
+ u_t017_013/m2_1795_2037# u_t017_013/m2_871_303# u_t017_013/m2_431_438# u_t017_013/m2_1290_2898#
+ u_t017_013/m2_1714_1210# u_t017_013/m2_431_1982# u_t017_013/m2_512_1265# u_t017_013/m2_2573_2126#
+ u_t017_013/m2_603_1259# u_t017_013/m2_2074_2909# u_t017_013/m2_7_336# u_t017_013/m2_717_2037#
+ u_t017_013/m2_1886_2031# u_t017_013/m2_2573_336# u_t017_013/m2_7_2898# u_t017_013/m2_2000_1265#
+ u_t017_013/m2_512_2037# u_t017_013/m2_1795_1265# u_t017_013/m2_1714_1982# u_t017_013/m2_1886_1259#
+ u_t017_013/m2_1290_2126# u_t017_013/m2_1714_438# u_t017_013/m2_431_1210# u_t017_013/m2_2573_2898#
+ u_t017_013/m2_2154_303# u_t017_013/m2_871_2081# VSUBS detronyx_12t_2w2r_rc4_4x4_routed_5layer_direct
Xu_t017_002 u_t017_002/c0_w0_bl u_t017_002/c0_w0_br u_t017_002/c0_w1_bl u_t017_002/c0_w1_br
+ u_t017_002/c0_r0_rbl u_t017_002/c0_r1_rbl u_t017_002/c1_w0_bl u_t017_002/c1_w0_br
+ u_t017_002/c1_w1_bl u_t017_002/c1_w1_br u_t017_002/c1_r0_rbl u_t017_002/c1_r1_rbl
+ u_t017_002/c2_w0_bl u_t017_002/c2_w0_br u_t017_002/c2_w1_bl u_t017_002/c2_w1_br
+ u_t017_002/c2_r0_rbl u_t017_002/c2_r1_rbl u_t017_002/c3_w0_bl u_t017_002/c3_w0_br
+ u_t017_002/c3_w1_bl u_t017_002/c3_w1_br u_t017_002/c3_r0_rbl u_t017_002/c3_r1_rbl
+ u_t017_002/r0_w0_wl u_t017_002/r0_w1_wl u_t017_002/r0_r0_rwl u_t017_002/r0_r1_rwl
+ u_t017_002/r1_w0_wl u_t017_002/r1_w1_wl u_t017_002/r1_r0_rwl u_t017_002/r1_r1_rwl
+ u_t017_002/r2_w0_wl u_t017_002/r2_w1_wl u_t017_002/r2_r0_rwl u_t017_002/r2_r1_rwl
+ u_t017_002/r3_w0_wl u_t017_002/r3_w1_wl u_t017_002/r3_r0_rwl u_t017_002/r3_r1_rwl
+ VSS VSS u_t017_002/m2_717_1265# u_t017_002/m2_603_2031# u_t017_002/m2_1290_336#
+ u_t017_002/m2_2000_2037# u_t017_002/m2_791_2909# u_t017_002/m2_7_2126# u_t017_002/m2_2154_2081#
+ u_t017_002/m2_1795_2037# u_t017_002/m2_871_303# u_t017_002/m2_431_438# u_t017_002/m2_1290_2898#
+ u_t017_002/m2_1714_1210# u_t017_002/m2_431_1982# u_t017_002/m2_512_1265# u_t017_002/m2_2573_2126#
+ u_t017_002/m2_603_1259# u_t017_002/m2_2074_2909# u_t017_002/m2_7_336# u_t017_002/m2_717_2037#
+ u_t017_002/m2_1886_2031# u_t017_002/m2_2573_336# u_t017_002/m2_7_2898# u_t017_002/m2_2000_1265#
+ u_t017_002/m2_512_2037# u_t017_002/m2_1795_1265# u_t017_002/m2_1714_1982# u_t017_002/m2_1886_1259#
+ u_t017_002/m2_1290_2126# u_t017_002/m2_1714_438# u_t017_002/m2_431_1210# u_t017_002/m2_2573_2898#
+ u_t017_002/m2_2154_303# u_t017_002/m2_871_2081# VSUBS detronyx_12t_2w2r_rc4_4x4_routed_5layer_direct
Xgf180mcu_as_sc_mcu7t3v3__inv_2_105 VSS VSS VSS gf180mcu_as_sc_mcu7t3v3__inv_2_106/Y
+ gf180mcu_as_sc_mcu7t3v3__nand4_2_9/VNW VSUBS gf180mcu_as_sc_mcu7t3v3__inv_2
Xgf180mcu_as_sc_mcu7t3v3__inv_2_116 VSS VSS gf180mcu_as_sc_mcu7t3v3__inv_2_116/Y gf180mcu_as_sc_mcu7t3v3__inv_2_116/A
+ gf180mcu_as_sc_mcu7t3v3__inv_2_116/VNW VSUBS gf180mcu_as_sc_mcu7t3v3__inv_2
Xgf180mcu_as_sc_mcu7t3v3__inv_2_149 VSS VSS gf180mcu_as_sc_mcu7t3v3__inv_2_149/Y gf180mcu_as_sc_mcu7t3v3__inv_2_149/A
+ gf180mcu_as_sc_mcu7t3v3__inv_2_149/VNW VSUBS gf180mcu_as_sc_mcu7t3v3__inv_2
Xgf180mcu_as_sc_mcu7t3v3__inv_2_138 VSS VSS VSS gf180mcu_as_sc_mcu7t3v3__inv_2_139/Y
+ gf180mcu_as_sc_mcu7t3v3__inv_2_140/VNW VSUBS gf180mcu_as_sc_mcu7t3v3__inv_2
Xgf180mcu_as_sc_mcu7t3v3__inv_2_127 VSS VSS gf180mcu_as_sc_mcu7t3v3__inv_2_127/Y gf180mcu_as_sc_mcu7t3v3__inv_2_128/Y
+ gf180mcu_as_sc_mcu7t3v3__inv_2_128/VNW VSUBS gf180mcu_as_sc_mcu7t3v3__inv_2
Xu_t008_013 u_t008_013/c0_w0_bl u_t008_013/c0_w0_br u_t008_013/c0_w1_bl u_t008_013/c0_w1_br
+ u_t008_013/c0_r0_rbl u_t008_013/c0_r1_rbl u_t008_013/c1_w0_bl u_t008_013/c1_w0_br
+ u_t008_013/c1_w1_bl u_t008_013/c1_w1_br u_t008_013/c1_r0_rbl u_t008_013/c1_r1_rbl
+ u_t008_013/c2_w0_bl u_t008_013/c2_w0_br u_t008_013/c2_w1_bl u_t008_013/c2_w1_br
+ u_t008_013/c2_r0_rbl u_t008_013/c2_r1_rbl u_t008_013/c3_w0_bl u_t008_013/c3_w0_br
+ u_t008_013/c3_w1_bl u_t008_013/c3_w1_br u_t008_013/c3_r0_rbl u_t008_013/c3_r1_rbl
+ u_t008_013/r0_w0_wl u_t008_013/r0_w1_wl u_t008_013/r0_r0_rwl u_t008_013/r0_r1_rwl
+ u_t008_013/r1_w0_wl u_t008_013/r1_w1_wl u_t008_013/r1_r0_rwl u_t008_013/r1_r1_rwl
+ u_t008_013/r2_w0_wl u_t008_013/r2_w1_wl u_t008_013/r2_r0_rwl u_t008_013/r2_r1_rwl
+ u_t008_013/r3_w0_wl u_t008_013/r3_w1_wl u_t008_013/r3_r0_rwl u_t008_013/r3_r1_rwl
+ VSS VSS u_t008_013/m2_717_1265# u_t008_013/m2_603_2031# u_t008_013/m2_1290_336#
+ u_t008_013/m2_2000_2037# u_t008_013/m2_791_2909# u_t008_013/m2_7_2126# u_t008_013/m2_2154_2081#
+ u_t008_013/m2_1795_2037# u_t008_013/m2_871_303# u_t008_013/m2_431_438# u_t008_013/m2_1290_2898#
+ u_t008_013/m2_1714_1210# u_t008_013/m2_431_1982# u_t008_013/m2_512_1265# u_t008_013/m2_2573_2126#
+ u_t008_013/m2_603_1259# u_t008_013/m2_2074_2909# u_t008_013/m2_7_336# u_t008_013/m2_717_2037#
+ u_t008_013/m2_1886_2031# u_t008_013/m2_2573_336# u_t008_013/m2_7_2898# u_t008_013/m2_2000_1265#
+ u_t008_013/m2_512_2037# u_t008_013/m2_1795_1265# u_t008_013/m2_1714_1982# u_t008_013/m2_1886_1259#
+ u_t008_013/m2_1290_2126# u_t008_013/m2_1714_438# u_t008_013/m2_431_1210# u_t008_013/m2_2573_2898#
+ u_t008_013/m2_2154_303# u_t008_013/m2_871_2081# VSUBS detronyx_12t_2w2r_rc4_4x4_routed_5layer_direct
Xu_t023_005 u_t023_005/c0_w0_bl u_t023_005/c0_w0_br u_t023_005/c0_w1_bl u_t023_005/c0_w1_br
+ u_t023_005/c0_r0_rbl u_t023_005/c0_r1_rbl u_t023_005/c1_w0_bl u_t023_005/c1_w0_br
+ u_t023_005/c1_w1_bl u_t023_005/c1_w1_br u_t023_005/c1_r0_rbl u_t023_005/c1_r1_rbl
+ u_t023_005/c2_w0_bl u_t023_005/c2_w0_br u_t023_005/c2_w1_bl u_t023_005/c2_w1_br
+ u_t023_005/c2_r0_rbl u_t023_005/c2_r1_rbl u_t023_005/c3_w0_bl u_t023_005/c3_w0_br
+ u_t023_005/c3_w1_bl u_t023_005/c3_w1_br u_t023_005/c3_r0_rbl u_t023_005/c3_r1_rbl
+ u_t023_005/r0_w0_wl u_t023_005/r0_w1_wl u_t023_005/r0_r0_rwl u_t023_005/r0_r1_rwl
+ u_t023_005/r1_w0_wl u_t023_005/r1_w1_wl u_t023_005/r1_r0_rwl u_t023_005/r1_r1_rwl
+ u_t023_005/r2_w0_wl u_t023_005/r2_w1_wl u_t023_005/r2_r0_rwl u_t023_005/r2_r1_rwl
+ u_t023_005/r3_w0_wl u_t023_005/r3_w1_wl u_t023_005/r3_r0_rwl u_t023_005/r3_r1_rwl
+ VSS VSS u_t023_005/m2_717_1265# u_t023_005/m2_603_2031# u_t023_005/m2_1290_336#
+ u_t023_005/m2_2000_2037# u_t023_005/m2_791_2909# u_t023_005/m2_7_2126# u_t023_005/m2_2154_2081#
+ u_t023_005/m2_1795_2037# u_t023_005/m2_871_303# u_t023_005/m2_431_438# u_t023_005/m2_1290_2898#
+ u_t023_005/m2_1714_1210# u_t023_005/m2_431_1982# u_t023_005/m2_512_1265# u_t023_005/m2_2573_2126#
+ u_t023_005/m2_603_1259# u_t023_005/m2_2074_2909# u_t023_005/m2_7_336# u_t023_005/m2_717_2037#
+ u_t023_005/m2_1886_2031# u_t023_005/m2_2573_336# u_t023_005/m2_7_2898# u_t023_005/m2_2000_1265#
+ u_t023_005/m2_512_2037# u_t023_005/m2_1795_1265# u_t023_005/m2_1714_1982# u_t023_005/m2_1886_1259#
+ u_t023_005/m2_1290_2126# u_t023_005/m2_1714_438# u_t023_005/m2_431_1210# u_t023_005/m2_2573_2898#
+ u_t023_005/m2_2154_303# u_t023_005/m2_871_2081# VSUBS detronyx_12t_2w2r_rc4_4x4_routed_5layer_direct
Xu_t008_002 u_t008_002/c0_w0_bl u_t008_002/c0_w0_br u_t008_002/c0_w1_bl u_t008_002/c0_w1_br
+ u_t008_002/c0_r0_rbl u_t008_002/c0_r1_rbl u_t008_002/c1_w0_bl u_t008_002/c1_w0_br
+ u_t008_002/c1_w1_bl u_t008_002/c1_w1_br u_t008_002/c1_r0_rbl u_t008_002/c1_r1_rbl
+ u_t008_002/c2_w0_bl u_t008_002/c2_w0_br u_t008_002/c2_w1_bl u_t008_002/c2_w1_br
+ u_t008_002/c2_r0_rbl u_t008_002/c2_r1_rbl u_t008_002/c3_w0_bl u_t008_002/c3_w0_br
+ u_t008_002/c3_w1_bl u_t008_002/c3_w1_br u_t008_002/c3_r0_rbl u_t008_002/c3_r1_rbl
+ u_t008_002/r0_w0_wl u_t008_002/r0_w1_wl u_t008_002/r0_r0_rwl u_t008_002/r0_r1_rwl
+ u_t008_002/r1_w0_wl u_t008_002/r1_w1_wl u_t008_002/r1_r0_rwl u_t008_002/r1_r1_rwl
+ u_t008_002/r2_w0_wl u_t008_002/r2_w1_wl u_t008_002/r2_r0_rwl u_t008_002/r2_r1_rwl
+ u_t008_002/r3_w0_wl u_t008_002/r3_w1_wl u_t008_002/r3_r0_rwl u_t008_002/r3_r1_rwl
+ VSS VSS u_t008_002/m2_717_1265# u_t008_002/m2_603_2031# u_t008_002/m2_1290_336#
+ u_t008_002/m2_2000_2037# u_t008_002/m2_791_2909# u_t008_002/m2_7_2126# u_t008_002/m2_2154_2081#
+ u_t008_002/m2_1795_2037# u_t008_002/m2_871_303# u_t008_002/m2_431_438# u_t008_002/m2_1290_2898#
+ u_t008_002/m2_1714_1210# u_t008_002/m2_431_1982# u_t008_002/m2_512_1265# u_t008_002/m2_2573_2126#
+ u_t008_002/m2_603_1259# u_t008_002/m2_2074_2909# u_t008_002/m2_7_336# u_t008_002/m2_717_2037#
+ u_t008_002/m2_1886_2031# u_t008_002/m2_2573_336# u_t008_002/m2_7_2898# u_t008_002/m2_2000_1265#
+ u_t008_002/m2_512_2037# u_t008_002/m2_1795_1265# u_t008_002/m2_1714_1982# u_t008_002/m2_1886_1259#
+ u_t008_002/m2_1290_2126# u_t008_002/m2_1714_438# u_t008_002/m2_431_1210# u_t008_002/m2_2573_2898#
+ u_t008_002/m2_2154_303# u_t008_002/m2_871_2081# VSUBS detronyx_12t_2w2r_rc4_4x4_routed_5layer_direct
Xgf180mcu_as_sc_mcu7t3v3__inv_2_650 VSS VSS gf180mcu_as_sc_mcu7t3v3__inv_2_650/Y gf180mcu_as_sc_mcu7t3v3__inv_2_650/A
+ gf180mcu_as_sc_mcu7t3v3__inv_2_650/VNW VSUBS gf180mcu_as_sc_mcu7t3v3__inv_2
Xgf180mcu_as_sc_mcu7t3v3__inv_2_661 VSS VSS gf180mcu_as_sc_mcu7t3v3__inv_2_661/Y gf180mcu_as_sc_mcu7t3v3__inv_2_661/A
+ gf180mcu_as_sc_mcu7t3v3__inv_2_661/VNW VSUBS gf180mcu_as_sc_mcu7t3v3__inv_2
Xgf180mcu_as_sc_mcu7t3v3__inv_2_672 VSS VSS VSS gf180mcu_as_sc_mcu7t3v3__inv_2_673/Y
+ gf180mcu_as_sc_mcu7t3v3__inv_2_674/VNW VSUBS gf180mcu_as_sc_mcu7t3v3__inv_2
Xgf180mcu_as_sc_mcu7t3v3__inv_2_683 VSS VSS gf180mcu_as_sc_mcu7t3v3__inv_2_683/Y gf180mcu_as_sc_mcu7t3v3__inv_2_684/Y
+ gf180mcu_as_sc_mcu7t3v3__inv_2_684/VNW VSUBS gf180mcu_as_sc_mcu7t3v3__inv_2
Xgf180mcu_as_sc_mcu7t3v3__inv_2_694 VSS VSS gf180mcu_as_sc_mcu7t3v3__inv_2_741/A gf180mcu_as_sc_mcu7t3v3__inv_2_705/Y
+ gf180mcu_as_sc_mcu7t3v3__inv_2_741/VNW VSUBS gf180mcu_as_sc_mcu7t3v3__inv_2
Xgf180mcu_as_sc_mcu7t3v3__nand2_2_17 gf180mcu_as_sc_mcu7t3v3__nor2_2_7/VDD gf180mcu_as_sc_mcu7t3v3__nor2_2_7/VSS
+ VSS VSS VSS gf180mcu_as_sc_mcu7t3v3__nor2_2_7/VNW VSUBS gf180mcu_as_sc_mcu7t3v3__nand2_2
Xgf180mcu_as_sc_mcu7t3v3__nand2_2_28 gf180mcu_as_sc_mcu7t3v3__nor2_2_7/VDD gf180mcu_as_sc_mcu7t3v3__nor2_2_7/VSS
+ VSS VSS VSS gf180mcu_as_sc_mcu7t3v3__nor2_2_7/VNW VSUBS gf180mcu_as_sc_mcu7t3v3__nand2_2
Xu_t014_005 u_t014_005/c0_w0_bl u_t014_005/c0_w0_br u_t014_005/c0_w1_bl u_t014_005/c0_w1_br
+ u_t014_005/c0_r0_rbl u_t014_005/c0_r1_rbl u_t014_005/c1_w0_bl u_t014_005/c1_w0_br
+ u_t014_005/c1_w1_bl u_t014_005/c1_w1_br u_t014_005/c1_r0_rbl u_t014_005/c1_r1_rbl
+ u_t014_005/c2_w0_bl u_t014_005/c2_w0_br u_t014_005/c2_w1_bl u_t014_005/c2_w1_br
+ u_t014_005/c2_r0_rbl u_t014_005/c2_r1_rbl u_t014_005/c3_w0_bl u_t014_005/c3_w0_br
+ u_t014_005/c3_w1_bl u_t014_005/c3_w1_br u_t014_005/c3_r0_rbl u_t014_005/c3_r1_rbl
+ u_t014_005/r0_w0_wl u_t014_005/r0_w1_wl u_t014_005/r0_r0_rwl u_t014_005/r0_r1_rwl
+ u_t014_005/r1_w0_wl u_t014_005/r1_w1_wl u_t014_005/r1_r0_rwl u_t014_005/r1_r1_rwl
+ u_t014_005/r2_w0_wl u_t014_005/r2_w1_wl u_t014_005/r2_r0_rwl u_t014_005/r2_r1_rwl
+ u_t014_005/r3_w0_wl u_t014_005/r3_w1_wl u_t014_005/r3_r0_rwl u_t014_005/r3_r1_rwl
+ VSS VSS u_t014_005/m2_717_1265# u_t014_005/m2_603_2031# u_t014_005/m2_1290_336#
+ u_t014_005/m2_2000_2037# u_t014_005/m2_791_2909# u_t014_005/m2_7_2126# u_t014_005/m2_2154_2081#
+ u_t014_005/m2_1795_2037# u_t014_005/m2_871_303# u_t014_005/m2_431_438# u_t014_005/m2_1290_2898#
+ u_t014_005/m2_1714_1210# u_t014_005/m2_431_1982# u_t014_005/m2_512_1265# u_t014_005/m2_2573_2126#
+ u_t014_005/m2_603_1259# u_t014_005/m2_2074_2909# u_t014_005/m2_7_336# u_t014_005/m2_717_2037#
+ u_t014_005/m2_1886_2031# u_t014_005/m2_2573_336# u_t014_005/m2_7_2898# u_t014_005/m2_2000_1265#
+ u_t014_005/m2_512_2037# u_t014_005/m2_1795_1265# u_t014_005/m2_1714_1982# u_t014_005/m2_1886_1259#
+ u_t014_005/m2_1290_2126# u_t014_005/m2_1714_438# u_t014_005/m2_431_1210# u_t014_005/m2_2573_2898#
+ u_t014_005/m2_2154_303# u_t014_005/m2_871_2081# VSUBS detronyx_12t_2w2r_rc4_4x4_routed_5layer_direct
Xgf180mcu_as_sc_mcu7t3v3__nand2_2_39 gf180mcu_as_sc_mcu7t3v3__nor2_2_9/VDD gf180mcu_as_sc_mcu7t3v3__nor2_2_9/VSS
+ VSS VSS VSS gf180mcu_as_sc_mcu7t3v3__nor2_2_9/VNW VSUBS gf180mcu_as_sc_mcu7t3v3__nand2_2
Xu_t005_005 u_t005_005/c0_w0_bl u_t005_005/c0_w0_br u_t005_005/c0_w1_bl u_t005_005/c0_w1_br
+ u_t005_005/c0_r0_rbl u_t005_005/c0_r1_rbl u_t005_005/c1_w0_bl u_t005_005/c1_w0_br
+ u_t005_005/c1_w1_bl u_t005_005/c1_w1_br u_t005_005/c1_r0_rbl u_t005_005/c1_r1_rbl
+ u_t005_005/c2_w0_bl u_t005_005/c2_w0_br u_t005_005/c2_w1_bl u_t005_005/c2_w1_br
+ u_t005_005/c2_r0_rbl u_t005_005/c2_r1_rbl u_t005_005/c3_w0_bl u_t005_005/c3_w0_br
+ u_t005_005/c3_w1_bl u_t005_005/c3_w1_br u_t005_005/c3_r0_rbl u_t005_005/c3_r1_rbl
+ u_t005_005/r0_w0_wl u_t005_005/r0_w1_wl u_t005_005/r0_r0_rwl u_t005_005/r0_r1_rwl
+ u_t005_005/r1_w0_wl u_t005_005/r1_w1_wl u_t005_005/r1_r0_rwl u_t005_005/r1_r1_rwl
+ u_t005_005/r2_w0_wl u_t005_005/r2_w1_wl u_t005_005/r2_r0_rwl u_t005_005/r2_r1_rwl
+ u_t005_005/r3_w0_wl u_t005_005/r3_w1_wl u_t005_005/r3_r0_rwl u_t005_005/r3_r1_rwl
+ VSS VSS u_t005_005/m2_717_1265# u_t005_005/m2_603_2031# u_t005_005/m2_1290_336#
+ u_t005_005/m2_2000_2037# u_t005_005/m2_791_2909# u_t005_005/m2_7_2126# u_t005_005/m2_2154_2081#
+ u_t005_005/m2_1795_2037# u_t005_005/m2_871_303# u_t005_005/m2_431_438# u_t005_005/m2_1290_2898#
+ u_t005_005/m2_1714_1210# u_t005_005/m2_431_1982# u_t005_005/m2_512_1265# u_t005_005/m2_2573_2126#
+ u_t005_005/m2_603_1259# u_t005_005/m2_2074_2909# u_t005_005/m2_7_336# u_t005_005/m2_717_2037#
+ u_t005_005/m2_1886_2031# u_t005_005/m2_2573_336# u_t005_005/m2_7_2898# u_t005_005/m2_2000_1265#
+ u_t005_005/m2_512_2037# u_t005_005/m2_1795_1265# u_t005_005/m2_1714_1982# u_t005_005/m2_1886_1259#
+ u_t005_005/m2_1290_2126# u_t005_005/m2_1714_438# u_t005_005/m2_431_1210# u_t005_005/m2_2573_2898#
+ u_t005_005/m2_2154_303# u_t005_005/m2_871_2081# VSUBS detronyx_12t_2w2r_rc4_4x4_routed_5layer_direct
Xu_t020_008 u_t020_008/c0_w0_bl u_t020_008/c0_w0_br u_t020_008/c0_w1_bl u_t020_008/c0_w1_br
+ u_t020_008/c0_r0_rbl u_t020_008/c0_r1_rbl u_t020_008/c1_w0_bl u_t020_008/c1_w0_br
+ u_t020_008/c1_w1_bl u_t020_008/c1_w1_br u_t020_008/c1_r0_rbl u_t020_008/c1_r1_rbl
+ u_t020_008/c2_w0_bl u_t020_008/c2_w0_br u_t020_008/c2_w1_bl u_t020_008/c2_w1_br
+ u_t020_008/c2_r0_rbl u_t020_008/c2_r1_rbl u_t020_008/c3_w0_bl u_t020_008/c3_w0_br
+ u_t020_008/c3_w1_bl u_t020_008/c3_w1_br u_t020_008/c3_r0_rbl u_t020_008/c3_r1_rbl
+ u_t020_008/r0_w0_wl u_t020_008/r0_w1_wl u_t020_008/r0_r0_rwl u_t020_008/r0_r1_rwl
+ u_t020_008/r1_w0_wl u_t020_008/r1_w1_wl u_t020_008/r1_r0_rwl u_t020_008/r1_r1_rwl
+ u_t020_008/r2_w0_wl u_t020_008/r2_w1_wl u_t020_008/r2_r0_rwl u_t020_008/r2_r1_rwl
+ u_t020_008/r3_w0_wl u_t020_008/r3_w1_wl u_t020_008/r3_r0_rwl u_t020_008/r3_r1_rwl
+ VSS VSS u_t020_008/m2_717_1265# u_t020_008/m2_603_2031# u_t020_008/m2_1290_336#
+ u_t020_008/m2_2000_2037# u_t020_008/m2_791_2909# u_t020_008/m2_7_2126# u_t020_008/m2_2154_2081#
+ u_t020_008/m2_1795_2037# u_t020_008/m2_871_303# u_t020_008/m2_431_438# u_t020_008/m2_1290_2898#
+ u_t020_008/m2_1714_1210# u_t020_008/m2_431_1982# u_t020_008/m2_512_1265# u_t020_008/m2_2573_2126#
+ u_t020_008/m2_603_1259# u_t020_008/m2_2074_2909# u_t020_008/m2_7_336# u_t020_008/m2_717_2037#
+ u_t020_008/m2_1886_2031# u_t020_008/m2_2573_336# u_t020_008/m2_7_2898# u_t020_008/m2_2000_1265#
+ u_t020_008/m2_512_2037# u_t020_008/m2_1795_1265# u_t020_008/m2_1714_1982# u_t020_008/m2_1886_1259#
+ u_t020_008/m2_1290_2126# u_t020_008/m2_1714_438# u_t020_008/m2_431_1210# u_t020_008/m2_2573_2898#
+ u_t020_008/m2_2154_303# u_t020_008/m2_871_2081# VSUBS detronyx_12t_2w2r_rc4_4x4_routed_5layer_direct
Xu_t011_008 u_t011_008/c0_w0_bl u_t011_008/c0_w0_br u_t011_008/c0_w1_bl u_t011_008/c0_w1_br
+ u_t011_008/c0_r0_rbl u_t011_008/c0_r1_rbl u_t011_008/c1_w0_bl u_t011_008/c1_w0_br
+ u_t011_008/c1_w1_bl u_t011_008/c1_w1_br u_t011_008/c1_r0_rbl u_t011_008/c1_r1_rbl
+ u_t011_008/c2_w0_bl u_t011_008/c2_w0_br u_t011_008/c2_w1_bl u_t011_008/c2_w1_br
+ u_t011_008/c2_r0_rbl u_t011_008/c2_r1_rbl u_t011_008/c3_w0_bl u_t011_008/c3_w0_br
+ u_t011_008/c3_w1_bl u_t011_008/c3_w1_br u_t011_008/c3_r0_rbl u_t011_008/c3_r1_rbl
+ u_t011_008/r0_w0_wl u_t011_008/r0_w1_wl u_t011_008/r0_r0_rwl u_t011_008/r0_r1_rwl
+ u_t011_008/r1_w0_wl u_t011_008/r1_w1_wl u_t011_008/r1_r0_rwl u_t011_008/r1_r1_rwl
+ u_t011_008/r2_w0_wl u_t011_008/r2_w1_wl u_t011_008/r2_r0_rwl u_t011_008/r2_r1_rwl
+ u_t011_008/r3_w0_wl u_t011_008/r3_w1_wl u_t011_008/r3_r0_rwl u_t011_008/r3_r1_rwl
+ VSS VSS u_t011_008/m2_717_1265# u_t011_008/m2_603_2031# u_t011_008/m2_1290_336#
+ u_t011_008/m2_2000_2037# u_t011_008/m2_791_2909# u_t011_008/m2_7_2126# u_t011_008/m2_2154_2081#
+ u_t011_008/m2_1795_2037# u_t011_008/m2_871_303# u_t011_008/m2_431_438# u_t011_008/m2_1290_2898#
+ u_t011_008/m2_1714_1210# u_t011_008/m2_431_1982# u_t011_008/m2_512_1265# u_t011_008/m2_2573_2126#
+ u_t011_008/m2_603_1259# u_t011_008/m2_2074_2909# u_t011_008/m2_7_336# u_t011_008/m2_717_2037#
+ u_t011_008/m2_1886_2031# u_t011_008/m2_2573_336# u_t011_008/m2_7_2898# u_t011_008/m2_2000_1265#
+ u_t011_008/m2_512_2037# u_t011_008/m2_1795_1265# u_t011_008/m2_1714_1982# u_t011_008/m2_1886_1259#
+ u_t011_008/m2_1290_2126# u_t011_008/m2_1714_438# u_t011_008/m2_431_1210# u_t011_008/m2_2573_2898#
+ u_t011_008/m2_2154_303# u_t011_008/m2_871_2081# VSUBS detronyx_12t_2w2r_rc4_4x4_routed_5layer_direct
Xgf180mcu_as_sc_mcu7t3v3__inv_2_480 gf180mcu_as_sc_mcu7t3v3__nor2_2_6/VDD gf180mcu_as_sc_mcu7t3v3__nand3_2_4/VSS
+ gf180mcu_as_sc_mcu7t3v3__inv_2_480/Y VSS gf180mcu_as_sc_mcu7t3v3__nor2_2_6/VNW VSUBS
+ gf180mcu_as_sc_mcu7t3v3__inv_2
Xgf180mcu_as_sc_mcu7t3v3__inv_2_491 VSS VSS gf180mcu_as_sc_mcu7t3v3__inv_2_553/A gf180mcu_as_sc_mcu7t3v3__inv_2_492/Y
+ gf180mcu_as_sc_mcu7t3v3__inv_2_553/VNW VSUBS gf180mcu_as_sc_mcu7t3v3__inv_2
Xu_t002_008 u_t002_008/c0_w0_bl u_t002_008/c0_w0_br u_t002_008/c0_w1_bl u_t002_008/c0_w1_br
+ u_t002_008/c0_r0_rbl u_t002_008/c0_r1_rbl u_t002_008/c1_w0_bl u_t002_008/c1_w0_br
+ u_t002_008/c1_w1_bl u_t002_008/c1_w1_br u_t002_008/c1_r0_rbl u_t002_008/c1_r1_rbl
+ u_t002_008/c2_w0_bl u_t002_008/c2_w0_br u_t002_008/c2_w1_bl u_t002_008/c2_w1_br
+ u_t002_008/c2_r0_rbl u_t002_008/c2_r1_rbl u_t002_008/c3_w0_bl u_t002_008/c3_w0_br
+ u_t002_008/c3_w1_bl u_t002_008/c3_w1_br u_t002_008/c3_r0_rbl u_t002_008/c3_r1_rbl
+ u_t002_008/r0_w0_wl u_t002_008/r0_w1_wl u_t002_008/r0_r0_rwl u_t002_008/r0_r1_rwl
+ u_t002_008/r1_w0_wl u_t002_008/r1_w1_wl u_t002_008/r1_r0_rwl u_t002_008/r1_r1_rwl
+ u_t002_008/r2_w0_wl u_t002_008/r2_w1_wl u_t002_008/r2_r0_rwl u_t002_008/r2_r1_rwl
+ u_t002_008/r3_w0_wl u_t002_008/r3_w1_wl u_t002_008/r3_r0_rwl u_t002_008/r3_r1_rwl
+ VSS VSS u_t002_008/m2_717_1265# u_t002_008/m2_603_2031# u_t002_008/m2_1290_336#
+ u_t002_008/m2_2000_2037# u_t002_008/m2_791_2909# u_t002_008/m2_7_2126# u_t002_008/m2_2154_2081#
+ u_t002_008/m2_1795_2037# u_t002_008/m2_871_303# u_t002_008/m2_431_438# u_t002_008/m2_1290_2898#
+ u_t002_008/m2_1714_1210# u_t002_008/m2_431_1982# u_t002_008/m2_512_1265# u_t002_008/m2_2573_2126#
+ u_t002_008/m2_603_1259# u_t002_008/m2_2074_2909# u_t002_008/m2_7_336# u_t002_008/m2_717_2037#
+ u_t002_008/m2_1886_2031# u_t002_008/m2_2573_336# u_t002_008/m2_7_2898# u_t002_008/m2_2000_1265#
+ u_t002_008/m2_512_2037# u_t002_008/m2_1795_1265# u_t002_008/m2_1714_1982# u_t002_008/m2_1886_1259#
+ u_t002_008/m2_1290_2126# u_t002_008/m2_1714_438# u_t002_008/m2_431_1210# u_t002_008/m2_2573_2898#
+ u_t002_008/m2_2154_303# u_t002_008/m2_871_2081# VSUBS detronyx_12t_2w2r_rc4_4x4_routed_5layer_direct
Xgf180mcu_as_sc_mcu7t3v3__inv_2_1209 gf180mcu_as_sc_mcu7t3v3__nor2_2_9/VDD gf180mcu_as_sc_mcu7t3v3__nor2_2_9/VSS
+ VSS VSS gf180mcu_as_sc_mcu7t3v3__nor2_2_9/VNW VSUBS gf180mcu_as_sc_mcu7t3v3__inv_2
Xgf180mcu_as_sc_mcu7t3v3__inv_2_1710 gf180mcu_as_sc_mcu7t3v3__nor2_2_7/VDD gf180mcu_as_sc_mcu7t3v3__nor2_2_7/VSS
+ VSS VSS gf180mcu_as_sc_mcu7t3v3__nor2_2_7/VNW VSUBS gf180mcu_as_sc_mcu7t3v3__inv_2
Xgf180mcu_as_sc_mcu7t3v3__inv_2_1721 VSS VSS VSS gf180mcu_as_sc_mcu7t3v3__inv_2_1722/Y
+ gf180mcu_as_sc_mcu7t3v3__inv_2_1723/VNW VSUBS gf180mcu_as_sc_mcu7t3v3__inv_2
Xgf180mcu_as_sc_mcu7t3v3__nand4_2_504 VSS VSS VSS VSS VSS VSS gf180mcu_as_sc_mcu7t3v3__inv_2_1681/A
+ gf180mcu_as_sc_mcu7t3v3__inv_2_1681/VNW VSUBS gf180mcu_as_sc_mcu7t3v3__nand4_2
Xgf180mcu_as_sc_mcu7t3v3__inv_2_36 VSS VSS gf180mcu_as_sc_mcu7t3v3__inv_2_36/Y gf180mcu_as_sc_mcu7t3v3__inv_2_36/A
+ gf180mcu_as_sc_mcu7t3v3__inv_2_36/VNW VSUBS gf180mcu_as_sc_mcu7t3v3__inv_2
Xgf180mcu_as_sc_mcu7t3v3__inv_2_14 VSS VSS VSS gf180mcu_as_sc_mcu7t3v3__inv_2_15/Y
+ gf180mcu_as_sc_mcu7t3v3__inv_2_16/VNW VSUBS gf180mcu_as_sc_mcu7t3v3__inv_2
Xgf180mcu_as_sc_mcu7t3v3__inv_2_47 VSS VSS VSS gf180mcu_as_sc_mcu7t3v3__inv_2_48/Y
+ gf180mcu_as_sc_mcu7t3v3__inv_2_49/VNW VSUBS gf180mcu_as_sc_mcu7t3v3__inv_2
Xgf180mcu_as_sc_mcu7t3v3__inv_2_58 VSS VSS gf180mcu_as_sc_mcu7t3v3__inv_2_58/Y gf180mcu_as_sc_mcu7t3v3__inv_2_62/Y
+ gf180mcu_as_sc_mcu7t3v3__inv_2_62/VNW VSUBS gf180mcu_as_sc_mcu7t3v3__inv_2
Xgf180mcu_as_sc_mcu7t3v3__inv_2_25 VSS VSS gf180mcu_as_sc_mcu7t3v3__inv_2_25/Y gf180mcu_as_sc_mcu7t3v3__inv_2_25/A
+ gf180mcu_as_sc_mcu7t3v3__inv_2_25/VNW VSUBS gf180mcu_as_sc_mcu7t3v3__inv_2
Xgf180mcu_as_sc_mcu7t3v3__inv_2_69 VSS VSS gf180mcu_as_sc_mcu7t3v3__inv_2_69/Y gf180mcu_as_sc_mcu7t3v3__inv_2_69/A
+ gf180mcu_as_sc_mcu7t3v3__inv_2_69/VNW VSUBS gf180mcu_as_sc_mcu7t3v3__inv_2
Xgf180mcu_as_sc_mcu7t3v3__inv_2_1006 VSS VSS VSS gf180mcu_as_sc_mcu7t3v3__inv_2_1007/Y
+ gf180mcu_as_sc_mcu7t3v3__inv_2_960/VNW VSUBS gf180mcu_as_sc_mcu7t3v3__inv_2
Xgf180mcu_as_sc_mcu7t3v3__inv_2_1017 VSS VSS gf180mcu_as_sc_mcu7t3v3__inv_2_1057/A
+ gf180mcu_as_sc_mcu7t3v3__inv_2_1021/Y gf180mcu_as_sc_mcu7t3v3__inv_2_1057/VNW VSUBS
+ gf180mcu_as_sc_mcu7t3v3__inv_2
Xgf180mcu_as_sc_mcu7t3v3__inv_2_1028 VSS VSS gf180mcu_as_sc_mcu7t3v3__inv_2_1028/Y
+ gf180mcu_as_sc_mcu7t3v3__inv_2_1028/A gf180mcu_as_sc_mcu7t3v3__inv_2_1028/VNW VSUBS
+ gf180mcu_as_sc_mcu7t3v3__inv_2
Xgf180mcu_as_sc_mcu7t3v3__inv_2_1039 VSS VSS gf180mcu_as_sc_mcu7t3v3__inv_2_1039/Y
+ gf180mcu_as_sc_mcu7t3v3__inv_2_1040/Y gf180mcu_as_sc_mcu7t3v3__inv_2_1040/VNW VSUBS
+ gf180mcu_as_sc_mcu7t3v3__inv_2
Xgf180mcu_as_sc_mcu7t3v3__inv_2_1551 VSS VSS VSS gf180mcu_as_sc_mcu7t3v3__inv_2_1552/Y
+ gf180mcu_as_sc_mcu7t3v3__inv_2_1553/VNW VSUBS gf180mcu_as_sc_mcu7t3v3__inv_2
Xgf180mcu_as_sc_mcu7t3v3__inv_2_1562 VSS VSS gf180mcu_as_sc_mcu7t3v3__inv_2_1562/Y
+ gf180mcu_as_sc_mcu7t3v3__inv_2_1562/A gf180mcu_as_sc_mcu7t3v3__inv_2_1562/VNW VSUBS
+ gf180mcu_as_sc_mcu7t3v3__inv_2
Xgf180mcu_as_sc_mcu7t3v3__inv_2_1540 VSS VSS gf180mcu_as_sc_mcu7t3v3__inv_2_1540/Y
+ gf180mcu_as_sc_mcu7t3v3__inv_2_1541/Y gf180mcu_as_sc_mcu7t3v3__inv_2_1541/VNW VSUBS
+ gf180mcu_as_sc_mcu7t3v3__inv_2
Xgf180mcu_as_sc_mcu7t3v3__inv_2_1595 VSS VSS VSS gf180mcu_as_sc_mcu7t3v3__inv_2_1596/Y
+ gf180mcu_as_sc_mcu7t3v3__inv_2_1597/VNW VSUBS gf180mcu_as_sc_mcu7t3v3__inv_2
Xgf180mcu_as_sc_mcu7t3v3__inv_2_1573 VSS VSS gf180mcu_as_sc_mcu7t3v3__inv_2_1573/Y
+ gf180mcu_as_sc_mcu7t3v3__inv_2_1573/A gf180mcu_as_sc_mcu7t3v3__inv_2_1573/VNW VSUBS
+ gf180mcu_as_sc_mcu7t3v3__inv_2
Xgf180mcu_as_sc_mcu7t3v3__inv_2_1584 VSS VSS gf180mcu_as_sc_mcu7t3v3__inv_2_1584/Y
+ gf180mcu_as_sc_mcu7t3v3__inv_2_1585/Y gf180mcu_as_sc_mcu7t3v3__inv_2_1585/VNW VSUBS
+ gf180mcu_as_sc_mcu7t3v3__inv_2
Xgf180mcu_as_sc_mcu7t3v3__nand3_2_6 gf180mcu_as_sc_mcu7t3v3__nand3_2_9/VDD gf180mcu_as_sc_mcu7t3v3__nor2_2_7/VSS
+ VSS VSS VSS VSS gf180mcu_as_sc_mcu7t3v3__nand3_2_9/VNW VSUBS gf180mcu_as_sc_mcu7t3v3__nand3_2
Xgf180mcu_as_sc_mcu7t3v3__nand4_2_367 VSS VSS VSS VSS VSS VSS gf180mcu_as_sc_mcu7t3v3__inv_2_1188/A
+ gf180mcu_as_sc_mcu7t3v3__inv_2_1279/VNW VSUBS gf180mcu_as_sc_mcu7t3v3__nand4_2
Xgf180mcu_as_sc_mcu7t3v3__nand4_2_334 VSS VSS VSS VSS VSS VSS gf180mcu_as_sc_mcu7t3v3__inv_2_1068/A
+ gf180mcu_as_sc_mcu7t3v3__inv_2_1100/VNW VSUBS gf180mcu_as_sc_mcu7t3v3__nand4_2
Xgf180mcu_as_sc_mcu7t3v3__nand4_2_345 VSS VSS VSS VSS VSS VSS gf180mcu_as_sc_mcu7t3v3__inv_2_1124/A
+ gf180mcu_as_sc_mcu7t3v3__inv_2_1124/VNW VSUBS gf180mcu_as_sc_mcu7t3v3__nand4_2
Xgf180mcu_as_sc_mcu7t3v3__nand4_2_323 VSS VSS VSS VSS VSS VSS gf180mcu_as_sc_mcu7t3v3__inv_2_1087/A
+ gf180mcu_as_sc_mcu7t3v3__inv_2_1087/VNW VSUBS gf180mcu_as_sc_mcu7t3v3__nand4_2
Xgf180mcu_as_sc_mcu7t3v3__nand4_2_356 VSS VSS VSS VSS VSS VSS gf180mcu_as_sc_mcu7t3v3__inv_2_1171/A
+ gf180mcu_as_sc_mcu7t3v3__inv_2_1271/VNW VSUBS gf180mcu_as_sc_mcu7t3v3__nand4_2
Xgf180mcu_as_sc_mcu7t3v3__nand4_2_378 VSS VSS VSS VSS VSS VSS gf180mcu_as_sc_mcu7t3v3__inv_2_1304/A
+ gf180mcu_as_sc_mcu7t3v3__inv_2_1304/VNW VSUBS gf180mcu_as_sc_mcu7t3v3__nand4_2
Xgf180mcu_as_sc_mcu7t3v3__nand4_2_312 VSS VSS VSS VSS VSS VSS gf180mcu_as_sc_mcu7t3v3__inv_2_1028/A
+ gf180mcu_as_sc_mcu7t3v3__inv_2_1028/VNW VSUBS gf180mcu_as_sc_mcu7t3v3__nand4_2
Xgf180mcu_as_sc_mcu7t3v3__nand4_2_301 VSS VSS VSS VSS VSS VSS gf180mcu_as_sc_mcu7t3v3__inv_2_1001/A
+ gf180mcu_as_sc_mcu7t3v3__inv_2_997/VNW VSUBS gf180mcu_as_sc_mcu7t3v3__nand4_2
Xgf180mcu_as_sc_mcu7t3v3__nand4_2_389 VSS VSS VSS VSS VSS VSS gf180mcu_as_sc_mcu7t3v3__inv_2_1437/A
+ gf180mcu_as_sc_mcu7t3v3__inv_2_1437/VNW VSUBS gf180mcu_as_sc_mcu7t3v3__nand4_2
Xu_t029_011 u_t029_011/c0_w0_bl u_t029_011/c0_w0_br u_t029_011/c0_w1_bl u_t029_011/c0_w1_br
+ u_t029_011/c0_r0_rbl u_t029_011/c0_r1_rbl u_t029_011/c1_w0_bl u_t029_011/c1_w0_br
+ u_t029_011/c1_w1_bl u_t029_011/c1_w1_br u_t029_011/c1_r0_rbl u_t029_011/c1_r1_rbl
+ u_t029_011/c2_w0_bl u_t029_011/c2_w0_br u_t029_011/c2_w1_bl u_t029_011/c2_w1_br
+ u_t029_011/c2_r0_rbl u_t029_011/c2_r1_rbl u_t029_011/c3_w0_bl u_t029_011/c3_w0_br
+ u_t029_011/c3_w1_bl u_t029_011/c3_w1_br u_t029_011/c3_r0_rbl u_t029_011/c3_r1_rbl
+ u_t029_011/r0_w0_wl u_t029_011/r0_w1_wl u_t029_011/r0_r0_rwl u_t029_011/r0_r1_rwl
+ u_t029_011/r1_w0_wl u_t029_011/r1_w1_wl u_t029_011/r1_r0_rwl u_t029_011/r1_r1_rwl
+ u_t029_011/r2_w0_wl u_t029_011/r2_w1_wl u_t029_011/r2_r0_rwl u_t029_011/r2_r1_rwl
+ u_t029_011/r3_w0_wl u_t029_011/r3_w1_wl u_t029_011/r3_r0_rwl u_t029_011/r3_r1_rwl
+ VSS VSS u_t029_011/m2_717_1265# u_t029_011/m2_603_2031# u_t029_011/m2_1290_336#
+ u_t029_011/m2_2000_2037# u_t029_011/m2_791_2909# u_t029_011/m2_7_2126# u_t029_011/m2_2154_2081#
+ u_t029_011/m2_1795_2037# u_t029_011/m2_871_303# u_t029_011/m2_431_438# u_t029_011/m2_1290_2898#
+ u_t029_011/m2_1714_1210# u_t029_011/m2_431_1982# u_t029_011/m2_512_1265# u_t029_011/m2_2573_2126#
+ u_t029_011/m2_603_1259# u_t029_011/m2_2074_2909# u_t029_011/m2_7_336# u_t029_011/m2_717_2037#
+ u_t029_011/m2_1886_2031# u_t029_011/m2_2573_336# u_t029_011/m2_7_2898# u_t029_011/m2_2000_1265#
+ u_t029_011/m2_512_2037# u_t029_011/m2_1795_1265# u_t029_011/m2_1714_1982# u_t029_011/m2_1886_1259#
+ u_t029_011/m2_1290_2126# u_t029_011/m2_1714_438# u_t029_011/m2_431_1210# u_t029_011/m2_2573_2898#
+ u_t029_011/m2_2154_303# u_t029_011/m2_871_2081# VSUBS detronyx_12t_2w2r_rc4_4x4_routed_5layer_direct
Xu_t029_000 VSS u_t029_000/c0_w0_br VSS u_t029_000/c0_w1_br u_t029_000/c0_r0_rbl u_t029_000/c0_r1_rbl
+ VSS VSS VSS VSS VSS VSS u_t029_000/c2_w0_bl u_t029_000/c2_w0_br u_t029_000/c2_w1_bl
+ u_t029_000/c2_w1_br u_t029_000/c2_r0_rbl u_t029_000/c2_r1_rbl u_t029_000/c3_w0_bl
+ u_t029_000/c3_w0_br u_t029_000/c3_w1_bl u_t029_000/c3_w1_br u_t029_000/c3_r0_rbl
+ u_t029_000/c3_r1_rbl VSS VSS VSS VSS VSS VSS VSS VSS VSS VSS VSS VSS VSS VSS VSS
+ VSS VSS VSS u_t029_000/m2_717_1265# VSS VSS VSS VSS u_t029_000/m2_7_2126# VSS VSS
+ VSS VSS VSS VSS VSS u_t029_000/m2_512_1265# VSS u_t029_000/m2_603_1259# VSS VSS
+ VSS VSS VSS VSS u_t029_000/m2_2000_1265# VSS u_t029_000/m2_1795_1265# VSS u_t029_000/m2_1886_1259#
+ u_t029_000/m2_1290_2126# VSS VSS VSS VSS VSS VSUBS detronyx_12t_2w2r_rc4_4x4_routed_5layer_direct
Xgf180mcu_as_sc_mcu7t3v3__inv_2_309 VSS VSS VSS gf180mcu_as_sc_mcu7t3v3__inv_2_310/Y
+ gf180mcu_as_sc_mcu7t3v3__inv_2_311/VNW VSUBS gf180mcu_as_sc_mcu7t3v3__inv_2
Xgf180mcu_as_sc_mcu7t3v3__inv_2_1370 VSS VSS gf180mcu_as_sc_mcu7t3v3__inv_2_1370/Y
+ gf180mcu_as_sc_mcu7t3v3__inv_2_1370/A gf180mcu_as_sc_mcu7t3v3__inv_2_1370/VNW VSUBS
+ gf180mcu_as_sc_mcu7t3v3__inv_2
Xgf180mcu_as_sc_mcu7t3v3__inv_2_1381 VSS VSS gf180mcu_as_sc_mcu7t3v3__inv_2_1381/Y
+ gf180mcu_as_sc_mcu7t3v3__inv_2_1382/Y gf180mcu_as_sc_mcu7t3v3__inv_2_1382/VNW VSUBS
+ gf180mcu_as_sc_mcu7t3v3__inv_2
Xgf180mcu_as_sc_mcu7t3v3__inv_2_1392 VSS VSS VSS gf180mcu_as_sc_mcu7t3v3__inv_2_1393/Y
+ gf180mcu_as_sc_mcu7t3v3__inv_2_1394/VNW VSUBS gf180mcu_as_sc_mcu7t3v3__inv_2
Xgf180mcu_as_sc_mcu7t3v3__inv_2_854 VSS VSS gf180mcu_as_sc_mcu7t3v3__inv_2_854/Y gf180mcu_as_sc_mcu7t3v3__inv_2_854/A
+ gf180mcu_as_sc_mcu7t3v3__inv_2_854/VNW VSUBS gf180mcu_as_sc_mcu7t3v3__inv_2
Xgf180mcu_as_sc_mcu7t3v3__inv_2_821 VSS VSS VSS gf180mcu_as_sc_mcu7t3v3__inv_2_821/A
+ gf180mcu_as_sc_mcu7t3v3__inv_2_821/VNW VSUBS gf180mcu_as_sc_mcu7t3v3__inv_2
Xgf180mcu_as_sc_mcu7t3v3__inv_2_832 VSS VSS VSS gf180mcu_as_sc_mcu7t3v3__inv_2_832/A
+ gf180mcu_as_sc_mcu7t3v3__inv_2_832/VNW VSUBS gf180mcu_as_sc_mcu7t3v3__inv_2
Xgf180mcu_as_sc_mcu7t3v3__inv_2_810 VSS VSS gf180mcu_as_sc_mcu7t3v3__inv_2_810/Y gf180mcu_as_sc_mcu7t3v3__inv_2_810/A
+ gf180mcu_as_sc_mcu7t3v3__inv_2_848/VNW VSUBS gf180mcu_as_sc_mcu7t3v3__inv_2
Xgf180mcu_as_sc_mcu7t3v3__inv_2_843 VSS VSS VSS gf180mcu_as_sc_mcu7t3v3__inv_2_843/A
+ gf180mcu_as_sc_mcu7t3v3__inv_2_843/VNW VSUBS gf180mcu_as_sc_mcu7t3v3__inv_2
Xgf180mcu_as_sc_mcu7t3v3__inv_2_898 VSS VSS gf180mcu_as_sc_mcu7t3v3__inv_2_927/A gf180mcu_as_sc_mcu7t3v3__inv_2_899/Y
+ gf180mcu_as_sc_mcu7t3v3__inv_2_927/VNW VSUBS gf180mcu_as_sc_mcu7t3v3__inv_2
Xgf180mcu_as_sc_mcu7t3v3__inv_2_865 VSS VSS gf180mcu_as_sc_mcu7t3v3__inv_2_939/A gf180mcu_as_sc_mcu7t3v3__inv_2_866/Y
+ gf180mcu_as_sc_mcu7t3v3__inv_2_939/VNW VSUBS gf180mcu_as_sc_mcu7t3v3__inv_2
Xgf180mcu_as_sc_mcu7t3v3__inv_2_887 VSS VSS gf180mcu_as_sc_mcu7t3v3__inv_2_887/Y gf180mcu_as_sc_mcu7t3v3__inv_2_887/A
+ gf180mcu_as_sc_mcu7t3v3__inv_2_935/VNW VSUBS gf180mcu_as_sc_mcu7t3v3__inv_2
Xgf180mcu_as_sc_mcu7t3v3__inv_2_876 VSS VSS gf180mcu_as_sc_mcu7t3v3__inv_2_876/Y gf180mcu_as_sc_mcu7t3v3__inv_2_876/A
+ gf180mcu_as_sc_mcu7t3v3__inv_2_931/VNW VSUBS gf180mcu_as_sc_mcu7t3v3__inv_2
Xu_t026_014 u_t026_014/c0_w0_bl u_t026_014/c0_w0_br u_t026_014/c0_w1_bl u_t026_014/c0_w1_br
+ u_t026_014/c0_r0_rbl u_t026_014/c0_r1_rbl u_t026_014/c1_w0_bl u_t026_014/c1_w0_br
+ u_t026_014/c1_w1_bl u_t026_014/c1_w1_br u_t026_014/c1_r0_rbl u_t026_014/c1_r1_rbl
+ u_t026_014/c2_w0_bl u_t026_014/c2_w0_br u_t026_014/c2_w1_bl u_t026_014/c2_w1_br
+ u_t026_014/c2_r0_rbl u_t026_014/c2_r1_rbl u_t026_014/c3_w0_bl u_t026_014/c3_w0_br
+ u_t026_014/c3_w1_bl u_t026_014/c3_w1_br u_t026_014/c3_r0_rbl u_t026_014/c3_r1_rbl
+ u_t026_014/r0_w0_wl u_t026_014/r0_w1_wl u_t026_014/r0_r0_rwl u_t026_014/r0_r1_rwl
+ u_t026_014/r1_w0_wl u_t026_014/r1_w1_wl u_t026_014/r1_r0_rwl u_t026_014/r1_r1_rwl
+ u_t026_014/r2_w0_wl u_t026_014/r2_w1_wl u_t026_014/r2_r0_rwl u_t026_014/r2_r1_rwl
+ u_t026_014/r3_w0_wl u_t026_014/r3_w1_wl u_t026_014/r3_r0_rwl u_t026_014/r3_r1_rwl
+ VSS VSS u_t026_014/m2_717_1265# u_t026_014/m2_603_2031# u_t026_014/m2_1290_336#
+ u_t026_014/m2_2000_2037# u_t026_014/m2_791_2909# u_t026_014/m2_7_2126# u_t026_014/m2_2154_2081#
+ u_t026_014/m2_1795_2037# u_t026_014/m2_871_303# u_t026_014/m2_431_438# u_t026_014/m2_1290_2898#
+ u_t026_014/m2_1714_1210# u_t026_014/m2_431_1982# u_t026_014/m2_512_1265# u_t026_014/m2_2573_2126#
+ u_t026_014/m2_603_1259# u_t026_014/m2_2074_2909# u_t026_014/m2_7_336# u_t026_014/m2_717_2037#
+ u_t026_014/m2_1886_2031# u_t026_014/m2_2573_336# u_t026_014/m2_7_2898# u_t026_014/m2_2000_1265#
+ u_t026_014/m2_512_2037# u_t026_014/m2_1795_1265# u_t026_014/m2_1714_1982# u_t026_014/m2_1886_1259#
+ u_t026_014/m2_1290_2126# u_t026_014/m2_1714_438# u_t026_014/m2_431_1210# u_t026_014/m2_2573_2898#
+ u_t026_014/m2_2154_303# u_t026_014/m2_871_2081# VSUBS detronyx_12t_2w2r_rc4_4x4_routed_5layer_direct
Xu_t026_003 u_t026_003/c0_w0_bl u_t026_003/c0_w0_br u_t026_003/c0_w1_bl u_t026_003/c0_w1_br
+ u_t026_003/c0_r0_rbl u_t026_003/c0_r1_rbl u_t026_003/c1_w0_bl u_t026_003/c1_w0_br
+ u_t026_003/c1_w1_bl u_t026_003/c1_w1_br u_t026_003/c1_r0_rbl u_t026_003/c1_r1_rbl
+ u_t026_003/c2_w0_bl u_t026_003/c2_w0_br u_t026_003/c2_w1_bl u_t026_003/c2_w1_br
+ u_t026_003/c2_r0_rbl u_t026_003/c2_r1_rbl u_t026_003/c3_w0_bl u_t026_003/c3_w0_br
+ u_t026_003/c3_w1_bl u_t026_003/c3_w1_br u_t026_003/c3_r0_rbl u_t026_003/c3_r1_rbl
+ u_t026_003/r0_w0_wl u_t026_003/r0_w1_wl u_t026_003/r0_r0_rwl u_t026_003/r0_r1_rwl
+ u_t026_003/r1_w0_wl u_t026_003/r1_w1_wl u_t026_003/r1_r0_rwl u_t026_003/r1_r1_rwl
+ u_t026_003/r2_w0_wl u_t026_003/r2_w1_wl u_t026_003/r2_r0_rwl u_t026_003/r2_r1_rwl
+ u_t026_003/r3_w0_wl u_t026_003/r3_w1_wl u_t026_003/r3_r0_rwl u_t026_003/r3_r1_rwl
+ VSS VSS u_t026_003/m2_717_1265# u_t026_003/m2_603_2031# u_t026_003/m2_1290_336#
+ u_t026_003/m2_2000_2037# u_t026_003/m2_791_2909# u_t026_003/m2_7_2126# u_t026_003/m2_2154_2081#
+ u_t026_003/m2_1795_2037# u_t026_003/m2_871_303# u_t026_003/m2_431_438# u_t026_003/m2_1290_2898#
+ u_t026_003/m2_1714_1210# u_t026_003/m2_431_1982# u_t026_003/m2_512_1265# u_t026_003/m2_2573_2126#
+ u_t026_003/m2_603_1259# u_t026_003/m2_2074_2909# u_t026_003/m2_7_336# u_t026_003/m2_717_2037#
+ u_t026_003/m2_1886_2031# u_t026_003/m2_2573_336# u_t026_003/m2_7_2898# u_t026_003/m2_2000_1265#
+ u_t026_003/m2_512_2037# u_t026_003/m2_1795_1265# u_t026_003/m2_1714_1982# u_t026_003/m2_1886_1259#
+ u_t026_003/m2_1290_2126# u_t026_003/m2_1714_438# u_t026_003/m2_431_1210# u_t026_003/m2_2573_2898#
+ u_t026_003/m2_2154_303# u_t026_003/m2_871_2081# VSUBS detronyx_12t_2w2r_rc4_4x4_routed_5layer_direct
Xgf180mcu_as_sc_mcu7t3v3__nand4_2_153 VSS VSS VSS VSS VSS VSS gf180mcu_as_sc_mcu7t3v3__inv_2_580/A
+ gf180mcu_as_sc_mcu7t3v3__inv_2_585/VNW VSUBS gf180mcu_as_sc_mcu7t3v3__nand4_2
Xgf180mcu_as_sc_mcu7t3v3__nand4_2_175 VSS VSS VSS VSS VSS VSS gf180mcu_as_sc_mcu7t3v3__inv_2_592/A
+ gf180mcu_as_sc_mcu7t3v3__inv_2_607/VNW VSUBS gf180mcu_as_sc_mcu7t3v3__nand4_2
Xgf180mcu_as_sc_mcu7t3v3__nand4_2_131 VSS VSS VSS VSS VSS VSS gf180mcu_as_sc_mcu7t3v3__inv_2_459/A
+ gf180mcu_as_sc_mcu7t3v3__inv_2_544/VNW VSUBS gf180mcu_as_sc_mcu7t3v3__nand4_2
Xgf180mcu_as_sc_mcu7t3v3__nand4_2_164 VSS VSS VSS VSS VSS VSS gf180mcu_as_sc_mcu7t3v3__inv_2_624/A
+ gf180mcu_as_sc_mcu7t3v3__inv_2_624/VNW VSUBS gf180mcu_as_sc_mcu7t3v3__nand4_2
Xgf180mcu_as_sc_mcu7t3v3__nand4_2_142 VSS VSS VSS VSS VSS VSS gf180mcu_as_sc_mcu7t3v3__inv_2_507/A
+ gf180mcu_as_sc_mcu7t3v3__inv_2_538/VNW VSUBS gf180mcu_as_sc_mcu7t3v3__nand4_2
Xgf180mcu_as_sc_mcu7t3v3__nand4_2_120 VSS VSS VSS VSS VSS VSS gf180mcu_as_sc_mcu7t3v3__inv_2_301/A
+ gf180mcu_as_sc_mcu7t3v3__inv_2_301/VNW VSUBS gf180mcu_as_sc_mcu7t3v3__nand4_2
Xgf180mcu_as_sc_mcu7t3v3__nand4_2_186 VSS VSS VSS VSS VSS VSS gf180mcu_as_sc_mcu7t3v3__inv_2_716/A
+ gf180mcu_as_sc_mcu7t3v3__inv_2_716/VNW VSUBS gf180mcu_as_sc_mcu7t3v3__nand4_2
Xgf180mcu_as_sc_mcu7t3v3__nand4_2_197 VSS VSS VSS VSS VSS VSS gf180mcu_as_sc_mcu7t3v3__inv_2_705/A
+ gf180mcu_as_sc_mcu7t3v3__inv_2_741/VNW VSUBS gf180mcu_as_sc_mcu7t3v3__nand4_2
Xgf180mcu_as_sc_mcu7t3v3__nand4_2_92 VSS VSS VSS VSS VSS VSS gf180mcu_as_sc_mcu7t3v3__inv_2_62/A
+ gf180mcu_as_sc_mcu7t3v3__inv_2_62/VNW VSUBS gf180mcu_as_sc_mcu7t3v3__nand4_2
Xgf180mcu_as_sc_mcu7t3v3__nand4_2_81 VSS VSS VSS VSS VSS VSS gf180mcu_as_sc_mcu7t3v3__inv_2_57/A
+ gf180mcu_as_sc_mcu7t3v3__inv_2_57/VNW VSUBS gf180mcu_as_sc_mcu7t3v3__nand4_2
Xgf180mcu_as_sc_mcu7t3v3__nand4_2_70 VSS VSS VSS VSS VSS VSS gf180mcu_as_sc_mcu7t3v3__inv_2_314/A
+ gf180mcu_as_sc_mcu7t3v3__inv_2_314/VNW VSUBS gf180mcu_as_sc_mcu7t3v3__nand4_2
Xu_t017_014 u_t017_014/c0_w0_bl u_t017_014/c0_w0_br u_t017_014/c0_w1_bl u_t017_014/c0_w1_br
+ u_t017_014/c0_r0_rbl u_t017_014/c0_r1_rbl u_t017_014/c1_w0_bl u_t017_014/c1_w0_br
+ u_t017_014/c1_w1_bl u_t017_014/c1_w1_br u_t017_014/c1_r0_rbl u_t017_014/c1_r1_rbl
+ u_t017_014/c2_w0_bl u_t017_014/c2_w0_br u_t017_014/c2_w1_bl u_t017_014/c2_w1_br
+ u_t017_014/c2_r0_rbl u_t017_014/c2_r1_rbl u_t017_014/c3_w0_bl u_t017_014/c3_w0_br
+ u_t017_014/c3_w1_bl u_t017_014/c3_w1_br u_t017_014/c3_r0_rbl u_t017_014/c3_r1_rbl
+ u_t017_014/r0_w0_wl u_t017_014/r0_w1_wl u_t017_014/r0_r0_rwl u_t017_014/r0_r1_rwl
+ u_t017_014/r1_w0_wl u_t017_014/r1_w1_wl u_t017_014/r1_r0_rwl u_t017_014/r1_r1_rwl
+ u_t017_014/r2_w0_wl u_t017_014/r2_w1_wl u_t017_014/r2_r0_rwl u_t017_014/r2_r1_rwl
+ u_t017_014/r3_w0_wl u_t017_014/r3_w1_wl u_t017_014/r3_r0_rwl u_t017_014/r3_r1_rwl
+ VSS VSS u_t017_014/m2_717_1265# u_t017_014/m2_603_2031# u_t017_014/m2_1290_336#
+ u_t017_014/m2_2000_2037# u_t017_014/m2_791_2909# u_t017_014/m2_7_2126# u_t017_014/m2_2154_2081#
+ u_t017_014/m2_1795_2037# u_t017_014/m2_871_303# u_t017_014/m2_431_438# u_t017_014/m2_1290_2898#
+ u_t017_014/m2_1714_1210# u_t017_014/m2_431_1982# u_t017_014/m2_512_1265# u_t017_014/m2_2573_2126#
+ u_t017_014/m2_603_1259# u_t017_014/m2_2074_2909# u_t017_014/m2_7_336# u_t017_014/m2_717_2037#
+ u_t017_014/m2_1886_2031# u_t017_014/m2_2573_336# u_t017_014/m2_7_2898# u_t017_014/m2_2000_1265#
+ u_t017_014/m2_512_2037# u_t017_014/m2_1795_1265# u_t017_014/m2_1714_1982# u_t017_014/m2_1886_1259#
+ u_t017_014/m2_1290_2126# u_t017_014/m2_1714_438# u_t017_014/m2_431_1210# u_t017_014/m2_2573_2898#
+ u_t017_014/m2_2154_303# u_t017_014/m2_871_2081# VSUBS detronyx_12t_2w2r_rc4_4x4_routed_5layer_direct
Xu_t017_003 u_t017_003/c0_w0_bl u_t017_003/c0_w0_br u_t017_003/c0_w1_bl u_t017_003/c0_w1_br
+ u_t017_003/c0_r0_rbl u_t017_003/c0_r1_rbl u_t017_003/c1_w0_bl u_t017_003/c1_w0_br
+ u_t017_003/c1_w1_bl u_t017_003/c1_w1_br u_t017_003/c1_r0_rbl u_t017_003/c1_r1_rbl
+ u_t017_003/c2_w0_bl u_t017_003/c2_w0_br u_t017_003/c2_w1_bl u_t017_003/c2_w1_br
+ u_t017_003/c2_r0_rbl u_t017_003/c2_r1_rbl u_t017_003/c3_w0_bl u_t017_003/c3_w0_br
+ u_t017_003/c3_w1_bl u_t017_003/c3_w1_br u_t017_003/c3_r0_rbl u_t017_003/c3_r1_rbl
+ u_t017_003/r0_w0_wl u_t017_003/r0_w1_wl u_t017_003/r0_r0_rwl u_t017_003/r0_r1_rwl
+ u_t017_003/r1_w0_wl u_t017_003/r1_w1_wl u_t017_003/r1_r0_rwl u_t017_003/r1_r1_rwl
+ u_t017_003/r2_w0_wl u_t017_003/r2_w1_wl u_t017_003/r2_r0_rwl u_t017_003/r2_r1_rwl
+ u_t017_003/r3_w0_wl u_t017_003/r3_w1_wl u_t017_003/r3_r0_rwl u_t017_003/r3_r1_rwl
+ VSS VSS u_t017_003/m2_717_1265# u_t017_003/m2_603_2031# u_t017_003/m2_1290_336#
+ u_t017_003/m2_2000_2037# u_t017_003/m2_791_2909# u_t017_003/m2_7_2126# u_t017_003/m2_2154_2081#
+ u_t017_003/m2_1795_2037# u_t017_003/m2_871_303# u_t017_003/m2_431_438# u_t017_003/m2_1290_2898#
+ u_t017_003/m2_1714_1210# u_t017_003/m2_431_1982# u_t017_003/m2_512_1265# u_t017_003/m2_2573_2126#
+ u_t017_003/m2_603_1259# u_t017_003/m2_2074_2909# u_t017_003/m2_7_336# u_t017_003/m2_717_2037#
+ u_t017_003/m2_1886_2031# u_t017_003/m2_2573_336# u_t017_003/m2_7_2898# u_t017_003/m2_2000_1265#
+ u_t017_003/m2_512_2037# u_t017_003/m2_1795_1265# u_t017_003/m2_1714_1982# u_t017_003/m2_1886_1259#
+ u_t017_003/m2_1290_2126# u_t017_003/m2_1714_438# u_t017_003/m2_431_1210# u_t017_003/m2_2573_2898#
+ u_t017_003/m2_2154_303# u_t017_003/m2_871_2081# VSUBS detronyx_12t_2w2r_rc4_4x4_routed_5layer_direct
Xgf180mcu_as_sc_mcu7t3v3__inv_2_106 VSS VSS gf180mcu_as_sc_mcu7t3v3__inv_2_106/Y gf180mcu_as_sc_mcu7t3v3__inv_2_107/Y
+ gf180mcu_as_sc_mcu7t3v3__nand4_2_9/VNW VSUBS gf180mcu_as_sc_mcu7t3v3__inv_2
Xgf180mcu_as_sc_mcu7t3v3__inv_2_139 VSS VSS gf180mcu_as_sc_mcu7t3v3__inv_2_139/Y gf180mcu_as_sc_mcu7t3v3__inv_2_140/Y
+ gf180mcu_as_sc_mcu7t3v3__inv_2_140/VNW VSUBS gf180mcu_as_sc_mcu7t3v3__inv_2
Xgf180mcu_as_sc_mcu7t3v3__inv_2_128 VSS VSS gf180mcu_as_sc_mcu7t3v3__inv_2_128/Y gf180mcu_as_sc_mcu7t3v3__inv_2_128/A
+ gf180mcu_as_sc_mcu7t3v3__inv_2_128/VNW VSUBS gf180mcu_as_sc_mcu7t3v3__inv_2
Xgf180mcu_as_sc_mcu7t3v3__inv_2_117 VSS VSS VSS gf180mcu_as_sc_mcu7t3v3__inv_2_118/Y
+ gf180mcu_as_sc_mcu7t3v3__inv_2_119/VNW VSUBS gf180mcu_as_sc_mcu7t3v3__inv_2
Xu_t008_003 u_t008_003/c0_w0_bl u_t008_003/c0_w0_br u_t008_003/c0_w1_bl u_t008_003/c0_w1_br
+ u_t008_003/c0_r0_rbl u_t008_003/c0_r1_rbl u_t008_003/c1_w0_bl u_t008_003/c1_w0_br
+ u_t008_003/c1_w1_bl u_t008_003/c1_w1_br u_t008_003/c1_r0_rbl u_t008_003/c1_r1_rbl
+ u_t008_003/c2_w0_bl u_t008_003/c2_w0_br u_t008_003/c2_w1_bl u_t008_003/c2_w1_br
+ u_t008_003/c2_r0_rbl u_t008_003/c2_r1_rbl u_t008_003/c3_w0_bl u_t008_003/c3_w0_br
+ u_t008_003/c3_w1_bl u_t008_003/c3_w1_br u_t008_003/c3_r0_rbl u_t008_003/c3_r1_rbl
+ u_t008_003/r0_w0_wl u_t008_003/r0_w1_wl u_t008_003/r0_r0_rwl u_t008_003/r0_r1_rwl
+ u_t008_003/r1_w0_wl u_t008_003/r1_w1_wl u_t008_003/r1_r0_rwl u_t008_003/r1_r1_rwl
+ u_t008_003/r2_w0_wl u_t008_003/r2_w1_wl u_t008_003/r2_r0_rwl u_t008_003/r2_r1_rwl
+ u_t008_003/r3_w0_wl u_t008_003/r3_w1_wl u_t008_003/r3_r0_rwl u_t008_003/r3_r1_rwl
+ VSS VSS u_t008_003/m2_717_1265# u_t008_003/m2_603_2031# u_t008_003/m2_1290_336#
+ u_t008_003/m2_2000_2037# u_t008_003/m2_791_2909# u_t008_003/m2_7_2126# u_t008_003/m2_2154_2081#
+ u_t008_003/m2_1795_2037# u_t008_003/m2_871_303# u_t008_003/m2_431_438# u_t008_003/m2_1290_2898#
+ u_t008_003/m2_1714_1210# u_t008_003/m2_431_1982# u_t008_003/m2_512_1265# u_t008_003/m2_2573_2126#
+ u_t008_003/m2_603_1259# u_t008_003/m2_2074_2909# u_t008_003/m2_7_336# u_t008_003/m2_717_2037#
+ u_t008_003/m2_1886_2031# u_t008_003/m2_2573_336# u_t008_003/m2_7_2898# u_t008_003/m2_2000_1265#
+ u_t008_003/m2_512_2037# u_t008_003/m2_1795_1265# u_t008_003/m2_1714_1982# u_t008_003/m2_1886_1259#
+ u_t008_003/m2_1290_2126# u_t008_003/m2_1714_438# u_t008_003/m2_431_1210# u_t008_003/m2_2573_2898#
+ u_t008_003/m2_2154_303# u_t008_003/m2_871_2081# VSUBS detronyx_12t_2w2r_rc4_4x4_routed_5layer_direct
Xu_t008_014 u_t008_014/c0_w0_bl u_t008_014/c0_w0_br u_t008_014/c0_w1_bl u_t008_014/c0_w1_br
+ u_t008_014/c0_r0_rbl u_t008_014/c0_r1_rbl u_t008_014/c1_w0_bl u_t008_014/c1_w0_br
+ u_t008_014/c1_w1_bl u_t008_014/c1_w1_br u_t008_014/c1_r0_rbl u_t008_014/c1_r1_rbl
+ u_t008_014/c2_w0_bl u_t008_014/c2_w0_br u_t008_014/c2_w1_bl u_t008_014/c2_w1_br
+ u_t008_014/c2_r0_rbl u_t008_014/c2_r1_rbl u_t008_014/c3_w0_bl u_t008_014/c3_w0_br
+ u_t008_014/c3_w1_bl u_t008_014/c3_w1_br u_t008_014/c3_r0_rbl u_t008_014/c3_r1_rbl
+ u_t008_014/r0_w0_wl u_t008_014/r0_w1_wl u_t008_014/r0_r0_rwl u_t008_014/r0_r1_rwl
+ u_t008_014/r1_w0_wl u_t008_014/r1_w1_wl u_t008_014/r1_r0_rwl u_t008_014/r1_r1_rwl
+ u_t008_014/r2_w0_wl u_t008_014/r2_w1_wl u_t008_014/r2_r0_rwl u_t008_014/r2_r1_rwl
+ u_t008_014/r3_w0_wl u_t008_014/r3_w1_wl u_t008_014/r3_r0_rwl u_t008_014/r3_r1_rwl
+ VSS VSS u_t008_014/m2_717_1265# u_t008_014/m2_603_2031# u_t008_014/m2_1290_336#
+ u_t008_014/m2_2000_2037# u_t008_014/m2_791_2909# u_t008_014/m2_7_2126# u_t008_014/m2_2154_2081#
+ u_t008_014/m2_1795_2037# u_t008_014/m2_871_303# u_t008_014/m2_431_438# u_t008_014/m2_1290_2898#
+ u_t008_014/m2_1714_1210# u_t008_014/m2_431_1982# u_t008_014/m2_512_1265# u_t008_014/m2_2573_2126#
+ u_t008_014/m2_603_1259# u_t008_014/m2_2074_2909# u_t008_014/m2_7_336# u_t008_014/m2_717_2037#
+ u_t008_014/m2_1886_2031# u_t008_014/m2_2573_336# u_t008_014/m2_7_2898# u_t008_014/m2_2000_1265#
+ u_t008_014/m2_512_2037# u_t008_014/m2_1795_1265# u_t008_014/m2_1714_1982# u_t008_014/m2_1886_1259#
+ u_t008_014/m2_1290_2126# u_t008_014/m2_1714_438# u_t008_014/m2_431_1210# u_t008_014/m2_2573_2898#
+ u_t008_014/m2_2154_303# u_t008_014/m2_871_2081# VSUBS detronyx_12t_2w2r_rc4_4x4_routed_5layer_direct
Xu_t023_006 u_t023_006/c0_w0_bl u_t023_006/c0_w0_br u_t023_006/c0_w1_bl u_t023_006/c0_w1_br
+ u_t023_006/c0_r0_rbl u_t023_006/c0_r1_rbl u_t023_006/c1_w0_bl u_t023_006/c1_w0_br
+ u_t023_006/c1_w1_bl u_t023_006/c1_w1_br u_t023_006/c1_r0_rbl u_t023_006/c1_r1_rbl
+ u_t023_006/c2_w0_bl u_t023_006/c2_w0_br u_t023_006/c2_w1_bl u_t023_006/c2_w1_br
+ u_t023_006/c2_r0_rbl u_t023_006/c2_r1_rbl u_t023_006/c3_w0_bl u_t023_006/c3_w0_br
+ u_t023_006/c3_w1_bl u_t023_006/c3_w1_br u_t023_006/c3_r0_rbl u_t023_006/c3_r1_rbl
+ u_t023_006/r0_w0_wl u_t023_006/r0_w1_wl u_t023_006/r0_r0_rwl u_t023_006/r0_r1_rwl
+ u_t023_006/r1_w0_wl u_t023_006/r1_w1_wl u_t023_006/r1_r0_rwl u_t023_006/r1_r1_rwl
+ u_t023_006/r2_w0_wl u_t023_006/r2_w1_wl u_t023_006/r2_r0_rwl u_t023_006/r2_r1_rwl
+ u_t023_006/r3_w0_wl u_t023_006/r3_w1_wl u_t023_006/r3_r0_rwl u_t023_006/r3_r1_rwl
+ VSS VSS u_t023_006/m2_717_1265# u_t023_006/m2_603_2031# u_t023_006/m2_1290_336#
+ u_t023_006/m2_2000_2037# u_t023_006/m2_791_2909# u_t023_006/m2_7_2126# u_t023_006/m2_2154_2081#
+ u_t023_006/m2_1795_2037# u_t023_006/m2_871_303# u_t023_006/m2_431_438# u_t023_006/m2_1290_2898#
+ u_t023_006/m2_1714_1210# u_t023_006/m2_431_1982# u_t023_006/m2_512_1265# u_t023_006/m2_2573_2126#
+ u_t023_006/m2_603_1259# u_t023_006/m2_2074_2909# u_t023_006/m2_7_336# u_t023_006/m2_717_2037#
+ u_t023_006/m2_1886_2031# u_t023_006/m2_2573_336# u_t023_006/m2_7_2898# u_t023_006/m2_2000_1265#
+ u_t023_006/m2_512_2037# u_t023_006/m2_1795_1265# u_t023_006/m2_1714_1982# u_t023_006/m2_1886_1259#
+ u_t023_006/m2_1290_2126# u_t023_006/m2_1714_438# u_t023_006/m2_431_1210# u_t023_006/m2_2573_2898#
+ u_t023_006/m2_2154_303# u_t023_006/m2_871_2081# VSUBS detronyx_12t_2w2r_rc4_4x4_routed_5layer_direct
Xgf180mcu_as_sc_mcu7t3v3__inv_2_640 VSS VSS gf180mcu_as_sc_mcu7t3v3__inv_2_640/Y gf180mcu_as_sc_mcu7t3v3__inv_2_641/Y
+ gf180mcu_as_sc_mcu7t3v3__inv_2_641/VNW VSUBS gf180mcu_as_sc_mcu7t3v3__inv_2
Xgf180mcu_as_sc_mcu7t3v3__inv_2_684 VSS VSS gf180mcu_as_sc_mcu7t3v3__inv_2_684/Y gf180mcu_as_sc_mcu7t3v3__inv_2_684/A
+ gf180mcu_as_sc_mcu7t3v3__inv_2_684/VNW VSUBS gf180mcu_as_sc_mcu7t3v3__inv_2
Xgf180mcu_as_sc_mcu7t3v3__inv_2_651 VSS VSS gf180mcu_as_sc_mcu7t3v3__inv_2_651/Y gf180mcu_as_sc_mcu7t3v3__inv_2_652/Y
+ gf180mcu_as_sc_mcu7t3v3__inv_2_652/VNW VSUBS gf180mcu_as_sc_mcu7t3v3__inv_2
Xgf180mcu_as_sc_mcu7t3v3__inv_2_662 VSS VSS VSS gf180mcu_as_sc_mcu7t3v3__inv_2_663/Y
+ gf180mcu_as_sc_mcu7t3v3__inv_2_664/VNW VSUBS gf180mcu_as_sc_mcu7t3v3__inv_2
Xgf180mcu_as_sc_mcu7t3v3__inv_2_673 VSS VSS gf180mcu_as_sc_mcu7t3v3__inv_2_673/Y gf180mcu_as_sc_mcu7t3v3__inv_2_674/Y
+ gf180mcu_as_sc_mcu7t3v3__inv_2_674/VNW VSUBS gf180mcu_as_sc_mcu7t3v3__inv_2
Xgf180mcu_as_sc_mcu7t3v3__inv_2_695 VSS VSS VSS gf180mcu_as_sc_mcu7t3v3__inv_2_697/Y
+ gf180mcu_as_sc_mcu7t3v3__inv_2_701/VNW VSUBS gf180mcu_as_sc_mcu7t3v3__inv_2
Xgf180mcu_as_sc_mcu7t3v3__nand2_2_18 gf180mcu_as_sc_mcu7t3v3__nand3_2_9/VDD gf180mcu_as_sc_mcu7t3v3__nor2_2_7/VSS
+ VSS VSS VSS gf180mcu_as_sc_mcu7t3v3__nand3_2_9/VNW VSUBS gf180mcu_as_sc_mcu7t3v3__nand2_2
Xgf180mcu_as_sc_mcu7t3v3__nand2_2_29 gf180mcu_as_sc_mcu7t3v3__nand3_2_9/VDD gf180mcu_as_sc_mcu7t3v3__nor2_2_7/VSS
+ VSS VSS VSS gf180mcu_as_sc_mcu7t3v3__nand3_2_9/VNW VSUBS gf180mcu_as_sc_mcu7t3v3__nand2_2
Xu_t014_006 u_t014_006/c0_w0_bl u_t014_006/c0_w0_br u_t014_006/c0_w1_bl u_t014_006/c0_w1_br
+ u_t014_006/c0_r0_rbl u_t014_006/c0_r1_rbl u_t014_006/c1_w0_bl u_t014_006/c1_w0_br
+ u_t014_006/c1_w1_bl u_t014_006/c1_w1_br u_t014_006/c1_r0_rbl u_t014_006/c1_r1_rbl
+ u_t014_006/c2_w0_bl u_t014_006/c2_w0_br u_t014_006/c2_w1_bl u_t014_006/c2_w1_br
+ u_t014_006/c2_r0_rbl u_t014_006/c2_r1_rbl u_t014_006/c3_w0_bl u_t014_006/c3_w0_br
+ u_t014_006/c3_w1_bl u_t014_006/c3_w1_br u_t014_006/c3_r0_rbl u_t014_006/c3_r1_rbl
+ u_t014_006/r0_w0_wl u_t014_006/r0_w1_wl u_t014_006/r0_r0_rwl u_t014_006/r0_r1_rwl
+ u_t014_006/r1_w0_wl u_t014_006/r1_w1_wl u_t014_006/r1_r0_rwl u_t014_006/r1_r1_rwl
+ u_t014_006/r2_w0_wl u_t014_006/r2_w1_wl u_t014_006/r2_r0_rwl u_t014_006/r2_r1_rwl
+ u_t014_006/r3_w0_wl u_t014_006/r3_w1_wl u_t014_006/r3_r0_rwl u_t014_006/r3_r1_rwl
+ VSS VSS u_t014_006/m2_717_1265# u_t014_006/m2_603_2031# u_t014_006/m2_1290_336#
+ u_t014_006/m2_2000_2037# u_t014_006/m2_791_2909# u_t014_006/m2_7_2126# u_t014_006/m2_2154_2081#
+ u_t014_006/m2_1795_2037# u_t014_006/m2_871_303# u_t014_006/m2_431_438# u_t014_006/m2_1290_2898#
+ u_t014_006/m2_1714_1210# u_t014_006/m2_431_1982# u_t014_006/m2_512_1265# u_t014_006/m2_2573_2126#
+ u_t014_006/m2_603_1259# u_t014_006/m2_2074_2909# u_t014_006/m2_7_336# u_t014_006/m2_717_2037#
+ u_t014_006/m2_1886_2031# u_t014_006/m2_2573_336# u_t014_006/m2_7_2898# u_t014_006/m2_2000_1265#
+ u_t014_006/m2_512_2037# u_t014_006/m2_1795_1265# u_t014_006/m2_1714_1982# u_t014_006/m2_1886_1259#
+ u_t014_006/m2_1290_2126# u_t014_006/m2_1714_438# u_t014_006/m2_431_1210# u_t014_006/m2_2573_2898#
+ u_t014_006/m2_2154_303# u_t014_006/m2_871_2081# VSUBS detronyx_12t_2w2r_rc4_4x4_routed_5layer_direct
Xu_t005_006 u_t005_006/c0_w0_bl u_t005_006/c0_w0_br u_t005_006/c0_w1_bl u_t005_006/c0_w1_br
+ u_t005_006/c0_r0_rbl u_t005_006/c0_r1_rbl u_t005_006/c1_w0_bl u_t005_006/c1_w0_br
+ u_t005_006/c1_w1_bl u_t005_006/c1_w1_br u_t005_006/c1_r0_rbl u_t005_006/c1_r1_rbl
+ u_t005_006/c2_w0_bl u_t005_006/c2_w0_br u_t005_006/c2_w1_bl u_t005_006/c2_w1_br
+ u_t005_006/c2_r0_rbl u_t005_006/c2_r1_rbl u_t005_006/c3_w0_bl u_t005_006/c3_w0_br
+ u_t005_006/c3_w1_bl u_t005_006/c3_w1_br u_t005_006/c3_r0_rbl u_t005_006/c3_r1_rbl
+ u_t005_006/r0_w0_wl u_t005_006/r0_w1_wl u_t005_006/r0_r0_rwl u_t005_006/r0_r1_rwl
+ u_t005_006/r1_w0_wl u_t005_006/r1_w1_wl u_t005_006/r1_r0_rwl u_t005_006/r1_r1_rwl
+ u_t005_006/r2_w0_wl u_t005_006/r2_w1_wl u_t005_006/r2_r0_rwl u_t005_006/r2_r1_rwl
+ u_t005_006/r3_w0_wl u_t005_006/r3_w1_wl u_t005_006/r3_r0_rwl u_t005_006/r3_r1_rwl
+ VSS VSS u_t005_006/m2_717_1265# u_t005_006/m2_603_2031# u_t005_006/m2_1290_336#
+ u_t005_006/m2_2000_2037# u_t005_006/m2_791_2909# u_t005_006/m2_7_2126# u_t005_006/m2_2154_2081#
+ u_t005_006/m2_1795_2037# u_t005_006/m2_871_303# u_t005_006/m2_431_438# u_t005_006/m2_1290_2898#
+ u_t005_006/m2_1714_1210# u_t005_006/m2_431_1982# u_t005_006/m2_512_1265# u_t005_006/m2_2573_2126#
+ u_t005_006/m2_603_1259# u_t005_006/m2_2074_2909# u_t005_006/m2_7_336# u_t005_006/m2_717_2037#
+ u_t005_006/m2_1886_2031# u_t005_006/m2_2573_336# u_t005_006/m2_7_2898# u_t005_006/m2_2000_1265#
+ u_t005_006/m2_512_2037# u_t005_006/m2_1795_1265# u_t005_006/m2_1714_1982# u_t005_006/m2_1886_1259#
+ u_t005_006/m2_1290_2126# u_t005_006/m2_1714_438# u_t005_006/m2_431_1210# u_t005_006/m2_2573_2898#
+ u_t005_006/m2_2154_303# u_t005_006/m2_871_2081# VSUBS detronyx_12t_2w2r_rc4_4x4_routed_5layer_direct
Xu_t020_009 u_t020_009/c0_w0_bl u_t020_009/c0_w0_br u_t020_009/c0_w1_bl u_t020_009/c0_w1_br
+ u_t020_009/c0_r0_rbl u_t020_009/c0_r1_rbl u_t020_009/c1_w0_bl u_t020_009/c1_w0_br
+ u_t020_009/c1_w1_bl u_t020_009/c1_w1_br u_t020_009/c1_r0_rbl u_t020_009/c1_r1_rbl
+ u_t020_009/c2_w0_bl u_t020_009/c2_w0_br u_t020_009/c2_w1_bl u_t020_009/c2_w1_br
+ u_t020_009/c2_r0_rbl u_t020_009/c2_r1_rbl u_t020_009/c3_w0_bl u_t020_009/c3_w0_br
+ u_t020_009/c3_w1_bl u_t020_009/c3_w1_br u_t020_009/c3_r0_rbl u_t020_009/c3_r1_rbl
+ u_t020_009/r0_w0_wl u_t020_009/r0_w1_wl u_t020_009/r0_r0_rwl u_t020_009/r0_r1_rwl
+ u_t020_009/r1_w0_wl u_t020_009/r1_w1_wl u_t020_009/r1_r0_rwl u_t020_009/r1_r1_rwl
+ u_t020_009/r2_w0_wl u_t020_009/r2_w1_wl u_t020_009/r2_r0_rwl u_t020_009/r2_r1_rwl
+ u_t020_009/r3_w0_wl u_t020_009/r3_w1_wl u_t020_009/r3_r0_rwl u_t020_009/r3_r1_rwl
+ VSS VSS u_t020_009/m2_717_1265# u_t020_009/m2_603_2031# u_t020_009/m2_1290_336#
+ u_t020_009/m2_2000_2037# u_t020_009/m2_791_2909# u_t020_009/m2_7_2126# u_t020_009/m2_2154_2081#
+ u_t020_009/m2_1795_2037# u_t020_009/m2_871_303# u_t020_009/m2_431_438# u_t020_009/m2_1290_2898#
+ u_t020_009/m2_1714_1210# u_t020_009/m2_431_1982# u_t020_009/m2_512_1265# u_t020_009/m2_2573_2126#
+ u_t020_009/m2_603_1259# u_t020_009/m2_2074_2909# u_t020_009/m2_7_336# u_t020_009/m2_717_2037#
+ u_t020_009/m2_1886_2031# u_t020_009/m2_2573_336# u_t020_009/m2_7_2898# u_t020_009/m2_2000_1265#
+ u_t020_009/m2_512_2037# u_t020_009/m2_1795_1265# u_t020_009/m2_1714_1982# u_t020_009/m2_1886_1259#
+ u_t020_009/m2_1290_2126# u_t020_009/m2_1714_438# u_t020_009/m2_431_1210# u_t020_009/m2_2573_2898#
+ u_t020_009/m2_2154_303# u_t020_009/m2_871_2081# VSUBS detronyx_12t_2w2r_rc4_4x4_routed_5layer_direct
Xu_t011_009 u_t011_009/c0_w0_bl u_t011_009/c0_w0_br u_t011_009/c0_w1_bl u_t011_009/c0_w1_br
+ u_t011_009/c0_r0_rbl u_t011_009/c0_r1_rbl u_t011_009/c1_w0_bl u_t011_009/c1_w0_br
+ u_t011_009/c1_w1_bl u_t011_009/c1_w1_br u_t011_009/c1_r0_rbl u_t011_009/c1_r1_rbl
+ u_t011_009/c2_w0_bl u_t011_009/c2_w0_br u_t011_009/c2_w1_bl u_t011_009/c2_w1_br
+ u_t011_009/c2_r0_rbl u_t011_009/c2_r1_rbl u_t011_009/c3_w0_bl u_t011_009/c3_w0_br
+ u_t011_009/c3_w1_bl u_t011_009/c3_w1_br u_t011_009/c3_r0_rbl u_t011_009/c3_r1_rbl
+ u_t011_009/r0_w0_wl u_t011_009/r0_w1_wl u_t011_009/r0_r0_rwl u_t011_009/r0_r1_rwl
+ u_t011_009/r1_w0_wl u_t011_009/r1_w1_wl u_t011_009/r1_r0_rwl u_t011_009/r1_r1_rwl
+ u_t011_009/r2_w0_wl u_t011_009/r2_w1_wl u_t011_009/r2_r0_rwl u_t011_009/r2_r1_rwl
+ u_t011_009/r3_w0_wl u_t011_009/r3_w1_wl u_t011_009/r3_r0_rwl u_t011_009/r3_r1_rwl
+ VSS VSS u_t011_009/m2_717_1265# u_t011_009/m2_603_2031# u_t011_009/m2_1290_336#
+ u_t011_009/m2_2000_2037# u_t011_009/m2_791_2909# u_t011_009/m2_7_2126# u_t011_009/m2_2154_2081#
+ u_t011_009/m2_1795_2037# u_t011_009/m2_871_303# u_t011_009/m2_431_438# u_t011_009/m2_1290_2898#
+ u_t011_009/m2_1714_1210# u_t011_009/m2_431_1982# u_t011_009/m2_512_1265# u_t011_009/m2_2573_2126#
+ u_t011_009/m2_603_1259# u_t011_009/m2_2074_2909# u_t011_009/m2_7_336# u_t011_009/m2_717_2037#
+ u_t011_009/m2_1886_2031# u_t011_009/m2_2573_336# u_t011_009/m2_7_2898# u_t011_009/m2_2000_1265#
+ u_t011_009/m2_512_2037# u_t011_009/m2_1795_1265# u_t011_009/m2_1714_1982# u_t011_009/m2_1886_1259#
+ u_t011_009/m2_1290_2126# u_t011_009/m2_1714_438# u_t011_009/m2_431_1210# u_t011_009/m2_2573_2898#
+ u_t011_009/m2_2154_303# u_t011_009/m2_871_2081# VSUBS detronyx_12t_2w2r_rc4_4x4_routed_5layer_direct
Xgf180mcu_as_sc_mcu7t3v3__inv_2_481 VSS VSS gf180mcu_as_sc_mcu7t3v3__inv_2_547/A gf180mcu_as_sc_mcu7t3v3__inv_2_482/Y
+ gf180mcu_as_sc_mcu7t3v3__inv_2_547/VNW VSUBS gf180mcu_as_sc_mcu7t3v3__inv_2
Xgf180mcu_as_sc_mcu7t3v3__inv_2_470 gf180mcu_as_sc_mcu7t3v3__nand3_2_9/VDD gf180mcu_as_sc_mcu7t3v3__nor2_2_4/VSS
+ VSS VSS gf180mcu_as_sc_mcu7t3v3__nand3_2_9/VNW VSUBS gf180mcu_as_sc_mcu7t3v3__inv_2
Xgf180mcu_as_sc_mcu7t3v3__inv_2_492 VSS VSS gf180mcu_as_sc_mcu7t3v3__inv_2_492/Y gf180mcu_as_sc_mcu7t3v3__inv_2_492/A
+ gf180mcu_as_sc_mcu7t3v3__inv_2_553/VNW VSUBS gf180mcu_as_sc_mcu7t3v3__inv_2
Xu_t002_009 u_t002_009/c0_w0_bl u_t002_009/c0_w0_br u_t002_009/c0_w1_bl u_t002_009/c0_w1_br
+ u_t002_009/c0_r0_rbl u_t002_009/c0_r1_rbl u_t002_009/c1_w0_bl u_t002_009/c1_w0_br
+ u_t002_009/c1_w1_bl u_t002_009/c1_w1_br u_t002_009/c1_r0_rbl u_t002_009/c1_r1_rbl
+ u_t002_009/c2_w0_bl u_t002_009/c2_w0_br u_t002_009/c2_w1_bl u_t002_009/c2_w1_br
+ u_t002_009/c2_r0_rbl u_t002_009/c2_r1_rbl u_t002_009/c3_w0_bl u_t002_009/c3_w0_br
+ u_t002_009/c3_w1_bl u_t002_009/c3_w1_br u_t002_009/c3_r0_rbl u_t002_009/c3_r1_rbl
+ u_t002_009/r0_w0_wl u_t002_009/r0_w1_wl u_t002_009/r0_r0_rwl u_t002_009/r0_r1_rwl
+ u_t002_009/r1_w0_wl u_t002_009/r1_w1_wl u_t002_009/r1_r0_rwl u_t002_009/r1_r1_rwl
+ u_t002_009/r2_w0_wl u_t002_009/r2_w1_wl u_t002_009/r2_r0_rwl u_t002_009/r2_r1_rwl
+ u_t002_009/r3_w0_wl u_t002_009/r3_w1_wl u_t002_009/r3_r0_rwl u_t002_009/r3_r1_rwl
+ VSS VSS u_t002_009/m2_717_1265# u_t002_009/m2_603_2031# u_t002_009/m2_1290_336#
+ u_t002_009/m2_2000_2037# u_t002_009/m2_791_2909# u_t002_009/m2_7_2126# u_t002_009/m2_2154_2081#
+ u_t002_009/m2_1795_2037# u_t002_009/m2_871_303# u_t002_009/m2_431_438# u_t002_009/m2_1290_2898#
+ u_t002_009/m2_1714_1210# u_t002_009/m2_431_1982# u_t002_009/m2_512_1265# u_t002_009/m2_2573_2126#
+ u_t002_009/m2_603_1259# u_t002_009/m2_2074_2909# u_t002_009/m2_7_336# u_t002_009/m2_717_2037#
+ u_t002_009/m2_1886_2031# u_t002_009/m2_2573_336# u_t002_009/m2_7_2898# u_t002_009/m2_2000_1265#
+ u_t002_009/m2_512_2037# u_t002_009/m2_1795_1265# u_t002_009/m2_1714_1982# u_t002_009/m2_1886_1259#
+ u_t002_009/m2_1290_2126# u_t002_009/m2_1714_438# u_t002_009/m2_431_1210# u_t002_009/m2_2573_2898#
+ u_t002_009/m2_2154_303# u_t002_009/m2_871_2081# VSUBS detronyx_12t_2w2r_rc4_4x4_routed_5layer_direct
Xgf180mcu_as_sc_mcu7t3v3__inv_2_1711 gf180mcu_as_sc_mcu7t3v3__nand3_2_65/VDD gf180mcu_as_sc_mcu7t3v3__nor2_2_9/VSS
+ VSS VSS gf180mcu_as_sc_mcu7t3v3__nand3_2_65/VNW VSUBS gf180mcu_as_sc_mcu7t3v3__inv_2
Xgf180mcu_as_sc_mcu7t3v3__inv_2_1700 gf180mcu_as_sc_mcu7t3v3__nor2_2_6/VDD gf180mcu_as_sc_mcu7t3v3__nand3_2_4/VSS
+ gf180mcu_as_sc_mcu7t3v3__inv_2_1700/Y VSS gf180mcu_as_sc_mcu7t3v3__nor2_2_6/VNW
+ VSUBS gf180mcu_as_sc_mcu7t3v3__inv_2
Xgf180mcu_as_sc_mcu7t3v3__inv_2_1722 VSS VSS gf180mcu_as_sc_mcu7t3v3__inv_2_1722/Y
+ gf180mcu_as_sc_mcu7t3v3__inv_2_1723/Y gf180mcu_as_sc_mcu7t3v3__inv_2_1723/VNW VSUBS
+ gf180mcu_as_sc_mcu7t3v3__inv_2
Xgf180mcu_as_sc_mcu7t3v3__nand4_2_505 VSS VSS VSS VSS VSS VSS gf180mcu_as_sc_mcu7t3v3__inv_2_1611/A
+ gf180mcu_as_sc_mcu7t3v3__inv_2_1689/VNW VSUBS gf180mcu_as_sc_mcu7t3v3__nand4_2
Xgf180mcu_as_sc_mcu7t3v3__inv_2_1029 VSS VSS VSS gf180mcu_as_sc_mcu7t3v3__inv_2_1033/Y
+ gf180mcu_as_sc_mcu7t3v3__inv_2_1037/VNW VSUBS gf180mcu_as_sc_mcu7t3v3__inv_2
Xgf180mcu_as_sc_mcu7t3v3__inv_2_15 VSS VSS gf180mcu_as_sc_mcu7t3v3__inv_2_15/Y gf180mcu_as_sc_mcu7t3v3__inv_2_16/Y
+ gf180mcu_as_sc_mcu7t3v3__inv_2_16/VNW VSUBS gf180mcu_as_sc_mcu7t3v3__inv_2
Xgf180mcu_as_sc_mcu7t3v3__inv_2_26 VSS VSS VSS gf180mcu_as_sc_mcu7t3v3__inv_2_27/Y
+ gf180mcu_as_sc_mcu7t3v3__inv_2_28/VNW VSUBS gf180mcu_as_sc_mcu7t3v3__inv_2
Xgf180mcu_as_sc_mcu7t3v3__inv_2_48 VSS VSS gf180mcu_as_sc_mcu7t3v3__inv_2_48/Y gf180mcu_as_sc_mcu7t3v3__inv_2_49/Y
+ gf180mcu_as_sc_mcu7t3v3__inv_2_49/VNW VSUBS gf180mcu_as_sc_mcu7t3v3__inv_2
Xgf180mcu_as_sc_mcu7t3v3__inv_2_37 VSS VSS gf180mcu_as_sc_mcu7t3v3__inv_2_37/Y gf180mcu_as_sc_mcu7t3v3__inv_2_38/Y
+ gf180mcu_as_sc_mcu7t3v3__inv_2_38/VNW VSUBS gf180mcu_as_sc_mcu7t3v3__inv_2
Xgf180mcu_as_sc_mcu7t3v3__inv_2_59 VSS VSS VSS gf180mcu_as_sc_mcu7t3v3__inv_2_60/Y
+ gf180mcu_as_sc_mcu7t3v3__inv_2_61/VNW VSUBS gf180mcu_as_sc_mcu7t3v3__inv_2
Xgf180mcu_as_sc_mcu7t3v3__inv_2_1007 VSS VSS gf180mcu_as_sc_mcu7t3v3__inv_2_1007/Y
+ gf180mcu_as_sc_mcu7t3v3__inv_2_960/Y gf180mcu_as_sc_mcu7t3v3__inv_2_960/VNW VSUBS
+ gf180mcu_as_sc_mcu7t3v3__inv_2
Xgf180mcu_as_sc_mcu7t3v3__inv_2_1018 VSS VSS VSS gf180mcu_as_sc_mcu7t3v3__inv_2_1019/Y
+ gf180mcu_as_sc_mcu7t3v3__inv_2_1020/VNW VSUBS gf180mcu_as_sc_mcu7t3v3__inv_2
Xgf180mcu_as_sc_mcu7t3v3__inv_2_1596 VSS VSS gf180mcu_as_sc_mcu7t3v3__inv_2_1596/Y
+ gf180mcu_as_sc_mcu7t3v3__inv_2_1597/Y gf180mcu_as_sc_mcu7t3v3__inv_2_1597/VNW VSUBS
+ gf180mcu_as_sc_mcu7t3v3__inv_2
Xgf180mcu_as_sc_mcu7t3v3__inv_2_1563 VSS VSS gf180mcu_as_sc_mcu7t3v3__inv_2_1598/A
+ gf180mcu_as_sc_mcu7t3v3__inv_2_1564/Y gf180mcu_as_sc_mcu7t3v3__inv_2_1598/VNW VSUBS
+ gf180mcu_as_sc_mcu7t3v3__inv_2
Xgf180mcu_as_sc_mcu7t3v3__inv_2_1574 VSS VSS VSS gf180mcu_as_sc_mcu7t3v3__inv_2_1575/Y
+ gf180mcu_as_sc_mcu7t3v3__inv_2_1576/VNW VSUBS gf180mcu_as_sc_mcu7t3v3__inv_2
Xgf180mcu_as_sc_mcu7t3v3__inv_2_1585 VSS VSS gf180mcu_as_sc_mcu7t3v3__inv_2_1585/Y
+ gf180mcu_as_sc_mcu7t3v3__inv_2_1585/A gf180mcu_as_sc_mcu7t3v3__inv_2_1585/VNW VSUBS
+ gf180mcu_as_sc_mcu7t3v3__inv_2
Xgf180mcu_as_sc_mcu7t3v3__inv_2_1552 VSS VSS gf180mcu_as_sc_mcu7t3v3__inv_2_1552/Y
+ gf180mcu_as_sc_mcu7t3v3__inv_2_1553/Y gf180mcu_as_sc_mcu7t3v3__inv_2_1553/VNW VSUBS
+ gf180mcu_as_sc_mcu7t3v3__inv_2
Xgf180mcu_as_sc_mcu7t3v3__inv_2_1530 VSS VSS VSS gf180mcu_as_sc_mcu7t3v3__inv_2_1531/Y
+ gf180mcu_as_sc_mcu7t3v3__inv_2_1532/VNW VSUBS gf180mcu_as_sc_mcu7t3v3__inv_2
Xgf180mcu_as_sc_mcu7t3v3__inv_2_1541 VSS VSS gf180mcu_as_sc_mcu7t3v3__inv_2_1541/Y
+ gf180mcu_as_sc_mcu7t3v3__inv_2_1541/A gf180mcu_as_sc_mcu7t3v3__inv_2_1541/VNW VSUBS
+ gf180mcu_as_sc_mcu7t3v3__inv_2
Xgf180mcu_as_sc_mcu7t3v3__nand3_2_7 gf180mcu_as_sc_mcu7t3v3__nand3_2_9/VDD gf180mcu_as_sc_mcu7t3v3__nor2_2_4/VSS
+ VSS VSS VSS VSS gf180mcu_as_sc_mcu7t3v3__nand3_2_9/VNW VSUBS gf180mcu_as_sc_mcu7t3v3__nand3_2
Xgf180mcu_as_sc_mcu7t3v3__nand4_2_335 VSS VSS VSS VSS VSS VSS gf180mcu_as_sc_mcu7t3v3__inv_2_1129/A
+ gf180mcu_as_sc_mcu7t3v3__inv_2_1129/VNW VSUBS gf180mcu_as_sc_mcu7t3v3__nand4_2
Xgf180mcu_as_sc_mcu7t3v3__nand4_2_368 VSS VSS VSS VSS VSS VSS gf180mcu_as_sc_mcu7t3v3__inv_2_1190/A
+ gf180mcu_as_sc_mcu7t3v3__inv_2_1268/VNW VSUBS gf180mcu_as_sc_mcu7t3v3__nand4_2
Xgf180mcu_as_sc_mcu7t3v3__nand4_2_346 VSS VSS VSS VSS VSS VSS gf180mcu_as_sc_mcu7t3v3__inv_2_1130/A
+ gf180mcu_as_sc_mcu7t3v3__inv_2_1130/VNW VSUBS gf180mcu_as_sc_mcu7t3v3__nand4_2
Xgf180mcu_as_sc_mcu7t3v3__nand4_2_324 VSS VSS VSS VSS VSS VSS gf180mcu_as_sc_mcu7t3v3__inv_2_1091/A
+ gf180mcu_as_sc_mcu7t3v3__inv_2_1091/VNW VSUBS gf180mcu_as_sc_mcu7t3v3__nand4_2
Xgf180mcu_as_sc_mcu7t3v3__nand4_2_357 VSS VSS VSS VSS VSS VSS gf180mcu_as_sc_mcu7t3v3__inv_2_1169/A
+ gf180mcu_as_sc_mcu7t3v3__inv_2_1287/VNW VSUBS gf180mcu_as_sc_mcu7t3v3__nand4_2
Xgf180mcu_as_sc_mcu7t3v3__nand4_2_313 VSS VSS VSS VSS VSS VSS gf180mcu_as_sc_mcu7t3v3__inv_2_1032/A
+ gf180mcu_as_sc_mcu7t3v3__inv_2_1032/VNW VSUBS gf180mcu_as_sc_mcu7t3v3__nand4_2
Xgf180mcu_as_sc_mcu7t3v3__nand4_2_379 VSS VSS VSS VSS VSS VSS gf180mcu_as_sc_mcu7t3v3__inv_2_1307/A
+ gf180mcu_as_sc_mcu7t3v3__inv_2_1307/VNW VSUBS gf180mcu_as_sc_mcu7t3v3__nand4_2
Xgf180mcu_as_sc_mcu7t3v3__nand4_2_302 VSS VSS VSS VSS VSS VSS gf180mcu_as_sc_mcu7t3v3__inv_2_969/A
+ gf180mcu_as_sc_mcu7t3v3__inv_2_969/VNW VSUBS gf180mcu_as_sc_mcu7t3v3__nand4_2
Xu_t029_012 u_t029_012/c0_w0_bl u_t029_012/c0_w0_br u_t029_012/c0_w1_bl u_t029_012/c0_w1_br
+ u_t029_012/c0_r0_rbl u_t029_012/c0_r1_rbl u_t029_012/c1_w0_bl u_t029_012/c1_w0_br
+ u_t029_012/c1_w1_bl u_t029_012/c1_w1_br u_t029_012/c1_r0_rbl u_t029_012/c1_r1_rbl
+ u_t029_012/c2_w0_bl u_t029_012/c2_w0_br u_t029_012/c2_w1_bl u_t029_012/c2_w1_br
+ u_t029_012/c2_r0_rbl u_t029_012/c2_r1_rbl u_t029_012/c3_w0_bl u_t029_012/c3_w0_br
+ u_t029_012/c3_w1_bl u_t029_012/c3_w1_br u_t029_012/c3_r0_rbl u_t029_012/c3_r1_rbl
+ u_t029_012/r0_w0_wl u_t029_012/r0_w1_wl u_t029_012/r0_r0_rwl u_t029_012/r0_r1_rwl
+ u_t029_012/r1_w0_wl u_t029_012/r1_w1_wl u_t029_012/r1_r0_rwl u_t029_012/r1_r1_rwl
+ u_t029_012/r2_w0_wl u_t029_012/r2_w1_wl u_t029_012/r2_r0_rwl u_t029_012/r2_r1_rwl
+ u_t029_012/r3_w0_wl u_t029_012/r3_w1_wl u_t029_012/r3_r0_rwl u_t029_012/r3_r1_rwl
+ VSS VSS u_t029_012/m2_717_1265# u_t029_012/m2_603_2031# u_t029_012/m2_1290_336#
+ u_t029_012/m2_2000_2037# u_t029_012/m2_791_2909# u_t029_012/m2_7_2126# u_t029_012/m2_2154_2081#
+ u_t029_012/m2_1795_2037# u_t029_012/m2_871_303# u_t029_012/m2_431_438# u_t029_012/m2_1290_2898#
+ u_t029_012/m2_1714_1210# u_t029_012/m2_431_1982# u_t029_012/m2_512_1265# u_t029_012/m2_2573_2126#
+ u_t029_012/m2_603_1259# u_t029_012/m2_2074_2909# u_t029_012/m2_7_336# u_t029_012/m2_717_2037#
+ u_t029_012/m2_1886_2031# u_t029_012/m2_2573_336# u_t029_012/m2_7_2898# u_t029_012/m2_2000_1265#
+ u_t029_012/m2_512_2037# u_t029_012/m2_1795_1265# u_t029_012/m2_1714_1982# u_t029_012/m2_1886_1259#
+ u_t029_012/m2_1290_2126# u_t029_012/m2_1714_438# u_t029_012/m2_431_1210# u_t029_012/m2_2573_2898#
+ u_t029_012/m2_2154_303# u_t029_012/m2_871_2081# VSUBS detronyx_12t_2w2r_rc4_4x4_routed_5layer_direct
Xu_t029_001 u_t029_001/c0_w0_bl u_t029_001/c0_w0_br u_t029_001/c0_w1_bl u_t029_001/c0_w1_br
+ u_t029_001/c0_r0_rbl u_t029_001/c0_r1_rbl u_t029_001/c1_w0_bl u_t029_001/c1_w0_br
+ u_t029_001/c1_w1_bl u_t029_001/c1_w1_br u_t029_001/c1_r0_rbl u_t029_001/c1_r1_rbl
+ u_t029_001/c2_w0_bl u_t029_001/c2_w0_br u_t029_001/c2_w1_bl u_t029_001/c2_w1_br
+ u_t029_001/c2_r0_rbl u_t029_001/c2_r1_rbl u_t029_001/c3_w0_bl u_t029_001/c3_w0_br
+ u_t029_001/c3_w1_bl u_t029_001/c3_w1_br u_t029_001/c3_r0_rbl u_t029_001/c3_r1_rbl
+ u_t029_001/r0_w0_wl u_t029_001/r0_w1_wl u_t029_001/r0_r0_rwl u_t029_001/r0_r1_rwl
+ u_t029_001/r1_w0_wl u_t029_001/r1_w1_wl u_t029_001/r1_r0_rwl u_t029_001/r1_r1_rwl
+ u_t029_001/r2_w0_wl u_t029_001/r2_w1_wl u_t029_001/r2_r0_rwl u_t029_001/r2_r1_rwl
+ u_t029_001/r3_w0_wl u_t029_001/r3_w1_wl u_t029_001/r3_r0_rwl u_t029_001/r3_r1_rwl
+ VSS VSS u_t029_001/m2_717_1265# u_t029_001/m2_603_2031# u_t029_001/m2_1290_336#
+ u_t029_001/m2_2000_2037# u_t029_001/m2_791_2909# u_t029_001/m2_7_2126# u_t029_001/m2_2154_2081#
+ u_t029_001/m2_1795_2037# u_t029_001/m2_871_303# u_t029_001/m2_431_438# u_t029_001/m2_1290_2898#
+ u_t029_001/m2_1714_1210# u_t029_001/m2_431_1982# u_t029_001/m2_512_1265# u_t029_001/m2_2573_2126#
+ u_t029_001/m2_603_1259# u_t029_001/m2_2074_2909# u_t029_001/m2_7_336# u_t029_001/m2_717_2037#
+ u_t029_001/m2_1886_2031# u_t029_001/m2_2573_336# u_t029_001/m2_7_2898# u_t029_001/m2_2000_1265#
+ u_t029_001/m2_512_2037# u_t029_001/m2_1795_1265# u_t029_001/m2_1714_1982# u_t029_001/m2_1886_1259#
+ u_t029_001/m2_1290_2126# u_t029_001/m2_1714_438# u_t029_001/m2_431_1210# u_t029_001/m2_2573_2898#
+ u_t029_001/m2_2154_303# u_t029_001/m2_871_2081# VSUBS detronyx_12t_2w2r_rc4_4x4_routed_5layer_direct
Xgf180mcu_as_sc_mcu7t3v3__inv_2_1360 VSS VSS VSS gf180mcu_as_sc_mcu7t3v3__inv_2_1361/Y
+ gf180mcu_as_sc_mcu7t3v3__inv_2_1362/VNW VSUBS gf180mcu_as_sc_mcu7t3v3__inv_2
Xgf180mcu_as_sc_mcu7t3v3__inv_2_1382 VSS VSS gf180mcu_as_sc_mcu7t3v3__inv_2_1382/Y
+ gf180mcu_as_sc_mcu7t3v3__inv_2_1382/A gf180mcu_as_sc_mcu7t3v3__inv_2_1382/VNW VSUBS
+ gf180mcu_as_sc_mcu7t3v3__inv_2
Xgf180mcu_as_sc_mcu7t3v3__inv_2_1393 VSS VSS gf180mcu_as_sc_mcu7t3v3__inv_2_1393/Y
+ gf180mcu_as_sc_mcu7t3v3__inv_2_1394/Y gf180mcu_as_sc_mcu7t3v3__inv_2_1394/VNW VSUBS
+ gf180mcu_as_sc_mcu7t3v3__inv_2
Xgf180mcu_as_sc_mcu7t3v3__inv_2_1371 VSS VSS gf180mcu_as_sc_mcu7t3v3__inv_2_1371/Y
+ gf180mcu_as_sc_mcu7t3v3__inv_2_1375/Y gf180mcu_as_sc_mcu7t3v3__inv_2_1375/VNW VSUBS
+ gf180mcu_as_sc_mcu7t3v3__inv_2
Xgf180mcu_as_sc_mcu7t3v3__inv_2_855 VSS VSS VSS gf180mcu_as_sc_mcu7t3v3__inv_2_856/Y
+ gf180mcu_as_sc_mcu7t3v3__inv_2_857/VNW VSUBS gf180mcu_as_sc_mcu7t3v3__inv_2
Xgf180mcu_as_sc_mcu7t3v3__inv_2_822 VSS VSS VSS gf180mcu_as_sc_mcu7t3v3__inv_2_822/A
+ gf180mcu_as_sc_mcu7t3v3__inv_2_822/VNW VSUBS gf180mcu_as_sc_mcu7t3v3__inv_2
Xgf180mcu_as_sc_mcu7t3v3__inv_2_833 VSS VSS VSS gf180mcu_as_sc_mcu7t3v3__inv_2_833/A
+ gf180mcu_as_sc_mcu7t3v3__inv_2_833/VNW VSUBS gf180mcu_as_sc_mcu7t3v3__inv_2
Xgf180mcu_as_sc_mcu7t3v3__inv_2_800 VSS VSS gf180mcu_as_sc_mcu7t3v3__inv_2_847/A gf180mcu_as_sc_mcu7t3v3__inv_2_801/Y
+ gf180mcu_as_sc_mcu7t3v3__inv_2_847/VNW VSUBS gf180mcu_as_sc_mcu7t3v3__inv_2
Xgf180mcu_as_sc_mcu7t3v3__inv_2_844 VSS VSS VSS gf180mcu_as_sc_mcu7t3v3__inv_2_844/A
+ gf180mcu_as_sc_mcu7t3v3__inv_2_844/VNW VSUBS gf180mcu_as_sc_mcu7t3v3__inv_2
Xgf180mcu_as_sc_mcu7t3v3__inv_2_811 VSS VSS gf180mcu_as_sc_mcu7t3v3__inv_2_840/A gf180mcu_as_sc_mcu7t3v3__inv_2_812/Y
+ gf180mcu_as_sc_mcu7t3v3__inv_2_840/VNW VSUBS gf180mcu_as_sc_mcu7t3v3__inv_2
Xgf180mcu_as_sc_mcu7t3v3__inv_2_866 VSS VSS gf180mcu_as_sc_mcu7t3v3__inv_2_866/Y gf180mcu_as_sc_mcu7t3v3__inv_2_866/A
+ gf180mcu_as_sc_mcu7t3v3__inv_2_939/VNW VSUBS gf180mcu_as_sc_mcu7t3v3__inv_2
Xgf180mcu_as_sc_mcu7t3v3__inv_2_877 VSS VSS gf180mcu_as_sc_mcu7t3v3__inv_2_943/A gf180mcu_as_sc_mcu7t3v3__inv_2_888/Y
+ gf180mcu_as_sc_mcu7t3v3__inv_2_943/VNW VSUBS gf180mcu_as_sc_mcu7t3v3__inv_2
Xgf180mcu_as_sc_mcu7t3v3__inv_2_888 VSS VSS gf180mcu_as_sc_mcu7t3v3__inv_2_888/Y gf180mcu_as_sc_mcu7t3v3__inv_2_888/A
+ gf180mcu_as_sc_mcu7t3v3__inv_2_943/VNW VSUBS gf180mcu_as_sc_mcu7t3v3__inv_2
Xgf180mcu_as_sc_mcu7t3v3__inv_2_899 VSS VSS gf180mcu_as_sc_mcu7t3v3__inv_2_899/Y gf180mcu_as_sc_mcu7t3v3__inv_2_899/A
+ gf180mcu_as_sc_mcu7t3v3__inv_2_927/VNW VSUBS gf180mcu_as_sc_mcu7t3v3__inv_2
Xgf180mcu_as_sc_mcu7t3v3__nand4_2_110 VSS VSS VSS VSS VSS VSS gf180mcu_as_sc_mcu7t3v3__inv_2_297/A
+ gf180mcu_as_sc_mcu7t3v3__inv_2_297/VNW VSUBS gf180mcu_as_sc_mcu7t3v3__nand4_2
Xu_t026_015 u_t026_015/c0_w0_bl u_t026_015/c0_w0_br u_t026_015/c0_w1_bl u_t026_015/c0_w1_br
+ u_t026_015/c0_r0_rbl u_t026_015/c0_r1_rbl u_t026_015/c1_w0_bl u_t026_015/c1_w0_br
+ u_t026_015/c1_w1_bl u_t026_015/c1_w1_br u_t026_015/c1_r0_rbl u_t026_015/c1_r1_rbl
+ u_t026_015/c2_w0_bl u_t026_015/c2_w0_br u_t026_015/c2_w1_bl u_t026_015/c2_w1_br
+ u_t026_015/c2_r0_rbl u_t026_015/c2_r1_rbl u_t026_015/c3_w0_bl u_t026_015/c3_w0_br
+ u_t026_015/c3_w1_bl u_t026_015/c3_w1_br u_t026_015/c3_r0_rbl u_t026_015/c3_r1_rbl
+ u_t026_015/r0_w0_wl u_t026_015/r0_w1_wl u_t026_015/r0_r0_rwl u_t026_015/r0_r1_rwl
+ u_t026_015/r1_w0_wl u_t026_015/r1_w1_wl u_t026_015/r1_r0_rwl u_t026_015/r1_r1_rwl
+ u_t026_015/r2_w0_wl u_t026_015/r2_w1_wl u_t026_015/r2_r0_rwl u_t026_015/r2_r1_rwl
+ u_t026_015/r3_w0_wl u_t026_015/r3_w1_wl u_t026_015/r3_r0_rwl u_t026_015/r3_r1_rwl
+ VSS VSS u_t026_015/m2_717_1265# u_t026_015/m2_603_2031# u_t026_015/m2_1290_336#
+ u_t026_015/m2_2000_2037# u_t026_015/m2_791_2909# u_t026_015/m2_7_2126# u_t026_015/m2_2154_2081#
+ u_t026_015/m2_1795_2037# u_t026_015/m2_871_303# u_t026_015/m2_431_438# u_t026_015/m2_1290_2898#
+ u_t026_015/m2_1714_1210# u_t026_015/m2_431_1982# u_t026_015/m2_512_1265# u_t026_015/m2_2573_2126#
+ u_t026_015/m2_603_1259# u_t026_015/m2_2074_2909# u_t026_015/m2_7_336# u_t026_015/m2_717_2037#
+ u_t026_015/m2_1886_2031# u_t026_015/m2_2573_336# u_t026_015/m2_7_2898# u_t026_015/m2_2000_1265#
+ u_t026_015/m2_512_2037# u_t026_015/m2_1795_1265# u_t026_015/m2_1714_1982# u_t026_015/m2_1886_1259#
+ u_t026_015/m2_1290_2126# u_t026_015/m2_1714_438# u_t026_015/m2_431_1210# u_t026_015/m2_2573_2898#
+ u_t026_015/m2_2154_303# u_t026_015/m2_871_2081# VSUBS detronyx_12t_2w2r_rc4_4x4_routed_5layer_direct
Xu_t026_004 u_t026_004/c0_w0_bl u_t026_004/c0_w0_br u_t026_004/c0_w1_bl u_t026_004/c0_w1_br
+ u_t026_004/c0_r0_rbl u_t026_004/c0_r1_rbl u_t026_004/c1_w0_bl u_t026_004/c1_w0_br
+ u_t026_004/c1_w1_bl u_t026_004/c1_w1_br u_t026_004/c1_r0_rbl u_t026_004/c1_r1_rbl
+ u_t026_004/c2_w0_bl u_t026_004/c2_w0_br u_t026_004/c2_w1_bl u_t026_004/c2_w1_br
+ u_t026_004/c2_r0_rbl u_t026_004/c2_r1_rbl u_t026_004/c3_w0_bl u_t026_004/c3_w0_br
+ u_t026_004/c3_w1_bl u_t026_004/c3_w1_br u_t026_004/c3_r0_rbl u_t026_004/c3_r1_rbl
+ u_t026_004/r0_w0_wl u_t026_004/r0_w1_wl u_t026_004/r0_r0_rwl u_t026_004/r0_r1_rwl
+ u_t026_004/r1_w0_wl u_t026_004/r1_w1_wl u_t026_004/r1_r0_rwl u_t026_004/r1_r1_rwl
+ u_t026_004/r2_w0_wl u_t026_004/r2_w1_wl u_t026_004/r2_r0_rwl u_t026_004/r2_r1_rwl
+ u_t026_004/r3_w0_wl u_t026_004/r3_w1_wl u_t026_004/r3_r0_rwl u_t026_004/r3_r1_rwl
+ VSS VSS u_t026_004/m2_717_1265# u_t026_004/m2_603_2031# u_t026_004/m2_1290_336#
+ u_t026_004/m2_2000_2037# u_t026_004/m2_791_2909# u_t026_004/m2_7_2126# u_t026_004/m2_2154_2081#
+ u_t026_004/m2_1795_2037# u_t026_004/m2_871_303# u_t026_004/m2_431_438# u_t026_004/m2_1290_2898#
+ u_t026_004/m2_1714_1210# u_t026_004/m2_431_1982# u_t026_004/m2_512_1265# u_t026_004/m2_2573_2126#
+ u_t026_004/m2_603_1259# u_t026_004/m2_2074_2909# u_t026_004/m2_7_336# u_t026_004/m2_717_2037#
+ u_t026_004/m2_1886_2031# u_t026_004/m2_2573_336# u_t026_004/m2_7_2898# u_t026_004/m2_2000_1265#
+ u_t026_004/m2_512_2037# u_t026_004/m2_1795_1265# u_t026_004/m2_1714_1982# u_t026_004/m2_1886_1259#
+ u_t026_004/m2_1290_2126# u_t026_004/m2_1714_438# u_t026_004/m2_431_1210# u_t026_004/m2_2573_2898#
+ u_t026_004/m2_2154_303# u_t026_004/m2_871_2081# VSUBS detronyx_12t_2w2r_rc4_4x4_routed_5layer_direct
Xgf180mcu_as_sc_mcu7t3v3__nand4_2_176 VSS VSS VSS VSS VSS VSS gf180mcu_as_sc_mcu7t3v3__inv_2_637/A
+ gf180mcu_as_sc_mcu7t3v3__inv_2_637/VNW VSUBS gf180mcu_as_sc_mcu7t3v3__nand4_2
Xgf180mcu_as_sc_mcu7t3v3__nand4_2_154 VSS VSS VSS VSS VSS VSS gf180mcu_as_sc_mcu7t3v3__inv_2_588/A
+ gf180mcu_as_sc_mcu7t3v3__inv_2_588/VNW VSUBS gf180mcu_as_sc_mcu7t3v3__nand4_2
Xgf180mcu_as_sc_mcu7t3v3__nand4_2_132 VSS VSS VSS VSS VSS VSS gf180mcu_as_sc_mcu7t3v3__inv_2_483/A
+ gf180mcu_as_sc_mcu7t3v3__inv_2_549/VNW VSUBS gf180mcu_as_sc_mcu7t3v3__nand4_2
Xgf180mcu_as_sc_mcu7t3v3__nand4_2_165 VSS VSS VSS VSS VSS VSS gf180mcu_as_sc_mcu7t3v3__inv_2_628/A
+ gf180mcu_as_sc_mcu7t3v3__inv_2_628/VNW VSUBS gf180mcu_as_sc_mcu7t3v3__nand4_2
Xgf180mcu_as_sc_mcu7t3v3__nand4_2_143 VSS VSS VSS VSS VSS VSS gf180mcu_as_sc_mcu7t3v3__inv_2_498/A
+ gf180mcu_as_sc_mcu7t3v3__inv_2_561/VNW VSUBS gf180mcu_as_sc_mcu7t3v3__nand4_2
Xgf180mcu_as_sc_mcu7t3v3__nand4_2_121 VSS VSS VSS VSS VSS VSS gf180mcu_as_sc_mcu7t3v3__inv_2_280/A
+ gf180mcu_as_sc_mcu7t3v3__inv_2_280/VNW VSUBS gf180mcu_as_sc_mcu7t3v3__nand4_2
Xgf180mcu_as_sc_mcu7t3v3__nand4_2_198 VSS VSS VSS VSS VSS VSS gf180mcu_as_sc_mcu7t3v3__inv_2_746/A
+ gf180mcu_as_sc_mcu7t3v3__inv_2_746/VNW VSUBS gf180mcu_as_sc_mcu7t3v3__nand4_2
Xgf180mcu_as_sc_mcu7t3v3__nand4_2_187 VSS VSS VSS VSS VSS VSS gf180mcu_as_sc_mcu7t3v3__inv_2_720/A
+ gf180mcu_as_sc_mcu7t3v3__inv_2_720/VNW VSUBS gf180mcu_as_sc_mcu7t3v3__nand4_2
Xgf180mcu_as_sc_mcu7t3v3__nand4_2_60 VSS VSS VSS VSS VSS VSS gf180mcu_as_sc_mcu7t3v3__inv_2_260/A
+ gf180mcu_as_sc_mcu7t3v3__inv_2_260/VNW VSUBS gf180mcu_as_sc_mcu7t3v3__nand4_2
Xgf180mcu_as_sc_mcu7t3v3__nand4_2_71 VSS VSS VSS VSS VSS VSS gf180mcu_as_sc_mcu7t3v3__inv_2_317/A
+ gf180mcu_as_sc_mcu7t3v3__inv_2_317/VNW VSUBS gf180mcu_as_sc_mcu7t3v3__nand4_2
Xgf180mcu_as_sc_mcu7t3v3__nand4_2_93 VSS VSS VSS VSS VSS VSS gf180mcu_as_sc_mcu7t3v3__inv_2_0/A
+ gf180mcu_as_sc_mcu7t3v3__inv_2_0/VNW VSUBS gf180mcu_as_sc_mcu7t3v3__nand4_2
Xgf180mcu_as_sc_mcu7t3v3__nand4_2_82 VSS VSS VSS VSS VSS VSS gf180mcu_as_sc_mcu7t3v3__inv_2_61/A
+ gf180mcu_as_sc_mcu7t3v3__inv_2_61/VNW VSUBS gf180mcu_as_sc_mcu7t3v3__nand4_2
Xu_t017_015 u_t017_015/c0_w0_bl u_t017_015/c0_w0_br u_t017_015/c0_w1_bl u_t017_015/c0_w1_br
+ u_t017_015/c0_r0_rbl u_t017_015/c0_r1_rbl u_t017_015/c1_w0_bl u_t017_015/c1_w0_br
+ u_t017_015/c1_w1_bl u_t017_015/c1_w1_br u_t017_015/c1_r0_rbl u_t017_015/c1_r1_rbl
+ u_t017_015/c2_w0_bl u_t017_015/c2_w0_br u_t017_015/c2_w1_bl u_t017_015/c2_w1_br
+ u_t017_015/c2_r0_rbl u_t017_015/c2_r1_rbl u_t017_015/c3_w0_bl u_t017_015/c3_w0_br
+ u_t017_015/c3_w1_bl u_t017_015/c3_w1_br u_t017_015/c3_r0_rbl u_t017_015/c3_r1_rbl
+ u_t017_015/r0_w0_wl u_t017_015/r0_w1_wl u_t017_015/r0_r0_rwl u_t017_015/r0_r1_rwl
+ u_t017_015/r1_w0_wl u_t017_015/r1_w1_wl u_t017_015/r1_r0_rwl u_t017_015/r1_r1_rwl
+ u_t017_015/r2_w0_wl u_t017_015/r2_w1_wl u_t017_015/r2_r0_rwl u_t017_015/r2_r1_rwl
+ u_t017_015/r3_w0_wl u_t017_015/r3_w1_wl u_t017_015/r3_r0_rwl u_t017_015/r3_r1_rwl
+ VSS VSS u_t017_015/m2_717_1265# u_t017_015/m2_603_2031# u_t017_015/m2_1290_336#
+ u_t017_015/m2_2000_2037# u_t017_015/m2_791_2909# u_t017_015/m2_7_2126# u_t017_015/m2_2154_2081#
+ u_t017_015/m2_1795_2037# u_t017_015/m2_871_303# u_t017_015/m2_431_438# u_t017_015/m2_1290_2898#
+ u_t017_015/m2_1714_1210# u_t017_015/m2_431_1982# u_t017_015/m2_512_1265# u_t017_015/m2_2573_2126#
+ u_t017_015/m2_603_1259# u_t017_015/m2_2074_2909# u_t017_015/m2_7_336# u_t017_015/m2_717_2037#
+ u_t017_015/m2_1886_2031# u_t017_015/m2_2573_336# u_t017_015/m2_7_2898# u_t017_015/m2_2000_1265#
+ u_t017_015/m2_512_2037# u_t017_015/m2_1795_1265# u_t017_015/m2_1714_1982# u_t017_015/m2_1886_1259#
+ u_t017_015/m2_1290_2126# u_t017_015/m2_1714_438# u_t017_015/m2_431_1210# u_t017_015/m2_2573_2898#
+ u_t017_015/m2_2154_303# u_t017_015/m2_871_2081# VSUBS detronyx_12t_2w2r_rc4_4x4_routed_5layer_direct
Xu_t017_004 u_t017_004/c0_w0_bl u_t017_004/c0_w0_br u_t017_004/c0_w1_bl u_t017_004/c0_w1_br
+ u_t017_004/c0_r0_rbl u_t017_004/c0_r1_rbl u_t017_004/c1_w0_bl u_t017_004/c1_w0_br
+ u_t017_004/c1_w1_bl u_t017_004/c1_w1_br u_t017_004/c1_r0_rbl u_t017_004/c1_r1_rbl
+ u_t017_004/c2_w0_bl u_t017_004/c2_w0_br u_t017_004/c2_w1_bl u_t017_004/c2_w1_br
+ u_t017_004/c2_r0_rbl u_t017_004/c2_r1_rbl u_t017_004/c3_w0_bl u_t017_004/c3_w0_br
+ u_t017_004/c3_w1_bl u_t017_004/c3_w1_br u_t017_004/c3_r0_rbl u_t017_004/c3_r1_rbl
+ u_t017_004/r0_w0_wl u_t017_004/r0_w1_wl u_t017_004/r0_r0_rwl u_t017_004/r0_r1_rwl
+ u_t017_004/r1_w0_wl u_t017_004/r1_w1_wl u_t017_004/r1_r0_rwl u_t017_004/r1_r1_rwl
+ u_t017_004/r2_w0_wl u_t017_004/r2_w1_wl u_t017_004/r2_r0_rwl u_t017_004/r2_r1_rwl
+ u_t017_004/r3_w0_wl u_t017_004/r3_w1_wl u_t017_004/r3_r0_rwl u_t017_004/r3_r1_rwl
+ VSS VSS u_t017_004/m2_717_1265# u_t017_004/m2_603_2031# u_t017_004/m2_1290_336#
+ u_t017_004/m2_2000_2037# u_t017_004/m2_791_2909# u_t017_004/m2_7_2126# u_t017_004/m2_2154_2081#
+ u_t017_004/m2_1795_2037# u_t017_004/m2_871_303# u_t017_004/m2_431_438# u_t017_004/m2_1290_2898#
+ u_t017_004/m2_1714_1210# u_t017_004/m2_431_1982# u_t017_004/m2_512_1265# u_t017_004/m2_2573_2126#
+ u_t017_004/m2_603_1259# u_t017_004/m2_2074_2909# u_t017_004/m2_7_336# u_t017_004/m2_717_2037#
+ u_t017_004/m2_1886_2031# u_t017_004/m2_2573_336# u_t017_004/m2_7_2898# u_t017_004/m2_2000_1265#
+ u_t017_004/m2_512_2037# u_t017_004/m2_1795_1265# u_t017_004/m2_1714_1982# u_t017_004/m2_1886_1259#
+ u_t017_004/m2_1290_2126# u_t017_004/m2_1714_438# u_t017_004/m2_431_1210# u_t017_004/m2_2573_2898#
+ u_t017_004/m2_2154_303# u_t017_004/m2_871_2081# VSUBS detronyx_12t_2w2r_rc4_4x4_routed_5layer_direct
Xgf180mcu_as_sc_mcu7t3v3__inv_2_107 VSS VSS gf180mcu_as_sc_mcu7t3v3__inv_2_107/Y gf180mcu_as_sc_mcu7t3v3__nand4_2_9/Y
+ gf180mcu_as_sc_mcu7t3v3__nand4_2_9/VNW VSUBS gf180mcu_as_sc_mcu7t3v3__inv_2
Xgf180mcu_as_sc_mcu7t3v3__inv_2_129 VSS VSS VSS gf180mcu_as_sc_mcu7t3v3__inv_2_130/Y
+ gf180mcu_as_sc_mcu7t3v3__inv_2_131/VNW VSUBS gf180mcu_as_sc_mcu7t3v3__inv_2
Xgf180mcu_as_sc_mcu7t3v3__inv_2_118 VSS VSS gf180mcu_as_sc_mcu7t3v3__inv_2_118/Y gf180mcu_as_sc_mcu7t3v3__inv_2_119/Y
+ gf180mcu_as_sc_mcu7t3v3__inv_2_119/VNW VSUBS gf180mcu_as_sc_mcu7t3v3__inv_2
Xgf180mcu_as_sc_mcu7t3v3__inv_2_1190 VSS VSS gf180mcu_as_sc_mcu7t3v3__inv_2_1190/Y
+ gf180mcu_as_sc_mcu7t3v3__inv_2_1190/A gf180mcu_as_sc_mcu7t3v3__inv_2_1268/VNW VSUBS
+ gf180mcu_as_sc_mcu7t3v3__inv_2
Xu_t008_015 u_t008_015/c0_w0_bl u_t008_015/c0_w0_br u_t008_015/c0_w1_bl u_t008_015/c0_w1_br
+ u_t008_015/c0_r0_rbl u_t008_015/c0_r1_rbl u_t008_015/c1_w0_bl u_t008_015/c1_w0_br
+ u_t008_015/c1_w1_bl u_t008_015/c1_w1_br u_t008_015/c1_r0_rbl u_t008_015/c1_r1_rbl
+ u_t008_015/c2_w0_bl u_t008_015/c2_w0_br u_t008_015/c2_w1_bl u_t008_015/c2_w1_br
+ u_t008_015/c2_r0_rbl u_t008_015/c2_r1_rbl u_t008_015/c3_w0_bl u_t008_015/c3_w0_br
+ u_t008_015/c3_w1_bl u_t008_015/c3_w1_br u_t008_015/c3_r0_rbl u_t008_015/c3_r1_rbl
+ u_t008_015/r0_w0_wl u_t008_015/r0_w1_wl u_t008_015/r0_r0_rwl u_t008_015/r0_r1_rwl
+ u_t008_015/r1_w0_wl u_t008_015/r1_w1_wl u_t008_015/r1_r0_rwl u_t008_015/r1_r1_rwl
+ u_t008_015/r2_w0_wl u_t008_015/r2_w1_wl u_t008_015/r2_r0_rwl u_t008_015/r2_r1_rwl
+ u_t008_015/r3_w0_wl u_t008_015/r3_w1_wl u_t008_015/r3_r0_rwl u_t008_015/r3_r1_rwl
+ VSS VSS u_t008_015/m2_717_1265# u_t008_015/m2_603_2031# u_t008_015/m2_1290_336#
+ u_t008_015/m2_2000_2037# u_t008_015/m2_791_2909# u_t008_015/m2_7_2126# u_t008_015/m2_2154_2081#
+ u_t008_015/m2_1795_2037# u_t008_015/m2_871_303# u_t008_015/m2_431_438# u_t008_015/m2_1290_2898#
+ u_t008_015/m2_1714_1210# u_t008_015/m2_431_1982# u_t008_015/m2_512_1265# u_t008_015/m2_2573_2126#
+ u_t008_015/m2_603_1259# u_t008_015/m2_2074_2909# u_t008_015/m2_7_336# u_t008_015/m2_717_2037#
+ u_t008_015/m2_1886_2031# u_t008_015/m2_2573_336# u_t008_015/m2_7_2898# u_t008_015/m2_2000_1265#
+ u_t008_015/m2_512_2037# u_t008_015/m2_1795_1265# u_t008_015/m2_1714_1982# u_t008_015/m2_1886_1259#
+ u_t008_015/m2_1290_2126# u_t008_015/m2_1714_438# u_t008_015/m2_431_1210# u_t008_015/m2_2573_2898#
+ u_t008_015/m2_2154_303# u_t008_015/m2_871_2081# VSUBS detronyx_12t_2w2r_rc4_4x4_routed_5layer_direct
Xu_t008_004 u_t008_004/c0_w0_bl u_t008_004/c0_w0_br u_t008_004/c0_w1_bl u_t008_004/c0_w1_br
+ u_t008_004/c0_r0_rbl u_t008_004/c0_r1_rbl u_t008_004/c1_w0_bl u_t008_004/c1_w0_br
+ u_t008_004/c1_w1_bl u_t008_004/c1_w1_br u_t008_004/c1_r0_rbl u_t008_004/c1_r1_rbl
+ u_t008_004/c2_w0_bl u_t008_004/c2_w0_br u_t008_004/c2_w1_bl u_t008_004/c2_w1_br
+ u_t008_004/c2_r0_rbl u_t008_004/c2_r1_rbl u_t008_004/c3_w0_bl u_t008_004/c3_w0_br
+ u_t008_004/c3_w1_bl u_t008_004/c3_w1_br u_t008_004/c3_r0_rbl u_t008_004/c3_r1_rbl
+ u_t008_004/r0_w0_wl u_t008_004/r0_w1_wl u_t008_004/r0_r0_rwl u_t008_004/r0_r1_rwl
+ u_t008_004/r1_w0_wl u_t008_004/r1_w1_wl u_t008_004/r1_r0_rwl u_t008_004/r1_r1_rwl
+ u_t008_004/r2_w0_wl u_t008_004/r2_w1_wl u_t008_004/r2_r0_rwl u_t008_004/r2_r1_rwl
+ u_t008_004/r3_w0_wl u_t008_004/r3_w1_wl u_t008_004/r3_r0_rwl u_t008_004/r3_r1_rwl
+ VSS VSS u_t008_004/m2_717_1265# u_t008_004/m2_603_2031# u_t008_004/m2_1290_336#
+ u_t008_004/m2_2000_2037# u_t008_004/m2_791_2909# u_t008_004/m2_7_2126# u_t008_004/m2_2154_2081#
+ u_t008_004/m2_1795_2037# u_t008_004/m2_871_303# u_t008_004/m2_431_438# u_t008_004/m2_1290_2898#
+ u_t008_004/m2_1714_1210# u_t008_004/m2_431_1982# u_t008_004/m2_512_1265# u_t008_004/m2_2573_2126#
+ u_t008_004/m2_603_1259# u_t008_004/m2_2074_2909# u_t008_004/m2_7_336# u_t008_004/m2_717_2037#
+ u_t008_004/m2_1886_2031# u_t008_004/m2_2573_336# u_t008_004/m2_7_2898# u_t008_004/m2_2000_1265#
+ u_t008_004/m2_512_2037# u_t008_004/m2_1795_1265# u_t008_004/m2_1714_1982# u_t008_004/m2_1886_1259#
+ u_t008_004/m2_1290_2126# u_t008_004/m2_1714_438# u_t008_004/m2_431_1210# u_t008_004/m2_2573_2898#
+ u_t008_004/m2_2154_303# u_t008_004/m2_871_2081# VSUBS detronyx_12t_2w2r_rc4_4x4_routed_5layer_direct
Xu_t023_007 u_t023_007/c0_w0_bl u_t023_007/c0_w0_br u_t023_007/c0_w1_bl u_t023_007/c0_w1_br
+ u_t023_007/c0_r0_rbl u_t023_007/c0_r1_rbl u_t023_007/c1_w0_bl u_t023_007/c1_w0_br
+ u_t023_007/c1_w1_bl u_t023_007/c1_w1_br u_t023_007/c1_r0_rbl u_t023_007/c1_r1_rbl
+ u_t023_007/c2_w0_bl u_t023_007/c2_w0_br u_t023_007/c2_w1_bl u_t023_007/c2_w1_br
+ u_t023_007/c2_r0_rbl u_t023_007/c2_r1_rbl u_t023_007/c3_w0_bl u_t023_007/c3_w0_br
+ u_t023_007/c3_w1_bl u_t023_007/c3_w1_br u_t023_007/c3_r0_rbl u_t023_007/c3_r1_rbl
+ u_t023_007/r0_w0_wl u_t023_007/r0_w1_wl u_t023_007/r0_r0_rwl u_t023_007/r0_r1_rwl
+ u_t023_007/r1_w0_wl u_t023_007/r1_w1_wl u_t023_007/r1_r0_rwl u_t023_007/r1_r1_rwl
+ u_t023_007/r2_w0_wl u_t023_007/r2_w1_wl u_t023_007/r2_r0_rwl u_t023_007/r2_r1_rwl
+ u_t023_007/r3_w0_wl u_t023_007/r3_w1_wl u_t023_007/r3_r0_rwl u_t023_007/r3_r1_rwl
+ VSS VSS u_t023_007/m2_717_1265# u_t023_007/m2_603_2031# u_t023_007/m2_1290_336#
+ u_t023_007/m2_2000_2037# u_t023_007/m2_791_2909# u_t023_007/m2_7_2126# u_t023_007/m2_2154_2081#
+ u_t023_007/m2_1795_2037# u_t023_007/m2_871_303# u_t023_007/m2_431_438# u_t023_007/m2_1290_2898#
+ u_t023_007/m2_1714_1210# u_t023_007/m2_431_1982# u_t023_007/m2_512_1265# u_t023_007/m2_2573_2126#
+ u_t023_007/m2_603_1259# u_t023_007/m2_2074_2909# u_t023_007/m2_7_336# u_t023_007/m2_717_2037#
+ u_t023_007/m2_1886_2031# u_t023_007/m2_2573_336# u_t023_007/m2_7_2898# u_t023_007/m2_2000_1265#
+ u_t023_007/m2_512_2037# u_t023_007/m2_1795_1265# u_t023_007/m2_1714_1982# u_t023_007/m2_1886_1259#
+ u_t023_007/m2_1290_2126# u_t023_007/m2_1714_438# u_t023_007/m2_431_1210# u_t023_007/m2_2573_2898#
+ u_t023_007/m2_2154_303# u_t023_007/m2_871_2081# VSUBS detronyx_12t_2w2r_rc4_4x4_routed_5layer_direct
Xgf180mcu_as_sc_mcu7t3v3__inv_2_641 VSS VSS gf180mcu_as_sc_mcu7t3v3__inv_2_641/Y gf180mcu_as_sc_mcu7t3v3__inv_2_641/A
+ gf180mcu_as_sc_mcu7t3v3__inv_2_641/VNW VSUBS gf180mcu_as_sc_mcu7t3v3__inv_2
Xgf180mcu_as_sc_mcu7t3v3__inv_2_630 VSS VSS VSS gf180mcu_as_sc_mcu7t3v3__inv_2_631/Y
+ gf180mcu_as_sc_mcu7t3v3__inv_2_632/VNW VSUBS gf180mcu_as_sc_mcu7t3v3__inv_2
Xgf180mcu_as_sc_mcu7t3v3__inv_2_652 VSS VSS gf180mcu_as_sc_mcu7t3v3__inv_2_652/Y gf180mcu_as_sc_mcu7t3v3__inv_2_652/A
+ gf180mcu_as_sc_mcu7t3v3__inv_2_652/VNW VSUBS gf180mcu_as_sc_mcu7t3v3__inv_2
Xgf180mcu_as_sc_mcu7t3v3__inv_2_663 VSS VSS gf180mcu_as_sc_mcu7t3v3__inv_2_663/Y gf180mcu_as_sc_mcu7t3v3__inv_2_664/Y
+ gf180mcu_as_sc_mcu7t3v3__inv_2_664/VNW VSUBS gf180mcu_as_sc_mcu7t3v3__inv_2
Xgf180mcu_as_sc_mcu7t3v3__inv_2_674 VSS VSS gf180mcu_as_sc_mcu7t3v3__inv_2_674/Y gf180mcu_as_sc_mcu7t3v3__inv_2_674/A
+ gf180mcu_as_sc_mcu7t3v3__inv_2_674/VNW VSUBS gf180mcu_as_sc_mcu7t3v3__inv_2
Xgf180mcu_as_sc_mcu7t3v3__inv_2_685 VSS VSS gf180mcu_as_sc_mcu7t3v3__inv_2_685/Y gf180mcu_as_sc_mcu7t3v3__inv_2_689/Y
+ gf180mcu_as_sc_mcu7t3v3__inv_2_689/VNW VSUBS gf180mcu_as_sc_mcu7t3v3__inv_2
Xgf180mcu_as_sc_mcu7t3v3__inv_2_696 VSS VSS gf180mcu_as_sc_mcu7t3v3__inv_2_733/A gf180mcu_as_sc_mcu7t3v3__inv_2_696/A
+ gf180mcu_as_sc_mcu7t3v3__inv_2_733/VNW VSUBS gf180mcu_as_sc_mcu7t3v3__inv_2
Xu_t014_007 u_t014_007/c0_w0_bl u_t014_007/c0_w0_br u_t014_007/c0_w1_bl u_t014_007/c0_w1_br
+ u_t014_007/c0_r0_rbl u_t014_007/c0_r1_rbl u_t014_007/c1_w0_bl u_t014_007/c1_w0_br
+ u_t014_007/c1_w1_bl u_t014_007/c1_w1_br u_t014_007/c1_r0_rbl u_t014_007/c1_r1_rbl
+ u_t014_007/c2_w0_bl u_t014_007/c2_w0_br u_t014_007/c2_w1_bl u_t014_007/c2_w1_br
+ u_t014_007/c2_r0_rbl u_t014_007/c2_r1_rbl u_t014_007/c3_w0_bl u_t014_007/c3_w0_br
+ u_t014_007/c3_w1_bl u_t014_007/c3_w1_br u_t014_007/c3_r0_rbl u_t014_007/c3_r1_rbl
+ u_t014_007/r0_w0_wl u_t014_007/r0_w1_wl u_t014_007/r0_r0_rwl u_t014_007/r0_r1_rwl
+ u_t014_007/r1_w0_wl u_t014_007/r1_w1_wl u_t014_007/r1_r0_rwl u_t014_007/r1_r1_rwl
+ u_t014_007/r2_w0_wl u_t014_007/r2_w1_wl u_t014_007/r2_r0_rwl u_t014_007/r2_r1_rwl
+ u_t014_007/r3_w0_wl u_t014_007/r3_w1_wl u_t014_007/r3_r0_rwl u_t014_007/r3_r1_rwl
+ VSS VSS u_t014_007/m2_717_1265# u_t014_007/m2_603_2031# u_t014_007/m2_1290_336#
+ u_t014_007/m2_2000_2037# u_t014_007/m2_791_2909# u_t014_007/m2_7_2126# u_t014_007/m2_2154_2081#
+ u_t014_007/m2_1795_2037# u_t014_007/m2_871_303# u_t014_007/m2_431_438# u_t014_007/m2_1290_2898#
+ u_t014_007/m2_1714_1210# u_t014_007/m2_431_1982# u_t014_007/m2_512_1265# u_t014_007/m2_2573_2126#
+ u_t014_007/m2_603_1259# u_t014_007/m2_2074_2909# u_t014_007/m2_7_336# u_t014_007/m2_717_2037#
+ u_t014_007/m2_1886_2031# u_t014_007/m2_2573_336# u_t014_007/m2_7_2898# u_t014_007/m2_2000_1265#
+ u_t014_007/m2_512_2037# u_t014_007/m2_1795_1265# u_t014_007/m2_1714_1982# u_t014_007/m2_1886_1259#
+ u_t014_007/m2_1290_2126# u_t014_007/m2_1714_438# u_t014_007/m2_431_1210# u_t014_007/m2_2573_2898#
+ u_t014_007/m2_2154_303# u_t014_007/m2_871_2081# VSUBS detronyx_12t_2w2r_rc4_4x4_routed_5layer_direct
Xgf180mcu_as_sc_mcu7t3v3__nand2_2_19 gf180mcu_as_sc_mcu7t3v3__nand3_2_9/VDD gf180mcu_as_sc_mcu7t3v3__nor2_2_4/VSS
+ VSS VSS VSS gf180mcu_as_sc_mcu7t3v3__nand3_2_9/VNW VSUBS gf180mcu_as_sc_mcu7t3v3__nand2_2
Xu_t005_007 u_t005_007/c0_w0_bl u_t005_007/c0_w0_br u_t005_007/c0_w1_bl u_t005_007/c0_w1_br
+ u_t005_007/c0_r0_rbl u_t005_007/c0_r1_rbl u_t005_007/c1_w0_bl u_t005_007/c1_w0_br
+ u_t005_007/c1_w1_bl u_t005_007/c1_w1_br u_t005_007/c1_r0_rbl u_t005_007/c1_r1_rbl
+ u_t005_007/c2_w0_bl u_t005_007/c2_w0_br u_t005_007/c2_w1_bl u_t005_007/c2_w1_br
+ u_t005_007/c2_r0_rbl u_t005_007/c2_r1_rbl u_t005_007/c3_w0_bl u_t005_007/c3_w0_br
+ u_t005_007/c3_w1_bl u_t005_007/c3_w1_br u_t005_007/c3_r0_rbl u_t005_007/c3_r1_rbl
+ u_t005_007/r0_w0_wl u_t005_007/r0_w1_wl u_t005_007/r0_r0_rwl u_t005_007/r0_r1_rwl
+ u_t005_007/r1_w0_wl u_t005_007/r1_w1_wl u_t005_007/r1_r0_rwl u_t005_007/r1_r1_rwl
+ u_t005_007/r2_w0_wl u_t005_007/r2_w1_wl u_t005_007/r2_r0_rwl u_t005_007/r2_r1_rwl
+ u_t005_007/r3_w0_wl u_t005_007/r3_w1_wl u_t005_007/r3_r0_rwl u_t005_007/r3_r1_rwl
+ VSS VSS u_t005_007/m2_717_1265# u_t005_007/m2_603_2031# u_t005_007/m2_1290_336#
+ u_t005_007/m2_2000_2037# u_t005_007/m2_791_2909# u_t005_007/m2_7_2126# u_t005_007/m2_2154_2081#
+ u_t005_007/m2_1795_2037# u_t005_007/m2_871_303# u_t005_007/m2_431_438# u_t005_007/m2_1290_2898#
+ u_t005_007/m2_1714_1210# u_t005_007/m2_431_1982# u_t005_007/m2_512_1265# u_t005_007/m2_2573_2126#
+ u_t005_007/m2_603_1259# u_t005_007/m2_2074_2909# u_t005_007/m2_7_336# u_t005_007/m2_717_2037#
+ u_t005_007/m2_1886_2031# u_t005_007/m2_2573_336# u_t005_007/m2_7_2898# u_t005_007/m2_2000_1265#
+ u_t005_007/m2_512_2037# u_t005_007/m2_1795_1265# u_t005_007/m2_1714_1982# u_t005_007/m2_1886_1259#
+ u_t005_007/m2_1290_2126# u_t005_007/m2_1714_438# u_t005_007/m2_431_1210# u_t005_007/m2_2573_2898#
+ u_t005_007/m2_2154_303# u_t005_007/m2_871_2081# VSUBS detronyx_12t_2w2r_rc4_4x4_routed_5layer_direct
Xgf180mcu_as_sc_mcu7t3v3__inv_2_482 VSS VSS gf180mcu_as_sc_mcu7t3v3__inv_2_482/Y gf180mcu_as_sc_mcu7t3v3__inv_2_482/A
+ gf180mcu_as_sc_mcu7t3v3__inv_2_547/VNW VSUBS gf180mcu_as_sc_mcu7t3v3__inv_2
Xgf180mcu_as_sc_mcu7t3v3__inv_2_460 gf180mcu_as_sc_mcu7t3v3__nor2_2_6/VDD gf180mcu_as_sc_mcu7t3v3__nor2_2_6/VSS
+ gf180mcu_as_sc_mcu7t3v3__inv_2_460/Y VSS gf180mcu_as_sc_mcu7t3v3__nor2_2_6/VNW VSUBS
+ gf180mcu_as_sc_mcu7t3v3__inv_2
Xgf180mcu_as_sc_mcu7t3v3__inv_2_471 gf180mcu_as_sc_mcu7t3v3__nor2_2_6/VDD gf180mcu_as_sc_mcu7t3v3__nor2_2_6/VSS
+ VSS VSS gf180mcu_as_sc_mcu7t3v3__nor2_2_6/VNW VSUBS gf180mcu_as_sc_mcu7t3v3__inv_2
Xgf180mcu_as_sc_mcu7t3v3__inv_2_493 VSS VSS gf180mcu_as_sc_mcu7t3v3__inv_2_554/A gf180mcu_as_sc_mcu7t3v3__inv_2_494/Y
+ gf180mcu_as_sc_mcu7t3v3__inv_2_554/VNW VSUBS gf180mcu_as_sc_mcu7t3v3__inv_2
Xu_t010_010 u_t010_010/c0_w0_bl u_t010_010/c0_w0_br u_t010_010/c0_w1_bl u_t010_010/c0_w1_br
+ u_t010_010/c0_r0_rbl u_t010_010/c0_r1_rbl u_t010_010/c1_w0_bl u_t010_010/c1_w0_br
+ u_t010_010/c1_w1_bl u_t010_010/c1_w1_br u_t010_010/c1_r0_rbl u_t010_010/c1_r1_rbl
+ u_t010_010/c2_w0_bl u_t010_010/c2_w0_br u_t010_010/c2_w1_bl u_t010_010/c2_w1_br
+ u_t010_010/c2_r0_rbl u_t010_010/c2_r1_rbl u_t010_010/c3_w0_bl u_t010_010/c3_w0_br
+ u_t010_010/c3_w1_bl u_t010_010/c3_w1_br u_t010_010/c3_r0_rbl u_t010_010/c3_r1_rbl
+ u_t010_010/r0_w0_wl u_t010_010/r0_w1_wl u_t010_010/r0_r0_rwl u_t010_010/r0_r1_rwl
+ u_t010_010/r1_w0_wl u_t010_010/r1_w1_wl u_t010_010/r1_r0_rwl u_t010_010/r1_r1_rwl
+ u_t010_010/r2_w0_wl u_t010_010/r2_w1_wl u_t010_010/r2_r0_rwl u_t010_010/r2_r1_rwl
+ u_t010_010/r3_w0_wl u_t010_010/r3_w1_wl u_t010_010/r3_r0_rwl u_t010_010/r3_r1_rwl
+ VSS VSS u_t010_010/m2_717_1265# u_t010_010/m2_603_2031# u_t010_010/m2_1290_336#
+ u_t010_010/m2_2000_2037# u_t010_010/m2_791_2909# u_t010_010/m2_7_2126# u_t010_010/m2_2154_2081#
+ u_t010_010/m2_1795_2037# u_t010_010/m2_871_303# u_t010_010/m2_431_438# u_t010_010/m2_1290_2898#
+ u_t010_010/m2_1714_1210# u_t010_010/m2_431_1982# u_t010_010/m2_512_1265# u_t010_010/m2_2573_2126#
+ u_t010_010/m2_603_1259# u_t010_010/m2_2074_2909# u_t010_010/m2_7_336# u_t010_010/m2_717_2037#
+ u_t010_010/m2_1886_2031# u_t010_010/m2_2573_336# u_t010_010/m2_7_2898# u_t010_010/m2_2000_1265#
+ u_t010_010/m2_512_2037# u_t010_010/m2_1795_1265# u_t010_010/m2_1714_1982# u_t010_010/m2_1886_1259#
+ u_t010_010/m2_1290_2126# u_t010_010/m2_1714_438# u_t010_010/m2_431_1210# u_t010_010/m2_2573_2898#
+ u_t010_010/m2_2154_303# u_t010_010/m2_871_2081# VSUBS detronyx_12t_2w2r_rc4_4x4_routed_5layer_direct
Xu_t001_010 u_t001_010/c0_w0_bl u_t001_010/c0_w0_br u_t001_010/c0_w1_bl u_t001_010/c0_w1_br
+ u_t001_010/c0_r0_rbl u_t001_010/c0_r1_rbl u_t001_010/c1_w0_bl u_t001_010/c1_w0_br
+ u_t001_010/c1_w1_bl u_t001_010/c1_w1_br u_t001_010/c1_r0_rbl u_t001_010/c1_r1_rbl
+ u_t001_010/c2_w0_bl u_t001_010/c2_w0_br u_t001_010/c2_w1_bl u_t001_010/c2_w1_br
+ u_t001_010/c2_r0_rbl u_t001_010/c2_r1_rbl u_t001_010/c3_w0_bl u_t001_010/c3_w0_br
+ u_t001_010/c3_w1_bl u_t001_010/c3_w1_br u_t001_010/c3_r0_rbl u_t001_010/c3_r1_rbl
+ u_t001_010/r0_w0_wl u_t001_010/r0_w1_wl u_t001_010/r0_r0_rwl u_t001_010/r0_r1_rwl
+ u_t001_010/r1_w0_wl u_t001_010/r1_w1_wl u_t001_010/r1_r0_rwl u_t001_010/r1_r1_rwl
+ u_t001_010/r2_w0_wl u_t001_010/r2_w1_wl u_t001_010/r2_r0_rwl u_t001_010/r2_r1_rwl
+ u_t001_010/r3_w0_wl u_t001_010/r3_w1_wl u_t001_010/r3_r0_rwl u_t001_010/r3_r1_rwl
+ VSS VSS u_t001_010/m2_717_1265# u_t001_010/m2_603_2031# u_t001_010/m2_1290_336#
+ u_t001_010/m2_2000_2037# u_t001_010/m2_791_2909# u_t001_010/m2_7_2126# u_t001_010/m2_2154_2081#
+ u_t001_010/m2_1795_2037# u_t001_010/m2_871_303# u_t001_010/m2_431_438# u_t001_010/m2_1290_2898#
+ u_t001_010/m2_1714_1210# u_t001_010/m2_431_1982# u_t001_010/m2_512_1265# u_t001_010/m2_2573_2126#
+ u_t001_010/m2_603_1259# u_t001_010/m2_2074_2909# u_t001_010/m2_7_336# u_t001_010/m2_717_2037#
+ u_t001_010/m2_1886_2031# u_t001_010/m2_2573_336# u_t001_010/m2_7_2898# u_t001_010/m2_2000_1265#
+ u_t001_010/m2_512_2037# u_t001_010/m2_1795_1265# u_t001_010/m2_1714_1982# u_t001_010/m2_1886_1259#
+ u_t001_010/m2_1290_2126# u_t001_010/m2_1714_438# u_t001_010/m2_431_1210# u_t001_010/m2_2573_2898#
+ u_t001_010/m2_2154_303# u_t001_010/m2_871_2081# VSUBS detronyx_12t_2w2r_rc4_4x4_routed_5layer_direct
Xgf180mcu_as_sc_mcu7t3v3__inv_2_1712 gf180mcu_as_sc_mcu7t3v3__nor2_2_9/VDD gf180mcu_as_sc_mcu7t3v3__nand3_2_63/VSS
+ VSS VSS gf180mcu_as_sc_mcu7t3v3__nor2_2_9/VNW VSUBS gf180mcu_as_sc_mcu7t3v3__inv_2
Xgf180mcu_as_sc_mcu7t3v3__inv_2_1701 gf180mcu_as_sc_mcu7t3v3__nor2_2_7/VDD gf180mcu_as_sc_mcu7t3v3__nand3_2_4/VSS
+ VSS VSS gf180mcu_as_sc_mcu7t3v3__nor2_2_7/VNW VSUBS gf180mcu_as_sc_mcu7t3v3__inv_2
Xgf180mcu_as_sc_mcu7t3v3__inv_2_290 VSS VSS gf180mcu_as_sc_mcu7t3v3__inv_2_304/A gf180mcu_as_sc_mcu7t3v3__inv_2_290/A
+ gf180mcu_as_sc_mcu7t3v3__inv_2_304/VNW VSUBS gf180mcu_as_sc_mcu7t3v3__inv_2
Xgf180mcu_as_sc_mcu7t3v3__inv_2_1723 VSS VSS gf180mcu_as_sc_mcu7t3v3__inv_2_1723/Y
+ gf180mcu_as_sc_mcu7t3v3__inv_2_1723/A gf180mcu_as_sc_mcu7t3v3__inv_2_1723/VNW VSUBS
+ gf180mcu_as_sc_mcu7t3v3__inv_2
Xgf180mcu_as_sc_mcu7t3v3__nand4_2_506 VSS VSS VSS VSS VSS VSS gf180mcu_as_sc_mcu7t3v3__inv_2_1627/A
+ gf180mcu_as_sc_mcu7t3v3__inv_2_1627/VNW VSUBS gf180mcu_as_sc_mcu7t3v3__nand4_2
Xgf180mcu_as_sc_mcu7t3v3__inv_2_16 VSS VSS gf180mcu_as_sc_mcu7t3v3__inv_2_16/Y gf180mcu_as_sc_mcu7t3v3__inv_2_16/A
+ gf180mcu_as_sc_mcu7t3v3__inv_2_16/VNW VSUBS gf180mcu_as_sc_mcu7t3v3__inv_2
Xgf180mcu_as_sc_mcu7t3v3__inv_2_1008 VSS VSS gf180mcu_as_sc_mcu7t3v3__inv_2_1053/A
+ gf180mcu_as_sc_mcu7t3v3__inv_2_1008/A gf180mcu_as_sc_mcu7t3v3__inv_2_1053/VNW VSUBS
+ gf180mcu_as_sc_mcu7t3v3__inv_2
Xgf180mcu_as_sc_mcu7t3v3__inv_2_27 VSS VSS gf180mcu_as_sc_mcu7t3v3__inv_2_27/Y gf180mcu_as_sc_mcu7t3v3__inv_2_28/Y
+ gf180mcu_as_sc_mcu7t3v3__inv_2_28/VNW VSUBS gf180mcu_as_sc_mcu7t3v3__inv_2
Xgf180mcu_as_sc_mcu7t3v3__inv_2_49 VSS VSS gf180mcu_as_sc_mcu7t3v3__inv_2_49/Y gf180mcu_as_sc_mcu7t3v3__inv_2_49/A
+ gf180mcu_as_sc_mcu7t3v3__inv_2_49/VNW VSUBS gf180mcu_as_sc_mcu7t3v3__inv_2
Xgf180mcu_as_sc_mcu7t3v3__inv_2_38 VSS VSS gf180mcu_as_sc_mcu7t3v3__inv_2_38/Y gf180mcu_as_sc_mcu7t3v3__inv_2_38/A
+ gf180mcu_as_sc_mcu7t3v3__inv_2_38/VNW VSUBS gf180mcu_as_sc_mcu7t3v3__inv_2
Xgf180mcu_as_sc_mcu7t3v3__inv_2_1019 VSS VSS gf180mcu_as_sc_mcu7t3v3__inv_2_1019/Y
+ gf180mcu_as_sc_mcu7t3v3__inv_2_1020/Y gf180mcu_as_sc_mcu7t3v3__inv_2_1020/VNW VSUBS
+ gf180mcu_as_sc_mcu7t3v3__inv_2
Xgf180mcu_as_sc_mcu7t3v3__inv_2_1597 VSS VSS gf180mcu_as_sc_mcu7t3v3__inv_2_1597/Y
+ gf180mcu_as_sc_mcu7t3v3__inv_2_1597/A gf180mcu_as_sc_mcu7t3v3__inv_2_1597/VNW VSUBS
+ gf180mcu_as_sc_mcu7t3v3__inv_2
Xgf180mcu_as_sc_mcu7t3v3__inv_2_1564 VSS VSS gf180mcu_as_sc_mcu7t3v3__inv_2_1564/Y
+ gf180mcu_as_sc_mcu7t3v3__inv_2_1564/A gf180mcu_as_sc_mcu7t3v3__inv_2_1598/VNW VSUBS
+ gf180mcu_as_sc_mcu7t3v3__inv_2
Xgf180mcu_as_sc_mcu7t3v3__inv_2_1586 VSS VSS gf180mcu_as_sc_mcu7t3v3__inv_2_1586/Y
+ gf180mcu_as_sc_mcu7t3v3__inv_2_1587/Y gf180mcu_as_sc_mcu7t3v3__inv_2_1587/VNW VSUBS
+ gf180mcu_as_sc_mcu7t3v3__inv_2
Xgf180mcu_as_sc_mcu7t3v3__inv_2_1575 VSS VSS gf180mcu_as_sc_mcu7t3v3__inv_2_1575/Y
+ gf180mcu_as_sc_mcu7t3v3__inv_2_1576/Y gf180mcu_as_sc_mcu7t3v3__inv_2_1576/VNW VSUBS
+ gf180mcu_as_sc_mcu7t3v3__inv_2
Xgf180mcu_as_sc_mcu7t3v3__inv_2_1542 VSS VSS VSS gf180mcu_as_sc_mcu7t3v3__inv_2_1543/Y
+ gf180mcu_as_sc_mcu7t3v3__inv_2_1544/VNW VSUBS gf180mcu_as_sc_mcu7t3v3__inv_2
Xgf180mcu_as_sc_mcu7t3v3__inv_2_1553 VSS VSS gf180mcu_as_sc_mcu7t3v3__inv_2_1553/Y
+ gf180mcu_as_sc_mcu7t3v3__inv_2_1553/A gf180mcu_as_sc_mcu7t3v3__inv_2_1553/VNW VSUBS
+ gf180mcu_as_sc_mcu7t3v3__inv_2
Xgf180mcu_as_sc_mcu7t3v3__inv_2_1520 VSS VSS gf180mcu_as_sc_mcu7t3v3__inv_2_1520/Y
+ gf180mcu_as_sc_mcu7t3v3__inv_2_1520/A gf180mcu_as_sc_mcu7t3v3__inv_2_1520/VNW VSUBS
+ gf180mcu_as_sc_mcu7t3v3__inv_2
Xgf180mcu_as_sc_mcu7t3v3__inv_2_1531 VSS VSS gf180mcu_as_sc_mcu7t3v3__inv_2_1531/Y
+ gf180mcu_as_sc_mcu7t3v3__inv_2_1532/Y gf180mcu_as_sc_mcu7t3v3__inv_2_1532/VNW VSUBS
+ gf180mcu_as_sc_mcu7t3v3__inv_2
Xgf180mcu_as_sc_mcu7t3v3__nand3_2_8 gf180mcu_as_sc_mcu7t3v3__nor2_2_7/VDD gf180mcu_as_sc_mcu7t3v3__nor2_2_7/VSS
+ VSS VSS VSS VSS gf180mcu_as_sc_mcu7t3v3__nor2_2_7/VNW VSUBS gf180mcu_as_sc_mcu7t3v3__nand3_2
Xgf180mcu_as_sc_mcu7t3v3__nand4_2_336 VSS VSS VSS VSS VSS VSS gf180mcu_as_sc_mcu7t3v3__inv_2_1133/A
+ gf180mcu_as_sc_mcu7t3v3__inv_2_1133/VNW VSUBS gf180mcu_as_sc_mcu7t3v3__nand4_2
Xgf180mcu_as_sc_mcu7t3v3__nand4_2_369 VSS VSS VSS VSS VSS VSS gf180mcu_as_sc_mcu7t3v3__inv_2_1222/A
+ gf180mcu_as_sc_mcu7t3v3__inv_2_1283/VNW VSUBS gf180mcu_as_sc_mcu7t3v3__nand4_2
Xgf180mcu_as_sc_mcu7t3v3__nand4_2_347 VSS VSS VSS VSS VSS VSS gf180mcu_as_sc_mcu7t3v3__inv_2_1151/A
+ gf180mcu_as_sc_mcu7t3v3__inv_2_1151/VNW VSUBS gf180mcu_as_sc_mcu7t3v3__nand4_2
Xgf180mcu_as_sc_mcu7t3v3__nand4_2_358 VSS VSS VSS VSS VSS VSS gf180mcu_as_sc_mcu7t3v3__inv_2_1172/A
+ gf180mcu_as_sc_mcu7t3v3__inv_2_1294/VNW VSUBS gf180mcu_as_sc_mcu7t3v3__nand4_2
Xgf180mcu_as_sc_mcu7t3v3__nand4_2_325 VSS VSS VSS VSS VSS VSS gf180mcu_as_sc_mcu7t3v3__inv_2_1095/A
+ gf180mcu_as_sc_mcu7t3v3__inv_2_1095/VNW VSUBS gf180mcu_as_sc_mcu7t3v3__nand4_2
Xgf180mcu_as_sc_mcu7t3v3__nand4_2_314 VSS VSS VSS VSS VSS VSS gf180mcu_as_sc_mcu7t3v3__inv_2_1036/A
+ gf180mcu_as_sc_mcu7t3v3__inv_2_1036/VNW VSUBS gf180mcu_as_sc_mcu7t3v3__nand4_2
Xgf180mcu_as_sc_mcu7t3v3__nand4_2_303 VSS VSS VSS VSS VSS VSS gf180mcu_as_sc_mcu7t3v3__inv_2_973/A
+ gf180mcu_as_sc_mcu7t3v3__inv_2_989/VNW VSUBS gf180mcu_as_sc_mcu7t3v3__nand4_2
Xu_t029_013 u_t029_013/c0_w0_bl u_t029_013/c0_w0_br u_t029_013/c0_w1_bl u_t029_013/c0_w1_br
+ u_t029_013/c0_r0_rbl u_t029_013/c0_r1_rbl u_t029_013/c1_w0_bl u_t029_013/c1_w0_br
+ u_t029_013/c1_w1_bl u_t029_013/c1_w1_br u_t029_013/c1_r0_rbl u_t029_013/c1_r1_rbl
+ u_t029_013/c2_w0_bl u_t029_013/c2_w0_br u_t029_013/c2_w1_bl u_t029_013/c2_w1_br
+ u_t029_013/c2_r0_rbl u_t029_013/c2_r1_rbl u_t029_013/c3_w0_bl u_t029_013/c3_w0_br
+ u_t029_013/c3_w1_bl u_t029_013/c3_w1_br u_t029_013/c3_r0_rbl u_t029_013/c3_r1_rbl
+ u_t029_013/r0_w0_wl u_t029_013/r0_w1_wl u_t029_013/r0_r0_rwl u_t029_013/r0_r1_rwl
+ u_t029_013/r1_w0_wl u_t029_013/r1_w1_wl u_t029_013/r1_r0_rwl u_t029_013/r1_r1_rwl
+ u_t029_013/r2_w0_wl u_t029_013/r2_w1_wl u_t029_013/r2_r0_rwl u_t029_013/r2_r1_rwl
+ u_t029_013/r3_w0_wl u_t029_013/r3_w1_wl u_t029_013/r3_r0_rwl u_t029_013/r3_r1_rwl
+ VSS VSS u_t029_013/m2_717_1265# u_t029_013/m2_603_2031# u_t029_013/m2_1290_336#
+ u_t029_013/m2_2000_2037# u_t029_013/m2_791_2909# u_t029_013/m2_7_2126# u_t029_013/m2_2154_2081#
+ u_t029_013/m2_1795_2037# u_t029_013/m2_871_303# u_t029_013/m2_431_438# u_t029_013/m2_1290_2898#
+ u_t029_013/m2_1714_1210# u_t029_013/m2_431_1982# u_t029_013/m2_512_1265# u_t029_013/m2_2573_2126#
+ u_t029_013/m2_603_1259# u_t029_013/m2_2074_2909# u_t029_013/m2_7_336# u_t029_013/m2_717_2037#
+ u_t029_013/m2_1886_2031# u_t029_013/m2_2573_336# u_t029_013/m2_7_2898# u_t029_013/m2_2000_1265#
+ u_t029_013/m2_512_2037# u_t029_013/m2_1795_1265# u_t029_013/m2_1714_1982# u_t029_013/m2_1886_1259#
+ u_t029_013/m2_1290_2126# u_t029_013/m2_1714_438# u_t029_013/m2_431_1210# u_t029_013/m2_2573_2898#
+ u_t029_013/m2_2154_303# u_t029_013/m2_871_2081# VSUBS detronyx_12t_2w2r_rc4_4x4_routed_5layer_direct
Xu_t029_002 u_t029_002/c0_w0_bl u_t029_002/c0_w0_br u_t029_002/c0_w1_bl u_t029_002/c0_w1_br
+ u_t029_002/c0_r0_rbl u_t029_002/c0_r1_rbl u_t029_002/c1_w0_bl u_t029_002/c1_w0_br
+ u_t029_002/c1_w1_bl u_t029_002/c1_w1_br u_t029_002/c1_r0_rbl u_t029_002/c1_r1_rbl
+ u_t029_002/c2_w0_bl u_t029_002/c2_w0_br u_t029_002/c2_w1_bl u_t029_002/c2_w1_br
+ u_t029_002/c2_r0_rbl u_t029_002/c2_r1_rbl u_t029_002/c3_w0_bl u_t029_002/c3_w0_br
+ u_t029_002/c3_w1_bl u_t029_002/c3_w1_br u_t029_002/c3_r0_rbl u_t029_002/c3_r1_rbl
+ u_t029_002/r0_w0_wl u_t029_002/r0_w1_wl u_t029_002/r0_r0_rwl u_t029_002/r0_r1_rwl
+ u_t029_002/r1_w0_wl u_t029_002/r1_w1_wl u_t029_002/r1_r0_rwl u_t029_002/r1_r1_rwl
+ u_t029_002/r2_w0_wl u_t029_002/r2_w1_wl u_t029_002/r2_r0_rwl u_t029_002/r2_r1_rwl
+ u_t029_002/r3_w0_wl u_t029_002/r3_w1_wl u_t029_002/r3_r0_rwl u_t029_002/r3_r1_rwl
+ VSS VSS u_t029_002/m2_717_1265# u_t029_002/m2_603_2031# u_t029_002/m2_1290_336#
+ u_t029_002/m2_2000_2037# u_t029_002/m2_791_2909# u_t029_002/m2_7_2126# u_t029_002/m2_2154_2081#
+ u_t029_002/m2_1795_2037# u_t029_002/m2_871_303# u_t029_002/m2_431_438# u_t029_002/m2_1290_2898#
+ u_t029_002/m2_1714_1210# u_t029_002/m2_431_1982# u_t029_002/m2_512_1265# u_t029_002/m2_2573_2126#
+ u_t029_002/m2_603_1259# u_t029_002/m2_2074_2909# u_t029_002/m2_7_336# u_t029_002/m2_717_2037#
+ u_t029_002/m2_1886_2031# u_t029_002/m2_2573_336# u_t029_002/m2_7_2898# u_t029_002/m2_2000_1265#
+ u_t029_002/m2_512_2037# u_t029_002/m2_1795_1265# u_t029_002/m2_1714_1982# u_t029_002/m2_1886_1259#
+ u_t029_002/m2_1290_2126# u_t029_002/m2_1714_438# u_t029_002/m2_431_1210# u_t029_002/m2_2573_2898#
+ u_t029_002/m2_2154_303# u_t029_002/m2_871_2081# VSUBS detronyx_12t_2w2r_rc4_4x4_routed_5layer_direct
Xgf180mcu_as_sc_mcu7t3v3__inv_2_1361 VSS VSS gf180mcu_as_sc_mcu7t3v3__inv_2_1361/Y
+ gf180mcu_as_sc_mcu7t3v3__inv_2_1362/Y gf180mcu_as_sc_mcu7t3v3__inv_2_1362/VNW VSUBS
+ gf180mcu_as_sc_mcu7t3v3__inv_2
Xgf180mcu_as_sc_mcu7t3v3__inv_2_1372 VSS VSS VSS gf180mcu_as_sc_mcu7t3v3__inv_2_1373/Y
+ gf180mcu_as_sc_mcu7t3v3__inv_2_1374/VNW VSUBS gf180mcu_as_sc_mcu7t3v3__inv_2
Xgf180mcu_as_sc_mcu7t3v3__inv_2_1394 VSS VSS gf180mcu_as_sc_mcu7t3v3__inv_2_1394/Y
+ gf180mcu_as_sc_mcu7t3v3__inv_2_1394/A gf180mcu_as_sc_mcu7t3v3__inv_2_1394/VNW VSUBS
+ gf180mcu_as_sc_mcu7t3v3__inv_2
Xgf180mcu_as_sc_mcu7t3v3__inv_2_1383 VSS VSS VSS gf180mcu_as_sc_mcu7t3v3__inv_2_1387/Y
+ gf180mcu_as_sc_mcu7t3v3__inv_2_1391/VNW VSUBS gf180mcu_as_sc_mcu7t3v3__inv_2
Xgf180mcu_as_sc_mcu7t3v3__inv_2_1350 VSS VSS VSS gf180mcu_as_sc_mcu7t3v3__inv_2_1351/Y
+ gf180mcu_as_sc_mcu7t3v3__inv_2_1352/VNW VSUBS gf180mcu_as_sc_mcu7t3v3__inv_2
Xgf180mcu_as_sc_mcu7t3v3__inv_2_856 VSS VSS gf180mcu_as_sc_mcu7t3v3__inv_2_856/Y gf180mcu_as_sc_mcu7t3v3__inv_2_857/Y
+ gf180mcu_as_sc_mcu7t3v3__inv_2_857/VNW VSUBS gf180mcu_as_sc_mcu7t3v3__inv_2
Xgf180mcu_as_sc_mcu7t3v3__inv_2_823 VSS VSS VSS gf180mcu_as_sc_mcu7t3v3__inv_2_823/A
+ gf180mcu_as_sc_mcu7t3v3__inv_2_823/VNW VSUBS gf180mcu_as_sc_mcu7t3v3__inv_2
Xgf180mcu_as_sc_mcu7t3v3__inv_2_834 VSS VSS VSS gf180mcu_as_sc_mcu7t3v3__inv_2_834/A
+ gf180mcu_as_sc_mcu7t3v3__inv_2_834/VNW VSUBS gf180mcu_as_sc_mcu7t3v3__inv_2
Xgf180mcu_as_sc_mcu7t3v3__inv_2_801 VSS VSS gf180mcu_as_sc_mcu7t3v3__inv_2_801/Y gf180mcu_as_sc_mcu7t3v3__inv_2_801/A
+ gf180mcu_as_sc_mcu7t3v3__inv_2_847/VNW VSUBS gf180mcu_as_sc_mcu7t3v3__inv_2
Xgf180mcu_as_sc_mcu7t3v3__inv_2_845 VSS VSS VSS gf180mcu_as_sc_mcu7t3v3__inv_2_845/A
+ gf180mcu_as_sc_mcu7t3v3__inv_2_845/VNW VSUBS gf180mcu_as_sc_mcu7t3v3__inv_2
Xgf180mcu_as_sc_mcu7t3v3__inv_2_812 VSS VSS gf180mcu_as_sc_mcu7t3v3__inv_2_812/Y gf180mcu_as_sc_mcu7t3v3__inv_2_812/A
+ gf180mcu_as_sc_mcu7t3v3__inv_2_840/VNW VSUBS gf180mcu_as_sc_mcu7t3v3__inv_2
Xgf180mcu_as_sc_mcu7t3v3__inv_2_889 VSS VSS gf180mcu_as_sc_mcu7t3v3__inv_2_936/A gf180mcu_as_sc_mcu7t3v3__inv_2_889/A
+ gf180mcu_as_sc_mcu7t3v3__inv_2_936/VNW VSUBS gf180mcu_as_sc_mcu7t3v3__inv_2
Xgf180mcu_as_sc_mcu7t3v3__inv_2_878 VSS VSS gf180mcu_as_sc_mcu7t3v3__inv_2_932/A gf180mcu_as_sc_mcu7t3v3__inv_2_879/Y
+ gf180mcu_as_sc_mcu7t3v3__inv_2_932/VNW VSUBS gf180mcu_as_sc_mcu7t3v3__inv_2
Xgf180mcu_as_sc_mcu7t3v3__inv_2_867 VSS VSS gf180mcu_as_sc_mcu7t3v3__inv_2_928/A gf180mcu_as_sc_mcu7t3v3__inv_2_868/Y
+ gf180mcu_as_sc_mcu7t3v3__inv_2_928/VNW VSUBS gf180mcu_as_sc_mcu7t3v3__inv_2
Xgf180mcu_as_sc_mcu7t3v3__nand4_2_133 VSS VSS VSS VSS VSS VSS gf180mcu_as_sc_mcu7t3v3__inv_2_490/A
+ gf180mcu_as_sc_mcu7t3v3__inv_2_560/VNW VSUBS gf180mcu_as_sc_mcu7t3v3__nand4_2
Xgf180mcu_as_sc_mcu7t3v3__nand4_2_144 VSS VSS VSS VSS VSS VSS gf180mcu_as_sc_mcu7t3v3__inv_2_509/A
+ gf180mcu_as_sc_mcu7t3v3__inv_2_539/VNW VSUBS gf180mcu_as_sc_mcu7t3v3__nand4_2
Xgf180mcu_as_sc_mcu7t3v3__nand4_2_122 VSS VSS VSS VSS VSS VSS gf180mcu_as_sc_mcu7t3v3__inv_2_292/A
+ gf180mcu_as_sc_mcu7t3v3__inv_2_302/VNW VSUBS gf180mcu_as_sc_mcu7t3v3__nand4_2
Xgf180mcu_as_sc_mcu7t3v3__nand4_2_111 VSS VSS VSS VSS VSS VSS gf180mcu_as_sc_mcu7t3v3__inv_2_307/A
+ gf180mcu_as_sc_mcu7t3v3__inv_2_307/VNW VSUBS gf180mcu_as_sc_mcu7t3v3__nand4_2
Xgf180mcu_as_sc_mcu7t3v3__nand4_2_100 VSS VSS VSS VSS VSS VSS gf180mcu_as_sc_mcu7t3v3__inv_2_353/A
+ gf180mcu_as_sc_mcu7t3v3__inv_2_353/VNW VSUBS gf180mcu_as_sc_mcu7t3v3__nand4_2
Xu_t026_005 u_t026_005/c0_w0_bl u_t026_005/c0_w0_br u_t026_005/c0_w1_bl u_t026_005/c0_w1_br
+ u_t026_005/c0_r0_rbl u_t026_005/c0_r1_rbl u_t026_005/c1_w0_bl u_t026_005/c1_w0_br
+ u_t026_005/c1_w1_bl u_t026_005/c1_w1_br u_t026_005/c1_r0_rbl u_t026_005/c1_r1_rbl
+ u_t026_005/c2_w0_bl u_t026_005/c2_w0_br u_t026_005/c2_w1_bl u_t026_005/c2_w1_br
+ u_t026_005/c2_r0_rbl u_t026_005/c2_r1_rbl u_t026_005/c3_w0_bl u_t026_005/c3_w0_br
+ u_t026_005/c3_w1_bl u_t026_005/c3_w1_br u_t026_005/c3_r0_rbl u_t026_005/c3_r1_rbl
+ u_t026_005/r0_w0_wl u_t026_005/r0_w1_wl u_t026_005/r0_r0_rwl u_t026_005/r0_r1_rwl
+ u_t026_005/r1_w0_wl u_t026_005/r1_w1_wl u_t026_005/r1_r0_rwl u_t026_005/r1_r1_rwl
+ u_t026_005/r2_w0_wl u_t026_005/r2_w1_wl u_t026_005/r2_r0_rwl u_t026_005/r2_r1_rwl
+ u_t026_005/r3_w0_wl u_t026_005/r3_w1_wl u_t026_005/r3_r0_rwl u_t026_005/r3_r1_rwl
+ VSS VSS u_t026_005/m2_717_1265# u_t026_005/m2_603_2031# u_t026_005/m2_1290_336#
+ u_t026_005/m2_2000_2037# u_t026_005/m2_791_2909# u_t026_005/m2_7_2126# u_t026_005/m2_2154_2081#
+ u_t026_005/m2_1795_2037# u_t026_005/m2_871_303# u_t026_005/m2_431_438# u_t026_005/m2_1290_2898#
+ u_t026_005/m2_1714_1210# u_t026_005/m2_431_1982# u_t026_005/m2_512_1265# u_t026_005/m2_2573_2126#
+ u_t026_005/m2_603_1259# u_t026_005/m2_2074_2909# u_t026_005/m2_7_336# u_t026_005/m2_717_2037#
+ u_t026_005/m2_1886_2031# u_t026_005/m2_2573_336# u_t026_005/m2_7_2898# u_t026_005/m2_2000_1265#
+ u_t026_005/m2_512_2037# u_t026_005/m2_1795_1265# u_t026_005/m2_1714_1982# u_t026_005/m2_1886_1259#
+ u_t026_005/m2_1290_2126# u_t026_005/m2_1714_438# u_t026_005/m2_431_1210# u_t026_005/m2_2573_2898#
+ u_t026_005/m2_2154_303# u_t026_005/m2_871_2081# VSUBS detronyx_12t_2w2r_rc4_4x4_routed_5layer_direct
Xgf180mcu_as_sc_mcu7t3v3__nand4_2_61 VSS VSS VSS VSS VSS VSS gf180mcu_as_sc_mcu7t3v3__inv_2_36/A
+ gf180mcu_as_sc_mcu7t3v3__inv_2_36/VNW VSUBS gf180mcu_as_sc_mcu7t3v3__nand4_2
Xgf180mcu_as_sc_mcu7t3v3__nand4_2_155 VSS VSS VSS VSS VSS VSS gf180mcu_as_sc_mcu7t3v3__inv_2_564/A
+ gf180mcu_as_sc_mcu7t3v3__inv_2_590/VNW VSUBS gf180mcu_as_sc_mcu7t3v3__nand4_2
Xgf180mcu_as_sc_mcu7t3v3__nand4_2_94 VSS VSS VSS VSS VSS VSS gf180mcu_as_sc_mcu7t3v3__inv_2_43/A
+ gf180mcu_as_sc_mcu7t3v3__inv_2_43/VNW VSUBS gf180mcu_as_sc_mcu7t3v3__nand4_2
Xgf180mcu_as_sc_mcu7t3v3__nand4_2_177 VSS VSS VSS VSS VSS VSS gf180mcu_as_sc_mcu7t3v3__inv_2_603/A
+ gf180mcu_as_sc_mcu7t3v3__inv_2_603/VNW VSUBS gf180mcu_as_sc_mcu7t3v3__nand4_2
Xgf180mcu_as_sc_mcu7t3v3__nand4_2_166 VSS VSS VSS VSS VSS VSS gf180mcu_as_sc_mcu7t3v3__inv_2_632/A
+ gf180mcu_as_sc_mcu7t3v3__inv_2_632/VNW VSUBS gf180mcu_as_sc_mcu7t3v3__nand4_2
Xgf180mcu_as_sc_mcu7t3v3__nand4_2_83 VSS VSS VSS VSS VSS VSS gf180mcu_as_sc_mcu7t3v3__inv_2_65/A
+ gf180mcu_as_sc_mcu7t3v3__inv_2_65/VNW VSUBS gf180mcu_as_sc_mcu7t3v3__nand4_2
Xgf180mcu_as_sc_mcu7t3v3__nand4_2_199 VSS VSS VSS VSS VSS VSS gf180mcu_as_sc_mcu7t3v3__inv_2_680/A
+ gf180mcu_as_sc_mcu7t3v3__inv_2_680/VNW VSUBS gf180mcu_as_sc_mcu7t3v3__nand4_2
Xgf180mcu_as_sc_mcu7t3v3__nand4_2_188 VSS VSS VSS VSS VSS VSS gf180mcu_as_sc_mcu7t3v3__inv_2_724/A
+ gf180mcu_as_sc_mcu7t3v3__inv_2_724/VNW VSUBS gf180mcu_as_sc_mcu7t3v3__nand4_2
Xgf180mcu_as_sc_mcu7t3v3__nand4_2_50 VSS VSS VSS VSS VSS VSS gf180mcu_as_sc_mcu7t3v3__inv_2_230/A
+ gf180mcu_as_sc_mcu7t3v3__inv_2_230/VNW VSUBS gf180mcu_as_sc_mcu7t3v3__nand4_2
Xgf180mcu_as_sc_mcu7t3v3__nand4_2_72 VSS VSS VSS VSS VSS VSS gf180mcu_as_sc_mcu7t3v3__inv_2_320/A
+ gf180mcu_as_sc_mcu7t3v3__inv_2_320/VNW VSUBS gf180mcu_as_sc_mcu7t3v3__nand4_2
Xu_t017_005 u_t017_005/c0_w0_bl u_t017_005/c0_w0_br u_t017_005/c0_w1_bl u_t017_005/c0_w1_br
+ u_t017_005/c0_r0_rbl u_t017_005/c0_r1_rbl u_t017_005/c1_w0_bl u_t017_005/c1_w0_br
+ u_t017_005/c1_w1_bl u_t017_005/c1_w1_br u_t017_005/c1_r0_rbl u_t017_005/c1_r1_rbl
+ u_t017_005/c2_w0_bl u_t017_005/c2_w0_br u_t017_005/c2_w1_bl u_t017_005/c2_w1_br
+ u_t017_005/c2_r0_rbl u_t017_005/c2_r1_rbl u_t017_005/c3_w0_bl u_t017_005/c3_w0_br
+ u_t017_005/c3_w1_bl u_t017_005/c3_w1_br u_t017_005/c3_r0_rbl u_t017_005/c3_r1_rbl
+ u_t017_005/r0_w0_wl u_t017_005/r0_w1_wl u_t017_005/r0_r0_rwl u_t017_005/r0_r1_rwl
+ u_t017_005/r1_w0_wl u_t017_005/r1_w1_wl u_t017_005/r1_r0_rwl u_t017_005/r1_r1_rwl
+ u_t017_005/r2_w0_wl u_t017_005/r2_w1_wl u_t017_005/r2_r0_rwl u_t017_005/r2_r1_rwl
+ u_t017_005/r3_w0_wl u_t017_005/r3_w1_wl u_t017_005/r3_r0_rwl u_t017_005/r3_r1_rwl
+ VSS VSS u_t017_005/m2_717_1265# u_t017_005/m2_603_2031# u_t017_005/m2_1290_336#
+ u_t017_005/m2_2000_2037# u_t017_005/m2_791_2909# u_t017_005/m2_7_2126# u_t017_005/m2_2154_2081#
+ u_t017_005/m2_1795_2037# u_t017_005/m2_871_303# u_t017_005/m2_431_438# u_t017_005/m2_1290_2898#
+ u_t017_005/m2_1714_1210# u_t017_005/m2_431_1982# u_t017_005/m2_512_1265# u_t017_005/m2_2573_2126#
+ u_t017_005/m2_603_1259# u_t017_005/m2_2074_2909# u_t017_005/m2_7_336# u_t017_005/m2_717_2037#
+ u_t017_005/m2_1886_2031# u_t017_005/m2_2573_336# u_t017_005/m2_7_2898# u_t017_005/m2_2000_1265#
+ u_t017_005/m2_512_2037# u_t017_005/m2_1795_1265# u_t017_005/m2_1714_1982# u_t017_005/m2_1886_1259#
+ u_t017_005/m2_1290_2126# u_t017_005/m2_1714_438# u_t017_005/m2_431_1210# u_t017_005/m2_2573_2898#
+ u_t017_005/m2_2154_303# u_t017_005/m2_871_2081# VSUBS detronyx_12t_2w2r_rc4_4x4_routed_5layer_direct
Xgf180mcu_as_sc_mcu7t3v3__inv_2_119 VSS VSS gf180mcu_as_sc_mcu7t3v3__inv_2_119/Y gf180mcu_as_sc_mcu7t3v3__inv_2_119/A
+ gf180mcu_as_sc_mcu7t3v3__inv_2_119/VNW VSUBS gf180mcu_as_sc_mcu7t3v3__inv_2
Xgf180mcu_as_sc_mcu7t3v3__inv_2_108 VSS VSS VSS gf180mcu_as_sc_mcu7t3v3__inv_2_109/Y
+ gf180mcu_as_sc_mcu7t3v3__inv_2_110/VNW VSUBS gf180mcu_as_sc_mcu7t3v3__inv_2
Xgf180mcu_as_sc_mcu7t3v3__inv_2_1180 VSS VSS gf180mcu_as_sc_mcu7t3v3__inv_2_1300/A
+ gf180mcu_as_sc_mcu7t3v3__inv_2_1183/Y gf180mcu_as_sc_mcu7t3v3__inv_2_1300/VNW VSUBS
+ gf180mcu_as_sc_mcu7t3v3__inv_2
Xgf180mcu_as_sc_mcu7t3v3__inv_2_1191 gf180mcu_as_sc_mcu7t3v3__nand3_2_65/VDD gf180mcu_as_sc_mcu7t3v3__nand3_2_62/VSS
+ gf180mcu_as_sc_mcu7t3v3__inv_2_1191/Y VSS gf180mcu_as_sc_mcu7t3v3__nand3_2_65/VNW
+ VSUBS gf180mcu_as_sc_mcu7t3v3__inv_2
Xu_t008_005 u_t008_005/c0_w0_bl u_t008_005/c0_w0_br u_t008_005/c0_w1_bl u_t008_005/c0_w1_br
+ u_t008_005/c0_r0_rbl u_t008_005/c0_r1_rbl u_t008_005/c1_w0_bl u_t008_005/c1_w0_br
+ u_t008_005/c1_w1_bl u_t008_005/c1_w1_br u_t008_005/c1_r0_rbl u_t008_005/c1_r1_rbl
+ u_t008_005/c2_w0_bl u_t008_005/c2_w0_br u_t008_005/c2_w1_bl u_t008_005/c2_w1_br
+ u_t008_005/c2_r0_rbl u_t008_005/c2_r1_rbl u_t008_005/c3_w0_bl u_t008_005/c3_w0_br
+ u_t008_005/c3_w1_bl u_t008_005/c3_w1_br u_t008_005/c3_r0_rbl u_t008_005/c3_r1_rbl
+ u_t008_005/r0_w0_wl u_t008_005/r0_w1_wl u_t008_005/r0_r0_rwl u_t008_005/r0_r1_rwl
+ u_t008_005/r1_w0_wl u_t008_005/r1_w1_wl u_t008_005/r1_r0_rwl u_t008_005/r1_r1_rwl
+ u_t008_005/r2_w0_wl u_t008_005/r2_w1_wl u_t008_005/r2_r0_rwl u_t008_005/r2_r1_rwl
+ u_t008_005/r3_w0_wl u_t008_005/r3_w1_wl u_t008_005/r3_r0_rwl u_t008_005/r3_r1_rwl
+ VSS VSS u_t008_005/m2_717_1265# u_t008_005/m2_603_2031# u_t008_005/m2_1290_336#
+ u_t008_005/m2_2000_2037# u_t008_005/m2_791_2909# u_t008_005/m2_7_2126# u_t008_005/m2_2154_2081#
+ u_t008_005/m2_1795_2037# u_t008_005/m2_871_303# u_t008_005/m2_431_438# u_t008_005/m2_1290_2898#
+ u_t008_005/m2_1714_1210# u_t008_005/m2_431_1982# u_t008_005/m2_512_1265# u_t008_005/m2_2573_2126#
+ u_t008_005/m2_603_1259# u_t008_005/m2_2074_2909# u_t008_005/m2_7_336# u_t008_005/m2_717_2037#
+ u_t008_005/m2_1886_2031# u_t008_005/m2_2573_336# u_t008_005/m2_7_2898# u_t008_005/m2_2000_1265#
+ u_t008_005/m2_512_2037# u_t008_005/m2_1795_1265# u_t008_005/m2_1714_1982# u_t008_005/m2_1886_1259#
+ u_t008_005/m2_1290_2126# u_t008_005/m2_1714_438# u_t008_005/m2_431_1210# u_t008_005/m2_2573_2898#
+ u_t008_005/m2_2154_303# u_t008_005/m2_871_2081# VSUBS detronyx_12t_2w2r_rc4_4x4_routed_5layer_direct
Xgf180mcu_as_sc_mcu7t3v3__inv_2_620 VSS VSS gf180mcu_as_sc_mcu7t3v3__inv_2_620/Y gf180mcu_as_sc_mcu7t3v3__inv_2_620/A
+ gf180mcu_as_sc_mcu7t3v3__inv_2_620/VNW VSUBS gf180mcu_as_sc_mcu7t3v3__inv_2
Xu_t023_008 u_t023_008/c0_w0_bl u_t023_008/c0_w0_br u_t023_008/c0_w1_bl u_t023_008/c0_w1_br
+ u_t023_008/c0_r0_rbl u_t023_008/c0_r1_rbl u_t023_008/c1_w0_bl u_t023_008/c1_w0_br
+ u_t023_008/c1_w1_bl u_t023_008/c1_w1_br u_t023_008/c1_r0_rbl u_t023_008/c1_r1_rbl
+ u_t023_008/c2_w0_bl u_t023_008/c2_w0_br u_t023_008/c2_w1_bl u_t023_008/c2_w1_br
+ u_t023_008/c2_r0_rbl u_t023_008/c2_r1_rbl u_t023_008/c3_w0_bl u_t023_008/c3_w0_br
+ u_t023_008/c3_w1_bl u_t023_008/c3_w1_br u_t023_008/c3_r0_rbl u_t023_008/c3_r1_rbl
+ u_t023_008/r0_w0_wl u_t023_008/r0_w1_wl u_t023_008/r0_r0_rwl u_t023_008/r0_r1_rwl
+ u_t023_008/r1_w0_wl u_t023_008/r1_w1_wl u_t023_008/r1_r0_rwl u_t023_008/r1_r1_rwl
+ u_t023_008/r2_w0_wl u_t023_008/r2_w1_wl u_t023_008/r2_r0_rwl u_t023_008/r2_r1_rwl
+ u_t023_008/r3_w0_wl u_t023_008/r3_w1_wl u_t023_008/r3_r0_rwl u_t023_008/r3_r1_rwl
+ VSS VSS u_t023_008/m2_717_1265# u_t023_008/m2_603_2031# u_t023_008/m2_1290_336#
+ u_t023_008/m2_2000_2037# u_t023_008/m2_791_2909# u_t023_008/m2_7_2126# u_t023_008/m2_2154_2081#
+ u_t023_008/m2_1795_2037# u_t023_008/m2_871_303# u_t023_008/m2_431_438# u_t023_008/m2_1290_2898#
+ u_t023_008/m2_1714_1210# u_t023_008/m2_431_1982# u_t023_008/m2_512_1265# u_t023_008/m2_2573_2126#
+ u_t023_008/m2_603_1259# u_t023_008/m2_2074_2909# u_t023_008/m2_7_336# u_t023_008/m2_717_2037#
+ u_t023_008/m2_1886_2031# u_t023_008/m2_2573_336# u_t023_008/m2_7_2898# u_t023_008/m2_2000_1265#
+ u_t023_008/m2_512_2037# u_t023_008/m2_1795_1265# u_t023_008/m2_1714_1982# u_t023_008/m2_1886_1259#
+ u_t023_008/m2_1290_2126# u_t023_008/m2_1714_438# u_t023_008/m2_431_1210# u_t023_008/m2_2573_2898#
+ u_t023_008/m2_2154_303# u_t023_008/m2_871_2081# VSUBS detronyx_12t_2w2r_rc4_4x4_routed_5layer_direct
Xgf180mcu_as_sc_mcu7t3v3__inv_2_631 VSS VSS gf180mcu_as_sc_mcu7t3v3__inv_2_631/Y gf180mcu_as_sc_mcu7t3v3__inv_2_632/Y
+ gf180mcu_as_sc_mcu7t3v3__inv_2_632/VNW VSUBS gf180mcu_as_sc_mcu7t3v3__inv_2
Xgf180mcu_as_sc_mcu7t3v3__inv_2_686 VSS VSS VSS gf180mcu_as_sc_mcu7t3v3__inv_2_687/Y
+ gf180mcu_as_sc_mcu7t3v3__inv_2_688/VNW VSUBS gf180mcu_as_sc_mcu7t3v3__inv_2
Xgf180mcu_as_sc_mcu7t3v3__inv_2_664 VSS VSS gf180mcu_as_sc_mcu7t3v3__inv_2_664/Y gf180mcu_as_sc_mcu7t3v3__inv_2_664/A
+ gf180mcu_as_sc_mcu7t3v3__inv_2_664/VNW VSUBS gf180mcu_as_sc_mcu7t3v3__inv_2
Xgf180mcu_as_sc_mcu7t3v3__inv_2_642 VSS VSS gf180mcu_as_sc_mcu7t3v3__inv_2_643/A gf180mcu_as_sc_mcu7t3v3__inv_2_642/A
+ gf180mcu_as_sc_mcu7t3v3__inv_2_665/VNW VSUBS gf180mcu_as_sc_mcu7t3v3__inv_2
Xgf180mcu_as_sc_mcu7t3v3__inv_2_675 VSS VSS gf180mcu_as_sc_mcu7t3v3__inv_2_675/Y gf180mcu_as_sc_mcu7t3v3__inv_2_679/Y
+ gf180mcu_as_sc_mcu7t3v3__inv_2_679/VNW VSUBS gf180mcu_as_sc_mcu7t3v3__inv_2
Xgf180mcu_as_sc_mcu7t3v3__inv_2_653 VSS VSS VSS gf180mcu_as_sc_mcu7t3v3__inv_2_657/Y
+ gf180mcu_as_sc_mcu7t3v3__inv_2_661/VNW VSUBS gf180mcu_as_sc_mcu7t3v3__inv_2
Xgf180mcu_as_sc_mcu7t3v3__inv_2_697 VSS VSS gf180mcu_as_sc_mcu7t3v3__inv_2_697/Y gf180mcu_as_sc_mcu7t3v3__inv_2_701/Y
+ gf180mcu_as_sc_mcu7t3v3__inv_2_701/VNW VSUBS gf180mcu_as_sc_mcu7t3v3__inv_2
Xu_t014_008 u_t014_008/c0_w0_bl u_t014_008/c0_w0_br u_t014_008/c0_w1_bl u_t014_008/c0_w1_br
+ u_t014_008/c0_r0_rbl u_t014_008/c0_r1_rbl u_t014_008/c1_w0_bl u_t014_008/c1_w0_br
+ u_t014_008/c1_w1_bl u_t014_008/c1_w1_br u_t014_008/c1_r0_rbl u_t014_008/c1_r1_rbl
+ u_t014_008/c2_w0_bl u_t014_008/c2_w0_br u_t014_008/c2_w1_bl u_t014_008/c2_w1_br
+ u_t014_008/c2_r0_rbl u_t014_008/c2_r1_rbl u_t014_008/c3_w0_bl u_t014_008/c3_w0_br
+ u_t014_008/c3_w1_bl u_t014_008/c3_w1_br u_t014_008/c3_r0_rbl u_t014_008/c3_r1_rbl
+ u_t014_008/r0_w0_wl u_t014_008/r0_w1_wl u_t014_008/r0_r0_rwl u_t014_008/r0_r1_rwl
+ u_t014_008/r1_w0_wl u_t014_008/r1_w1_wl u_t014_008/r1_r0_rwl u_t014_008/r1_r1_rwl
+ u_t014_008/r2_w0_wl u_t014_008/r2_w1_wl u_t014_008/r2_r0_rwl u_t014_008/r2_r1_rwl
+ u_t014_008/r3_w0_wl u_t014_008/r3_w1_wl u_t014_008/r3_r0_rwl u_t014_008/r3_r1_rwl
+ VSS VSS u_t014_008/m2_717_1265# u_t014_008/m2_603_2031# u_t014_008/m2_1290_336#
+ u_t014_008/m2_2000_2037# u_t014_008/m2_791_2909# u_t014_008/m2_7_2126# u_t014_008/m2_2154_2081#
+ u_t014_008/m2_1795_2037# u_t014_008/m2_871_303# u_t014_008/m2_431_438# u_t014_008/m2_1290_2898#
+ u_t014_008/m2_1714_1210# u_t014_008/m2_431_1982# u_t014_008/m2_512_1265# u_t014_008/m2_2573_2126#
+ u_t014_008/m2_603_1259# u_t014_008/m2_2074_2909# u_t014_008/m2_7_336# u_t014_008/m2_717_2037#
+ u_t014_008/m2_1886_2031# u_t014_008/m2_2573_336# u_t014_008/m2_7_2898# u_t014_008/m2_2000_1265#
+ u_t014_008/m2_512_2037# u_t014_008/m2_1795_1265# u_t014_008/m2_1714_1982# u_t014_008/m2_1886_1259#
+ u_t014_008/m2_1290_2126# u_t014_008/m2_1714_438# u_t014_008/m2_431_1210# u_t014_008/m2_2573_2898#
+ u_t014_008/m2_2154_303# u_t014_008/m2_871_2081# VSUBS detronyx_12t_2w2r_rc4_4x4_routed_5layer_direct
Xu_t005_008 u_t005_008/c0_w0_bl u_t005_008/c0_w0_br u_t005_008/c0_w1_bl u_t005_008/c0_w1_br
+ u_t005_008/c0_r0_rbl u_t005_008/c0_r1_rbl u_t005_008/c1_w0_bl u_t005_008/c1_w0_br
+ u_t005_008/c1_w1_bl u_t005_008/c1_w1_br u_t005_008/c1_r0_rbl u_t005_008/c1_r1_rbl
+ u_t005_008/c2_w0_bl u_t005_008/c2_w0_br u_t005_008/c2_w1_bl u_t005_008/c2_w1_br
+ u_t005_008/c2_r0_rbl u_t005_008/c2_r1_rbl u_t005_008/c3_w0_bl u_t005_008/c3_w0_br
+ u_t005_008/c3_w1_bl u_t005_008/c3_w1_br u_t005_008/c3_r0_rbl u_t005_008/c3_r1_rbl
+ u_t005_008/r0_w0_wl u_t005_008/r0_w1_wl u_t005_008/r0_r0_rwl u_t005_008/r0_r1_rwl
+ u_t005_008/r1_w0_wl u_t005_008/r1_w1_wl u_t005_008/r1_r0_rwl u_t005_008/r1_r1_rwl
+ u_t005_008/r2_w0_wl u_t005_008/r2_w1_wl u_t005_008/r2_r0_rwl u_t005_008/r2_r1_rwl
+ u_t005_008/r3_w0_wl u_t005_008/r3_w1_wl u_t005_008/r3_r0_rwl u_t005_008/r3_r1_rwl
+ VSS VSS u_t005_008/m2_717_1265# u_t005_008/m2_603_2031# u_t005_008/m2_1290_336#
+ u_t005_008/m2_2000_2037# u_t005_008/m2_791_2909# u_t005_008/m2_7_2126# u_t005_008/m2_2154_2081#
+ u_t005_008/m2_1795_2037# u_t005_008/m2_871_303# u_t005_008/m2_431_438# u_t005_008/m2_1290_2898#
+ u_t005_008/m2_1714_1210# u_t005_008/m2_431_1982# u_t005_008/m2_512_1265# u_t005_008/m2_2573_2126#
+ u_t005_008/m2_603_1259# u_t005_008/m2_2074_2909# u_t005_008/m2_7_336# u_t005_008/m2_717_2037#
+ u_t005_008/m2_1886_2031# u_t005_008/m2_2573_336# u_t005_008/m2_7_2898# u_t005_008/m2_2000_1265#
+ u_t005_008/m2_512_2037# u_t005_008/m2_1795_1265# u_t005_008/m2_1714_1982# u_t005_008/m2_1886_1259#
+ u_t005_008/m2_1290_2126# u_t005_008/m2_1714_438# u_t005_008/m2_431_1210# u_t005_008/m2_2573_2898#
+ u_t005_008/m2_2154_303# u_t005_008/m2_871_2081# VSUBS detronyx_12t_2w2r_rc4_4x4_routed_5layer_direct
Xgf180mcu_as_sc_mcu7t3v3__inv_2_461 gf180mcu_as_sc_mcu7t3v3__nor2_2_6/VDD gf180mcu_as_sc_mcu7t3v3__nand3_2_4/VSS
+ gf180mcu_as_sc_mcu7t3v3__inv_2_461/Y VSS gf180mcu_as_sc_mcu7t3v3__nor2_2_6/VNW VSUBS
+ gf180mcu_as_sc_mcu7t3v3__inv_2
Xgf180mcu_as_sc_mcu7t3v3__inv_2_472 gf180mcu_as_sc_mcu7t3v3__nor2_2_6/VDD gf180mcu_as_sc_mcu7t3v3__nand3_2_4/VSS
+ VSS VSS gf180mcu_as_sc_mcu7t3v3__nor2_2_6/VNW VSUBS gf180mcu_as_sc_mcu7t3v3__inv_2
Xgf180mcu_as_sc_mcu7t3v3__inv_2_450 gf180mcu_as_sc_mcu7t3v3__nand3_2_9/VDD gf180mcu_as_sc_mcu7t3v3__nor2_2_4/VSS
+ VSS VSS gf180mcu_as_sc_mcu7t3v3__nand3_2_9/VNW VSUBS gf180mcu_as_sc_mcu7t3v3__inv_2
Xgf180mcu_as_sc_mcu7t3v3__inv_2_483 VSS VSS gf180mcu_as_sc_mcu7t3v3__inv_2_483/Y gf180mcu_as_sc_mcu7t3v3__inv_2_483/A
+ gf180mcu_as_sc_mcu7t3v3__inv_2_549/VNW VSUBS gf180mcu_as_sc_mcu7t3v3__inv_2
Xgf180mcu_as_sc_mcu7t3v3__inv_2_494 VSS VSS gf180mcu_as_sc_mcu7t3v3__inv_2_494/Y gf180mcu_as_sc_mcu7t3v3__inv_2_494/A
+ gf180mcu_as_sc_mcu7t3v3__inv_2_554/VNW VSUBS gf180mcu_as_sc_mcu7t3v3__inv_2
Xu_t010_011 u_t010_011/c0_w0_bl u_t010_011/c0_w0_br u_t010_011/c0_w1_bl u_t010_011/c0_w1_br
+ u_t010_011/c0_r0_rbl u_t010_011/c0_r1_rbl u_t010_011/c1_w0_bl u_t010_011/c1_w0_br
+ u_t010_011/c1_w1_bl u_t010_011/c1_w1_br u_t010_011/c1_r0_rbl u_t010_011/c1_r1_rbl
+ u_t010_011/c2_w0_bl u_t010_011/c2_w0_br u_t010_011/c2_w1_bl u_t010_011/c2_w1_br
+ u_t010_011/c2_r0_rbl u_t010_011/c2_r1_rbl u_t010_011/c3_w0_bl u_t010_011/c3_w0_br
+ u_t010_011/c3_w1_bl u_t010_011/c3_w1_br u_t010_011/c3_r0_rbl u_t010_011/c3_r1_rbl
+ u_t010_011/r0_w0_wl u_t010_011/r0_w1_wl u_t010_011/r0_r0_rwl u_t010_011/r0_r1_rwl
+ u_t010_011/r1_w0_wl u_t010_011/r1_w1_wl u_t010_011/r1_r0_rwl u_t010_011/r1_r1_rwl
+ u_t010_011/r2_w0_wl u_t010_011/r2_w1_wl u_t010_011/r2_r0_rwl u_t010_011/r2_r1_rwl
+ u_t010_011/r3_w0_wl u_t010_011/r3_w1_wl u_t010_011/r3_r0_rwl u_t010_011/r3_r1_rwl
+ VSS VSS u_t010_011/m2_717_1265# u_t010_011/m2_603_2031# u_t010_011/m2_1290_336#
+ u_t010_011/m2_2000_2037# u_t010_011/m2_791_2909# u_t010_011/m2_7_2126# u_t010_011/m2_2154_2081#
+ u_t010_011/m2_1795_2037# u_t010_011/m2_871_303# u_t010_011/m2_431_438# u_t010_011/m2_1290_2898#
+ u_t010_011/m2_1714_1210# u_t010_011/m2_431_1982# u_t010_011/m2_512_1265# u_t010_011/m2_2573_2126#
+ u_t010_011/m2_603_1259# u_t010_011/m2_2074_2909# u_t010_011/m2_7_336# u_t010_011/m2_717_2037#
+ u_t010_011/m2_1886_2031# u_t010_011/m2_2573_336# u_t010_011/m2_7_2898# u_t010_011/m2_2000_1265#
+ u_t010_011/m2_512_2037# u_t010_011/m2_1795_1265# u_t010_011/m2_1714_1982# u_t010_011/m2_1886_1259#
+ u_t010_011/m2_1290_2126# u_t010_011/m2_1714_438# u_t010_011/m2_431_1210# u_t010_011/m2_2573_2898#
+ u_t010_011/m2_2154_303# u_t010_011/m2_871_2081# VSUBS detronyx_12t_2w2r_rc4_4x4_routed_5layer_direct
Xu_t010_000 VSS u_t010_000/c0_w0_br VSS u_t010_000/c0_w1_br u_t010_000/c0_r0_rbl u_t010_000/c0_r1_rbl
+ VSS VSS VSS VSS VSS VSS u_t010_000/c2_w0_bl u_t010_000/c2_w0_br u_t010_000/c2_w1_bl
+ u_t010_000/c2_w1_br u_t010_000/c2_r0_rbl u_t010_000/c2_r1_rbl u_t010_000/c3_w0_bl
+ u_t010_000/c3_w0_br u_t010_000/c3_w1_bl u_t010_000/c3_w1_br u_t010_000/c3_r0_rbl
+ u_t010_000/c3_r1_rbl VSS VSS VSS VSS VSS VSS VSS VSS VSS VSS VSS VSS VSS VSS VSS
+ VSS VSS VSS u_t010_000/m2_717_1265# u_t010_000/m2_603_2031# u_t010_000/m2_1290_336#
+ u_t010_000/m2_2000_2037# u_t010_000/m2_791_2909# u_t010_000/m2_7_2126# u_t010_000/m2_2154_2081#
+ u_t010_000/m2_1795_2037# u_t010_000/m2_871_303# u_t010_000/m2_431_438# u_t010_000/m2_1290_2898#
+ u_t010_000/m2_1714_1210# u_t010_000/m2_431_1982# u_t010_000/m2_512_1265# u_t010_000/m2_2573_2126#
+ u_t010_000/m2_603_1259# u_t010_000/m2_2074_2909# u_t010_000/m2_7_336# u_t010_000/m2_717_2037#
+ u_t010_000/m2_1886_2031# u_t010_000/m2_2573_336# u_t010_000/m2_7_2898# u_t010_000/m2_2000_1265#
+ u_t010_000/m2_512_2037# u_t010_000/m2_1795_1265# u_t010_000/m2_1714_1982# u_t010_000/m2_1886_1259#
+ u_t010_000/m2_1290_2126# u_t010_000/m2_1714_438# u_t010_000/m2_431_1210# u_t010_000/m2_2573_2898#
+ u_t010_000/m2_2154_303# u_t010_000/m2_871_2081# VSUBS detronyx_12t_2w2r_rc4_4x4_routed_5layer_direct
Xu_t001_011 u_t001_011/c0_w0_bl u_t001_011/c0_w0_br u_t001_011/c0_w1_bl u_t001_011/c0_w1_br
+ u_t001_011/c0_r0_rbl u_t001_011/c0_r1_rbl u_t001_011/c1_w0_bl u_t001_011/c1_w0_br
+ u_t001_011/c1_w1_bl u_t001_011/c1_w1_br u_t001_011/c1_r0_rbl u_t001_011/c1_r1_rbl
+ u_t001_011/c2_w0_bl u_t001_011/c2_w0_br u_t001_011/c2_w1_bl u_t001_011/c2_w1_br
+ u_t001_011/c2_r0_rbl u_t001_011/c2_r1_rbl u_t001_011/c3_w0_bl u_t001_011/c3_w0_br
+ u_t001_011/c3_w1_bl u_t001_011/c3_w1_br u_t001_011/c3_r0_rbl u_t001_011/c3_r1_rbl
+ u_t001_011/r0_w0_wl u_t001_011/r0_w1_wl u_t001_011/r0_r0_rwl u_t001_011/r0_r1_rwl
+ u_t001_011/r1_w0_wl u_t001_011/r1_w1_wl u_t001_011/r1_r0_rwl u_t001_011/r1_r1_rwl
+ u_t001_011/r2_w0_wl u_t001_011/r2_w1_wl u_t001_011/r2_r0_rwl u_t001_011/r2_r1_rwl
+ u_t001_011/r3_w0_wl u_t001_011/r3_w1_wl u_t001_011/r3_r0_rwl u_t001_011/r3_r1_rwl
+ VSS VSS u_t001_011/m2_717_1265# u_t001_011/m2_603_2031# u_t001_011/m2_1290_336#
+ u_t001_011/m2_2000_2037# u_t001_011/m2_791_2909# u_t001_011/m2_7_2126# u_t001_011/m2_2154_2081#
+ u_t001_011/m2_1795_2037# u_t001_011/m2_871_303# u_t001_011/m2_431_438# u_t001_011/m2_1290_2898#
+ u_t001_011/m2_1714_1210# u_t001_011/m2_431_1982# u_t001_011/m2_512_1265# u_t001_011/m2_2573_2126#
+ u_t001_011/m2_603_1259# u_t001_011/m2_2074_2909# u_t001_011/m2_7_336# u_t001_011/m2_717_2037#
+ u_t001_011/m2_1886_2031# u_t001_011/m2_2573_336# u_t001_011/m2_7_2898# u_t001_011/m2_2000_1265#
+ u_t001_011/m2_512_2037# u_t001_011/m2_1795_1265# u_t001_011/m2_1714_1982# u_t001_011/m2_1886_1259#
+ u_t001_011/m2_1290_2126# u_t001_011/m2_1714_438# u_t001_011/m2_431_1210# u_t001_011/m2_2573_2898#
+ u_t001_011/m2_2154_303# u_t001_011/m2_871_2081# VSUBS detronyx_12t_2w2r_rc4_4x4_routed_5layer_direct
Xu_t001_000 VSS u_t001_000/c0_w0_br VSS u_t001_000/c0_w1_br u_t001_000/c0_r0_rbl u_t001_000/c0_r1_rbl
+ VSS VSS VSS VSS VSS VSS u_t001_000/c2_w0_bl u_t001_000/c2_w0_br u_t001_000/c2_w1_bl
+ u_t001_000/c2_w1_br u_t001_000/c2_r0_rbl u_t001_000/c2_r1_rbl u_t001_000/c3_w0_bl
+ u_t001_000/c3_w0_br u_t001_000/c3_w1_bl u_t001_000/c3_w1_br u_t001_000/c3_r0_rbl
+ u_t001_000/c3_r1_rbl VSS VSS VSS VSS VSS VSS VSS VSS VSS VSS VSS VSS VSS VSS VSS
+ VSS VSS VSS u_t001_000/m2_717_1265# u_t001_000/m2_603_2031# u_t001_000/m2_1290_336#
+ u_t001_000/m2_2000_2037# u_t001_000/m2_791_2909# u_t001_000/m2_7_2126# u_t001_000/m2_2154_2081#
+ u_t001_000/m2_1795_2037# u_t001_000/m2_871_303# u_t001_000/m2_431_438# u_t001_000/m2_1290_2898#
+ u_t001_000/m2_1714_1210# u_t001_000/m2_431_1982# u_t001_000/m2_512_1265# u_t001_000/m2_2573_2126#
+ u_t001_000/m2_603_1259# u_t001_000/m2_2074_2909# u_t001_000/m2_7_336# u_t001_000/m2_717_2037#
+ u_t001_000/m2_1886_2031# u_t001_000/m2_2573_336# u_t001_000/m2_7_2898# u_t001_000/m2_2000_1265#
+ u_t001_000/m2_512_2037# u_t001_000/m2_1795_1265# u_t001_000/m2_1714_1982# u_t001_000/m2_1886_1259#
+ u_t001_000/m2_1290_2126# u_t001_000/m2_1714_438# u_t001_000/m2_431_1210# u_t001_000/m2_2573_2898#
+ u_t001_000/m2_2154_303# u_t001_000/m2_871_2081# VSUBS detronyx_12t_2w2r_rc4_4x4_routed_5layer_direct
Xgf180mcu_as_sc_mcu7t3v3__inv_2_280 VSS VSS gf180mcu_as_sc_mcu7t3v3__inv_2_280/Y gf180mcu_as_sc_mcu7t3v3__inv_2_280/A
+ gf180mcu_as_sc_mcu7t3v3__inv_2_280/VNW VSUBS gf180mcu_as_sc_mcu7t3v3__inv_2
Xgf180mcu_as_sc_mcu7t3v3__inv_2_291 VSS VSS gf180mcu_as_sc_mcu7t3v3__inv_2_303/A gf180mcu_as_sc_mcu7t3v3__inv_2_300/Y
+ gf180mcu_as_sc_mcu7t3v3__inv_2_303/VNW VSUBS gf180mcu_as_sc_mcu7t3v3__inv_2
Xgf180mcu_as_sc_mcu7t3v3__inv_2_1713 gf180mcu_as_sc_mcu7t3v3__nor2_2_9/VDD gf180mcu_as_sc_mcu7t3v3__nor2_2_9/VSS
+ VSS VSS gf180mcu_as_sc_mcu7t3v3__nor2_2_9/VNW VSUBS gf180mcu_as_sc_mcu7t3v3__inv_2
Xgf180mcu_as_sc_mcu7t3v3__inv_2_1702 gf180mcu_as_sc_mcu7t3v3__nor2_2_7/VDD gf180mcu_as_sc_mcu7t3v3__nor2_2_7/VSS
+ VSS VSS gf180mcu_as_sc_mcu7t3v3__nor2_2_7/VNW VSUBS gf180mcu_as_sc_mcu7t3v3__inv_2
Xgf180mcu_as_sc_mcu7t3v3__inv_2_1724 VSS VSS VSS gf180mcu_as_sc_mcu7t3v3__inv_2_1725/Y
+ gf180mcu_as_sc_mcu7t3v3__inv_2_1726/VNW VSUBS gf180mcu_as_sc_mcu7t3v3__inv_2
Xgf180mcu_as_sc_mcu7t3v3__nand4_2_507 VSS VSS VSS VSS VSS VSS gf180mcu_as_sc_mcu7t3v3__inv_2_1631/A
+ gf180mcu_as_sc_mcu7t3v3__inv_2_1631/VNW VSUBS gf180mcu_as_sc_mcu7t3v3__nand4_2
Xgf180mcu_as_sc_mcu7t3v3__inv_2_28 VSS VSS gf180mcu_as_sc_mcu7t3v3__inv_2_28/Y gf180mcu_as_sc_mcu7t3v3__inv_2_28/A
+ gf180mcu_as_sc_mcu7t3v3__inv_2_28/VNW VSUBS gf180mcu_as_sc_mcu7t3v3__inv_2
Xgf180mcu_as_sc_mcu7t3v3__inv_2_39 VSS VSS gf180mcu_as_sc_mcu7t3v3__inv_2_39/Y gf180mcu_as_sc_mcu7t3v3__inv_2_43/Y
+ gf180mcu_as_sc_mcu7t3v3__inv_2_43/VNW VSUBS gf180mcu_as_sc_mcu7t3v3__inv_2
Xgf180mcu_as_sc_mcu7t3v3__inv_2_17 VSS VSS VSS gf180mcu_as_sc_mcu7t3v3__inv_2_21/Y
+ gf180mcu_as_sc_mcu7t3v3__inv_2_25/VNW VSUBS gf180mcu_as_sc_mcu7t3v3__inv_2
Xgf180mcu_as_sc_mcu7t3v3__inv_2_1009 VSS VSS gf180mcu_as_sc_mcu7t3v3__inv_2_1058/A
+ gf180mcu_as_sc_mcu7t3v3__inv_2_1013/Y gf180mcu_as_sc_mcu7t3v3__inv_2_1058/VNW VSUBS
+ gf180mcu_as_sc_mcu7t3v3__inv_2
Xgf180mcu_as_sc_mcu7t3v3__inv_2_1510 VSS VSS gf180mcu_as_sc_mcu7t3v3__inv_2_1510/Y
+ gf180mcu_as_sc_mcu7t3v3__inv_2_1511/Y gf180mcu_as_sc_mcu7t3v3__inv_2_1511/VNW VSUBS
+ gf180mcu_as_sc_mcu7t3v3__inv_2
Xgf180mcu_as_sc_mcu7t3v3__inv_2_1565 VSS VSS VSS gf180mcu_as_sc_mcu7t3v3__inv_2_1586/Y
+ gf180mcu_as_sc_mcu7t3v3__inv_2_1587/VNW VSUBS gf180mcu_as_sc_mcu7t3v3__inv_2
Xgf180mcu_as_sc_mcu7t3v3__inv_2_1598 VSS VSS VSS gf180mcu_as_sc_mcu7t3v3__inv_2_1598/A
+ gf180mcu_as_sc_mcu7t3v3__inv_2_1598/VNW VSUBS gf180mcu_as_sc_mcu7t3v3__inv_2
Xgf180mcu_as_sc_mcu7t3v3__inv_2_1587 VSS VSS gf180mcu_as_sc_mcu7t3v3__inv_2_1587/Y
+ gf180mcu_as_sc_mcu7t3v3__inv_2_1587/A gf180mcu_as_sc_mcu7t3v3__inv_2_1587/VNW VSUBS
+ gf180mcu_as_sc_mcu7t3v3__inv_2
Xgf180mcu_as_sc_mcu7t3v3__inv_2_1576 VSS VSS gf180mcu_as_sc_mcu7t3v3__inv_2_1576/Y
+ gf180mcu_as_sc_mcu7t3v3__inv_2_1576/A gf180mcu_as_sc_mcu7t3v3__inv_2_1576/VNW VSUBS
+ gf180mcu_as_sc_mcu7t3v3__inv_2
Xgf180mcu_as_sc_mcu7t3v3__inv_2_1543 VSS VSS gf180mcu_as_sc_mcu7t3v3__inv_2_1543/Y
+ gf180mcu_as_sc_mcu7t3v3__inv_2_1544/Y gf180mcu_as_sc_mcu7t3v3__inv_2_1544/VNW VSUBS
+ gf180mcu_as_sc_mcu7t3v3__inv_2
Xgf180mcu_as_sc_mcu7t3v3__inv_2_1554 VSS VSS VSS gf180mcu_as_sc_mcu7t3v3__inv_2_1555/Y
+ gf180mcu_as_sc_mcu7t3v3__inv_2_1556/VNW VSUBS gf180mcu_as_sc_mcu7t3v3__inv_2
Xgf180mcu_as_sc_mcu7t3v3__inv_2_1521 VSS VSS VSS gf180mcu_as_sc_mcu7t3v3__inv_2_1522/Y
+ gf180mcu_as_sc_mcu7t3v3__inv_2_1523/VNW VSUBS gf180mcu_as_sc_mcu7t3v3__inv_2
Xgf180mcu_as_sc_mcu7t3v3__inv_2_1532 VSS VSS gf180mcu_as_sc_mcu7t3v3__inv_2_1532/Y
+ gf180mcu_as_sc_mcu7t3v3__inv_2_1532/A gf180mcu_as_sc_mcu7t3v3__inv_2_1532/VNW VSUBS
+ gf180mcu_as_sc_mcu7t3v3__inv_2
Xgf180mcu_as_sc_mcu7t3v3__nand3_2_9 gf180mcu_as_sc_mcu7t3v3__nand3_2_9/VDD gf180mcu_as_sc_mcu7t3v3__nor2_2_4/VSS
+ VSS VSS VSS VSS gf180mcu_as_sc_mcu7t3v3__nand3_2_9/VNW VSUBS gf180mcu_as_sc_mcu7t3v3__nand3_2
Xgf180mcu_as_sc_mcu7t3v3__nand4_2_326 VSS VSS VSS VSS VSS VSS gf180mcu_as_sc_mcu7t3v3__inv_2_1099/A
+ gf180mcu_as_sc_mcu7t3v3__inv_2_1099/VNW VSUBS gf180mcu_as_sc_mcu7t3v3__nand4_2
Xgf180mcu_as_sc_mcu7t3v3__nand4_2_315 VSS VSS VSS VSS VSS VSS gf180mcu_as_sc_mcu7t3v3__inv_2_1049/A
+ gf180mcu_as_sc_mcu7t3v3__inv_2_1049/VNW VSUBS gf180mcu_as_sc_mcu7t3v3__nand4_2
Xgf180mcu_as_sc_mcu7t3v3__nand4_2_304 VSS VSS VSS VSS VSS VSS gf180mcu_as_sc_mcu7t3v3__inv_2_1040/A
+ gf180mcu_as_sc_mcu7t3v3__inv_2_1040/VNW VSUBS gf180mcu_as_sc_mcu7t3v3__nand4_2
Xgf180mcu_as_sc_mcu7t3v3__nand4_2_337 VSS VSS VSS VSS VSS VSS gf180mcu_as_sc_mcu7t3v3__inv_2_1136/A
+ gf180mcu_as_sc_mcu7t3v3__inv_2_1136/VNW VSUBS gf180mcu_as_sc_mcu7t3v3__nand4_2
Xgf180mcu_as_sc_mcu7t3v3__nand4_2_348 VSS VSS VSS VSS VSS VSS gf180mcu_as_sc_mcu7t3v3__inv_2_1152/A
+ gf180mcu_as_sc_mcu7t3v3__inv_2_1289/VNW VSUBS gf180mcu_as_sc_mcu7t3v3__nand4_2
Xgf180mcu_as_sc_mcu7t3v3__nand4_2_359 VSS VSS VSS VSS VSS VSS gf180mcu_as_sc_mcu7t3v3__inv_2_1165/A
+ gf180mcu_as_sc_mcu7t3v3__inv_2_1299/VNW VSUBS gf180mcu_as_sc_mcu7t3v3__nand4_2
Xu_t029_014 u_t029_014/c0_w0_bl u_t029_014/c0_w0_br u_t029_014/c0_w1_bl u_t029_014/c0_w1_br
+ u_t029_014/c0_r0_rbl u_t029_014/c0_r1_rbl u_t029_014/c1_w0_bl u_t029_014/c1_w0_br
+ u_t029_014/c1_w1_bl u_t029_014/c1_w1_br u_t029_014/c1_r0_rbl u_t029_014/c1_r1_rbl
+ u_t029_014/c2_w0_bl u_t029_014/c2_w0_br u_t029_014/c2_w1_bl u_t029_014/c2_w1_br
+ u_t029_014/c2_r0_rbl u_t029_014/c2_r1_rbl u_t029_014/c3_w0_bl u_t029_014/c3_w0_br
+ u_t029_014/c3_w1_bl u_t029_014/c3_w1_br u_t029_014/c3_r0_rbl u_t029_014/c3_r1_rbl
+ u_t029_014/r0_w0_wl u_t029_014/r0_w1_wl u_t029_014/r0_r0_rwl u_t029_014/r0_r1_rwl
+ u_t029_014/r1_w0_wl u_t029_014/r1_w1_wl u_t029_014/r1_r0_rwl u_t029_014/r1_r1_rwl
+ u_t029_014/r2_w0_wl u_t029_014/r2_w1_wl u_t029_014/r2_r0_rwl u_t029_014/r2_r1_rwl
+ u_t029_014/r3_w0_wl u_t029_014/r3_w1_wl u_t029_014/r3_r0_rwl u_t029_014/r3_r1_rwl
+ VSS VSS u_t029_014/m2_717_1265# u_t029_014/m2_603_2031# u_t029_014/m2_1290_336#
+ u_t029_014/m2_2000_2037# u_t029_014/m2_791_2909# u_t029_014/m2_7_2126# u_t029_014/m2_2154_2081#
+ u_t029_014/m2_1795_2037# u_t029_014/m2_871_303# u_t029_014/m2_431_438# u_t029_014/m2_1290_2898#
+ u_t029_014/m2_1714_1210# u_t029_014/m2_431_1982# u_t029_014/m2_512_1265# u_t029_014/m2_2573_2126#
+ u_t029_014/m2_603_1259# u_t029_014/m2_2074_2909# u_t029_014/m2_7_336# u_t029_014/m2_717_2037#
+ u_t029_014/m2_1886_2031# u_t029_014/m2_2573_336# u_t029_014/m2_7_2898# u_t029_014/m2_2000_1265#
+ u_t029_014/m2_512_2037# u_t029_014/m2_1795_1265# u_t029_014/m2_1714_1982# u_t029_014/m2_1886_1259#
+ u_t029_014/m2_1290_2126# u_t029_014/m2_1714_438# u_t029_014/m2_431_1210# u_t029_014/m2_2573_2898#
+ u_t029_014/m2_2154_303# u_t029_014/m2_871_2081# VSUBS detronyx_12t_2w2r_rc4_4x4_routed_5layer_direct
Xu_t029_003 u_t029_003/c0_w0_bl u_t029_003/c0_w0_br u_t029_003/c0_w1_bl u_t029_003/c0_w1_br
+ u_t029_003/c0_r0_rbl u_t029_003/c0_r1_rbl u_t029_003/c1_w0_bl u_t029_003/c1_w0_br
+ u_t029_003/c1_w1_bl u_t029_003/c1_w1_br u_t029_003/c1_r0_rbl u_t029_003/c1_r1_rbl
+ u_t029_003/c2_w0_bl u_t029_003/c2_w0_br u_t029_003/c2_w1_bl u_t029_003/c2_w1_br
+ u_t029_003/c2_r0_rbl u_t029_003/c2_r1_rbl u_t029_003/c3_w0_bl u_t029_003/c3_w0_br
+ u_t029_003/c3_w1_bl u_t029_003/c3_w1_br u_t029_003/c3_r0_rbl u_t029_003/c3_r1_rbl
+ u_t029_003/r0_w0_wl u_t029_003/r0_w1_wl u_t029_003/r0_r0_rwl u_t029_003/r0_r1_rwl
+ u_t029_003/r1_w0_wl u_t029_003/r1_w1_wl u_t029_003/r1_r0_rwl u_t029_003/r1_r1_rwl
+ u_t029_003/r2_w0_wl u_t029_003/r2_w1_wl u_t029_003/r2_r0_rwl u_t029_003/r2_r1_rwl
+ u_t029_003/r3_w0_wl u_t029_003/r3_w1_wl u_t029_003/r3_r0_rwl u_t029_003/r3_r1_rwl
+ VSS VSS u_t029_003/m2_717_1265# u_t029_003/m2_603_2031# u_t029_003/m2_1290_336#
+ u_t029_003/m2_2000_2037# u_t029_003/m2_791_2909# u_t029_003/m2_7_2126# u_t029_003/m2_2154_2081#
+ u_t029_003/m2_1795_2037# u_t029_003/m2_871_303# u_t029_003/m2_431_438# u_t029_003/m2_1290_2898#
+ u_t029_003/m2_1714_1210# u_t029_003/m2_431_1982# u_t029_003/m2_512_1265# u_t029_003/m2_2573_2126#
+ u_t029_003/m2_603_1259# u_t029_003/m2_2074_2909# u_t029_003/m2_7_336# u_t029_003/m2_717_2037#
+ u_t029_003/m2_1886_2031# u_t029_003/m2_2573_336# u_t029_003/m2_7_2898# u_t029_003/m2_2000_1265#
+ u_t029_003/m2_512_2037# u_t029_003/m2_1795_1265# u_t029_003/m2_1714_1982# u_t029_003/m2_1886_1259#
+ u_t029_003/m2_1290_2126# u_t029_003/m2_1714_438# u_t029_003/m2_431_1210# u_t029_003/m2_2573_2898#
+ u_t029_003/m2_2154_303# u_t029_003/m2_871_2081# VSUBS detronyx_12t_2w2r_rc4_4x4_routed_5layer_direct
Xgf180mcu_as_sc_mcu7t3v3__inv_2_1362 VSS VSS gf180mcu_as_sc_mcu7t3v3__inv_2_1362/Y
+ gf180mcu_as_sc_mcu7t3v3__inv_2_1362/A gf180mcu_as_sc_mcu7t3v3__inv_2_1362/VNW VSUBS
+ gf180mcu_as_sc_mcu7t3v3__inv_2
Xgf180mcu_as_sc_mcu7t3v3__inv_2_1351 VSS VSS gf180mcu_as_sc_mcu7t3v3__inv_2_1351/Y
+ gf180mcu_as_sc_mcu7t3v3__inv_2_1352/Y gf180mcu_as_sc_mcu7t3v3__inv_2_1352/VNW VSUBS
+ gf180mcu_as_sc_mcu7t3v3__inv_2
Xgf180mcu_as_sc_mcu7t3v3__inv_2_1340 VSS VSS gf180mcu_as_sc_mcu7t3v3__inv_2_1340/Y
+ gf180mcu_as_sc_mcu7t3v3__inv_2_1340/A gf180mcu_as_sc_mcu7t3v3__inv_2_1340/VNW VSUBS
+ gf180mcu_as_sc_mcu7t3v3__inv_2
Xgf180mcu_as_sc_mcu7t3v3__inv_2_1373 VSS VSS gf180mcu_as_sc_mcu7t3v3__inv_2_1373/Y
+ gf180mcu_as_sc_mcu7t3v3__inv_2_1374/Y gf180mcu_as_sc_mcu7t3v3__inv_2_1374/VNW VSUBS
+ gf180mcu_as_sc_mcu7t3v3__inv_2
Xgf180mcu_as_sc_mcu7t3v3__inv_2_1384 VSS VSS VSS gf180mcu_as_sc_mcu7t3v3__inv_2_1385/Y
+ gf180mcu_as_sc_mcu7t3v3__inv_2_1386/VNW VSUBS gf180mcu_as_sc_mcu7t3v3__inv_2
Xgf180mcu_as_sc_mcu7t3v3__inv_2_1395 VSS VSS gf180mcu_as_sc_mcu7t3v3__inv_2_1395/Y
+ gf180mcu_as_sc_mcu7t3v3__inv_2_1395/A gf180mcu_as_sc_mcu7t3v3__inv_2_1395/VNW VSUBS
+ gf180mcu_as_sc_mcu7t3v3__inv_2
Xgf180mcu_as_sc_mcu7t3v3__inv_2_802 VSS VSS gf180mcu_as_sc_mcu7t3v3__inv_2_837/A gf180mcu_as_sc_mcu7t3v3__inv_2_803/Y
+ gf180mcu_as_sc_mcu7t3v3__inv_2_837/VNW VSUBS gf180mcu_as_sc_mcu7t3v3__inv_2
Xgf180mcu_as_sc_mcu7t3v3__inv_2_857 VSS VSS gf180mcu_as_sc_mcu7t3v3__inv_2_857/Y gf180mcu_as_sc_mcu7t3v3__inv_2_857/A
+ gf180mcu_as_sc_mcu7t3v3__inv_2_857/VNW VSUBS gf180mcu_as_sc_mcu7t3v3__inv_2
Xgf180mcu_as_sc_mcu7t3v3__inv_2_824 VSS VSS VSS gf180mcu_as_sc_mcu7t3v3__inv_2_824/A
+ gf180mcu_as_sc_mcu7t3v3__inv_2_824/VNW VSUBS gf180mcu_as_sc_mcu7t3v3__inv_2
Xgf180mcu_as_sc_mcu7t3v3__inv_2_835 VSS VSS VSS gf180mcu_as_sc_mcu7t3v3__inv_2_835/A
+ gf180mcu_as_sc_mcu7t3v3__inv_2_835/VNW VSUBS gf180mcu_as_sc_mcu7t3v3__inv_2
Xgf180mcu_as_sc_mcu7t3v3__inv_2_846 VSS VSS VSS gf180mcu_as_sc_mcu7t3v3__inv_2_846/A
+ gf180mcu_as_sc_mcu7t3v3__inv_2_846/VNW VSUBS gf180mcu_as_sc_mcu7t3v3__inv_2
Xgf180mcu_as_sc_mcu7t3v3__inv_2_813 VSS VSS gf180mcu_as_sc_mcu7t3v3__inv_2_841/A gf180mcu_as_sc_mcu7t3v3__inv_2_814/Y
+ gf180mcu_as_sc_mcu7t3v3__inv_2_841/VNW VSUBS gf180mcu_as_sc_mcu7t3v3__inv_2
Xgf180mcu_as_sc_mcu7t3v3__inv_2_879 VSS VSS gf180mcu_as_sc_mcu7t3v3__inv_2_879/Y gf180mcu_as_sc_mcu7t3v3__inv_2_879/A
+ gf180mcu_as_sc_mcu7t3v3__inv_2_932/VNW VSUBS gf180mcu_as_sc_mcu7t3v3__inv_2
Xgf180mcu_as_sc_mcu7t3v3__inv_2_868 VSS VSS gf180mcu_as_sc_mcu7t3v3__inv_2_868/Y gf180mcu_as_sc_mcu7t3v3__inv_2_868/A
+ gf180mcu_as_sc_mcu7t3v3__inv_2_928/VNW VSUBS gf180mcu_as_sc_mcu7t3v3__inv_2
Xgf180mcu_as_sc_mcu7t3v3__nand4_2_145 VSS VSS VSS VSS VSS VSS gf180mcu_as_sc_mcu7t3v3__inv_2_511/A
+ gf180mcu_as_sc_mcu7t3v3__inv_2_557/VNW VSUBS gf180mcu_as_sc_mcu7t3v3__nand4_2
Xgf180mcu_as_sc_mcu7t3v3__nand4_2_156 VSS VSS VSS VSS VSS VSS gf180mcu_as_sc_mcu7t3v3__inv_2_567/A
+ gf180mcu_as_sc_mcu7t3v3__inv_2_567/VNW VSUBS gf180mcu_as_sc_mcu7t3v3__nand4_2
Xgf180mcu_as_sc_mcu7t3v3__nand4_2_134 VSS VSS VSS VSS VSS VSS gf180mcu_as_sc_mcu7t3v3__inv_2_492/A
+ gf180mcu_as_sc_mcu7t3v3__inv_2_553/VNW VSUBS gf180mcu_as_sc_mcu7t3v3__nand4_2
Xgf180mcu_as_sc_mcu7t3v3__nand4_2_167 VSS VSS VSS VSS VSS VSS gf180mcu_as_sc_mcu7t3v3__inv_2_636/A
+ gf180mcu_as_sc_mcu7t3v3__inv_2_636/VNW VSUBS gf180mcu_as_sc_mcu7t3v3__nand4_2
Xgf180mcu_as_sc_mcu7t3v3__nand4_2_123 VSS VSS VSS VSS VSS VSS gf180mcu_as_sc_mcu7t3v3__inv_2_265/A
+ gf180mcu_as_sc_mcu7t3v3__inv_2_308/VNW VSUBS gf180mcu_as_sc_mcu7t3v3__nand4_2
Xgf180mcu_as_sc_mcu7t3v3__nand4_2_112 VSS VSS VSS VSS VSS VSS gf180mcu_as_sc_mcu7t3v3__inv_2_311/A
+ gf180mcu_as_sc_mcu7t3v3__inv_2_311/VNW VSUBS gf180mcu_as_sc_mcu7t3v3__nand4_2
Xgf180mcu_as_sc_mcu7t3v3__nand4_2_101 VSS VSS VSS VSS VSS VSS gf180mcu_as_sc_mcu7t3v3__inv_2_356/A
+ gf180mcu_as_sc_mcu7t3v3__inv_2_356/VNW VSUBS gf180mcu_as_sc_mcu7t3v3__nand4_2
Xu_t026_006 u_t026_006/c0_w0_bl u_t026_006/c0_w0_br u_t026_006/c0_w1_bl u_t026_006/c0_w1_br
+ u_t026_006/c0_r0_rbl u_t026_006/c0_r1_rbl u_t026_006/c1_w0_bl u_t026_006/c1_w0_br
+ u_t026_006/c1_w1_bl u_t026_006/c1_w1_br u_t026_006/c1_r0_rbl u_t026_006/c1_r1_rbl
+ u_t026_006/c2_w0_bl u_t026_006/c2_w0_br u_t026_006/c2_w1_bl u_t026_006/c2_w1_br
+ u_t026_006/c2_r0_rbl u_t026_006/c2_r1_rbl u_t026_006/c3_w0_bl u_t026_006/c3_w0_br
+ u_t026_006/c3_w1_bl u_t026_006/c3_w1_br u_t026_006/c3_r0_rbl u_t026_006/c3_r1_rbl
+ u_t026_006/r0_w0_wl u_t026_006/r0_w1_wl u_t026_006/r0_r0_rwl u_t026_006/r0_r1_rwl
+ u_t026_006/r1_w0_wl u_t026_006/r1_w1_wl u_t026_006/r1_r0_rwl u_t026_006/r1_r1_rwl
+ u_t026_006/r2_w0_wl u_t026_006/r2_w1_wl u_t026_006/r2_r0_rwl u_t026_006/r2_r1_rwl
+ u_t026_006/r3_w0_wl u_t026_006/r3_w1_wl u_t026_006/r3_r0_rwl u_t026_006/r3_r1_rwl
+ VSS VSS u_t026_006/m2_717_1265# u_t026_006/m2_603_2031# u_t026_006/m2_1290_336#
+ u_t026_006/m2_2000_2037# u_t026_006/m2_791_2909# u_t026_006/m2_7_2126# u_t026_006/m2_2154_2081#
+ u_t026_006/m2_1795_2037# u_t026_006/m2_871_303# u_t026_006/m2_431_438# u_t026_006/m2_1290_2898#
+ u_t026_006/m2_1714_1210# u_t026_006/m2_431_1982# u_t026_006/m2_512_1265# u_t026_006/m2_2573_2126#
+ u_t026_006/m2_603_1259# u_t026_006/m2_2074_2909# u_t026_006/m2_7_336# u_t026_006/m2_717_2037#
+ u_t026_006/m2_1886_2031# u_t026_006/m2_2573_336# u_t026_006/m2_7_2898# u_t026_006/m2_2000_1265#
+ u_t026_006/m2_512_2037# u_t026_006/m2_1795_1265# u_t026_006/m2_1714_1982# u_t026_006/m2_1886_1259#
+ u_t026_006/m2_1290_2126# u_t026_006/m2_1714_438# u_t026_006/m2_431_1210# u_t026_006/m2_2573_2898#
+ u_t026_006/m2_2154_303# u_t026_006/m2_871_2081# VSUBS detronyx_12t_2w2r_rc4_4x4_routed_5layer_direct
Xgf180mcu_as_sc_mcu7t3v3__nand4_2_62 VSS VSS VSS VSS VSS VSS gf180mcu_as_sc_mcu7t3v3__inv_2_4/A
+ gf180mcu_as_sc_mcu7t3v3__inv_2_4/VNW VSUBS gf180mcu_as_sc_mcu7t3v3__nand4_2
Xgf180mcu_as_sc_mcu7t3v3__nand4_2_95 VSS VSS VSS VSS VSS VSS gf180mcu_as_sc_mcu7t3v3__inv_2_66/A
+ gf180mcu_as_sc_mcu7t3v3__inv_2_66/VNW VSUBS gf180mcu_as_sc_mcu7t3v3__nand4_2
Xgf180mcu_as_sc_mcu7t3v3__nand4_2_84 VSS VSS VSS VSS VSS VSS gf180mcu_as_sc_mcu7t3v3__inv_2_69/A
+ gf180mcu_as_sc_mcu7t3v3__inv_2_69/VNW VSUBS gf180mcu_as_sc_mcu7t3v3__nand4_2
Xgf180mcu_as_sc_mcu7t3v3__nand4_2_40 VSS VSS VSS VSS VSS VSS gf180mcu_as_sc_mcu7t3v3__inv_2_200/A
+ gf180mcu_as_sc_mcu7t3v3__inv_2_200/VNW VSUBS gf180mcu_as_sc_mcu7t3v3__nand4_2
Xgf180mcu_as_sc_mcu7t3v3__nand4_2_178 VSS VSS VSS VSS VSS VSS gf180mcu_as_sc_mcu7t3v3__inv_2_642/A
+ gf180mcu_as_sc_mcu7t3v3__inv_2_665/VNW VSUBS gf180mcu_as_sc_mcu7t3v3__nand4_2
Xgf180mcu_as_sc_mcu7t3v3__nand4_2_189 VSS VSS VSS VSS VSS VSS gf180mcu_as_sc_mcu7t3v3__inv_2_728/A
+ gf180mcu_as_sc_mcu7t3v3__inv_2_728/VNW VSUBS gf180mcu_as_sc_mcu7t3v3__nand4_2
Xgf180mcu_as_sc_mcu7t3v3__nand4_2_73 VSS VSS VSS VSS VSS VSS gf180mcu_as_sc_mcu7t3v3__inv_2_323/A
+ gf180mcu_as_sc_mcu7t3v3__inv_2_323/VNW VSUBS gf180mcu_as_sc_mcu7t3v3__nand4_2
Xgf180mcu_as_sc_mcu7t3v3__nand4_2_51 VSS VSS VSS VSS VSS VSS gf180mcu_as_sc_mcu7t3v3__inv_2_233/A
+ gf180mcu_as_sc_mcu7t3v3__inv_2_233/VNW VSUBS gf180mcu_as_sc_mcu7t3v3__nand4_2
Xu_t017_006 u_t017_006/c0_w0_bl u_t017_006/c0_w0_br u_t017_006/c0_w1_bl u_t017_006/c0_w1_br
+ u_t017_006/c0_r0_rbl u_t017_006/c0_r1_rbl u_t017_006/c1_w0_bl u_t017_006/c1_w0_br
+ u_t017_006/c1_w1_bl u_t017_006/c1_w1_br u_t017_006/c1_r0_rbl u_t017_006/c1_r1_rbl
+ u_t017_006/c2_w0_bl u_t017_006/c2_w0_br u_t017_006/c2_w1_bl u_t017_006/c2_w1_br
+ u_t017_006/c2_r0_rbl u_t017_006/c2_r1_rbl u_t017_006/c3_w0_bl u_t017_006/c3_w0_br
+ u_t017_006/c3_w1_bl u_t017_006/c3_w1_br u_t017_006/c3_r0_rbl u_t017_006/c3_r1_rbl
+ u_t017_006/r0_w0_wl u_t017_006/r0_w1_wl u_t017_006/r0_r0_rwl u_t017_006/r0_r1_rwl
+ u_t017_006/r1_w0_wl u_t017_006/r1_w1_wl u_t017_006/r1_r0_rwl u_t017_006/r1_r1_rwl
+ u_t017_006/r2_w0_wl u_t017_006/r2_w1_wl u_t017_006/r2_r0_rwl u_t017_006/r2_r1_rwl
+ u_t017_006/r3_w0_wl u_t017_006/r3_w1_wl u_t017_006/r3_r0_rwl u_t017_006/r3_r1_rwl
+ VSS VSS u_t017_006/m2_717_1265# u_t017_006/m2_603_2031# u_t017_006/m2_1290_336#
+ u_t017_006/m2_2000_2037# u_t017_006/m2_791_2909# u_t017_006/m2_7_2126# u_t017_006/m2_2154_2081#
+ u_t017_006/m2_1795_2037# u_t017_006/m2_871_303# u_t017_006/m2_431_438# u_t017_006/m2_1290_2898#
+ u_t017_006/m2_1714_1210# u_t017_006/m2_431_1982# u_t017_006/m2_512_1265# u_t017_006/m2_2573_2126#
+ u_t017_006/m2_603_1259# u_t017_006/m2_2074_2909# u_t017_006/m2_7_336# u_t017_006/m2_717_2037#
+ u_t017_006/m2_1886_2031# u_t017_006/m2_2573_336# u_t017_006/m2_7_2898# u_t017_006/m2_2000_1265#
+ u_t017_006/m2_512_2037# u_t017_006/m2_1795_1265# u_t017_006/m2_1714_1982# u_t017_006/m2_1886_1259#
+ u_t017_006/m2_1290_2126# u_t017_006/m2_1714_438# u_t017_006/m2_431_1210# u_t017_006/m2_2573_2898#
+ u_t017_006/m2_2154_303# u_t017_006/m2_871_2081# VSUBS detronyx_12t_2w2r_rc4_4x4_routed_5layer_direct
Xgf180mcu_as_sc_mcu7t3v3__inv_2_109 VSS VSS gf180mcu_as_sc_mcu7t3v3__inv_2_109/Y gf180mcu_as_sc_mcu7t3v3__inv_2_110/Y
+ gf180mcu_as_sc_mcu7t3v3__inv_2_110/VNW VSUBS gf180mcu_as_sc_mcu7t3v3__inv_2
Xgf180mcu_as_sc_mcu7t3v3__inv_2_1192 gf180mcu_as_sc_mcu7t3v3__nand3_2_65/VDD gf180mcu_as_sc_mcu7t3v3__nor2_2_9/VSS
+ VSS VSS gf180mcu_as_sc_mcu7t3v3__nand3_2_65/VNW VSUBS gf180mcu_as_sc_mcu7t3v3__inv_2
Xgf180mcu_as_sc_mcu7t3v3__inv_2_1181 VSS VSS gf180mcu_as_sc_mcu7t3v3__inv_2_1297/A
+ gf180mcu_as_sc_mcu7t3v3__inv_2_1182/Y gf180mcu_as_sc_mcu7t3v3__inv_2_1297/VNW VSUBS
+ gf180mcu_as_sc_mcu7t3v3__inv_2
Xgf180mcu_as_sc_mcu7t3v3__inv_2_1170 VSS VSS gf180mcu_as_sc_mcu7t3v3__inv_2_1271/A
+ gf180mcu_as_sc_mcu7t3v3__inv_2_1171/Y gf180mcu_as_sc_mcu7t3v3__inv_2_1271/VNW VSUBS
+ gf180mcu_as_sc_mcu7t3v3__inv_2
Xu_t023_009 u_t023_009/c0_w0_bl u_t023_009/c0_w0_br u_t023_009/c0_w1_bl u_t023_009/c0_w1_br
+ u_t023_009/c0_r0_rbl u_t023_009/c0_r1_rbl u_t023_009/c1_w0_bl u_t023_009/c1_w0_br
+ u_t023_009/c1_w1_bl u_t023_009/c1_w1_br u_t023_009/c1_r0_rbl u_t023_009/c1_r1_rbl
+ u_t023_009/c2_w0_bl u_t023_009/c2_w0_br u_t023_009/c2_w1_bl u_t023_009/c2_w1_br
+ u_t023_009/c2_r0_rbl u_t023_009/c2_r1_rbl u_t023_009/c3_w0_bl u_t023_009/c3_w0_br
+ u_t023_009/c3_w1_bl u_t023_009/c3_w1_br u_t023_009/c3_r0_rbl u_t023_009/c3_r1_rbl
+ u_t023_009/r0_w0_wl u_t023_009/r0_w1_wl u_t023_009/r0_r0_rwl u_t023_009/r0_r1_rwl
+ u_t023_009/r1_w0_wl u_t023_009/r1_w1_wl u_t023_009/r1_r0_rwl u_t023_009/r1_r1_rwl
+ u_t023_009/r2_w0_wl u_t023_009/r2_w1_wl u_t023_009/r2_r0_rwl u_t023_009/r2_r1_rwl
+ u_t023_009/r3_w0_wl u_t023_009/r3_w1_wl u_t023_009/r3_r0_rwl u_t023_009/r3_r1_rwl
+ VSS VSS u_t023_009/m2_717_1265# u_t023_009/m2_603_2031# u_t023_009/m2_1290_336#
+ u_t023_009/m2_2000_2037# u_t023_009/m2_791_2909# u_t023_009/m2_7_2126# u_t023_009/m2_2154_2081#
+ u_t023_009/m2_1795_2037# u_t023_009/m2_871_303# u_t023_009/m2_431_438# u_t023_009/m2_1290_2898#
+ u_t023_009/m2_1714_1210# u_t023_009/m2_431_1982# u_t023_009/m2_512_1265# u_t023_009/m2_2573_2126#
+ u_t023_009/m2_603_1259# u_t023_009/m2_2074_2909# u_t023_009/m2_7_336# u_t023_009/m2_717_2037#
+ u_t023_009/m2_1886_2031# u_t023_009/m2_2573_336# u_t023_009/m2_7_2898# u_t023_009/m2_2000_1265#
+ u_t023_009/m2_512_2037# u_t023_009/m2_1795_1265# u_t023_009/m2_1714_1982# u_t023_009/m2_1886_1259#
+ u_t023_009/m2_1290_2126# u_t023_009/m2_1714_438# u_t023_009/m2_431_1210# u_t023_009/m2_2573_2898#
+ u_t023_009/m2_2154_303# u_t023_009/m2_871_2081# VSUBS detronyx_12t_2w2r_rc4_4x4_routed_5layer_direct
Xu_t008_006 u_t008_006/c0_w0_bl u_t008_006/c0_w0_br u_t008_006/c0_w1_bl u_t008_006/c0_w1_br
+ u_t008_006/c0_r0_rbl u_t008_006/c0_r1_rbl u_t008_006/c1_w0_bl u_t008_006/c1_w0_br
+ u_t008_006/c1_w1_bl u_t008_006/c1_w1_br u_t008_006/c1_r0_rbl u_t008_006/c1_r1_rbl
+ u_t008_006/c2_w0_bl u_t008_006/c2_w0_br u_t008_006/c2_w1_bl u_t008_006/c2_w1_br
+ u_t008_006/c2_r0_rbl u_t008_006/c2_r1_rbl u_t008_006/c3_w0_bl u_t008_006/c3_w0_br
+ u_t008_006/c3_w1_bl u_t008_006/c3_w1_br u_t008_006/c3_r0_rbl u_t008_006/c3_r1_rbl
+ u_t008_006/r0_w0_wl u_t008_006/r0_w1_wl u_t008_006/r0_r0_rwl u_t008_006/r0_r1_rwl
+ u_t008_006/r1_w0_wl u_t008_006/r1_w1_wl u_t008_006/r1_r0_rwl u_t008_006/r1_r1_rwl
+ u_t008_006/r2_w0_wl u_t008_006/r2_w1_wl u_t008_006/r2_r0_rwl u_t008_006/r2_r1_rwl
+ u_t008_006/r3_w0_wl u_t008_006/r3_w1_wl u_t008_006/r3_r0_rwl u_t008_006/r3_r1_rwl
+ VSS VSS u_t008_006/m2_717_1265# u_t008_006/m2_603_2031# u_t008_006/m2_1290_336#
+ u_t008_006/m2_2000_2037# u_t008_006/m2_791_2909# u_t008_006/m2_7_2126# u_t008_006/m2_2154_2081#
+ u_t008_006/m2_1795_2037# u_t008_006/m2_871_303# u_t008_006/m2_431_438# u_t008_006/m2_1290_2898#
+ u_t008_006/m2_1714_1210# u_t008_006/m2_431_1982# u_t008_006/m2_512_1265# u_t008_006/m2_2573_2126#
+ u_t008_006/m2_603_1259# u_t008_006/m2_2074_2909# u_t008_006/m2_7_336# u_t008_006/m2_717_2037#
+ u_t008_006/m2_1886_2031# u_t008_006/m2_2573_336# u_t008_006/m2_7_2898# u_t008_006/m2_2000_1265#
+ u_t008_006/m2_512_2037# u_t008_006/m2_1795_1265# u_t008_006/m2_1714_1982# u_t008_006/m2_1886_1259#
+ u_t008_006/m2_1290_2126# u_t008_006/m2_1714_438# u_t008_006/m2_431_1210# u_t008_006/m2_2573_2898#
+ u_t008_006/m2_2154_303# u_t008_006/m2_871_2081# VSUBS detronyx_12t_2w2r_rc4_4x4_routed_5layer_direct
Xgf180mcu_as_sc_mcu7t3v3__inv_2_621 VSS VSS gf180mcu_as_sc_mcu7t3v3__inv_2_621/Y gf180mcu_as_sc_mcu7t3v3__inv_2_637/Y
+ gf180mcu_as_sc_mcu7t3v3__inv_2_637/VNW VSUBS gf180mcu_as_sc_mcu7t3v3__inv_2
Xgf180mcu_as_sc_mcu7t3v3__inv_2_610 VSS VSS gf180mcu_as_sc_mcu7t3v3__inv_2_610/Y gf180mcu_as_sc_mcu7t3v3__inv_2_610/A
+ gf180mcu_as_sc_mcu7t3v3__inv_2_610/VNW VSUBS gf180mcu_as_sc_mcu7t3v3__inv_2
Xgf180mcu_as_sc_mcu7t3v3__inv_2_632 VSS VSS gf180mcu_as_sc_mcu7t3v3__inv_2_632/Y gf180mcu_as_sc_mcu7t3v3__inv_2_632/A
+ gf180mcu_as_sc_mcu7t3v3__inv_2_632/VNW VSUBS gf180mcu_as_sc_mcu7t3v3__inv_2
Xgf180mcu_as_sc_mcu7t3v3__inv_2_654 VSS VSS VSS gf180mcu_as_sc_mcu7t3v3__inv_2_655/Y
+ gf180mcu_as_sc_mcu7t3v3__inv_2_656/VNW VSUBS gf180mcu_as_sc_mcu7t3v3__inv_2
Xgf180mcu_as_sc_mcu7t3v3__inv_2_643 VSS VSS gf180mcu_as_sc_mcu7t3v3__inv_2_665/A gf180mcu_as_sc_mcu7t3v3__inv_2_643/A
+ gf180mcu_as_sc_mcu7t3v3__inv_2_665/VNW VSUBS gf180mcu_as_sc_mcu7t3v3__inv_2
Xgf180mcu_as_sc_mcu7t3v3__inv_2_687 VSS VSS gf180mcu_as_sc_mcu7t3v3__inv_2_687/Y gf180mcu_as_sc_mcu7t3v3__inv_2_688/Y
+ gf180mcu_as_sc_mcu7t3v3__inv_2_688/VNW VSUBS gf180mcu_as_sc_mcu7t3v3__inv_2
Xgf180mcu_as_sc_mcu7t3v3__inv_2_665 VSS VSS VSS gf180mcu_as_sc_mcu7t3v3__inv_2_665/A
+ gf180mcu_as_sc_mcu7t3v3__inv_2_665/VNW VSUBS gf180mcu_as_sc_mcu7t3v3__inv_2
Xgf180mcu_as_sc_mcu7t3v3__inv_2_676 VSS VSS VSS gf180mcu_as_sc_mcu7t3v3__inv_2_677/Y
+ gf180mcu_as_sc_mcu7t3v3__inv_2_678/VNW VSUBS gf180mcu_as_sc_mcu7t3v3__inv_2
Xgf180mcu_as_sc_mcu7t3v3__inv_2_698 VSS VSS VSS gf180mcu_as_sc_mcu7t3v3__inv_2_699/Y
+ gf180mcu_as_sc_mcu7t3v3__inv_2_708/VNW VSUBS gf180mcu_as_sc_mcu7t3v3__inv_2
Xu_t014_009 u_t014_009/c0_w0_bl u_t014_009/c0_w0_br u_t014_009/c0_w1_bl u_t014_009/c0_w1_br
+ u_t014_009/c0_r0_rbl u_t014_009/c0_r1_rbl u_t014_009/c1_w0_bl u_t014_009/c1_w0_br
+ u_t014_009/c1_w1_bl u_t014_009/c1_w1_br u_t014_009/c1_r0_rbl u_t014_009/c1_r1_rbl
+ u_t014_009/c2_w0_bl u_t014_009/c2_w0_br u_t014_009/c2_w1_bl u_t014_009/c2_w1_br
+ u_t014_009/c2_r0_rbl u_t014_009/c2_r1_rbl u_t014_009/c3_w0_bl u_t014_009/c3_w0_br
+ u_t014_009/c3_w1_bl u_t014_009/c3_w1_br u_t014_009/c3_r0_rbl u_t014_009/c3_r1_rbl
+ u_t014_009/r0_w0_wl u_t014_009/r0_w1_wl u_t014_009/r0_r0_rwl u_t014_009/r0_r1_rwl
+ u_t014_009/r1_w0_wl u_t014_009/r1_w1_wl u_t014_009/r1_r0_rwl u_t014_009/r1_r1_rwl
+ u_t014_009/r2_w0_wl u_t014_009/r2_w1_wl u_t014_009/r2_r0_rwl u_t014_009/r2_r1_rwl
+ u_t014_009/r3_w0_wl u_t014_009/r3_w1_wl u_t014_009/r3_r0_rwl u_t014_009/r3_r1_rwl
+ VSS VSS u_t014_009/m2_717_1265# u_t014_009/m2_603_2031# u_t014_009/m2_1290_336#
+ u_t014_009/m2_2000_2037# u_t014_009/m2_791_2909# u_t014_009/m2_7_2126# u_t014_009/m2_2154_2081#
+ u_t014_009/m2_1795_2037# u_t014_009/m2_871_303# u_t014_009/m2_431_438# u_t014_009/m2_1290_2898#
+ u_t014_009/m2_1714_1210# u_t014_009/m2_431_1982# u_t014_009/m2_512_1265# u_t014_009/m2_2573_2126#
+ u_t014_009/m2_603_1259# u_t014_009/m2_2074_2909# u_t014_009/m2_7_336# u_t014_009/m2_717_2037#
+ u_t014_009/m2_1886_2031# u_t014_009/m2_2573_336# u_t014_009/m2_7_2898# u_t014_009/m2_2000_1265#
+ u_t014_009/m2_512_2037# u_t014_009/m2_1795_1265# u_t014_009/m2_1714_1982# u_t014_009/m2_1886_1259#
+ u_t014_009/m2_1290_2126# u_t014_009/m2_1714_438# u_t014_009/m2_431_1210# u_t014_009/m2_2573_2898#
+ u_t014_009/m2_2154_303# u_t014_009/m2_871_2081# VSUBS detronyx_12t_2w2r_rc4_4x4_routed_5layer_direct
Xu_t005_009 u_t005_009/c0_w0_bl u_t005_009/c0_w0_br u_t005_009/c0_w1_bl u_t005_009/c0_w1_br
+ u_t005_009/c0_r0_rbl u_t005_009/c0_r1_rbl u_t005_009/c1_w0_bl u_t005_009/c1_w0_br
+ u_t005_009/c1_w1_bl u_t005_009/c1_w1_br u_t005_009/c1_r0_rbl u_t005_009/c1_r1_rbl
+ u_t005_009/c2_w0_bl u_t005_009/c2_w0_br u_t005_009/c2_w1_bl u_t005_009/c2_w1_br
+ u_t005_009/c2_r0_rbl u_t005_009/c2_r1_rbl u_t005_009/c3_w0_bl u_t005_009/c3_w0_br
+ u_t005_009/c3_w1_bl u_t005_009/c3_w1_br u_t005_009/c3_r0_rbl u_t005_009/c3_r1_rbl
+ u_t005_009/r0_w0_wl u_t005_009/r0_w1_wl u_t005_009/r0_r0_rwl u_t005_009/r0_r1_rwl
+ u_t005_009/r1_w0_wl u_t005_009/r1_w1_wl u_t005_009/r1_r0_rwl u_t005_009/r1_r1_rwl
+ u_t005_009/r2_w0_wl u_t005_009/r2_w1_wl u_t005_009/r2_r0_rwl u_t005_009/r2_r1_rwl
+ u_t005_009/r3_w0_wl u_t005_009/r3_w1_wl u_t005_009/r3_r0_rwl u_t005_009/r3_r1_rwl
+ VSS VSS u_t005_009/m2_717_1265# u_t005_009/m2_603_2031# u_t005_009/m2_1290_336#
+ u_t005_009/m2_2000_2037# u_t005_009/m2_791_2909# u_t005_009/m2_7_2126# u_t005_009/m2_2154_2081#
+ u_t005_009/m2_1795_2037# u_t005_009/m2_871_303# u_t005_009/m2_431_438# u_t005_009/m2_1290_2898#
+ u_t005_009/m2_1714_1210# u_t005_009/m2_431_1982# u_t005_009/m2_512_1265# u_t005_009/m2_2573_2126#
+ u_t005_009/m2_603_1259# u_t005_009/m2_2074_2909# u_t005_009/m2_7_336# u_t005_009/m2_717_2037#
+ u_t005_009/m2_1886_2031# u_t005_009/m2_2573_336# u_t005_009/m2_7_2898# u_t005_009/m2_2000_1265#
+ u_t005_009/m2_512_2037# u_t005_009/m2_1795_1265# u_t005_009/m2_1714_1982# u_t005_009/m2_1886_1259#
+ u_t005_009/m2_1290_2126# u_t005_009/m2_1714_438# u_t005_009/m2_431_1210# u_t005_009/m2_2573_2898#
+ u_t005_009/m2_2154_303# u_t005_009/m2_871_2081# VSUBS detronyx_12t_2w2r_rc4_4x4_routed_5layer_direct
Xgf180mcu_as_sc_mcu7t3v3__inv_2_484 VSS VSS gf180mcu_as_sc_mcu7t3v3__inv_2_548/A gf180mcu_as_sc_mcu7t3v3__inv_2_485/Y
+ gf180mcu_as_sc_mcu7t3v3__inv_2_548/VNW VSUBS gf180mcu_as_sc_mcu7t3v3__inv_2
Xgf180mcu_as_sc_mcu7t3v3__inv_2_440 VSS VSS gf180mcu_as_sc_mcu7t3v3__inv_2_440/Y gf180mcu_as_sc_mcu7t3v3__inv_2_440/A
+ gf180mcu_as_sc_mcu7t3v3__inv_2_551/VNW VSUBS gf180mcu_as_sc_mcu7t3v3__inv_2
Xgf180mcu_as_sc_mcu7t3v3__inv_2_462 gf180mcu_as_sc_mcu7t3v3__nor2_2_7/VDD gf180mcu_as_sc_mcu7t3v3__nand3_2_4/VSS
+ gf180mcu_as_sc_mcu7t3v3__inv_2_462/Y VSS gf180mcu_as_sc_mcu7t3v3__nor2_2_7/VNW VSUBS
+ gf180mcu_as_sc_mcu7t3v3__inv_2
Xgf180mcu_as_sc_mcu7t3v3__inv_2_451 gf180mcu_as_sc_mcu7t3v3__nor2_2_4/VDD gf180mcu_as_sc_mcu7t3v3__nor2_2_4/VSS
+ VSS VSS gf180mcu_as_sc_mcu7t3v3__nor2_2_4/VNW VSUBS gf180mcu_as_sc_mcu7t3v3__inv_2
Xgf180mcu_as_sc_mcu7t3v3__inv_2_473 gf180mcu_as_sc_mcu7t3v3__nor2_2_4/VDD gf180mcu_as_sc_mcu7t3v3__nor2_2_4/VSS
+ VSS VSS gf180mcu_as_sc_mcu7t3v3__nor2_2_4/VNW VSUBS gf180mcu_as_sc_mcu7t3v3__inv_2
Xgf180mcu_as_sc_mcu7t3v3__inv_2_495 VSS VSS gf180mcu_as_sc_mcu7t3v3__inv_2_561/A gf180mcu_as_sc_mcu7t3v3__inv_2_498/Y
+ gf180mcu_as_sc_mcu7t3v3__inv_2_561/VNW VSUBS gf180mcu_as_sc_mcu7t3v3__inv_2
Xu_t010_012 u_t010_012/c0_w0_bl u_t010_012/c0_w0_br u_t010_012/c0_w1_bl u_t010_012/c0_w1_br
+ u_t010_012/c0_r0_rbl u_t010_012/c0_r1_rbl u_t010_012/c1_w0_bl u_t010_012/c1_w0_br
+ u_t010_012/c1_w1_bl u_t010_012/c1_w1_br u_t010_012/c1_r0_rbl u_t010_012/c1_r1_rbl
+ u_t010_012/c2_w0_bl u_t010_012/c2_w0_br u_t010_012/c2_w1_bl u_t010_012/c2_w1_br
+ u_t010_012/c2_r0_rbl u_t010_012/c2_r1_rbl u_t010_012/c3_w0_bl u_t010_012/c3_w0_br
+ u_t010_012/c3_w1_bl u_t010_012/c3_w1_br u_t010_012/c3_r0_rbl u_t010_012/c3_r1_rbl
+ u_t010_012/r0_w0_wl u_t010_012/r0_w1_wl u_t010_012/r0_r0_rwl u_t010_012/r0_r1_rwl
+ u_t010_012/r1_w0_wl u_t010_012/r1_w1_wl u_t010_012/r1_r0_rwl u_t010_012/r1_r1_rwl
+ u_t010_012/r2_w0_wl u_t010_012/r2_w1_wl u_t010_012/r2_r0_rwl u_t010_012/r2_r1_rwl
+ u_t010_012/r3_w0_wl u_t010_012/r3_w1_wl u_t010_012/r3_r0_rwl u_t010_012/r3_r1_rwl
+ VSS VSS u_t010_012/m2_717_1265# u_t010_012/m2_603_2031# u_t010_012/m2_1290_336#
+ u_t010_012/m2_2000_2037# u_t010_012/m2_791_2909# u_t010_012/m2_7_2126# u_t010_012/m2_2154_2081#
+ u_t010_012/m2_1795_2037# u_t010_012/m2_871_303# u_t010_012/m2_431_438# u_t010_012/m2_1290_2898#
+ u_t010_012/m2_1714_1210# u_t010_012/m2_431_1982# u_t010_012/m2_512_1265# u_t010_012/m2_2573_2126#
+ u_t010_012/m2_603_1259# u_t010_012/m2_2074_2909# u_t010_012/m2_7_336# u_t010_012/m2_717_2037#
+ u_t010_012/m2_1886_2031# u_t010_012/m2_2573_336# u_t010_012/m2_7_2898# u_t010_012/m2_2000_1265#
+ u_t010_012/m2_512_2037# u_t010_012/m2_1795_1265# u_t010_012/m2_1714_1982# u_t010_012/m2_1886_1259#
+ u_t010_012/m2_1290_2126# u_t010_012/m2_1714_438# u_t010_012/m2_431_1210# u_t010_012/m2_2573_2898#
+ u_t010_012/m2_2154_303# u_t010_012/m2_871_2081# VSUBS detronyx_12t_2w2r_rc4_4x4_routed_5layer_direct
Xu_t010_001 u_t010_001/c0_w0_bl u_t010_001/c0_w0_br u_t010_001/c0_w1_bl u_t010_001/c0_w1_br
+ u_t010_001/c0_r0_rbl u_t010_001/c0_r1_rbl u_t010_001/c1_w0_bl u_t010_001/c1_w0_br
+ u_t010_001/c1_w1_bl u_t010_001/c1_w1_br u_t010_001/c1_r0_rbl u_t010_001/c1_r1_rbl
+ u_t010_001/c2_w0_bl u_t010_001/c2_w0_br u_t010_001/c2_w1_bl u_t010_001/c2_w1_br
+ u_t010_001/c2_r0_rbl u_t010_001/c2_r1_rbl u_t010_001/c3_w0_bl u_t010_001/c3_w0_br
+ u_t010_001/c3_w1_bl u_t010_001/c3_w1_br u_t010_001/c3_r0_rbl u_t010_001/c3_r1_rbl
+ u_t010_001/r0_w0_wl u_t010_001/r0_w1_wl u_t010_001/r0_r0_rwl u_t010_001/r0_r1_rwl
+ u_t010_001/r1_w0_wl u_t010_001/r1_w1_wl u_t010_001/r1_r0_rwl u_t010_001/r1_r1_rwl
+ u_t010_001/r2_w0_wl u_t010_001/r2_w1_wl u_t010_001/r2_r0_rwl u_t010_001/r2_r1_rwl
+ u_t010_001/r3_w0_wl u_t010_001/r3_w1_wl u_t010_001/r3_r0_rwl u_t010_001/r3_r1_rwl
+ VSS VSS u_t010_001/m2_717_1265# u_t010_001/m2_603_2031# u_t010_001/m2_1290_336#
+ u_t010_001/m2_2000_2037# u_t010_001/m2_791_2909# u_t010_001/m2_7_2126# u_t010_001/m2_2154_2081#
+ u_t010_001/m2_1795_2037# u_t010_001/m2_871_303# u_t010_001/m2_431_438# u_t010_001/m2_1290_2898#
+ u_t010_001/m2_1714_1210# u_t010_001/m2_431_1982# u_t010_001/m2_512_1265# u_t010_001/m2_2573_2126#
+ u_t010_001/m2_603_1259# u_t010_001/m2_2074_2909# u_t010_001/m2_7_336# u_t010_001/m2_717_2037#
+ u_t010_001/m2_1886_2031# u_t010_001/m2_2573_336# u_t010_001/m2_7_2898# u_t010_001/m2_2000_1265#
+ u_t010_001/m2_512_2037# u_t010_001/m2_1795_1265# u_t010_001/m2_1714_1982# u_t010_001/m2_1886_1259#
+ u_t010_001/m2_1290_2126# u_t010_001/m2_1714_438# u_t010_001/m2_431_1210# u_t010_001/m2_2573_2898#
+ u_t010_001/m2_2154_303# u_t010_001/m2_871_2081# VSUBS detronyx_12t_2w2r_rc4_4x4_routed_5layer_direct
Xu_t001_012 u_t001_012/c0_w0_bl u_t001_012/c0_w0_br u_t001_012/c0_w1_bl u_t001_012/c0_w1_br
+ u_t001_012/c0_r0_rbl u_t001_012/c0_r1_rbl u_t001_012/c1_w0_bl u_t001_012/c1_w0_br
+ u_t001_012/c1_w1_bl u_t001_012/c1_w1_br u_t001_012/c1_r0_rbl u_t001_012/c1_r1_rbl
+ u_t001_012/c2_w0_bl u_t001_012/c2_w0_br u_t001_012/c2_w1_bl u_t001_012/c2_w1_br
+ u_t001_012/c2_r0_rbl u_t001_012/c2_r1_rbl u_t001_012/c3_w0_bl u_t001_012/c3_w0_br
+ u_t001_012/c3_w1_bl u_t001_012/c3_w1_br u_t001_012/c3_r0_rbl u_t001_012/c3_r1_rbl
+ u_t001_012/r0_w0_wl u_t001_012/r0_w1_wl u_t001_012/r0_r0_rwl u_t001_012/r0_r1_rwl
+ u_t001_012/r1_w0_wl u_t001_012/r1_w1_wl u_t001_012/r1_r0_rwl u_t001_012/r1_r1_rwl
+ u_t001_012/r2_w0_wl u_t001_012/r2_w1_wl u_t001_012/r2_r0_rwl u_t001_012/r2_r1_rwl
+ u_t001_012/r3_w0_wl u_t001_012/r3_w1_wl u_t001_012/r3_r0_rwl u_t001_012/r3_r1_rwl
+ VSS VSS u_t001_012/m2_717_1265# u_t001_012/m2_603_2031# u_t001_012/m2_1290_336#
+ u_t001_012/m2_2000_2037# u_t001_012/m2_791_2909# u_t001_012/m2_7_2126# u_t001_012/m2_2154_2081#
+ u_t001_012/m2_1795_2037# u_t001_012/m2_871_303# u_t001_012/m2_431_438# u_t001_012/m2_1290_2898#
+ u_t001_012/m2_1714_1210# u_t001_012/m2_431_1982# u_t001_012/m2_512_1265# u_t001_012/m2_2573_2126#
+ u_t001_012/m2_603_1259# u_t001_012/m2_2074_2909# u_t001_012/m2_7_336# u_t001_012/m2_717_2037#
+ u_t001_012/m2_1886_2031# u_t001_012/m2_2573_336# u_t001_012/m2_7_2898# u_t001_012/m2_2000_1265#
+ u_t001_012/m2_512_2037# u_t001_012/m2_1795_1265# u_t001_012/m2_1714_1982# u_t001_012/m2_1886_1259#
+ u_t001_012/m2_1290_2126# u_t001_012/m2_1714_438# u_t001_012/m2_431_1210# u_t001_012/m2_2573_2898#
+ u_t001_012/m2_2154_303# u_t001_012/m2_871_2081# VSUBS detronyx_12t_2w2r_rc4_4x4_routed_5layer_direct
Xu_t001_001 u_t001_001/c0_w0_bl u_t001_001/c0_w0_br u_t001_001/c0_w1_bl u_t001_001/c0_w1_br
+ u_t001_001/c0_r0_rbl u_t001_001/c0_r1_rbl u_t001_001/c1_w0_bl u_t001_001/c1_w0_br
+ u_t001_001/c1_w1_bl u_t001_001/c1_w1_br u_t001_001/c1_r0_rbl u_t001_001/c1_r1_rbl
+ u_t001_001/c2_w0_bl u_t001_001/c2_w0_br u_t001_001/c2_w1_bl u_t001_001/c2_w1_br
+ u_t001_001/c2_r0_rbl u_t001_001/c2_r1_rbl u_t001_001/c3_w0_bl u_t001_001/c3_w0_br
+ u_t001_001/c3_w1_bl u_t001_001/c3_w1_br u_t001_001/c3_r0_rbl u_t001_001/c3_r1_rbl
+ u_t001_001/r0_w0_wl u_t001_001/r0_w1_wl u_t001_001/r0_r0_rwl u_t001_001/r0_r1_rwl
+ u_t001_001/r1_w0_wl u_t001_001/r1_w1_wl u_t001_001/r1_r0_rwl u_t001_001/r1_r1_rwl
+ u_t001_001/r2_w0_wl u_t001_001/r2_w1_wl u_t001_001/r2_r0_rwl u_t001_001/r2_r1_rwl
+ u_t001_001/r3_w0_wl u_t001_001/r3_w1_wl u_t001_001/r3_r0_rwl u_t001_001/r3_r1_rwl
+ VSS VSS u_t001_001/m2_717_1265# u_t001_001/m2_603_2031# u_t001_001/m2_1290_336#
+ u_t001_001/m2_2000_2037# u_t001_001/m2_791_2909# u_t001_001/m2_7_2126# u_t001_001/m2_2154_2081#
+ u_t001_001/m2_1795_2037# u_t001_001/m2_871_303# u_t001_001/m2_431_438# u_t001_001/m2_1290_2898#
+ u_t001_001/m2_1714_1210# u_t001_001/m2_431_1982# u_t001_001/m2_512_1265# u_t001_001/m2_2573_2126#
+ u_t001_001/m2_603_1259# u_t001_001/m2_2074_2909# u_t001_001/m2_7_336# u_t001_001/m2_717_2037#
+ u_t001_001/m2_1886_2031# u_t001_001/m2_2573_336# u_t001_001/m2_7_2898# u_t001_001/m2_2000_1265#
+ u_t001_001/m2_512_2037# u_t001_001/m2_1795_1265# u_t001_001/m2_1714_1982# u_t001_001/m2_1886_1259#
+ u_t001_001/m2_1290_2126# u_t001_001/m2_1714_438# u_t001_001/m2_431_1210# u_t001_001/m2_2573_2898#
+ u_t001_001/m2_2154_303# u_t001_001/m2_871_2081# VSUBS detronyx_12t_2w2r_rc4_4x4_routed_5layer_direct
Xgf180mcu_as_sc_mcu7t3v3__inv_2_1703 gf180mcu_as_sc_mcu7t3v3__nand3_2_9/VDD gf180mcu_as_sc_mcu7t3v3__nor2_2_7/VSS
+ VSS VSS gf180mcu_as_sc_mcu7t3v3__nand3_2_9/VNW VSUBS gf180mcu_as_sc_mcu7t3v3__inv_2
Xgf180mcu_as_sc_mcu7t3v3__inv_2_281 VSS VSS gf180mcu_as_sc_mcu7t3v3__inv_2_281/Y gf180mcu_as_sc_mcu7t3v3__inv_2_281/A
+ gf180mcu_as_sc_mcu7t3v3__inv_2_281/VNW VSUBS gf180mcu_as_sc_mcu7t3v3__inv_2
Xgf180mcu_as_sc_mcu7t3v3__inv_2_292 VSS VSS gf180mcu_as_sc_mcu7t3v3__inv_2_302/A gf180mcu_as_sc_mcu7t3v3__inv_2_292/A
+ gf180mcu_as_sc_mcu7t3v3__inv_2_302/VNW VSUBS gf180mcu_as_sc_mcu7t3v3__inv_2
Xgf180mcu_as_sc_mcu7t3v3__inv_2_270 VSS VSS VSS gf180mcu_as_sc_mcu7t3v3__inv_2_275/Y
+ gf180mcu_as_sc_mcu7t3v3__inv_2_280/VNW VSUBS gf180mcu_as_sc_mcu7t3v3__inv_2
Xgf180mcu_as_sc_mcu7t3v3__inv_2_1714 gf180mcu_as_sc_mcu7t3v3__nand3_2_65/VDD gf180mcu_as_sc_mcu7t3v3__nand3_2_62/VSS
+ VSS VSS gf180mcu_as_sc_mcu7t3v3__nand3_2_65/VNW VSUBS gf180mcu_as_sc_mcu7t3v3__inv_2
Xgf180mcu_as_sc_mcu7t3v3__inv_2_1725 VSS VSS gf180mcu_as_sc_mcu7t3v3__inv_2_1725/Y
+ gf180mcu_as_sc_mcu7t3v3__inv_2_1726/Y gf180mcu_as_sc_mcu7t3v3__inv_2_1726/VNW VSUBS
+ gf180mcu_as_sc_mcu7t3v3__inv_2
Xgf180mcu_as_sc_mcu7t3v3__nand4_2_508 VSS VSS VSS VSS VSS VSS gf180mcu_as_sc_mcu7t3v3__inv_2_1653/A
+ gf180mcu_as_sc_mcu7t3v3__inv_2_1653/VNW VSUBS gf180mcu_as_sc_mcu7t3v3__nand4_2
Xgf180mcu_as_sc_mcu7t3v3__inv_2_18 VSS VSS VSS gf180mcu_as_sc_mcu7t3v3__inv_2_19/Y
+ gf180mcu_as_sc_mcu7t3v3__inv_2_20/VNW VSUBS gf180mcu_as_sc_mcu7t3v3__inv_2
Xgf180mcu_as_sc_mcu7t3v3__inv_2_29 VSS VSS VSS gf180mcu_as_sc_mcu7t3v3__inv_2_39/Y
+ gf180mcu_as_sc_mcu7t3v3__inv_2_43/VNW VSUBS gf180mcu_as_sc_mcu7t3v3__inv_2
Xgf180mcu_as_sc_mcu7t3v3__inv_2_1544 VSS VSS gf180mcu_as_sc_mcu7t3v3__inv_2_1544/Y
+ gf180mcu_as_sc_mcu7t3v3__inv_2_1544/A gf180mcu_as_sc_mcu7t3v3__inv_2_1544/VNW VSUBS
+ gf180mcu_as_sc_mcu7t3v3__inv_2
Xgf180mcu_as_sc_mcu7t3v3__inv_2_1522 VSS VSS gf180mcu_as_sc_mcu7t3v3__inv_2_1522/Y
+ gf180mcu_as_sc_mcu7t3v3__inv_2_1523/Y gf180mcu_as_sc_mcu7t3v3__inv_2_1523/VNW VSUBS
+ gf180mcu_as_sc_mcu7t3v3__inv_2
Xgf180mcu_as_sc_mcu7t3v3__inv_2_1533 VSS VSS VSS gf180mcu_as_sc_mcu7t3v3__inv_2_1534/Y
+ gf180mcu_as_sc_mcu7t3v3__inv_2_1535/VNW VSUBS gf180mcu_as_sc_mcu7t3v3__inv_2
Xgf180mcu_as_sc_mcu7t3v3__inv_2_1500 VSS VSS gf180mcu_as_sc_mcu7t3v3__inv_2_1500/Y
+ gf180mcu_as_sc_mcu7t3v3__inv_2_1500/A gf180mcu_as_sc_mcu7t3v3__inv_2_1500/VNW VSUBS
+ gf180mcu_as_sc_mcu7t3v3__inv_2
Xgf180mcu_as_sc_mcu7t3v3__inv_2_1511 VSS VSS gf180mcu_as_sc_mcu7t3v3__inv_2_1511/Y
+ gf180mcu_as_sc_mcu7t3v3__inv_2_1511/A gf180mcu_as_sc_mcu7t3v3__inv_2_1511/VNW VSUBS
+ gf180mcu_as_sc_mcu7t3v3__inv_2
.ends

.subckt gf180mcu_3v3_12t_2r2w_sram_1024x8
Xdetronyx_12t_write_driver_rc1_12 detronyx_12t_write_driver_rc1_12/VDD VSUBS detronyx_12t_write_driver_rc1_12/din
+ VSUBS detronyx_12t_write_driver_rc1_12/wbl0 VSUBS detronyx_12t_write_driver_rc1_12/a_240_2348#
+ detronyx_12t_write_driver_rc1
Xdetronyx_12t_write_driver_rc1_11 detronyx_12t_write_driver_rc1_11/VDD VSUBS detronyx_12t_write_driver_rc1_11/din
+ VSUBS detronyx_12t_write_driver_rc1_11/wbl0 VSUBS detronyx_12t_write_driver_rc1_11/a_240_2348#
+ detronyx_12t_write_driver_rc1
Xdetronyx_12t_write_driver_rc1_13 detronyx_12t_write_driver_rc1_13/VDD VSUBS detronyx_12t_write_driver_rc1_13/din
+ VSUBS detronyx_12t_write_driver_rc1_13/wbl0 VSUBS detronyx_12t_write_driver_rc1_13/a_240_2348#
+ detronyx_12t_write_driver_rc1
Xdetronyx_12t_write_driver_rc1_14 detronyx_12t_write_driver_rc1_14/VDD VSUBS detronyx_12t_write_driver_rc1_14/din
+ VSUBS detronyx_12t_write_driver_rc1_14/wbl0 VSUBS detronyx_12t_write_driver_rc1_14/a_240_2348#
+ detronyx_12t_write_driver_rc1
Xdetronyx_12t_write_driver_rc1_15 detronyx_12t_write_driver_rc1_15/VDD VSUBS VSUBS
+ VSUBS detronyx_12t_write_driver_rc1_15/wbl0 VSUBS VSUBS detronyx_12t_write_driver_rc1
Xdetronyx_12t_precharge_sense_rc1_10 detronyx_12t_precharge_sense_rc1_10/VDD VSUBS
+ VSUBS VSUBS VSUBS VSUBS detronyx_12t_precharge_sense_rc1_10/a_672_2172# detronyx_12t_precharge_sense_rc1_10/a_240_2172#
+ detronyx_12t_precharge_sense_rc1
Xdetronyx_12t_precharge_sense_rc1_11 detronyx_12t_precharge_sense_rc1_11/VDD VSUBS
+ VSUBS VSUBS VSUBS VSUBS detronyx_12t_precharge_sense_rc1_11/a_672_2172# detronyx_12t_precharge_sense_rc1_11/a_240_2172#
+ detronyx_12t_precharge_sense_rc1
Xdetronyx_12t_precharge_sense_rc1_12 detronyx_12t_precharge_sense_rc1_12/VDD VSUBS
+ VSUBS VSUBS VSUBS VSUBS detronyx_12t_precharge_sense_rc1_12/a_672_2172# detronyx_12t_precharge_sense_rc1_12/a_240_2172#
+ detronyx_12t_precharge_sense_rc1
Xdetronyx_12t_precharge_sense_rc1_13 detronyx_12t_precharge_sense_rc1_13/VDD VSUBS
+ VSUBS VSUBS VSUBS VSUBS detronyx_12t_precharge_sense_rc1_13/a_672_2172# detronyx_12t_precharge_sense_rc1_13/a_240_2172#
+ detronyx_12t_precharge_sense_rc1
Xgf180mcu_3v3_12t_2r2w_sram_1024x8_array_control_core_0 VSUBS VSUBS VSUBS detronyx_12t_write_driver_rc1_14/din
+ detronyx_12t_write_driver_rc1_13/din detronyx_12t_write_driver_rc1_12/din detronyx_12t_write_driver_rc1_11/din
+ detronyx_12t_write_driver_rc1_10/din detronyx_12t_write_driver_rc1_9/din detronyx_12t_write_driver_rc1_8/din
+ detronyx_12t_write_driver_rc1_7/din detronyx_12t_write_driver_rc1_6/din detronyx_12t_write_driver_rc1_5/din
+ detronyx_12t_write_driver_rc1_4/din detronyx_12t_write_driver_rc1_3/din detronyx_12t_write_driver_rc1_2/din
+ detronyx_12t_write_driver_rc1_1/din detronyx_12t_write_driver_rc1_0/din VSUBS VSUBS
+ VSUBS VSUBS VSUBS VSUBS VSUBS VSUBS VSUBS VSUBS VSUBS VSUBS VSUBS VSUBS VSUBS VSUBS
+ VSUBS VSUBS VSUBS VSUBS VSUBS VSUBS VSUBS VSUBS VSUBS VSUBS VSUBS VSUBS VSUBS VSUBS
+ VSUBS VSUBS VSUBS VSUBS VSUBS VSUBS VSUBS VSUBS VSUBS VSUBS VSUBS VSUBS VSUBS VSUBS
+ VSUBS VSUBS VSUBS VSUBS VSUBS VSUBS VSUBS VSUBS VSUBS VSUBS VSUBS VSUBS VSUBS VSUBS
+ VSUBS VSUBS VSUBS VSUBS VSUBS VSUBS VSUBS VSUBS VSUBS VSUBS VSUBS VSUBS VSUBS VSUBS
+ VSUBS VSUBS VSUBS VSUBS VSUBS VSUBS VSUBS VSUBS VSUBS VSUBS VSUBS VSUBS VSUBS VSUBS
+ VSUBS VSUBS VSUBS VSUBS VSUBS VSUBS VSUBS VSUBS VSUBS VSUBS VSUBS VSUBS VSUBS VSUBS
+ VSUBS VSUBS VSUBS VSUBS VSUBS VSUBS VSUBS VSUBS VSUBS VSUBS VSUBS VSUBS VSUBS VSUBS
+ VSUBS VSUBS VSUBS VSUBS VSUBS VSUBS VSUBS VSUBS VSUBS VSUBS VSUBS VSUBS VSUBS VSUBS
+ VSUBS VSUBS VSUBS VSUBS VSUBS VSUBS VSUBS VSUBS VSUBS VSUBS VSUBS VSUBS VSUBS VSUBS
+ VSUBS VSUBS VSUBS VSUBS VSUBS VSUBS VSUBS VSUBS VSUBS VSUBS VSUBS VSUBS VSUBS VSUBS
+ VSUBS VSUBS VSUBS VSUBS VSUBS VSUBS VSUBS VSUBS VSUBS VSUBS VSUBS VSUBS VSUBS VSUBS
+ VSUBS VSUBS VSUBS VSUBS VSUBS VSUBS VSUBS VSUBS VSUBS VSUBS VSUBS VSUBS VSUBS VSUBS
+ VSUBS VSUBS VSUBS VSUBS VSUBS VSUBS VSUBS VSUBS VSUBS VSUBS VSUBS VSUBS VSUBS VSUBS
+ VSUBS VSUBS VSUBS VSUBS VSUBS VSUBS VSUBS VSUBS VSUBS VSUBS VSUBS VSUBS VSUBS VSUBS
+ VSUBS VSUBS VSUBS VSUBS VSUBS VSUBS VSUBS VSUBS VSUBS VSUBS VSUBS VSUBS VSUBS VSUBS
+ VSUBS VSUBS VSUBS VSUBS VSUBS VSUBS VSUBS VSUBS VSUBS VSUBS VSUBS VSUBS VSUBS VSUBS
+ VSUBS VSUBS VSUBS VSUBS VSUBS VSUBS VSUBS VSUBS VSUBS VSUBS VSUBS VSUBS VSUBS VSUBS
+ VSUBS VSUBS VSUBS VSUBS VSUBS VSUBS VSUBS VSUBS VSUBS VSUBS VSUBS VSUBS VSUBS VSUBS
+ VSUBS VSUBS VSUBS VSUBS VSUBS VSUBS VSUBS VSUBS VSUBS VSUBS VSUBS VSUBS VSUBS VSUBS
+ VSUBS VSUBS VSUBS VSUBS VSUBS VSUBS VSUBS VSUBS VSUBS VSUBS VSUBS VSUBS VSUBS VSUBS
+ VSUBS VSUBS VSUBS VSUBS VSUBS VSUBS VSUBS VSUBS VSUBS VSUBS VSUBS VSUBS VSUBS VSUBS
+ VSUBS VSUBS VSUBS VSUBS VSUBS VSUBS VSUBS VSUBS VSUBS VSUBS VSUBS VSUBS VSUBS VSUBS
+ VSUBS VSUBS VSUBS VSUBS VSUBS VSUBS VSUBS VSUBS VSUBS VSUBS VSUBS VSUBS VSUBS VSUBS
+ VSUBS VSUBS VSUBS VSUBS VSUBS VSUBS VSUBS VSUBS VSUBS VSUBS VSUBS VSUBS VSUBS VSUBS
+ VSUBS VSUBS VSUBS VSUBS VSUBS VSUBS VSUBS VSUBS VSUBS VSUBS VSUBS VSUBS VSUBS VSUBS
+ VSUBS VSUBS VSUBS VSUBS VSUBS VSUBS VSUBS VSUBS VSUBS VSUBS VSUBS VSUBS VSUBS VSUBS
+ VSUBS VSUBS VSUBS VSUBS VSUBS VSUBS VSUBS VSUBS VSUBS VSUBS VSUBS VSUBS VSUBS VSUBS
+ VSUBS VSUBS VSUBS VSUBS VSUBS VSUBS VSUBS VSUBS VSUBS VSUBS VSUBS VSUBS VSUBS VSUBS
+ VSUBS VSUBS VSUBS VSUBS VSUBS VSUBS VSUBS VSUBS VSUBS VSUBS VSUBS VSUBS VSUBS VSUBS
+ VSUBS VSUBS VSUBS VSUBS VSUBS VSUBS VSUBS VSUBS VSUBS VSUBS VSUBS VSUBS VSUBS VSUBS
+ VSUBS VSUBS VSUBS VSUBS VSUBS VSUBS VSUBS VSUBS VSUBS VSUBS VSUBS VSUBS VSUBS VSUBS
+ VSUBS VSUBS VSUBS VSUBS VSUBS VSUBS VSUBS VSUBS VSUBS VSUBS VSUBS VSUBS VSUBS VSUBS
+ VSUBS VSUBS VSUBS VSUBS VSUBS VSUBS VSUBS VSUBS VSUBS VSUBS VSUBS VSUBS VSUBS VSUBS
+ VSUBS VSUBS VSUBS VSUBS VSUBS VSUBS VSUBS VSUBS VSUBS VSUBS VSUBS VSUBS VSUBS VSUBS
+ VSUBS VSUBS VSUBS VSUBS VSUBS VSUBS VSUBS VSUBS VSUBS VSUBS VSUBS VSUBS VSUBS VSUBS
+ VSUBS VSUBS VSUBS VSUBS VSUBS VSUBS VSUBS VSUBS VSUBS VSUBS VSUBS VSUBS VSUBS VSUBS
+ VSUBS VSUBS VSUBS VSUBS VSUBS VSUBS VSUBS VSUBS VSUBS VSUBS VSUBS VSUBS VSUBS VSUBS
+ VSUBS VSUBS VSUBS VSUBS VSUBS VSUBS VSUBS VSUBS VSUBS VSUBS VSUBS VSUBS VSUBS VSUBS
+ VSUBS VSUBS VSUBS VSUBS VSUBS VSUBS VSUBS VSUBS VSUBS VSUBS VSUBS VSUBS VSUBS VSUBS
+ VSUBS VSUBS VSUBS VSUBS VSUBS VSUBS VSUBS VSUBS VSUBS VSUBS VSUBS VSUBS VSUBS VSUBS
+ VSUBS VSUBS VSUBS VSUBS VSUBS VSUBS VSUBS VSUBS VSUBS VSUBS VSUBS VSUBS VSUBS VSUBS
+ VSUBS VSUBS VSUBS VSUBS VSUBS VSUBS VSUBS VSUBS VSUBS VSUBS VSUBS VSUBS VSUBS VSUBS
+ VSUBS VSUBS VSUBS VSUBS VSUBS VSUBS VSUBS VSUBS VSUBS VSUBS VSUBS VSUBS VSUBS VSUBS
+ VSUBS VSUBS VSUBS VSUBS VSUBS VSUBS VSUBS VSUBS VSUBS VSUBS VSUBS VSUBS VSUBS VSUBS
+ VSUBS VSUBS VSUBS VSUBS VSUBS VSUBS VSUBS VSUBS VSUBS VSUBS VSUBS VSUBS VSUBS VSUBS
+ VSUBS VSUBS VSUBS VSUBS VSUBS VSUBS VSUBS VSUBS VSUBS VSUBS VSUBS VSUBS VSUBS VSUBS
+ VSUBS VSUBS VSUBS VSUBS VSUBS VSUBS VSUBS VSUBS VSUBS VSUBS VSUBS VSUBS VSUBS VSUBS
+ VSUBS VSUBS VSUBS VSUBS VSUBS VSUBS VSUBS VSUBS VSUBS VSUBS VSUBS VSUBS VSUBS VSUBS
+ VSUBS VSUBS VSUBS VSUBS VSUBS VSUBS VSUBS VSUBS VSUBS VSUBS VSUBS VSUBS VSUBS VSUBS
+ VSUBS VSUBS VSUBS VSUBS VSUBS VSUBS VSUBS VSUBS VSUBS VSUBS VSUBS VSUBS VSUBS VSUBS
+ VSUBS VSUBS VSUBS VSUBS VSUBS VSUBS VSUBS VSUBS VSUBS VSUBS VSUBS VSUBS VSUBS VSUBS
+ VSUBS VSUBS VSUBS VSUBS VSUBS VSUBS VSUBS VSUBS VSUBS VSUBS VSUBS VSUBS VSUBS VSUBS
+ VSUBS VSUBS VSUBS VSUBS VSUBS VSUBS VSUBS VSUBS VSUBS VSUBS VSUBS VSUBS VSUBS VSUBS
+ VSUBS VSUBS VSUBS VSUBS VSUBS VSUBS VSUBS VSUBS VSUBS VSUBS VSUBS VSUBS VSUBS VSUBS
+ VSUBS VSUBS VSUBS VSUBS VSUBS VSUBS VSUBS VSUBS VSUBS VSUBS VSUBS VSUBS VSUBS VSUBS
+ VSUBS VSUBS VSUBS VSUBS VSUBS VSUBS VSUBS VSUBS VSUBS VSUBS VSUBS VSUBS VSUBS VSUBS
+ VSUBS VSUBS VSUBS VSUBS VSUBS VSUBS VSUBS VSUBS VSUBS VSUBS VSUBS VSUBS VSUBS VSUBS
+ VSUBS VSUBS VSUBS VSUBS VSUBS VSUBS VSUBS VSUBS VSUBS VSUBS VSUBS VSUBS VSUBS VSUBS
+ VSUBS VSUBS VSUBS VSUBS VSUBS VSUBS VSUBS VSUBS VSUBS VSUBS VSUBS VSUBS VSUBS VSUBS
+ VSUBS VSUBS VSUBS VSUBS VSUBS VSUBS VSUBS VSUBS VSUBS VSUBS VSUBS VSUBS VSUBS VSUBS
+ VSUBS VSUBS VSUBS VSUBS VSUBS VSUBS VSUBS VSUBS VSUBS VSUBS VSUBS VSUBS VSUBS VSUBS
+ VSUBS VSUBS VSUBS VSUBS VSUBS VSUBS VSUBS VSUBS VSUBS VSUBS VSUBS VSUBS VSUBS VSUBS
+ VSUBS VSUBS VSUBS VSUBS VSUBS VSUBS VSUBS VSUBS VSUBS VSUBS VSUBS VSUBS VSUBS VSUBS
+ VSUBS VSUBS VSUBS VSUBS VSUBS VSUBS VSUBS VSUBS VSUBS VSUBS VSUBS VSUBS VSUBS VSUBS
+ VSUBS VSUBS VSUBS VSUBS VSUBS VSUBS VSUBS VSUBS VSUBS VSUBS VSUBS VSUBS VSUBS VSUBS
+ VSUBS VSUBS VSUBS VSUBS VSUBS VSUBS VSUBS VSUBS VSUBS VSUBS VSUBS VSUBS VSUBS VSUBS
+ VSUBS VSUBS VSUBS VSUBS VSUBS VSUBS VSUBS VSUBS VSUBS VSUBS VSUBS VSUBS VSUBS VSUBS
+ VSUBS VSUBS VSUBS VSUBS VSUBS VSUBS VSUBS VSUBS VSUBS VSUBS VSUBS VSUBS VSUBS VSUBS
+ VSUBS VSUBS VSUBS VSUBS VSUBS VSUBS VSUBS VSUBS VSUBS VSUBS VSUBS VSUBS VSUBS VSUBS
+ VSUBS VSUBS VSUBS VSUBS VSUBS VSUBS VSUBS VSUBS VSUBS VSUBS VSUBS VSUBS VSUBS VSUBS
+ VSUBS VSUBS VSUBS VSUBS VSUBS VSUBS VSUBS VSUBS VSUBS VSUBS VSUBS VSUBS VSUBS VSUBS
+ VSUBS VSUBS VSUBS VSUBS VSUBS VSUBS VSUBS VSUBS VSUBS VSUBS VSUBS VSUBS VSUBS VSUBS
+ VSUBS VSUBS VSUBS VSUBS VSUBS VSUBS VSUBS VSUBS VSUBS VSUBS VSUBS VSUBS VSUBS VSUBS
+ VSUBS VSUBS VSUBS VSUBS VSUBS VSUBS VSUBS VSUBS VSUBS VSUBS VSUBS VSUBS VSUBS VSUBS
+ VSUBS VSUBS VSUBS VSUBS VSUBS VSUBS VSUBS VSUBS VSUBS VSUBS VSUBS VSUBS VSUBS VSUBS
+ VSUBS VSUBS VSUBS VSUBS VSUBS VSUBS VSUBS VSUBS VSUBS VSUBS VSUBS VSUBS VSUBS VSUBS
+ VSUBS VSUBS VSUBS VSUBS VSUBS VSUBS VSUBS VSUBS VSUBS VSUBS VSUBS VSUBS VSUBS VSUBS
+ VSUBS VSUBS VSUBS VSUBS VSUBS VSUBS VSUBS VSUBS VSUBS VSUBS VSUBS VSUBS VSUBS VSUBS
+ VSUBS VSUBS VSUBS VSUBS VSUBS VSUBS VSUBS VSUBS VSUBS VSUBS VSUBS VSUBS VSUBS VSUBS
+ VSUBS VSUBS VSUBS VSUBS VSUBS VSUBS VSUBS VSUBS VSUBS VSUBS VSUBS VSUBS VSUBS VSUBS
+ VSUBS VSUBS VSUBS VSUBS VSUBS VSUBS VSUBS VSUBS VSUBS VSUBS VSUBS VSUBS VSUBS VSUBS
+ VSUBS VSUBS VSUBS VSUBS VSUBS VSUBS VSUBS VSUBS VSUBS VSUBS VSUBS VSUBS VSUBS VSUBS
+ VSUBS VSUBS VSUBS VSUBS VSUBS VSUBS VSUBS VSUBS VSUBS VSUBS VSUBS VSUBS VSUBS VSUBS
+ VSUBS VSUBS VSUBS VSUBS VSUBS VSUBS VSUBS VSUBS VSUBS VSUBS VSUBS VSUBS VSUBS VSUBS
+ VSUBS VSUBS VSUBS VSUBS VSUBS VSUBS VSUBS VSUBS VSUBS VSUBS VSUBS VSUBS VSUBS VSUBS
+ VSUBS VSUBS VSUBS VSUBS VSUBS VSUBS VSUBS VSUBS VSUBS VSUBS VSUBS VSUBS VSUBS VSUBS
+ VSUBS VSUBS VSUBS VSUBS VSUBS VSUBS VSUBS VSUBS VSUBS VSUBS VSUBS VSUBS VSUBS VSUBS
+ VSUBS VSUBS VSUBS VSUBS VSUBS VSUBS VSUBS VSUBS VSUBS VSUBS VSUBS VSUBS VSUBS VSUBS
+ VSUBS VSUBS VSUBS VSUBS VSUBS VSUBS VSUBS VSUBS VSUBS VSUBS VSUBS VSUBS VSUBS VSUBS
+ VSUBS VSUBS VSUBS VSUBS VSUBS VSUBS VSUBS VSUBS VSUBS VSUBS VSUBS VSUBS VSUBS VSUBS
+ VSUBS VSUBS VSUBS VSUBS VSUBS VSUBS VSUBS VSUBS VSUBS VSUBS VSUBS VSUBS VSUBS VSUBS
+ VSUBS VSUBS VSUBS VSUBS VSUBS VSUBS VSUBS VSUBS VSUBS VSUBS VSUBS VSUBS VSUBS VSUBS
+ VSUBS VSUBS VSUBS VSUBS VSUBS VSUBS VSUBS VSUBS VSUBS VSUBS VSUBS VSUBS VSUBS VSUBS
+ VSUBS VSUBS VSUBS VSUBS VSUBS VSUBS VSUBS VSUBS VSUBS VSUBS VSUBS VSUBS VSUBS VSUBS
+ VSUBS VSUBS VSUBS VSUBS VSUBS VSUBS VSUBS VSUBS VSUBS VSUBS VSUBS VSUBS VSUBS VSUBS
+ VSUBS VSUBS VSUBS VSUBS VSUBS VSUBS VSUBS VSUBS VSUBS VSUBS VSUBS VSUBS VSUBS VSUBS
+ VSUBS VSUBS VSUBS VSUBS VSUBS VSUBS VSUBS VSUBS VSUBS VSUBS VSUBS VSUBS VSUBS VSUBS
+ VSUBS VSUBS VSUBS VSUBS VSUBS VSUBS VSUBS VSUBS VSUBS VSUBS VSUBS VSUBS VSUBS VSUBS
+ VSUBS VSUBS VSUBS VSUBS VSUBS VSUBS VSUBS VSUBS VSUBS VSUBS VSUBS VSUBS VSUBS VSUBS
+ VSUBS VSUBS VSUBS VSUBS VSUBS VSUBS VSUBS VSUBS VSUBS VSUBS VSUBS VSUBS VSUBS VSUBS
+ VSUBS VSUBS VSUBS VSUBS VSUBS VSUBS VSUBS VSUBS VSUBS VSUBS VSUBS VSUBS VSUBS VSUBS
+ VSUBS VSUBS VSUBS VSUBS VSUBS VSUBS VSUBS VSUBS VSUBS VSUBS VSUBS VSUBS VSUBS VSUBS
+ VSUBS VSUBS VSUBS VSUBS VSUBS VSUBS VSUBS VSUBS VSUBS VSUBS VSUBS VSUBS VSUBS VSUBS
+ VSUBS VSUBS VSUBS VSUBS VSUBS VSUBS VSUBS VSUBS VSUBS VSUBS VSUBS VSUBS VSUBS VSUBS
+ VSUBS VSUBS VSUBS VSUBS VSUBS VSUBS VSUBS VSUBS VSUBS VSUBS VSUBS VSUBS VSUBS VSUBS
+ VSUBS VSUBS VSUBS VSUBS VSUBS VSUBS VSUBS VSUBS VSUBS VSUBS VSUBS VSUBS VSUBS VSUBS
+ VSUBS VSUBS VSUBS VSUBS VSUBS VSUBS VSUBS VSUBS VSUBS VSUBS VSUBS VSUBS VSUBS VSUBS
+ VSUBS VSUBS VSUBS VSUBS VSUBS VSUBS VSUBS VSUBS VSUBS VSUBS VSUBS VSUBS VSUBS VSUBS
+ VSUBS VSUBS VSUBS VSUBS VSUBS VSUBS VSUBS VSUBS VSUBS VSUBS VSUBS VSUBS VSUBS VSUBS
+ VSUBS VSUBS VSUBS VSUBS VSUBS VSUBS VSUBS VSUBS VSUBS VSUBS VSUBS VSUBS VSUBS VSUBS
+ VSUBS VSUBS VSUBS VSUBS VSUBS VSUBS VSUBS VSUBS VSUBS VSUBS VSUBS VSUBS VSUBS VSUBS
+ VSUBS VSUBS VSUBS VSUBS VSUBS VSUBS VSUBS VSUBS VSUBS VSUBS VSUBS VSUBS VSUBS VSUBS
+ VSUBS VSUBS VSUBS VSUBS VSUBS VSUBS VSUBS VSUBS VSUBS VSUBS VSUBS VSUBS VSUBS VSUBS
+ VSUBS VSUBS VSUBS VSUBS VSUBS VSUBS VSUBS VSUBS VSUBS VSUBS VSUBS VSUBS VSUBS VSUBS
+ VSUBS VSUBS VSUBS VSUBS VSUBS VSUBS VSUBS VSUBS VSUBS VSUBS VSUBS VSUBS VSUBS VSUBS
+ VSUBS VSUBS VSUBS VSUBS VSUBS VSUBS VSUBS VSUBS VSUBS VSUBS VSUBS VSUBS VSUBS VSUBS
+ VSUBS VSUBS VSUBS VSUBS VSUBS VSUBS VSUBS VSUBS VSUBS VSUBS VSUBS VSUBS VSUBS VSUBS
+ VSUBS VSUBS VSUBS VSUBS VSUBS VSUBS VSUBS VSUBS VSUBS VSUBS VSUBS VSUBS VSUBS VSUBS
+ VSUBS VSUBS VSUBS VSUBS VSUBS VSUBS VSUBS VSUBS VSUBS VSUBS VSUBS VSUBS VSUBS VSUBS
+ VSUBS VSUBS VSUBS VSUBS VSUBS VSUBS VSUBS VSUBS VSUBS VSUBS VSUBS VSUBS VSUBS VSUBS
+ VSUBS VSUBS VSUBS VSUBS VSUBS VSUBS VSUBS VSUBS VSUBS VSUBS VSUBS VSUBS VSUBS VSUBS
+ VSUBS VSUBS VSUBS VSUBS VSUBS VSUBS VSUBS VSUBS VSUBS VSUBS VSUBS VSUBS VSUBS VSUBS
+ VSUBS VSUBS VSUBS VSUBS VSUBS VSUBS VSUBS VSUBS VSUBS VSUBS VSUBS VSUBS VSUBS VSUBS
+ VSUBS VSUBS VSUBS VSUBS VSUBS VSUBS VSUBS VSUBS VSUBS VSUBS VSUBS VSUBS VSUBS VSUBS
+ VSUBS VSUBS VSUBS VSUBS VSUBS VSUBS VSUBS VSUBS VSUBS VSUBS VSUBS VSUBS VSUBS VSUBS
+ VSUBS VSUBS VSUBS VSUBS VSUBS VSUBS VSUBS VSUBS VSUBS VSUBS VSUBS VSUBS VSUBS VSUBS
+ VSUBS VSUBS VSUBS VSUBS VSUBS VSUBS VSUBS VSUBS VSUBS VSUBS VSUBS VSUBS VSUBS VSUBS
+ VSUBS VSUBS VSUBS VSUBS VSUBS VSUBS VSUBS VSUBS VSUBS VSUBS VSUBS VSUBS VSUBS VSUBS
+ VSUBS VSUBS VSUBS VSUBS VSUBS VSUBS VSUBS VSUBS VSUBS VSUBS VSUBS VSUBS VSUBS VSUBS
+ VSUBS VSUBS VSUBS VSUBS VSUBS VSUBS VSUBS VSUBS VSUBS VSUBS VSUBS VSUBS VSUBS VSUBS
+ VSUBS VSUBS VSUBS VSUBS VSUBS VSUBS VSUBS VSUBS VSUBS VSUBS VSUBS VSUBS VSUBS VSUBS
+ VSUBS VSUBS VSUBS VSUBS VSUBS VSUBS VSUBS VSUBS VSUBS VSUBS VSUBS VSUBS VSUBS VSUBS
+ VSUBS VSUBS VSUBS VSUBS VSUBS VSUBS VSUBS VSUBS VSUBS VSUBS VSUBS VSUBS VSUBS VSUBS
+ VSUBS VSUBS VSUBS VSUBS VSUBS VSUBS VSUBS VSUBS VSUBS VSUBS VSUBS VSUBS VSUBS VSUBS
+ VSUBS VSUBS VSUBS VSUBS VSUBS VSUBS VSUBS VSUBS VSUBS VSUBS VSUBS VSUBS VSUBS VSUBS
+ VSUBS VSUBS VSUBS VSUBS VSUBS VSUBS VSUBS VSUBS VSUBS VSUBS VSUBS VSUBS VSUBS VSUBS
+ VSUBS VSUBS VSUBS VSUBS VSUBS VSUBS VSUBS VSUBS VSUBS VSUBS VSUBS VSUBS VSUBS VSUBS
+ VSUBS VSUBS VSUBS VSUBS VSUBS VSUBS VSUBS VSUBS VSUBS VSUBS VSUBS VSUBS VSUBS VSUBS
+ VSUBS VSUBS VSUBS VSUBS VSUBS VSUBS VSUBS VSUBS VSUBS VSUBS VSUBS VSUBS VSUBS VSUBS
+ VSUBS VSUBS VSUBS VSUBS VSUBS VSUBS VSUBS VSUBS VSUBS VSUBS VSUBS VSUBS VSUBS VSUBS
+ VSUBS VSUBS VSUBS VSUBS VSUBS VSUBS VSUBS VSUBS VSUBS VSUBS VSUBS VSUBS VSUBS VSUBS
+ VSUBS VSUBS VSUBS VSUBS VSUBS VSUBS VSUBS VSUBS VSUBS VSUBS VSUBS VSUBS VSUBS VSUBS
+ VSUBS VSUBS VSUBS VSUBS VSUBS VSUBS VSUBS VSUBS VSUBS VSUBS VSUBS VSUBS VSUBS VSUBS
+ VSUBS VSUBS VSUBS VSUBS VSUBS VSUBS VSUBS VSUBS VSUBS VSUBS VSUBS VSUBS VSUBS VSUBS
+ VSUBS VSUBS VSUBS VSUBS VSUBS VSUBS VSUBS VSUBS VSUBS VSUBS VSUBS VSUBS VSUBS VSUBS
+ VSUBS VSUBS VSUBS VSUBS VSUBS VSUBS VSUBS VSUBS VSUBS VSUBS VSUBS VSUBS VSUBS VSUBS
+ VSUBS VSUBS VSUBS VSUBS VSUBS VSUBS VSUBS VSUBS VSUBS VSUBS VSUBS VSUBS VSUBS VSUBS
+ VSUBS VSUBS VSUBS VSUBS VSUBS VSUBS VSUBS VSUBS VSUBS VSUBS VSUBS VSUBS VSUBS VSUBS
+ VSUBS VSUBS VSUBS VSUBS VSUBS VSUBS VSUBS VSUBS VSUBS VSUBS VSUBS VSUBS VSUBS VSUBS
+ VSUBS VSUBS VSUBS VSUBS VSUBS VSUBS VSUBS VSUBS VSUBS VSUBS VSUBS VSUBS VSUBS VSUBS
+ VSUBS VSUBS VSUBS VSUBS VSUBS VSUBS VSUBS VSUBS VSUBS VSUBS VSUBS VSUBS VSUBS VSUBS
+ VSUBS VSUBS VSUBS VSUBS VSUBS VSUBS VSUBS VSUBS VSUBS VSUBS VSUBS VSUBS VSUBS gf180mcu_3v3_12t_2r2w_sram_1024x8_array_control_core
Xdetronyx_12t_precharge_sense_rc1_14 detronyx_12t_precharge_sense_rc1_14/VDD VSUBS
+ VSUBS VSUBS VSUBS VSUBS detronyx_12t_precharge_sense_rc1_14/a_672_2172# detronyx_12t_precharge_sense_rc1_14/a_240_2172#
+ detronyx_12t_precharge_sense_rc1
Xdetronyx_12t_precharge_sense_rc1_15 VSUBS VSUBS VSUBS VSUBS VSUBS VSUBS VSUBS VSUBS
+ detronyx_12t_precharge_sense_rc1
Xdetronyx_12t_write_driver_rc1_0 detronyx_12t_write_driver_rc1_0/VDD VSUBS detronyx_12t_write_driver_rc1_0/din
+ VSUBS detronyx_12t_write_driver_rc1_0/wbl0 detronyx_12t_write_driver_rc1_0/wbr0
+ detronyx_12t_write_driver_rc1_0/a_240_2348# detronyx_12t_write_driver_rc1
Xdetronyx_12t_write_driver_rc1_1 detronyx_12t_write_driver_rc1_1/VDD VSUBS detronyx_12t_write_driver_rc1_1/din
+ VSUBS detronyx_12t_write_driver_rc1_1/wbl0 VSUBS detronyx_12t_write_driver_rc1_1/a_240_2348#
+ detronyx_12t_write_driver_rc1
Xdetronyx_12t_write_driver_rc1_2 detronyx_12t_write_driver_rc1_2/VDD VSUBS detronyx_12t_write_driver_rc1_2/din
+ VSUBS detronyx_12t_write_driver_rc1_2/wbl0 VSUBS detronyx_12t_write_driver_rc1_2/a_240_2348#
+ detronyx_12t_write_driver_rc1
Xdetronyx_12t_write_driver_rc1_4 detronyx_12t_write_driver_rc1_4/VDD VSUBS detronyx_12t_write_driver_rc1_4/din
+ VSUBS detronyx_12t_write_driver_rc1_4/wbl0 VSUBS detronyx_12t_write_driver_rc1_4/a_240_2348#
+ detronyx_12t_write_driver_rc1
Xdetronyx_12t_write_driver_rc1_3 detronyx_12t_write_driver_rc1_3/VDD VSUBS detronyx_12t_write_driver_rc1_3/din
+ VSUBS detronyx_12t_write_driver_rc1_3/wbl0 VSUBS detronyx_12t_write_driver_rc1_3/a_240_2348#
+ detronyx_12t_write_driver_rc1
Xdetronyx_12t_precharge_sense_rc1_0 detronyx_12t_precharge_sense_rc1_0/VDD VSUBS VSUBS
+ VSUBS VSUBS VSUBS detronyx_12t_precharge_sense_rc1_0/a_672_2172# detronyx_12t_precharge_sense_rc1_0/a_240_2172#
+ detronyx_12t_precharge_sense_rc1
Xdetronyx_12t_write_driver_rc1_5 detronyx_12t_write_driver_rc1_5/VDD VSUBS detronyx_12t_write_driver_rc1_5/din
+ VSUBS detronyx_12t_write_driver_rc1_5/wbl0 VSUBS detronyx_12t_write_driver_rc1_5/a_240_2348#
+ detronyx_12t_write_driver_rc1
Xdetronyx_12t_precharge_sense_rc1_1 detronyx_12t_precharge_sense_rc1_1/VDD VSUBS VSUBS
+ VSUBS VSUBS VSUBS detronyx_12t_precharge_sense_rc1_1/a_672_2172# detronyx_12t_precharge_sense_rc1_1/a_240_2172#
+ detronyx_12t_precharge_sense_rc1
Xdetronyx_12t_write_driver_rc1_6 detronyx_12t_write_driver_rc1_6/VDD VSUBS detronyx_12t_write_driver_rc1_6/din
+ VSUBS detronyx_12t_write_driver_rc1_6/wbl0 VSUBS detronyx_12t_write_driver_rc1_6/a_240_2348#
+ detronyx_12t_write_driver_rc1
Xdetronyx_12t_precharge_sense_rc1_2 detronyx_12t_precharge_sense_rc1_2/VDD VSUBS VSUBS
+ VSUBS VSUBS VSUBS detronyx_12t_precharge_sense_rc1_2/a_672_2172# detronyx_12t_precharge_sense_rc1_2/a_240_2172#
+ detronyx_12t_precharge_sense_rc1
Xdetronyx_12t_write_driver_rc1_7 detronyx_12t_write_driver_rc1_7/VDD VSUBS detronyx_12t_write_driver_rc1_7/din
+ VSUBS detronyx_12t_write_driver_rc1_7/wbl0 VSUBS detronyx_12t_write_driver_rc1_7/a_240_2348#
+ detronyx_12t_write_driver_rc1
Xdetronyx_12t_precharge_sense_rc1_3 detronyx_12t_precharge_sense_rc1_3/VDD VSUBS VSUBS
+ VSUBS VSUBS VSUBS detronyx_12t_precharge_sense_rc1_3/a_672_2172# detronyx_12t_precharge_sense_rc1_3/a_240_2172#
+ detronyx_12t_precharge_sense_rc1
Xdetronyx_12t_write_driver_rc1_8 detronyx_12t_write_driver_rc1_8/VDD VSUBS detronyx_12t_write_driver_rc1_8/din
+ VSUBS detronyx_12t_write_driver_rc1_8/wbl0 VSUBS detronyx_12t_write_driver_rc1_8/a_240_2348#
+ detronyx_12t_write_driver_rc1
Xdetronyx_12t_precharge_sense_rc1_4 detronyx_12t_precharge_sense_rc1_4/VDD VSUBS VSUBS
+ VSUBS VSUBS VSUBS detronyx_12t_precharge_sense_rc1_4/a_672_2172# detronyx_12t_precharge_sense_rc1_4/a_240_2172#
+ detronyx_12t_precharge_sense_rc1
Xdetronyx_12t_write_driver_rc1_9 detronyx_12t_write_driver_rc1_9/VDD VSUBS detronyx_12t_write_driver_rc1_9/din
+ VSUBS detronyx_12t_write_driver_rc1_9/wbl0 VSUBS detronyx_12t_write_driver_rc1_9/a_240_2348#
+ detronyx_12t_write_driver_rc1
Xdetronyx_12t_precharge_sense_rc1_6 detronyx_12t_precharge_sense_rc1_6/VDD VSUBS VSUBS
+ VSUBS VSUBS VSUBS detronyx_12t_precharge_sense_rc1_6/a_672_2172# detronyx_12t_precharge_sense_rc1_6/a_240_2172#
+ detronyx_12t_precharge_sense_rc1
Xdetronyx_12t_precharge_sense_rc1_5 detronyx_12t_precharge_sense_rc1_5/VDD VSUBS VSUBS
+ VSUBS VSUBS VSUBS detronyx_12t_precharge_sense_rc1_5/a_672_2172# detronyx_12t_precharge_sense_rc1_5/a_240_2172#
+ detronyx_12t_precharge_sense_rc1
Xdetronyx_12t_precharge_sense_rc1_7 detronyx_12t_precharge_sense_rc1_7/VDD VSUBS VSUBS
+ VSUBS VSUBS VSUBS detronyx_12t_precharge_sense_rc1_7/a_672_2172# detronyx_12t_precharge_sense_rc1_7/a_240_2172#
+ detronyx_12t_precharge_sense_rc1
Xdetronyx_12t_precharge_sense_rc1_8 detronyx_12t_precharge_sense_rc1_8/VDD VSUBS VSUBS
+ VSUBS VSUBS VSUBS detronyx_12t_precharge_sense_rc1_8/a_672_2172# detronyx_12t_precharge_sense_rc1_8/a_240_2172#
+ detronyx_12t_precharge_sense_rc1
Xdetronyx_12t_precharge_sense_rc1_9 detronyx_12t_precharge_sense_rc1_9/VDD VSUBS VSUBS
+ VSUBS VSUBS VSUBS detronyx_12t_precharge_sense_rc1_9/a_672_2172# detronyx_12t_precharge_sense_rc1_9/a_240_2172#
+ detronyx_12t_precharge_sense_rc1
Xdetronyx_12t_write_driver_rc1_10 detronyx_12t_write_driver_rc1_10/VDD VSUBS detronyx_12t_write_driver_rc1_10/din
+ VSUBS detronyx_12t_write_driver_rc1_10/wbl0 VSUBS detronyx_12t_write_driver_rc1_10/a_240_2348#
+ detronyx_12t_write_driver_rc1
.ends
