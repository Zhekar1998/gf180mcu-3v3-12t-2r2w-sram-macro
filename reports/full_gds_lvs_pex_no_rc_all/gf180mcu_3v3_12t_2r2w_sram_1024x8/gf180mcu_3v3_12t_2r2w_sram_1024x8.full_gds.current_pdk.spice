* NGSPICE file created from gf180mcu_3v3_12t_2r2w_sram_1024x8.ext - technology: gf180mcuD

.subckt detronyx_12t_write_driver_rc1 VDD VSS din wen wbl0 wbr0 a_240_2348#
X0 VDD a_240_2348# a_326_9670# VDD pfet_03v3 ad=0.1232p pd=1u as=0.1232p ps=1u w=0.56u l=0.28u
X1 VSS wen a_988_2348# VSS nfet_03v3 ad=0.4642p pd=2.99u as=0.4642p ps=2.99u w=1.055u l=0.28u
X2 VDD wen a_326_9670# VDD pfet_03v3 ad=0.1232p pd=1u as=0.1232p ps=1u w=0.56u l=0.28u
X3 VSS a_844_5266# a_328_6681# VSS nfet_03v3 ad=0.4642p pd=2.99u as=0.4642p ps=2.99u w=1.055u l=0.28u
X4 VSS wen a_240_3807# VSS nfet_03v3 ad=0.4642p pd=2.99u as=0.4642p ps=2.99u w=1.055u l=0.28u
X5 VDD wen a_326_11114# VDD pfet_03v3 ad=0.1232p pd=1u as=0.1232p ps=1u w=0.56u l=0.28u
X6 VDD wen a_844_2348# VDD pfet_03v3 ad=0.1232p pd=1u as=0.1232p ps=1u w=0.56u l=0.28u
X7 a_240_3807# a_240_2348# a_326_9670# VSS nfet_03v3 ad=0.4642p pd=2.99u as=0.4642p ps=2.99u w=1.055u l=0.28u
X8 VDD din a_844_5266# VDD pfet_03v3 ad=0.1232p pd=1u as=0.1232p ps=1u w=0.56u l=0.28u
X9 VDD wen a_844_5266# VDD pfet_03v3 ad=0.1232p pd=1u as=0.1232p ps=1u w=0.56u l=0.28u
X10 VDD a_240_2348# a_326_11114# VDD pfet_03v3 ad=0.1232p pd=1u as=0.1232p ps=1u w=0.56u l=0.28u
X11 VDD a_844_2348# wbl0 VDD pfet_03v3 ad=0.1232p pd=1u as=0.1232p ps=1u w=0.56u l=0.28u
X12 VDD a_844_5266# a_328_6681# VDD pfet_03v3 ad=0.1232p pd=1u as=0.1232p ps=1u w=0.56u l=0.28u
X13 VSS a_844_3807# wbl0 VSS nfet_03v3 ad=0.4642p pd=2.99u as=0.4642p ps=2.99u w=1.055u l=0.28u
X14 VDD din a_844_2348# VDD pfet_03v3 ad=0.1232p pd=1u as=0.1232p ps=1u w=0.56u l=0.28u
X15 a_988_5266# din a_844_5266# VSS nfet_03v3 ad=0.4642p pd=2.99u as=0.4642p ps=2.99u w=1.055u l=0.28u
X16 a_240_5266# a_240_2348# a_326_11114# VSS nfet_03v3 ad=0.4642p pd=2.99u as=0.4642p ps=2.99u w=1.055u l=0.28u
X17 VDD a_326_9670# a_844_3807# VDD pfet_03v3 ad=0.1232p pd=1u as=0.1232p ps=1u w=0.56u l=0.28u
X18 a_988_2348# din a_844_2348# VSS nfet_03v3 ad=0.4642p pd=2.99u as=0.4642p ps=2.99u w=1.055u l=0.28u
X19 VSS wen a_240_5266# VSS nfet_03v3 ad=0.4642p pd=2.99u as=0.4642p ps=2.99u w=1.055u l=0.28u
X20 VSS din a_240_2348# VSS nfet_03v3 ad=0.4642p pd=2.99u as=0.4642p ps=2.99u w=1.055u l=0.28u
X21 VSS a_326_9670# a_844_3807# VSS nfet_03v3 ad=0.4642p pd=2.99u as=0.4642p ps=2.99u w=1.055u l=0.28u
X22 VDD din a_240_2348# VDD pfet_03v3 ad=0.1232p pd=1u as=0.1232p ps=1u w=0.56u l=0.28u
X23 VSS wen a_988_5266# VSS nfet_03v3 ad=0.4642p pd=2.99u as=0.4642p ps=2.99u w=1.055u l=0.28u
X24 VDD a_326_11114# wbr0 VDD pfet_03v3 ad=0.1232p pd=1u as=0.1232p ps=1u w=0.56u l=0.28u
X25 VSS a_328_6681# wbr0 VSS nfet_03v3 ad=0.4642p pd=2.99u as=0.4642p ps=2.99u w=1.055u l=0.28u
.ends

.subckt detronyx_12t_precharge_sense_rc1 VDD VSS pchgb ren rbl0 dout a_672_2172# a_240_2172#
X0 VDD rbl0 a_240_2172# VDD pfet_03v3 ad=0.1232p pd=1u as=0.1232p ps=1u w=0.56u l=0.28u
X1 VSS a_240_2172# a_672_2172# VSS nfet_03v3 ad=0.4642p pd=2.99u as=0.4642p ps=2.99u w=1.055u l=0.28u
X2 VSS rbl0 a_240_2172# VSS nfet_03v3 ad=0.4642p pd=2.99u as=0.4642p ps=2.99u w=1.055u l=0.28u
X3 VDD pchgb rbl0 VDD pfet_03v3 ad=0.1232p pd=1u as=0.1232p ps=1u w=0.56u l=0.28u
X4 VDD a_672_2172# dout VDD pfet_03v3 ad=0.1232p pd=1u as=0.1232p ps=1u w=0.56u l=0.28u
X5 VSS a_672_2172# dout VSS nfet_03v3 ad=0.4642p pd=2.99u as=0.4642p ps=2.99u w=1.055u l=0.28u
X6 VDD a_240_2172# a_672_2172# VDD pfet_03v3 ad=0.1232p pd=1u as=0.1232p ps=1u w=0.56u l=0.28u
.ends

.subckt gf180mcu_as_sc_mcu7t3v3__inv_2 VDD VSS Y A VNW VPW
X0 VDD A Y VNW pfet_03v3 ad=0.6072p pd=3.64u as=0.3588p ps=1.9u w=1.38u l=0.28u
X1 Y A VSS VPW nfet_03v3 ad=0.26p pd=1.52u as=0.44p ps=2.88u w=1u l=0.28u
X2 Y A VDD VNW pfet_03v3 ad=0.3588p pd=1.9u as=0.6072p ps=3.64u w=1.38u l=0.28u
X3 VSS A Y VPW nfet_03v3 ad=0.44p pd=2.88u as=0.26p ps=1.52u w=1u l=0.28u
.ends

.subckt gf180mcu_as_sc_mcu7t3v3__nand4_2 VDD VSS A B C D Y VNW VPW
X0 VDD A Y VNW pfet_03v3 ad=0.3588p pd=1.9u as=0.3588p ps=1.9u w=1.38u l=0.28u
X1 Y D a_796_68# VPW nfet_03v3 ad=0.26p pd=1.52u as=0.26p ps=1.52u w=1u l=0.28u
X2 VSS A a_28_68# VPW nfet_03v3 ad=0.26p pd=1.52u as=0.44p ps=2.88u w=1u l=0.28u
X3 VDD C Y VNW pfet_03v3 ad=0.3588p pd=1.9u as=0.3588p ps=1.9u w=1.38u l=0.28u
X4 a_796_68# C a_492_68# VPW nfet_03v3 ad=0.26p pd=1.52u as=0.26p ps=1.52u w=1u l=0.28u
X5 Y B VDD VNW pfet_03v3 ad=0.3588p pd=1.9u as=0.3588p ps=1.9u w=1.38u l=0.28u
X6 a_28_68# B a_492_68# VPW nfet_03v3 ad=0.44p pd=2.88u as=0.26p ps=1.52u w=1u l=0.28u
X7 Y D VDD VNW pfet_03v3 ad=0.3588p pd=1.9u as=0.3588p ps=1.9u w=1.38u l=0.28u
X8 VDD B Y VNW pfet_03v3 ad=0.8004p pd=2.54u as=0.3588p ps=1.9u w=1.38u l=0.28u
X9 Y C VDD VNW pfet_03v3 ad=0.3588p pd=1.9u as=0.8004p ps=2.54u w=1.38u l=0.28u
X10 a_492_68# C a_796_68# VPW nfet_03v3 ad=0.26p pd=1.52u as=0.44p ps=2.88u w=1u l=0.28u
X11 a_492_68# B a_28_68# VPW nfet_03v3 ad=0.26p pd=1.52u as=0.26p ps=1.52u w=1u l=0.28u
X12 VDD D Y VNW pfet_03v3 ad=0.6348p pd=3.68u as=0.3588p ps=1.9u w=1.38u l=0.28u
X13 Y A VDD VNW pfet_03v3 ad=0.3588p pd=1.9u as=0.6072p ps=3.64u w=1.38u l=0.28u
X14 a_796_68# D Y VPW nfet_03v3 ad=0.46p pd=2.92u as=0.26p ps=1.52u w=1u l=0.28u
X15 a_28_68# A VSS VPW nfet_03v3 ad=0.26p pd=1.52u as=0.26p ps=1.52u w=1u l=0.28u
.ends

.subckt detronyx_12t_2w2r_rc4_4x4_routed_5layer_direct c0_w0_bl c0_w0_br c0_w1_bl
+ c0_w1_br c0_r0_rbl c0_r1_rbl c1_w0_bl c1_w0_br c1_w1_bl c1_w1_br c1_r0_rbl c1_r1_rbl
+ c2_w0_bl c2_w0_br c2_w1_bl c2_w1_br c2_r0_rbl c2_r1_rbl c3_w0_bl c3_w0_br c3_w1_bl
+ c3_w1_br c3_r0_rbl c3_r1_rbl r0_w0_wl r0_w1_wl r0_r0_rwl r0_r1_rwl r1_w0_wl r1_w1_wl
+ r1_r0_rwl r1_r1_rwl r2_w0_wl r2_w1_wl r2_r0_rwl r2_r1_rwl r3_w0_wl r3_w1_wl r3_r0_rwl
+ r3_r1_rwl VDD VSS m2_717_1265# m2_603_2031# m2_1290_336# m2_2000_2037# m2_791_2909#
+ m2_7_2126# m2_2154_2081# m2_1795_2037# m2_871_303# m2_431_438# m2_1290_2898# m2_1714_1210#
+ m2_431_1982# m2_512_1265# m2_2573_2126# m2_603_1259# m2_2074_2909# m2_7_336# m2_717_2037#
+ m2_1886_2031# m2_2573_336# m2_7_2898# m2_2000_1265# m2_512_2037# m2_1795_1265# m2_1714_1982#
+ m2_1886_1259# m2_1290_2126# m2_1714_438# m2_431_1210# m2_2573_2898# m2_2154_303#
+ m2_871_2081# VSUBS
X0 a_684_1814# a_484_1742# a_680_1660# VSUBS nfet_03v3 ad=0.1288p pd=1.48u as=0.1208p ps=1.42u w=0.28u l=0.36u
X1 a_1365_936# a_1283_888# a_1421_1243# w_1283_1162# pfet_03v3 ad=0.1238p pd=1.44u as=0.3061p ps=2.445u w=0.28u l=0.28u
X2 a_2215_1938# a_2159_1894# a_2071_1938# VSUBS nfet_03v3 ad=0.1378p pd=1.05u as=0.2332p ps=1.94u w=0.53u l=0.28u
X3 a_82_1708# a_484_2028# a_532_1946# VSUBS nfet_03v3 ad=0.1288p pd=1.48u as=0.1208p ps=1.42u w=0.28u l=0.36u
X4 a_2648_1708# a_2566_1660# a_2704_1752# VSUBS nfet_03v3 ad=0.3133p pd=2.64u as=0.342p ps=2.21u w=0.45u l=0.28u
X5 a_3658_932# a_3602_888# a_3498_932# VSUBS nfet_03v3 ad=0.23585p pd=1.95u as=0.1378p ps=1.05u w=0.53u l=0.28u
X6 a_932_1938# a_876_1894# a_788_1938# VSUBS nfet_03v3 ad=0.1378p pd=1.05u as=0.2332p ps=1.94u w=0.53u l=0.28u
X7 a_3250_2100# a_3050_2028# a_3246_1946# VSUBS nfet_03v3 ad=0.1288p pd=1.48u as=0.1208p ps=1.42u w=0.28u l=0.36u
X8 a_2375_160# a_2319_116# a_2215_160# VSUBS nfet_03v3 ad=0.23585p pd=1.95u as=0.1378p ps=1.05u w=0.53u l=0.28u
X9 a_1365_936# a_1283_888# a_1421_980# VSUBS nfet_03v3 ad=0.3133p pd=2.64u as=0.342p ps=2.21u w=0.45u l=0.28u
X10 a_4533_2100# a_4333_2028# a_4529_1946# VSUBS nfet_03v3 ad=0.1288p pd=1.48u as=0.1208p ps=1.42u w=0.28u l=0.36u
X11 a_82_164# a_0_116# a_138_471# w_0_390# pfet_03v3 ad=0.1238p pd=1.44u as=0.3061p ps=2.445u w=0.28u l=0.28u
X12 a_82_936# a_484_970# a_532_888# VSUBS nfet_03v3 ad=0.1288p pd=1.48u as=0.1208p ps=1.42u w=0.28u l=0.36u
X13 a_3931_1708# a_3849_1660# a_3987_2015# w_3849_1934# pfet_03v3 ad=0.1238p pd=1.44u as=0.3061p ps=2.445u w=0.28u l=0.28u
X14 a_1967_1042# a_1767_970# a_1963_888# VSUBS nfet_03v3 ad=0.1288p pd=1.48u as=0.1208p ps=1.42u w=0.28u l=0.36u
X15 a_1421_2787# a_1365_2480# a_1283_2432# w_1283_2706# pfet_03v3 ad=0.3061p pd=2.445u as=0.1238p ps=1.44u w=0.28u l=0.28u
X16 a_1365_2480# a_1767_2514# a_1815_2432# VSUBS nfet_03v3 ad=0.1288p pd=1.48u as=0.1208p ps=1.42u w=0.28u l=0.36u
X17 a_2704_2787# a_2648_2480# a_2566_2432# w_2566_2706# pfet_03v3 ad=0.3061p pd=2.445u as=0.1238p ps=1.44u w=0.28u l=0.28u
X18 a_138_2787# a_82_2480# a_0_2432# w_0_2706# pfet_03v3 ad=0.3061p pd=2.445u as=0.1238p ps=1.44u w=0.28u l=0.28u
X19 a_2648_936# a_3050_1256# a_3098_1174# VSUBS nfet_03v3 ad=0.1288p pd=1.48u as=0.1208p ps=1.42u w=0.28u l=0.36u
X20 a_1365_2480# a_1767_2800# a_1815_2718# VSUBS nfet_03v3 ad=0.1288p pd=1.48u as=0.1208p ps=1.42u w=0.28u l=0.36u
X21 a_2704_980# a_2648_936# a_2566_888# VSUBS nfet_03v3 ad=0.342p pd=2.21u as=0.3133p ps=2.64u w=0.45u l=0.28u
X22 a_82_1708# a_0_1660# a_138_1752# VSUBS nfet_03v3 ad=0.3133p pd=2.64u as=0.342p ps=2.21u w=0.45u l=0.28u
X23 a_3931_164# a_4333_198# a_4381_116# VSUBS nfet_03v3 ad=0.1288p pd=1.48u as=0.1208p ps=1.42u w=0.28u l=0.36u
X24 a_1092_160# a_1036_116# a_932_160# VSUBS nfet_03v3 ad=0.23585p pd=1.95u as=0.1378p ps=1.05u w=0.53u l=0.28u
X25 a_82_164# a_0_116# a_138_208# VSUBS nfet_03v3 ad=0.3133p pd=2.64u as=0.342p ps=2.21u w=0.45u l=0.28u
X26 a_4941_932# a_4885_1122# a_4781_1166# VSUBS nfet_03v3 ad=0.23585p pd=1.95u as=0.1378p ps=1.05u w=0.53u l=0.28u
X27 a_3931_164# a_4333_484# a_4381_402# VSUBS nfet_03v3 ad=0.1288p pd=1.48u as=0.1208p ps=1.42u w=0.28u l=0.36u
X28 a_2648_164# a_2566_116# a_2704_471# w_2566_390# pfet_03v3 ad=0.1238p pd=1.44u as=0.3061p ps=2.445u w=0.28u l=0.28u
X29 a_3498_1166# a_3442_1122# a_3354_1166# VSUBS nfet_03v3 ad=0.1378p pd=1.05u as=0.2332p ps=1.94u w=0.53u l=0.28u
X30 a_4533_270# a_4333_198# a_4529_116# VSUBS nfet_03v3 ad=0.1288p pd=1.48u as=0.1208p ps=1.42u w=0.28u l=0.36u
X31 a_2375_932# a_2319_888# a_2215_932# VSUBS nfet_03v3 ad=0.23585p pd=1.95u as=0.1378p ps=1.05u w=0.53u l=0.28u
X32 a_4781_1166# a_4725_1122# a_4637_1166# VSUBS nfet_03v3 ad=0.1378p pd=1.05u as=0.2332p ps=1.94u w=0.53u l=0.28u
X33 a_3658_1704# a_3602_1660# a_3498_1704# VSUBS nfet_03v3 ad=0.23585p pd=1.95u as=0.1378p ps=1.05u w=0.53u l=0.28u
X34 a_684_2586# a_484_2514# a_680_2432# VSUBS nfet_03v3 ad=0.1288p pd=1.48u as=0.1208p ps=1.42u w=0.28u l=0.36u
X35 a_1365_1708# a_1283_1660# a_1421_2015# w_1283_1934# pfet_03v3 ad=0.1238p pd=1.44u as=0.3061p ps=2.445u w=0.28u l=0.28u
X36 a_4533_556# a_4333_484# a_4529_402# VSUBS nfet_03v3 ad=0.1288p pd=1.48u as=0.1208p ps=1.42u w=0.28u l=0.36u
X37 a_1092_2476# a_1036_2666# a_932_2710# VSUBS nfet_03v3 ad=0.23585p pd=1.95u as=0.1378p ps=1.05u w=0.53u l=0.28u
X38 a_2215_1704# a_2159_1660# a_2071_1704# VSUBS nfet_03v3 ad=0.1378p pd=1.05u as=0.2332p ps=1.94u w=0.53u l=0.28u
X39 a_3987_471# a_3931_164# a_3849_116# w_3849_390# pfet_03v3 ad=0.3061p pd=2.445u as=0.1238p ps=1.44u w=0.28u l=0.28u
X40 a_4781_394# a_4725_350# a_4637_394# VSUBS nfet_03v3 ad=0.1378p pd=1.05u as=0.2332p ps=1.94u w=0.53u l=0.28u
X41 a_1421_980# a_1365_936# a_1283_888# VSUBS nfet_03v3 ad=0.342p pd=2.21u as=0.3133p ps=2.64u w=0.45u l=0.28u
X42 a_684_2872# a_484_2800# a_680_2718# VSUBS nfet_03v3 ad=0.1288p pd=1.48u as=0.1208p ps=1.42u w=0.28u l=0.36u
X43 a_2375_2476# a_2319_2666# a_2215_2710# VSUBS nfet_03v3 ad=0.23585p pd=1.95u as=0.1378p ps=1.05u w=0.53u l=0.28u
X44 a_2648_2480# a_2566_2432# a_2704_2524# VSUBS nfet_03v3 ad=0.3133p pd=2.64u as=0.342p ps=2.21u w=0.45u l=0.28u
X45 a_932_1704# a_876_1660# a_788_1704# VSUBS nfet_03v3 ad=0.1378p pd=1.05u as=0.2332p ps=1.94u w=0.53u l=0.28u
X46 a_2648_164# a_2566_116# a_2704_208# VSUBS nfet_03v3 ad=0.3133p pd=2.64u as=0.342p ps=2.21u w=0.45u l=0.28u
X47 a_1967_1328# a_1767_1256# a_1963_1174# VSUBS nfet_03v3 ad=0.1288p pd=1.48u as=0.1208p ps=1.42u w=0.28u l=0.36u
X48 a_82_1708# a_484_1742# a_532_1660# VSUBS nfet_03v3 ad=0.1288p pd=1.48u as=0.1208p ps=1.42u w=0.28u l=0.36u
X49 a_3250_1814# a_3050_1742# a_3246_1660# VSUBS nfet_03v3 ad=0.1288p pd=1.48u as=0.1208p ps=1.42u w=0.28u l=0.36u
X50 a_3250_270# a_3050_198# a_3246_116# VSUBS nfet_03v3 ad=0.1288p pd=1.48u as=0.1208p ps=1.42u w=0.28u l=0.36u
X51 a_2648_164# a_3050_198# a_3098_116# VSUBS nfet_03v3 ad=0.1288p pd=1.48u as=0.1208p ps=1.42u w=0.28u l=0.36u
X52 a_1092_932# a_1036_888# a_932_932# VSUBS nfet_03v3 ad=0.23585p pd=1.95u as=0.1378p ps=1.05u w=0.53u l=0.28u
X53 a_4941_1704# a_4885_1894# a_4781_1938# VSUBS nfet_03v3 ad=0.23585p pd=1.95u as=0.1378p ps=1.05u w=0.53u l=0.28u
X54 a_4533_1814# a_4333_1742# a_4529_1660# VSUBS nfet_03v3 ad=0.1288p pd=1.48u as=0.1208p ps=1.42u w=0.28u l=0.36u
X55 a_2648_1708# a_3050_2028# a_3098_1946# VSUBS nfet_03v3 ad=0.1288p pd=1.48u as=0.1208p ps=1.42u w=0.28u l=0.36u
X56 a_3250_556# a_3050_484# a_3246_402# VSUBS nfet_03v3 ad=0.1288p pd=1.48u as=0.1208p ps=1.42u w=0.28u l=0.36u
X57 a_2648_164# a_3050_484# a_3098_402# VSUBS nfet_03v3 ad=0.1288p pd=1.48u as=0.1208p ps=1.42u w=0.28u l=0.36u
X58 a_2648_936# a_2566_888# a_2704_1243# w_2566_1162# pfet_03v3 ad=0.1238p pd=1.44u as=0.3061p ps=2.445u w=0.28u l=0.28u
X59 a_3498_1938# a_3442_1894# a_3354_1938# VSUBS nfet_03v3 ad=0.1378p pd=1.05u as=0.2332p ps=1.94u w=0.53u l=0.28u
X60 a_1365_164# a_1283_116# a_1421_471# w_1283_390# pfet_03v3 ad=0.1238p pd=1.44u as=0.3061p ps=2.445u w=0.28u l=0.28u
X61 a_82_2480# a_0_2432# a_138_2524# VSUBS nfet_03v3 ad=0.3133p pd=2.64u as=0.342p ps=2.21u w=0.45u l=0.28u
X62 a_4781_1938# a_4725_1894# a_4637_1938# VSUBS nfet_03v3 ad=0.1378p pd=1.05u as=0.2332p ps=1.94u w=0.53u l=0.28u
X63 a_3498_394# a_3442_350# a_3354_394# VSUBS nfet_03v3 ad=0.1378p pd=1.05u as=0.2332p ps=1.94u w=0.53u l=0.28u
X64 a_1365_936# a_1767_970# a_1815_888# VSUBS nfet_03v3 ad=0.1288p pd=1.48u as=0.1208p ps=1.42u w=0.28u l=0.36u
X65 a_3987_208# a_3931_164# a_3849_116# VSUBS nfet_03v3 ad=0.342p pd=2.21u as=0.3133p ps=2.64u w=0.45u l=0.28u
X66 a_3931_936# a_3849_888# a_3987_980# VSUBS nfet_03v3 ad=0.3133p pd=2.64u as=0.342p ps=2.21u w=0.45u l=0.28u
X67 a_1421_1752# a_1365_1708# a_1283_1660# VSUBS nfet_03v3 ad=0.342p pd=2.21u as=0.3133p ps=2.64u w=0.45u l=0.28u
X68 a_1092_2476# a_1036_2432# a_932_2476# VSUBS nfet_03v3 ad=0.23585p pd=1.95u as=0.1378p ps=1.05u w=0.53u l=0.28u
X69 a_138_980# a_82_936# a_0_888# VSUBS nfet_03v3 ad=0.342p pd=2.21u as=0.3133p ps=2.64u w=0.45u l=0.28u
X70 a_2375_2476# a_2319_2432# a_2215_2476# VSUBS nfet_03v3 ad=0.23585p pd=1.95u as=0.1378p ps=1.05u w=0.53u l=0.28u
X71 a_2704_1752# a_2648_1708# a_2566_1660# VSUBS nfet_03v3 ad=0.342p pd=2.21u as=0.3133p ps=2.64u w=0.45u l=0.28u
X72 a_2704_471# a_2648_164# a_2566_116# w_2566_390# pfet_03v3 ad=0.3061p pd=2.445u as=0.1238p ps=1.44u w=0.28u l=0.28u
X73 a_138_1752# a_82_1708# a_0_1660# VSUBS nfet_03v3 ad=0.342p pd=2.21u as=0.3133p ps=2.64u w=0.45u l=0.28u
X74 a_3987_2787# a_3931_2480# a_3849_2432# w_3849_2706# pfet_03v3 ad=0.3061p pd=2.445u as=0.1238p ps=1.44u w=0.28u l=0.28u
X75 a_4941_160# a_4885_350# a_4781_394# VSUBS nfet_03v3 ad=0.23585p pd=1.95u as=0.1378p ps=1.05u w=0.53u l=0.28u
X76 a_3931_936# a_4333_1256# a_4381_1174# VSUBS nfet_03v3 ad=0.1288p pd=1.48u as=0.1208p ps=1.42u w=0.28u l=0.36u
X77 a_82_936# a_0_888# a_138_1243# w_0_1162# pfet_03v3 ad=0.1238p pd=1.44u as=0.3061p ps=2.445u w=0.28u l=0.28u
X78 a_1365_164# a_1283_116# a_1421_208# VSUBS nfet_03v3 ad=0.3133p pd=2.64u as=0.342p ps=2.21u w=0.45u l=0.28u
X79 a_4781_160# a_4725_116# a_4637_160# VSUBS nfet_03v3 ad=0.1378p pd=1.05u as=0.2332p ps=1.94u w=0.53u l=0.28u
X80 a_684_270# a_484_198# a_680_116# VSUBS nfet_03v3 ad=0.1288p pd=1.48u as=0.1208p ps=1.42u w=0.28u l=0.36u
X81 a_1421_471# a_1365_164# a_1283_116# w_1283_390# pfet_03v3 ad=0.3061p pd=2.445u as=0.1238p ps=1.44u w=0.28u l=0.28u
X82 a_684_556# a_484_484# a_680_402# VSUBS nfet_03v3 ad=0.1288p pd=1.48u as=0.1208p ps=1.42u w=0.28u l=0.36u
X83 a_3931_2480# a_3849_2432# a_3987_2787# w_3849_2706# pfet_03v3 ad=0.1238p pd=1.44u as=0.3061p ps=2.445u w=0.28u l=0.28u
X84 a_1967_2100# a_1767_2028# a_1963_1946# VSUBS nfet_03v3 ad=0.1288p pd=1.48u as=0.1208p ps=1.42u w=0.28u l=0.36u
X85 a_2215_394# a_2159_350# a_2071_394# VSUBS nfet_03v3 ad=0.1378p pd=1.05u as=0.2332p ps=1.94u w=0.53u l=0.28u
X86 a_82_2480# a_484_2514# a_532_2432# VSUBS nfet_03v3 ad=0.1288p pd=1.48u as=0.1208p ps=1.42u w=0.28u l=0.36u
X87 a_2704_208# a_2648_164# a_2566_116# VSUBS nfet_03v3 ad=0.342p pd=2.21u as=0.3133p ps=2.64u w=0.45u l=0.28u
X88 a_932_394# a_876_350# a_788_394# VSUBS nfet_03v3 ad=0.1378p pd=1.05u as=0.2332p ps=1.94u w=0.53u l=0.28u
X89 a_3250_2586# a_3050_2514# a_3246_2432# VSUBS nfet_03v3 ad=0.1288p pd=1.48u as=0.1208p ps=1.42u w=0.28u l=0.36u
X90 a_4941_1704# a_4885_1660# a_4781_1704# VSUBS nfet_03v3 ad=0.23585p pd=1.95u as=0.1378p ps=1.05u w=0.53u l=0.28u
X91 a_4533_2586# a_4333_2514# a_4529_2432# VSUBS nfet_03v3 ad=0.1288p pd=1.48u as=0.1208p ps=1.42u w=0.28u l=0.36u
X92 a_82_2480# a_484_2800# a_532_2718# VSUBS nfet_03v3 ad=0.1288p pd=1.48u as=0.1208p ps=1.42u w=0.28u l=0.36u
X93 a_2648_1708# a_2566_1660# a_2704_2015# w_2566_1934# pfet_03v3 ad=0.1238p pd=1.44u as=0.3061p ps=2.445u w=0.28u l=0.28u
X94 a_3250_2872# a_3050_2800# a_3246_2718# VSUBS nfet_03v3 ad=0.1288p pd=1.48u as=0.1208p ps=1.42u w=0.28u l=0.36u
X95 a_3498_1704# a_3442_1660# a_3354_1704# VSUBS nfet_03v3 ad=0.1378p pd=1.05u as=0.2332p ps=1.94u w=0.53u l=0.28u
X96 a_3658_2476# a_3602_2666# a_3498_2710# VSUBS nfet_03v3 ad=0.23585p pd=1.95u as=0.1378p ps=1.05u w=0.53u l=0.28u
X97 a_4533_2872# a_4333_2800# a_4529_2718# VSUBS nfet_03v3 ad=0.1288p pd=1.48u as=0.1208p ps=1.42u w=0.28u l=0.36u
X98 a_4781_1704# a_4725_1660# a_4637_1704# VSUBS nfet_03v3 ad=0.1378p pd=1.05u as=0.2332p ps=1.94u w=0.53u l=0.28u
X99 a_3498_160# a_3442_116# a_3354_160# VSUBS nfet_03v3 ad=0.1378p pd=1.05u as=0.2332p ps=1.94u w=0.53u l=0.28u
X100 a_1421_2524# a_1365_2480# a_1283_2432# VSUBS nfet_03v3 ad=0.342p pd=2.21u as=0.3133p ps=2.64u w=0.45u l=0.28u
X101 a_2215_2710# a_2159_2666# a_2071_2710# VSUBS nfet_03v3 ad=0.1378p pd=1.05u as=0.2332p ps=1.94u w=0.53u l=0.28u
X102 a_2648_1708# a_3050_1742# a_3098_1660# VSUBS nfet_03v3 ad=0.1288p pd=1.48u as=0.1208p ps=1.42u w=0.28u l=0.36u
X103 a_1365_936# a_1767_1256# a_1815_1174# VSUBS nfet_03v3 ad=0.1288p pd=1.48u as=0.1208p ps=1.42u w=0.28u l=0.36u
X104 a_2704_2524# a_2648_2480# a_2566_2432# VSUBS nfet_03v3 ad=0.342p pd=2.21u as=0.3133p ps=2.64u w=0.45u l=0.28u
X105 a_932_2710# a_876_2666# a_788_2710# VSUBS nfet_03v3 ad=0.1378p pd=1.05u as=0.2332p ps=1.94u w=0.53u l=0.28u
X106 a_138_2524# a_82_2480# a_0_2432# VSUBS nfet_03v3 ad=0.342p pd=2.21u as=0.3133p ps=2.64u w=0.45u l=0.28u
X107 a_4781_932# a_4725_888# a_4637_932# VSUBS nfet_03v3 ad=0.1378p pd=1.05u as=0.2332p ps=1.94u w=0.53u l=0.28u
X108 a_1421_208# a_1365_164# a_1283_116# VSUBS nfet_03v3 ad=0.342p pd=2.21u as=0.3133p ps=2.64u w=0.45u l=0.28u
X109 a_1421_1243# a_1365_936# a_1283_888# w_1283_1162# pfet_03v3 ad=0.3061p pd=2.445u as=0.1238p ps=1.44u w=0.28u l=0.28u
X110 a_138_471# a_82_164# a_0_116# w_0_390# pfet_03v3 ad=0.3061p pd=2.445u as=0.1238p ps=1.44u w=0.28u l=0.28u
X111 a_2704_1243# a_2648_936# a_2566_888# w_2566_1162# pfet_03v3 ad=0.3061p pd=2.445u as=0.1238p ps=1.44u w=0.28u l=0.28u
X112 a_82_1708# a_0_1660# a_138_2015# w_0_1934# pfet_03v3 ad=0.1238p pd=1.44u as=0.3061p ps=2.445u w=0.28u l=0.28u
X113 a_3931_1708# a_4333_2028# a_4381_1946# VSUBS nfet_03v3 ad=0.1288p pd=1.48u as=0.1208p ps=1.42u w=0.28u l=0.36u
X114 a_4941_160# a_4885_116# a_4781_160# VSUBS nfet_03v3 ad=0.23585p pd=1.95u as=0.1378p ps=1.05u w=0.53u l=0.28u
X115 a_138_1243# a_82_936# a_0_888# w_0_1162# pfet_03v3 ad=0.3061p pd=2.445u as=0.1238p ps=1.44u w=0.28u l=0.28u
X116 a_3931_164# a_3849_116# a_3987_471# w_3849_390# pfet_03v3 ad=0.1238p pd=1.44u as=0.3061p ps=2.445u w=0.28u l=0.28u
X117 a_3931_936# a_4333_970# a_4381_888# VSUBS nfet_03v3 ad=0.1288p pd=1.48u as=0.1208p ps=1.42u w=0.28u l=0.36u
X118 a_1365_2480# a_1283_2432# a_1421_2787# w_1283_2706# pfet_03v3 ad=0.1238p pd=1.44u as=0.3061p ps=2.445u w=0.28u l=0.28u
X119 a_1092_932# a_1036_1122# a_932_1166# VSUBS nfet_03v3 ad=0.23585p pd=1.95u as=0.1378p ps=1.05u w=0.53u l=0.28u
X120 a_3987_1752# a_3931_1708# a_3849_1660# VSUBS nfet_03v3 ad=0.342p pd=2.21u as=0.3133p ps=2.64u w=0.45u l=0.28u
X121 a_4533_1042# a_4333_970# a_4529_888# VSUBS nfet_03v3 ad=0.1288p pd=1.48u as=0.1208p ps=1.42u w=0.28u l=0.36u
X122 a_3658_2476# a_3602_2432# a_3498_2476# VSUBS nfet_03v3 ad=0.23585p pd=1.95u as=0.1378p ps=1.05u w=0.53u l=0.28u
X123 a_2375_932# a_2319_1122# a_2215_1166# VSUBS nfet_03v3 ad=0.23585p pd=1.95u as=0.1378p ps=1.05u w=0.53u l=0.28u
X124 a_684_1328# a_484_1256# a_680_1174# VSUBS nfet_03v3 ad=0.1288p pd=1.48u as=0.1208p ps=1.42u w=0.28u l=0.36u
X125 a_2215_160# a_2159_116# a_2071_160# VSUBS nfet_03v3 ad=0.1378p pd=1.05u as=0.2332p ps=1.94u w=0.53u l=0.28u
X126 a_3498_932# a_3442_888# a_3354_932# VSUBS nfet_03v3 ad=0.1378p pd=1.05u as=0.2332p ps=1.94u w=0.53u l=0.28u
X127 a_2215_2476# a_2159_2432# a_2071_2476# VSUBS nfet_03v3 ad=0.1378p pd=1.05u as=0.2332p ps=1.94u w=0.53u l=0.28u
X128 a_932_160# a_876_116# a_788_160# VSUBS nfet_03v3 ad=0.1378p pd=1.05u as=0.2332p ps=1.94u w=0.53u l=0.28u
X129 a_82_164# a_484_198# a_532_116# VSUBS nfet_03v3 ad=0.1288p pd=1.48u as=0.1208p ps=1.42u w=0.28u l=0.36u
X130 a_932_2476# a_876_2432# a_788_2476# VSUBS nfet_03v3 ad=0.1378p pd=1.05u as=0.2332p ps=1.94u w=0.53u l=0.28u
X131 a_3931_1708# a_3849_1660# a_3987_1752# VSUBS nfet_03v3 ad=0.3133p pd=2.64u as=0.342p ps=2.21u w=0.45u l=0.28u
X132 a_3931_164# a_3849_116# a_3987_208# VSUBS nfet_03v3 ad=0.3133p pd=2.64u as=0.342p ps=2.21u w=0.45u l=0.28u
X133 a_1967_270# a_1767_198# a_1963_116# VSUBS nfet_03v3 ad=0.1288p pd=1.48u as=0.1208p ps=1.42u w=0.28u l=0.36u
X134 a_1967_1814# a_1767_1742# a_1963_1660# VSUBS nfet_03v3 ad=0.1288p pd=1.48u as=0.1208p ps=1.42u w=0.28u l=0.36u
X135 a_82_164# a_484_484# a_532_402# VSUBS nfet_03v3 ad=0.1288p pd=1.48u as=0.1208p ps=1.42u w=0.28u l=0.36u
X136 a_138_208# a_82_164# a_0_116# VSUBS nfet_03v3 ad=0.342p pd=2.21u as=0.3133p ps=2.64u w=0.45u l=0.28u
X137 a_1967_556# a_1767_484# a_1963_402# VSUBS nfet_03v3 ad=0.1288p pd=1.48u as=0.1208p ps=1.42u w=0.28u l=0.36u
X138 a_1365_1708# a_1767_2028# a_1815_1946# VSUBS nfet_03v3 ad=0.1288p pd=1.48u as=0.1208p ps=1.42u w=0.28u l=0.36u
X139 a_4941_932# a_4885_888# a_4781_932# VSUBS nfet_03v3 ad=0.23585p pd=1.95u as=0.1378p ps=1.05u w=0.53u l=0.28u
X140 a_2648_2480# a_3050_2514# a_3098_2432# VSUBS nfet_03v3 ad=0.1288p pd=1.48u as=0.1208p ps=1.42u w=0.28u l=0.36u
X141 a_3250_1042# a_3050_970# a_3246_888# VSUBS nfet_03v3 ad=0.1288p pd=1.48u as=0.1208p ps=1.42u w=0.28u l=0.36u
X142 a_2648_936# a_3050_970# a_3098_888# VSUBS nfet_03v3 ad=0.1288p pd=1.48u as=0.1208p ps=1.42u w=0.28u l=0.36u
X143 a_2648_2480# a_3050_2800# a_3098_2718# VSUBS nfet_03v3 ad=0.1288p pd=1.48u as=0.1208p ps=1.42u w=0.28u l=0.36u
X144 a_1421_2015# a_1365_1708# a_1283_1660# w_1283_1934# pfet_03v3 ad=0.3061p pd=2.445u as=0.1238p ps=1.44u w=0.28u l=0.28u
X145 a_1092_1704# a_1036_1894# a_932_1938# VSUBS nfet_03v3 ad=0.23585p pd=1.95u as=0.1378p ps=1.05u w=0.53u l=0.28u
X146 a_3658_160# a_3602_350# a_3498_394# VSUBS nfet_03v3 ad=0.23585p pd=1.95u as=0.1378p ps=1.05u w=0.53u l=0.28u
X147 a_2375_1704# a_2319_1894# a_2215_1938# VSUBS nfet_03v3 ad=0.23585p pd=1.95u as=0.1378p ps=1.05u w=0.53u l=0.28u
X148 a_2704_2015# a_2648_1708# a_2566_1660# w_2566_1934# pfet_03v3 ad=0.3061p pd=2.445u as=0.1238p ps=1.44u w=0.28u l=0.28u
X149 a_138_2015# a_82_1708# a_0_1660# w_0_1934# pfet_03v3 ad=0.3061p pd=2.445u as=0.1238p ps=1.44u w=0.28u l=0.28u
X150 a_4941_2476# a_4885_2666# a_4781_2710# VSUBS nfet_03v3 ad=0.23585p pd=1.95u as=0.1378p ps=1.05u w=0.53u l=0.28u
X151 a_2215_932# a_2159_888# a_2071_932# VSUBS nfet_03v3 ad=0.1378p pd=1.05u as=0.2332p ps=1.94u w=0.53u l=0.28u
X152 a_932_932# a_876_888# a_788_932# VSUBS nfet_03v3 ad=0.1378p pd=1.05u as=0.2332p ps=1.94u w=0.53u l=0.28u
X153 a_1365_1708# a_1283_1660# a_1421_1752# VSUBS nfet_03v3 ad=0.3133p pd=2.64u as=0.342p ps=2.21u w=0.45u l=0.28u
X154 a_3498_2710# a_3442_2666# a_3354_2710# VSUBS nfet_03v3 ad=0.1378p pd=1.05u as=0.2332p ps=1.94u w=0.53u l=0.28u
X155 a_3987_2524# a_3931_2480# a_3849_2432# VSUBS nfet_03v3 ad=0.342p pd=2.21u as=0.3133p ps=2.64u w=0.45u l=0.28u
X156 a_3931_1708# a_4333_1742# a_4381_1660# VSUBS nfet_03v3 ad=0.1288p pd=1.48u as=0.1208p ps=1.42u w=0.28u l=0.36u
X157 a_4781_2710# a_4725_2666# a_4637_2710# VSUBS nfet_03v3 ad=0.1378p pd=1.05u as=0.2332p ps=1.94u w=0.53u l=0.28u
X158 a_684_2100# a_484_2028# a_680_1946# VSUBS nfet_03v3 ad=0.1288p pd=1.48u as=0.1208p ps=1.42u w=0.28u l=0.36u
X159 a_82_936# a_0_888# a_138_980# VSUBS nfet_03v3 ad=0.3133p pd=2.64u as=0.342p ps=2.21u w=0.45u l=0.28u
X160 a_3931_2480# a_3849_2432# a_3987_2524# VSUBS nfet_03v3 ad=0.3133p pd=2.64u as=0.342p ps=2.21u w=0.45u l=0.28u
X161 a_3987_1243# a_3931_936# a_3849_888# w_3849_1162# pfet_03v3 ad=0.3061p pd=2.445u as=0.1238p ps=1.44u w=0.28u l=0.28u
X162 a_2648_2480# a_2566_2432# a_2704_2787# w_2566_2706# pfet_03v3 ad=0.1238p pd=1.44u as=0.3061p ps=2.445u w=0.28u l=0.28u
X163 a_684_1042# a_484_970# a_680_888# VSUBS nfet_03v3 ad=0.1288p pd=1.48u as=0.1208p ps=1.42u w=0.28u l=0.36u
X164 a_1967_2586# a_1767_2514# a_1963_2432# VSUBS nfet_03v3 ad=0.1288p pd=1.48u as=0.1208p ps=1.42u w=0.28u l=0.36u
X165 a_3250_1328# a_3050_1256# a_3246_1174# VSUBS nfet_03v3 ad=0.1288p pd=1.48u as=0.1208p ps=1.42u w=0.28u l=0.36u
X166 a_82_936# a_484_1256# a_532_1174# VSUBS nfet_03v3 ad=0.1288p pd=1.48u as=0.1208p ps=1.42u w=0.28u l=0.36u
X167 a_1967_2872# a_1767_2800# a_1963_2718# VSUBS nfet_03v3 ad=0.1288p pd=1.48u as=0.1208p ps=1.42u w=0.28u l=0.36u
X168 a_4941_2476# a_4885_2432# a_4781_2476# VSUBS nfet_03v3 ad=0.23585p pd=1.95u as=0.1378p ps=1.05u w=0.53u l=0.28u
X169 a_2375_160# a_2319_350# a_2215_394# VSUBS nfet_03v3 ad=0.23585p pd=1.95u as=0.1378p ps=1.05u w=0.53u l=0.28u
X170 a_1365_164# a_1767_198# a_1815_116# VSUBS nfet_03v3 ad=0.1288p pd=1.48u as=0.1208p ps=1.42u w=0.28u l=0.36u
X171 a_4533_1328# a_4333_1256# a_4529_1174# VSUBS nfet_03v3 ad=0.1288p pd=1.48u as=0.1208p ps=1.42u w=0.28u l=0.36u
X172 a_3658_932# a_3602_1122# a_3498_1166# VSUBS nfet_03v3 ad=0.23585p pd=1.95u as=0.1378p ps=1.05u w=0.53u l=0.28u
X173 a_3931_936# a_3849_888# a_3987_1243# w_3849_1162# pfet_03v3 ad=0.1238p pd=1.44u as=0.3061p ps=2.445u w=0.28u l=0.28u
X174 a_3498_2476# a_3442_2432# a_3354_2476# VSUBS nfet_03v3 ad=0.1378p pd=1.05u as=0.2332p ps=1.94u w=0.53u l=0.28u
X175 a_1365_164# a_1767_484# a_1815_402# VSUBS nfet_03v3 ad=0.1288p pd=1.48u as=0.1208p ps=1.42u w=0.28u l=0.36u
X176 a_2215_1166# a_2159_1122# a_2071_1166# VSUBS nfet_03v3 ad=0.1378p pd=1.05u as=0.2332p ps=1.94u w=0.53u l=0.28u
X177 a_4781_2476# a_4725_2432# a_4637_2476# VSUBS nfet_03v3 ad=0.1378p pd=1.05u as=0.2332p ps=1.94u w=0.53u l=0.28u
X178 a_1092_1704# a_1036_1660# a_932_1704# VSUBS nfet_03v3 ad=0.23585p pd=1.95u as=0.1378p ps=1.05u w=0.53u l=0.28u
X179 a_3658_160# a_3602_116# a_3498_160# VSUBS nfet_03v3 ad=0.23585p pd=1.95u as=0.1378p ps=1.05u w=0.53u l=0.28u
X180 a_1365_1708# a_1767_1742# a_1815_1660# VSUBS nfet_03v3 ad=0.1288p pd=1.48u as=0.1208p ps=1.42u w=0.28u l=0.36u
X181 a_2375_1704# a_2319_1660# a_2215_1704# VSUBS nfet_03v3 ad=0.23585p pd=1.95u as=0.1378p ps=1.05u w=0.53u l=0.28u
X182 a_2648_936# a_2566_888# a_2704_980# VSUBS nfet_03v3 ad=0.3133p pd=2.64u as=0.342p ps=2.21u w=0.45u l=0.28u
X183 a_932_1166# a_876_1122# a_788_1166# VSUBS nfet_03v3 ad=0.1378p pd=1.05u as=0.2332p ps=1.94u w=0.53u l=0.28u
X184 a_82_2480# a_0_2432# a_138_2787# w_0_2706# pfet_03v3 ad=0.1238p pd=1.44u as=0.3061p ps=2.445u w=0.28u l=0.28u
X185 a_1365_2480# a_1283_2432# a_1421_2524# VSUBS nfet_03v3 ad=0.3133p pd=2.64u as=0.342p ps=2.21u w=0.45u l=0.28u
X186 a_3931_2480# a_4333_2514# a_4381_2432# VSUBS nfet_03v3 ad=0.1288p pd=1.48u as=0.1208p ps=1.42u w=0.28u l=0.36u
X187 a_1092_160# a_1036_350# a_932_394# VSUBS nfet_03v3 ad=0.23585p pd=1.95u as=0.1378p ps=1.05u w=0.53u l=0.28u
X188 a_3931_2480# a_4333_2800# a_4381_2718# VSUBS nfet_03v3 ad=0.1288p pd=1.48u as=0.1208p ps=1.42u w=0.28u l=0.36u
X189 a_3987_980# a_3931_936# a_3849_888# VSUBS nfet_03v3 ad=0.342p pd=2.21u as=0.3133p ps=2.64u w=0.45u l=0.28u
X190 a_3987_2015# a_3931_1708# a_3849_1660# w_3849_1934# pfet_03v3 ad=0.3061p pd=2.445u as=0.1238p ps=1.44u w=0.28u l=0.28u
X191 a_3658_1704# a_3602_1894# a_3498_1938# VSUBS nfet_03v3 ad=0.23585p pd=1.95u as=0.1378p ps=1.05u w=0.53u l=0.28u
.ends

.subckt gf180mcu_as_sc_mcu7t3v3__nand2_2 VDD VSS Y B A VNW VPW
X0 VDD A Y VNW pfet_03v3 ad=0.3588p pd=1.9u as=0.3588p ps=1.9u w=1.38u l=0.28u
X1 VSS A a_28_68# VPW nfet_03v3 ad=0.26p pd=1.52u as=0.44p ps=2.88u w=1u l=0.28u
X2 Y B VDD VNW pfet_03v3 ad=0.3588p pd=1.9u as=0.3588p ps=1.9u w=1.38u l=0.28u
X3 a_28_68# B Y VPW nfet_03v3 ad=0.515p pd=3.03u as=0.26p ps=1.52u w=1u l=0.28u
X4 VDD B Y VNW pfet_03v3 ad=0.7176p pd=3.8u as=0.3588p ps=1.9u w=1.38u l=0.28u
X5 Y B a_28_68# VPW nfet_03v3 ad=0.26p pd=1.52u as=0.26p ps=1.52u w=1u l=0.28u
X6 Y A VDD VNW pfet_03v3 ad=0.3588p pd=1.9u as=0.6072p ps=3.64u w=1.38u l=0.28u
X7 a_28_68# A VSS VPW nfet_03v3 ad=0.26p pd=1.52u as=0.26p ps=1.52u w=1u l=0.28u
.ends

.subckt gf180mcu_as_sc_mcu7t3v3__nor2_2 VDD VSS Y B A VNW VPW
X0 a_28_440# A VDD VNW pfet_03v3 ad=0.3588p pd=1.9u as=0.3588p ps=1.9u w=1.38u l=0.28u
X1 Y A VSS VPW nfet_03v3 ad=0.26p pd=1.52u as=0.44p ps=2.88u w=1u l=0.28u
X2 Y B a_28_440# VNW pfet_03v3 ad=0.3588p pd=1.9u as=0.3588p ps=1.9u w=1.38u l=0.28u
X3 VSS B Y VPW nfet_03v3 ad=0.515p pd=3.03u as=0.26p ps=1.52u w=1u l=0.28u
X4 a_28_440# B Y VNW pfet_03v3 ad=0.7176p pd=3.8u as=0.3588p ps=1.9u w=1.38u l=0.28u
X5 Y B VSS VPW nfet_03v3 ad=0.26p pd=1.52u as=0.26p ps=1.52u w=1u l=0.28u
X6 VDD A a_28_440# VNW pfet_03v3 ad=0.3588p pd=1.9u as=0.6072p ps=3.64u w=1.38u l=0.28u
X7 VSS A Y VPW nfet_03v3 ad=0.26p pd=1.52u as=0.26p ps=1.52u w=1u l=0.28u
.ends

.subckt gf180mcu_as_sc_mcu7t3v3__nand3_2 VDD VSS A B C Y VNW VPW
X0 VDD A Y VNW pfet_03v3 ad=0.3588p pd=1.9u as=0.3588p ps=1.9u w=1.38u l=0.28u
X1 VSS A a_28_68# VPW nfet_03v3 ad=0.26p pd=1.52u as=0.44p ps=2.88u w=1u l=0.28u
X2 VDD C Y VNW pfet_03v3 ad=0.621p pd=3.66u as=0.3588p ps=1.9u w=1.38u l=0.28u
X3 a_492_68# C Y VPW nfet_03v3 ad=0.45p pd=2.9u as=0.26p ps=1.52u w=1u l=0.28u
X4 Y B VDD VNW pfet_03v3 ad=0.3588p pd=1.9u as=0.3588p ps=1.9u w=1.38u l=0.28u
X5 a_28_68# B a_492_68# VPW nfet_03v3 ad=0.44p pd=2.88u as=0.26p ps=1.52u w=1u l=0.28u
X6 VDD B Y VNW pfet_03v3 ad=0.8004p pd=2.54u as=0.3588p ps=1.9u w=1.38u l=0.28u
X7 Y C VDD VNW pfet_03v3 ad=0.3588p pd=1.9u as=0.8004p ps=2.54u w=1.38u l=0.28u
X8 Y C a_492_68# VPW nfet_03v3 ad=0.26p pd=1.52u as=0.44p ps=2.88u w=1u l=0.28u
X9 a_492_68# B a_28_68# VPW nfet_03v3 ad=0.26p pd=1.52u as=0.26p ps=1.52u w=1u l=0.28u
X10 Y A VDD VNW pfet_03v3 ad=0.3588p pd=1.9u as=0.6072p ps=3.64u w=1.38u l=0.28u
X11 a_28_68# A VSS VPW nfet_03v3 ad=0.26p pd=1.52u as=0.26p ps=1.52u w=1u l=0.28u
.ends

.subckt gf180mcu_3v3_12t_2r2w_sram_1024x8_array_control_core clk VSS w0_data[0] w0_data[1]
+ w0_data[2] w0_data[3] w0_data[4] w0_data[5] w0_data[6] w0_data[7] w1_data[0] w1_data[1]
+ w1_data[2] w1_data[3] w1_data[4] w1_data[5] w1_data[6] w1_data[7] r0_data[0] r0_data[1]
+ r0_data[2] r0_data[3] r0_data[4] r0_data[5] r0_data[6] r0_data[7] r1_data[0] r1_data[1]
+ r1_data[2] r1_data[3] r1_data[4] r1_data[5] r1_data[6] r1_data[7] u_t001_006/c1_r0_rbl
+ u_t000_013/c3_w1_br u_t023_011/c2_w0_bl u_t000_013/r1_w1_wl u_t003_009/c0_w1_bl
+ u_t001_010/r3_r1_rwl u_t001_012/c3_w0_bl u_t026_005/c2_w1_bl u_t001_011/c2_r1_rbl
+ u_t003_003/VSS u_t004_003/VDD u_t001_013/c3_r0_rbl u_t005_009/c2_w0_bl u_t021_013/c2_w0_bl
+ u_t003_012/VSS u_t004_012/VDD u_t002_005/c0_w1_bl u_t019_013/c2_w0_bl u_t003_006/c2_w1_br
+ u_t003_001/c0_r1_rbl u_t006_001/r3_w1_wl u_t024_007/c2_w1_bl u_t003_003/c1_r0_rbl
+ u_t000_015/r3_w0_wl u_t030_015/r0_w0_wl u_t002_004/c2_r1_rbl u_t006_010/c2_w1_bl
+ u_t002_006/c3_r0_rbl u_t003_005/c1_w0_br u_t003_002/c3_w1_bl u_t017_015/c2_w0_bl
+ u_t028_015/r0_w0_wl u_t001_001/c0_w1_bl u_t003_010/c3_r0_rbl u_t022_009/c2_w1_bl
+ u_t002_002/c2_w1_br a_200_39400# u_t023_003/c2_w1_bl u_t002_007/c2_w0_bl a_22600_95400#
+ u_t003_001/c2_w0_bl u_t001_007/c1_w0_br u_t001_004/c3_w1_bl u_t003_012/c1_w1_br
+ u_t002_001/c1_w0_br u_t016_011/c2_w0_bl u_t000_004/c2_w1_br u_t021_005/c2_w1_bl
+ u_t000_009/c2_w0_bl u_t003_011/c0_w0_br u_t019_005/c2_w1_bl u_t001_014/c1_w1_br
+ u_t002_004/r2_w0_wl u_t014_013/c2_w0_bl u_t001_001/r3_w1_wl u_t003_014/c3_w0_br
+ u_t031_001/r0_w1_wl u_t003_014/r1_w0_wl m4_10200_9273# u_t017_007/c2_w1_bl u_t000_003/c2_r1_rbl
+ u_t001_010/c2_w1_bl a_22600_3000# u_t000_005/c3_r0_rbl a_14200_45000# u_t012_015/c2_w0_bl
+ u_t029_001/r0_w1_wl u_t023_015/r0_w0_wl u_t015_009/c2_w1_bl u_t001_009/c1_r1_rbl
+ u_t003_012/c0_r0_rbl u_t016_003/c2_w1_bl u_t003_009/c1_w1_bl u_t027_008/c2_w0_bl
+ u_t011_011/c2_w0_bl u_t002_000/c2_r1_rbl u_t003_003/c0_w1_br u_t000_012/c3_w0_br
+ u_t009_011/c2_w0_bl u_t002_002/c3_r0_rbl a_22600_120600# a_200_92600# a_200_19800#
+ u_t014_005/c2_w1_bl u_t003_008/c0_w0_bl a_22600_75800# u_t002_005/c1_w1_bl u_t003_006/c3_w1_br
+ u_t003_006/c1_r1_rbl u_t007_013/c2_w0_bl u_t003_008/c2_r0_rbl u_t012_007/c2_w1_bl
+ u_t030_015/r1_w0_wl u_t003_015/c0_w1_bl u_t002_004/c0_w0_bl u_t003_005/c2_w0_br
+ u_t024_001/r0_w1_wl u_t000_007/c1_w1_bl u_t028_015/r1_w0_wl u_t002_002/c3_w1_br
+ u_t003_013/c3_r1_rbl u_t005_015/c2_w0_bl a_14200_109400# u_t016_015/r0_w0_wl u_t010_009/c2_w1_bl
+ u_t011_003/c2_w1_bl u_t003_001/c3_w0_bl u_t001_011/c0_r0_rbl u_t003_012/c2_w1_br
+ u_t001_007/r0_w0_wl u_t008_009/c2_w1_bl u_t002_004/VSS u_t022_008/c2_w0_bl a_14200_25400#
+ u_t002_001/c2_w0_br u_t000_012/c1_r1_rbl u_t009_003/c2_w1_bl u_t000_004/r1_w1_wl
+ u_t004_011/c2_w0_bl u_t001_003/c3_w0_bl u_t003_011/c1_w0_br m4_15800_9273# u_t000_003/c2_w0_br
+ u_t007_005/c2_w1_bl u_t002_004/c0_r0_rbl u_t002_013/c2_w0_bl u_t031_001/r1_w1_wl
+ u_t001_013/c1_w0_br u_t000_008/c3_r1_rbl u_t000_010/c2_w1_br u_t029_001/r1_w1_wl
+ u_t005_007/c2_w1_bl u_t023_015/r1_w0_wl u_t000_015/c2_w0_bl u_t017_001/r0_w1_wl
+ u_t011_015/r0_w0_wl u_t009_015/r0_w0_wl u_t003_015/c0_r1_rbl u_t003_009/c2_w1_bl
+ u_t003_002/c1_r1_rbl u_t004_003/c2_w1_bl u_t003_004/c2_r0_rbl u_t003_003/c1_w1_br
+ u_t015_008/c2_w0_bl u_t031_012/c2_w0_bl u_t002_005/c3_r1_rbl u_t003_008/c1_w0_bl
+ u_t029_012/c2_w0_bl u_t002_005/c2_w1_bl u_t000_003/c0_r0_rbl a_200_28200# u_t003_002/c0_w0_br
+ u_t001_005/c1_w1_br a_22600_84200# u_t030_015/r2_w0_wl m4_21400_9273# u_t003_015/c1_w1_bl
+ u_t002_004/c1_w0_bl u_t027_014/c2_w0_bl u_t024_001/r1_w1_wl u_t003_005/c3_w0_br
+ u_t000_007/c2_w1_bl u_t000_010/c2_r0_rbl u_t000_009/r1_r1_rwl u_t003_005/r1_w0_wl
+ u_t028_015/r2_w0_wl u_t001_004/c0_w0_br u_t001_001/c2_w1_bl u_t012_001/r0_w1_wl
+ u_t002_002/r2_w1_wl u_t016_015/r1_w0_wl u_t003_014/c0_w0_bl u_t004_015/r0_w0_wl
+ u_t000_006/c1_w0_bl u_t002_000/c0_r0_rbl u_t001_007/c3_w0_br u_t003_012/c3_w1_br
+ u_t026_010/c2_w0_bl u_t002_001/c3_w0_br u_t001_011/c0_w1_br u_t001_001/c1_r1_rbl
+ u_t031_004/c2_w1_bl u_t001_003/c2_r0_rbl u_t010_008/c2_w0_bl u_t029_004/c2_w1_bl
+ u_t003_011/c2_w0_br u_t000_013/c1_w1_bl u_t008_008/c2_w0_bl u_t001_014/c3_w1_br
+ u_t024_012/c2_w0_bl u_t002_007/c0_r1_rbl u_t001_009/r3_r1_rwl u_t027_006/c2_w1_bl
+ u_t003_011/c0_r1_rbl u_t031_001/r2_w1_wl u_t003_013/c1_r0_rbl u_t022_014/c2_w0_bl
+ u_t003_000/c2_r0_rbl u_t029_001/r2_w1_wl u_t023_015/r2_w0_wl u_t000_010/r1_w1_wl
+ u_t003_006/c0_w1_bl a_200_81400# u_t002_001/c3_r1_rbl u_t017_001/r1_w1_wl u_t011_015/r1_w0_wl
+ u_t025_008/c2_w1_bl a_22600_64600# u_t005_001/r0_w1_wl u_t026_002/c2_w1_bl u_t001_005/VDD
+ u_t009_015/r1_w0_wl u_t003_009/c3_w1_bl u_t021_010/c2_w0_bl u_t001_014/VDD u_t001_008/c0_w1_bl
+ u_t003_007/c2_r1_rbl u_t002_002/c0_w1_bl u_t019_010/c2_w0_bl u_t003_003/c2_w1_br
+ u_t003_009/c3_r0_rbl u_t001_004/r0_r0_rwl u_t024_004/c2_w1_bl u_t003_008/c2_w0_bl
+ u_t000_005/r1_r1_rwl u_t002_005/c3_w1_bl u_t003_002/c1_w0_br u_t017_012/c2_w0_bl
+ u_t000_008/c1_r0_rbl u_t001_005/r0_w1_wl u_t022_006/c2_w1_bl u_t001_010/c0_r1_rbl
+ u_t030_015/r3_w0_wl a_14200_14200# u_t002_004/c2_w0_bl u_t024_001/r2_w1_wl u_t028_015/r3_w0_wl
+ u_t015_014/c2_w0_bl u_t001_008/r3_w1_wl u_t012_001/r1_w1_wl u_t000_000/c3_r1_rbl
+ u_t016_015/r2_w0_wl u_t020_008/c2_w1_bl u_t000_001/c2_w1_br u_t003_014/c1_w0_bl
+ u_t000_001/r0_w1_wl u_t002_004/r2_r0_rwl u_t021_002/c2_w1_bl u_t004_015/r1_w0_wl
+ u_t018_008/c2_w1_bl u_t002_003/c0_r1_rbl u_t001_005/r3_r1_rwl u_t001_000/c2_w0_bl
+ u_t002_005/c1_r0_rbl u_t019_002/c2_w1_bl u_t002_001/r2_w0_wl u_t014_010/c2_w0_bl
+ u_t001_008/c3_r0_rbl a_200_61800# u_t003_011/c3_w0_br u_t030_009/c2_w0_bl u_t003_011/r1_w0_wl
+ u_t001_010/c0_w0_br u_t017_004/c2_w1_bl u_t028_009/c2_w0_bl u_t012_012/c2_w0_bl
+ u_t000_012/c1_w0_bl u_t031_001/r3_w1_wl u_t001_013/c3_w0_br m4_32600_9273# u_t015_006/c2_w1_bl
+ u_t029_001/r3_w1_wl u_t003_003/c2_r1_rbl u_t031_010/c2_w1_bl u_t023_015/r3_w0_wl
+ u_t003_005/c3_r0_rbl u_t010_014/c2_w0_bl u_t003_006/c1_w1_bl u_t017_001/r2_w1_wl
+ u_t011_015/r2_w0_wl u_t029_010/c2_w1_bl a_19800_120600# u_t002_006/c0_w1_br u_t000_001/r1_r1_rwl
+ u_t008_014/c2_w0_bl u_t005_001/r1_w1_wl u_t003_000/c0_w1_br u_t009_015/r2_w0_wl
+ u_t013_008/c2_w1_bl a_200_17000# u_t003_005/c0_w0_bl u_t014_002/c2_w1_bl a_22600_73000#
+ u_t002_002/c1_w1_bl u_t003_003/c3_w1_br u_t001_002/c0_w1_br u_t007_010/c2_w0_bl
+ u_t003_008/c3_w0_bl u_t012_004/c2_w1_bl u_t003_012/c0_w1_bl u_t002_001/c0_w0_bl
+ u_t023_009/c2_w0_bl u_t003_002/c2_w0_br u_t000_004/c1_w1_bl u_t001_005/c3_w1_br
+ u_t005_012/c2_w0_bl u_t001_001/r3_r1_rwl u_t002_001/c1_r0_rbl u_t001_015/c1_r1_rbl
+ u_t010_006/c2_w1_bl u_t002_004/c3_w0_bl u_t024_001/r3_w1_wl u_t000_003/c0_w0_bl
+ u_t001_002/c2_r1_rbl u_t001_004/r0_w0_wl u_t008_006/c2_w1_bl u_t012_001/r2_w1_wl
+ u_t000_006/VDD u_t024_010/c2_w1_bl u_t016_015/r3_w0_wl u_t003_014/c2_w0_bl u_t000_001/r1_w1_wl
+ u_t003_007/c0_r0_rbl u_t004_015/r2_w0_wl u_t000_006/c3_w0_bl u_t000_010/c0_w1_bl
+ u_t001_011/c2_w1_br u_t006_008/c2_w1_bl u_t007_002/c2_w1_bl u_t003_012/c1_r1_rbl
+ u_t003_014/c2_r0_rbl u_t002_010/c2_w0_bl u_t000_013/c3_w1_bl u_t003_001/c3_r0_rbl
+ u_t001_014/r3_w1_wl a_200_70200# a_22600_53400# u_t005_004/c2_w1_bl u_t016_009/c2_w0_bl
+ u_t000_012/c2_w0_bl u_t003_009/c0_w0_br u_t003_008/c3_r1_rbl u_t003_006/c2_w1_bl
+ u_t017_001/r3_w1_wl u_t011_015/r3_w0_wl u_t002_006/c1_w1_br u_t030_015/c2_w0_bl
+ u_t005_001/r2_w1_wl u_t017_010/c2_w1_bl u_t009_015/r3_w0_wl u_t003_005/c1_w0_bl
+ u_t028_015/c2_w0_bl u_t000_007/c1_r1_rbl u_t001_008/c2_w1_bl u_t000_009/c2_r0_rbl
+ u_t002_005/c0_w0_br u_t002_002/c2_w1_bl u_t000_008/c1_w1_br u_t001_000/c3_r0_rbl
+ u_t000_014/c3_r1_rbl u_t003_012/c1_w1_bl u_t002_001/c1_w0_bl u_t027_011/c2_w0_bl
+ u_t003_002/c3_w0_br u_t000_004/c2_w1_bl u_t003_002/r1_w0_wl u_t001_011/VDD u_t003_003/c0_r0_rbl
+ u_t011_009/c2_w0_bl u_t002_004/c1_r1_rbl u_t003_011/c0_w0_bl u_t002_006/c2_r0_rbl
+ u_t001_014/c1_w1_bl u_t009_009/c2_w0_bl u_t025_013/c2_w0_bl u_t001_004/c3_w0_br
+ a_200_50600# u_t001_007/c3_r1_rbl u_t012_001/r3_w1_wl u_t030_007/c2_w1_bl u_t003_010/c2_r0_rbl
+ a_22600_33800# u_t003_014/c3_w0_bl u_t000_001/r2_w1_wl u_t028_007/c2_w1_bl u_t012_010/c2_w1_bl
+ u_t004_015/r3_w0_wl u_t023_015/c2_w0_bl a_22600_200# a_22600_117800# a_200_89800#
+ u_t026_009/c2_w1_bl u_t027_003/c2_w1_bl u_t003_004/c3_r1_rbl u_t001_010/c2_w0_br
+ u_t022_011/c2_w0_bl u_t000_015/r1_r1_rwl u_t003_003/c0_w1_bl u_t000_012/c3_w0_bl
+ u_t025_005/c2_w1_bl u_t004_009/c2_w0_bl u_t020_013/c2_w0_bl u_t003_009/c1_w0_br
+ u_t003_006/c3_w1_bl u_t018_013/c2_w0_bl u_t002_006/c2_w1_br u_t005_001/r3_w1_wl
+ u_t023_007/c2_w1_bl u_t003_000/c2_w1_br u_t003_005/c2_w0_bl a_14200_95400# u_t005_010/c2_w1_bl
+ u_t002_005/c1_w0_br u_t001_015/r3_r1_rwl u_t002_002/c3_w1_bl u_t016_015/c2_w0_bl
+ u_t027_015/r0_w0_wl u_t000_001/c0_w1_bl u_t021_009/c2_w1_bl u_t001_002/c2_w1_br
+ u_t002_002/c2_r0_rbl u_t001_002/r0_w1_wl u_t022_003/c2_w1_bl u_t001_007/c2_w0_bl
+ u_t003_015/c0_w0_br u_t019_009/c2_w1_bl u_t003_012/c2_w1_bl u_t002_001/c2_w0_bl
+ u_t000_007/c1_w0_br u_t000_004/c3_w1_bl u_t015_011/c2_w0_bl u_t001_005/r3_w1_wl
+ u_t003_006/c0_r1_rbl u_t003_008/c1_r0_rbl u_t020_005/c2_w1_bl u_t003_011/c1_w0_bl
+ u_t018_005/c2_w1_bl u_t000_014/c1_w1_br u_t003_013/c2_r1_rbl u_t013_013/c2_w0_bl
+ u_t000_001/r3_w1_wl u_t003_000/c3_r1_rbl u_t001_013/c1_w0_bl u_t000_011/r1_r1_rwl
+ u_t030_001/r0_w1_wl a_22600_42200# u_t016_007/c2_w1_bl u_t000_010/c2_w1_bl u_t000_012/c0_r1_rbl
+ u_t011_015/c2_w0_bl u_t028_001/r0_w1_wl u_t000_014/c1_r0_rbl u_t022_015/r0_w0_wl
+ u_t003_007/c0_w1_br u_t000_003/VDD u_t009_015/c2_w0_bl u_t014_009/c2_w1_bl u_t000_012/VDD
+ a_200_98200# u_t015_003/c2_w1_bl a_14200_75800# u_t026_008/c2_w0_bl u_t010_011/c2_w0_bl
+ u_t003_003/c1_w1_bl u_t001_005/c0_r1_rbl u_t001_009/c0_w1_br u_t001_007/c1_r0_rbl
+ u_t002_003/c0_w1_br u_t008_011/c2_w0_bl u_t001_011/r3_r1_rwl u_t013_005/c2_w1_bl
+ u_t003_009/c2_w0_br u_t003_002/c0_w0_bl u_t001_005/c1_w1_bl u_t001_012/c2_r1_rbl
+ u_t002_006/c3_w1_br u_t001_014/c3_r0_rbl u_t003_000/c3_w1_br u_t006_013/c2_w0_bl
+ u_t011_007/c2_w1_bl u_t003_005/c3_w0_bl u_t003_002/c0_r1_rbl u_t002_005/c2_w0_br
+ u_t023_001/r0_w1_wl u_t003_004/c1_r0_rbl u_t009_007/c2_w1_bl u_t027_015/r1_w0_wl
+ u_t000_008/r1_w1_wl u_t002_005/c2_r1_rbl u_t004_015/c2_w0_bl u_t015_015/r0_w0_wl
+ u_t003_015/c1_w0_br u_t003_012/c3_w1_bl u_t010_003/c2_w1_bl u_t002_001/c3_w0_bl
+ a_22600_22600# u_t001_011/c0_w1_bl u_t003_011/c3_r0_rbl u_t007_009/c2_w1_bl u_t021_008/c2_w0_bl
+ u_t001_001/c2_w0_br u_t001_001/r0_w0_wl u_t008_003/c2_w1_bl u_t003_011/c2_w0_bl
+ u_t019_008/c2_w0_bl u_t001_014/c3_w1_bl u_t000_003/c3_w0_bl a_22600_106600# a_200_78600#
+ u_t006_005/c2_w1_bl u_t001_013/c2_w0_bl u_t030_001/r1_w1_wl u_t000_013/c1_w0_br
+ u_t001_011/r3_w1_wl u_t028_001/r1_w1_wl u_t004_007/c2_w1_bl u_t022_015/r1_w0_wl
+ u_t003_007/c1_w1_br u_t016_001/r0_w1_wl u_t000_004/c2_r1_rbl u_t010_015/r0_w0_wl
+ u_t000_006/c3_r0_rbl u_t008_015/r0_w0_wl u_t002_009/c2_w1_bl u_t003_006/c0_w0_br
+ u_t003_003/c2_w1_bl u_t002_003/c1_w1_br u_t014_008/c2_w0_bl a_14200_84200# u_t003_013/c0_r0_rbl
+ u_t030_012/c2_w0_bl u_t003_009/c3_w0_br u_t003_002/c1_w0_bl u_t003_009/r1_w0_wl
+ u_t028_012/c2_w0_bl u_t001_005/c2_w1_bl u_t002_001/c2_r1_rbl u_t003_013/c0_w1_br
+ u_t002_003/c3_r0_rbl u_t002_002/c0_w0_br u_t002_006/r2_w1_wl u_t000_005/c1_w1_br
+ u_t001_004/c1_w0_bl u_t026_014/c2_w0_bl u_t023_001/r1_w1_wl u_t002_005/c3_w0_br
+ u_t003_007/c1_r1_rbl u_t027_015/r2_w0_wl u_t031_008/c2_w1_bl u_t000_004/c0_w0_br
+ u_t003_009/c2_r0_rbl u_t000_001/c2_w1_bl u_t011_001/r0_w1_wl u_t015_015/r1_w0_wl
+ u_t029_008/c2_w1_bl u_t009_001/r0_w1_wl u_t003_015/r0_w0_wl u_t000_007/c3_w0_br
+ u_t003_014/c3_r1_rbl u_t025_010/c2_w0_bl u_t000_011/c0_w1_br u_t030_004/c2_w1_bl
+ a_22600_31000# u_t003_011/c3_w0_bl u_t001_012/c0_r0_rbl u_t028_004/c2_w1_bl u_t001_010/c0_w0_bl
+ u_t007_008/c2_w0_bl u_t000_013/c1_r1_rbl u_t000_014/c3_w1_br u_t023_012/c2_w0_bl
+ u_t000_014/r1_w1_wl u_t001_013/c3_w0_bl u_t026_006/c2_w1_bl a_22600_115000# a_200_87000#
+ u_t030_001/r2_w1_wl a_14200_64600# u_t002_005/c0_r0_rbl u_t021_014/c2_w0_bl u_t028_001/r2_w1_wl
+ u_t022_015/r2_w0_wl u_t001_006/c1_r1_rbl u_t002_006/c0_w1_bl u_t019_014/c2_w0_bl
+ u_t003_007/c2_w1_br u_t016_001/r1_w1_wl u_t010_015/r1_w0_wl u_t024_008/c2_w1_bl
+ u_t004_001/r0_w1_wl u_t025_002/c2_w1_bl u_t008_015/r1_w0_wl u_t003_004/VSS u_t004_004/VDD
+ u_t001_013/c3_r1_rbl u_t020_010/c2_w0_bl u_t003_006/c1_w0_br u_t000_008/c0_w1_bl
+ u_t003_013/VSS u_t003_003/c3_w1_bl u_t001_009/c2_w1_br u_t004_013/VDD u_t001_002/c0_w1_bl
+ u_t018_010/c2_w0_bl u_t002_003/c2_w1_br u_t023_004/c2_w1_bl u_t002_008/c2_w0_bl
+ u_t003_003/c1_r1_rbl u_t003_005/c2_r0_rbl u_t003_002/c2_w0_bl u_t001_005/c3_w1_bl
+ u_t003_013/c1_w1_br u_t002_002/c1_w0_br u_t002_006/c3_r1_rbl u_t016_012/c2_w0_bl
+ u_t021_006/c2_w1_bl a_22600_11400# u_t003_010/c3_r1_rbl a_25400_200# u_t000_004/c0_r0_rbl
+ u_t003_012/c0_w0_br u_t019_006/c2_w1_bl u_t023_001/r2_w1_wl u_t001_015/c1_w1_br
+ u_t002_005/r2_w0_wl u_t027_015/r3_w0_wl u_t014_014/c2_w0_bl u_t011_001/r1_w1_wl
+ u_t001_002/r3_w1_wl u_t015_015/r2_w0_wl u_t020_002/c2_w1_bl u_t000_011/c2_r0_rbl
+ u_t009_001/r1_w1_wl a_200_67400# u_t003_015/r1_w0_wl u_t017_008/c2_w1_bl a_200_103800#
+ u_t000_000/c2_w0_bl u_t018_002/c2_w1_bl u_t013_010/c2_w0_bl u_t002_001/c0_r0_rbl
+ a_19800_200# u_t000_010/c0_w0_br u_t001_004/c2_r0_rbl u_t016_004/c2_w1_bl u_t027_009/c2_w0_bl
+ u_t011_012/c2_w0_bl u_t003_004/c0_w1_br u_t030_001/r3_w1_wl u_t000_013/c3_w0_br
+ u_t009_012/c2_w0_bl u_t003_009/c0_w0_bl u_t014_006/c2_w1_bl u_t028_001/r3_w1_wl
+ u_t030_010/c2_w1_bl u_t022_015/r3_w0_wl u_t002_006/c1_w1_bl a_14200_73000# u_t003_012/c0_r1_rbl
+ u_t003_007/c3_w1_br u_t016_001/r2_w1_wl u_t003_014/c1_r0_rbl u_t010_015/r2_w0_wl
+ u_t028_010/c2_w1_bl u_t007_014/c2_w0_bl u_t003_001/c2_r0_rbl u_t004_001/r1_w1_wl
+ u_t002_000/c0_w1_br u_t008_015/r2_w0_wl u_t012_008/c2_w1_bl u_t002_002/c3_r1_rbl
+ u_t002_005/c0_w0_bl u_t013_002/c2_w1_bl u_t003_006/c2_w0_br gf180mcu_as_sc_mcu7t3v3__inv_2_977/A
+ u_t002_003/c3_w1_br u_t000_002/c0_w1_br u_t006_010/c2_w0_bl a_200_47800# u_t011_004/c2_w1_bl
+ u_t003_002/c3_w0_bl u_t003_008/c2_r1_rbl u_t001_008/c2_w0_br u_t003_013/c2_w1_br
+ u_t001_001/c0_w0_bl u_t001_005/r0_r0_rwl u_t022_009/c2_w0_bl u_t002_002/c2_w0_br
+ u_t000_005/c3_w1_br u_t009_004/c2_w1_bl u_t000_005/r1_w1_wl u_t000_006/r1_r1_rwl
+ u_t004_012/c2_w0_bl u_t001_004/c3_w0_bl u_t003_012/c1_w0_br u_t023_001/r3_w1_wl
+ u_t007_006/c2_w1_bl u_t001_011/c0_r1_rbl u_t011_001/r2_w1_wl m4_7400_9273# u_t023_010/c2_w1_bl
+ u_t015_015/r3_w0_wl u_t002_005/VSS u_t002_014/c2_w0_bl u_t002_004/VDD u_t009_001/r2_w1_wl
+ u_t003_015/r2_w0_wl u_t001_014/c1_w0_br u_t001_011/c3_w1_bl u_t000_011/c2_w1_br
+ u_t005_008/c2_w1_bl u_t002_005/r2_r0_rwl a_14200_53400# u_t006_002/c2_w1_bl a_200_112200#
+ a_22600_59000# u_t002_004/c0_r1_rbl u_t001_006/r3_r1_rwl u_t001_010/c2_w0_bl u_t002_006/c1_r0_rbl
+ u_t003_010/c1_r0_rbl u_t004_004/c2_w1_bl u_t003_004/c1_w1_br u_t015_009/c2_w0_bl
+ u_t031_013/c2_w0_bl u_t003_009/c1_w0_bl u_t029_013/c2_w0_bl u_t002_006/c2_w1_bl
+ u_t016_001/r3_w1_wl u_t003_003/c0_w0_br u_t010_015/r3_w0_wl u_t003_000/c2_w1_bl
+ u_t001_006/c1_w1_br u_t004_001/r2_w1_wl u_t003_004/c2_r1_rbl u_t016_010/c2_w1_bl
+ u_t008_015/r3_w0_wl u_t003_006/c3_r0_rbl u_t001_001/r0_r0_rwl u_t002_005/c1_w0_bl
+ u_t027_015/c2_w0_bl u_t003_006/c3_w0_br u_t000_008/c2_w1_bl u_t000_002/r1_r1_rwl
+ u_t003_006/r1_w0_wl u_t001_002/c2_w1_bl u_t003_010/c0_w1_br u_t002_003/r2_w1_wl
+ u_t000_003/c0_r1_rbl u_t003_015/c0_w0_bl u_t003_013/c3_w1_br u_t026_011/c2_w0_bl
+ u_t002_002/c3_w0_br u_t001_012/c0_w1_br u_t031_005/c2_w1_bl u_t000_010/c2_r1_rbl
+ a_200_56200# u_t010_009/c2_w0_bl a_14200_33800# u_t003_010/VSS a_22600_39400# a_19800_3000#
+ u_t029_005/c2_w1_bl u_t003_012/c2_w0_br u_t000_014/c1_w1_bl u_t008_009/c2_w0_bl
+ u_t002_001/r2_r0_rwl u_t024_013/c2_w0_bl u_t000_004/c3_w0_br u_t002_000/c0_r1_rbl
+ u_t011_001/r3_w1_wl u_t001_002/r3_r1_rwl u_t002_002/c1_r0_rbl u_t027_007/c2_w1_bl
+ u_t009_001/r3_w1_wl u_t001_003/c2_r1_rbl u_t011_010/c2_w1_bl u_t003_015/r3_w0_wl
+ m4_1566_18600# u_t001_005/c3_r0_rbl u_t022_015/c2_w0_bl u_t009_010/c2_w1_bl u_t000_011/r1_w1_wl
+ u_t003_007/c0_w1_bl u_t003_008/c0_r0_rbl u_t025_009/c2_w1_bl gf180mcu_as_sc_mcu7t3v3__inv_2_1340/Y
+ u_t026_003/c2_w1_bl u_t000_010/c2_w0_br u_t021_011/c2_w0_bl u_t003_013/c1_r1_rbl
+ u_t001_009/c0_w1_bl u_t003_000/c2_r1_rbl u_t002_003/c0_w1_bl u_t019_011/c2_w0_bl
+ u_t003_002/c3_r0_rbl u_t003_004/c2_w1_br u_t024_005/c2_w1_bl u_t003_009/c2_w0_bl
+ gf180mcu_as_sc_mcu7t3v3__inv_2_66/Y u_t001_006/VDD u_t002_006/c3_w1_bl u_t003_003/c1_w0_br
+ u_t000_001/c1_r0_rbl u_t017_013/c2_w0_bl u_t003_000/c3_w1_bl a_25400_3000# u_t001_006/r0_w1_wl
+ u_t004_001/r3_w1_wl u_t022_007/c2_w1_bl a_200_36600# u_t002_000/c2_w1_br a_22600_92600#
+ u_t003_009/c3_r1_rbl a_22600_19800# u_t002_005/c2_w0_bl u_t004_010/c2_w1_bl u_t001_005/c1_w0_br
+ u_t001_009/r3_w1_wl u_t003_010/c1_w1_br u_t015_015/c2_w0_bl u_t026_015/r0_w0_wl
+ u_t020_009/c2_w1_bl u_t000_002/c2_w1_br u_t003_015/c1_w0_bl u_t000_008/c1_r1_rbl
+ u_t021_003/c2_w1_bl u_t000_007/c2_w0_bl u_t018_009/c2_w1_bl u_t001_001/c2_w0_bl
+ u_t019_003/c2_w1_bl u_t002_002/r2_w0_wl u_t014_011/c2_w0_bl u_t003_012/c3_w0_br
+ u_t003_012/r1_w0_wl u_t001_011/c0_w0_br u_t017_005/c2_w1_bl u_t003_004/c0_r0_rbl
+ a_14200_42200# a_200_101000# u_t012_013/c2_w0_bl u_t002_005/c1_r1_rbl u_t000_013/c1_w0_bl
+ u_t001_014/c3_w0_br u_t001_008/c3_r1_rbl u_t003_011/c2_r0_rbl u_t015_007/c2_w1_bl
+ u_t010_015/c2_w0_bl u_t027_001/r0_w1_wl u_t003_007/c1_w1_bl u_t021_015/r0_w0_wl
+ u_t002_007/c0_w1_br u_t008_015/c2_w0_bl u_t019_015/r0_w0_wl u_t003_001/c0_w1_br
+ u_t000_010/c0_r0_rbl u_t013_009/c2_w1_bl u_t003_006/c0_w0_bl u_t014_003/c2_w1_bl
+ u_t025_008/c2_w0_bl u_t002_003/c1_w1_bl u_t000_009/c0_w1_br u_t003_004/c3_w1_br
+ u_t003_005/c3_r1_rbl m4_18600_9273# a_28200_200# u_t001_003/c0_w1_br u_t007_011/c2_w0_bl
+ u_t003_009/c3_w0_bl u_t001_008/c0_w0_bl u_t012_005/c2_w1_bl u_t001_003/c0_r0_rbl
+ u_t003_013/c0_w1_bl u_t002_002/c0_w0_bl u_t003_003/c2_w0_br u_t000_005/c1_w1_bl
+ u_t001_006/c3_w1_br a_14200_106600# u_t002_000/c3_w1_br u_t005_013/c2_w0_bl u_t010_007/c2_w1_bl
+ u_t001_010/c2_r0_rbl u_t002_005/c3_w0_bl a_200_45000# u_t022_001/r0_w1_wl a_14200_22600#
+ u_t003_010/c2_w1_br u_t008_007/c2_w1_bl u_t001_005/r0_w0_wl u_t026_015/r1_w0_wl
+ a_22600_28200# u_t003_015/c2_w0_bl u_t000_002/r1_w1_wl u_t014_015/r0_w0_wl u_t003_000/c0_r0_rbl
+ u_t002_001/c1_r1_rbl u_t000_011/c0_w1_bl u_t002_003/c2_r0_rbl u_t006_009/c2_w1_bl
+ u_t020_008/c2_w0_bl u_t000_001/c2_w0_br u_t000_001/r0_w0_wl u_t007_003/c2_w1_bl
+ u_t018_008/c2_w0_bl u_t002_011/c2_w0_bl u_t000_014/c3_w1_bl u_t001_015/r3_w1_wl
+ u_t003_007/c0_r1_rbl u_t003_009/c1_r0_rbl u_t005_005/c2_w1_bl m4_24200_9273# u_t000_013/c2_w0_bl
+ u_t003_014/c2_r1_rbl u_t003_001/c3_r1_rbl u_t027_001/r1_w1_wl u_t003_007/c2_w1_bl
+ u_t021_015/r1_w0_wl u_t000_012/r1_r1_rwl u_t002_007/c1_w1_br u_t015_001/r0_w1_wl
+ u_t019_015/r1_w0_wl u_t003_001/c1_w1_br u_t000_013/c0_r1_rbl u_t031_010/c2_w0_bl
+ u_t000_015/c1_r0_rbl u_t007_015/r0_w0_wl u_t003_006/c1_w0_bl u_t001_009/c2_w1_bl
+ u_t000_002/c2_r0_rbl a_200_25400# u_t029_010/c2_w0_bl u_t002_006/c0_w0_br u_t002_003/c2_w1_bl
+ a_22600_81400# u_t003_000/c0_w0_br u_t013_008/c2_w0_bl u_t003_013/c1_w1_bl u_t002_002/c1_w0_bl
+ u_t027_012/c2_w0_bl u_t001_008/c1_r0_rbl u_t003_003/c3_w0_br u_t000_005/c2_w1_bl
+ u_t003_003/r1_w0_wl u_t001_002/c0_w0_br u_t001_012/r3_r1_rwl u_t003_012/c0_w0_bl
+ a_14200_115000# u_t000_004/c1_w0_bl u_t025_014/c2_w0_bl u_t022_001/r1_w1_wl u_t001_005/c3_w0_br
+ u_t001_000/c3_r1_rbl u_t003_010/c3_w1_br u_t026_015/r2_w0_wl u_t030_008/c2_w1_bl
+ u_t001_003/VDD u_t010_001/r0_w1_wl u_t031_002/c2_w1_bl u_t014_015/r1_w0_wl u_t001_012/VDD
+ u_t028_008/c2_w1_bl a_14200_31000# u_t003_003/c0_r1_rbl u_t003_005/c1_r0_rbl u_t008_001/r0_w1_wl
+ u_t002_015/r0_w0_wl u_t029_002/c2_w1_bl u_t001_012/c3_w1_br u_t002_006/c2_r1_rbl
+ u_t024_010/c2_w0_bl u_t000_001/r1_w0_wl m4_29800_9273# u_t003_010/c2_r1_rbl u_t003_012/c3_r0_rbl
+ u_t027_004/c2_w1_bl u_t000_010/c0_w0_bl u_t001_011/c2_w0_br u_t006_008/c2_w0_bl
+ u_t022_012/c2_w0_bl u_t003_004/c0_w1_bl u_t000_013/c3_w0_bl a_22600_61800# u_t025_006/c2_w1_bl
+ u_t020_014/c2_w0_bl u_t027_001/r2_w1_wl u_t003_007/c3_w1_bl u_t021_015/r2_w0_wl
+ u_t018_014/c2_w0_bl u_t015_001/r1_w1_wl u_t019_015/r2_w0_wl u_t023_008/c2_w1_bl
+ u_t003_001/c2_w1_br u_t003_001/r0_w1_wl u_t024_002/c2_w1_bl u_t007_015/r1_w0_wl
+ u_t003_006/c2_w0_bl u_t000_005/c2_r1_rbl u_t002_006/c1_w0_br u_t000_007/c3_r0_rbl
+ u_t002_003/c3_w1_bl u_t000_009/c2_w1_br u_t000_002/c0_w1_bl u_t017_010/c2_w0_bl
+ u_t001_003/c2_w1_br u_t001_003/r0_w1_wl u_t022_004/c2_w1_bl a_14200_11400# u_t001_008/c2_w0_bl
+ u_t003_013/c2_w1_bl a_22600_17000# u_t002_002/c2_w0_bl u_t000_005/c3_w1_bl u_t003_014/c0_r0_rbl
+ u_t015_012/c2_w0_bl u_t001_006/r3_w1_wl u_t003_001/c1_r0_rbl u_t020_006/c2_w1_bl
+ u_t003_012/c1_w0_bl u_t002_002/c2_r1_rbl u_t002_004/c3_r0_rbl u_t018_006/c2_w1_bl
+ u_t022_001/r2_w1_wl u_t000_015/c1_w1_br a_22600_8600# u_t026_015/r3_w0_wl a_200_109400#
+ u_t013_014/c2_w0_bl u_t010_001/r1_w1_wl u_t014_015/r2_w0_wl u_t001_014/c1_w0_bl
+ u_t008_001/r1_w1_wl u_t002_015/r1_w0_wl u_t003_008/c1_r1_rbl u_t016_008/c2_w1_bl
+ u_t017_002/c2_w1_bl u_t012_010/c2_w0_bl u_t003_008/c0_w1_br u_t015_004/c2_w1_bl
+ u_t026_009/c2_w0_bl u_t010_012/c2_w0_bl u_t003_004/c1_w1_bl u_t000_014/c1_r1_rbl
+ u_t002_004/c0_w1_br u_t008_012/c2_w0_bl a_200_14200# u_t000_004/VDD u_t013_006/c2_w1_bl
+ a_22600_70200# u_t027_001/r3_w1_wl u_t021_015/r3_w0_wl u_t000_013/VDD u_t003_003/c0_w0_bl
+ u_t001_006/c1_w1_bl u_t015_001/r2_w1_wl u_t002_006/c0_r0_rbl u_t027_010/c2_w1_bl
+ u_t019_015/r3_w0_wl u_t003_001/c3_w1_br u_t006_014/c2_w0_bl u_t003_001/r1_w1_wl
+ u_t001_007/c1_r1_rbl u_t007_015/r2_w0_wl u_t011_008/c2_w1_bl u_t003_006/c3_w0_bl
+ u_t003_010/c0_r0_rbl u_t001_009/c2_r0_rbl u_t012_002/c2_w1_bl u_t002_006/c2_w0_br
+ u_t003_010/c0_w1_bl u_t009_008/c2_w1_bl u_t003_000/c2_w0_br u_t000_009/r1_w1_wl
+ u_t002_000/c3_r0_rbl u_t001_014/c3_r1_rbl u_t005_010/c2_w0_bl u_t003_013/c3_w1_bl
+ u_t010_004/c2_w1_bl u_t002_002/c3_w0_bl u_t000_008/c2_w0_br u_t000_001/c0_w0_bl
+ u_t021_009/c2_w0_bl u_t001_002/c2_w0_br u_t008_004/c2_w1_bl u_t001_002/r0_w0_wl
+ u_t003_004/c1_r1_rbl u_t003_006/c2_r0_rbl u_t003_012/c2_w0_bl u_t019_009/c2_w0_bl
+ u_t000_004/c3_w0_bl u_t022_001/r3_w1_wl u_t006_006/c2_w1_bl u_t010_001/r2_w1_wl
+ u_t003_011/c3_r1_rbl gf180mcu_as_sc_mcu7t3v3__inv_2_1684/Y u_t022_010/c2_w1_bl u_t014_015/r3_w0_wl
+ u_t000_005/c0_r0_rbl u_t001_014/c2_w0_bl a_14200_59000# u_t008_001/r2_w1_wl u_t002_015/r2_w0_wl
+ u_t000_014/c1_w0_br u_t000_011/c3_w1_bl u_t001_012/r3_w1_wl a_22600_50600# u_t004_008/c2_w1_bl
+ u_t000_010/c1_r1_rbl u_t000_012/c2_r0_rbl u_t005_002/c2_w1_bl u_t003_008/c1_w1_br
+ a_200_8600# u_t000_010/c2_w0_bl u_t002_002/c0_r0_rbl u_t003_007/c0_w0_br u_t003_004/c2_w1_bl
+ a_22600_89800# u_t002_004/c1_w1_br u_t014_009/c2_w0_bl u_t030_013/c2_w0_bl u_t000_006/c3_r1_rbl
+ u_t003_003/c1_w0_bl u_t028_013/c2_w0_bl u_t001_009/c0_w0_br u_t001_006/c2_w1_bl
+ u_t003_014/c0_w1_br gf180mcu_as_sc_mcu7t3v3__inv_2_8/Y u_t015_001/r3_w1_wl u_t002_003/c0_w0_br
+ u_t002_000/c2_w1_bl u_t002_007/r2_w1_wl u_t000_006/c1_w1_br u_t003_001/r2_w1_wl
+ u_t015_010/c2_w1_bl u_t007_015/r3_w0_wl u_t003_013/c0_r1_rbl u_t001_005/c1_w0_bl
+ u_t003_015/c1_r0_rbl u_t026_015/c2_w0_bl u_t003_010/c1_w1_bl u_t002_006/c3_w0_br
+ u_t031_009/c2_w1_bl u_t003_000/c3_w0_br u_t003_002/c2_r0_rbl u_t000_002/c2_w1_bl
+ u_t002_003/c3_r1_rbl u_t029_009/c2_w1_bl a_14200_39400# u_t001_012/c1_w1_bl u_t025_011/c2_w0_bl
+ u_t000_012/c0_w1_br u_t030_005/c2_w1_bl u_t003_009/c2_r1_rbl u_t003_012/c3_w0_bl
+ u_t028_005/c2_w1_bl u_t001_006/r0_r0_rwl u_t007_009/c2_w0_bl u_t023_013/c2_w0_bl
+ u_t000_015/r1_w1_wl u_t000_007/r1_r1_rwl u_t010_001/r3_w1_wl u_t008_001/r3_w1_wl
+ u_t026_007/c2_w1_bl u_t010_010/c2_w1_bl u_t002_015/r3_w0_wl u_t001_012/c0_r1_rbl
+ u_t021_015/c2_w0_bl u_t001_014/c1_r0_rbl u_t008_010/c2_w1_bl u_t002_007/c0_w1_bl
+ u_t019_015/c2_w0_bl u_t003_008/c2_w1_br u_t003_001/c0_w1_bl u_t024_009/c2_w1_bl
+ u_t025_003/c2_w1_bl u_t002_006/r2_r0_rwl u_t020_011/c2_w0_bl u_t002_005/c0_r1_rbl
+ u_t003_007/c1_w0_br u_t000_009/c0_w1_bl u_t001_007/r3_r1_rwl u_t003_004/c3_w1_bl
+ u_t002_007/c1_r0_rbl u_t001_003/c0_w1_bl u_t018_011/c2_w0_bl u_t002_004/c2_w1_br
+ a_28200_120600# u_t023_005/c2_w1_bl u_t003_011/c1_r0_rbl u_t002_009/c2_w0_bl a_14200_92600#
+ a_14200_19800# a_22600_98200# u_t003_003/c2_w0_bl u_t001_006/c3_w1_bl u_t003_014/c1_w1_br
+ u_t003_005/VSS u_t002_003/c1_w0_br u_t004_005/VDD u_t016_013/c2_w0_bl u_t002_000/c3_w1_bl
+ u_t003_001/r3_w1_wl u_t021_007/c2_w1_bl u_t004_014/VDD u_t003_013/c0_w0_br u_t019_007/c2_w1_bl
+ u_t003_010/c2_w1_bl u_t002_006/r2_w0_wl u_t000_005/c1_w0_br u_t003_005/c2_r1_rbl
+ u_t014_015/c2_w0_bl u_t025_015/r0_w0_wl u_t003_007/c3_r0_rbl u_t001_002/r0_r0_rwl
+ u_t001_003/r3_w1_wl u_t020_003/c2_w1_bl u_t000_003/r1_r1_rwl u_t017_009/c2_w1_bl
+ u_t031_008/c2_w0_bl u_t000_001/c2_w0_bl u_t018_003/c2_w1_bl u_t000_004/c0_r1_rbl
+ u_t000_006/c1_r0_rbl u_t029_008/c2_w0_bl u_t013_011/c2_w0_bl u_t001_011/c1_w0_bl
+ u_t000_011/c0_w0_br u_t016_005/c2_w1_bl u_t000_011/c2_r1_rbl u_t000_013/c3_r0_rbl
+ u_t011_013/c2_w0_bl u_t002_002/r2_r0_rwl u_t003_005/c0_w1_br u_t009_013/c2_w0_bl
+ u_t000_014/c3_w0_br u_t002_001/c0_r1_rbl u_t001_003/r3_r1_rwl gf180mcu_as_sc_mcu7t3v3__inv_2_1122/A
+ u_t014_007/c2_w1_bl a_200_95400# u_t002_003/c1_r0_rbl a_22600_78600# u_t026_001/r0_w1_wl
+ u_t002_007/c1_w1_bl u_t020_015/r0_w0_wl u_t001_004/c2_r1_rbl u_t003_008/c3_w1_br
+ u_t001_006/c3_r0_rbl u_t003_001/c1_w1_bl u_t007_015/c2_w0_bl u_t018_015/r0_w0_wl
+ u_t002_001/c0_w1_br u_t012_009/c2_w1_bl u_t003_009/c0_r0_rbl u_t002_006/c0_w0_bl
+ u_t013_003/c2_w1_bl u_t003_007/c2_w0_br u_t024_008/c2_w0_bl u_t002_004/c3_w1_br
+ u_t000_003/c0_w1_br u_t003_014/c1_r1_rbl u_t006_011/c2_w0_bl u_t000_008/c0_w0_bl
+ u_t011_005/c2_w1_bl u_t003_001/c2_r1_rbl u_t003_003/c3_w0_bl u_t001_009/c2_w0_br
+ u_t003_003/c3_r0_rbl u_t003_014/c2_w1_br u_t001_002/c0_w0_bl u_t002_003/c2_w0_br
+ u_t000_006/c3_w1_br u_t009_005/c2_w1_bl a_14200_28200# u_t000_006/r1_w1_wl u_t001_000/c3_w1_br
+ u_t004_013/c2_w0_bl u_t001_005/c3_w0_bl u_t003_013/c1_w0_br u_t003_010/c3_w1_bl
+ u_t021_001/r0_w1_wl u_t007_007/c2_w1_bl u_t025_015/r1_w0_wl u_t002_015/c2_w0_bl
+ u_t019_001/r0_w1_wl u_t013_015/r0_w0_wl u_t001_015/c1_w0_br u_t001_012/c3_w1_bl
+ a_22600_103800# a_200_75800# u_t005_009/c2_w1_bl u_t000_009/c1_r1_rbl u_t006_003/c2_w1_bl
+ u_t017_008/c2_w0_bl u_t001_011/c2_w0_bl u_t004_005/c2_w1_bl u_t003_005/c1_w1_br
+ u_t003_005/c0_r0_rbl u_t031_014/c2_w0_bl u_t002_006/c1_r1_rbl u_t029_014/c2_w0_bl
+ u_t026_001/r1_w1_wl u_t002_007/c2_w1_bl u_t020_015/r1_w0_wl u_t003_004/c0_w0_br
+ u_t003_010/c1_r1_rbl u_t003_001/c2_w1_bl u_t001_007/c1_w1_br u_t014_001/r0_w1_wl
+ u_t003_012/c2_r0_rbl a_14200_81400# u_t018_015/r1_w0_wl u_t002_001/c1_w1_br a_22600_87000#
+ u_t030_010/c2_w0_bl u_t006_015/r0_w0_wl u_t002_006/c1_w0_bl u_t003_007/c3_w0_br
+ u_t000_009/c2_w1_bl u_t003_007/r1_w0_wl u_t028_010/c2_w0_bl u_t001_003/c2_w1_bl
+ u_t003_011/c0_w1_br u_t002_005/VDD u_t000_011/c0_r0_rbl u_t002_000/c0_w0_br u_t002_004/r2_w1_wl
+ u_t012_008/c2_w0_bl u_t003_014/c3_w1_br u_t003_006/c3_r1_rbl u_t026_012/c2_w0_bl
+ u_t002_003/c3_w0_br u_t031_006/c2_w1_bl u_t000_002/c0_w0_br u_t001_004/c0_r0_rbl
+ u_t029_006/c2_w1_bl u_t003_013/c2_w0_br u_t024_014/c2_w0_bl u_t021_001/r1_w1_wl
+ u_t000_005/c3_w0_br u_t025_015/r2_w0_wl u_t030_002/c2_w1_bl u_t001_011/c2_r0_rbl
+ u_t019_001/r1_w1_wl u_t013_015/r1_w0_wl u_t027_008/c2_w1_bl u_t003_011/VSS u_t007_001/r0_w1_wl
+ u_t001_015/r0_w0_wl u_t004_011/VDD u_t028_002/c2_w1_bl u_t000_012/c3_w1_br u_t023_010/c2_w0_bl
+ u_t000_012/r1_w1_wl u_t003_008/c0_w1_bl u_t003_001/c0_r0_rbl a_22600_112200# a_200_84200#
+ u_t001_011/c3_w0_bl u_t002_002/c1_r1_rbl a_14200_61800# u_t002_004/c2_r0_rbl u_t026_004/c2_w1_bl
+ a_22600_67400# u_t000_011/c2_w0_br u_t005_008/c2_w0_bl u_t021_012/c2_w0_bl u_t002_004/c0_w1_bl
+ u_t019_012/c2_w0_bl u_t003_005/c2_w1_br gf180mcu_as_sc_mcu7t3v3__inv_2_365/Y u_t003_008/c0_r1_rbl
+ u_t024_006/c2_w1_bl gf180mcu_as_sc_mcu7t3v3__inv_2_1724/A u_t026_001/r2_w1_wl u_t020_015/r2_w0_wl
+ u_t003_004/c1_w0_br u_t017_014/c2_w0_bl u_t003_001/c3_w1_bl gf180mcu_as_sc_mcu7t3v3__inv_2_73/Y
+ u_t014_001/r1_w1_wl u_t001_007/r0_w1_wl u_t018_015/r2_w0_wl u_t022_008/c2_w1_bl
+ u_t002_001/c2_w1_br u_t002_001/r0_w1_wl u_t003_002/c3_r1_rbl u_t023_002/c2_w1_bl
+ u_t006_015/r1_w0_wl u_t002_006/c2_w0_bl u_t000_013/r1_r1_rwl a_14200_17000# u_t003_000/c2_w0_bl
+ u_t001_006/c1_w0_br u_t003_011/c1_w1_br u_t016_010/c2_w0_bl u_t000_003/c2_w1_br
+ u_t000_001/c1_r1_rbl u_t021_004/c2_w1_bl u_t000_003/c2_r0_rbl u_t000_008/c2_w0_bl
+ u_t001_002/c2_w0_bl u_t003_010/c0_w0_br u_t019_004/c2_w1_bl u_t001_013/c1_w1_br
+ u_t002_003/r2_w0_wl u_t014_012/c2_w0_bl a_200_64600# u_t003_013/c3_w0_br u_t003_013/r1_w0_wl
+ a_22600_47800# u_t001_012/c0_w0_br u_t017_006/c2_w1_bl u_t021_001/r2_w1_wl u_t001_013/r3_r1_rwl
+ u_t025_015/r3_w0_wl u_t012_014/c2_w0_bl u_t002_000/c2_r0_rbl u_t019_001/r2_w1_wl
+ u_t013_015/r2_w0_wl u_t000_014/c1_w0_bl u_t007_001/r1_w1_wl u_t001_015/r1_w0_wl
+ u_t015_008/c2_w1_bl gf180mcu_as_sc_mcu7t3v3__inv_2_853/Y u_t016_002/c2_w1_bl u_t003_008/c1_w1_bl
+ u_t003_004/c0_r1_rbl u_t003_006/c1_r0_rbl u_t011_010/c2_w0_bl u_t003_002/c0_w1_br
+ u_t009_010/c2_w0_bl gf180mcu_as_sc_mcu7t3v3__inv_2_590/Y u_t014_004/c2_w1_bl u_t003_007/c0_w0_bl
+ u_t003_011/c2_r1_rbl a_14200_70200# u_t003_013/c3_r0_rbl u_t025_009/c2_w0_bl u_t002_004/c1_w1_bl
+ u_t003_005/c3_w1_br u_t001_004/c0_w1_br u_t007_012/c2_w0_bl u_t001_009/c0_w0_bl
+ u_t012_006/c2_w1_bl u_t002_003/VSS u_t003_014/c0_w1_bl u_t000_010/c0_r1_rbl u_t026_001/r3_w1_wl
+ u_t002_003/VDD u_t020_015/r3_w0_wl u_t002_003/c0_w0_bl u_t003_004/c2_w0_br u_t000_006/c1_w1_bl
+ u_t001_007/c3_w1_br u_t014_001/r2_w1_wl u_t026_010/c2_w1_bl u_t018_015/r3_w0_wl
+ u_t002_001/c3_w1_br u_t005_014/c2_w0_bl u_t002_001/r1_w1_wl u_t006_015/r2_w0_wl
+ u_t010_008/c2_w1_bl u_t002_006/c3_w0_bl u_t011_002/c2_w1_bl u_t003_000/c3_w0_bl
+ u_t003_011/c2_w1_br u_t001_006/r0_w0_wl u_t008_008/c2_w1_bl u_t001_003/c0_r1_rbl
+ u_t002_000/c2_w0_br u_t009_002/c2_w1_bl u_t000_003/r1_w1_wl u_t004_010/c2_w0_bl
+ u_t000_008/c3_r0_rbl u_t003_010/c1_w0_br u_t001_010/c2_r1_rbl u_t020_009/c2_w0_bl
+ u_t000_002/c2_w0_br u_t007_004/c2_w1_bl u_t018_009/c2_w0_bl u_t002_012/c2_w0_bl
+ u_t003_015/c0_r0_rbl u_t003_000/c0_r1_rbl u_t021_001/r3_w1_wl u_t003_002/c1_r0_rbl
+ gf180mcu_as_sc_mcu7t3v3__inv_2_1717/Y a_22600_101000# a_200_73000# u_t005_006/c2_w1_bl
+ a_14200_50600# u_t019_001/r3_w1_wl u_t002_003/c2_r1_rbl u_t021_010/c2_w1_bl a_22600_56200#
+ u_t013_015/r3_w0_wl u_t002_005/c3_r0_rbl u_t000_014/c2_w0_bl u_t007_001/r2_w1_wl
+ u_t001_015/r2_w0_wl u_t019_010/c2_w1_bl u_t003_008/c2_w1_bl u_t003_009/c1_r1_rbl
+ u_t004_002/c2_w1_bl gf180mcu_as_sc_mcu7t3v3__inv_2_733/Y a_14200_89800# u_t003_002/c1_w1_br
+ u_t031_011/c2_w0_bl u_t003_007/c1_w0_bl u_t029_011/c2_w0_bl u_t002_007/c0_w0_br
+ u_t002_004/c2_w1_bl u_t003_001/c0_w0_br u_t013_009/c2_w0_bl gf180mcu_as_sc_mcu7t3v3__inv_2_1306/Y
+ u_t003_014/c1_w1_bl gf180mcu_as_sc_mcu7t3v3__inv_2_1149/A u_t002_003/c1_w0_bl u_t027_013/c2_w0_bl
+ u_t001_001/c1_r0_rbl u_t000_009/c0_w0_br u_t000_015/c1_r1_rbl u_t003_004/c3_w0_br
+ u_t000_006/c2_w1_bl u_t003_004/r1_w0_wl u_t014_001/r3_w1_wl u_t001_003/c0_w0_br
+ u_t000_002/c2_r1_rbl u_t001_000/c2_w1_bl u_t002_001/r2_w1_wl u_t003_013/c0_w0_bl
+ u_t014_010/c2_w1_bl u_t006_015/r3_w0_wl u_t000_005/c1_w0_bl u_t025_015/c2_w0_bl
+ u_t001_006/c3_w0_br u_t002_007/c0_r0_rbl u_t003_011/c3_w1_br u_t030_009/c2_w1_bl
+ u_t002_000/c3_w0_br u_t001_010/c0_w1_br a_200_53400# u_t001_008/c1_r1_rbl u_t031_003/c2_w1_bl
+ u_t003_011/c0_r0_rbl a_22600_36600# u_t028_009/c2_w1_bl u_t029_003/c2_w1_bl u_t003_010/c2_w0_br
+ u_t000_012/c1_w1_bl u_t001_013/c3_w1_br u_t024_011/c2_w0_bl u_t002_001/c3_r0_rbl
+ u_t001_004/VDD m4_1566_15800# u_t027_005/c2_w1_bl u_t001_013/VDD u_t006_009/c2_w0_bl
+ a_28200_3000# u_t022_013/c2_w0_bl u_t003_005/c1_r1_rbl u_t003_007/c2_r0_rbl u_t003_005/c0_w1_bl
+ u_t007_001/r3_w1_wl u_t025_007/c2_w1_bl u_t001_015/r3_w0_wl u_t003_012/c3_r1_rbl
+ u_t020_015/c2_w0_bl u_t031_015/r0_w0_wl u_t007_010/c2_w1_bl u_t003_008/c3_w1_bl
+ u_t018_015/c2_w0_bl u_t029_015/r0_w0_wl u_t001_010/c0_r0_rbl u_t002_001/c0_w1_bl
+ u_t023_009/c2_w1_bl u_t003_002/c2_w1_br u_t024_003/c2_w1_bl u_t000_011/c1_r1_rbl
+ u_t003_007/c2_w0_bl a_14200_98200# u_t002_007/c1_w0_br u_t000_000/c3_r0_rbl u_t002_004/c3_w1_bl
+ u_t003_001/c1_w0_br u_t000_003/c0_w1_bl u_t017_011/c2_w0_bl a_200_33800# u_t001_004/c2_w1_br
+ u_t001_004/r0_w1_wl u_t022_005/c2_w1_bl u_t002_003/c0_r0_rbl u_t001_009/c2_w0_bl
+ u_t003_014/c2_w1_bl u_t002_003/c2_w0_bl u_t000_006/c3_w1_bl gf180mcu_as_sc_mcu7t3v3__inv_2_1101/A
+ u_t015_013/c2_w0_bl u_t001_007/r3_w1_wl u_t000_007/c3_r1_rbl u_t002_001/r3_w1_wl
+ u_t020_007/c2_w1_bl u_t003_013/c1_w0_bl u_t018_007/c2_w1_bl u_t002_010/c2_w1_bl
+ a_25400_120600# u_t013_015/c2_w0_bl u_t024_015/r0_w0_wl u_t003_014/c0_r1_rbl u_t003_001/c1_r1_rbl
+ gf180mcu_as_sc_mcu7t3v3__inv_2_350/Y u_t003_003/c2_r0_rbl u_t003_010/c3_w0_br u_t016_009/c2_w1_bl
+ u_t030_008/c2_w0_bl u_t003_010/r1_w0_wl a_22600_45000# u_t017_003/c2_w1_bl u_t002_004/c3_r1_rbl
+ u_t028_008/c2_w0_bl u_t012_011/c2_w0_bl u_t003_009/c0_w1_br u_t000_011/c1_w0_bl
+ u_t001_012/c3_w0_br u_t015_005/c2_w1_bl a_14200_78600# u_t010_013/c2_w0_bl u_t003_005/c1_w1_bl
+ u_t001_007/r0_r0_rwl u_t002_005/c0_w1_br u_t008_013/c2_w0_bl u_t000_008/r1_r1_rwl
+ u_t013_007/c2_w1_bl u_t031_015/r1_w0_wl u_t003_004/c0_w0_bl u_t025_001/r0_w1_wl
+ u_t001_007/c1_w1_bl u_t029_015/r1_w0_wl u_t002_001/c1_w1_bl u_t001_013/c0_r1_rbl
+ u_t003_002/c3_w1_br u_t001_015/c1_r0_rbl u_t006_015/c2_w0_bl u_t017_015/r0_w0_wl
+ m4_10808_9273# u_t011_009/c2_w1_bl u_t003_007/c3_w0_bl u_t001_002/c2_r0_rbl u_t012_003/c2_w1_bl
+ u_t003_011/c0_w1_bl u_t000_005/VDD u_t009_009/c2_w1_bl u_t023_008/c2_w0_bl u_t003_001/c2_w0_br
+ a_14200_103800# u_t000_014/VDD u_t002_007/r2_r0_rwl u_t005_011/c2_w0_bl u_t002_006/c0_r1_rbl
+ m4_27000_9273# u_t001_008/r3_r1_rwl u_t003_014/c3_w1_bl u_t010_005/c2_w1_bl a_200_42200#
+ u_t002_003/c3_w0_bl u_t000_009/c2_w0_br u_t000_002/c0_w0_bl u_t003_010/c0_r1_rbl
+ a_22600_25400# u_t001_003/c2_w0_br u_t003_012/c1_r0_rbl gf180mcu_as_sc_mcu7t3v3__inv_2_744/A
+ u_t008_005/c2_w1_bl u_t001_003/r0_w0_wl a_14200_8600# u_t000_000/c3_w1_br u_t003_013/c2_w0_bl
+ u_t000_005/c3_w0_bl u_t002_000/c3_r1_rbl u_t020_001/r0_w1_wl u_t001_010/c2_w1_br
+ u_t006_007/c2_w1_bl u_t024_015/r1_w0_wl a_22600_109400# u_t001_015/c2_w0_bl u_t018_001/r0_w1_wl
+ u_t012_015/r0_w0_wl u_t000_015/c1_w0_br u_t000_012/c3_w1_bl u_t003_006/c2_r1_rbl
+ u_t003_008/c3_r0_rbl u_t001_013/r3_w1_wl u_t001_003/r0_r0_rwl u_t004_009/c2_w1_bl
+ u_t000_004/r1_r1_rwl u_t005_003/c2_w1_bl u_t003_009/c1_w1_br u_t016_008/c2_w0_bl
+ u_t000_011/c2_w0_bl u_t000_005/c0_r1_rbl u_t000_007/c1_r0_rbl u_t003_008/c0_w0_br
+ u_t003_005/c2_w1_bl gf180mcu_as_sc_mcu7t3v3__inv_2_1394/Y gf180mcu_as_sc_mcu7t3v3__inv_2_1689/A
+ u_t002_005/c1_w1_br u_t000_012/c2_r1_rbl gf180mcu_as_sc_mcu7t3v3__inv_2_1672/Y u_t030_014/c2_w0_bl
+ u_t000_014/c3_r0_rbl a_14200_87000# u_t031_015/r2_w0_wl u_t003_004/c1_w0_bl u_t028_014/c2_w0_bl
+ a_200_22600# u_t025_001/r1_w1_wl u_t001_007/c2_w1_bl u_t002_003/r2_r0_rwl u_t003_015/c0_w1_br
+ u_t029_015/r2_w0_wl u_t002_004/c0_w0_br u_t002_001/c2_w1_bl u_t002_002/c0_r1_rbl
+ u_t000_007/c1_w1_br u_t013_001/r0_w1_wl u_t001_004/r3_r1_rwl u_t002_004/c1_r0_rbl
+ u_t017_015/r1_w0_wl u_t001_005/c2_r1_rbl u_t005_015/r0_w0_wl gf180mcu_as_sc_mcu7t3v3__inv_2_1041/A
+ u_t001_006/c1_w0_bl u_t001_007/c3_r0_rbl u_t003_011/c1_w1_bl u_t027_010/c2_w0_bl
+ u_t003_001/c3_w0_br u_t000_003/c2_w1_bl u_t003_001/r1_w0_wl u_t011_008/c2_w0_bl
+ gf180mcu_as_sc_mcu7t3v3__inv_2_634/A u_t003_010/c0_w0_bl a_14200_112200# u_t001_013/c1_w1_bl
+ u_t009_008/c2_w0_bl u_t025_012/c2_w0_bl u_t003_015/c1_r1_rbl u_t030_006/c2_w1_bl
+ u_t003_002/c2_r1_rbl u_t003_013/c3_w0_bl u_t003_004/c3_r0_rbl u_t028_006/c2_w1_bl
+ u_t023_014/c2_w0_bl u_t020_001/r1_w1_wl u_t024_015/r2_w0_wl gf180mcu_as_sc_mcu7t3v3__inv_2_675/Y
+ u_t018_001/r1_w1_wl u_t012_015/r1_w0_wl u_t026_008/c2_w1_bl gf180mcu_as_sc_mcu7t3v3__inv_2_1409/A
+ u_t006_001/r0_w1_wl u_t000_015/r0_w0_wl u_t027_002/c2_w1_bl a_14200_67400# u_t022_010/c2_w0_bl
+ u_t003_009/c2_w1_br u_t003_002/c0_w1_bl u_t000_011/c3_w0_bl u_t025_004/c2_w1_bl
+ u_t004_008/c2_w0_bl u_t020_012/c2_w0_bl u_t003_008/c1_w0_br u_t003_005/c3_w1_bl
+ u_t001_014/c1_r1_rbl u_t018_012/c2_w0_bl u_t002_005/c2_w1_br u_t023_006/c2_w1_bl
+ u_t031_015/r3_w0_wl u_t003_004/c2_w0_bl u_t025_001/r2_w1_wl u_t003_015/c1_w1_br
+ u_t003_006/c0_r0_rbl u_t029_015/r3_w0_wl u_t002_004/c1_w0_br u_t016_014/c2_w0_bl
+ u_t002_001/c3_w1_bl u_t013_001/r1_w1_wl u_t002_007/c1_r1_rbl u_t017_015/r2_w0_wl
+ u_t021_008/c2_w1_bl u_t001_001/c2_w1_br a_200_31000# u_t001_001/r0_w1_wl u_t022_002/c2_w1_bl
+ a_22600_14200# u_t005_015/r1_w0_wl u_t003_014/c0_w0_br u_t003_011/c1_r1_rbl u_t019_008/c2_w1_bl
+ u_t003_011/c2_w1_bl u_t003_013/c2_r0_rbl u_t002_007/r2_w0_wl u_t002_000/c2_w0_bl
+ u_t000_006/c1_w0_br u_t003_000/c3_r0_rbl u_t001_004/r3_w1_wl u_t003_009/VSS u_t015_010/c2_w0_bl
+ u_t004_006/VDD u_t020_004/c2_w1_bl u_t002_006/VDD u_t003_015/VSS u_t003_010/c1_w0_bl
+ a_22600_5800# u_t000_012/c0_r0_rbl u_t031_009/c2_w0_bl u_t000_002/c2_w0_bl a_14200_47800#
+ u_t018_004/c2_w1_bl a_200_106600# u_t000_013/c1_w1_br u_t029_009/c2_w0_bl u_t013_012/c2_w0_bl
+ u_t003_007/c3_r1_rbl u_t001_012/c1_w0_bl u_t000_011/VDD u_t000_012/c0_w0_br u_t016_006/c2_w1_bl
+ u_t020_001/r2_w1_wl u_t024_015/r3_w0_wl u_t001_005/c0_r0_rbl gf180mcu_as_sc_mcu7t3v3__inv_2_722/A
+ u_t011_014/c2_w0_bl u_t018_001/r2_w1_wl u_t012_015/r2_w0_wl u_t000_006/c1_r1_rbl
+ gf180mcu_as_sc_mcu7t3v3__inv_2_638/A u_t003_006/c0_w1_br gf180mcu_as_sc_mcu7t3v3__inv_2_9/Y
+ u_t009_014/c2_w0_bl gf180mcu_as_sc_mcu7t3v3__inv_2_962/A u_t006_001/r1_w1_wl u_t000_015/r1_w0_wl
+ u_t014_008/c2_w1_bl u_t001_012/c2_r0_rbl u_t015_002/c2_w1_bl gf180mcu_as_sc_mcu7t3v3__inv_2_1382/Y
+ u_t003_009/c3_w1_br gf180mcu_as_sc_mcu7t3v3__inv_2_1669/A gf180mcu_as_sc_mcu7t3v3__inv_2_341/Y
+ u_t000_013/c3_r1_rbl u_t010_010/c2_w0_bl u_t003_002/c1_w1_bl u_t002_002/c0_w1_br
+ a_200_11400# u_t008_010/c2_w0_bl u_t003_002/c0_r0_rbl u_t002_007/c0_w0_bl u_t013_004/c2_w1_bl
+ u_t003_008/c2_w0_br u_t002_003/c1_r1_rbl u_t003_001/c0_w0_bl u_t024_009/c2_w0_bl
+ u_t001_004/c1_w1_bl u_t002_005/c2_r0_rbl u_t002_005/c3_w1_br u_t000_004/c0_w1_br
+ u_t001_006/c3_r1_rbl u_t006_012/c2_w0_bl gf180mcu_as_sc_mcu7t3v3__inv_2_998/A u_t000_009/c0_w0_bl
+ u_t011_006/c2_w1_bl u_t003_004/c3_w0_bl u_t025_001/r3_w1_wl u_t001_003/c0_w0_bl
+ u_t003_009/c0_r1_rbl u_t002_004/c2_w0_br u_t009_006/c2_w1_bl u_t000_007/c3_w1_br
+ u_t013_001/r2_w1_wl u_t000_007/r1_w1_wl u_t025_010/c2_w1_bl u_t017_015/r3_w0_wl
+ a_14200_101000# u_t004_014/c2_w0_bl u_t001_001/r1_w1_wl gf180mcu_as_sc_mcu7t3v3__inv_2_24/Y
+ u_t005_015/r2_w0_wl u_t001_006/c3_w0_bl u_t003_014/c1_w0_br u_t003_011/c3_w1_bl
+ u_t010_002/c2_w1_bl u_t002_000/c3_w0_bl u_t001_010/c0_w1_bl u_t007_008/c2_w1_bl
+ u_t003_003/c3_r1_rbl u_t008_002/c2_w1_bl u_t000_014/r1_r1_rwl u_t003_010/c2_w0_bl
+ u_t001_013/c3_w1_bl gf180mcu_as_sc_mcu7t3v3__inv_2_301/Y u_t000_004/c2_r0_rbl gf180mcu_as_sc_mcu7t3v3__inv_2_61/Y
+ gf180mcu_as_sc_mcu7t3v3__inv_2_1057/A u_t006_004/c2_w1_bl gf180mcu_as_sc_mcu7t3v3__inv_2_1355/Y
+ a_14200_56200# u_t017_009/c2_w0_bl u_t001_012/c2_w0_bl a_200_115000# u_t020_001/r3_w1_wl
+ u_t001_010/r3_w1_wl u_t004_006/c2_w1_bl u_t018_001/r3_w1_wl u_t020_010/c2_w1_bl
+ u_t012_015/r3_w0_wl u_t003_006/c1_w1_br u_t031_015/c2_w0_bl u_t006_001/r2_w1_wl
+ u_t001_014/r3_r1_rwl gf180mcu_as_sc_mcu7t3v3__inv_2_742/A u_t000_015/r2_w0_wl gf180mcu_as_sc_mcu7t3v3__inv_2_640/Y
+ u_t018_010/c2_w1_bl gf180mcu_as_sc_mcu7t3v3__inv_2_1109/A m4_4600_9273# u_t002_009/VSS
+ u_t002_001/c2_r0_rbl u_t029_015/c2_w0_bl u_t002_008/c2_w1_bl u_t003_005/c0_w0_br
+ u_t003_002/c2_w1_bl u_t001_008/c1_w1_br u_t002_002/c1_w1_br u_t030_011/c2_w0_bl
+ u_t003_005/c0_r1_rbl u_t002_007/c1_w0_bl u_t003_007/c1_r0_rbl u_t003_008/c3_w0_br
+ u_t003_001/c1_w0_bl u_t003_008/r1_w0_wl u_t028_011/c2_w0_bl u_t001_004/c2_w1_bl
+ u_t003_012/c0_w1_br gf180mcu_as_sc_mcu7t3v3__inv_2_1685/A gf180mcu_as_sc_mcu7t3v3__inv_2_1694/Y
+ u_t002_001/c0_w0_br u_t002_005/r2_w1_wl u_t012_009/c2_w0_bl u_t003_012/c2_r1_rbl
+ u_t003_014/c3_r0_rbl u_t026_013/c2_w0_bl VSUBS u_t002_004/c3_w0_br u_t000_010/r1_r1_rwl
+ u_t013_001/r3_w1_wl u_t031_007/c2_w1_bl u_t000_003/c0_w0_br u_t000_000/c2_w1_bl
+ gf180mcu_as_sc_mcu7t3v3__inv_2_359/Y a_200_59000# u_t000_011/c0_r1_rbl u_t001_001/r2_w1_wl
+ a_14200_36600# u_t029_007/c2_w1_bl u_t013_010/c2_w1_bl u_t005_015/r3_w0_wl u_t003_014/c2_w0_br
+ gf180mcu_as_sc_mcu7t3v3__inv_2_304/A u_t024_015/c2_w0_bl u_t000_006/c3_w0_br u_t000_010/c0_w1_br
+ u_t030_003/c2_w1_bl u_t027_009/c2_w1_bl u_t003_010/c3_w0_bl u_t028_003/c2_w1_bl
+ u_t001_004/c0_r1_rbl gf180mcu_as_sc_mcu7t3v3__inv_2_662/A
Xgf180mcu_as_sc_mcu7t3v3__inv_2_1588 VSS gf180mcu_as_sc_mcu7t3v3__inv_2_1588/VSS VSS
+ VSS gf180mcu_as_sc_mcu7t3v3__inv_2_1588/VNW VSUBS gf180mcu_as_sc_mcu7t3v3__inv_2
Xgf180mcu_as_sc_mcu7t3v3__inv_2_1566 VSS gf180mcu_as_sc_mcu7t3v3__inv_2_1588/VSS VSS
+ VSS gf180mcu_as_sc_mcu7t3v3__inv_2_1588/VNW VSUBS gf180mcu_as_sc_mcu7t3v3__inv_2
Xgf180mcu_as_sc_mcu7t3v3__inv_2_1577 VSS gf180mcu_as_sc_mcu7t3v3__inv_2_1582/VDD VSS
+ VSS gf180mcu_as_sc_mcu7t3v3__inv_2_1579/VNW VSUBS gf180mcu_as_sc_mcu7t3v3__inv_2
Xgf180mcu_as_sc_mcu7t3v3__inv_2_1599 VSS VSS VSS VSS gf180mcu_as_sc_mcu7t3v3__inv_2_1601/VNW
+ VSUBS gf180mcu_as_sc_mcu7t3v3__inv_2
Xgf180mcu_as_sc_mcu7t3v3__inv_2_1555 gf180mcu_as_sc_mcu7t3v3__inv_2_1556/VDD VSS VSS
+ VSS gf180mcu_as_sc_mcu7t3v3__inv_2_1556/VNW VSUBS gf180mcu_as_sc_mcu7t3v3__inv_2
Xgf180mcu_as_sc_mcu7t3v3__nand4_2_338 gf180mcu_as_sc_mcu7t3v3__inv_2_1139/VDD gf180mcu_as_sc_mcu7t3v3__inv_2_1142/VDD
+ VSS VSS VSS VSS VSS gf180mcu_as_sc_mcu7t3v3__inv_2_1139/VNW VSUBS gf180mcu_as_sc_mcu7t3v3__nand4_2
Xgf180mcu_as_sc_mcu7t3v3__nand4_2_349 VSS VSS VSS VSS VSS VSS gf180mcu_as_sc_mcu7t3v3__nand4_2_349/Y
+ gf180mcu_as_sc_mcu7t3v3__inv_2_1290/VNW VSUBS gf180mcu_as_sc_mcu7t3v3__nand4_2
Xgf180mcu_as_sc_mcu7t3v3__nand4_2_327 gf180mcu_as_sc_mcu7t3v3__inv_2_1103/VDD VSS
+ VSS VSS VSS VSS VSS gf180mcu_as_sc_mcu7t3v3__inv_2_1103/VNW VSUBS gf180mcu_as_sc_mcu7t3v3__nand4_2
Xgf180mcu_as_sc_mcu7t3v3__nand4_2_316 VSS VSS VSS VSS VSS VSS VSS gf180mcu_as_sc_mcu7t3v3__inv_2_1057/VNW
+ VSUBS gf180mcu_as_sc_mcu7t3v3__nand4_2
Xgf180mcu_as_sc_mcu7t3v3__nand4_2_305 VSS gf180mcu_as_sc_mcu7t3v3__inv_2_1048/VDD
+ VSS VSS VSS VSS VSS gf180mcu_as_sc_mcu7t3v3__inv_2_1044/VNW VSUBS gf180mcu_as_sc_mcu7t3v3__nand4_2
Xu_t029_015 u_t029_015/c0_w0_bl u_t029_015/c0_w0_br u_t029_015/c0_w1_bl u_t029_015/c0_w1_br
+ u_t029_015/c0_r0_rbl u_t029_015/c0_r1_rbl u_t029_015/c1_w0_bl u_t029_015/c1_w0_br
+ u_t029_015/c1_w1_bl u_t029_015/c1_w1_br u_t029_015/c1_r0_rbl u_t029_015/c1_r1_rbl
+ u_t029_015/c2_w0_bl u_t029_015/c2_w0_br u_t029_015/c2_w1_bl u_t029_015/c2_w1_br
+ u_t029_015/c2_r0_rbl u_t029_015/c2_r1_rbl u_t029_015/c3_w0_bl u_t029_015/c3_w0_br
+ u_t029_015/c3_w1_bl u_t029_015/c3_w1_br u_t029_015/c3_r0_rbl u_t029_015/c3_r1_rbl
+ u_t029_015/r0_w0_wl u_t029_015/r0_w1_wl u_t029_015/r0_r0_rwl u_t029_015/r0_r1_rwl
+ u_t029_015/r1_w0_wl u_t029_015/r1_w1_wl u_t029_015/r1_r0_rwl u_t029_015/r1_r1_rwl
+ u_t029_015/r2_w0_wl u_t029_015/r2_w1_wl u_t029_015/r2_r0_rwl u_t029_015/r2_r1_rwl
+ u_t029_015/r3_w0_wl u_t029_015/r3_w1_wl u_t029_015/r3_r0_rwl u_t029_015/r3_r1_rwl
+ VSS VSS u_t029_015/m2_717_1265# u_t029_015/m2_603_2031# u_t029_015/m2_1290_336#
+ u_t029_015/m2_2000_2037# u_t029_015/m2_791_2909# u_t029_015/m2_7_2126# u_t029_015/m2_2154_2081#
+ u_t029_015/m2_1795_2037# u_t029_015/m2_871_303# u_t029_015/m2_431_438# u_t029_015/m2_1290_2898#
+ u_t029_015/m2_1714_1210# u_t029_015/m2_431_1982# u_t029_015/m2_512_1265# u_t029_015/m2_2573_2126#
+ u_t029_015/m2_603_1259# u_t029_015/m2_2074_2909# u_t029_015/m2_7_336# u_t029_015/m2_717_2037#
+ u_t029_015/m2_1886_2031# u_t029_015/m2_2573_336# u_t029_015/m2_7_2898# u_t029_015/m2_2000_1265#
+ u_t029_015/m2_512_2037# u_t029_015/m2_1795_1265# u_t029_015/m2_1714_1982# u_t029_015/m2_1886_1259#
+ u_t029_015/m2_1290_2126# u_t029_015/m2_1714_438# u_t029_015/m2_431_1210# u_t029_015/m2_2573_2898#
+ u_t029_015/m2_2154_303# u_t029_015/m2_871_2081# VSUBS detronyx_12t_2w2r_rc4_4x4_routed_5layer_direct
Xu_t029_004 u_t029_004/c0_w0_bl u_t029_004/c0_w0_br u_t029_004/c0_w1_bl u_t029_004/c0_w1_br
+ u_t029_004/c0_r0_rbl u_t029_004/c0_r1_rbl u_t029_004/c1_w0_bl u_t029_004/c1_w0_br
+ u_t029_004/c1_w1_bl u_t029_004/c1_w1_br u_t029_004/c1_r0_rbl u_t029_004/c1_r1_rbl
+ u_t029_004/c2_w0_bl u_t029_004/c2_w0_br u_t029_004/c2_w1_bl u_t029_004/c2_w1_br
+ u_t029_004/c2_r0_rbl u_t029_004/c2_r1_rbl u_t029_004/c3_w0_bl u_t029_004/c3_w0_br
+ u_t029_004/c3_w1_bl u_t029_004/c3_w1_br u_t029_004/c3_r0_rbl u_t029_004/c3_r1_rbl
+ u_t029_004/r0_w0_wl u_t029_004/r0_w1_wl u_t029_004/r0_r0_rwl u_t029_004/r0_r1_rwl
+ u_t029_004/r1_w0_wl u_t029_004/r1_w1_wl u_t029_004/r1_r0_rwl u_t029_004/r1_r1_rwl
+ u_t029_004/r2_w0_wl u_t029_004/r2_w1_wl u_t029_004/r2_r0_rwl u_t029_004/r2_r1_rwl
+ u_t029_004/r3_w0_wl u_t029_004/r3_w1_wl u_t029_004/r3_r0_rwl u_t029_004/r3_r1_rwl
+ u_t029_004/VDD VSS u_t029_004/m2_717_1265# u_t029_004/m2_603_2031# u_t029_004/m2_1290_336#
+ u_t029_004/m2_2000_2037# u_t029_004/m2_791_2909# u_t029_004/m2_7_2126# u_t029_004/m2_2154_2081#
+ u_t029_004/m2_1795_2037# u_t029_004/m2_871_303# u_t029_004/m2_431_438# u_t029_004/m2_1290_2898#
+ u_t029_004/m2_1714_1210# u_t029_004/m2_431_1982# u_t029_004/m2_512_1265# u_t029_004/m2_2573_2126#
+ u_t029_004/m2_603_1259# u_t029_004/m2_2074_2909# u_t029_004/m2_7_336# u_t029_004/m2_717_2037#
+ u_t029_004/m2_1886_2031# u_t029_004/m2_2573_336# u_t029_004/m2_7_2898# u_t029_004/m2_2000_1265#
+ u_t029_004/m2_512_2037# u_t029_004/m2_1795_1265# u_t029_004/m2_1714_1982# u_t029_004/m2_1886_1259#
+ u_t029_004/m2_1290_2126# u_t029_004/m2_1714_438# u_t029_004/m2_431_1210# u_t029_004/m2_2573_2898#
+ u_t029_004/m2_2154_303# u_t029_004/m2_871_2081# VSUBS detronyx_12t_2w2r_rc4_4x4_routed_5layer_direct
Xgf180mcu_as_sc_mcu7t3v3__inv_2_1374 VSS gf180mcu_as_sc_mcu7t3v3__inv_2_1378/VDD gf180mcu_as_sc_mcu7t3v3__inv_2_1382/Y
+ VSS gf180mcu_as_sc_mcu7t3v3__inv_2_1374/VNW VSUBS gf180mcu_as_sc_mcu7t3v3__inv_2
Xgf180mcu_as_sc_mcu7t3v3__inv_2_1385 VSS VSS gf180mcu_as_sc_mcu7t3v3__inv_2_1394/Y
+ gf180mcu_as_sc_mcu7t3v3__inv_2_1394/Y gf180mcu_as_sc_mcu7t3v3__inv_2_1386/VNW VSUBS
+ gf180mcu_as_sc_mcu7t3v3__inv_2
Xgf180mcu_as_sc_mcu7t3v3__inv_2_1396 VSS VSS VSS gf180mcu_as_sc_mcu7t3v3__inv_2_1409/A
+ gf180mcu_as_sc_mcu7t3v3__inv_2_1398/VNW VSUBS gf180mcu_as_sc_mcu7t3v3__inv_2
Xgf180mcu_as_sc_mcu7t3v3__inv_2_1363 gf180mcu_as_sc_mcu7t3v3__inv_2_1403/VDD VSS gf180mcu_as_sc_mcu7t3v3__inv_2_1409/A
+ VSS gf180mcu_as_sc_mcu7t3v3__inv_2_1403/VNW VSUBS gf180mcu_as_sc_mcu7t3v3__inv_2
Xgf180mcu_as_sc_mcu7t3v3__inv_2_1341 gf180mcu_as_sc_mcu7t3v3__inv_2_1349/VDD gf180mcu_as_sc_mcu7t3v3__inv_2_1349/VSS
+ VSS gf180mcu_as_sc_mcu7t3v3__inv_2_1355/Y gf180mcu_as_sc_mcu7t3v3__inv_2_1349/VNW
+ VSUBS gf180mcu_as_sc_mcu7t3v3__inv_2
Xgf180mcu_as_sc_mcu7t3v3__inv_2_1352 gf180mcu_as_sc_mcu7t3v3__inv_2_1352/VDD gf180mcu_as_sc_mcu7t3v3__inv_2_1355/VDD
+ gf180mcu_as_sc_mcu7t3v3__inv_2_1355/Y VSS gf180mcu_as_sc_mcu7t3v3__inv_2_1352/VNW
+ VSUBS gf180mcu_as_sc_mcu7t3v3__inv_2
Xgf180mcu_as_sc_mcu7t3v3__inv_2_1330 VSS VSS VSS gf180mcu_as_sc_mcu7t3v3__inv_2_1340/Y
+ gf180mcu_as_sc_mcu7t3v3__inv_2_1332/VNW VSUBS gf180mcu_as_sc_mcu7t3v3__inv_2
Xgf180mcu_as_sc_mcu7t3v3__inv_2_825 VSS VSS VSS VSS gf180mcu_as_sc_mcu7t3v3__inv_2_825/VNW
+ VSUBS gf180mcu_as_sc_mcu7t3v3__inv_2
Xgf180mcu_as_sc_mcu7t3v3__inv_2_836 VSS VSS VSS VSS gf180mcu_as_sc_mcu7t3v3__inv_2_836/VNW
+ VSUBS gf180mcu_as_sc_mcu7t3v3__inv_2
Xgf180mcu_as_sc_mcu7t3v3__inv_2_814 VSS VSS gf180mcu_as_sc_mcu7t3v3__inv_2_814/Y VSS
+ gf180mcu_as_sc_mcu7t3v3__inv_2_841/VNW VSUBS gf180mcu_as_sc_mcu7t3v3__inv_2
Xgf180mcu_as_sc_mcu7t3v3__inv_2_803 VSS VSS VSS VSS gf180mcu_as_sc_mcu7t3v3__inv_2_837/VNW
+ VSUBS gf180mcu_as_sc_mcu7t3v3__inv_2
Xgf180mcu_as_sc_mcu7t3v3__inv_2_847 VSS VSS VSS VSS gf180mcu_as_sc_mcu7t3v3__inv_2_847/VNW
+ VSUBS gf180mcu_as_sc_mcu7t3v3__inv_2
Xgf180mcu_as_sc_mcu7t3v3__inv_2_869 VSS VSS VSS VSS gf180mcu_as_sc_mcu7t3v3__inv_2_940/VNW
+ VSUBS gf180mcu_as_sc_mcu7t3v3__inv_2
Xgf180mcu_as_sc_mcu7t3v3__inv_2_858 VSS VSS VSS VSS gf180mcu_as_sc_mcu7t3v3__inv_2_936/VNW
+ VSUBS gf180mcu_as_sc_mcu7t3v3__inv_2
Xgf180mcu_as_sc_mcu7t3v3__nand4_2_146 VSS VSS VSS VSS VSS VSS gf180mcu_as_sc_mcu7t3v3__nand4_2_146/Y
+ gf180mcu_as_sc_mcu7t3v3__inv_2_558/VNW VSUBS gf180mcu_as_sc_mcu7t3v3__nand4_2
Xgf180mcu_as_sc_mcu7t3v3__nand4_2_157 gf180mcu_as_sc_mcu7t3v3__inv_2_570/VDD gf180mcu_as_sc_mcu7t3v3__inv_2_576/VDD
+ VSS VSS VSS VSS VSS gf180mcu_as_sc_mcu7t3v3__inv_2_570/VNW VSUBS gf180mcu_as_sc_mcu7t3v3__nand4_2
Xgf180mcu_as_sc_mcu7t3v3__nand4_2_124 VSS VSS VSS VSS VSS VSS VSS gf180mcu_as_sc_mcu7t3v3__inv_2_551/VNW
+ VSUBS gf180mcu_as_sc_mcu7t3v3__nand4_2
Xgf180mcu_as_sc_mcu7t3v3__nand4_2_168 gf180mcu_as_sc_mcu7t3v3__inv_2_638/VSS gf180mcu_as_sc_mcu7t3v3__inv_2_638/VSS
+ VSS VSS VSS VSS VSS gf180mcu_as_sc_mcu7t3v3__inv_2_638/VNW VSUBS gf180mcu_as_sc_mcu7t3v3__nand4_2
Xgf180mcu_as_sc_mcu7t3v3__nand4_2_135 VSS VSS VSS VSS VSS VSS gf180mcu_as_sc_mcu7t3v3__nand4_2_135/Y
+ gf180mcu_as_sc_mcu7t3v3__inv_2_562/VNW VSUBS gf180mcu_as_sc_mcu7t3v3__nand4_2
Xgf180mcu_as_sc_mcu7t3v3__nand4_2_179 gf180mcu_as_sc_mcu7t3v3__inv_2_665/VSS VSS VSS
+ VSS VSS VSS VSS gf180mcu_as_sc_mcu7t3v3__inv_2_646/VNW VSUBS gf180mcu_as_sc_mcu7t3v3__nand4_2
Xgf180mcu_as_sc_mcu7t3v3__nand4_2_113 gf180mcu_as_sc_mcu7t3v3__inv_2_311/VSS gf180mcu_as_sc_mcu7t3v3__inv_2_279/VDD
+ VSS VSS VSS VSS VSS gf180mcu_as_sc_mcu7t3v3__inv_2_274/VNW VSUBS gf180mcu_as_sc_mcu7t3v3__nand4_2
Xgf180mcu_as_sc_mcu7t3v3__nand4_2_102 VSS gf180mcu_as_sc_mcu7t3v3__inv_2_365/VDD VSS
+ VSS VSS VSS VSS gf180mcu_as_sc_mcu7t3v3__inv_2_359/VNW VSUBS gf180mcu_as_sc_mcu7t3v3__nand4_2
Xu_t026_007 u_t026_007/c0_w0_bl u_t026_007/c0_w0_br u_t026_007/c0_w1_bl u_t026_007/c0_w1_br
+ u_t026_007/c0_r0_rbl u_t026_007/c0_r1_rbl u_t026_007/c1_w0_bl u_t026_007/c1_w0_br
+ u_t026_007/c1_w1_bl u_t026_007/c1_w1_br u_t026_007/c1_r0_rbl u_t026_007/c1_r1_rbl
+ u_t026_007/c2_w0_bl u_t026_007/c2_w0_br u_t026_007/c2_w1_bl u_t026_007/c2_w1_br
+ u_t026_007/c2_r0_rbl u_t026_007/c2_r1_rbl u_t026_007/c3_w0_bl u_t026_007/c3_w0_br
+ u_t026_007/c3_w1_bl u_t026_007/c3_w1_br u_t026_007/c3_r0_rbl u_t026_007/c3_r1_rbl
+ u_t026_007/r0_w0_wl u_t026_007/r0_w1_wl u_t026_007/r0_r0_rwl u_t026_007/r0_r1_rwl
+ u_t026_007/r1_w0_wl u_t026_007/r1_w1_wl u_t026_007/r1_r0_rwl u_t026_007/r1_r1_rwl
+ u_t026_007/r2_w0_wl u_t026_007/r2_w1_wl u_t026_007/r2_r0_rwl u_t026_007/r2_r1_rwl
+ u_t026_007/r3_w0_wl u_t026_007/r3_w1_wl u_t026_007/r3_r0_rwl u_t026_007/r3_r1_rwl
+ VSS VSS u_t026_007/m2_717_1265# u_t026_007/m2_603_2031# u_t026_007/m2_1290_336#
+ u_t026_007/m2_2000_2037# u_t026_007/m2_791_2909# u_t026_007/m2_7_2126# u_t026_007/m2_2154_2081#
+ u_t026_007/m2_1795_2037# u_t026_007/m2_871_303# u_t026_007/m2_431_438# u_t026_007/m2_1290_2898#
+ u_t026_007/m2_1714_1210# u_t026_007/m2_431_1982# u_t026_007/m2_512_1265# u_t026_007/m2_2573_2126#
+ u_t026_007/m2_603_1259# u_t026_007/m2_2074_2909# u_t026_007/m2_7_336# u_t026_007/m2_717_2037#
+ u_t026_007/m2_1886_2031# u_t026_007/m2_2573_336# u_t026_007/m2_7_2898# u_t026_007/m2_2000_1265#
+ u_t026_007/m2_512_2037# u_t026_007/m2_1795_1265# u_t026_007/m2_1714_1982# u_t026_007/m2_1886_1259#
+ u_t026_007/m2_1290_2126# u_t026_007/m2_1714_438# u_t026_007/m2_431_1210# u_t026_007/m2_2573_2898#
+ u_t026_007/m2_2154_303# u_t026_007/m2_871_2081# VSUBS detronyx_12t_2w2r_rc4_4x4_routed_5layer_direct
Xgf180mcu_as_sc_mcu7t3v3__nand4_2_63 gf180mcu_as_sc_mcu7t3v3__inv_2_8/VDD gf180mcu_as_sc_mcu7t3v3__inv_2_8/VSS
+ VSS VSS VSS VSS VSS gf180mcu_as_sc_mcu7t3v3__inv_2_8/VNW VSUBS gf180mcu_as_sc_mcu7t3v3__nand4_2
Xgf180mcu_as_sc_mcu7t3v3__nand4_2_85 gf180mcu_as_sc_mcu7t3v3__inv_2_73/VDD gf180mcu_as_sc_mcu7t3v3__inv_2_9/VDD
+ VSS VSS VSS VSS VSS gf180mcu_as_sc_mcu7t3v3__inv_2_73/VNW VSUBS gf180mcu_as_sc_mcu7t3v3__nand4_2
Xgf180mcu_as_sc_mcu7t3v3__nand4_2_30 gf180mcu_as_sc_mcu7t3v3__inv_2_171/VDD VSS VSS
+ VSS VSS VSS gf180mcu_as_sc_mcu7t3v3__nand4_2_30/Y gf180mcu_as_sc_mcu7t3v3__inv_2_171/VNW
+ VSUBS gf180mcu_as_sc_mcu7t3v3__nand4_2
Xgf180mcu_as_sc_mcu7t3v3__nand4_2_41 VSS gf180mcu_as_sc_mcu7t3v3__inv_2_203/VSS VSS
+ VSS VSS VSS gf180mcu_as_sc_mcu7t3v3__nand4_2_41/Y gf180mcu_as_sc_mcu7t3v3__inv_2_203/VNW
+ VSUBS gf180mcu_as_sc_mcu7t3v3__nand4_2
Xgf180mcu_as_sc_mcu7t3v3__nand4_2_96 gf180mcu_as_sc_mcu7t3v3__inv_2_341/VDD VSS VSS
+ VSS VSS VSS VSS gf180mcu_as_sc_mcu7t3v3__inv_2_341/VNW VSUBS gf180mcu_as_sc_mcu7t3v3__nand4_2
Xgf180mcu_as_sc_mcu7t3v3__nand4_2_74 VSS gf180mcu_as_sc_mcu7t3v3__inv_2_329/VDD VSS
+ VSS VSS VSS VSS gf180mcu_as_sc_mcu7t3v3__inv_2_326/VNW VSUBS gf180mcu_as_sc_mcu7t3v3__nand4_2
Xgf180mcu_as_sc_mcu7t3v3__nand4_2_52 VSS gf180mcu_as_sc_mcu7t3v3__inv_2_239/VDD VSS
+ VSS VSS VSS gf180mcu_as_sc_mcu7t3v3__nand4_2_52/Y gf180mcu_as_sc_mcu7t3v3__inv_2_236/VNW
+ VSUBS gf180mcu_as_sc_mcu7t3v3__nand4_2
Xu_t017_007 u_t017_007/c0_w0_bl u_t017_007/c0_w0_br u_t017_007/c0_w1_bl u_t017_007/c0_w1_br
+ u_t017_007/c0_r0_rbl u_t017_007/c0_r1_rbl u_t017_007/c1_w0_bl u_t017_007/c1_w0_br
+ u_t017_007/c1_w1_bl u_t017_007/c1_w1_br u_t017_007/c1_r0_rbl u_t017_007/c1_r1_rbl
+ u_t017_007/c2_w0_bl u_t017_007/c2_w0_br u_t017_007/c2_w1_bl u_t017_007/c2_w1_br
+ u_t017_007/c2_r0_rbl u_t017_007/c2_r1_rbl u_t017_007/c3_w0_bl u_t017_007/c3_w0_br
+ u_t017_007/c3_w1_bl u_t017_007/c3_w1_br u_t017_007/c3_r0_rbl u_t017_007/c3_r1_rbl
+ u_t017_007/r0_w0_wl u_t017_007/r0_w1_wl u_t017_007/r0_r0_rwl u_t017_007/r0_r1_rwl
+ u_t017_007/r1_w0_wl u_t017_007/r1_w1_wl u_t017_007/r1_r0_rwl u_t017_007/r1_r1_rwl
+ u_t017_007/r2_w0_wl u_t017_007/r2_w1_wl u_t017_007/r2_r0_rwl u_t017_007/r2_r1_rwl
+ u_t017_007/r3_w0_wl u_t017_007/r3_w1_wl u_t017_007/r3_r0_rwl u_t017_007/r3_r1_rwl
+ VSS VSS u_t017_007/m2_717_1265# u_t017_007/m2_603_2031# u_t017_007/m2_1290_336#
+ u_t017_007/m2_2000_2037# u_t017_007/m2_791_2909# u_t017_007/m2_7_2126# u_t017_007/m2_2154_2081#
+ u_t017_007/m2_1795_2037# u_t017_007/m2_871_303# u_t017_007/m2_431_438# u_t017_007/m2_1290_2898#
+ u_t017_007/m2_1714_1210# u_t017_007/m2_431_1982# u_t017_007/m2_512_1265# u_t017_007/m2_2573_2126#
+ u_t017_007/m2_603_1259# u_t017_007/m2_2074_2909# u_t017_007/m2_7_336# u_t017_007/m2_717_2037#
+ u_t017_007/m2_1886_2031# u_t017_007/m2_2573_336# u_t017_007/m2_7_2898# u_t017_007/m2_2000_1265#
+ u_t017_007/m2_512_2037# u_t017_007/m2_1795_1265# u_t017_007/m2_1714_1982# u_t017_007/m2_1886_1259#
+ u_t017_007/m2_1290_2126# u_t017_007/m2_1714_438# u_t017_007/m2_431_1210# u_t017_007/m2_2573_2898#
+ u_t017_007/m2_2154_303# u_t017_007/m2_871_2081# VSUBS detronyx_12t_2w2r_rc4_4x4_routed_5layer_direct
Xgf180mcu_as_sc_mcu7t3v3__inv_2_1193 gf180mcu_as_sc_mcu7t3v3__nor2_2_9/VDD gf180mcu_as_sc_mcu7t3v3__nand3_2_63/VSS
+ VSS VSS gf180mcu_as_sc_mcu7t3v3__nor2_2_9/VNW VSUBS gf180mcu_as_sc_mcu7t3v3__inv_2
Xgf180mcu_as_sc_mcu7t3v3__inv_2_1160 VSS VSS VSS VSS gf180mcu_as_sc_mcu7t3v3__inv_2_1292/VNW
+ VSUBS gf180mcu_as_sc_mcu7t3v3__inv_2
Xgf180mcu_as_sc_mcu7t3v3__inv_2_1182 VSS VSS gf180mcu_as_sc_mcu7t3v3__inv_2_1182/Y
+ VSS gf180mcu_as_sc_mcu7t3v3__inv_2_1297/VNW VSUBS gf180mcu_as_sc_mcu7t3v3__inv_2
Xgf180mcu_as_sc_mcu7t3v3__inv_2_1171 VSS VSS VSS VSS gf180mcu_as_sc_mcu7t3v3__inv_2_1271/VNW
+ VSUBS gf180mcu_as_sc_mcu7t3v3__inv_2
Xu_t031_010 u_t031_010/c0_w0_bl u_t031_010/c0_w0_br u_t031_010/c0_w1_bl u_t031_010/c0_w1_br
+ u_t031_010/c0_r0_rbl u_t031_010/c0_r1_rbl u_t031_010/c1_w0_bl u_t031_010/c1_w0_br
+ u_t031_010/c1_w1_bl u_t031_010/c1_w1_br u_t031_010/c1_r0_rbl u_t031_010/c1_r1_rbl
+ u_t031_010/c2_w0_bl u_t031_010/c2_w0_br u_t031_010/c2_w1_bl u_t031_010/c2_w1_br
+ u_t031_010/c2_r0_rbl u_t031_010/c2_r1_rbl u_t031_010/c3_w0_bl u_t031_010/c3_w0_br
+ u_t031_010/c3_w1_bl u_t031_010/c3_w1_br u_t031_010/c3_r0_rbl u_t031_010/c3_r1_rbl
+ u_t031_010/r0_w0_wl u_t031_010/r0_w1_wl u_t031_010/r0_r0_rwl u_t031_010/r0_r1_rwl
+ u_t031_010/r1_w0_wl u_t031_010/r1_w1_wl u_t031_010/r1_r0_rwl u_t031_010/r1_r1_rwl
+ u_t031_010/r2_w0_wl u_t031_010/r2_w1_wl u_t031_010/r2_r0_rwl u_t031_010/r2_r1_rwl
+ u_t031_010/r3_w0_wl u_t031_010/r3_w1_wl u_t031_010/r3_r0_rwl u_t031_010/r3_r1_rwl
+ VSS u_t031_010/VSS u_t031_010/m2_717_1265# u_t031_010/m2_603_2031# u_t031_010/m2_1290_336#
+ u_t031_010/m2_2000_2037# u_t031_010/m2_791_2909# u_t031_010/m2_7_2126# u_t031_010/m2_2154_2081#
+ u_t031_010/m2_1795_2037# u_t031_010/m2_871_303# u_t031_010/m2_431_438# u_t031_010/m2_1290_2898#
+ u_t031_010/m2_1714_1210# u_t031_010/m2_431_1982# u_t031_010/m2_512_1265# u_t031_010/m2_2573_2126#
+ u_t031_010/m2_603_1259# u_t031_010/m2_2074_2909# u_t031_010/m2_7_336# u_t031_010/m2_717_2037#
+ u_t031_010/m2_1886_2031# u_t031_010/m2_2573_336# u_t031_010/m2_7_2898# u_t031_010/m2_2000_1265#
+ u_t031_010/m2_512_2037# u_t031_010/m2_1795_1265# u_t031_010/m2_1714_1982# u_t031_010/m2_1886_1259#
+ u_t031_010/m2_1290_2126# u_t031_010/m2_1714_438# u_t031_010/m2_431_1210# u_t031_010/m2_2573_2898#
+ u_t031_010/m2_2154_303# u_t031_010/m2_871_2081# VSUBS detronyx_12t_2w2r_rc4_4x4_routed_5layer_direct
Xu_t008_007 u_t008_007/c0_w0_bl u_t008_007/c0_w0_br u_t008_007/c0_w1_bl u_t008_007/c0_w1_br
+ u_t008_007/c0_r0_rbl u_t008_007/c0_r1_rbl u_t008_007/c1_w0_bl u_t008_007/c1_w0_br
+ u_t008_007/c1_w1_bl u_t008_007/c1_w1_br u_t008_007/c1_r0_rbl u_t008_007/c1_r1_rbl
+ u_t008_007/c2_w0_bl u_t008_007/c2_w0_br u_t008_007/c2_w1_bl u_t008_007/c2_w1_br
+ u_t008_007/c2_r0_rbl u_t008_007/c2_r1_rbl u_t008_007/c3_w0_bl u_t008_007/c3_w0_br
+ u_t008_007/c3_w1_bl u_t008_007/c3_w1_br u_t008_007/c3_r0_rbl u_t008_007/c3_r1_rbl
+ u_t008_007/r0_w0_wl u_t008_007/r0_w1_wl u_t008_007/r0_r0_rwl u_t008_007/r0_r1_rwl
+ u_t008_007/r1_w0_wl u_t008_007/r1_w1_wl u_t008_007/r1_r0_rwl u_t008_007/r1_r1_rwl
+ u_t008_007/r2_w0_wl u_t008_007/r2_w1_wl u_t008_007/r2_r0_rwl u_t008_007/r2_r1_rwl
+ u_t008_007/r3_w0_wl u_t008_007/r3_w1_wl u_t008_007/r3_r0_rwl u_t008_007/r3_r1_rwl
+ VSS VSS u_t008_007/m2_717_1265# u_t008_007/m2_603_2031# u_t008_007/m2_1290_336#
+ u_t008_007/m2_2000_2037# u_t008_007/m2_791_2909# u_t008_007/m2_7_2126# u_t008_007/m2_2154_2081#
+ u_t008_007/m2_1795_2037# u_t008_007/m2_871_303# u_t008_007/m2_431_438# u_t008_007/m2_1290_2898#
+ u_t008_007/m2_1714_1210# u_t008_007/m2_431_1982# u_t008_007/m2_512_1265# u_t008_007/m2_2573_2126#
+ u_t008_007/m2_603_1259# u_t008_007/m2_2074_2909# u_t008_007/m2_7_336# u_t008_007/m2_717_2037#
+ u_t008_007/m2_1886_2031# u_t008_007/m2_2573_336# u_t008_007/m2_7_2898# u_t008_007/m2_2000_1265#
+ u_t008_007/m2_512_2037# u_t008_007/m2_1795_1265# u_t008_007/m2_1714_1982# u_t008_007/m2_1886_1259#
+ u_t008_007/m2_1290_2126# u_t008_007/m2_1714_438# u_t008_007/m2_431_1210# u_t008_007/m2_2573_2898#
+ u_t008_007/m2_2154_303# u_t008_007/m2_871_2081# VSUBS detronyx_12t_2w2r_rc4_4x4_routed_5layer_direct
Xgf180mcu_as_sc_mcu7t3v3__inv_2_611 gf180mcu_as_sc_mcu7t3v3__inv_2_637/VDD VSS gf180mcu_as_sc_mcu7t3v3__inv_2_611/Y
+ gf180mcu_as_sc_mcu7t3v3__inv_2_638/A gf180mcu_as_sc_mcu7t3v3__inv_2_637/VNW VSUBS
+ gf180mcu_as_sc_mcu7t3v3__inv_2
Xgf180mcu_as_sc_mcu7t3v3__inv_2_633 gf180mcu_as_sc_mcu7t3v3__inv_2_633/VDD VSS gf180mcu_as_sc_mcu7t3v3__inv_2_633/Y
+ VSS gf180mcu_as_sc_mcu7t3v3__inv_2_633/VNW VSUBS gf180mcu_as_sc_mcu7t3v3__inv_2
Xgf180mcu_as_sc_mcu7t3v3__inv_2_600 gf180mcu_as_sc_mcu7t3v3__inv_2_602/VDD gf180mcu_as_sc_mcu7t3v3__inv_2_606/VDD
+ gf180mcu_as_sc_mcu7t3v3__inv_2_600/Y gf180mcu_as_sc_mcu7t3v3__inv_2_638/A gf180mcu_as_sc_mcu7t3v3__inv_2_602/VNW
+ VSUBS gf180mcu_as_sc_mcu7t3v3__inv_2
Xgf180mcu_as_sc_mcu7t3v3__inv_2_622 gf180mcu_as_sc_mcu7t3v3__inv_2_624/VDD gf180mcu_as_sc_mcu7t3v3__inv_2_632/VDD
+ gf180mcu_as_sc_mcu7t3v3__inv_2_622/Y gf180mcu_as_sc_mcu7t3v3__inv_2_853/Y gf180mcu_as_sc_mcu7t3v3__inv_2_624/VNW
+ VSUBS gf180mcu_as_sc_mcu7t3v3__inv_2
Xgf180mcu_as_sc_mcu7t3v3__inv_2_655 gf180mcu_as_sc_mcu7t3v3__inv_2_656/VDD gf180mcu_as_sc_mcu7t3v3__inv_2_854/VDD
+ gf180mcu_as_sc_mcu7t3v3__inv_2_655/Y gf180mcu_as_sc_mcu7t3v3__inv_2_656/Y gf180mcu_as_sc_mcu7t3v3__inv_2_656/VNW
+ VSUBS gf180mcu_as_sc_mcu7t3v3__inv_2
Xgf180mcu_as_sc_mcu7t3v3__inv_2_688 gf180mcu_as_sc_mcu7t3v3__inv_2_688/VDD VSS gf180mcu_as_sc_mcu7t3v3__inv_2_688/Y
+ VSS gf180mcu_as_sc_mcu7t3v3__inv_2_688/VNW VSUBS gf180mcu_as_sc_mcu7t3v3__inv_2
Xgf180mcu_as_sc_mcu7t3v3__inv_2_666 VSS VSS gf180mcu_as_sc_mcu7t3v3__inv_2_666/Y gf180mcu_as_sc_mcu7t3v3__inv_2_853/Y
+ gf180mcu_as_sc_mcu7t3v3__inv_2_680/VNW VSUBS gf180mcu_as_sc_mcu7t3v3__inv_2
Xgf180mcu_as_sc_mcu7t3v3__inv_2_644 gf180mcu_as_sc_mcu7t3v3__inv_2_665/VSS VSS gf180mcu_as_sc_mcu7t3v3__inv_2_644/Y
+ gf180mcu_as_sc_mcu7t3v3__inv_2_675/Y gf180mcu_as_sc_mcu7t3v3__inv_2_646/VNW VSUBS
+ gf180mcu_as_sc_mcu7t3v3__inv_2
Xgf180mcu_as_sc_mcu7t3v3__inv_2_677 gf180mcu_as_sc_mcu7t3v3__inv_2_678/VDD gf180mcu_as_sc_mcu7t3v3__inv_2_689/VDD
+ gf180mcu_as_sc_mcu7t3v3__inv_2_744/A gf180mcu_as_sc_mcu7t3v3__inv_2_678/Y gf180mcu_as_sc_mcu7t3v3__inv_2_678/VNW
+ VSUBS gf180mcu_as_sc_mcu7t3v3__inv_2
Xgf180mcu_as_sc_mcu7t3v3__inv_2_699 VSS gf180mcu_as_sc_mcu7t3v3__inv_2_712/VDD gf180mcu_as_sc_mcu7t3v3__inv_2_699/Y
+ gf180mcu_as_sc_mcu7t3v3__inv_2_708/Y gf180mcu_as_sc_mcu7t3v3__inv_2_708/VNW VSUBS
+ gf180mcu_as_sc_mcu7t3v3__inv_2
Xu_t022_010 u_t022_010/c0_w0_bl u_t022_010/c0_w0_br u_t022_010/c0_w1_bl u_t022_010/c0_w1_br
+ u_t022_010/c0_r0_rbl u_t022_010/c0_r1_rbl u_t022_010/c1_w0_bl u_t022_010/c1_w0_br
+ u_t022_010/c1_w1_bl u_t022_010/c1_w1_br u_t022_010/c1_r0_rbl u_t022_010/c1_r1_rbl
+ u_t022_010/c2_w0_bl u_t022_010/c2_w0_br u_t022_010/c2_w1_bl u_t022_010/c2_w1_br
+ u_t022_010/c2_r0_rbl u_t022_010/c2_r1_rbl u_t022_010/c3_w0_bl u_t022_010/c3_w0_br
+ u_t022_010/c3_w1_bl u_t022_010/c3_w1_br u_t022_010/c3_r0_rbl u_t022_010/c3_r1_rbl
+ u_t022_010/r0_w0_wl u_t022_010/r0_w1_wl u_t022_010/r0_r0_rwl u_t022_010/r0_r1_rwl
+ u_t022_010/r1_w0_wl u_t022_010/r1_w1_wl u_t022_010/r1_r0_rwl u_t022_010/r1_r1_rwl
+ u_t022_010/r2_w0_wl u_t022_010/r2_w1_wl u_t022_010/r2_r0_rwl u_t022_010/r2_r1_rwl
+ u_t022_010/r3_w0_wl u_t022_010/r3_w1_wl u_t022_010/r3_r0_rwl u_t022_010/r3_r1_rwl
+ VSS VSS u_t022_010/m2_717_1265# u_t022_010/m2_603_2031# u_t022_010/m2_1290_336#
+ u_t022_010/m2_2000_2037# u_t022_010/m2_791_2909# u_t022_010/m2_7_2126# u_t022_010/m2_2154_2081#
+ u_t022_010/m2_1795_2037# u_t022_010/m2_871_303# u_t022_010/m2_431_438# u_t022_010/m2_1290_2898#
+ u_t022_010/m2_1714_1210# u_t022_010/m2_431_1982# u_t022_010/m2_512_1265# u_t022_010/m2_2573_2126#
+ u_t022_010/m2_603_1259# u_t022_010/m2_2074_2909# u_t022_010/m2_7_336# u_t022_010/m2_717_2037#
+ u_t022_010/m2_1886_2031# u_t022_010/m2_2573_336# u_t022_010/m2_7_2898# u_t022_010/m2_2000_1265#
+ u_t022_010/m2_512_2037# u_t022_010/m2_1795_1265# u_t022_010/m2_1714_1982# u_t022_010/m2_1886_1259#
+ u_t022_010/m2_1290_2126# u_t022_010/m2_1714_438# u_t022_010/m2_431_1210# u_t022_010/m2_2573_2898#
+ u_t022_010/m2_2154_303# u_t022_010/m2_871_2081# VSUBS detronyx_12t_2w2r_rc4_4x4_routed_5layer_direct
Xu_t013_010 u_t013_010/c0_w0_bl u_t013_010/c0_w0_br u_t013_010/c0_w1_bl u_t013_010/c0_w1_br
+ u_t013_010/c0_r0_rbl u_t013_010/c0_r1_rbl u_t013_010/c1_w0_bl u_t013_010/c1_w0_br
+ u_t013_010/c1_w1_bl u_t013_010/c1_w1_br u_t013_010/c1_r0_rbl u_t013_010/c1_r1_rbl
+ u_t013_010/c2_w0_bl u_t013_010/c2_w0_br u_t013_010/c2_w1_bl u_t013_010/c2_w1_br
+ u_t013_010/c2_r0_rbl u_t013_010/c2_r1_rbl u_t013_010/c3_w0_bl u_t013_010/c3_w0_br
+ u_t013_010/c3_w1_bl u_t013_010/c3_w1_br u_t013_010/c3_r0_rbl u_t013_010/c3_r1_rbl
+ u_t013_010/r0_w0_wl u_t013_010/r0_w1_wl u_t013_010/r0_r0_rwl u_t013_010/r0_r1_rwl
+ u_t013_010/r1_w0_wl u_t013_010/r1_w1_wl u_t013_010/r1_r0_rwl u_t013_010/r1_r1_rwl
+ u_t013_010/r2_w0_wl u_t013_010/r2_w1_wl u_t013_010/r2_r0_rwl u_t013_010/r2_r1_rwl
+ u_t013_010/r3_w0_wl u_t013_010/r3_w1_wl u_t013_010/r3_r0_rwl u_t013_010/r3_r1_rwl
+ VSS VSS u_t013_010/m2_717_1265# u_t013_010/m2_603_2031# u_t013_010/m2_1290_336#
+ u_t013_010/m2_2000_2037# u_t013_010/m2_791_2909# u_t013_010/m2_7_2126# u_t013_010/m2_2154_2081#
+ u_t013_010/m2_1795_2037# u_t013_010/m2_871_303# u_t013_010/m2_431_438# u_t013_010/m2_1290_2898#
+ u_t013_010/m2_1714_1210# u_t013_010/m2_431_1982# u_t013_010/m2_512_1265# u_t013_010/m2_2573_2126#
+ u_t013_010/m2_603_1259# u_t013_010/m2_2074_2909# u_t013_010/m2_7_336# u_t013_010/m2_717_2037#
+ u_t013_010/m2_1886_2031# u_t013_010/m2_2573_336# u_t013_010/m2_7_2898# u_t013_010/m2_2000_1265#
+ u_t013_010/m2_512_2037# u_t013_010/m2_1795_1265# u_t013_010/m2_1714_1982# u_t013_010/m2_1886_1259#
+ u_t013_010/m2_1290_2126# u_t013_010/m2_1714_438# u_t013_010/m2_431_1210# u_t013_010/m2_2573_2898#
+ u_t013_010/m2_2154_303# u_t013_010/m2_871_2081# VSUBS detronyx_12t_2w2r_rc4_4x4_routed_5layer_direct
Xu_t004_010 u_t004_010/c0_w0_bl u_t004_010/c0_w0_br u_t004_010/c0_w1_bl u_t004_010/c0_w1_br
+ u_t004_010/c0_r0_rbl u_t004_010/c0_r1_rbl u_t004_010/c1_w0_bl u_t004_010/c1_w0_br
+ u_t004_010/c1_w1_bl u_t004_010/c1_w1_br u_t004_010/c1_r0_rbl u_t004_010/c1_r1_rbl
+ u_t004_010/c2_w0_bl u_t004_010/c2_w0_br u_t004_010/c2_w1_bl u_t004_010/c2_w1_br
+ u_t004_010/c2_r0_rbl u_t004_010/c2_r1_rbl u_t004_010/c3_w0_bl u_t004_010/c3_w0_br
+ u_t004_010/c3_w1_bl u_t004_010/c3_w1_br u_t004_010/c3_r0_rbl u_t004_010/c3_r1_rbl
+ u_t004_010/r0_w0_wl u_t004_010/r0_w1_wl u_t004_010/r0_r0_rwl u_t004_010/r0_r1_rwl
+ u_t004_010/r1_w0_wl u_t004_010/r1_w1_wl u_t004_010/r1_r0_rwl u_t004_010/r1_r1_rwl
+ u_t004_010/r2_w0_wl u_t004_010/r2_w1_wl u_t004_010/r2_r0_rwl u_t004_010/r2_r1_rwl
+ u_t004_010/r3_w0_wl u_t004_010/r3_w1_wl u_t004_010/r3_r0_rwl u_t004_010/r3_r1_rwl
+ VSS VSS u_t004_010/m2_717_1265# u_t004_010/m2_603_2031# u_t004_010/m2_1290_336#
+ u_t004_010/m2_2000_2037# u_t004_010/m2_791_2909# u_t004_010/m2_7_2126# u_t004_010/m2_2154_2081#
+ u_t004_010/m2_1795_2037# u_t004_010/m2_871_303# u_t004_010/m2_431_438# u_t004_010/m2_1290_2898#
+ u_t004_010/m2_1714_1210# u_t004_010/m2_431_1982# u_t004_010/m2_512_1265# u_t004_010/m2_2573_2126#
+ u_t004_010/m2_603_1259# u_t004_010/m2_2074_2909# u_t004_010/m2_7_336# u_t004_010/m2_717_2037#
+ u_t004_010/m2_1886_2031# u_t004_010/m2_2573_336# u_t004_010/m2_7_2898# u_t004_010/m2_2000_1265#
+ u_t004_010/m2_512_2037# u_t004_010/m2_1795_1265# u_t004_010/m2_1714_1982# u_t004_010/m2_1886_1259#
+ u_t004_010/m2_1290_2126# u_t004_010/m2_1714_438# u_t004_010/m2_431_1210# u_t004_010/m2_2573_2898#
+ u_t004_010/m2_2154_303# u_t004_010/m2_871_2081# VSUBS detronyx_12t_2w2r_rc4_4x4_routed_5layer_direct
Xgf180mcu_as_sc_mcu7t3v3__inv_2_441 VSS VSS VSS VSS gf180mcu_as_sc_mcu7t3v3__inv_2_543/VNW
+ VSUBS gf180mcu_as_sc_mcu7t3v3__inv_2
Xgf180mcu_as_sc_mcu7t3v3__inv_2_485 VSS VSS gf180mcu_as_sc_mcu7t3v3__inv_2_485/Y VSS
+ gf180mcu_as_sc_mcu7t3v3__inv_2_548/VNW VSUBS gf180mcu_as_sc_mcu7t3v3__inv_2
Xgf180mcu_as_sc_mcu7t3v3__inv_2_463 gf180mcu_as_sc_mcu7t3v3__nor2_2_7/VDD gf180mcu_as_sc_mcu7t3v3__nor2_2_7/VSS
+ gf180mcu_as_sc_mcu7t3v3__inv_2_463/Y VSS gf180mcu_as_sc_mcu7t3v3__nor2_2_7/VNW VSUBS
+ gf180mcu_as_sc_mcu7t3v3__inv_2
Xgf180mcu_as_sc_mcu7t3v3__inv_2_452 gf180mcu_as_sc_mcu7t3v3__nor2_2_4/VDD gf180mcu_as_sc_mcu7t3v3__nand2_2_3/VSS
+ VSS VSS gf180mcu_as_sc_mcu7t3v3__nor2_2_4/VNW VSUBS gf180mcu_as_sc_mcu7t3v3__inv_2
Xgf180mcu_as_sc_mcu7t3v3__inv_2_474 gf180mcu_as_sc_mcu7t3v3__nor2_2_4/VDD gf180mcu_as_sc_mcu7t3v3__nand2_2_3/VSS
+ VSS VSS gf180mcu_as_sc_mcu7t3v3__nor2_2_4/VNW VSUBS gf180mcu_as_sc_mcu7t3v3__inv_2
Xgf180mcu_as_sc_mcu7t3v3__inv_2_430 gf180mcu_as_sc_mcu7t3v3__nor2_2_4/VDD gf180mcu_as_sc_mcu7t3v3__nor2_2_4/VSS
+ gf180mcu_as_sc_mcu7t3v3__inv_2_430/Y VSS gf180mcu_as_sc_mcu7t3v3__nor2_2_4/VNW VSUBS
+ gf180mcu_as_sc_mcu7t3v3__inv_2
Xgf180mcu_as_sc_mcu7t3v3__inv_2_496 VSS VSS VSS VSS gf180mcu_as_sc_mcu7t3v3__inv_2_555/VNW
+ VSUBS gf180mcu_as_sc_mcu7t3v3__inv_2
Xu_t010_013 u_t010_013/c0_w0_bl u_t010_013/c0_w0_br u_t010_013/c0_w1_bl u_t010_013/c0_w1_br
+ u_t010_013/c0_r0_rbl u_t010_013/c0_r1_rbl u_t010_013/c1_w0_bl u_t010_013/c1_w0_br
+ u_t010_013/c1_w1_bl u_t010_013/c1_w1_br u_t010_013/c1_r0_rbl u_t010_013/c1_r1_rbl
+ u_t010_013/c2_w0_bl u_t010_013/c2_w0_br u_t010_013/c2_w1_bl u_t010_013/c2_w1_br
+ u_t010_013/c2_r0_rbl u_t010_013/c2_r1_rbl u_t010_013/c3_w0_bl u_t010_013/c3_w0_br
+ u_t010_013/c3_w1_bl u_t010_013/c3_w1_br u_t010_013/c3_r0_rbl u_t010_013/c3_r1_rbl
+ u_t010_013/r0_w0_wl u_t010_013/r0_w1_wl u_t010_013/r0_r0_rwl u_t010_013/r0_r1_rwl
+ u_t010_013/r1_w0_wl u_t010_013/r1_w1_wl u_t010_013/r1_r0_rwl u_t010_013/r1_r1_rwl
+ u_t010_013/r2_w0_wl u_t010_013/r2_w1_wl u_t010_013/r2_r0_rwl u_t010_013/r2_r1_rwl
+ u_t010_013/r3_w0_wl u_t010_013/r3_w1_wl u_t010_013/r3_r0_rwl u_t010_013/r3_r1_rwl
+ u_t010_013/VDD u_t010_013/VSS u_t010_013/m2_717_1265# u_t010_013/m2_603_2031# u_t010_013/m2_1290_336#
+ u_t010_013/m2_2000_2037# u_t010_013/m2_791_2909# u_t010_013/m2_7_2126# u_t010_013/m2_2154_2081#
+ u_t010_013/m2_1795_2037# u_t010_013/m2_871_303# u_t010_013/m2_431_438# u_t010_013/m2_1290_2898#
+ u_t010_013/m2_1714_1210# u_t010_013/m2_431_1982# u_t010_013/m2_512_1265# u_t010_013/m2_2573_2126#
+ u_t010_013/m2_603_1259# u_t010_013/m2_2074_2909# u_t010_013/m2_7_336# u_t010_013/m2_717_2037#
+ u_t010_013/m2_1886_2031# u_t010_013/m2_2573_336# u_t010_013/m2_7_2898# u_t010_013/m2_2000_1265#
+ u_t010_013/m2_512_2037# u_t010_013/m2_1795_1265# u_t010_013/m2_1714_1982# u_t010_013/m2_1886_1259#
+ u_t010_013/m2_1290_2126# u_t010_013/m2_1714_438# u_t010_013/m2_431_1210# u_t010_013/m2_2573_2898#
+ u_t010_013/m2_2154_303# u_t010_013/m2_871_2081# VSUBS detronyx_12t_2w2r_rc4_4x4_routed_5layer_direct
Xu_t010_002 u_t010_002/c0_w0_bl u_t010_002/c0_w0_br u_t010_002/c0_w1_bl u_t010_002/c0_w1_br
+ u_t010_002/c0_r0_rbl u_t010_002/c0_r1_rbl u_t010_002/c1_w0_bl u_t010_002/c1_w0_br
+ u_t010_002/c1_w1_bl u_t010_002/c1_w1_br u_t010_002/c1_r0_rbl u_t010_002/c1_r1_rbl
+ u_t010_002/c2_w0_bl u_t010_002/c2_w0_br u_t010_002/c2_w1_bl u_t010_002/c2_w1_br
+ u_t010_002/c2_r0_rbl u_t010_002/c2_r1_rbl u_t010_002/c3_w0_bl u_t010_002/c3_w0_br
+ u_t010_002/c3_w1_bl u_t010_002/c3_w1_br u_t010_002/c3_r0_rbl u_t010_002/c3_r1_rbl
+ u_t010_002/r0_w0_wl u_t010_002/r0_w1_wl u_t010_002/r0_r0_rwl u_t010_002/r0_r1_rwl
+ u_t010_002/r1_w0_wl u_t010_002/r1_w1_wl u_t010_002/r1_r0_rwl u_t010_002/r1_r1_rwl
+ u_t010_002/r2_w0_wl u_t010_002/r2_w1_wl u_t010_002/r2_r0_rwl u_t010_002/r2_r1_rwl
+ u_t010_002/r3_w0_wl u_t010_002/r3_w1_wl u_t010_002/r3_r0_rwl u_t010_002/r3_r1_rwl
+ VSS VSS u_t010_002/m2_717_1265# u_t010_002/m2_603_2031# u_t010_002/m2_1290_336#
+ u_t010_002/m2_2000_2037# u_t010_002/m2_791_2909# u_t010_002/m2_7_2126# u_t010_002/m2_2154_2081#
+ u_t010_002/m2_1795_2037# u_t010_002/m2_871_303# u_t010_002/m2_431_438# u_t010_002/m2_1290_2898#
+ u_t010_002/m2_1714_1210# u_t010_002/m2_431_1982# u_t010_002/m2_512_1265# u_t010_002/m2_2573_2126#
+ u_t010_002/m2_603_1259# u_t010_002/m2_2074_2909# u_t010_002/m2_7_336# u_t010_002/m2_717_2037#
+ u_t010_002/m2_1886_2031# u_t010_002/m2_2573_336# u_t010_002/m2_7_2898# u_t010_002/m2_2000_1265#
+ u_t010_002/m2_512_2037# u_t010_002/m2_1795_1265# u_t010_002/m2_1714_1982# u_t010_002/m2_1886_1259#
+ u_t010_002/m2_1290_2126# u_t010_002/m2_1714_438# u_t010_002/m2_431_1210# u_t010_002/m2_2573_2898#
+ u_t010_002/m2_2154_303# u_t010_002/m2_871_2081# VSUBS detronyx_12t_2w2r_rc4_4x4_routed_5layer_direct
Xu_t001_013 u_t001_013/c0_w0_bl u_t001_013/c0_w0_br u_t001_013/c0_w1_bl u_t001_013/c0_w1_br
+ u_t001_013/c0_r0_rbl u_t001_013/c0_r1_rbl u_t001_013/c1_w0_bl u_t001_013/c1_w0_br
+ u_t001_013/c1_w1_bl u_t001_013/c1_w1_br u_t001_013/c1_r0_rbl u_t001_013/c1_r1_rbl
+ u_t001_013/c2_w0_bl u_t001_013/c2_w0_br u_t001_013/c2_w1_bl u_t001_013/c2_w1_br
+ u_t001_013/c2_r0_rbl u_t001_013/c2_r1_rbl u_t001_013/c3_w0_bl u_t001_013/c3_w0_br
+ u_t001_013/c3_w1_bl u_t001_013/c3_w1_br u_t001_013/c3_r0_rbl u_t001_013/c3_r1_rbl
+ u_t001_013/r0_w0_wl u_t001_013/r0_w1_wl u_t001_013/r0_r0_rwl u_t001_013/r0_r1_rwl
+ u_t001_013/r1_w0_wl u_t001_013/r1_w1_wl u_t001_013/r1_r0_rwl u_t001_013/r1_r1_rwl
+ u_t001_013/r2_w0_wl u_t001_013/r2_w1_wl u_t001_013/r2_r0_rwl u_t001_013/r2_r1_rwl
+ u_t001_013/r3_w0_wl u_t001_013/r3_w1_wl u_t001_013/r3_r0_rwl u_t001_013/r3_r1_rwl
+ u_t001_013/VDD VSS u_t001_013/m2_717_1265# u_t001_013/m2_603_2031# u_t001_013/m2_1290_336#
+ u_t001_013/m2_2000_2037# u_t001_013/m2_791_2909# u_t001_013/m2_7_2126# u_t001_013/m2_2154_2081#
+ u_t001_013/m2_1795_2037# u_t001_013/m2_871_303# u_t001_013/m2_431_438# u_t001_013/m2_1290_2898#
+ u_t001_013/m2_1714_1210# u_t001_013/m2_431_1982# u_t001_013/m2_512_1265# u_t001_013/m2_2573_2126#
+ u_t001_013/m2_603_1259# u_t001_013/m2_2074_2909# u_t001_013/m2_7_336# u_t001_013/m2_717_2037#
+ u_t001_013/m2_1886_2031# u_t001_013/m2_2573_336# u_t001_013/m2_7_2898# u_t001_013/m2_2000_1265#
+ u_t001_013/m2_512_2037# u_t001_013/m2_1795_1265# u_t001_013/m2_1714_1982# u_t001_013/m2_1886_1259#
+ u_t001_013/m2_1290_2126# u_t001_013/m2_1714_438# u_t001_013/m2_431_1210# u_t001_013/m2_2573_2898#
+ u_t001_013/m2_2154_303# u_t001_013/m2_871_2081# VSUBS detronyx_12t_2w2r_rc4_4x4_routed_5layer_direct
Xu_t001_002 u_t001_002/c0_w0_bl u_t001_002/c0_w0_br u_t001_002/c0_w1_bl u_t001_002/c0_w1_br
+ u_t001_002/c0_r0_rbl u_t001_002/c0_r1_rbl u_t001_002/c1_w0_bl u_t001_002/c1_w0_br
+ u_t001_002/c1_w1_bl u_t001_002/c1_w1_br u_t001_002/c1_r0_rbl u_t001_002/c1_r1_rbl
+ u_t001_002/c2_w0_bl u_t001_002/c2_w0_br u_t001_002/c2_w1_bl u_t001_002/c2_w1_br
+ u_t001_002/c2_r0_rbl u_t001_002/c2_r1_rbl u_t001_002/c3_w0_bl u_t001_002/c3_w0_br
+ u_t001_002/c3_w1_bl u_t001_002/c3_w1_br u_t001_002/c3_r0_rbl u_t001_002/c3_r1_rbl
+ u_t001_002/r0_w0_wl u_t001_002/r0_w1_wl u_t001_002/r0_r0_rwl u_t001_002/r0_r1_rwl
+ u_t001_002/r1_w0_wl u_t001_002/r1_w1_wl u_t001_002/r1_r0_rwl u_t001_002/r1_r1_rwl
+ u_t001_002/r2_w0_wl u_t001_002/r2_w1_wl u_t001_002/r2_r0_rwl u_t001_002/r2_r1_rwl
+ u_t001_002/r3_w0_wl u_t001_002/r3_w1_wl u_t001_002/r3_r0_rwl u_t001_002/r3_r1_rwl
+ VSS VSS u_t001_002/m2_717_1265# u_t001_002/m2_603_2031# u_t001_002/m2_1290_336#
+ u_t001_002/m2_2000_2037# u_t001_002/m2_791_2909# u_t001_002/m2_7_2126# u_t001_002/m2_2154_2081#
+ u_t001_002/m2_1795_2037# u_t001_002/m2_871_303# u_t001_002/m2_431_438# u_t001_002/m2_1290_2898#
+ u_t001_002/m2_1714_1210# u_t001_002/m2_431_1982# u_t001_002/m2_512_1265# u_t001_002/m2_2573_2126#
+ u_t001_002/m2_603_1259# u_t001_002/m2_2074_2909# u_t001_002/m2_7_336# u_t001_002/m2_717_2037#
+ u_t001_002/m2_1886_2031# u_t001_002/m2_2573_336# u_t001_002/m2_7_2898# u_t001_002/m2_2000_1265#
+ u_t001_002/m2_512_2037# u_t001_002/m2_1795_1265# u_t001_002/m2_1714_1982# u_t001_002/m2_1886_1259#
+ u_t001_002/m2_1290_2126# u_t001_002/m2_1714_438# u_t001_002/m2_431_1210# u_t001_002/m2_2573_2898#
+ u_t001_002/m2_2154_303# u_t001_002/m2_871_2081# VSUBS detronyx_12t_2w2r_rc4_4x4_routed_5layer_direct
Xgf180mcu_as_sc_mcu7t3v3__inv_2_1704 gf180mcu_as_sc_mcu7t3v3__nand3_2_9/VDD gf180mcu_as_sc_mcu7t3v3__nor2_2_4/VSS
+ VSS VSS gf180mcu_as_sc_mcu7t3v3__nand3_2_9/VNW VSUBS gf180mcu_as_sc_mcu7t3v3__inv_2
Xgf180mcu_as_sc_mcu7t3v3__inv_2_282 VSS gf180mcu_as_sc_mcu7t3v3__inv_2_304/VDD VSS
+ gf180mcu_as_sc_mcu7t3v3__inv_2_304/A gf180mcu_as_sc_mcu7t3v3__inv_2_288/VNW VSUBS
+ gf180mcu_as_sc_mcu7t3v3__inv_2
Xgf180mcu_as_sc_mcu7t3v3__inv_2_271 gf180mcu_as_sc_mcu7t3v3__inv_2_311/VSS gf180mcu_as_sc_mcu7t3v3__inv_2_279/VDD
+ VSS gf180mcu_as_sc_mcu7t3v3__inv_2_365/Y gf180mcu_as_sc_mcu7t3v3__inv_2_274/VNW
+ VSUBS gf180mcu_as_sc_mcu7t3v3__inv_2
Xgf180mcu_as_sc_mcu7t3v3__inv_2_293 gf180mcu_as_sc_mcu7t3v3__inv_2_365/VSS gf180mcu_as_sc_mcu7t3v3__inv_2_307/VDD
+ gf180mcu_as_sc_mcu7t3v3__inv_2_293/Y gf180mcu_as_sc_mcu7t3v3__inv_2_365/Y gf180mcu_as_sc_mcu7t3v3__inv_2_297/VNW
+ VSUBS gf180mcu_as_sc_mcu7t3v3__inv_2
Xgf180mcu_as_sc_mcu7t3v3__inv_2_260 gf180mcu_as_sc_mcu7t3v3__inv_2_260/VDD gf180mcu_as_sc_mcu7t3v3__inv_2_260/VSS
+ gf180mcu_as_sc_mcu7t3v3__inv_2_260/Y VSS gf180mcu_as_sc_mcu7t3v3__inv_2_260/VNW
+ VSUBS gf180mcu_as_sc_mcu7t3v3__inv_2
Xgf180mcu_as_sc_mcu7t3v3__inv_2_1726 gf180mcu_as_sc_mcu7t3v3__inv_2_960/VSS VSS gf180mcu_as_sc_mcu7t3v3__inv_2_1726/Y
+ VSS gf180mcu_as_sc_mcu7t3v3__inv_2_1726/VNW VSUBS gf180mcu_as_sc_mcu7t3v3__inv_2
Xgf180mcu_as_sc_mcu7t3v3__inv_2_1715 gf180mcu_as_sc_mcu7t3v3__inv_2_1717/VDD VSS VSS
+ gf180mcu_as_sc_mcu7t3v3__inv_2_1717/Y gf180mcu_as_sc_mcu7t3v3__inv_2_1717/VNW VSUBS
+ gf180mcu_as_sc_mcu7t3v3__inv_2
Xgf180mcu_as_sc_mcu7t3v3__nand4_2_509 gf180mcu_as_sc_mcu7t3v3__inv_2_1685/VDD VSS
+ VSS VSS VSS VSS VSS gf180mcu_as_sc_mcu7t3v3__inv_2_1685/VNW VSUBS gf180mcu_as_sc_mcu7t3v3__nand4_2
Xgf180mcu_as_sc_mcu7t3v3__inv_2_19 gf180mcu_as_sc_mcu7t3v3__inv_2_20/VDD gf180mcu_as_sc_mcu7t3v3__inv_2_24/VDD
+ gf180mcu_as_sc_mcu7t3v3__inv_2_19/Y gf180mcu_as_sc_mcu7t3v3__inv_2_24/Y gf180mcu_as_sc_mcu7t3v3__inv_2_20/VNW
+ VSUBS gf180mcu_as_sc_mcu7t3v3__inv_2
Xgf180mcu_as_sc_mcu7t3v3__inv_2_1567 VSS gf180mcu_as_sc_mcu7t3v3__inv_2_1588/VSS VSS
+ VSS gf180mcu_as_sc_mcu7t3v3__inv_2_1588/VNW VSUBS gf180mcu_as_sc_mcu7t3v3__inv_2
Xgf180mcu_as_sc_mcu7t3v3__inv_2_1578 VSS gf180mcu_as_sc_mcu7t3v3__inv_2_1582/VDD gf180mcu_as_sc_mcu7t3v3__inv_2_1578/Y
+ VSS gf180mcu_as_sc_mcu7t3v3__inv_2_1579/VNW VSUBS gf180mcu_as_sc_mcu7t3v3__inv_2
Xgf180mcu_as_sc_mcu7t3v3__inv_2_1545 gf180mcu_as_sc_mcu7t3v3__inv_2_1547/VDD VSS VSS
+ VSS gf180mcu_as_sc_mcu7t3v3__inv_2_1547/VNW VSUBS gf180mcu_as_sc_mcu7t3v3__inv_2
Xgf180mcu_as_sc_mcu7t3v3__inv_2_1556 gf180mcu_as_sc_mcu7t3v3__inv_2_1556/VDD VSS VSS
+ VSS gf180mcu_as_sc_mcu7t3v3__inv_2_1556/VNW VSUBS gf180mcu_as_sc_mcu7t3v3__inv_2
Xgf180mcu_as_sc_mcu7t3v3__inv_2_1512 VSS VSS VSS VSS gf180mcu_as_sc_mcu7t3v3__inv_2_1514/VNW
+ VSUBS gf180mcu_as_sc_mcu7t3v3__inv_2
Xgf180mcu_as_sc_mcu7t3v3__inv_2_1523 gf180mcu_as_sc_mcu7t3v3__inv_2_1523/VDD VSS gf180mcu_as_sc_mcu7t3v3__inv_2_1523/Y
+ VSS gf180mcu_as_sc_mcu7t3v3__inv_2_1523/VNW VSUBS gf180mcu_as_sc_mcu7t3v3__inv_2
Xgf180mcu_as_sc_mcu7t3v3__inv_2_1534 VSS VSS VSS VSS gf180mcu_as_sc_mcu7t3v3__inv_2_1535/VNW
+ VSUBS gf180mcu_as_sc_mcu7t3v3__inv_2
Xgf180mcu_as_sc_mcu7t3v3__inv_2_1501 gf180mcu_as_sc_mcu7t3v3__inv_2_1503/VDD VSS VSS
+ VSS gf180mcu_as_sc_mcu7t3v3__inv_2_1503/VNW VSUBS gf180mcu_as_sc_mcu7t3v3__inv_2
Xgf180mcu_as_sc_mcu7t3v3__inv_2_1589 gf180mcu_as_sc_mcu7t3v3__inv_2_1591/VDD gf180mcu_as_sc_mcu7t3v3__inv_2_1594/VDD
+ VSS VSS gf180mcu_as_sc_mcu7t3v3__inv_2_1591/VNW VSUBS gf180mcu_as_sc_mcu7t3v3__inv_2
Xgf180mcu_as_sc_mcu7t3v3__nand4_2_339 gf180mcu_as_sc_mcu7t3v3__inv_2_1142/VDD VSS
+ VSS VSS VSS VSS VSS gf180mcu_as_sc_mcu7t3v3__inv_2_1142/VNW VSUBS gf180mcu_as_sc_mcu7t3v3__nand4_2
Xgf180mcu_as_sc_mcu7t3v3__nand4_2_328 VSS VSS VSS VSS VSS VSS VSS gf180mcu_as_sc_mcu7t3v3__inv_2_1107/VNW
+ VSUBS gf180mcu_as_sc_mcu7t3v3__nand4_2
Xgf180mcu_as_sc_mcu7t3v3__nand4_2_317 VSS gf180mcu_as_sc_mcu7t3v3__inv_2_1053/VDD
+ VSS VSS VSS VSS VSS gf180mcu_as_sc_mcu7t3v3__inv_2_1037/VNW VSUBS gf180mcu_as_sc_mcu7t3v3__nand4_2
Xgf180mcu_as_sc_mcu7t3v3__nand4_2_306 gf180mcu_as_sc_mcu7t3v3__inv_2_1048/VDD gf180mcu_as_sc_mcu7t3v3__inv_2_1052/VDD
+ VSS VSS VSS VSS VSS gf180mcu_as_sc_mcu7t3v3__inv_2_1048/VNW VSUBS gf180mcu_as_sc_mcu7t3v3__nand4_2
Xgf180mcu_as_sc_mcu7t3v3__nand2_2_0 gf180mcu_as_sc_mcu7t3v3__nor2_2_4/VDD gf180mcu_as_sc_mcu7t3v3__nand2_2_3/VSS
+ VSS VSS VSS gf180mcu_as_sc_mcu7t3v3__nor2_2_4/VNW VSUBS gf180mcu_as_sc_mcu7t3v3__nand2_2
Xu_t029_005 u_t029_005/c0_w0_bl u_t029_005/c0_w0_br u_t029_005/c0_w1_bl u_t029_005/c0_w1_br
+ u_t029_005/c0_r0_rbl u_t029_005/c0_r1_rbl u_t029_005/c1_w0_bl u_t029_005/c1_w0_br
+ u_t029_005/c1_w1_bl u_t029_005/c1_w1_br u_t029_005/c1_r0_rbl u_t029_005/c1_r1_rbl
+ u_t029_005/c2_w0_bl u_t029_005/c2_w0_br u_t029_005/c2_w1_bl u_t029_005/c2_w1_br
+ u_t029_005/c2_r0_rbl u_t029_005/c2_r1_rbl u_t029_005/c3_w0_bl u_t029_005/c3_w0_br
+ u_t029_005/c3_w1_bl u_t029_005/c3_w1_br u_t029_005/c3_r0_rbl u_t029_005/c3_r1_rbl
+ u_t029_005/r0_w0_wl u_t029_005/r0_w1_wl u_t029_005/r0_r0_rwl u_t029_005/r0_r1_rwl
+ u_t029_005/r1_w0_wl u_t029_005/r1_w1_wl u_t029_005/r1_r0_rwl u_t029_005/r1_r1_rwl
+ u_t029_005/r2_w0_wl u_t029_005/r2_w1_wl u_t029_005/r2_r0_rwl u_t029_005/r2_r1_rwl
+ u_t029_005/r3_w0_wl u_t029_005/r3_w1_wl u_t029_005/r3_r0_rwl u_t029_005/r3_r1_rwl
+ u_t029_005/VDD VSS u_t029_005/m2_717_1265# u_t029_005/m2_603_2031# u_t029_005/m2_1290_336#
+ u_t029_005/m2_2000_2037# u_t029_005/m2_791_2909# u_t029_005/m2_7_2126# u_t029_005/m2_2154_2081#
+ u_t029_005/m2_1795_2037# u_t029_005/m2_871_303# u_t029_005/m2_431_438# u_t029_005/m2_1290_2898#
+ u_t029_005/m2_1714_1210# u_t029_005/m2_431_1982# u_t029_005/m2_512_1265# u_t029_005/m2_2573_2126#
+ u_t029_005/m2_603_1259# u_t029_005/m2_2074_2909# u_t029_005/m2_7_336# u_t029_005/m2_717_2037#
+ u_t029_005/m2_1886_2031# u_t029_005/m2_2573_336# u_t029_005/m2_7_2898# u_t029_005/m2_2000_1265#
+ u_t029_005/m2_512_2037# u_t029_005/m2_1795_1265# u_t029_005/m2_1714_1982# u_t029_005/m2_1886_1259#
+ u_t029_005/m2_1290_2126# u_t029_005/m2_1714_438# u_t029_005/m2_431_1210# u_t029_005/m2_2573_2898#
+ u_t029_005/m2_2154_303# u_t029_005/m2_871_2081# VSUBS detronyx_12t_2w2r_rc4_4x4_routed_5layer_direct
Xgf180mcu_as_sc_mcu7t3v3__inv_2_1364 gf180mcu_as_sc_mcu7t3v3__inv_2_1366/VDD gf180mcu_as_sc_mcu7t3v3__inv_2_1370/VDD
+ VSS gf180mcu_as_sc_mcu7t3v3__inv_2_1694/Y gf180mcu_as_sc_mcu7t3v3__inv_2_1366/VNW
+ VSUBS gf180mcu_as_sc_mcu7t3v3__inv_2
Xgf180mcu_as_sc_mcu7t3v3__inv_2_1386 VSS VSS gf180mcu_as_sc_mcu7t3v3__inv_2_1394/Y
+ VSS gf180mcu_as_sc_mcu7t3v3__inv_2_1386/VNW VSUBS gf180mcu_as_sc_mcu7t3v3__inv_2
Xgf180mcu_as_sc_mcu7t3v3__inv_2_1397 VSS VSS gf180mcu_as_sc_mcu7t3v3__inv_2_1409/A
+ gf180mcu_as_sc_mcu7t3v3__inv_2_1409/A gf180mcu_as_sc_mcu7t3v3__inv_2_1398/VNW VSUBS
+ gf180mcu_as_sc_mcu7t3v3__inv_2
Xgf180mcu_as_sc_mcu7t3v3__inv_2_1375 VSS gf180mcu_as_sc_mcu7t3v3__inv_2_1391/VDD gf180mcu_as_sc_mcu7t3v3__inv_2_1409/A
+ VSS gf180mcu_as_sc_mcu7t3v3__inv_2_1375/VNW VSUBS gf180mcu_as_sc_mcu7t3v3__inv_2
Xgf180mcu_as_sc_mcu7t3v3__inv_2_1353 VSS VSS gf180mcu_as_sc_mcu7t3v3__inv_2_1717/Y
+ gf180mcu_as_sc_mcu7t3v3__inv_2_1717/Y gf180mcu_as_sc_mcu7t3v3__inv_2_1353/VNW VSUBS
+ gf180mcu_as_sc_mcu7t3v3__inv_2
Xgf180mcu_as_sc_mcu7t3v3__inv_2_1320 gf180mcu_as_sc_mcu7t3v3__inv_2_1320/VDD VSS gf180mcu_as_sc_mcu7t3v3__inv_2_1355/Y
+ VSS gf180mcu_as_sc_mcu7t3v3__inv_2_1320/VNW VSUBS gf180mcu_as_sc_mcu7t3v3__inv_2
Xgf180mcu_as_sc_mcu7t3v3__inv_2_1342 VSS VSS VSS gf180mcu_as_sc_mcu7t3v3__inv_2_1355/Y
+ gf180mcu_as_sc_mcu7t3v3__inv_2_1344/VNW VSUBS gf180mcu_as_sc_mcu7t3v3__inv_2
Xgf180mcu_as_sc_mcu7t3v3__inv_2_1331 VSS VSS gf180mcu_as_sc_mcu7t3v3__inv_2_1340/Y
+ gf180mcu_as_sc_mcu7t3v3__inv_2_1340/Y gf180mcu_as_sc_mcu7t3v3__inv_2_1332/VNW VSUBS
+ gf180mcu_as_sc_mcu7t3v3__inv_2
Xgf180mcu_as_sc_mcu7t3v3__inv_2_826 VSS VSS VSS VSS gf180mcu_as_sc_mcu7t3v3__inv_2_826/VNW
+ VSUBS gf180mcu_as_sc_mcu7t3v3__inv_2
Xgf180mcu_as_sc_mcu7t3v3__inv_2_815 VSS VSS VSS VSS gf180mcu_as_sc_mcu7t3v3__inv_2_815/VNW
+ VSUBS gf180mcu_as_sc_mcu7t3v3__inv_2
Xgf180mcu_as_sc_mcu7t3v3__inv_2_804 VSS VSS VSS VSS gf180mcu_as_sc_mcu7t3v3__inv_2_850/VNW
+ VSUBS gf180mcu_as_sc_mcu7t3v3__inv_2
Xgf180mcu_as_sc_mcu7t3v3__inv_2_848 VSS VSS VSS VSS gf180mcu_as_sc_mcu7t3v3__inv_2_848/VNW
+ VSUBS gf180mcu_as_sc_mcu7t3v3__inv_2
Xgf180mcu_as_sc_mcu7t3v3__inv_2_837 VSS VSS VSS VSS gf180mcu_as_sc_mcu7t3v3__inv_2_837/VNW
+ VSUBS gf180mcu_as_sc_mcu7t3v3__inv_2
Xgf180mcu_as_sc_mcu7t3v3__inv_2_859 VSS VSS VSS VSS gf180mcu_as_sc_mcu7t3v3__inv_2_942/VNW
+ VSUBS gf180mcu_as_sc_mcu7t3v3__inv_2
Xu_t026_008 u_t026_008/c0_w0_bl u_t026_008/c0_w0_br u_t026_008/c0_w1_bl u_t026_008/c0_w1_br
+ u_t026_008/c0_r0_rbl u_t026_008/c0_r1_rbl u_t026_008/c1_w0_bl u_t026_008/c1_w0_br
+ u_t026_008/c1_w1_bl u_t026_008/c1_w1_br u_t026_008/c1_r0_rbl u_t026_008/c1_r1_rbl
+ u_t026_008/c2_w0_bl u_t026_008/c2_w0_br u_t026_008/c2_w1_bl u_t026_008/c2_w1_br
+ u_t026_008/c2_r0_rbl u_t026_008/c2_r1_rbl u_t026_008/c3_w0_bl u_t026_008/c3_w0_br
+ u_t026_008/c3_w1_bl u_t026_008/c3_w1_br u_t026_008/c3_r0_rbl u_t026_008/c3_r1_rbl
+ u_t026_008/r0_w0_wl u_t026_008/r0_w1_wl u_t026_008/r0_r0_rwl u_t026_008/r0_r1_rwl
+ u_t026_008/r1_w0_wl u_t026_008/r1_w1_wl u_t026_008/r1_r0_rwl u_t026_008/r1_r1_rwl
+ u_t026_008/r2_w0_wl u_t026_008/r2_w1_wl u_t026_008/r2_r0_rwl u_t026_008/r2_r1_rwl
+ u_t026_008/r3_w0_wl u_t026_008/r3_w1_wl u_t026_008/r3_r0_rwl u_t026_008/r3_r1_rwl
+ VSS VSS u_t026_008/m2_717_1265# u_t026_008/m2_603_2031# u_t026_008/m2_1290_336#
+ u_t026_008/m2_2000_2037# u_t026_008/m2_791_2909# u_t026_008/m2_7_2126# u_t026_008/m2_2154_2081#
+ u_t026_008/m2_1795_2037# u_t026_008/m2_871_303# u_t026_008/m2_431_438# u_t026_008/m2_1290_2898#
+ u_t026_008/m2_1714_1210# u_t026_008/m2_431_1982# u_t026_008/m2_512_1265# u_t026_008/m2_2573_2126#
+ u_t026_008/m2_603_1259# u_t026_008/m2_2074_2909# u_t026_008/m2_7_336# u_t026_008/m2_717_2037#
+ u_t026_008/m2_1886_2031# u_t026_008/m2_2573_336# u_t026_008/m2_7_2898# u_t026_008/m2_2000_1265#
+ u_t026_008/m2_512_2037# u_t026_008/m2_1795_1265# u_t026_008/m2_1714_1982# u_t026_008/m2_1886_1259#
+ u_t026_008/m2_1290_2126# u_t026_008/m2_1714_438# u_t026_008/m2_431_1210# u_t026_008/m2_2573_2898#
+ u_t026_008/m2_2154_303# u_t026_008/m2_871_2081# VSUBS detronyx_12t_2w2r_rc4_4x4_routed_5layer_direct
Xgf180mcu_as_sc_mcu7t3v3__nand4_2_125 VSS VSS VSS VSS VSS VSS gf180mcu_as_sc_mcu7t3v3__nand4_2_125/Y
+ gf180mcu_as_sc_mcu7t3v3__inv_2_543/VNW VSUBS gf180mcu_as_sc_mcu7t3v3__nand4_2
Xgf180mcu_as_sc_mcu7t3v3__nand4_2_158 gf180mcu_as_sc_mcu7t3v3__inv_2_576/VDD gf180mcu_as_sc_mcu7t3v3__inv_2_576/VDD
+ VSS VSS VSS VSS VSS gf180mcu_as_sc_mcu7t3v3__inv_2_573/VNW VSUBS gf180mcu_as_sc_mcu7t3v3__nand4_2
Xgf180mcu_as_sc_mcu7t3v3__nand4_2_136 VSS VSS VSS VSS VSS VSS gf180mcu_as_sc_mcu7t3v3__nand4_2_136/Y
+ gf180mcu_as_sc_mcu7t3v3__inv_2_554/VNW VSUBS gf180mcu_as_sc_mcu7t3v3__nand4_2
Xgf180mcu_as_sc_mcu7t3v3__nand4_2_20 VSS gf180mcu_as_sc_mcu7t3v3__inv_2_143/VDD VSS
+ VSS VSS VSS VSS gf180mcu_as_sc_mcu7t3v3__inv_2_140/VNW VSUBS gf180mcu_as_sc_mcu7t3v3__nand4_2
Xgf180mcu_as_sc_mcu7t3v3__nand4_2_169 gf180mcu_as_sc_mcu7t3v3__inv_2_638/VSS gf180mcu_as_sc_mcu7t3v3__inv_2_602/VDD
+ VSS VSS VSS VSS VSS gf180mcu_as_sc_mcu7t3v3__inv_2_598/VNW VSUBS gf180mcu_as_sc_mcu7t3v3__nand4_2
Xgf180mcu_as_sc_mcu7t3v3__nand4_2_147 VSS VSS VSS VSS VSS VSS gf180mcu_as_sc_mcu7t3v3__nand4_2_147/Y
+ gf180mcu_as_sc_mcu7t3v3__inv_2_552/VNW VSUBS gf180mcu_as_sc_mcu7t3v3__nand4_2
Xgf180mcu_as_sc_mcu7t3v3__nand4_2_31 VSS VSS VSS VSS VSS VSS VSS gf180mcu_as_sc_mcu7t3v3__inv_2_174/VNW
+ VSUBS gf180mcu_as_sc_mcu7t3v3__nand4_2
Xgf180mcu_as_sc_mcu7t3v3__nand4_2_114 gf180mcu_as_sc_mcu7t3v3__inv_2_279/VDD VSS VSS
+ VSS VSS VSS VSS gf180mcu_as_sc_mcu7t3v3__inv_2_279/VNW VSUBS gf180mcu_as_sc_mcu7t3v3__nand4_2
Xgf180mcu_as_sc_mcu7t3v3__nand4_2_42 gf180mcu_as_sc_mcu7t3v3__inv_2_260/VSS gf180mcu_as_sc_mcu7t3v3__inv_2_206/VSS
+ VSS VSS VSS VSS gf180mcu_as_sc_mcu7t3v3__nand4_2_42/Y gf180mcu_as_sc_mcu7t3v3__inv_2_206/VNW
+ VSUBS gf180mcu_as_sc_mcu7t3v3__nand4_2
Xgf180mcu_as_sc_mcu7t3v3__nand4_2_103 gf180mcu_as_sc_mcu7t3v3__inv_2_365/VDD gf180mcu_as_sc_mcu7t3v3__inv_2_365/VDD
+ VSS VSS VSS VSS VSS gf180mcu_as_sc_mcu7t3v3__inv_2_362/VNW VSUBS gf180mcu_as_sc_mcu7t3v3__nand4_2
Xgf180mcu_as_sc_mcu7t3v3__nand4_2_53 gf180mcu_as_sc_mcu7t3v3__inv_2_239/VDD gf180mcu_as_sc_mcu7t3v3__inv_2_242/VDD
+ VSS VSS VSS VSS gf180mcu_as_sc_mcu7t3v3__nand4_2_53/Y gf180mcu_as_sc_mcu7t3v3__inv_2_239/VNW
+ VSUBS gf180mcu_as_sc_mcu7t3v3__nand4_2
Xgf180mcu_as_sc_mcu7t3v3__nand4_2_64 gf180mcu_as_sc_mcu7t3v3__inv_2_8/VSS gf180mcu_as_sc_mcu7t3v3__inv_2_8/VSS
+ VSS VSS VSS VSS VSS gf180mcu_as_sc_mcu7t3v3__inv_2_12/VNW VSUBS gf180mcu_as_sc_mcu7t3v3__nand4_2
Xgf180mcu_as_sc_mcu7t3v3__nand4_2_86 gf180mcu_as_sc_mcu7t3v3__inv_2_9/VDD gf180mcu_as_sc_mcu7t3v3__inv_2_9/VDD
+ VSS VSS VSS VSS VSS gf180mcu_as_sc_mcu7t3v3__inv_2_77/VNW VSUBS gf180mcu_as_sc_mcu7t3v3__nand4_2
Xgf180mcu_as_sc_mcu7t3v3__nand4_2_97 VSS VSS VSS VSS VSS VSS VSS gf180mcu_as_sc_mcu7t3v3__inv_2_344/VNW
+ VSUBS gf180mcu_as_sc_mcu7t3v3__nand4_2
Xgf180mcu_as_sc_mcu7t3v3__nand4_2_75 gf180mcu_as_sc_mcu7t3v3__inv_2_329/VDD gf180mcu_as_sc_mcu7t3v3__inv_2_332/VDD
+ VSS VSS VSS VSS VSS gf180mcu_as_sc_mcu7t3v3__inv_2_329/VNW VSUBS gf180mcu_as_sc_mcu7t3v3__nand4_2
Xu_t017_008 u_t017_008/c0_w0_bl u_t017_008/c0_w0_br u_t017_008/c0_w1_bl u_t017_008/c0_w1_br
+ u_t017_008/c0_r0_rbl u_t017_008/c0_r1_rbl u_t017_008/c1_w0_bl u_t017_008/c1_w0_br
+ u_t017_008/c1_w1_bl u_t017_008/c1_w1_br u_t017_008/c1_r0_rbl u_t017_008/c1_r1_rbl
+ u_t017_008/c2_w0_bl u_t017_008/c2_w0_br u_t017_008/c2_w1_bl u_t017_008/c2_w1_br
+ u_t017_008/c2_r0_rbl u_t017_008/c2_r1_rbl u_t017_008/c3_w0_bl u_t017_008/c3_w0_br
+ u_t017_008/c3_w1_bl u_t017_008/c3_w1_br u_t017_008/c3_r0_rbl u_t017_008/c3_r1_rbl
+ u_t017_008/r0_w0_wl u_t017_008/r0_w1_wl u_t017_008/r0_r0_rwl u_t017_008/r0_r1_rwl
+ u_t017_008/r1_w0_wl u_t017_008/r1_w1_wl u_t017_008/r1_r0_rwl u_t017_008/r1_r1_rwl
+ u_t017_008/r2_w0_wl u_t017_008/r2_w1_wl u_t017_008/r2_r0_rwl u_t017_008/r2_r1_rwl
+ u_t017_008/r3_w0_wl u_t017_008/r3_w1_wl u_t017_008/r3_r0_rwl u_t017_008/r3_r1_rwl
+ VSS VSS u_t017_008/m2_717_1265# u_t017_008/m2_603_2031# u_t017_008/m2_1290_336#
+ u_t017_008/m2_2000_2037# u_t017_008/m2_791_2909# u_t017_008/m2_7_2126# u_t017_008/m2_2154_2081#
+ u_t017_008/m2_1795_2037# u_t017_008/m2_871_303# u_t017_008/m2_431_438# u_t017_008/m2_1290_2898#
+ u_t017_008/m2_1714_1210# u_t017_008/m2_431_1982# u_t017_008/m2_512_1265# u_t017_008/m2_2573_2126#
+ u_t017_008/m2_603_1259# u_t017_008/m2_2074_2909# u_t017_008/m2_7_336# u_t017_008/m2_717_2037#
+ u_t017_008/m2_1886_2031# u_t017_008/m2_2573_336# u_t017_008/m2_7_2898# u_t017_008/m2_2000_1265#
+ u_t017_008/m2_512_2037# u_t017_008/m2_1795_1265# u_t017_008/m2_1714_1982# u_t017_008/m2_1886_1259#
+ u_t017_008/m2_1290_2126# u_t017_008/m2_1714_438# u_t017_008/m2_431_1210# u_t017_008/m2_2573_2898#
+ u_t017_008/m2_2154_303# u_t017_008/m2_871_2081# VSUBS detronyx_12t_2w2r_rc4_4x4_routed_5layer_direct
Xgf180mcu_as_sc_mcu7t3v3__inv_2_1194 gf180mcu_as_sc_mcu7t3v3__nor2_2_9/VDD gf180mcu_as_sc_mcu7t3v3__nor2_2_9/VSS
+ VSS VSS gf180mcu_as_sc_mcu7t3v3__nor2_2_9/VNW VSUBS gf180mcu_as_sc_mcu7t3v3__inv_2
Xgf180mcu_as_sc_mcu7t3v3__inv_2_1150 VSS VSS gf180mcu_as_sc_mcu7t3v3__inv_2_1150/Y
+ gf180mcu_as_sc_mcu7t3v3__inv_2_1151/Y gf180mcu_as_sc_mcu7t3v3__inv_2_1151/VNW VSUBS
+ gf180mcu_as_sc_mcu7t3v3__inv_2
Xgf180mcu_as_sc_mcu7t3v3__inv_2_1161 VSS VSS VSS VSS gf180mcu_as_sc_mcu7t3v3__inv_2_1292/VNW
+ VSUBS gf180mcu_as_sc_mcu7t3v3__inv_2
Xgf180mcu_as_sc_mcu7t3v3__inv_2_1172 VSS VSS gf180mcu_as_sc_mcu7t3v3__inv_2_1172/Y
+ VSS gf180mcu_as_sc_mcu7t3v3__inv_2_1294/VNW VSUBS gf180mcu_as_sc_mcu7t3v3__inv_2
Xgf180mcu_as_sc_mcu7t3v3__inv_2_1183 VSS VSS gf180mcu_as_sc_mcu7t3v3__inv_2_1183/Y
+ VSS gf180mcu_as_sc_mcu7t3v3__inv_2_1300/VNW VSUBS gf180mcu_as_sc_mcu7t3v3__inv_2
Xu_t008_008 u_t008_008/c0_w0_bl u_t008_008/c0_w0_br u_t008_008/c0_w1_bl u_t008_008/c0_w1_br
+ u_t008_008/c0_r0_rbl u_t008_008/c0_r1_rbl u_t008_008/c1_w0_bl u_t008_008/c1_w0_br
+ u_t008_008/c1_w1_bl u_t008_008/c1_w1_br u_t008_008/c1_r0_rbl u_t008_008/c1_r1_rbl
+ u_t008_008/c2_w0_bl u_t008_008/c2_w0_br u_t008_008/c2_w1_bl u_t008_008/c2_w1_br
+ u_t008_008/c2_r0_rbl u_t008_008/c2_r1_rbl u_t008_008/c3_w0_bl u_t008_008/c3_w0_br
+ u_t008_008/c3_w1_bl u_t008_008/c3_w1_br u_t008_008/c3_r0_rbl u_t008_008/c3_r1_rbl
+ u_t008_008/r0_w0_wl u_t008_008/r0_w1_wl u_t008_008/r0_r0_rwl u_t008_008/r0_r1_rwl
+ u_t008_008/r1_w0_wl u_t008_008/r1_w1_wl u_t008_008/r1_r0_rwl u_t008_008/r1_r1_rwl
+ u_t008_008/r2_w0_wl u_t008_008/r2_w1_wl u_t008_008/r2_r0_rwl u_t008_008/r2_r1_rwl
+ u_t008_008/r3_w0_wl u_t008_008/r3_w1_wl u_t008_008/r3_r0_rwl u_t008_008/r3_r1_rwl
+ VSS VSS u_t008_008/m2_717_1265# u_t008_008/m2_603_2031# u_t008_008/m2_1290_336#
+ u_t008_008/m2_2000_2037# u_t008_008/m2_791_2909# u_t008_008/m2_7_2126# u_t008_008/m2_2154_2081#
+ u_t008_008/m2_1795_2037# u_t008_008/m2_871_303# u_t008_008/m2_431_438# u_t008_008/m2_1290_2898#
+ u_t008_008/m2_1714_1210# u_t008_008/m2_431_1982# u_t008_008/m2_512_1265# u_t008_008/m2_2573_2126#
+ u_t008_008/m2_603_1259# u_t008_008/m2_2074_2909# u_t008_008/m2_7_336# u_t008_008/m2_717_2037#
+ u_t008_008/m2_1886_2031# u_t008_008/m2_2573_336# u_t008_008/m2_7_2898# u_t008_008/m2_2000_1265#
+ u_t008_008/m2_512_2037# u_t008_008/m2_1795_1265# u_t008_008/m2_1714_1982# u_t008_008/m2_1886_1259#
+ u_t008_008/m2_1290_2126# u_t008_008/m2_1714_438# u_t008_008/m2_431_1210# u_t008_008/m2_2573_2898#
+ u_t008_008/m2_2154_303# u_t008_008/m2_871_2081# VSUBS detronyx_12t_2w2r_rc4_4x4_routed_5layer_direct
Xu_t031_011 u_t031_011/c0_w0_bl u_t031_011/c0_w0_br u_t031_011/c0_w1_bl u_t031_011/c0_w1_br
+ u_t031_011/c0_r0_rbl u_t031_011/c0_r1_rbl u_t031_011/c1_w0_bl u_t031_011/c1_w0_br
+ u_t031_011/c1_w1_bl u_t031_011/c1_w1_br u_t031_011/c1_r0_rbl u_t031_011/c1_r1_rbl
+ u_t031_011/c2_w0_bl u_t031_011/c2_w0_br u_t031_011/c2_w1_bl u_t031_011/c2_w1_br
+ u_t031_011/c2_r0_rbl u_t031_011/c2_r1_rbl u_t031_011/c3_w0_bl u_t031_011/c3_w0_br
+ u_t031_011/c3_w1_bl u_t031_011/c3_w1_br u_t031_011/c3_r0_rbl u_t031_011/c3_r1_rbl
+ u_t031_011/r0_w0_wl u_t031_011/r0_w1_wl u_t031_011/r0_r0_rwl u_t031_011/r0_r1_rwl
+ u_t031_011/r1_w0_wl u_t031_011/r1_w1_wl u_t031_011/r1_r0_rwl u_t031_011/r1_r1_rwl
+ u_t031_011/r2_w0_wl u_t031_011/r2_w1_wl u_t031_011/r2_r0_rwl u_t031_011/r2_r1_rwl
+ u_t031_011/r3_w0_wl u_t031_011/r3_w1_wl u_t031_011/r3_r0_rwl u_t031_011/r3_r1_rwl
+ u_t031_011/VDD u_t031_011/VSS u_t031_011/m2_717_1265# u_t031_011/m2_603_2031# u_t031_011/m2_1290_336#
+ u_t031_011/m2_2000_2037# u_t031_011/m2_791_2909# u_t031_011/m2_7_2126# u_t031_011/m2_2154_2081#
+ u_t031_011/m2_1795_2037# u_t031_011/m2_871_303# u_t031_011/m2_431_438# u_t031_011/m2_1290_2898#
+ u_t031_011/m2_1714_1210# u_t031_011/m2_431_1982# u_t031_011/m2_512_1265# u_t031_011/m2_2573_2126#
+ u_t031_011/m2_603_1259# u_t031_011/m2_2074_2909# u_t031_011/m2_7_336# u_t031_011/m2_717_2037#
+ u_t031_011/m2_1886_2031# u_t031_011/m2_2573_336# u_t031_011/m2_7_2898# u_t031_011/m2_2000_1265#
+ u_t031_011/m2_512_2037# u_t031_011/m2_1795_1265# u_t031_011/m2_1714_1982# u_t031_011/m2_1886_1259#
+ u_t031_011/m2_1290_2126# u_t031_011/m2_1714_438# u_t031_011/m2_431_1210# u_t031_011/m2_2573_2898#
+ u_t031_011/m2_2154_303# u_t031_011/m2_871_2081# VSUBS detronyx_12t_2w2r_rc4_4x4_routed_5layer_direct
Xu_t031_000 VSS u_t031_000/c0_w0_br VSS u_t031_000/c0_w1_br u_t031_000/c0_r0_rbl u_t031_000/c0_r1_rbl
+ VSS VSS VSS VSS VSS VSS u_t031_000/c2_w0_bl u_t031_000/c2_w0_br u_t031_000/c2_w1_bl
+ u_t031_000/c2_w1_br u_t031_000/c2_r0_rbl u_t031_000/c2_r1_rbl u_t031_000/c3_w0_bl
+ u_t031_000/c3_w0_br u_t031_000/c3_w1_bl u_t031_000/c3_w1_br u_t031_000/c3_r0_rbl
+ u_t031_000/c3_r1_rbl VSS VSS VSS VSS VSS VSS VSS VSS VSS VSS VSS VSS VSS VSS VSS
+ VSS VSS VSS u_t031_000/m2_717_1265# VSS VSS VSS VSS u_t031_000/m2_7_2126# VSS VSS
+ VSS VSS VSS VSS VSS u_t031_000/m2_512_1265# VSS u_t031_000/m2_603_1259# VSS VSS
+ VSS VSS VSS VSS u_t031_000/m2_2000_1265# VSS u_t031_000/m2_1795_1265# VSS u_t031_000/m2_1886_1259#
+ u_t031_000/m2_1290_2126# VSS VSS VSS VSS VSS VSUBS detronyx_12t_2w2r_rc4_4x4_routed_5layer_direct
Xgf180mcu_as_sc_mcu7t3v3__inv_2_612 gf180mcu_as_sc_mcu7t3v3__inv_2_617/VDD gf180mcu_as_sc_mcu7t3v3__inv_2_633/VDD
+ gf180mcu_as_sc_mcu7t3v3__inv_2_612/Y gf180mcu_as_sc_mcu7t3v3__inv_2_638/A gf180mcu_as_sc_mcu7t3v3__inv_2_617/VNW
+ VSUBS gf180mcu_as_sc_mcu7t3v3__inv_2
Xgf180mcu_as_sc_mcu7t3v3__inv_2_601 gf180mcu_as_sc_mcu7t3v3__inv_2_602/VDD gf180mcu_as_sc_mcu7t3v3__inv_2_606/VDD
+ gf180mcu_as_sc_mcu7t3v3__inv_2_601/Y gf180mcu_as_sc_mcu7t3v3__inv_2_602/Y gf180mcu_as_sc_mcu7t3v3__inv_2_602/VNW
+ VSUBS gf180mcu_as_sc_mcu7t3v3__inv_2
Xgf180mcu_as_sc_mcu7t3v3__inv_2_634 gf180mcu_as_sc_mcu7t3v3__inv_2_636/VDD gf180mcu_as_sc_mcu7t3v3__inv_2_638/VSS
+ gf180mcu_as_sc_mcu7t3v3__inv_2_634/Y gf180mcu_as_sc_mcu7t3v3__inv_2_634/A gf180mcu_as_sc_mcu7t3v3__inv_2_636/VNW
+ VSUBS gf180mcu_as_sc_mcu7t3v3__inv_2
Xgf180mcu_as_sc_mcu7t3v3__inv_2_623 gf180mcu_as_sc_mcu7t3v3__inv_2_624/VDD gf180mcu_as_sc_mcu7t3v3__inv_2_632/VDD
+ gf180mcu_as_sc_mcu7t3v3__inv_2_623/Y gf180mcu_as_sc_mcu7t3v3__inv_2_624/Y gf180mcu_as_sc_mcu7t3v3__inv_2_624/VNW
+ VSUBS gf180mcu_as_sc_mcu7t3v3__inv_2
Xgf180mcu_as_sc_mcu7t3v3__inv_2_656 gf180mcu_as_sc_mcu7t3v3__inv_2_656/VDD gf180mcu_as_sc_mcu7t3v3__inv_2_854/VDD
+ gf180mcu_as_sc_mcu7t3v3__inv_2_656/Y VSS gf180mcu_as_sc_mcu7t3v3__inv_2_656/VNW
+ VSUBS gf180mcu_as_sc_mcu7t3v3__inv_2
Xgf180mcu_as_sc_mcu7t3v3__inv_2_667 VSS VSS gf180mcu_as_sc_mcu7t3v3__inv_2_853/Y gf180mcu_as_sc_mcu7t3v3__inv_2_680/Y
+ gf180mcu_as_sc_mcu7t3v3__inv_2_680/VNW VSUBS gf180mcu_as_sc_mcu7t3v3__inv_2
Xgf180mcu_as_sc_mcu7t3v3__inv_2_645 gf180mcu_as_sc_mcu7t3v3__inv_2_665/VSS VSS gf180mcu_as_sc_mcu7t3v3__inv_2_645/Y
+ gf180mcu_as_sc_mcu7t3v3__inv_2_646/Y gf180mcu_as_sc_mcu7t3v3__inv_2_646/VNW VSUBS
+ gf180mcu_as_sc_mcu7t3v3__inv_2
Xgf180mcu_as_sc_mcu7t3v3__inv_2_689 gf180mcu_as_sc_mcu7t3v3__inv_2_689/VDD gf180mcu_as_sc_mcu7t3v3__inv_2_689/VSS
+ gf180mcu_as_sc_mcu7t3v3__inv_2_689/Y VSS gf180mcu_as_sc_mcu7t3v3__inv_2_689/VNW
+ VSUBS gf180mcu_as_sc_mcu7t3v3__inv_2
Xgf180mcu_as_sc_mcu7t3v3__inv_2_678 gf180mcu_as_sc_mcu7t3v3__inv_2_678/VDD gf180mcu_as_sc_mcu7t3v3__inv_2_689/VDD
+ gf180mcu_as_sc_mcu7t3v3__inv_2_678/Y VSS gf180mcu_as_sc_mcu7t3v3__inv_2_678/VNW
+ VSUBS gf180mcu_as_sc_mcu7t3v3__inv_2
Xu_t022_011 u_t022_011/c0_w0_bl u_t022_011/c0_w0_br u_t022_011/c0_w1_bl u_t022_011/c0_w1_br
+ u_t022_011/c0_r0_rbl u_t022_011/c0_r1_rbl u_t022_011/c1_w0_bl u_t022_011/c1_w0_br
+ u_t022_011/c1_w1_bl u_t022_011/c1_w1_br u_t022_011/c1_r0_rbl u_t022_011/c1_r1_rbl
+ u_t022_011/c2_w0_bl u_t022_011/c2_w0_br u_t022_011/c2_w1_bl u_t022_011/c2_w1_br
+ u_t022_011/c2_r0_rbl u_t022_011/c2_r1_rbl u_t022_011/c3_w0_bl u_t022_011/c3_w0_br
+ u_t022_011/c3_w1_bl u_t022_011/c3_w1_br u_t022_011/c3_r0_rbl u_t022_011/c3_r1_rbl
+ u_t022_011/r0_w0_wl u_t022_011/r0_w1_wl u_t022_011/r0_r0_rwl u_t022_011/r0_r1_rwl
+ u_t022_011/r1_w0_wl u_t022_011/r1_w1_wl u_t022_011/r1_r0_rwl u_t022_011/r1_r1_rwl
+ u_t022_011/r2_w0_wl u_t022_011/r2_w1_wl u_t022_011/r2_r0_rwl u_t022_011/r2_r1_rwl
+ u_t022_011/r3_w0_wl u_t022_011/r3_w1_wl u_t022_011/r3_r0_rwl u_t022_011/r3_r1_rwl
+ u_t022_011/VDD VSS u_t022_011/m2_717_1265# u_t022_011/m2_603_2031# u_t022_011/m2_1290_336#
+ u_t022_011/m2_2000_2037# u_t022_011/m2_791_2909# u_t022_011/m2_7_2126# u_t022_011/m2_2154_2081#
+ u_t022_011/m2_1795_2037# u_t022_011/m2_871_303# u_t022_011/m2_431_438# u_t022_011/m2_1290_2898#
+ u_t022_011/m2_1714_1210# u_t022_011/m2_431_1982# u_t022_011/m2_512_1265# u_t022_011/m2_2573_2126#
+ u_t022_011/m2_603_1259# u_t022_011/m2_2074_2909# u_t022_011/m2_7_336# u_t022_011/m2_717_2037#
+ u_t022_011/m2_1886_2031# u_t022_011/m2_2573_336# u_t022_011/m2_7_2898# u_t022_011/m2_2000_1265#
+ u_t022_011/m2_512_2037# u_t022_011/m2_1795_1265# u_t022_011/m2_1714_1982# u_t022_011/m2_1886_1259#
+ u_t022_011/m2_1290_2126# u_t022_011/m2_1714_438# u_t022_011/m2_431_1210# u_t022_011/m2_2573_2898#
+ u_t022_011/m2_2154_303# u_t022_011/m2_871_2081# VSUBS detronyx_12t_2w2r_rc4_4x4_routed_5layer_direct
Xu_t022_000 VSS u_t022_000/c0_w0_br VSS u_t022_000/c0_w1_br u_t022_000/c0_r0_rbl u_t022_000/c0_r1_rbl
+ VSS VSS VSS VSS VSS VSS u_t022_000/c2_w0_bl u_t022_000/c2_w0_br u_t022_000/c2_w1_bl
+ u_t022_000/c2_w1_br u_t022_000/c2_r0_rbl u_t022_000/c2_r1_rbl u_t022_000/c3_w0_bl
+ u_t022_000/c3_w0_br u_t022_000/c3_w1_bl u_t022_000/c3_w1_br u_t022_000/c3_r0_rbl
+ u_t022_000/c3_r1_rbl VSS VSS VSS VSS VSS VSS VSS VSS VSS VSS VSS VSS VSS VSS VSS
+ VSS VSS VSS u_t022_000/m2_717_1265# VSS VSS VSS VSS VSS VSS VSS VSS VSS VSS VSS
+ VSS u_t022_000/m2_512_1265# u_t022_000/m2_2573_2126# VSS VSS VSS VSS VSS u_t022_000/m2_2573_336#
+ VSS u_t022_000/m2_2000_1265# VSS u_t022_000/m2_1795_1265# VSS VSS VSS VSS VSS u_t022_000/m2_2573_2898#
+ VSS VSS VSUBS detronyx_12t_2w2r_rc4_4x4_routed_5layer_direct
Xu_t013_011 u_t013_011/c0_w0_bl u_t013_011/c0_w0_br u_t013_011/c0_w1_bl u_t013_011/c0_w1_br
+ u_t013_011/c0_r0_rbl u_t013_011/c0_r1_rbl u_t013_011/c1_w0_bl u_t013_011/c1_w0_br
+ u_t013_011/c1_w1_bl u_t013_011/c1_w1_br u_t013_011/c1_r0_rbl u_t013_011/c1_r1_rbl
+ u_t013_011/c2_w0_bl u_t013_011/c2_w0_br u_t013_011/c2_w1_bl u_t013_011/c2_w1_br
+ u_t013_011/c2_r0_rbl u_t013_011/c2_r1_rbl u_t013_011/c3_w0_bl u_t013_011/c3_w0_br
+ u_t013_011/c3_w1_bl u_t013_011/c3_w1_br u_t013_011/c3_r0_rbl u_t013_011/c3_r1_rbl
+ u_t013_011/r0_w0_wl u_t013_011/r0_w1_wl u_t013_011/r0_r0_rwl u_t013_011/r0_r1_rwl
+ u_t013_011/r1_w0_wl u_t013_011/r1_w1_wl u_t013_011/r1_r0_rwl u_t013_011/r1_r1_rwl
+ u_t013_011/r2_w0_wl u_t013_011/r2_w1_wl u_t013_011/r2_r0_rwl u_t013_011/r2_r1_rwl
+ u_t013_011/r3_w0_wl u_t013_011/r3_w1_wl u_t013_011/r3_r0_rwl u_t013_011/r3_r1_rwl
+ u_t013_011/VDD VSS u_t013_011/m2_717_1265# u_t013_011/m2_603_2031# u_t013_011/m2_1290_336#
+ u_t013_011/m2_2000_2037# u_t013_011/m2_791_2909# u_t013_011/m2_7_2126# u_t013_011/m2_2154_2081#
+ u_t013_011/m2_1795_2037# u_t013_011/m2_871_303# u_t013_011/m2_431_438# u_t013_011/m2_1290_2898#
+ u_t013_011/m2_1714_1210# u_t013_011/m2_431_1982# u_t013_011/m2_512_1265# u_t013_011/m2_2573_2126#
+ u_t013_011/m2_603_1259# u_t013_011/m2_2074_2909# u_t013_011/m2_7_336# u_t013_011/m2_717_2037#
+ u_t013_011/m2_1886_2031# u_t013_011/m2_2573_336# u_t013_011/m2_7_2898# u_t013_011/m2_2000_1265#
+ u_t013_011/m2_512_2037# u_t013_011/m2_1795_1265# u_t013_011/m2_1714_1982# u_t013_011/m2_1886_1259#
+ u_t013_011/m2_1290_2126# u_t013_011/m2_1714_438# u_t013_011/m2_431_1210# u_t013_011/m2_2573_2898#
+ u_t013_011/m2_2154_303# u_t013_011/m2_871_2081# VSUBS detronyx_12t_2w2r_rc4_4x4_routed_5layer_direct
Xu_t013_000 VSS u_t013_000/c0_w0_br VSS u_t013_000/c0_w1_br u_t013_000/c0_r0_rbl u_t013_000/c0_r1_rbl
+ VSS VSS VSS VSS VSS VSS u_t013_000/c2_w0_bl u_t013_000/c2_w0_br u_t013_000/c2_w1_bl
+ u_t013_000/c2_w1_br u_t013_000/c2_r0_rbl u_t013_000/c2_r1_rbl u_t013_000/c3_w0_bl
+ u_t013_000/c3_w0_br u_t013_000/c3_w1_bl u_t013_000/c3_w1_br u_t013_000/c3_r0_rbl
+ u_t013_000/c3_r1_rbl VSS VSS VSS VSS VSS VSS VSS VSS VSS VSS VSS VSS VSS VSS VSS
+ VSS VSS VSS u_t013_000/m2_717_1265# u_t013_000/m2_603_2031# u_t013_000/m2_1290_336#
+ u_t013_000/m2_2000_2037# u_t013_000/m2_791_2909# u_t013_000/m2_7_2126# u_t013_000/m2_2154_2081#
+ u_t013_000/m2_1795_2037# u_t013_000/m2_871_303# u_t013_000/m2_431_438# u_t013_000/m2_1290_2898#
+ u_t013_000/m2_1714_1210# u_t013_000/m2_431_1982# u_t013_000/m2_512_1265# u_t013_000/m2_2573_2126#
+ u_t013_000/m2_603_1259# u_t013_000/m2_2074_2909# u_t013_000/m2_7_336# u_t013_000/m2_717_2037#
+ u_t013_000/m2_1886_2031# u_t013_000/m2_2573_336# u_t013_000/m2_7_2898# u_t013_000/m2_2000_1265#
+ u_t013_000/m2_512_2037# u_t013_000/m2_1795_1265# u_t013_000/m2_1714_1982# u_t013_000/m2_1886_1259#
+ u_t013_000/m2_1290_2126# u_t013_000/m2_1714_438# u_t013_000/m2_431_1210# u_t013_000/m2_2573_2898#
+ u_t013_000/m2_2154_303# u_t013_000/m2_871_2081# VSUBS detronyx_12t_2w2r_rc4_4x4_routed_5layer_direct
Xgf180mcu_as_sc_mcu7t3v3__inv_2_420 gf180mcu_as_sc_mcu7t3v3__nor2_2_6/VDD gf180mcu_as_sc_mcu7t3v3__nand3_2_4/VSS
+ gf180mcu_as_sc_mcu7t3v3__inv_2_420/Y VSS gf180mcu_as_sc_mcu7t3v3__nor2_2_6/VNW VSUBS
+ gf180mcu_as_sc_mcu7t3v3__inv_2
Xu_t004_011 u_t004_011/c0_w0_bl u_t004_011/c0_w0_br u_t004_011/c0_w1_bl u_t004_011/c0_w1_br
+ u_t004_011/c0_r0_rbl u_t004_011/c0_r1_rbl u_t004_011/c1_w0_bl u_t004_011/c1_w0_br
+ u_t004_011/c1_w1_bl u_t004_011/c1_w1_br u_t004_011/c1_r0_rbl u_t004_011/c1_r1_rbl
+ u_t004_011/c2_w0_bl u_t004_011/c2_w0_br u_t004_011/c2_w1_bl u_t004_011/c2_w1_br
+ u_t004_011/c2_r0_rbl u_t004_011/c2_r1_rbl u_t004_011/c3_w0_bl u_t004_011/c3_w0_br
+ u_t004_011/c3_w1_bl u_t004_011/c3_w1_br u_t004_011/c3_r0_rbl u_t004_011/c3_r1_rbl
+ u_t004_011/r0_w0_wl u_t004_011/r0_w1_wl u_t004_011/r0_r0_rwl u_t004_011/r0_r1_rwl
+ u_t004_011/r1_w0_wl u_t004_011/r1_w1_wl u_t004_011/r1_r0_rwl u_t004_011/r1_r1_rwl
+ u_t004_011/r2_w0_wl u_t004_011/r2_w1_wl u_t004_011/r2_r0_rwl u_t004_011/r2_r1_rwl
+ u_t004_011/r3_w0_wl u_t004_011/r3_w1_wl u_t004_011/r3_r0_rwl u_t004_011/r3_r1_rwl
+ u_t004_011/VDD VSS u_t004_011/m2_717_1265# u_t004_011/m2_603_2031# u_t004_011/m2_1290_336#
+ u_t004_011/m2_2000_2037# u_t004_011/m2_791_2909# u_t004_011/m2_7_2126# u_t004_011/m2_2154_2081#
+ u_t004_011/m2_1795_2037# u_t004_011/m2_871_303# u_t004_011/m2_431_438# u_t004_011/m2_1290_2898#
+ u_t004_011/m2_1714_1210# u_t004_011/m2_431_1982# u_t004_011/m2_512_1265# u_t004_011/m2_2573_2126#
+ u_t004_011/m2_603_1259# u_t004_011/m2_2074_2909# u_t004_011/m2_7_336# u_t004_011/m2_717_2037#
+ u_t004_011/m2_1886_2031# u_t004_011/m2_2573_336# u_t004_011/m2_7_2898# u_t004_011/m2_2000_1265#
+ u_t004_011/m2_512_2037# u_t004_011/m2_1795_1265# u_t004_011/m2_1714_1982# u_t004_011/m2_1886_1259#
+ u_t004_011/m2_1290_2126# u_t004_011/m2_1714_438# u_t004_011/m2_431_1210# u_t004_011/m2_2573_2898#
+ u_t004_011/m2_2154_303# u_t004_011/m2_871_2081# VSUBS detronyx_12t_2w2r_rc4_4x4_routed_5layer_direct
Xgf180mcu_as_sc_mcu7t3v3__inv_2_442 VSS VSS gf180mcu_as_sc_mcu7t3v3__inv_2_442/Y VSS
+ gf180mcu_as_sc_mcu7t3v3__inv_2_543/VNW VSUBS gf180mcu_as_sc_mcu7t3v3__inv_2
Xgf180mcu_as_sc_mcu7t3v3__inv_2_453 VSS VSS VSS VSS gf180mcu_as_sc_mcu7t3v3__inv_2_546/VNW
+ VSUBS gf180mcu_as_sc_mcu7t3v3__inv_2
Xgf180mcu_as_sc_mcu7t3v3__inv_2_486 VSS VSS VSS VSS gf180mcu_as_sc_mcu7t3v3__inv_2_550/VNW
+ VSUBS gf180mcu_as_sc_mcu7t3v3__inv_2
Xgf180mcu_as_sc_mcu7t3v3__inv_2_475 gf180mcu_as_sc_mcu7t3v3__nor2_2_7/VDD gf180mcu_as_sc_mcu7t3v3__nand3_2_4/VSS
+ VSS VSS gf180mcu_as_sc_mcu7t3v3__nor2_2_7/VNW VSUBS gf180mcu_as_sc_mcu7t3v3__inv_2
Xgf180mcu_as_sc_mcu7t3v3__inv_2_431 gf180mcu_as_sc_mcu7t3v3__nor2_2_4/VDD gf180mcu_as_sc_mcu7t3v3__nand2_2_3/VSS
+ gf180mcu_as_sc_mcu7t3v3__inv_2_431/Y VSS gf180mcu_as_sc_mcu7t3v3__nor2_2_4/VNW VSUBS
+ gf180mcu_as_sc_mcu7t3v3__inv_2
Xgf180mcu_as_sc_mcu7t3v3__inv_2_464 gf180mcu_as_sc_mcu7t3v3__nand3_2_9/VDD gf180mcu_as_sc_mcu7t3v3__nor2_2_7/VSS
+ VSS VSS gf180mcu_as_sc_mcu7t3v3__nand3_2_9/VNW VSUBS gf180mcu_as_sc_mcu7t3v3__inv_2
Xgf180mcu_as_sc_mcu7t3v3__inv_2_497 VSS VSS VSS VSS gf180mcu_as_sc_mcu7t3v3__inv_2_555/VNW
+ VSUBS gf180mcu_as_sc_mcu7t3v3__inv_2
Xu_t004_000 VSS u_t004_000/c0_w0_br VSS u_t004_000/c0_w1_br u_t004_000/c0_r0_rbl u_t004_000/c0_r1_rbl
+ VSS VSS VSS VSS VSS VSS u_t004_000/c2_w0_bl u_t004_000/c2_w0_br u_t004_000/c2_w1_bl
+ u_t004_000/c2_w1_br u_t004_000/c2_r0_rbl u_t004_000/c2_r1_rbl u_t004_000/c3_w0_bl
+ u_t004_000/c3_w0_br u_t004_000/c3_w1_bl u_t004_000/c3_w1_br u_t004_000/c3_r0_rbl
+ u_t004_000/c3_r1_rbl VSS VSS VSS VSS VSS VSS VSS VSS VSS VSS VSS VSS VSS VSS VSS
+ VSS VSS VSS u_t004_000/m2_717_1265# u_t004_000/m2_603_2031# u_t004_000/m2_1290_336#
+ u_t004_000/m2_2000_2037# u_t004_000/m2_791_2909# u_t004_000/m2_7_2126# u_t004_000/m2_2154_2081#
+ u_t004_000/m2_1795_2037# u_t004_000/m2_871_303# u_t004_000/m2_431_438# u_t004_000/m2_1290_2898#
+ u_t004_000/m2_1714_1210# u_t004_000/m2_431_1982# u_t004_000/m2_512_1265# u_t004_000/m2_2573_2126#
+ u_t004_000/m2_603_1259# u_t004_000/m2_2074_2909# u_t004_000/m2_7_336# u_t004_000/m2_717_2037#
+ u_t004_000/m2_1886_2031# u_t004_000/m2_2573_336# u_t004_000/m2_7_2898# u_t004_000/m2_2000_1265#
+ u_t004_000/m2_512_2037# u_t004_000/m2_1795_1265# u_t004_000/m2_1714_1982# u_t004_000/m2_1886_1259#
+ u_t004_000/m2_1290_2126# u_t004_000/m2_1714_438# u_t004_000/m2_431_1210# u_t004_000/m2_2573_2898#
+ u_t004_000/m2_2154_303# u_t004_000/m2_871_2081# VSUBS detronyx_12t_2w2r_rc4_4x4_routed_5layer_direct
Xu_t010_014 u_t010_014/c0_w0_bl u_t010_014/c0_w0_br u_t010_014/c0_w1_bl u_t010_014/c0_w1_br
+ u_t010_014/c0_r0_rbl u_t010_014/c0_r1_rbl u_t010_014/c1_w0_bl u_t010_014/c1_w0_br
+ u_t010_014/c1_w1_bl u_t010_014/c1_w1_br u_t010_014/c1_r0_rbl u_t010_014/c1_r1_rbl
+ u_t010_014/c2_w0_bl u_t010_014/c2_w0_br u_t010_014/c2_w1_bl u_t010_014/c2_w1_br
+ u_t010_014/c2_r0_rbl u_t010_014/c2_r1_rbl u_t010_014/c3_w0_bl u_t010_014/c3_w0_br
+ u_t010_014/c3_w1_bl u_t010_014/c3_w1_br u_t010_014/c3_r0_rbl u_t010_014/c3_r1_rbl
+ u_t010_014/r0_w0_wl u_t010_014/r0_w1_wl u_t010_014/r0_r0_rwl u_t010_014/r0_r1_rwl
+ u_t010_014/r1_w0_wl u_t010_014/r1_w1_wl u_t010_014/r1_r0_rwl u_t010_014/r1_r1_rwl
+ u_t010_014/r2_w0_wl u_t010_014/r2_w1_wl u_t010_014/r2_r0_rwl u_t010_014/r2_r1_rwl
+ u_t010_014/r3_w0_wl u_t010_014/r3_w1_wl u_t010_014/r3_r0_rwl u_t010_014/r3_r1_rwl
+ u_t010_014/VDD u_t010_015/VSS u_t010_014/m2_717_1265# u_t010_014/m2_603_2031# u_t010_014/m2_1290_336#
+ u_t010_014/m2_2000_2037# u_t010_014/m2_791_2909# u_t010_014/m2_7_2126# u_t010_014/m2_2154_2081#
+ u_t010_014/m2_1795_2037# u_t010_014/m2_871_303# u_t010_014/m2_431_438# u_t010_014/m2_1290_2898#
+ u_t010_014/m2_1714_1210# u_t010_014/m2_431_1982# u_t010_014/m2_512_1265# u_t010_014/m2_2573_2126#
+ u_t010_014/m2_603_1259# u_t010_014/m2_2074_2909# u_t010_014/m2_7_336# u_t010_014/m2_717_2037#
+ u_t010_014/m2_1886_2031# u_t010_014/m2_2573_336# u_t010_014/m2_7_2898# u_t010_014/m2_2000_1265#
+ u_t010_014/m2_512_2037# u_t010_014/m2_1795_1265# u_t010_014/m2_1714_1982# u_t010_014/m2_1886_1259#
+ u_t010_014/m2_1290_2126# u_t010_014/m2_1714_438# u_t010_014/m2_431_1210# u_t010_014/m2_2573_2898#
+ u_t010_014/m2_2154_303# u_t010_014/m2_871_2081# VSUBS detronyx_12t_2w2r_rc4_4x4_routed_5layer_direct
Xu_t010_003 u_t010_003/c0_w0_bl u_t010_003/c0_w0_br u_t010_003/c0_w1_bl u_t010_003/c0_w1_br
+ u_t010_003/c0_r0_rbl u_t010_003/c0_r1_rbl u_t010_003/c1_w0_bl u_t010_003/c1_w0_br
+ u_t010_003/c1_w1_bl u_t010_003/c1_w1_br u_t010_003/c1_r0_rbl u_t010_003/c1_r1_rbl
+ u_t010_003/c2_w0_bl u_t010_003/c2_w0_br u_t010_003/c2_w1_bl u_t010_003/c2_w1_br
+ u_t010_003/c2_r0_rbl u_t010_003/c2_r1_rbl u_t010_003/c3_w0_bl u_t010_003/c3_w0_br
+ u_t010_003/c3_w1_bl u_t010_003/c3_w1_br u_t010_003/c3_r0_rbl u_t010_003/c3_r1_rbl
+ u_t010_003/r0_w0_wl u_t010_003/r0_w1_wl u_t010_003/r0_r0_rwl u_t010_003/r0_r1_rwl
+ u_t010_003/r1_w0_wl u_t010_003/r1_w1_wl u_t010_003/r1_r0_rwl u_t010_003/r1_r1_rwl
+ u_t010_003/r2_w0_wl u_t010_003/r2_w1_wl u_t010_003/r2_r0_rwl u_t010_003/r2_r1_rwl
+ u_t010_003/r3_w0_wl u_t010_003/r3_w1_wl u_t010_003/r3_r0_rwl u_t010_003/r3_r1_rwl
+ u_t010_003/VDD u_t010_003/VSS u_t010_003/m2_717_1265# u_t010_003/m2_603_2031# u_t010_003/m2_1290_336#
+ u_t010_003/m2_2000_2037# u_t010_003/m2_791_2909# u_t010_003/m2_7_2126# u_t010_003/m2_2154_2081#
+ u_t010_003/m2_1795_2037# u_t010_003/m2_871_303# u_t010_003/m2_431_438# u_t010_003/m2_1290_2898#
+ u_t010_003/m2_1714_1210# u_t010_003/m2_431_1982# u_t010_003/m2_512_1265# u_t010_003/m2_2573_2126#
+ u_t010_003/m2_603_1259# u_t010_003/m2_2074_2909# u_t010_003/m2_7_336# u_t010_003/m2_717_2037#
+ u_t010_003/m2_1886_2031# u_t010_003/m2_2573_336# u_t010_003/m2_7_2898# u_t010_003/m2_2000_1265#
+ u_t010_003/m2_512_2037# u_t010_003/m2_1795_1265# u_t010_003/m2_1714_1982# u_t010_003/m2_1886_1259#
+ u_t010_003/m2_1290_2126# u_t010_003/m2_1714_438# u_t010_003/m2_431_1210# u_t010_003/m2_2573_2898#
+ u_t010_003/m2_2154_303# u_t010_003/m2_871_2081# VSUBS detronyx_12t_2w2r_rc4_4x4_routed_5layer_direct
Xu_t001_014 u_t001_014/c0_w0_bl u_t001_014/c0_w0_br u_t001_014/c0_w1_bl u_t001_014/c0_w1_br
+ u_t001_014/c0_r0_rbl u_t001_014/c0_r1_rbl u_t001_014/c1_w0_bl u_t001_014/c1_w0_br
+ u_t001_014/c1_w1_bl u_t001_014/c1_w1_br u_t001_014/c1_r0_rbl u_t001_014/c1_r1_rbl
+ u_t001_014/c2_w0_bl u_t001_014/c2_w0_br u_t001_014/c2_w1_bl u_t001_014/c2_w1_br
+ u_t001_014/c2_r0_rbl u_t001_014/c2_r1_rbl u_t001_014/c3_w0_bl u_t001_014/c3_w0_br
+ u_t001_014/c3_w1_bl u_t001_014/c3_w1_br u_t001_014/c3_r0_rbl u_t001_014/c3_r1_rbl
+ u_t001_014/r0_w0_wl u_t001_014/r0_w1_wl u_t001_014/r0_r0_rwl u_t001_014/r0_r1_rwl
+ u_t001_014/r1_w0_wl u_t001_014/r1_w1_wl u_t001_014/r1_r0_rwl u_t001_014/r1_r1_rwl
+ u_t001_014/r2_w0_wl u_t001_014/r2_w1_wl u_t001_014/r2_r0_rwl u_t001_014/r2_r1_rwl
+ u_t001_014/r3_w0_wl u_t001_014/r3_w1_wl u_t001_014/r3_r0_rwl u_t001_014/r3_r1_rwl
+ u_t001_014/VDD VSS u_t001_014/m2_717_1265# u_t001_014/m2_603_2031# u_t001_014/m2_1290_336#
+ u_t001_014/m2_2000_2037# u_t001_014/m2_791_2909# u_t001_014/m2_7_2126# u_t001_014/m2_2154_2081#
+ u_t001_014/m2_1795_2037# u_t001_014/m2_871_303# u_t001_014/m2_431_438# u_t001_014/m2_1290_2898#
+ u_t001_014/m2_1714_1210# u_t001_014/m2_431_1982# u_t001_014/m2_512_1265# u_t001_014/m2_2573_2126#
+ u_t001_014/m2_603_1259# u_t001_014/m2_2074_2909# u_t001_014/m2_7_336# u_t001_014/m2_717_2037#
+ u_t001_014/m2_1886_2031# u_t001_014/m2_2573_336# u_t001_014/m2_7_2898# u_t001_014/m2_2000_1265#
+ u_t001_014/m2_512_2037# u_t001_014/m2_1795_1265# u_t001_014/m2_1714_1982# u_t001_014/m2_1886_1259#
+ u_t001_014/m2_1290_2126# u_t001_014/m2_1714_438# u_t001_014/m2_431_1210# u_t001_014/m2_2573_2898#
+ u_t001_014/m2_2154_303# u_t001_014/m2_871_2081# VSUBS detronyx_12t_2w2r_rc4_4x4_routed_5layer_direct
Xu_t001_003 u_t001_003/c0_w0_bl u_t001_003/c0_w0_br u_t001_003/c0_w1_bl u_t001_003/c0_w1_br
+ u_t001_003/c0_r0_rbl u_t001_003/c0_r1_rbl u_t001_003/c1_w0_bl u_t001_003/c1_w0_br
+ u_t001_003/c1_w1_bl u_t001_003/c1_w1_br u_t001_003/c1_r0_rbl u_t001_003/c1_r1_rbl
+ u_t001_003/c2_w0_bl u_t001_003/c2_w0_br u_t001_003/c2_w1_bl u_t001_003/c2_w1_br
+ u_t001_003/c2_r0_rbl u_t001_003/c2_r1_rbl u_t001_003/c3_w0_bl u_t001_003/c3_w0_br
+ u_t001_003/c3_w1_bl u_t001_003/c3_w1_br u_t001_003/c3_r0_rbl u_t001_003/c3_r1_rbl
+ u_t001_003/r0_w0_wl u_t001_003/r0_w1_wl u_t001_003/r0_r0_rwl u_t001_003/r0_r1_rwl
+ u_t001_003/r1_w0_wl u_t001_003/r1_w1_wl u_t001_003/r1_r0_rwl u_t001_003/r1_r1_rwl
+ u_t001_003/r2_w0_wl u_t001_003/r2_w1_wl u_t001_003/r2_r0_rwl u_t001_003/r2_r1_rwl
+ u_t001_003/r3_w0_wl u_t001_003/r3_w1_wl u_t001_003/r3_r0_rwl u_t001_003/r3_r1_rwl
+ u_t001_003/VDD VSS u_t001_003/m2_717_1265# u_t001_003/m2_603_2031# u_t001_003/m2_1290_336#
+ u_t001_003/m2_2000_2037# u_t001_003/m2_791_2909# u_t001_003/m2_7_2126# u_t001_003/m2_2154_2081#
+ u_t001_003/m2_1795_2037# u_t001_003/m2_871_303# u_t001_003/m2_431_438# u_t001_003/m2_1290_2898#
+ u_t001_003/m2_1714_1210# u_t001_003/m2_431_1982# u_t001_003/m2_512_1265# u_t001_003/m2_2573_2126#
+ u_t001_003/m2_603_1259# u_t001_003/m2_2074_2909# u_t001_003/m2_7_336# u_t001_003/m2_717_2037#
+ u_t001_003/m2_1886_2031# u_t001_003/m2_2573_336# u_t001_003/m2_7_2898# u_t001_003/m2_2000_1265#
+ u_t001_003/m2_512_2037# u_t001_003/m2_1795_1265# u_t001_003/m2_1714_1982# u_t001_003/m2_1886_1259#
+ u_t001_003/m2_1290_2126# u_t001_003/m2_1714_438# u_t001_003/m2_431_1210# u_t001_003/m2_2573_2898#
+ u_t001_003/m2_2154_303# u_t001_003/m2_871_2081# VSUBS detronyx_12t_2w2r_rc4_4x4_routed_5layer_direct
Xgf180mcu_as_sc_mcu7t3v3__inv_2_261 VSS gf180mcu_as_sc_mcu7t3v3__inv_2_301/VDD gf180mcu_as_sc_mcu7t3v3__inv_2_301/Y
+ VSS gf180mcu_as_sc_mcu7t3v3__inv_2_298/VNW VSUBS gf180mcu_as_sc_mcu7t3v3__inv_2
Xgf180mcu_as_sc_mcu7t3v3__inv_2_250 gf180mcu_as_sc_mcu7t3v3__inv_2_251/VDD VSS VSS
+ VSS gf180mcu_as_sc_mcu7t3v3__inv_2_251/VNW VSUBS gf180mcu_as_sc_mcu7t3v3__inv_2
Xgf180mcu_as_sc_mcu7t3v3__inv_2_1705 gf180mcu_as_sc_mcu7t3v3__nor2_2_4/VDD gf180mcu_as_sc_mcu7t3v3__nor2_2_4/VSS
+ VSS VSS gf180mcu_as_sc_mcu7t3v3__nor2_2_4/VNW VSUBS gf180mcu_as_sc_mcu7t3v3__inv_2
Xgf180mcu_as_sc_mcu7t3v3__inv_2_294 gf180mcu_as_sc_mcu7t3v3__inv_2_308/VDD gf180mcu_as_sc_mcu7t3v3__inv_2_308/VSS
+ gf180mcu_as_sc_mcu7t3v3__inv_2_294/Y gf180mcu_as_sc_mcu7t3v3__inv_2_61/Y gf180mcu_as_sc_mcu7t3v3__inv_2_308/VNW
+ VSUBS gf180mcu_as_sc_mcu7t3v3__inv_2
Xgf180mcu_as_sc_mcu7t3v3__inv_2_283 VSS gf180mcu_as_sc_mcu7t3v3__inv_2_304/VDD gf180mcu_as_sc_mcu7t3v3__inv_2_304/A
+ gf180mcu_as_sc_mcu7t3v3__inv_2_304/A gf180mcu_as_sc_mcu7t3v3__inv_2_288/VNW VSUBS
+ gf180mcu_as_sc_mcu7t3v3__inv_2
Xgf180mcu_as_sc_mcu7t3v3__inv_2_272 gf180mcu_as_sc_mcu7t3v3__inv_2_311/VSS gf180mcu_as_sc_mcu7t3v3__inv_2_279/VDD
+ gf180mcu_as_sc_mcu7t3v3__inv_2_272/Y gf180mcu_as_sc_mcu7t3v3__inv_2_365/Y gf180mcu_as_sc_mcu7t3v3__inv_2_274/VNW
+ VSUBS gf180mcu_as_sc_mcu7t3v3__inv_2
Xgf180mcu_as_sc_mcu7t3v3__inv_2_1716 gf180mcu_as_sc_mcu7t3v3__inv_2_1717/VDD VSS gf180mcu_as_sc_mcu7t3v3__inv_2_1716/Y
+ gf180mcu_as_sc_mcu7t3v3__inv_2_1717/Y gf180mcu_as_sc_mcu7t3v3__inv_2_1717/VNW VSUBS
+ gf180mcu_as_sc_mcu7t3v3__inv_2
Xgf180mcu_as_sc_mcu7t3v3__inv_2_1568 gf180mcu_as_sc_mcu7t3v3__inv_2_1588/VSS gf180mcu_as_sc_mcu7t3v3__inv_2_1573/VDD
+ VSS VSS gf180mcu_as_sc_mcu7t3v3__inv_2_1570/VNW VSUBS gf180mcu_as_sc_mcu7t3v3__inv_2
Xgf180mcu_as_sc_mcu7t3v3__inv_2_1579 VSS gf180mcu_as_sc_mcu7t3v3__inv_2_1582/VDD gf180mcu_as_sc_mcu7t3v3__inv_2_1579/Y
+ VSS gf180mcu_as_sc_mcu7t3v3__inv_2_1579/VNW VSUBS gf180mcu_as_sc_mcu7t3v3__inv_2
Xgf180mcu_as_sc_mcu7t3v3__inv_2_1546 gf180mcu_as_sc_mcu7t3v3__inv_2_1547/VDD VSS VSS
+ VSS gf180mcu_as_sc_mcu7t3v3__inv_2_1547/VNW VSUBS gf180mcu_as_sc_mcu7t3v3__inv_2
Xgf180mcu_as_sc_mcu7t3v3__inv_2_1557 VSS gf180mcu_as_sc_mcu7t3v3__inv_2_1562/VDD VSS
+ VSS gf180mcu_as_sc_mcu7t3v3__inv_2_1559/VNW VSUBS gf180mcu_as_sc_mcu7t3v3__inv_2
Xgf180mcu_as_sc_mcu7t3v3__inv_2_1513 VSS VSS VSS VSS gf180mcu_as_sc_mcu7t3v3__inv_2_1514/VNW
+ VSUBS gf180mcu_as_sc_mcu7t3v3__inv_2
Xgf180mcu_as_sc_mcu7t3v3__inv_2_1524 VSS VSS VSS VSS gf180mcu_as_sc_mcu7t3v3__inv_2_1526/VNW
+ VSUBS gf180mcu_as_sc_mcu7t3v3__inv_2
Xgf180mcu_as_sc_mcu7t3v3__inv_2_1535 VSS VSS VSS VSS gf180mcu_as_sc_mcu7t3v3__inv_2_1535/VNW
+ VSUBS gf180mcu_as_sc_mcu7t3v3__inv_2
Xgf180mcu_as_sc_mcu7t3v3__inv_2_1502 gf180mcu_as_sc_mcu7t3v3__inv_2_1503/VDD VSS VSS
+ VSS gf180mcu_as_sc_mcu7t3v3__inv_2_1503/VNW VSUBS gf180mcu_as_sc_mcu7t3v3__inv_2
Xgf180mcu_as_sc_mcu7t3v3__nand4_2_318 gf180mcu_as_sc_mcu7t3v3__inv_2_1100/VSS VSS
+ VSS VSS VSS VSS VSS gf180mcu_as_sc_mcu7t3v3__inv_2_1067/VNW VSUBS gf180mcu_as_sc_mcu7t3v3__nand4_2
Xgf180mcu_as_sc_mcu7t3v3__nand4_2_329 VSS gf180mcu_as_sc_mcu7t3v3__inv_2_1111/VSS
+ VSS VSS VSS VSS VSS gf180mcu_as_sc_mcu7t3v3__inv_2_1111/VNW VSUBS gf180mcu_as_sc_mcu7t3v3__nand4_2
Xgf180mcu_as_sc_mcu7t3v3__nand4_2_307 gf180mcu_as_sc_mcu7t3v3__inv_2_1052/VDD VSS
+ VSS VSS VSS VSS VSS gf180mcu_as_sc_mcu7t3v3__inv_2_1052/VNW VSUBS gf180mcu_as_sc_mcu7t3v3__nand4_2
Xgf180mcu_as_sc_mcu7t3v3__nand2_2_1 gf180mcu_as_sc_mcu7t3v3__nor2_2_6/VDD gf180mcu_as_sc_mcu7t3v3__nand3_2_4/VSS
+ VSS VSS VSS gf180mcu_as_sc_mcu7t3v3__nor2_2_6/VNW VSUBS gf180mcu_as_sc_mcu7t3v3__nand2_2
Xu_t029_006 u_t029_006/c0_w0_bl u_t029_006/c0_w0_br u_t029_006/c0_w1_bl u_t029_006/c0_w1_br
+ u_t029_006/c0_r0_rbl u_t029_006/c0_r1_rbl u_t029_006/c1_w0_bl u_t029_006/c1_w0_br
+ u_t029_006/c1_w1_bl u_t029_006/c1_w1_br u_t029_006/c1_r0_rbl u_t029_006/c1_r1_rbl
+ u_t029_006/c2_w0_bl u_t029_006/c2_w0_br u_t029_006/c2_w1_bl u_t029_006/c2_w1_br
+ u_t029_006/c2_r0_rbl u_t029_006/c2_r1_rbl u_t029_006/c3_w0_bl u_t029_006/c3_w0_br
+ u_t029_006/c3_w1_bl u_t029_006/c3_w1_br u_t029_006/c3_r0_rbl u_t029_006/c3_r1_rbl
+ u_t029_006/r0_w0_wl u_t029_006/r0_w1_wl u_t029_006/r0_r0_rwl u_t029_006/r0_r1_rwl
+ u_t029_006/r1_w0_wl u_t029_006/r1_w1_wl u_t029_006/r1_r0_rwl u_t029_006/r1_r1_rwl
+ u_t029_006/r2_w0_wl u_t029_006/r2_w1_wl u_t029_006/r2_r0_rwl u_t029_006/r2_r1_rwl
+ u_t029_006/r3_w0_wl u_t029_006/r3_w1_wl u_t029_006/r3_r0_rwl u_t029_006/r3_r1_rwl
+ u_t029_006/VDD VSS u_t029_006/m2_717_1265# u_t029_006/m2_603_2031# u_t029_006/m2_1290_336#
+ u_t029_006/m2_2000_2037# u_t029_006/m2_791_2909# u_t029_006/m2_7_2126# u_t029_006/m2_2154_2081#
+ u_t029_006/m2_1795_2037# u_t029_006/m2_871_303# u_t029_006/m2_431_438# u_t029_006/m2_1290_2898#
+ u_t029_006/m2_1714_1210# u_t029_006/m2_431_1982# u_t029_006/m2_512_1265# u_t029_006/m2_2573_2126#
+ u_t029_006/m2_603_1259# u_t029_006/m2_2074_2909# u_t029_006/m2_7_336# u_t029_006/m2_717_2037#
+ u_t029_006/m2_1886_2031# u_t029_006/m2_2573_336# u_t029_006/m2_7_2898# u_t029_006/m2_2000_1265#
+ u_t029_006/m2_512_2037# u_t029_006/m2_1795_1265# u_t029_006/m2_1714_1982# u_t029_006/m2_1886_1259#
+ u_t029_006/m2_1290_2126# u_t029_006/m2_1714_438# u_t029_006/m2_431_1210# u_t029_006/m2_2573_2898#
+ u_t029_006/m2_2154_303# u_t029_006/m2_871_2081# VSUBS detronyx_12t_2w2r_rc4_4x4_routed_5layer_direct
Xgf180mcu_as_sc_mcu7t3v3__inv_2_1310 VSS gf180mcu_as_sc_mcu7t3v3__inv_2_1316/VDD VSS
+ gf180mcu_as_sc_mcu7t3v3__inv_2_1355/Y gf180mcu_as_sc_mcu7t3v3__inv_2_1312/VNW VSUBS
+ gf180mcu_as_sc_mcu7t3v3__inv_2
Xgf180mcu_as_sc_mcu7t3v3__inv_2_1365 gf180mcu_as_sc_mcu7t3v3__inv_2_1366/VDD gf180mcu_as_sc_mcu7t3v3__inv_2_1370/VDD
+ gf180mcu_as_sc_mcu7t3v3__inv_2_1365/Y gf180mcu_as_sc_mcu7t3v3__inv_2_1694/Y gf180mcu_as_sc_mcu7t3v3__inv_2_1366/VNW
+ VSUBS gf180mcu_as_sc_mcu7t3v3__inv_2
Xgf180mcu_as_sc_mcu7t3v3__inv_2_1376 gf180mcu_as_sc_mcu7t3v3__inv_2_1378/VDD gf180mcu_as_sc_mcu7t3v3__inv_2_1382/VDD
+ VSS gf180mcu_as_sc_mcu7t3v3__inv_2_1382/Y gf180mcu_as_sc_mcu7t3v3__inv_2_1378/VNW
+ VSUBS gf180mcu_as_sc_mcu7t3v3__inv_2
Xgf180mcu_as_sc_mcu7t3v3__inv_2_1398 VSS VSS gf180mcu_as_sc_mcu7t3v3__inv_2_1409/A
+ VSS gf180mcu_as_sc_mcu7t3v3__inv_2_1398/VNW VSUBS gf180mcu_as_sc_mcu7t3v3__inv_2
Xgf180mcu_as_sc_mcu7t3v3__inv_2_1387 gf180mcu_as_sc_mcu7t3v3__inv_2_1391/VDD gf180mcu_as_sc_mcu7t3v3__inv_2_1403/VDD
+ gf180mcu_as_sc_mcu7t3v3__inv_2_1387/Y gf180mcu_as_sc_mcu7t3v3__inv_2_1409/A gf180mcu_as_sc_mcu7t3v3__inv_2_1391/VNW
+ VSUBS gf180mcu_as_sc_mcu7t3v3__inv_2
Xgf180mcu_as_sc_mcu7t3v3__inv_2_1321 VSS VSS gf180mcu_as_sc_mcu7t3v3__inv_2_1717/Y
+ VSS gf180mcu_as_sc_mcu7t3v3__inv_2_1353/VNW VSUBS gf180mcu_as_sc_mcu7t3v3__inv_2
Xgf180mcu_as_sc_mcu7t3v3__inv_2_1354 gf180mcu_as_sc_mcu7t3v3__inv_2_1355/VDD VSS VSS
+ gf180mcu_as_sc_mcu7t3v3__inv_2_1355/Y gf180mcu_as_sc_mcu7t3v3__inv_2_1355/VNW VSUBS
+ gf180mcu_as_sc_mcu7t3v3__inv_2
Xgf180mcu_as_sc_mcu7t3v3__inv_2_1343 VSS VSS gf180mcu_as_sc_mcu7t3v3__inv_2_1355/Y
+ gf180mcu_as_sc_mcu7t3v3__inv_2_1355/Y gf180mcu_as_sc_mcu7t3v3__inv_2_1344/VNW VSUBS
+ gf180mcu_as_sc_mcu7t3v3__inv_2
Xgf180mcu_as_sc_mcu7t3v3__inv_2_1332 VSS VSS gf180mcu_as_sc_mcu7t3v3__inv_2_1340/Y
+ VSS gf180mcu_as_sc_mcu7t3v3__inv_2_1332/VNW VSUBS gf180mcu_as_sc_mcu7t3v3__inv_2
Xgf180mcu_as_sc_mcu7t3v3__inv_2_827 VSS VSS VSS VSS gf180mcu_as_sc_mcu7t3v3__inv_2_827/VNW
+ VSUBS gf180mcu_as_sc_mcu7t3v3__inv_2
Xgf180mcu_as_sc_mcu7t3v3__inv_2_816 VSS VSS VSS VSS gf180mcu_as_sc_mcu7t3v3__inv_2_816/VNW
+ VSUBS gf180mcu_as_sc_mcu7t3v3__inv_2
Xgf180mcu_as_sc_mcu7t3v3__inv_2_849 VSS VSS VSS VSS gf180mcu_as_sc_mcu7t3v3__inv_2_849/VNW
+ VSUBS gf180mcu_as_sc_mcu7t3v3__inv_2
Xgf180mcu_as_sc_mcu7t3v3__inv_2_805 VSS VSS VSS VSS gf180mcu_as_sc_mcu7t3v3__inv_2_838/VNW
+ VSUBS gf180mcu_as_sc_mcu7t3v3__inv_2
Xgf180mcu_as_sc_mcu7t3v3__inv_2_838 VSS VSS VSS VSS gf180mcu_as_sc_mcu7t3v3__inv_2_838/VNW
+ VSUBS gf180mcu_as_sc_mcu7t3v3__inv_2
Xgf180mcu_as_sc_mcu7t3v3__nand4_2_126 VSS VSS VSS VSS VSS VSS gf180mcu_as_sc_mcu7t3v3__nand4_2_126/Y
+ gf180mcu_as_sc_mcu7t3v3__inv_2_545/VNW VSUBS gf180mcu_as_sc_mcu7t3v3__nand4_2
Xgf180mcu_as_sc_mcu7t3v3__nand4_2_115 VSS gf180mcu_as_sc_mcu7t3v3__inv_2_304/VDD VSS
+ VSS VSS VSS VSS gf180mcu_as_sc_mcu7t3v3__inv_2_288/VNW VSUBS gf180mcu_as_sc_mcu7t3v3__nand4_2
Xgf180mcu_as_sc_mcu7t3v3__nand4_2_104 gf180mcu_as_sc_mcu7t3v3__inv_2_365/VDD gf180mcu_as_sc_mcu7t3v3__inv_2_365/VSS
+ VSS VSS VSS VSS VSS gf180mcu_as_sc_mcu7t3v3__inv_2_365/VNW VSUBS gf180mcu_as_sc_mcu7t3v3__nand4_2
Xu_t026_009 u_t026_009/c0_w0_bl u_t026_009/c0_w0_br u_t026_009/c0_w1_bl u_t026_009/c0_w1_br
+ u_t026_009/c0_r0_rbl u_t026_009/c0_r1_rbl u_t026_009/c1_w0_bl u_t026_009/c1_w0_br
+ u_t026_009/c1_w1_bl u_t026_009/c1_w1_br u_t026_009/c1_r0_rbl u_t026_009/c1_r1_rbl
+ u_t026_009/c2_w0_bl u_t026_009/c2_w0_br u_t026_009/c2_w1_bl u_t026_009/c2_w1_br
+ u_t026_009/c2_r0_rbl u_t026_009/c2_r1_rbl u_t026_009/c3_w0_bl u_t026_009/c3_w0_br
+ u_t026_009/c3_w1_bl u_t026_009/c3_w1_br u_t026_009/c3_r0_rbl u_t026_009/c3_r1_rbl
+ u_t026_009/r0_w0_wl u_t026_009/r0_w1_wl u_t026_009/r0_r0_rwl u_t026_009/r0_r1_rwl
+ u_t026_009/r1_w0_wl u_t026_009/r1_w1_wl u_t026_009/r1_r0_rwl u_t026_009/r1_r1_rwl
+ u_t026_009/r2_w0_wl u_t026_009/r2_w1_wl u_t026_009/r2_r0_rwl u_t026_009/r2_r1_rwl
+ u_t026_009/r3_w0_wl u_t026_009/r3_w1_wl u_t026_009/r3_r0_rwl u_t026_009/r3_r1_rwl
+ VSS VSS u_t026_009/m2_717_1265# u_t026_009/m2_603_2031# u_t026_009/m2_1290_336#
+ u_t026_009/m2_2000_2037# u_t026_009/m2_791_2909# u_t026_009/m2_7_2126# u_t026_009/m2_2154_2081#
+ u_t026_009/m2_1795_2037# u_t026_009/m2_871_303# u_t026_009/m2_431_438# u_t026_009/m2_1290_2898#
+ u_t026_009/m2_1714_1210# u_t026_009/m2_431_1982# u_t026_009/m2_512_1265# u_t026_009/m2_2573_2126#
+ u_t026_009/m2_603_1259# u_t026_009/m2_2074_2909# u_t026_009/m2_7_336# u_t026_009/m2_717_2037#
+ u_t026_009/m2_1886_2031# u_t026_009/m2_2573_336# u_t026_009/m2_7_2898# u_t026_009/m2_2000_1265#
+ u_t026_009/m2_512_2037# u_t026_009/m2_1795_1265# u_t026_009/m2_1714_1982# u_t026_009/m2_1886_1259#
+ u_t026_009/m2_1290_2126# u_t026_009/m2_1714_438# u_t026_009/m2_431_1210# u_t026_009/m2_2573_2898#
+ u_t026_009/m2_2154_303# u_t026_009/m2_871_2081# VSUBS detronyx_12t_2w2r_rc4_4x4_routed_5layer_direct
Xgf180mcu_as_sc_mcu7t3v3__nand4_2_65 gf180mcu_as_sc_mcu7t3v3__inv_2_8/VSS gf180mcu_as_sc_mcu7t3v3__inv_2_20/VDD
+ VSS VSS VSS VSS VSS gf180mcu_as_sc_mcu7t3v3__inv_2_16/VNW VSUBS gf180mcu_as_sc_mcu7t3v3__nand4_2
Xgf180mcu_as_sc_mcu7t3v3__nand4_2_159 gf180mcu_as_sc_mcu7t3v3__inv_2_576/VDD gf180mcu_as_sc_mcu7t3v3__inv_2_579/VDD
+ VSS VSS VSS VSS VSS gf180mcu_as_sc_mcu7t3v3__inv_2_576/VNW VSUBS gf180mcu_as_sc_mcu7t3v3__nand4_2
Xgf180mcu_as_sc_mcu7t3v3__nand4_2_137 VSS VSS VSS VSS VSS VSS VSS gf180mcu_as_sc_mcu7t3v3__inv_2_555/VNW
+ VSUBS gf180mcu_as_sc_mcu7t3v3__nand4_2
Xgf180mcu_as_sc_mcu7t3v3__nand4_2_21 gf180mcu_as_sc_mcu7t3v3__inv_2_143/VDD gf180mcu_as_sc_mcu7t3v3__inv_2_146/VDD
+ VSS VSS VSS VSS gf180mcu_as_sc_mcu7t3v3__nand4_2_21/Y gf180mcu_as_sc_mcu7t3v3__inv_2_143/VNW
+ VSUBS gf180mcu_as_sc_mcu7t3v3__nand4_2
Xgf180mcu_as_sc_mcu7t3v3__nand4_2_148 VSS VSS VSS VSS VSS VSS gf180mcu_as_sc_mcu7t3v3__nand4_2_148/Y
+ gf180mcu_as_sc_mcu7t3v3__inv_2_559/VNW VSUBS gf180mcu_as_sc_mcu7t3v3__nand4_2
Xgf180mcu_as_sc_mcu7t3v3__nand4_2_10 gf180mcu_as_sc_mcu7t3v3__inv_2_371/VSS gf180mcu_as_sc_mcu7t3v3__inv_2_113/VDD
+ VSS VSS VSS VSS VSS gf180mcu_as_sc_mcu7t3v3__inv_2_110/VNW VSUBS gf180mcu_as_sc_mcu7t3v3__nand4_2
Xgf180mcu_as_sc_mcu7t3v3__nand4_2_32 gf180mcu_as_sc_mcu7t3v3__inv_2_182/VDD gf180mcu_as_sc_mcu7t3v3__inv_2_371/VDD
+ VSS VSS VSS VSS gf180mcu_as_sc_mcu7t3v3__nand4_2_32/Y gf180mcu_as_sc_mcu7t3v3__inv_2_182/VNW
+ VSUBS gf180mcu_as_sc_mcu7t3v3__nand4_2
Xgf180mcu_as_sc_mcu7t3v3__nand4_2_43 gf180mcu_as_sc_mcu7t3v3__inv_2_257/VSS VSS VSS
+ VSS VSS VSS gf180mcu_as_sc_mcu7t3v3__nand4_2_43/Y gf180mcu_as_sc_mcu7t3v3__inv_2_209/VNW
+ VSUBS gf180mcu_as_sc_mcu7t3v3__nand4_2
Xgf180mcu_as_sc_mcu7t3v3__nand4_2_54 gf180mcu_as_sc_mcu7t3v3__inv_2_242/VDD VSS VSS
+ VSS VSS VSS VSS gf180mcu_as_sc_mcu7t3v3__inv_2_242/VNW VSUBS gf180mcu_as_sc_mcu7t3v3__nand4_2
Xgf180mcu_as_sc_mcu7t3v3__nand4_2_76 gf180mcu_as_sc_mcu7t3v3__inv_2_332/VDD VSS VSS
+ VSS VSS VSS VSS gf180mcu_as_sc_mcu7t3v3__inv_2_332/VNW VSUBS gf180mcu_as_sc_mcu7t3v3__nand4_2
Xgf180mcu_as_sc_mcu7t3v3__nand4_2_87 gf180mcu_as_sc_mcu7t3v3__inv_2_9/VDD gf180mcu_as_sc_mcu7t3v3__inv_2_9/VSS
+ VSS VSS VSS VSS VSS gf180mcu_as_sc_mcu7t3v3__inv_2_9/VNW VSUBS gf180mcu_as_sc_mcu7t3v3__nand4_2
Xgf180mcu_as_sc_mcu7t3v3__nand4_2_98 VSS gf180mcu_as_sc_mcu7t3v3__inv_2_350/VDD VSS
+ VSS VSS VSS VSS gf180mcu_as_sc_mcu7t3v3__inv_2_347/VNW VSUBS gf180mcu_as_sc_mcu7t3v3__nand4_2
Xu_t017_009 u_t017_009/c0_w0_bl u_t017_009/c0_w0_br u_t017_009/c0_w1_bl u_t017_009/c0_w1_br
+ u_t017_009/c0_r0_rbl u_t017_009/c0_r1_rbl u_t017_009/c1_w0_bl u_t017_009/c1_w0_br
+ u_t017_009/c1_w1_bl u_t017_009/c1_w1_br u_t017_009/c1_r0_rbl u_t017_009/c1_r1_rbl
+ u_t017_009/c2_w0_bl u_t017_009/c2_w0_br u_t017_009/c2_w1_bl u_t017_009/c2_w1_br
+ u_t017_009/c2_r0_rbl u_t017_009/c2_r1_rbl u_t017_009/c3_w0_bl u_t017_009/c3_w0_br
+ u_t017_009/c3_w1_bl u_t017_009/c3_w1_br u_t017_009/c3_r0_rbl u_t017_009/c3_r1_rbl
+ u_t017_009/r0_w0_wl u_t017_009/r0_w1_wl u_t017_009/r0_r0_rwl u_t017_009/r0_r1_rwl
+ u_t017_009/r1_w0_wl u_t017_009/r1_w1_wl u_t017_009/r1_r0_rwl u_t017_009/r1_r1_rwl
+ u_t017_009/r2_w0_wl u_t017_009/r2_w1_wl u_t017_009/r2_r0_rwl u_t017_009/r2_r1_rwl
+ u_t017_009/r3_w0_wl u_t017_009/r3_w1_wl u_t017_009/r3_r0_rwl u_t017_009/r3_r1_rwl
+ VSS VSS u_t017_009/m2_717_1265# u_t017_009/m2_603_2031# u_t017_009/m2_1290_336#
+ u_t017_009/m2_2000_2037# u_t017_009/m2_791_2909# u_t017_009/m2_7_2126# u_t017_009/m2_2154_2081#
+ u_t017_009/m2_1795_2037# u_t017_009/m2_871_303# u_t017_009/m2_431_438# u_t017_009/m2_1290_2898#
+ u_t017_009/m2_1714_1210# u_t017_009/m2_431_1982# u_t017_009/m2_512_1265# u_t017_009/m2_2573_2126#
+ u_t017_009/m2_603_1259# u_t017_009/m2_2074_2909# u_t017_009/m2_7_336# u_t017_009/m2_717_2037#
+ u_t017_009/m2_1886_2031# u_t017_009/m2_2573_336# u_t017_009/m2_7_2898# u_t017_009/m2_2000_1265#
+ u_t017_009/m2_512_2037# u_t017_009/m2_1795_1265# u_t017_009/m2_1714_1982# u_t017_009/m2_1886_1259#
+ u_t017_009/m2_1290_2126# u_t017_009/m2_1714_438# u_t017_009/m2_431_1210# u_t017_009/m2_2573_2898#
+ u_t017_009/m2_2154_303# u_t017_009/m2_871_2081# VSUBS detronyx_12t_2w2r_rc4_4x4_routed_5layer_direct
Xgf180mcu_as_sc_mcu7t3v3__inv_2_1140 gf180mcu_as_sc_mcu7t3v3__inv_2_1142/VDD VSS VSS
+ VSS gf180mcu_as_sc_mcu7t3v3__inv_2_1142/VNW VSUBS gf180mcu_as_sc_mcu7t3v3__inv_2
Xgf180mcu_as_sc_mcu7t3v3__inv_2_1151 VSS VSS gf180mcu_as_sc_mcu7t3v3__inv_2_1151/Y
+ VSS gf180mcu_as_sc_mcu7t3v3__inv_2_1151/VNW VSUBS gf180mcu_as_sc_mcu7t3v3__inv_2
Xgf180mcu_as_sc_mcu7t3v3__inv_2_1162 VSS VSS VSS VSS gf180mcu_as_sc_mcu7t3v3__inv_2_1299/VNW
+ VSUBS gf180mcu_as_sc_mcu7t3v3__inv_2
Xgf180mcu_as_sc_mcu7t3v3__inv_2_1195 VSS VSS VSS VSS gf180mcu_as_sc_mcu7t3v3__inv_2_1280/VNW
+ VSUBS gf180mcu_as_sc_mcu7t3v3__inv_2
Xgf180mcu_as_sc_mcu7t3v3__inv_2_1173 VSS VSS VSS VSS gf180mcu_as_sc_mcu7t3v3__inv_2_1295/VNW
+ VSUBS gf180mcu_as_sc_mcu7t3v3__inv_2
Xgf180mcu_as_sc_mcu7t3v3__inv_2_1184 VSS VSS VSS VSS gf180mcu_as_sc_mcu7t3v3__inv_2_1298/VNW
+ VSUBS gf180mcu_as_sc_mcu7t3v3__inv_2
Xu_t008_009 u_t008_009/c0_w0_bl u_t008_009/c0_w0_br u_t008_009/c0_w1_bl u_t008_009/c0_w1_br
+ u_t008_009/c0_r0_rbl u_t008_009/c0_r1_rbl u_t008_009/c1_w0_bl u_t008_009/c1_w0_br
+ u_t008_009/c1_w1_bl u_t008_009/c1_w1_br u_t008_009/c1_r0_rbl u_t008_009/c1_r1_rbl
+ u_t008_009/c2_w0_bl u_t008_009/c2_w0_br u_t008_009/c2_w1_bl u_t008_009/c2_w1_br
+ u_t008_009/c2_r0_rbl u_t008_009/c2_r1_rbl u_t008_009/c3_w0_bl u_t008_009/c3_w0_br
+ u_t008_009/c3_w1_bl u_t008_009/c3_w1_br u_t008_009/c3_r0_rbl u_t008_009/c3_r1_rbl
+ u_t008_009/r0_w0_wl u_t008_009/r0_w1_wl u_t008_009/r0_r0_rwl u_t008_009/r0_r1_rwl
+ u_t008_009/r1_w0_wl u_t008_009/r1_w1_wl u_t008_009/r1_r0_rwl u_t008_009/r1_r1_rwl
+ u_t008_009/r2_w0_wl u_t008_009/r2_w1_wl u_t008_009/r2_r0_rwl u_t008_009/r2_r1_rwl
+ u_t008_009/r3_w0_wl u_t008_009/r3_w1_wl u_t008_009/r3_r0_rwl u_t008_009/r3_r1_rwl
+ VSS VSS u_t008_009/m2_717_1265# u_t008_009/m2_603_2031# u_t008_009/m2_1290_336#
+ u_t008_009/m2_2000_2037# u_t008_009/m2_791_2909# u_t008_009/m2_7_2126# u_t008_009/m2_2154_2081#
+ u_t008_009/m2_1795_2037# u_t008_009/m2_871_303# u_t008_009/m2_431_438# u_t008_009/m2_1290_2898#
+ u_t008_009/m2_1714_1210# u_t008_009/m2_431_1982# u_t008_009/m2_512_1265# u_t008_009/m2_2573_2126#
+ u_t008_009/m2_603_1259# u_t008_009/m2_2074_2909# u_t008_009/m2_7_336# u_t008_009/m2_717_2037#
+ u_t008_009/m2_1886_2031# u_t008_009/m2_2573_336# u_t008_009/m2_7_2898# u_t008_009/m2_2000_1265#
+ u_t008_009/m2_512_2037# u_t008_009/m2_1795_1265# u_t008_009/m2_1714_1982# u_t008_009/m2_1886_1259#
+ u_t008_009/m2_1290_2126# u_t008_009/m2_1714_438# u_t008_009/m2_431_1210# u_t008_009/m2_2573_2898#
+ u_t008_009/m2_2154_303# u_t008_009/m2_871_2081# VSUBS detronyx_12t_2w2r_rc4_4x4_routed_5layer_direct
Xgf180mcu_as_sc_mcu7t3v3__inv_2_602 gf180mcu_as_sc_mcu7t3v3__inv_2_602/VDD gf180mcu_as_sc_mcu7t3v3__inv_2_606/VDD
+ gf180mcu_as_sc_mcu7t3v3__inv_2_602/Y VSS gf180mcu_as_sc_mcu7t3v3__inv_2_602/VNW
+ VSUBS gf180mcu_as_sc_mcu7t3v3__inv_2
Xu_t031_012 u_t031_012/c0_w0_bl u_t031_012/c0_w0_br u_t031_012/c0_w1_bl u_t031_012/c0_w1_br
+ u_t031_012/c0_r0_rbl u_t031_012/c0_r1_rbl u_t031_012/c1_w0_bl u_t031_012/c1_w0_br
+ u_t031_012/c1_w1_bl u_t031_012/c1_w1_br u_t031_012/c1_r0_rbl u_t031_012/c1_r1_rbl
+ u_t031_012/c2_w0_bl u_t031_012/c2_w0_br u_t031_012/c2_w1_bl u_t031_012/c2_w1_br
+ u_t031_012/c2_r0_rbl u_t031_012/c2_r1_rbl u_t031_012/c3_w0_bl u_t031_012/c3_w0_br
+ u_t031_012/c3_w1_bl u_t031_012/c3_w1_br u_t031_012/c3_r0_rbl u_t031_012/c3_r1_rbl
+ u_t031_012/r0_w0_wl u_t031_012/r0_w1_wl u_t031_012/r0_r0_rwl u_t031_012/r0_r1_rwl
+ u_t031_012/r1_w0_wl u_t031_012/r1_w1_wl u_t031_012/r1_r0_rwl u_t031_012/r1_r1_rwl
+ u_t031_012/r2_w0_wl u_t031_012/r2_w1_wl u_t031_012/r2_r0_rwl u_t031_012/r2_r1_rwl
+ u_t031_012/r3_w0_wl u_t031_012/r3_w1_wl u_t031_012/r3_r0_rwl u_t031_012/r3_r1_rwl
+ u_t031_012/VDD u_t031_012/VSS u_t031_012/m2_717_1265# u_t031_012/m2_603_2031# u_t031_012/m2_1290_336#
+ u_t031_012/m2_2000_2037# u_t031_012/m2_791_2909# u_t031_012/m2_7_2126# u_t031_012/m2_2154_2081#
+ u_t031_012/m2_1795_2037# u_t031_012/m2_871_303# u_t031_012/m2_431_438# u_t031_012/m2_1290_2898#
+ u_t031_012/m2_1714_1210# u_t031_012/m2_431_1982# u_t031_012/m2_512_1265# u_t031_012/m2_2573_2126#
+ u_t031_012/m2_603_1259# u_t031_012/m2_2074_2909# u_t031_012/m2_7_336# u_t031_012/m2_717_2037#
+ u_t031_012/m2_1886_2031# u_t031_012/m2_2573_336# u_t031_012/m2_7_2898# u_t031_012/m2_2000_1265#
+ u_t031_012/m2_512_2037# u_t031_012/m2_1795_1265# u_t031_012/m2_1714_1982# u_t031_012/m2_1886_1259#
+ u_t031_012/m2_1290_2126# u_t031_012/m2_1714_438# u_t031_012/m2_431_1210# u_t031_012/m2_2573_2898#
+ u_t031_012/m2_2154_303# u_t031_012/m2_871_2081# VSUBS detronyx_12t_2w2r_rc4_4x4_routed_5layer_direct
Xu_t031_001 u_t031_001/c0_w0_bl u_t031_001/c0_w0_br u_t031_001/c0_w1_bl u_t031_001/c0_w1_br
+ u_t031_001/c0_r0_rbl u_t031_001/c0_r1_rbl u_t031_001/c1_w0_bl u_t031_001/c1_w0_br
+ u_t031_001/c1_w1_bl u_t031_001/c1_w1_br u_t031_001/c1_r0_rbl u_t031_001/c1_r1_rbl
+ u_t031_001/c2_w0_bl u_t031_001/c2_w0_br u_t031_001/c2_w1_bl u_t031_001/c2_w1_br
+ u_t031_001/c2_r0_rbl u_t031_001/c2_r1_rbl u_t031_001/c3_w0_bl u_t031_001/c3_w0_br
+ u_t031_001/c3_w1_bl u_t031_001/c3_w1_br u_t031_001/c3_r0_rbl u_t031_001/c3_r1_rbl
+ u_t031_001/r0_w0_wl u_t031_001/r0_w1_wl u_t031_001/r0_r0_rwl u_t031_001/r0_r1_rwl
+ u_t031_001/r1_w0_wl u_t031_001/r1_w1_wl u_t031_001/r1_r0_rwl u_t031_001/r1_r1_rwl
+ u_t031_001/r2_w0_wl u_t031_001/r2_w1_wl u_t031_001/r2_r0_rwl u_t031_001/r2_r1_rwl
+ u_t031_001/r3_w0_wl u_t031_001/r3_w1_wl u_t031_001/r3_r0_rwl u_t031_001/r3_r1_rwl
+ VSS VSS u_t031_001/m2_717_1265# u_t031_001/m2_603_2031# u_t031_001/m2_1290_336#
+ u_t031_001/m2_2000_2037# u_t031_001/m2_791_2909# u_t031_001/m2_7_2126# u_t031_001/m2_2154_2081#
+ u_t031_001/m2_1795_2037# u_t031_001/m2_871_303# u_t031_001/m2_431_438# u_t031_001/m2_1290_2898#
+ u_t031_001/m2_1714_1210# u_t031_001/m2_431_1982# u_t031_001/m2_512_1265# u_t031_001/m2_2573_2126#
+ u_t031_001/m2_603_1259# u_t031_001/m2_2074_2909# u_t031_001/m2_7_336# u_t031_001/m2_717_2037#
+ u_t031_001/m2_1886_2031# u_t031_001/m2_2573_336# u_t031_001/m2_7_2898# u_t031_001/m2_2000_1265#
+ u_t031_001/m2_512_2037# u_t031_001/m2_1795_1265# u_t031_001/m2_1714_1982# u_t031_001/m2_1886_1259#
+ u_t031_001/m2_1290_2126# u_t031_001/m2_1714_438# u_t031_001/m2_431_1210# u_t031_001/m2_2573_2898#
+ u_t031_001/m2_2154_303# u_t031_001/m2_871_2081# VSUBS detronyx_12t_2w2r_rc4_4x4_routed_5layer_direct
Xgf180mcu_as_sc_mcu7t3v3__inv_2_613 gf180mcu_as_sc_mcu7t3v3__inv_2_617/VDD gf180mcu_as_sc_mcu7t3v3__inv_2_633/VDD
+ gf180mcu_as_sc_mcu7t3v3__inv_2_613/Y gf180mcu_as_sc_mcu7t3v3__inv_2_617/Y gf180mcu_as_sc_mcu7t3v3__inv_2_617/VNW
+ VSUBS gf180mcu_as_sc_mcu7t3v3__inv_2
Xgf180mcu_as_sc_mcu7t3v3__inv_2_624 gf180mcu_as_sc_mcu7t3v3__inv_2_624/VDD gf180mcu_as_sc_mcu7t3v3__inv_2_632/VDD
+ gf180mcu_as_sc_mcu7t3v3__inv_2_624/Y VSS gf180mcu_as_sc_mcu7t3v3__inv_2_624/VNW
+ VSUBS gf180mcu_as_sc_mcu7t3v3__inv_2
Xgf180mcu_as_sc_mcu7t3v3__inv_2_635 gf180mcu_as_sc_mcu7t3v3__inv_2_636/VDD gf180mcu_as_sc_mcu7t3v3__inv_2_638/VSS
+ gf180mcu_as_sc_mcu7t3v3__inv_2_635/Y gf180mcu_as_sc_mcu7t3v3__inv_2_636/Y gf180mcu_as_sc_mcu7t3v3__inv_2_636/VNW
+ VSUBS gf180mcu_as_sc_mcu7t3v3__inv_2
Xgf180mcu_as_sc_mcu7t3v3__inv_2_679 VSS gf180mcu_as_sc_mcu7t3v3__inv_2_679/VSS gf180mcu_as_sc_mcu7t3v3__inv_2_679/Y
+ VSS gf180mcu_as_sc_mcu7t3v3__inv_2_679/VNW VSUBS gf180mcu_as_sc_mcu7t3v3__inv_2
Xgf180mcu_as_sc_mcu7t3v3__inv_2_646 gf180mcu_as_sc_mcu7t3v3__inv_2_665/VSS VSS gf180mcu_as_sc_mcu7t3v3__inv_2_646/Y
+ VSS gf180mcu_as_sc_mcu7t3v3__inv_2_646/VNW VSUBS gf180mcu_as_sc_mcu7t3v3__inv_2
Xgf180mcu_as_sc_mcu7t3v3__inv_2_657 gf180mcu_as_sc_mcu7t3v3__inv_2_689/VSS VSS gf180mcu_as_sc_mcu7t3v3__inv_2_744/A
+ gf180mcu_as_sc_mcu7t3v3__inv_2_661/Y gf180mcu_as_sc_mcu7t3v3__inv_2_661/VNW VSUBS
+ gf180mcu_as_sc_mcu7t3v3__inv_2
Xgf180mcu_as_sc_mcu7t3v3__inv_2_668 gf180mcu_as_sc_mcu7t3v3__inv_2_746/VSS gf180mcu_as_sc_mcu7t3v3__inv_2_674/VDD
+ gf180mcu_as_sc_mcu7t3v3__inv_2_668/Y gf180mcu_as_sc_mcu7t3v3__inv_2_744/A gf180mcu_as_sc_mcu7t3v3__inv_2_670/VNW
+ VSUBS gf180mcu_as_sc_mcu7t3v3__inv_2
Xu_t022_001 u_t022_001/c0_w0_bl u_t022_001/c0_w0_br u_t022_001/c0_w1_bl u_t022_001/c0_w1_br
+ u_t022_001/c0_r0_rbl u_t022_001/c0_r1_rbl u_t022_001/c1_w0_bl u_t022_001/c1_w0_br
+ u_t022_001/c1_w1_bl u_t022_001/c1_w1_br u_t022_001/c1_r0_rbl u_t022_001/c1_r1_rbl
+ u_t022_001/c2_w0_bl u_t022_001/c2_w0_br u_t022_001/c2_w1_bl u_t022_001/c2_w1_br
+ u_t022_001/c2_r0_rbl u_t022_001/c2_r1_rbl u_t022_001/c3_w0_bl u_t022_001/c3_w0_br
+ u_t022_001/c3_w1_bl u_t022_001/c3_w1_br u_t022_001/c3_r0_rbl u_t022_001/c3_r1_rbl
+ u_t022_001/r0_w0_wl u_t022_001/r0_w1_wl u_t022_001/r0_r0_rwl u_t022_001/r0_r1_rwl
+ u_t022_001/r1_w0_wl u_t022_001/r1_w1_wl u_t022_001/r1_r0_rwl u_t022_001/r1_r1_rwl
+ u_t022_001/r2_w0_wl u_t022_001/r2_w1_wl u_t022_001/r2_r0_rwl u_t022_001/r2_r1_rwl
+ u_t022_001/r3_w0_wl u_t022_001/r3_w1_wl u_t022_001/r3_r0_rwl u_t022_001/r3_r1_rwl
+ VSS VSS u_t022_001/m2_717_1265# u_t022_001/m2_603_2031# u_t022_001/m2_1290_336#
+ u_t022_001/m2_2000_2037# u_t022_001/m2_791_2909# u_t022_001/m2_7_2126# u_t022_001/m2_2154_2081#
+ u_t022_001/m2_1795_2037# u_t022_001/m2_871_303# u_t022_001/m2_431_438# u_t022_001/m2_1290_2898#
+ u_t022_001/m2_1714_1210# u_t022_001/m2_431_1982# u_t022_001/m2_512_1265# u_t022_001/m2_2573_2126#
+ u_t022_001/m2_603_1259# u_t022_001/m2_2074_2909# u_t022_001/m2_7_336# u_t022_001/m2_717_2037#
+ u_t022_001/m2_1886_2031# u_t022_001/m2_2573_336# u_t022_001/m2_7_2898# u_t022_001/m2_2000_1265#
+ u_t022_001/m2_512_2037# u_t022_001/m2_1795_1265# u_t022_001/m2_1714_1982# u_t022_001/m2_1886_1259#
+ u_t022_001/m2_1290_2126# u_t022_001/m2_1714_438# u_t022_001/m2_431_1210# u_t022_001/m2_2573_2898#
+ u_t022_001/m2_2154_303# u_t022_001/m2_871_2081# VSUBS detronyx_12t_2w2r_rc4_4x4_routed_5layer_direct
Xu_t022_012 u_t022_012/c0_w0_bl u_t022_012/c0_w0_br u_t022_012/c0_w1_bl u_t022_012/c0_w1_br
+ u_t022_012/c0_r0_rbl u_t022_012/c0_r1_rbl u_t022_012/c1_w0_bl u_t022_012/c1_w0_br
+ u_t022_012/c1_w1_bl u_t022_012/c1_w1_br u_t022_012/c1_r0_rbl u_t022_012/c1_r1_rbl
+ u_t022_012/c2_w0_bl u_t022_012/c2_w0_br u_t022_012/c2_w1_bl u_t022_012/c2_w1_br
+ u_t022_012/c2_r0_rbl u_t022_012/c2_r1_rbl u_t022_012/c3_w0_bl u_t022_012/c3_w0_br
+ u_t022_012/c3_w1_bl u_t022_012/c3_w1_br u_t022_012/c3_r0_rbl u_t022_012/c3_r1_rbl
+ u_t022_012/r0_w0_wl u_t022_012/r0_w1_wl u_t022_012/r0_r0_rwl u_t022_012/r0_r1_rwl
+ u_t022_012/r1_w0_wl u_t022_012/r1_w1_wl u_t022_012/r1_r0_rwl u_t022_012/r1_r1_rwl
+ u_t022_012/r2_w0_wl u_t022_012/r2_w1_wl u_t022_012/r2_r0_rwl u_t022_012/r2_r1_rwl
+ u_t022_012/r3_w0_wl u_t022_012/r3_w1_wl u_t022_012/r3_r0_rwl u_t022_012/r3_r1_rwl
+ u_t022_012/VDD VSS u_t022_012/m2_717_1265# u_t022_012/m2_603_2031# u_t022_012/m2_1290_336#
+ u_t022_012/m2_2000_2037# u_t022_012/m2_791_2909# u_t022_012/m2_7_2126# u_t022_012/m2_2154_2081#
+ u_t022_012/m2_1795_2037# u_t022_012/m2_871_303# u_t022_012/m2_431_438# u_t022_012/m2_1290_2898#
+ u_t022_012/m2_1714_1210# u_t022_012/m2_431_1982# u_t022_012/m2_512_1265# u_t022_012/m2_2573_2126#
+ u_t022_012/m2_603_1259# u_t022_012/m2_2074_2909# u_t022_012/m2_7_336# u_t022_012/m2_717_2037#
+ u_t022_012/m2_1886_2031# u_t022_012/m2_2573_336# u_t022_012/m2_7_2898# u_t022_012/m2_2000_1265#
+ u_t022_012/m2_512_2037# u_t022_012/m2_1795_1265# u_t022_012/m2_1714_1982# u_t022_012/m2_1886_1259#
+ u_t022_012/m2_1290_2126# u_t022_012/m2_1714_438# u_t022_012/m2_431_1210# u_t022_012/m2_2573_2898#
+ u_t022_012/m2_2154_303# u_t022_012/m2_871_2081# VSUBS detronyx_12t_2w2r_rc4_4x4_routed_5layer_direct
Xgf180mcu_as_sc_mcu7t3v3__nand4_2_490 gf180mcu_as_sc_mcu7t3v3__inv_2_1684/VDD VSS
+ VSS VSS VSS VSS VSS gf180mcu_as_sc_mcu7t3v3__inv_2_1684/VNW VSUBS gf180mcu_as_sc_mcu7t3v3__nand4_2
Xu_t013_012 u_t013_012/c0_w0_bl u_t013_012/c0_w0_br u_t013_012/c0_w1_bl u_t013_012/c0_w1_br
+ u_t013_012/c0_r0_rbl u_t013_012/c0_r1_rbl u_t013_012/c1_w0_bl u_t013_012/c1_w0_br
+ u_t013_012/c1_w1_bl u_t013_012/c1_w1_br u_t013_012/c1_r0_rbl u_t013_012/c1_r1_rbl
+ u_t013_012/c2_w0_bl u_t013_012/c2_w0_br u_t013_012/c2_w1_bl u_t013_012/c2_w1_br
+ u_t013_012/c2_r0_rbl u_t013_012/c2_r1_rbl u_t013_012/c3_w0_bl u_t013_012/c3_w0_br
+ u_t013_012/c3_w1_bl u_t013_012/c3_w1_br u_t013_012/c3_r0_rbl u_t013_012/c3_r1_rbl
+ u_t013_012/r0_w0_wl u_t013_012/r0_w1_wl u_t013_012/r0_r0_rwl u_t013_012/r0_r1_rwl
+ u_t013_012/r1_w0_wl u_t013_012/r1_w1_wl u_t013_012/r1_r0_rwl u_t013_012/r1_r1_rwl
+ u_t013_012/r2_w0_wl u_t013_012/r2_w1_wl u_t013_012/r2_r0_rwl u_t013_012/r2_r1_rwl
+ u_t013_012/r3_w0_wl u_t013_012/r3_w1_wl u_t013_012/r3_r0_rwl u_t013_012/r3_r1_rwl
+ u_t013_012/VDD VSS u_t013_012/m2_717_1265# u_t013_012/m2_603_2031# u_t013_012/m2_1290_336#
+ u_t013_012/m2_2000_2037# u_t013_012/m2_791_2909# u_t013_012/m2_7_2126# u_t013_012/m2_2154_2081#
+ u_t013_012/m2_1795_2037# u_t013_012/m2_871_303# u_t013_012/m2_431_438# u_t013_012/m2_1290_2898#
+ u_t013_012/m2_1714_1210# u_t013_012/m2_431_1982# u_t013_012/m2_512_1265# u_t013_012/m2_2573_2126#
+ u_t013_012/m2_603_1259# u_t013_012/m2_2074_2909# u_t013_012/m2_7_336# u_t013_012/m2_717_2037#
+ u_t013_012/m2_1886_2031# u_t013_012/m2_2573_336# u_t013_012/m2_7_2898# u_t013_012/m2_2000_1265#
+ u_t013_012/m2_512_2037# u_t013_012/m2_1795_1265# u_t013_012/m2_1714_1982# u_t013_012/m2_1886_1259#
+ u_t013_012/m2_1290_2126# u_t013_012/m2_1714_438# u_t013_012/m2_431_1210# u_t013_012/m2_2573_2898#
+ u_t013_012/m2_2154_303# u_t013_012/m2_871_2081# VSUBS detronyx_12t_2w2r_rc4_4x4_routed_5layer_direct
Xu_t013_001 u_t013_001/c0_w0_bl u_t013_001/c0_w0_br u_t013_001/c0_w1_bl u_t013_001/c0_w1_br
+ u_t013_001/c0_r0_rbl u_t013_001/c0_r1_rbl u_t013_001/c1_w0_bl u_t013_001/c1_w0_br
+ u_t013_001/c1_w1_bl u_t013_001/c1_w1_br u_t013_001/c1_r0_rbl u_t013_001/c1_r1_rbl
+ u_t013_001/c2_w0_bl u_t013_001/c2_w0_br u_t013_001/c2_w1_bl u_t013_001/c2_w1_br
+ u_t013_001/c2_r0_rbl u_t013_001/c2_r1_rbl u_t013_001/c3_w0_bl u_t013_001/c3_w0_br
+ u_t013_001/c3_w1_bl u_t013_001/c3_w1_br u_t013_001/c3_r0_rbl u_t013_001/c3_r1_rbl
+ u_t013_001/r0_w0_wl u_t013_001/r0_w1_wl u_t013_001/r0_r0_rwl u_t013_001/r0_r1_rwl
+ u_t013_001/r1_w0_wl u_t013_001/r1_w1_wl u_t013_001/r1_r0_rwl u_t013_001/r1_r1_rwl
+ u_t013_001/r2_w0_wl u_t013_001/r2_w1_wl u_t013_001/r2_r0_rwl u_t013_001/r2_r1_rwl
+ u_t013_001/r3_w0_wl u_t013_001/r3_w1_wl u_t013_001/r3_r0_rwl u_t013_001/r3_r1_rwl
+ VSS VSS u_t013_001/m2_717_1265# u_t013_001/m2_603_2031# u_t013_001/m2_1290_336#
+ u_t013_001/m2_2000_2037# u_t013_001/m2_791_2909# u_t013_001/m2_7_2126# u_t013_001/m2_2154_2081#
+ u_t013_001/m2_1795_2037# u_t013_001/m2_871_303# u_t013_001/m2_431_438# u_t013_001/m2_1290_2898#
+ u_t013_001/m2_1714_1210# u_t013_001/m2_431_1982# u_t013_001/m2_512_1265# u_t013_001/m2_2573_2126#
+ u_t013_001/m2_603_1259# u_t013_001/m2_2074_2909# u_t013_001/m2_7_336# u_t013_001/m2_717_2037#
+ u_t013_001/m2_1886_2031# u_t013_001/m2_2573_336# u_t013_001/m2_7_2898# u_t013_001/m2_2000_1265#
+ u_t013_001/m2_512_2037# u_t013_001/m2_1795_1265# u_t013_001/m2_1714_1982# u_t013_001/m2_1886_1259#
+ u_t013_001/m2_1290_2126# u_t013_001/m2_1714_438# u_t013_001/m2_431_1210# u_t013_001/m2_2573_2898#
+ u_t013_001/m2_2154_303# u_t013_001/m2_871_2081# VSUBS detronyx_12t_2w2r_rc4_4x4_routed_5layer_direct
Xgf180mcu_as_sc_mcu7t3v3__inv_2_443 VSS VSS VSS VSS gf180mcu_as_sc_mcu7t3v3__inv_2_545/VNW
+ VSUBS gf180mcu_as_sc_mcu7t3v3__inv_2
Xgf180mcu_as_sc_mcu7t3v3__inv_2_421 gf180mcu_as_sc_mcu7t3v3__nor2_2_7/VDD gf180mcu_as_sc_mcu7t3v3__nand3_2_4/VSS
+ gf180mcu_as_sc_mcu7t3v3__inv_2_421/Y VSS gf180mcu_as_sc_mcu7t3v3__nor2_2_7/VNW VSUBS
+ gf180mcu_as_sc_mcu7t3v3__inv_2
Xgf180mcu_as_sc_mcu7t3v3__inv_2_410 gf180mcu_as_sc_mcu7t3v3__nor2_2_4/VDD gf180mcu_as_sc_mcu7t3v3__nand2_2_3/VSS
+ VSS VSS gf180mcu_as_sc_mcu7t3v3__nor2_2_4/VNW VSUBS gf180mcu_as_sc_mcu7t3v3__inv_2
Xgf180mcu_as_sc_mcu7t3v3__inv_2_454 gf180mcu_as_sc_mcu7t3v3__nand3_2_9/VDD gf180mcu_as_sc_mcu7t3v3__nor2_2_7/VSS
+ VSS VSS gf180mcu_as_sc_mcu7t3v3__nand3_2_9/VNW VSUBS gf180mcu_as_sc_mcu7t3v3__inv_2
Xgf180mcu_as_sc_mcu7t3v3__inv_2_432 gf180mcu_as_sc_mcu7t3v3__nand3_2_9/VDD gf180mcu_as_sc_mcu7t3v3__nor2_2_7/VSS
+ VSS VSS gf180mcu_as_sc_mcu7t3v3__nand3_2_9/VNW VSUBS gf180mcu_as_sc_mcu7t3v3__inv_2
Xu_t004_012 u_t004_012/c0_w0_bl u_t004_012/c0_w0_br u_t004_012/c0_w1_bl u_t004_012/c0_w1_br
+ u_t004_012/c0_r0_rbl u_t004_012/c0_r1_rbl u_t004_012/c1_w0_bl u_t004_012/c1_w0_br
+ u_t004_012/c1_w1_bl u_t004_012/c1_w1_br u_t004_012/c1_r0_rbl u_t004_012/c1_r1_rbl
+ u_t004_012/c2_w0_bl u_t004_012/c2_w0_br u_t004_012/c2_w1_bl u_t004_012/c2_w1_br
+ u_t004_012/c2_r0_rbl u_t004_012/c2_r1_rbl u_t004_012/c3_w0_bl u_t004_012/c3_w0_br
+ u_t004_012/c3_w1_bl u_t004_012/c3_w1_br u_t004_012/c3_r0_rbl u_t004_012/c3_r1_rbl
+ u_t004_012/r0_w0_wl u_t004_012/r0_w1_wl u_t004_012/r0_r0_rwl u_t004_012/r0_r1_rwl
+ u_t004_012/r1_w0_wl u_t004_012/r1_w1_wl u_t004_012/r1_r0_rwl u_t004_012/r1_r1_rwl
+ u_t004_012/r2_w0_wl u_t004_012/r2_w1_wl u_t004_012/r2_r0_rwl u_t004_012/r2_r1_rwl
+ u_t004_012/r3_w0_wl u_t004_012/r3_w1_wl u_t004_012/r3_r0_rwl u_t004_012/r3_r1_rwl
+ u_t004_012/VDD VSS u_t004_012/m2_717_1265# u_t004_012/m2_603_2031# u_t004_012/m2_1290_336#
+ u_t004_012/m2_2000_2037# u_t004_012/m2_791_2909# u_t004_012/m2_7_2126# u_t004_012/m2_2154_2081#
+ u_t004_012/m2_1795_2037# u_t004_012/m2_871_303# u_t004_012/m2_431_438# u_t004_012/m2_1290_2898#
+ u_t004_012/m2_1714_1210# u_t004_012/m2_431_1982# u_t004_012/m2_512_1265# u_t004_012/m2_2573_2126#
+ u_t004_012/m2_603_1259# u_t004_012/m2_2074_2909# u_t004_012/m2_7_336# u_t004_012/m2_717_2037#
+ u_t004_012/m2_1886_2031# u_t004_012/m2_2573_336# u_t004_012/m2_7_2898# u_t004_012/m2_2000_1265#
+ u_t004_012/m2_512_2037# u_t004_012/m2_1795_1265# u_t004_012/m2_1714_1982# u_t004_012/m2_1886_1259#
+ u_t004_012/m2_1290_2126# u_t004_012/m2_1714_438# u_t004_012/m2_431_1210# u_t004_012/m2_2573_2898#
+ u_t004_012/m2_2154_303# u_t004_012/m2_871_2081# VSUBS detronyx_12t_2w2r_rc4_4x4_routed_5layer_direct
Xu_t004_001 u_t004_001/c0_w0_bl u_t004_001/c0_w0_br u_t004_001/c0_w1_bl u_t004_001/c0_w1_br
+ u_t004_001/c0_r0_rbl u_t004_001/c0_r1_rbl u_t004_001/c1_w0_bl u_t004_001/c1_w0_br
+ u_t004_001/c1_w1_bl u_t004_001/c1_w1_br u_t004_001/c1_r0_rbl u_t004_001/c1_r1_rbl
+ u_t004_001/c2_w0_bl u_t004_001/c2_w0_br u_t004_001/c2_w1_bl u_t004_001/c2_w1_br
+ u_t004_001/c2_r0_rbl u_t004_001/c2_r1_rbl u_t004_001/c3_w0_bl u_t004_001/c3_w0_br
+ u_t004_001/c3_w1_bl u_t004_001/c3_w1_br u_t004_001/c3_r0_rbl u_t004_001/c3_r1_rbl
+ u_t004_001/r0_w0_wl u_t004_001/r0_w1_wl u_t004_001/r0_r0_rwl u_t004_001/r0_r1_rwl
+ u_t004_001/r1_w0_wl u_t004_001/r1_w1_wl u_t004_001/r1_r0_rwl u_t004_001/r1_r1_rwl
+ u_t004_001/r2_w0_wl u_t004_001/r2_w1_wl u_t004_001/r2_r0_rwl u_t004_001/r2_r1_rwl
+ u_t004_001/r3_w0_wl u_t004_001/r3_w1_wl u_t004_001/r3_r0_rwl u_t004_001/r3_r1_rwl
+ VSS VSS u_t004_001/m2_717_1265# u_t004_001/m2_603_2031# u_t004_001/m2_1290_336#
+ u_t004_001/m2_2000_2037# u_t004_001/m2_791_2909# u_t004_001/m2_7_2126# u_t004_001/m2_2154_2081#
+ u_t004_001/m2_1795_2037# u_t004_001/m2_871_303# u_t004_001/m2_431_438# u_t004_001/m2_1290_2898#
+ u_t004_001/m2_1714_1210# u_t004_001/m2_431_1982# u_t004_001/m2_512_1265# u_t004_001/m2_2573_2126#
+ u_t004_001/m2_603_1259# u_t004_001/m2_2074_2909# u_t004_001/m2_7_336# u_t004_001/m2_717_2037#
+ u_t004_001/m2_1886_2031# u_t004_001/m2_2573_336# u_t004_001/m2_7_2898# u_t004_001/m2_2000_1265#
+ u_t004_001/m2_512_2037# u_t004_001/m2_1795_1265# u_t004_001/m2_1714_1982# u_t004_001/m2_1886_1259#
+ u_t004_001/m2_1290_2126# u_t004_001/m2_1714_438# u_t004_001/m2_431_1210# u_t004_001/m2_2573_2898#
+ u_t004_001/m2_2154_303# u_t004_001/m2_871_2081# VSUBS detronyx_12t_2w2r_rc4_4x4_routed_5layer_direct
Xgf180mcu_as_sc_mcu7t3v3__inv_2_487 VSS VSS VSS VSS gf180mcu_as_sc_mcu7t3v3__inv_2_550/VNW
+ VSUBS gf180mcu_as_sc_mcu7t3v3__inv_2
Xgf180mcu_as_sc_mcu7t3v3__inv_2_476 gf180mcu_as_sc_mcu7t3v3__nor2_2_7/VDD gf180mcu_as_sc_mcu7t3v3__nor2_2_7/VSS
+ VSS VSS gf180mcu_as_sc_mcu7t3v3__nor2_2_7/VNW VSUBS gf180mcu_as_sc_mcu7t3v3__inv_2
Xgf180mcu_as_sc_mcu7t3v3__inv_2_465 gf180mcu_as_sc_mcu7t3v3__nand3_2_9/VDD gf180mcu_as_sc_mcu7t3v3__nor2_2_4/VSS
+ VSS VSS gf180mcu_as_sc_mcu7t3v3__nand3_2_9/VNW VSUBS gf180mcu_as_sc_mcu7t3v3__inv_2
Xgf180mcu_as_sc_mcu7t3v3__inv_2_498 VSS VSS VSS VSS gf180mcu_as_sc_mcu7t3v3__inv_2_561/VNW
+ VSUBS gf180mcu_as_sc_mcu7t3v3__inv_2
Xu_t010_015 u_t010_015/c0_w0_bl u_t010_015/c0_w0_br u_t010_015/c0_w1_bl u_t010_015/c0_w1_br
+ u_t010_015/c0_r0_rbl u_t010_015/c0_r1_rbl u_t010_015/c1_w0_bl u_t010_015/c1_w0_br
+ u_t010_015/c1_w1_bl u_t010_015/c1_w1_br u_t010_015/c1_r0_rbl u_t010_015/c1_r1_rbl
+ u_t010_015/c2_w0_bl u_t010_015/c2_w0_br u_t010_015/c2_w1_bl u_t010_015/c2_w1_br
+ u_t010_015/c2_r0_rbl u_t010_015/c2_r1_rbl u_t010_015/c3_w0_bl u_t010_015/c3_w0_br
+ u_t010_015/c3_w1_bl u_t010_015/c3_w1_br u_t010_015/c3_r0_rbl u_t010_015/c3_r1_rbl
+ u_t010_015/r0_w0_wl u_t010_015/r0_w1_wl u_t010_015/r0_r0_rwl u_t010_015/r0_r1_rwl
+ u_t010_015/r1_w0_wl u_t010_015/r1_w1_wl u_t010_015/r1_r0_rwl u_t010_015/r1_r1_rwl
+ u_t010_015/r2_w0_wl u_t010_015/r2_w1_wl u_t010_015/r2_r0_rwl u_t010_015/r2_r1_rwl
+ u_t010_015/r3_w0_wl u_t010_015/r3_w1_wl u_t010_015/r3_r0_rwl u_t010_015/r3_r1_rwl
+ VSS u_t010_015/VSS u_t010_015/m2_717_1265# u_t010_015/m2_603_2031# u_t010_015/m2_1290_336#
+ u_t010_015/m2_2000_2037# u_t010_015/m2_791_2909# u_t010_015/m2_7_2126# u_t010_015/m2_2154_2081#
+ u_t010_015/m2_1795_2037# u_t010_015/m2_871_303# u_t010_015/m2_431_438# u_t010_015/m2_1290_2898#
+ u_t010_015/m2_1714_1210# u_t010_015/m2_431_1982# u_t010_015/m2_512_1265# u_t010_015/m2_2573_2126#
+ u_t010_015/m2_603_1259# u_t010_015/m2_2074_2909# u_t010_015/m2_7_336# u_t010_015/m2_717_2037#
+ u_t010_015/m2_1886_2031# u_t010_015/m2_2573_336# u_t010_015/m2_7_2898# u_t010_015/m2_2000_1265#
+ u_t010_015/m2_512_2037# u_t010_015/m2_1795_1265# u_t010_015/m2_1714_1982# u_t010_015/m2_1886_1259#
+ u_t010_015/m2_1290_2126# u_t010_015/m2_1714_438# u_t010_015/m2_431_1210# u_t010_015/m2_2573_2898#
+ u_t010_015/m2_2154_303# u_t010_015/m2_871_2081# VSUBS detronyx_12t_2w2r_rc4_4x4_routed_5layer_direct
Xu_t010_004 u_t010_004/c0_w0_bl u_t010_004/c0_w0_br u_t010_004/c0_w1_bl u_t010_004/c0_w1_br
+ u_t010_004/c0_r0_rbl u_t010_004/c0_r1_rbl u_t010_004/c1_w0_bl u_t010_004/c1_w0_br
+ u_t010_004/c1_w1_bl u_t010_004/c1_w1_br u_t010_004/c1_r0_rbl u_t010_004/c1_r1_rbl
+ u_t010_004/c2_w0_bl u_t010_004/c2_w0_br u_t010_004/c2_w1_bl u_t010_004/c2_w1_br
+ u_t010_004/c2_r0_rbl u_t010_004/c2_r1_rbl u_t010_004/c3_w0_bl u_t010_004/c3_w0_br
+ u_t010_004/c3_w1_bl u_t010_004/c3_w1_br u_t010_004/c3_r0_rbl u_t010_004/c3_r1_rbl
+ u_t010_004/r0_w0_wl u_t010_004/r0_w1_wl u_t010_004/r0_r0_rwl u_t010_004/r0_r1_rwl
+ u_t010_004/r1_w0_wl u_t010_004/r1_w1_wl u_t010_004/r1_r0_rwl u_t010_004/r1_r1_rwl
+ u_t010_004/r2_w0_wl u_t010_004/r2_w1_wl u_t010_004/r2_r0_rwl u_t010_004/r2_r1_rwl
+ u_t010_004/r3_w0_wl u_t010_004/r3_w1_wl u_t010_004/r3_r0_rwl u_t010_004/r3_r1_rwl
+ u_t010_004/VDD u_t010_004/VSS u_t010_004/m2_717_1265# u_t010_004/m2_603_2031# u_t010_004/m2_1290_336#
+ u_t010_004/m2_2000_2037# u_t010_004/m2_791_2909# u_t010_004/m2_7_2126# u_t010_004/m2_2154_2081#
+ u_t010_004/m2_1795_2037# u_t010_004/m2_871_303# u_t010_004/m2_431_438# u_t010_004/m2_1290_2898#
+ u_t010_004/m2_1714_1210# u_t010_004/m2_431_1982# u_t010_004/m2_512_1265# u_t010_004/m2_2573_2126#
+ u_t010_004/m2_603_1259# u_t010_004/m2_2074_2909# u_t010_004/m2_7_336# u_t010_004/m2_717_2037#
+ u_t010_004/m2_1886_2031# u_t010_004/m2_2573_336# u_t010_004/m2_7_2898# u_t010_004/m2_2000_1265#
+ u_t010_004/m2_512_2037# u_t010_004/m2_1795_1265# u_t010_004/m2_1714_1982# u_t010_004/m2_1886_1259#
+ u_t010_004/m2_1290_2126# u_t010_004/m2_1714_438# u_t010_004/m2_431_1210# u_t010_004/m2_2573_2898#
+ u_t010_004/m2_2154_303# u_t010_004/m2_871_2081# VSUBS detronyx_12t_2w2r_rc4_4x4_routed_5layer_direct
Xu_t001_015 u_t001_015/c0_w0_bl u_t001_015/c0_w0_br u_t001_015/c0_w1_bl u_t001_015/c0_w1_br
+ u_t001_015/c0_r0_rbl u_t001_015/c0_r1_rbl u_t001_015/c1_w0_bl u_t001_015/c1_w0_br
+ u_t001_015/c1_w1_bl u_t001_015/c1_w1_br u_t001_015/c1_r0_rbl u_t001_015/c1_r1_rbl
+ u_t001_015/c2_w0_bl u_t001_015/c2_w0_br u_t001_015/c2_w1_bl u_t001_015/c2_w1_br
+ u_t001_015/c2_r0_rbl u_t001_015/c2_r1_rbl u_t001_015/c3_w0_bl u_t001_015/c3_w0_br
+ u_t001_015/c3_w1_bl u_t001_015/c3_w1_br u_t001_015/c3_r0_rbl u_t001_015/c3_r1_rbl
+ u_t001_015/r0_w0_wl u_t001_015/r0_w1_wl u_t001_015/r0_r0_rwl u_t001_015/r0_r1_rwl
+ u_t001_015/r1_w0_wl u_t001_015/r1_w1_wl u_t001_015/r1_r0_rwl u_t001_015/r1_r1_rwl
+ u_t001_015/r2_w0_wl u_t001_015/r2_w1_wl u_t001_015/r2_r0_rwl u_t001_015/r2_r1_rwl
+ u_t001_015/r3_w0_wl u_t001_015/r3_w1_wl u_t001_015/r3_r0_rwl u_t001_015/r3_r1_rwl
+ VSS VSS u_t001_015/m2_717_1265# u_t001_015/m2_603_2031# u_t001_015/m2_1290_336#
+ u_t001_015/m2_2000_2037# u_t001_015/m2_791_2909# u_t001_015/m2_7_2126# u_t001_015/m2_2154_2081#
+ u_t001_015/m2_1795_2037# u_t001_015/m2_871_303# u_t001_015/m2_431_438# u_t001_015/m2_1290_2898#
+ u_t001_015/m2_1714_1210# u_t001_015/m2_431_1982# u_t001_015/m2_512_1265# u_t001_015/m2_2573_2126#
+ u_t001_015/m2_603_1259# u_t001_015/m2_2074_2909# u_t001_015/m2_7_336# u_t001_015/m2_717_2037#
+ u_t001_015/m2_1886_2031# u_t001_015/m2_2573_336# u_t001_015/m2_7_2898# u_t001_015/m2_2000_1265#
+ u_t001_015/m2_512_2037# u_t001_015/m2_1795_1265# u_t001_015/m2_1714_1982# u_t001_015/m2_1886_1259#
+ u_t001_015/m2_1290_2126# u_t001_015/m2_1714_438# u_t001_015/m2_431_1210# u_t001_015/m2_2573_2898#
+ u_t001_015/m2_2154_303# u_t001_015/m2_871_2081# VSUBS detronyx_12t_2w2r_rc4_4x4_routed_5layer_direct
Xu_t001_004 u_t001_004/c0_w0_bl u_t001_004/c0_w0_br u_t001_004/c0_w1_bl u_t001_004/c0_w1_br
+ u_t001_004/c0_r0_rbl u_t001_004/c0_r1_rbl u_t001_004/c1_w0_bl u_t001_004/c1_w0_br
+ u_t001_004/c1_w1_bl u_t001_004/c1_w1_br u_t001_004/c1_r0_rbl u_t001_004/c1_r1_rbl
+ u_t001_004/c2_w0_bl u_t001_004/c2_w0_br u_t001_004/c2_w1_bl u_t001_004/c2_w1_br
+ u_t001_004/c2_r0_rbl u_t001_004/c2_r1_rbl u_t001_004/c3_w0_bl u_t001_004/c3_w0_br
+ u_t001_004/c3_w1_bl u_t001_004/c3_w1_br u_t001_004/c3_r0_rbl u_t001_004/c3_r1_rbl
+ u_t001_004/r0_w0_wl u_t001_004/r0_w1_wl u_t001_004/r0_r0_rwl u_t001_004/r0_r1_rwl
+ u_t001_004/r1_w0_wl u_t001_004/r1_w1_wl u_t001_004/r1_r0_rwl u_t001_004/r1_r1_rwl
+ u_t001_004/r2_w0_wl u_t001_004/r2_w1_wl u_t001_004/r2_r0_rwl u_t001_004/r2_r1_rwl
+ u_t001_004/r3_w0_wl u_t001_004/r3_w1_wl u_t001_004/r3_r0_rwl u_t001_004/r3_r1_rwl
+ u_t001_004/VDD VSS u_t001_004/m2_717_1265# u_t001_004/m2_603_2031# u_t001_004/m2_1290_336#
+ u_t001_004/m2_2000_2037# u_t001_004/m2_791_2909# u_t001_004/m2_7_2126# u_t001_004/m2_2154_2081#
+ u_t001_004/m2_1795_2037# u_t001_004/m2_871_303# u_t001_004/m2_431_438# u_t001_004/m2_1290_2898#
+ u_t001_004/m2_1714_1210# u_t001_004/m2_431_1982# u_t001_004/m2_512_1265# u_t001_004/m2_2573_2126#
+ u_t001_004/m2_603_1259# u_t001_004/m2_2074_2909# u_t001_004/m2_7_336# u_t001_004/m2_717_2037#
+ u_t001_004/m2_1886_2031# u_t001_004/m2_2573_336# u_t001_004/m2_7_2898# u_t001_004/m2_2000_1265#
+ u_t001_004/m2_512_2037# u_t001_004/m2_1795_1265# u_t001_004/m2_1714_1982# u_t001_004/m2_1886_1259#
+ u_t001_004/m2_1290_2126# u_t001_004/m2_1714_438# u_t001_004/m2_431_1210# u_t001_004/m2_2573_2898#
+ u_t001_004/m2_2154_303# u_t001_004/m2_871_2081# VSUBS detronyx_12t_2w2r_rc4_4x4_routed_5layer_direct
Xgf180mcu_as_sc_mcu7t3v3__inv_2_273 gf180mcu_as_sc_mcu7t3v3__inv_2_281/VDD VSS VSS
+ gf180mcu_as_sc_mcu7t3v3__inv_2_61/Y gf180mcu_as_sc_mcu7t3v3__inv_2_281/VNW VSUBS
+ gf180mcu_as_sc_mcu7t3v3__inv_2
Xgf180mcu_as_sc_mcu7t3v3__inv_2_262 gf180mcu_as_sc_mcu7t3v3__inv_2_308/VSS VSS VSS
+ gf180mcu_as_sc_mcu7t3v3__inv_2_61/Y gf180mcu_as_sc_mcu7t3v3__inv_2_264/VNW VSUBS
+ gf180mcu_as_sc_mcu7t3v3__inv_2
Xgf180mcu_as_sc_mcu7t3v3__inv_2_284 VSS VSS VSS gf180mcu_as_sc_mcu7t3v3__inv_2_301/Y
+ gf180mcu_as_sc_mcu7t3v3__inv_2_287/VNW VSUBS gf180mcu_as_sc_mcu7t3v3__inv_2
Xgf180mcu_as_sc_mcu7t3v3__inv_2_295 VSS gf180mcu_as_sc_mcu7t3v3__inv_2_301/VDD VSS
+ gf180mcu_as_sc_mcu7t3v3__inv_2_301/Y gf180mcu_as_sc_mcu7t3v3__inv_2_298/VNW VSUBS
+ gf180mcu_as_sc_mcu7t3v3__inv_2
Xgf180mcu_as_sc_mcu7t3v3__inv_2_251 gf180mcu_as_sc_mcu7t3v3__inv_2_251/VDD VSS VSS
+ VSS gf180mcu_as_sc_mcu7t3v3__inv_2_251/VNW VSUBS gf180mcu_as_sc_mcu7t3v3__inv_2
Xgf180mcu_as_sc_mcu7t3v3__inv_2_240 gf180mcu_as_sc_mcu7t3v3__inv_2_242/VDD VSS gf180mcu_as_sc_mcu7t3v3__inv_2_240/Y
+ VSS gf180mcu_as_sc_mcu7t3v3__inv_2_242/VNW VSUBS gf180mcu_as_sc_mcu7t3v3__inv_2
Xgf180mcu_as_sc_mcu7t3v3__inv_2_1706 gf180mcu_as_sc_mcu7t3v3__nor2_2_4/VDD gf180mcu_as_sc_mcu7t3v3__nand2_2_3/VSS
+ VSS VSS gf180mcu_as_sc_mcu7t3v3__nor2_2_4/VNW VSUBS gf180mcu_as_sc_mcu7t3v3__inv_2
Xgf180mcu_as_sc_mcu7t3v3__inv_2_1717 gf180mcu_as_sc_mcu7t3v3__inv_2_1717/VDD VSS gf180mcu_as_sc_mcu7t3v3__inv_2_1717/Y
+ VSS gf180mcu_as_sc_mcu7t3v3__inv_2_1717/VNW VSUBS gf180mcu_as_sc_mcu7t3v3__inv_2
Xgf180mcu_as_sc_mcu7t3v3__inv_2_1569 gf180mcu_as_sc_mcu7t3v3__inv_2_1588/VSS gf180mcu_as_sc_mcu7t3v3__inv_2_1573/VDD
+ gf180mcu_as_sc_mcu7t3v3__inv_2_1569/Y VSS gf180mcu_as_sc_mcu7t3v3__inv_2_1570/VNW
+ VSUBS gf180mcu_as_sc_mcu7t3v3__inv_2
Xgf180mcu_as_sc_mcu7t3v3__inv_2_1547 gf180mcu_as_sc_mcu7t3v3__inv_2_1547/VDD VSS VSS
+ VSS gf180mcu_as_sc_mcu7t3v3__inv_2_1547/VNW VSUBS gf180mcu_as_sc_mcu7t3v3__inv_2
Xgf180mcu_as_sc_mcu7t3v3__inv_2_1558 VSS gf180mcu_as_sc_mcu7t3v3__inv_2_1562/VDD VSS
+ VSS gf180mcu_as_sc_mcu7t3v3__inv_2_1559/VNW VSUBS gf180mcu_as_sc_mcu7t3v3__inv_2
Xgf180mcu_as_sc_mcu7t3v3__inv_2_1514 VSS VSS VSS VSS gf180mcu_as_sc_mcu7t3v3__inv_2_1514/VNW
+ VSUBS gf180mcu_as_sc_mcu7t3v3__inv_2
Xgf180mcu_as_sc_mcu7t3v3__inv_2_1525 VSS VSS VSS VSS gf180mcu_as_sc_mcu7t3v3__inv_2_1526/VNW
+ VSUBS gf180mcu_as_sc_mcu7t3v3__inv_2
Xgf180mcu_as_sc_mcu7t3v3__inv_2_1536 VSS gf180mcu_as_sc_mcu7t3v3__inv_2_1541/VDD VSS
+ VSS gf180mcu_as_sc_mcu7t3v3__inv_2_1538/VNW VSUBS gf180mcu_as_sc_mcu7t3v3__inv_2
Xgf180mcu_as_sc_mcu7t3v3__inv_2_1503 gf180mcu_as_sc_mcu7t3v3__inv_2_1503/VDD VSS VSS
+ VSS gf180mcu_as_sc_mcu7t3v3__inv_2_1503/VNW VSUBS gf180mcu_as_sc_mcu7t3v3__inv_2
Xgf180mcu_as_sc_mcu7t3v3__nand4_2_308 VSS gf180mcu_as_sc_mcu7t3v3__inv_2_1058/VDD
+ VSS VSS VSS VSS VSS gf180mcu_as_sc_mcu7t3v3__inv_2_1056/VNW VSUBS gf180mcu_as_sc_mcu7t3v3__nand4_2
Xgf180mcu_as_sc_mcu7t3v3__nand4_2_319 VSS gf180mcu_as_sc_mcu7t3v3__inv_2_1075/VDD
+ VSS VSS VSS VSS VSS gf180mcu_as_sc_mcu7t3v3__inv_2_1071/VNW VSUBS gf180mcu_as_sc_mcu7t3v3__nand4_2
Xgf180mcu_as_sc_mcu7t3v3__nand2_2_2 gf180mcu_as_sc_mcu7t3v3__nor2_2_7/VDD gf180mcu_as_sc_mcu7t3v3__nand3_2_4/VSS
+ VSS VSS VSS gf180mcu_as_sc_mcu7t3v3__nor2_2_7/VNW VSUBS gf180mcu_as_sc_mcu7t3v3__nand2_2
Xu_t029_007 u_t029_007/c0_w0_bl u_t029_007/c0_w0_br u_t029_007/c0_w1_bl u_t029_007/c0_w1_br
+ u_t029_007/c0_r0_rbl u_t029_007/c0_r1_rbl u_t029_007/c1_w0_bl u_t029_007/c1_w0_br
+ u_t029_007/c1_w1_bl u_t029_007/c1_w1_br u_t029_007/c1_r0_rbl u_t029_007/c1_r1_rbl
+ u_t029_007/c2_w0_bl u_t029_007/c2_w0_br u_t029_007/c2_w1_bl u_t029_007/c2_w1_br
+ u_t029_007/c2_r0_rbl u_t029_007/c2_r1_rbl u_t029_007/c3_w0_bl u_t029_007/c3_w0_br
+ u_t029_007/c3_w1_bl u_t029_007/c3_w1_br u_t029_007/c3_r0_rbl u_t029_007/c3_r1_rbl
+ u_t029_007/r0_w0_wl u_t029_007/r0_w1_wl u_t029_007/r0_r0_rwl u_t029_007/r0_r1_rwl
+ u_t029_007/r1_w0_wl u_t029_007/r1_w1_wl u_t029_007/r1_r0_rwl u_t029_007/r1_r1_rwl
+ u_t029_007/r2_w0_wl u_t029_007/r2_w1_wl u_t029_007/r2_r0_rwl u_t029_007/r2_r1_rwl
+ u_t029_007/r3_w0_wl u_t029_007/r3_w1_wl u_t029_007/r3_r0_rwl u_t029_007/r3_r1_rwl
+ VSS VSS u_t029_007/m2_717_1265# u_t029_007/m2_603_2031# u_t029_007/m2_1290_336#
+ u_t029_007/m2_2000_2037# u_t029_007/m2_791_2909# u_t029_007/m2_7_2126# u_t029_007/m2_2154_2081#
+ u_t029_007/m2_1795_2037# u_t029_007/m2_871_303# u_t029_007/m2_431_438# u_t029_007/m2_1290_2898#
+ u_t029_007/m2_1714_1210# u_t029_007/m2_431_1982# u_t029_007/m2_512_1265# u_t029_007/m2_2573_2126#
+ u_t029_007/m2_603_1259# u_t029_007/m2_2074_2909# u_t029_007/m2_7_336# u_t029_007/m2_717_2037#
+ u_t029_007/m2_1886_2031# u_t029_007/m2_2573_336# u_t029_007/m2_7_2898# u_t029_007/m2_2000_1265#
+ u_t029_007/m2_512_2037# u_t029_007/m2_1795_1265# u_t029_007/m2_1714_1982# u_t029_007/m2_1886_1259#
+ u_t029_007/m2_1290_2126# u_t029_007/m2_1714_438# u_t029_007/m2_431_1210# u_t029_007/m2_2573_2898#
+ u_t029_007/m2_2154_303# u_t029_007/m2_871_2081# VSUBS detronyx_12t_2w2r_rc4_4x4_routed_5layer_direct
Xgf180mcu_as_sc_mcu7t3v3__inv_2_1300 VSS VSS VSS VSS gf180mcu_as_sc_mcu7t3v3__inv_2_1300/VNW
+ VSUBS gf180mcu_as_sc_mcu7t3v3__inv_2
Xgf180mcu_as_sc_mcu7t3v3__inv_2_1322 VSS gf180mcu_as_sc_mcu7t3v3__inv_2_1717/VDD VSS
+ gf180mcu_as_sc_mcu7t3v3__inv_2_1717/Y gf180mcu_as_sc_mcu7t3v3__inv_2_1324/VNW VSUBS
+ gf180mcu_as_sc_mcu7t3v3__inv_2
Xgf180mcu_as_sc_mcu7t3v3__inv_2_1333 VSS gf180mcu_as_sc_mcu7t3v3__inv_2_1349/VDD gf180mcu_as_sc_mcu7t3v3__inv_2_1355/Y
+ VSS gf180mcu_as_sc_mcu7t3v3__inv_2_1333/VNW VSUBS gf180mcu_as_sc_mcu7t3v3__inv_2
Xgf180mcu_as_sc_mcu7t3v3__inv_2_1311 VSS gf180mcu_as_sc_mcu7t3v3__inv_2_1316/VDD gf180mcu_as_sc_mcu7t3v3__inv_2_1355/Y
+ gf180mcu_as_sc_mcu7t3v3__inv_2_1355/Y gf180mcu_as_sc_mcu7t3v3__inv_2_1312/VNW VSUBS
+ gf180mcu_as_sc_mcu7t3v3__inv_2
Xgf180mcu_as_sc_mcu7t3v3__inv_2_1344 VSS VSS gf180mcu_as_sc_mcu7t3v3__inv_2_1355/Y
+ VSS gf180mcu_as_sc_mcu7t3v3__inv_2_1344/VNW VSUBS gf180mcu_as_sc_mcu7t3v3__inv_2
Xgf180mcu_as_sc_mcu7t3v3__inv_2_1366 gf180mcu_as_sc_mcu7t3v3__inv_2_1366/VDD gf180mcu_as_sc_mcu7t3v3__inv_2_1370/VDD
+ gf180mcu_as_sc_mcu7t3v3__inv_2_1694/Y VSS gf180mcu_as_sc_mcu7t3v3__inv_2_1366/VNW
+ VSUBS gf180mcu_as_sc_mcu7t3v3__inv_2
Xgf180mcu_as_sc_mcu7t3v3__inv_2_1377 gf180mcu_as_sc_mcu7t3v3__inv_2_1378/VDD gf180mcu_as_sc_mcu7t3v3__inv_2_1382/VDD
+ gf180mcu_as_sc_mcu7t3v3__inv_2_1377/Y gf180mcu_as_sc_mcu7t3v3__inv_2_1382/Y gf180mcu_as_sc_mcu7t3v3__inv_2_1378/VNW
+ VSUBS gf180mcu_as_sc_mcu7t3v3__inv_2
Xgf180mcu_as_sc_mcu7t3v3__inv_2_1388 VSS gf180mcu_as_sc_mcu7t3v3__inv_2_1394/VDD VSS
+ gf180mcu_as_sc_mcu7t3v3__inv_2_1394/Y gf180mcu_as_sc_mcu7t3v3__inv_2_1390/VNW VSUBS
+ gf180mcu_as_sc_mcu7t3v3__inv_2
Xgf180mcu_as_sc_mcu7t3v3__inv_2_1399 gf180mcu_as_sc_mcu7t3v3__inv_2_1403/VDD VSS VSS
+ gf180mcu_as_sc_mcu7t3v3__inv_2_1409/A gf180mcu_as_sc_mcu7t3v3__inv_2_1403/VNW VSUBS
+ gf180mcu_as_sc_mcu7t3v3__inv_2
Xgf180mcu_as_sc_mcu7t3v3__inv_2_1355 gf180mcu_as_sc_mcu7t3v3__inv_2_1355/VDD VSS gf180mcu_as_sc_mcu7t3v3__inv_2_1355/Y
+ gf180mcu_as_sc_mcu7t3v3__inv_2_1355/Y gf180mcu_as_sc_mcu7t3v3__inv_2_1355/VNW VSUBS
+ gf180mcu_as_sc_mcu7t3v3__inv_2
Xgf180mcu_as_sc_mcu7t3v3__inv_2_828 VSS VSS VSS VSS gf180mcu_as_sc_mcu7t3v3__inv_2_828/VNW
+ VSUBS gf180mcu_as_sc_mcu7t3v3__inv_2
Xgf180mcu_as_sc_mcu7t3v3__inv_2_817 VSS VSS VSS VSS gf180mcu_as_sc_mcu7t3v3__inv_2_819/VNW
+ VSUBS gf180mcu_as_sc_mcu7t3v3__inv_2
Xgf180mcu_as_sc_mcu7t3v3__inv_2_839 VSS VSS VSS VSS gf180mcu_as_sc_mcu7t3v3__inv_2_839/VNW
+ VSUBS gf180mcu_as_sc_mcu7t3v3__inv_2
Xgf180mcu_as_sc_mcu7t3v3__inv_2_806 VSS VSS gf180mcu_as_sc_mcu7t3v3__inv_2_806/Y VSS
+ gf180mcu_as_sc_mcu7t3v3__inv_2_838/VNW VSUBS gf180mcu_as_sc_mcu7t3v3__inv_2
Xgf180mcu_as_sc_mcu7t3v3__nand4_2_149 VSS VSS VSS VSS VSS VSS VSS gf180mcu_as_sc_mcu7t3v3__inv_2_542/VNW
+ VSUBS gf180mcu_as_sc_mcu7t3v3__nand4_2
Xgf180mcu_as_sc_mcu7t3v3__nand4_2_127 VSS VSS VSS VSS VSS VSS VSS gf180mcu_as_sc_mcu7t3v3__inv_2_546/VNW
+ VSUBS gf180mcu_as_sc_mcu7t3v3__nand4_2
Xgf180mcu_as_sc_mcu7t3v3__nand4_2_138 VSS VSS VSS VSS VSS VSS gf180mcu_as_sc_mcu7t3v3__nand4_2_138/Y
+ gf180mcu_as_sc_mcu7t3v3__inv_2_563/VNW VSUBS gf180mcu_as_sc_mcu7t3v3__nand4_2
Xgf180mcu_as_sc_mcu7t3v3__nand4_2_105 VSS gf180mcu_as_sc_mcu7t3v3__inv_2_53/VDD VSS
+ VSS VSS VSS VSS gf180mcu_as_sc_mcu7t3v3__inv_2_368/VNW VSUBS gf180mcu_as_sc_mcu7t3v3__nand4_2
Xgf180mcu_as_sc_mcu7t3v3__nand4_2_116 gf180mcu_as_sc_mcu7t3v3__inv_2_304/VDD gf180mcu_as_sc_mcu7t3v3__inv_2_304/VSS
+ VSS VSS VSS VSS VSS gf180mcu_as_sc_mcu7t3v3__inv_2_304/VNW VSUBS gf180mcu_as_sc_mcu7t3v3__nand4_2
Xgf180mcu_as_sc_mcu7t3v3__nand4_2_66 gf180mcu_as_sc_mcu7t3v3__inv_2_20/VDD gf180mcu_as_sc_mcu7t3v3__inv_2_24/VDD
+ VSS VSS VSS VSS VSS gf180mcu_as_sc_mcu7t3v3__inv_2_20/VNW VSUBS gf180mcu_as_sc_mcu7t3v3__nand4_2
Xgf180mcu_as_sc_mcu7t3v3__nand4_2_22 gf180mcu_as_sc_mcu7t3v3__inv_2_146/VDD VSS VSS
+ VSS VSS VSS VSS gf180mcu_as_sc_mcu7t3v3__inv_2_146/VNW VSUBS gf180mcu_as_sc_mcu7t3v3__nand4_2
Xgf180mcu_as_sc_mcu7t3v3__nand4_2_88 gf180mcu_as_sc_mcu7t3v3__inv_2_9/VSS gf180mcu_as_sc_mcu7t3v3__inv_2_38/VDD
+ VSS VSS VSS VSS VSS gf180mcu_as_sc_mcu7t3v3__inv_2_25/VNW VSUBS gf180mcu_as_sc_mcu7t3v3__nand4_2
Xgf180mcu_as_sc_mcu7t3v3__nand4_2_11 gf180mcu_as_sc_mcu7t3v3__inv_2_113/VDD gf180mcu_as_sc_mcu7t3v3__inv_2_116/VDD
+ VSS VSS VSS VSS gf180mcu_as_sc_mcu7t3v3__nand4_2_11/Y gf180mcu_as_sc_mcu7t3v3__inv_2_113/VNW
+ VSUBS gf180mcu_as_sc_mcu7t3v3__nand4_2
Xgf180mcu_as_sc_mcu7t3v3__nand4_2_33 VSS gf180mcu_as_sc_mcu7t3v3__inv_2_182/VDD VSS
+ VSS VSS VSS VSS gf180mcu_as_sc_mcu7t3v3__inv_2_180/VNW VSUBS gf180mcu_as_sc_mcu7t3v3__nand4_2
Xgf180mcu_as_sc_mcu7t3v3__nand4_2_99 gf180mcu_as_sc_mcu7t3v3__inv_2_350/VDD VSS VSS
+ VSS VSS VSS VSS gf180mcu_as_sc_mcu7t3v3__inv_2_350/VNW VSUBS gf180mcu_as_sc_mcu7t3v3__nand4_2
Xgf180mcu_as_sc_mcu7t3v3__nand4_2_44 VSS VSS VSS VSS VSS VSS VSS gf180mcu_as_sc_mcu7t3v3__inv_2_212/VNW
+ VSUBS gf180mcu_as_sc_mcu7t3v3__nand4_2
Xgf180mcu_as_sc_mcu7t3v3__nand4_2_77 VSS gf180mcu_as_sc_mcu7t3v3__inv_2_338/VDD VSS
+ VSS VSS VSS VSS gf180mcu_as_sc_mcu7t3v3__inv_2_335/VNW VSUBS gf180mcu_as_sc_mcu7t3v3__nand4_2
Xgf180mcu_as_sc_mcu7t3v3__nand4_2_55 VSS gf180mcu_as_sc_mcu7t3v3__inv_2_248/VDD VSS
+ VSS VSS VSS gf180mcu_as_sc_mcu7t3v3__nand4_2_55/Y gf180mcu_as_sc_mcu7t3v3__inv_2_245/VNW
+ VSUBS gf180mcu_as_sc_mcu7t3v3__nand4_2
Xu_t025_010 u_t025_010/c0_w0_bl u_t025_010/c0_w0_br u_t025_010/c0_w1_bl u_t025_010/c0_w1_br
+ u_t025_010/c0_r0_rbl u_t025_010/c0_r1_rbl u_t025_010/c1_w0_bl u_t025_010/c1_w0_br
+ u_t025_010/c1_w1_bl u_t025_010/c1_w1_br u_t025_010/c1_r0_rbl u_t025_010/c1_r1_rbl
+ u_t025_010/c2_w0_bl u_t025_010/c2_w0_br u_t025_010/c2_w1_bl u_t025_010/c2_w1_br
+ u_t025_010/c2_r0_rbl u_t025_010/c2_r1_rbl u_t025_010/c3_w0_bl u_t025_010/c3_w0_br
+ u_t025_010/c3_w1_bl u_t025_010/c3_w1_br u_t025_010/c3_r0_rbl u_t025_010/c3_r1_rbl
+ u_t025_010/r0_w0_wl u_t025_010/r0_w1_wl u_t025_010/r0_r0_rwl u_t025_010/r0_r1_rwl
+ u_t025_010/r1_w0_wl u_t025_010/r1_w1_wl u_t025_010/r1_r0_rwl u_t025_010/r1_r1_rwl
+ u_t025_010/r2_w0_wl u_t025_010/r2_w1_wl u_t025_010/r2_r0_rwl u_t025_010/r2_r1_rwl
+ u_t025_010/r3_w0_wl u_t025_010/r3_w1_wl u_t025_010/r3_r0_rwl u_t025_010/r3_r1_rwl
+ VSS VSS u_t025_010/m2_717_1265# u_t025_010/m2_603_2031# u_t025_010/m2_1290_336#
+ u_t025_010/m2_2000_2037# u_t025_010/m2_791_2909# u_t025_010/m2_7_2126# u_t025_010/m2_2154_2081#
+ u_t025_010/m2_1795_2037# u_t025_010/m2_871_303# u_t025_010/m2_431_438# u_t025_010/m2_1290_2898#
+ u_t025_010/m2_1714_1210# u_t025_010/m2_431_1982# u_t025_010/m2_512_1265# u_t025_010/m2_2573_2126#
+ u_t025_010/m2_603_1259# u_t025_010/m2_2074_2909# u_t025_010/m2_7_336# u_t025_010/m2_717_2037#
+ u_t025_010/m2_1886_2031# u_t025_010/m2_2573_336# u_t025_010/m2_7_2898# u_t025_010/m2_2000_1265#
+ u_t025_010/m2_512_2037# u_t025_010/m2_1795_1265# u_t025_010/m2_1714_1982# u_t025_010/m2_1886_1259#
+ u_t025_010/m2_1290_2126# u_t025_010/m2_1714_438# u_t025_010/m2_431_1210# u_t025_010/m2_2573_2898#
+ u_t025_010/m2_2154_303# u_t025_010/m2_871_2081# VSUBS detronyx_12t_2w2r_rc4_4x4_routed_5layer_direct
Xgf180mcu_as_sc_mcu7t3v3__inv_2_1141 gf180mcu_as_sc_mcu7t3v3__inv_2_1142/VDD VSS VSS
+ gf180mcu_as_sc_mcu7t3v3__inv_2_1142/Y gf180mcu_as_sc_mcu7t3v3__inv_2_1142/VNW VSUBS
+ gf180mcu_as_sc_mcu7t3v3__inv_2
Xgf180mcu_as_sc_mcu7t3v3__inv_2_1130 VSS VSS gf180mcu_as_sc_mcu7t3v3__inv_2_1130/Y
+ VSS gf180mcu_as_sc_mcu7t3v3__inv_2_1130/VNW VSUBS gf180mcu_as_sc_mcu7t3v3__inv_2
Xgf180mcu_as_sc_mcu7t3v3__inv_2_1185 VSS VSS VSS VSS gf180mcu_as_sc_mcu7t3v3__inv_2_1289/VNW
+ VSUBS gf180mcu_as_sc_mcu7t3v3__inv_2
Xgf180mcu_as_sc_mcu7t3v3__inv_2_1152 VSS VSS VSS VSS gf180mcu_as_sc_mcu7t3v3__inv_2_1289/VNW
+ VSUBS gf180mcu_as_sc_mcu7t3v3__inv_2
Xgf180mcu_as_sc_mcu7t3v3__inv_2_1163 VSS VSS VSS VSS gf180mcu_as_sc_mcu7t3v3__inv_2_1293/VNW
+ VSUBS gf180mcu_as_sc_mcu7t3v3__inv_2
Xgf180mcu_as_sc_mcu7t3v3__inv_2_1174 VSS VSS gf180mcu_as_sc_mcu7t3v3__inv_2_1174/Y
+ VSS gf180mcu_as_sc_mcu7t3v3__inv_2_1295/VNW VSUBS gf180mcu_as_sc_mcu7t3v3__inv_2
Xgf180mcu_as_sc_mcu7t3v3__inv_2_1196 gf180mcu_as_sc_mcu7t3v3__nand3_2_65/VDD gf180mcu_as_sc_mcu7t3v3__nor2_2_9/VSS
+ gf180mcu_as_sc_mcu7t3v3__inv_2_1196/Y VSS gf180mcu_as_sc_mcu7t3v3__nand3_2_65/VNW
+ VSUBS gf180mcu_as_sc_mcu7t3v3__inv_2
Xu_t016_010 u_t016_010/c0_w0_bl u_t016_010/c0_w0_br u_t016_010/c0_w1_bl u_t016_010/c0_w1_br
+ u_t016_010/c0_r0_rbl u_t016_010/c0_r1_rbl u_t016_010/c1_w0_bl u_t016_010/c1_w0_br
+ u_t016_010/c1_w1_bl u_t016_010/c1_w1_br u_t016_010/c1_r0_rbl u_t016_010/c1_r1_rbl
+ u_t016_010/c2_w0_bl u_t016_010/c2_w0_br u_t016_010/c2_w1_bl u_t016_010/c2_w1_br
+ u_t016_010/c2_r0_rbl u_t016_010/c2_r1_rbl u_t016_010/c3_w0_bl u_t016_010/c3_w0_br
+ u_t016_010/c3_w1_bl u_t016_010/c3_w1_br u_t016_010/c3_r0_rbl u_t016_010/c3_r1_rbl
+ u_t016_010/r0_w0_wl u_t016_010/r0_w1_wl u_t016_010/r0_r0_rwl u_t016_010/r0_r1_rwl
+ u_t016_010/r1_w0_wl u_t016_010/r1_w1_wl u_t016_010/r1_r0_rwl u_t016_010/r1_r1_rwl
+ u_t016_010/r2_w0_wl u_t016_010/r2_w1_wl u_t016_010/r2_r0_rwl u_t016_010/r2_r1_rwl
+ u_t016_010/r3_w0_wl u_t016_010/r3_w1_wl u_t016_010/r3_r0_rwl u_t016_010/r3_r1_rwl
+ VSS u_t016_010/VSS u_t016_010/m2_717_1265# u_t016_010/m2_603_2031# u_t016_010/m2_1290_336#
+ u_t016_010/m2_2000_2037# u_t016_010/m2_791_2909# u_t016_010/m2_7_2126# u_t016_010/m2_2154_2081#
+ u_t016_010/m2_1795_2037# u_t016_010/m2_871_303# u_t016_010/m2_431_438# u_t016_010/m2_1290_2898#
+ u_t016_010/m2_1714_1210# u_t016_010/m2_431_1982# u_t016_010/m2_512_1265# u_t016_010/m2_2573_2126#
+ u_t016_010/m2_603_1259# u_t016_010/m2_2074_2909# u_t016_010/m2_7_336# u_t016_010/m2_717_2037#
+ u_t016_010/m2_1886_2031# u_t016_010/m2_2573_336# u_t016_010/m2_7_2898# u_t016_010/m2_2000_1265#
+ u_t016_010/m2_512_2037# u_t016_010/m2_1795_1265# u_t016_010/m2_1714_1982# u_t016_010/m2_1886_1259#
+ u_t016_010/m2_1290_2126# u_t016_010/m2_1714_438# u_t016_010/m2_431_1210# u_t016_010/m2_2573_2898#
+ u_t016_010/m2_2154_303# u_t016_010/m2_871_2081# VSUBS detronyx_12t_2w2r_rc4_4x4_routed_5layer_direct
Xgf180mcu_as_sc_mcu7t3v3__inv_2_603 VSS gf180mcu_as_sc_mcu7t3v3__inv_2_607/VDD gf180mcu_as_sc_mcu7t3v3__inv_2_603/Y
+ VSS gf180mcu_as_sc_mcu7t3v3__inv_2_603/VNW VSUBS gf180mcu_as_sc_mcu7t3v3__inv_2
Xgf180mcu_as_sc_mcu7t3v3__inv_2_625 gf180mcu_as_sc_mcu7t3v3__inv_2_633/VDD VSS gf180mcu_as_sc_mcu7t3v3__inv_2_625/Y
+ gf180mcu_as_sc_mcu7t3v3__inv_2_638/A gf180mcu_as_sc_mcu7t3v3__inv_2_633/VNW VSUBS
+ gf180mcu_as_sc_mcu7t3v3__inv_2
Xgf180mcu_as_sc_mcu7t3v3__inv_2_636 gf180mcu_as_sc_mcu7t3v3__inv_2_636/VDD gf180mcu_as_sc_mcu7t3v3__inv_2_638/VSS
+ gf180mcu_as_sc_mcu7t3v3__inv_2_636/Y VSS gf180mcu_as_sc_mcu7t3v3__inv_2_636/VNW
+ VSUBS gf180mcu_as_sc_mcu7t3v3__inv_2
Xgf180mcu_as_sc_mcu7t3v3__inv_2_614 gf180mcu_as_sc_mcu7t3v3__inv_2_854/VSS gf180mcu_as_sc_mcu7t3v3__inv_2_620/VDD
+ gf180mcu_as_sc_mcu7t3v3__inv_2_614/Y gf180mcu_as_sc_mcu7t3v3__inv_2_853/Y gf180mcu_as_sc_mcu7t3v3__inv_2_616/VNW
+ VSUBS gf180mcu_as_sc_mcu7t3v3__inv_2
Xu_t031_013 u_t031_013/c0_w0_bl u_t031_013/c0_w0_br u_t031_013/c0_w1_bl u_t031_013/c0_w1_br
+ u_t031_013/c0_r0_rbl u_t031_013/c0_r1_rbl u_t031_013/c1_w0_bl u_t031_013/c1_w0_br
+ u_t031_013/c1_w1_bl u_t031_013/c1_w1_br u_t031_013/c1_r0_rbl u_t031_013/c1_r1_rbl
+ u_t031_013/c2_w0_bl u_t031_013/c2_w0_br u_t031_013/c2_w1_bl u_t031_013/c2_w1_br
+ u_t031_013/c2_r0_rbl u_t031_013/c2_r1_rbl u_t031_013/c3_w0_bl u_t031_013/c3_w0_br
+ u_t031_013/c3_w1_bl u_t031_013/c3_w1_br u_t031_013/c3_r0_rbl u_t031_013/c3_r1_rbl
+ u_t031_013/r0_w0_wl u_t031_013/r0_w1_wl u_t031_013/r0_r0_rwl u_t031_013/r0_r1_rwl
+ u_t031_013/r1_w0_wl u_t031_013/r1_w1_wl u_t031_013/r1_r0_rwl u_t031_013/r1_r1_rwl
+ u_t031_013/r2_w0_wl u_t031_013/r2_w1_wl u_t031_013/r2_r0_rwl u_t031_013/r2_r1_rwl
+ u_t031_013/r3_w0_wl u_t031_013/r3_w1_wl u_t031_013/r3_r0_rwl u_t031_013/r3_r1_rwl
+ u_t031_013/VDD u_t031_013/VSS u_t031_013/m2_717_1265# u_t031_013/m2_603_2031# u_t031_013/m2_1290_336#
+ u_t031_013/m2_2000_2037# u_t031_013/m2_791_2909# u_t031_013/m2_7_2126# u_t031_013/m2_2154_2081#
+ u_t031_013/m2_1795_2037# u_t031_013/m2_871_303# u_t031_013/m2_431_438# u_t031_013/m2_1290_2898#
+ u_t031_013/m2_1714_1210# u_t031_013/m2_431_1982# u_t031_013/m2_512_1265# u_t031_013/m2_2573_2126#
+ u_t031_013/m2_603_1259# u_t031_013/m2_2074_2909# u_t031_013/m2_7_336# u_t031_013/m2_717_2037#
+ u_t031_013/m2_1886_2031# u_t031_013/m2_2573_336# u_t031_013/m2_7_2898# u_t031_013/m2_2000_1265#
+ u_t031_013/m2_512_2037# u_t031_013/m2_1795_1265# u_t031_013/m2_1714_1982# u_t031_013/m2_1886_1259#
+ u_t031_013/m2_1290_2126# u_t031_013/m2_1714_438# u_t031_013/m2_431_1210# u_t031_013/m2_2573_2898#
+ u_t031_013/m2_2154_303# u_t031_013/m2_871_2081# VSUBS detronyx_12t_2w2r_rc4_4x4_routed_5layer_direct
Xu_t031_002 u_t031_002/c0_w0_bl u_t031_002/c0_w0_br u_t031_002/c0_w1_bl u_t031_002/c0_w1_br
+ u_t031_002/c0_r0_rbl u_t031_002/c0_r1_rbl u_t031_002/c1_w0_bl u_t031_002/c1_w0_br
+ u_t031_002/c1_w1_bl u_t031_002/c1_w1_br u_t031_002/c1_r0_rbl u_t031_002/c1_r1_rbl
+ u_t031_002/c2_w0_bl u_t031_002/c2_w0_br u_t031_002/c2_w1_bl u_t031_002/c2_w1_br
+ u_t031_002/c2_r0_rbl u_t031_002/c2_r1_rbl u_t031_002/c3_w0_bl u_t031_002/c3_w0_br
+ u_t031_002/c3_w1_bl u_t031_002/c3_w1_br u_t031_002/c3_r0_rbl u_t031_002/c3_r1_rbl
+ u_t031_002/r0_w0_wl u_t031_002/r0_w1_wl u_t031_002/r0_r0_rwl u_t031_002/r0_r1_rwl
+ u_t031_002/r1_w0_wl u_t031_002/r1_w1_wl u_t031_002/r1_r0_rwl u_t031_002/r1_r1_rwl
+ u_t031_002/r2_w0_wl u_t031_002/r2_w1_wl u_t031_002/r2_r0_rwl u_t031_002/r2_r1_rwl
+ u_t031_002/r3_w0_wl u_t031_002/r3_w1_wl u_t031_002/r3_r0_rwl u_t031_002/r3_r1_rwl
+ VSS VSS u_t031_002/m2_717_1265# u_t031_002/m2_603_2031# u_t031_002/m2_1290_336#
+ u_t031_002/m2_2000_2037# u_t031_002/m2_791_2909# u_t031_002/m2_7_2126# u_t031_002/m2_2154_2081#
+ u_t031_002/m2_1795_2037# u_t031_002/m2_871_303# u_t031_002/m2_431_438# u_t031_002/m2_1290_2898#
+ u_t031_002/m2_1714_1210# u_t031_002/m2_431_1982# u_t031_002/m2_512_1265# u_t031_002/m2_2573_2126#
+ u_t031_002/m2_603_1259# u_t031_002/m2_2074_2909# u_t031_002/m2_7_336# u_t031_002/m2_717_2037#
+ u_t031_002/m2_1886_2031# u_t031_002/m2_2573_336# u_t031_002/m2_7_2898# u_t031_002/m2_2000_1265#
+ u_t031_002/m2_512_2037# u_t031_002/m2_1795_1265# u_t031_002/m2_1714_1982# u_t031_002/m2_1886_1259#
+ u_t031_002/m2_1290_2126# u_t031_002/m2_1714_438# u_t031_002/m2_431_1210# u_t031_002/m2_2573_2898#
+ u_t031_002/m2_2154_303# u_t031_002/m2_871_2081# VSUBS detronyx_12t_2w2r_rc4_4x4_routed_5layer_direct
Xgf180mcu_as_sc_mcu7t3v3__inv_2_647 VSS gf180mcu_as_sc_mcu7t3v3__inv_2_656/VDD gf180mcu_as_sc_mcu7t3v3__inv_2_647/Y
+ gf180mcu_as_sc_mcu7t3v3__inv_2_853/Y gf180mcu_as_sc_mcu7t3v3__inv_2_652/VNW VSUBS
+ gf180mcu_as_sc_mcu7t3v3__inv_2
Xgf180mcu_as_sc_mcu7t3v3__inv_2_658 VSS gf180mcu_as_sc_mcu7t3v3__inv_2_664/VDD gf180mcu_as_sc_mcu7t3v3__inv_2_658/Y
+ gf180mcu_as_sc_mcu7t3v3__inv_2_662/A gf180mcu_as_sc_mcu7t3v3__inv_2_660/VNW VSUBS
+ gf180mcu_as_sc_mcu7t3v3__inv_2
Xgf180mcu_as_sc_mcu7t3v3__inv_2_669 gf180mcu_as_sc_mcu7t3v3__inv_2_746/VSS gf180mcu_as_sc_mcu7t3v3__inv_2_674/VDD
+ gf180mcu_as_sc_mcu7t3v3__inv_2_669/Y gf180mcu_as_sc_mcu7t3v3__inv_2_670/Y gf180mcu_as_sc_mcu7t3v3__inv_2_670/VNW
+ VSUBS gf180mcu_as_sc_mcu7t3v3__inv_2
Xu_t022_013 u_t022_013/c0_w0_bl u_t022_013/c0_w0_br u_t022_013/c0_w1_bl u_t022_013/c0_w1_br
+ u_t022_013/c0_r0_rbl u_t022_013/c0_r1_rbl u_t022_013/c1_w0_bl u_t022_013/c1_w0_br
+ u_t022_013/c1_w1_bl u_t022_013/c1_w1_br u_t022_013/c1_r0_rbl u_t022_013/c1_r1_rbl
+ u_t022_013/c2_w0_bl u_t022_013/c2_w0_br u_t022_013/c2_w1_bl u_t022_013/c2_w1_br
+ u_t022_013/c2_r0_rbl u_t022_013/c2_r1_rbl u_t022_013/c3_w0_bl u_t022_013/c3_w0_br
+ u_t022_013/c3_w1_bl u_t022_013/c3_w1_br u_t022_013/c3_r0_rbl u_t022_013/c3_r1_rbl
+ u_t022_013/r0_w0_wl u_t022_013/r0_w1_wl u_t022_013/r0_r0_rwl u_t022_013/r0_r1_rwl
+ u_t022_013/r1_w0_wl u_t022_013/r1_w1_wl u_t022_013/r1_r0_rwl u_t022_013/r1_r1_rwl
+ u_t022_013/r2_w0_wl u_t022_013/r2_w1_wl u_t022_013/r2_r0_rwl u_t022_013/r2_r1_rwl
+ u_t022_013/r3_w0_wl u_t022_013/r3_w1_wl u_t022_013/r3_r0_rwl u_t022_013/r3_r1_rwl
+ u_t022_013/VDD VSS u_t022_013/m2_717_1265# u_t022_013/m2_603_2031# u_t022_013/m2_1290_336#
+ u_t022_013/m2_2000_2037# u_t022_013/m2_791_2909# u_t022_013/m2_7_2126# u_t022_013/m2_2154_2081#
+ u_t022_013/m2_1795_2037# u_t022_013/m2_871_303# u_t022_013/m2_431_438# u_t022_013/m2_1290_2898#
+ u_t022_013/m2_1714_1210# u_t022_013/m2_431_1982# u_t022_013/m2_512_1265# u_t022_013/m2_2573_2126#
+ u_t022_013/m2_603_1259# u_t022_013/m2_2074_2909# u_t022_013/m2_7_336# u_t022_013/m2_717_2037#
+ u_t022_013/m2_1886_2031# u_t022_013/m2_2573_336# u_t022_013/m2_7_2898# u_t022_013/m2_2000_1265#
+ u_t022_013/m2_512_2037# u_t022_013/m2_1795_1265# u_t022_013/m2_1714_1982# u_t022_013/m2_1886_1259#
+ u_t022_013/m2_1290_2126# u_t022_013/m2_1714_438# u_t022_013/m2_431_1210# u_t022_013/m2_2573_2898#
+ u_t022_013/m2_2154_303# u_t022_013/m2_871_2081# VSUBS detronyx_12t_2w2r_rc4_4x4_routed_5layer_direct
Xu_t007_010 u_t007_010/c0_w0_bl u_t007_010/c0_w0_br u_t007_010/c0_w1_bl u_t007_010/c0_w1_br
+ u_t007_010/c0_r0_rbl u_t007_010/c0_r1_rbl u_t007_010/c1_w0_bl u_t007_010/c1_w0_br
+ u_t007_010/c1_w1_bl u_t007_010/c1_w1_br u_t007_010/c1_r0_rbl u_t007_010/c1_r1_rbl
+ u_t007_010/c2_w0_bl u_t007_010/c2_w0_br u_t007_010/c2_w1_bl u_t007_010/c2_w1_br
+ u_t007_010/c2_r0_rbl u_t007_010/c2_r1_rbl u_t007_010/c3_w0_bl u_t007_010/c3_w0_br
+ u_t007_010/c3_w1_bl u_t007_010/c3_w1_br u_t007_010/c3_r0_rbl u_t007_010/c3_r1_rbl
+ u_t007_010/r0_w0_wl u_t007_010/r0_w1_wl u_t007_010/r0_r0_rwl u_t007_010/r0_r1_rwl
+ u_t007_010/r1_w0_wl u_t007_010/r1_w1_wl u_t007_010/r1_r0_rwl u_t007_010/r1_r1_rwl
+ u_t007_010/r2_w0_wl u_t007_010/r2_w1_wl u_t007_010/r2_r0_rwl u_t007_010/r2_r1_rwl
+ u_t007_010/r3_w0_wl u_t007_010/r3_w1_wl u_t007_010/r3_r0_rwl u_t007_010/r3_r1_rwl
+ VSS u_t007_010/VSS u_t007_010/m2_717_1265# u_t007_010/m2_603_2031# u_t007_010/m2_1290_336#
+ u_t007_010/m2_2000_2037# u_t007_010/m2_791_2909# u_t007_010/m2_7_2126# u_t007_010/m2_2154_2081#
+ u_t007_010/m2_1795_2037# u_t007_010/m2_871_303# u_t007_010/m2_431_438# u_t007_010/m2_1290_2898#
+ u_t007_010/m2_1714_1210# u_t007_010/m2_431_1982# u_t007_010/m2_512_1265# u_t007_010/m2_2573_2126#
+ u_t007_010/m2_603_1259# u_t007_010/m2_2074_2909# u_t007_010/m2_7_336# u_t007_010/m2_717_2037#
+ u_t007_010/m2_1886_2031# u_t007_010/m2_2573_336# u_t007_010/m2_7_2898# u_t007_010/m2_2000_1265#
+ u_t007_010/m2_512_2037# u_t007_010/m2_1795_1265# u_t007_010/m2_1714_1982# u_t007_010/m2_1886_1259#
+ u_t007_010/m2_1290_2126# u_t007_010/m2_1714_438# u_t007_010/m2_431_1210# u_t007_010/m2_2573_2898#
+ u_t007_010/m2_2154_303# u_t007_010/m2_871_2081# VSUBS detronyx_12t_2w2r_rc4_4x4_routed_5layer_direct
Xu_t022_002 u_t022_002/c0_w0_bl u_t022_002/c0_w0_br u_t022_002/c0_w1_bl u_t022_002/c0_w1_br
+ u_t022_002/c0_r0_rbl u_t022_002/c0_r1_rbl u_t022_002/c1_w0_bl u_t022_002/c1_w0_br
+ u_t022_002/c1_w1_bl u_t022_002/c1_w1_br u_t022_002/c1_r0_rbl u_t022_002/c1_r1_rbl
+ u_t022_002/c2_w0_bl u_t022_002/c2_w0_br u_t022_002/c2_w1_bl u_t022_002/c2_w1_br
+ u_t022_002/c2_r0_rbl u_t022_002/c2_r1_rbl u_t022_002/c3_w0_bl u_t022_002/c3_w0_br
+ u_t022_002/c3_w1_bl u_t022_002/c3_w1_br u_t022_002/c3_r0_rbl u_t022_002/c3_r1_rbl
+ u_t022_002/r0_w0_wl u_t022_002/r0_w1_wl u_t022_002/r0_r0_rwl u_t022_002/r0_r1_rwl
+ u_t022_002/r1_w0_wl u_t022_002/r1_w1_wl u_t022_002/r1_r0_rwl u_t022_002/r1_r1_rwl
+ u_t022_002/r2_w0_wl u_t022_002/r2_w1_wl u_t022_002/r2_r0_rwl u_t022_002/r2_r1_rwl
+ u_t022_002/r3_w0_wl u_t022_002/r3_w1_wl u_t022_002/r3_r0_rwl u_t022_002/r3_r1_rwl
+ VSS VSS u_t022_002/m2_717_1265# u_t022_002/m2_603_2031# u_t022_002/m2_1290_336#
+ u_t022_002/m2_2000_2037# u_t022_002/m2_791_2909# u_t022_002/m2_7_2126# u_t022_002/m2_2154_2081#
+ u_t022_002/m2_1795_2037# u_t022_002/m2_871_303# u_t022_002/m2_431_438# u_t022_002/m2_1290_2898#
+ u_t022_002/m2_1714_1210# u_t022_002/m2_431_1982# u_t022_002/m2_512_1265# u_t022_002/m2_2573_2126#
+ u_t022_002/m2_603_1259# u_t022_002/m2_2074_2909# u_t022_002/m2_7_336# u_t022_002/m2_717_2037#
+ u_t022_002/m2_1886_2031# u_t022_002/m2_2573_336# u_t022_002/m2_7_2898# u_t022_002/m2_2000_1265#
+ u_t022_002/m2_512_2037# u_t022_002/m2_1795_1265# u_t022_002/m2_1714_1982# u_t022_002/m2_1886_1259#
+ u_t022_002/m2_1290_2126# u_t022_002/m2_1714_438# u_t022_002/m2_431_1210# u_t022_002/m2_2573_2898#
+ u_t022_002/m2_2154_303# u_t022_002/m2_871_2081# VSUBS detronyx_12t_2w2r_rc4_4x4_routed_5layer_direct
Xgf180mcu_as_sc_mcu7t3v3__nand4_2_491 VSS VSS VSS VSS VSS VSS VSS gf180mcu_as_sc_mcu7t3v3__inv_2_1688/VNW
+ VSUBS gf180mcu_as_sc_mcu7t3v3__nand4_2
Xgf180mcu_as_sc_mcu7t3v3__nand4_2_480 gf180mcu_as_sc_mcu7t3v3__inv_2_1409/VDD gf180mcu_as_sc_mcu7t3v3__inv_2_1409/VSS
+ VSS VSS VSS VSS VSS gf180mcu_as_sc_mcu7t3v3__inv_2_1409/VNW VSUBS gf180mcu_as_sc_mcu7t3v3__nand4_2
Xu_t013_013 u_t013_013/c0_w0_bl u_t013_013/c0_w0_br u_t013_013/c0_w1_bl u_t013_013/c0_w1_br
+ u_t013_013/c0_r0_rbl u_t013_013/c0_r1_rbl u_t013_013/c1_w0_bl u_t013_013/c1_w0_br
+ u_t013_013/c1_w1_bl u_t013_013/c1_w1_br u_t013_013/c1_r0_rbl u_t013_013/c1_r1_rbl
+ u_t013_013/c2_w0_bl u_t013_013/c2_w0_br u_t013_013/c2_w1_bl u_t013_013/c2_w1_br
+ u_t013_013/c2_r0_rbl u_t013_013/c2_r1_rbl u_t013_013/c3_w0_bl u_t013_013/c3_w0_br
+ u_t013_013/c3_w1_bl u_t013_013/c3_w1_br u_t013_013/c3_r0_rbl u_t013_013/c3_r1_rbl
+ u_t013_013/r0_w0_wl u_t013_013/r0_w1_wl u_t013_013/r0_r0_rwl u_t013_013/r0_r1_rwl
+ u_t013_013/r1_w0_wl u_t013_013/r1_w1_wl u_t013_013/r1_r0_rwl u_t013_013/r1_r1_rwl
+ u_t013_013/r2_w0_wl u_t013_013/r2_w1_wl u_t013_013/r2_r0_rwl u_t013_013/r2_r1_rwl
+ u_t013_013/r3_w0_wl u_t013_013/r3_w1_wl u_t013_013/r3_r0_rwl u_t013_013/r3_r1_rwl
+ u_t013_013/VDD VSS u_t013_013/m2_717_1265# u_t013_013/m2_603_2031# u_t013_013/m2_1290_336#
+ u_t013_013/m2_2000_2037# u_t013_013/m2_791_2909# u_t013_013/m2_7_2126# u_t013_013/m2_2154_2081#
+ u_t013_013/m2_1795_2037# u_t013_013/m2_871_303# u_t013_013/m2_431_438# u_t013_013/m2_1290_2898#
+ u_t013_013/m2_1714_1210# u_t013_013/m2_431_1982# u_t013_013/m2_512_1265# u_t013_013/m2_2573_2126#
+ u_t013_013/m2_603_1259# u_t013_013/m2_2074_2909# u_t013_013/m2_7_336# u_t013_013/m2_717_2037#
+ u_t013_013/m2_1886_2031# u_t013_013/m2_2573_336# u_t013_013/m2_7_2898# u_t013_013/m2_2000_1265#
+ u_t013_013/m2_512_2037# u_t013_013/m2_1795_1265# u_t013_013/m2_1714_1982# u_t013_013/m2_1886_1259#
+ u_t013_013/m2_1290_2126# u_t013_013/m2_1714_438# u_t013_013/m2_431_1210# u_t013_013/m2_2573_2898#
+ u_t013_013/m2_2154_303# u_t013_013/m2_871_2081# VSUBS detronyx_12t_2w2r_rc4_4x4_routed_5layer_direct
Xu_t013_002 u_t013_002/c0_w0_bl u_t013_002/c0_w0_br u_t013_002/c0_w1_bl u_t013_002/c0_w1_br
+ u_t013_002/c0_r0_rbl u_t013_002/c0_r1_rbl u_t013_002/c1_w0_bl u_t013_002/c1_w0_br
+ u_t013_002/c1_w1_bl u_t013_002/c1_w1_br u_t013_002/c1_r0_rbl u_t013_002/c1_r1_rbl
+ u_t013_002/c2_w0_bl u_t013_002/c2_w0_br u_t013_002/c2_w1_bl u_t013_002/c2_w1_br
+ u_t013_002/c2_r0_rbl u_t013_002/c2_r1_rbl u_t013_002/c3_w0_bl u_t013_002/c3_w0_br
+ u_t013_002/c3_w1_bl u_t013_002/c3_w1_br u_t013_002/c3_r0_rbl u_t013_002/c3_r1_rbl
+ u_t013_002/r0_w0_wl u_t013_002/r0_w1_wl u_t013_002/r0_r0_rwl u_t013_002/r0_r1_rwl
+ u_t013_002/r1_w0_wl u_t013_002/r1_w1_wl u_t013_002/r1_r0_rwl u_t013_002/r1_r1_rwl
+ u_t013_002/r2_w0_wl u_t013_002/r2_w1_wl u_t013_002/r2_r0_rwl u_t013_002/r2_r1_rwl
+ u_t013_002/r3_w0_wl u_t013_002/r3_w1_wl u_t013_002/r3_r0_rwl u_t013_002/r3_r1_rwl
+ VSS VSS u_t013_002/m2_717_1265# u_t013_002/m2_603_2031# u_t013_002/m2_1290_336#
+ u_t013_002/m2_2000_2037# u_t013_002/m2_791_2909# u_t013_002/m2_7_2126# u_t013_002/m2_2154_2081#
+ u_t013_002/m2_1795_2037# u_t013_002/m2_871_303# u_t013_002/m2_431_438# u_t013_002/m2_1290_2898#
+ u_t013_002/m2_1714_1210# u_t013_002/m2_431_1982# u_t013_002/m2_512_1265# u_t013_002/m2_2573_2126#
+ u_t013_002/m2_603_1259# u_t013_002/m2_2074_2909# u_t013_002/m2_7_336# u_t013_002/m2_717_2037#
+ u_t013_002/m2_1886_2031# u_t013_002/m2_2573_336# u_t013_002/m2_7_2898# u_t013_002/m2_2000_1265#
+ u_t013_002/m2_512_2037# u_t013_002/m2_1795_1265# u_t013_002/m2_1714_1982# u_t013_002/m2_1886_1259#
+ u_t013_002/m2_1290_2126# u_t013_002/m2_1714_438# u_t013_002/m2_431_1210# u_t013_002/m2_2573_2898#
+ u_t013_002/m2_2154_303# u_t013_002/m2_871_2081# VSUBS detronyx_12t_2w2r_rc4_4x4_routed_5layer_direct
Xu_t004_013 u_t004_013/c0_w0_bl u_t004_013/c0_w0_br u_t004_013/c0_w1_bl u_t004_013/c0_w1_br
+ u_t004_013/c0_r0_rbl u_t004_013/c0_r1_rbl u_t004_013/c1_w0_bl u_t004_013/c1_w0_br
+ u_t004_013/c1_w1_bl u_t004_013/c1_w1_br u_t004_013/c1_r0_rbl u_t004_013/c1_r1_rbl
+ u_t004_013/c2_w0_bl u_t004_013/c2_w0_br u_t004_013/c2_w1_bl u_t004_013/c2_w1_br
+ u_t004_013/c2_r0_rbl u_t004_013/c2_r1_rbl u_t004_013/c3_w0_bl u_t004_013/c3_w0_br
+ u_t004_013/c3_w1_bl u_t004_013/c3_w1_br u_t004_013/c3_r0_rbl u_t004_013/c3_r1_rbl
+ u_t004_013/r0_w0_wl u_t004_013/r0_w1_wl u_t004_013/r0_r0_rwl u_t004_013/r0_r1_rwl
+ u_t004_013/r1_w0_wl u_t004_013/r1_w1_wl u_t004_013/r1_r0_rwl u_t004_013/r1_r1_rwl
+ u_t004_013/r2_w0_wl u_t004_013/r2_w1_wl u_t004_013/r2_r0_rwl u_t004_013/r2_r1_rwl
+ u_t004_013/r3_w0_wl u_t004_013/r3_w1_wl u_t004_013/r3_r0_rwl u_t004_013/r3_r1_rwl
+ u_t004_013/VDD VSS u_t004_013/m2_717_1265# u_t004_013/m2_603_2031# u_t004_013/m2_1290_336#
+ u_t004_013/m2_2000_2037# u_t004_013/m2_791_2909# u_t004_013/m2_7_2126# u_t004_013/m2_2154_2081#
+ u_t004_013/m2_1795_2037# u_t004_013/m2_871_303# u_t004_013/m2_431_438# u_t004_013/m2_1290_2898#
+ u_t004_013/m2_1714_1210# u_t004_013/m2_431_1982# u_t004_013/m2_512_1265# u_t004_013/m2_2573_2126#
+ u_t004_013/m2_603_1259# u_t004_013/m2_2074_2909# u_t004_013/m2_7_336# u_t004_013/m2_717_2037#
+ u_t004_013/m2_1886_2031# u_t004_013/m2_2573_336# u_t004_013/m2_7_2898# u_t004_013/m2_2000_1265#
+ u_t004_013/m2_512_2037# u_t004_013/m2_1795_1265# u_t004_013/m2_1714_1982# u_t004_013/m2_1886_1259#
+ u_t004_013/m2_1290_2126# u_t004_013/m2_1714_438# u_t004_013/m2_431_1210# u_t004_013/m2_2573_2898#
+ u_t004_013/m2_2154_303# u_t004_013/m2_871_2081# VSUBS detronyx_12t_2w2r_rc4_4x4_routed_5layer_direct
Xu_t004_002 u_t004_002/c0_w0_bl u_t004_002/c0_w0_br u_t004_002/c0_w1_bl u_t004_002/c0_w1_br
+ u_t004_002/c0_r0_rbl u_t004_002/c0_r1_rbl u_t004_002/c1_w0_bl u_t004_002/c1_w0_br
+ u_t004_002/c1_w1_bl u_t004_002/c1_w1_br u_t004_002/c1_r0_rbl u_t004_002/c1_r1_rbl
+ u_t004_002/c2_w0_bl u_t004_002/c2_w0_br u_t004_002/c2_w1_bl u_t004_002/c2_w1_br
+ u_t004_002/c2_r0_rbl u_t004_002/c2_r1_rbl u_t004_002/c3_w0_bl u_t004_002/c3_w0_br
+ u_t004_002/c3_w1_bl u_t004_002/c3_w1_br u_t004_002/c3_r0_rbl u_t004_002/c3_r1_rbl
+ u_t004_002/r0_w0_wl u_t004_002/r0_w1_wl u_t004_002/r0_r0_rwl u_t004_002/r0_r1_rwl
+ u_t004_002/r1_w0_wl u_t004_002/r1_w1_wl u_t004_002/r1_r0_rwl u_t004_002/r1_r1_rwl
+ u_t004_002/r2_w0_wl u_t004_002/r2_w1_wl u_t004_002/r2_r0_rwl u_t004_002/r2_r1_rwl
+ u_t004_002/r3_w0_wl u_t004_002/r3_w1_wl u_t004_002/r3_r0_rwl u_t004_002/r3_r1_rwl
+ VSS VSS u_t004_002/m2_717_1265# u_t004_002/m2_603_2031# u_t004_002/m2_1290_336#
+ u_t004_002/m2_2000_2037# u_t004_002/m2_791_2909# u_t004_002/m2_7_2126# u_t004_002/m2_2154_2081#
+ u_t004_002/m2_1795_2037# u_t004_002/m2_871_303# u_t004_002/m2_431_438# u_t004_002/m2_1290_2898#
+ u_t004_002/m2_1714_1210# u_t004_002/m2_431_1982# u_t004_002/m2_512_1265# u_t004_002/m2_2573_2126#
+ u_t004_002/m2_603_1259# u_t004_002/m2_2074_2909# u_t004_002/m2_7_336# u_t004_002/m2_717_2037#
+ u_t004_002/m2_1886_2031# u_t004_002/m2_2573_336# u_t004_002/m2_7_2898# u_t004_002/m2_2000_1265#
+ u_t004_002/m2_512_2037# u_t004_002/m2_1795_1265# u_t004_002/m2_1714_1982# u_t004_002/m2_1886_1259#
+ u_t004_002/m2_1290_2126# u_t004_002/m2_1714_438# u_t004_002/m2_431_1210# u_t004_002/m2_2573_2898#
+ u_t004_002/m2_2154_303# u_t004_002/m2_871_2081# VSUBS detronyx_12t_2w2r_rc4_4x4_routed_5layer_direct
Xgf180mcu_as_sc_mcu7t3v3__inv_2_444 VSS VSS gf180mcu_as_sc_mcu7t3v3__inv_2_444/Y VSS
+ gf180mcu_as_sc_mcu7t3v3__inv_2_545/VNW VSUBS gf180mcu_as_sc_mcu7t3v3__inv_2
Xgf180mcu_as_sc_mcu7t3v3__inv_2_411 gf180mcu_as_sc_mcu7t3v3__nor2_2_6/VDD gf180mcu_as_sc_mcu7t3v3__nor2_2_6/VSS
+ VSS VSS gf180mcu_as_sc_mcu7t3v3__nor2_2_6/VNW VSUBS gf180mcu_as_sc_mcu7t3v3__inv_2
Xgf180mcu_as_sc_mcu7t3v3__inv_2_455 gf180mcu_as_sc_mcu7t3v3__nor2_2_6/VDD gf180mcu_as_sc_mcu7t3v3__nor2_2_6/VSS
+ VSS VSS gf180mcu_as_sc_mcu7t3v3__nor2_2_6/VNW VSUBS gf180mcu_as_sc_mcu7t3v3__inv_2
Xgf180mcu_as_sc_mcu7t3v3__inv_2_422 gf180mcu_as_sc_mcu7t3v3__nor2_2_7/VDD gf180mcu_as_sc_mcu7t3v3__nor2_2_7/VSS
+ gf180mcu_as_sc_mcu7t3v3__inv_2_422/Y VSS gf180mcu_as_sc_mcu7t3v3__nor2_2_7/VNW VSUBS
+ gf180mcu_as_sc_mcu7t3v3__inv_2
Xgf180mcu_as_sc_mcu7t3v3__inv_2_477 gf180mcu_as_sc_mcu7t3v3__nor2_2_4/VDD gf180mcu_as_sc_mcu7t3v3__nor2_2_4/VSS
+ gf180mcu_as_sc_mcu7t3v3__inv_2_477/Y VSS gf180mcu_as_sc_mcu7t3v3__nor2_2_4/VNW VSUBS
+ gf180mcu_as_sc_mcu7t3v3__inv_2
Xgf180mcu_as_sc_mcu7t3v3__inv_2_466 gf180mcu_as_sc_mcu7t3v3__nor2_2_4/VDD gf180mcu_as_sc_mcu7t3v3__nor2_2_4/VSS
+ VSS VSS gf180mcu_as_sc_mcu7t3v3__nor2_2_4/VNW VSUBS gf180mcu_as_sc_mcu7t3v3__inv_2
Xgf180mcu_as_sc_mcu7t3v3__inv_2_400 gf180mcu_as_sc_mcu7t3v3__nor2_2_4/VDD gf180mcu_as_sc_mcu7t3v3__nand2_2_3/VSS
+ VSS VSS gf180mcu_as_sc_mcu7t3v3__nor2_2_4/VNW VSUBS gf180mcu_as_sc_mcu7t3v3__inv_2
Xgf180mcu_as_sc_mcu7t3v3__inv_2_433 gf180mcu_as_sc_mcu7t3v3__nand3_2_9/VDD gf180mcu_as_sc_mcu7t3v3__nor2_2_4/VSS
+ VSS VSS gf180mcu_as_sc_mcu7t3v3__nand3_2_9/VNW VSUBS gf180mcu_as_sc_mcu7t3v3__inv_2
Xgf180mcu_as_sc_mcu7t3v3__inv_2_488 VSS VSS VSS VSS gf180mcu_as_sc_mcu7t3v3__inv_2_552/VNW
+ VSUBS gf180mcu_as_sc_mcu7t3v3__inv_2
Xgf180mcu_as_sc_mcu7t3v3__inv_2_499 VSS VSS gf180mcu_as_sc_mcu7t3v3__inv_2_499/Y VSS
+ gf180mcu_as_sc_mcu7t3v3__inv_2_563/VNW VSUBS gf180mcu_as_sc_mcu7t3v3__inv_2
Xu_t010_005 u_t010_005/c0_w0_bl u_t010_005/c0_w0_br u_t010_005/c0_w1_bl u_t010_005/c0_w1_br
+ u_t010_005/c0_r0_rbl u_t010_005/c0_r1_rbl u_t010_005/c1_w0_bl u_t010_005/c1_w0_br
+ u_t010_005/c1_w1_bl u_t010_005/c1_w1_br u_t010_005/c1_r0_rbl u_t010_005/c1_r1_rbl
+ u_t010_005/c2_w0_bl u_t010_005/c2_w0_br u_t010_005/c2_w1_bl u_t010_005/c2_w1_br
+ u_t010_005/c2_r0_rbl u_t010_005/c2_r1_rbl u_t010_005/c3_w0_bl u_t010_005/c3_w0_br
+ u_t010_005/c3_w1_bl u_t010_005/c3_w1_br u_t010_005/c3_r0_rbl u_t010_005/c3_r1_rbl
+ u_t010_005/r0_w0_wl u_t010_005/r0_w1_wl u_t010_005/r0_r0_rwl u_t010_005/r0_r1_rwl
+ u_t010_005/r1_w0_wl u_t010_005/r1_w1_wl u_t010_005/r1_r0_rwl u_t010_005/r1_r1_rwl
+ u_t010_005/r2_w0_wl u_t010_005/r2_w1_wl u_t010_005/r2_r0_rwl u_t010_005/r2_r1_rwl
+ u_t010_005/r3_w0_wl u_t010_005/r3_w1_wl u_t010_005/r3_r0_rwl u_t010_005/r3_r1_rwl
+ u_t010_005/VDD u_t010_005/VSS u_t010_005/m2_717_1265# u_t010_005/m2_603_2031# u_t010_005/m2_1290_336#
+ u_t010_005/m2_2000_2037# u_t010_005/m2_791_2909# u_t010_005/m2_7_2126# u_t010_005/m2_2154_2081#
+ u_t010_005/m2_1795_2037# u_t010_005/m2_871_303# u_t010_005/m2_431_438# u_t010_005/m2_1290_2898#
+ u_t010_005/m2_1714_1210# u_t010_005/m2_431_1982# u_t010_005/m2_512_1265# u_t010_005/m2_2573_2126#
+ u_t010_005/m2_603_1259# u_t010_005/m2_2074_2909# u_t010_005/m2_7_336# u_t010_005/m2_717_2037#
+ u_t010_005/m2_1886_2031# u_t010_005/m2_2573_336# u_t010_005/m2_7_2898# u_t010_005/m2_2000_1265#
+ u_t010_005/m2_512_2037# u_t010_005/m2_1795_1265# u_t010_005/m2_1714_1982# u_t010_005/m2_1886_1259#
+ u_t010_005/m2_1290_2126# u_t010_005/m2_1714_438# u_t010_005/m2_431_1210# u_t010_005/m2_2573_2898#
+ u_t010_005/m2_2154_303# u_t010_005/m2_871_2081# VSUBS detronyx_12t_2w2r_rc4_4x4_routed_5layer_direct
Xu_t001_005 u_t001_005/c0_w0_bl u_t001_005/c0_w0_br u_t001_005/c0_w1_bl u_t001_005/c0_w1_br
+ u_t001_005/c0_r0_rbl u_t001_005/c0_r1_rbl u_t001_005/c1_w0_bl u_t001_005/c1_w0_br
+ u_t001_005/c1_w1_bl u_t001_005/c1_w1_br u_t001_005/c1_r0_rbl u_t001_005/c1_r1_rbl
+ u_t001_005/c2_w0_bl u_t001_005/c2_w0_br u_t001_005/c2_w1_bl u_t001_005/c2_w1_br
+ u_t001_005/c2_r0_rbl u_t001_005/c2_r1_rbl u_t001_005/c3_w0_bl u_t001_005/c3_w0_br
+ u_t001_005/c3_w1_bl u_t001_005/c3_w1_br u_t001_005/c3_r0_rbl u_t001_005/c3_r1_rbl
+ u_t001_005/r0_w0_wl u_t001_005/r0_w1_wl u_t001_005/r0_r0_rwl u_t001_005/r0_r1_rwl
+ u_t001_005/r1_w0_wl u_t001_005/r1_w1_wl u_t001_005/r1_r0_rwl u_t001_005/r1_r1_rwl
+ u_t001_005/r2_w0_wl u_t001_005/r2_w1_wl u_t001_005/r2_r0_rwl u_t001_005/r2_r1_rwl
+ u_t001_005/r3_w0_wl u_t001_005/r3_w1_wl u_t001_005/r3_r0_rwl u_t001_005/r3_r1_rwl
+ u_t001_005/VDD VSS u_t001_005/m2_717_1265# u_t001_005/m2_603_2031# u_t001_005/m2_1290_336#
+ u_t001_005/m2_2000_2037# u_t001_005/m2_791_2909# u_t001_005/m2_7_2126# u_t001_005/m2_2154_2081#
+ u_t001_005/m2_1795_2037# u_t001_005/m2_871_303# u_t001_005/m2_431_438# u_t001_005/m2_1290_2898#
+ u_t001_005/m2_1714_1210# u_t001_005/m2_431_1982# u_t001_005/m2_512_1265# u_t001_005/m2_2573_2126#
+ u_t001_005/m2_603_1259# u_t001_005/m2_2074_2909# u_t001_005/m2_7_336# u_t001_005/m2_717_2037#
+ u_t001_005/m2_1886_2031# u_t001_005/m2_2573_336# u_t001_005/m2_7_2898# u_t001_005/m2_2000_1265#
+ u_t001_005/m2_512_2037# u_t001_005/m2_1795_1265# u_t001_005/m2_1714_1982# u_t001_005/m2_1886_1259#
+ u_t001_005/m2_1290_2126# u_t001_005/m2_1714_438# u_t001_005/m2_431_1210# u_t001_005/m2_2573_2898#
+ u_t001_005/m2_2154_303# u_t001_005/m2_871_2081# VSUBS detronyx_12t_2w2r_rc4_4x4_routed_5layer_direct
Xgf180mcu_as_sc_mcu7t3v3__inv_2_263 gf180mcu_as_sc_mcu7t3v3__inv_2_308/VSS VSS gf180mcu_as_sc_mcu7t3v3__inv_2_61/Y
+ gf180mcu_as_sc_mcu7t3v3__inv_2_61/Y gf180mcu_as_sc_mcu7t3v3__inv_2_264/VNW VSUBS
+ gf180mcu_as_sc_mcu7t3v3__inv_2
Xgf180mcu_as_sc_mcu7t3v3__inv_2_296 VSS gf180mcu_as_sc_mcu7t3v3__inv_2_308/VDD VSS
+ gf180mcu_as_sc_mcu7t3v3__inv_2_61/Y gf180mcu_as_sc_mcu7t3v3__inv_2_302/VNW VSUBS
+ gf180mcu_as_sc_mcu7t3v3__inv_2
Xgf180mcu_as_sc_mcu7t3v3__inv_2_285 gf180mcu_as_sc_mcu7t3v3__inv_2_301/VDD VSS gf180mcu_as_sc_mcu7t3v3__inv_2_285/Y
+ gf180mcu_as_sc_mcu7t3v3__inv_2_301/Y gf180mcu_as_sc_mcu7t3v3__inv_2_301/VNW VSUBS
+ gf180mcu_as_sc_mcu7t3v3__inv_2
Xgf180mcu_as_sc_mcu7t3v3__inv_2_274 gf180mcu_as_sc_mcu7t3v3__inv_2_311/VSS gf180mcu_as_sc_mcu7t3v3__inv_2_279/VDD
+ gf180mcu_as_sc_mcu7t3v3__inv_2_365/Y VSS gf180mcu_as_sc_mcu7t3v3__inv_2_274/VNW
+ VSUBS gf180mcu_as_sc_mcu7t3v3__inv_2
Xgf180mcu_as_sc_mcu7t3v3__inv_2_230 gf180mcu_as_sc_mcu7t3v3__inv_2_260/VDD gf180mcu_as_sc_mcu7t3v3__inv_2_260/VDD
+ VSS VSS gf180mcu_as_sc_mcu7t3v3__inv_2_230/VNW VSUBS gf180mcu_as_sc_mcu7t3v3__inv_2
Xgf180mcu_as_sc_mcu7t3v3__inv_2_252 VSS gf180mcu_as_sc_mcu7t3v3__inv_2_257/VDD gf180mcu_as_sc_mcu7t3v3__inv_2_252/Y
+ VSS gf180mcu_as_sc_mcu7t3v3__inv_2_254/VNW VSUBS gf180mcu_as_sc_mcu7t3v3__inv_2
Xgf180mcu_as_sc_mcu7t3v3__inv_2_241 gf180mcu_as_sc_mcu7t3v3__inv_2_242/VDD VSS VSS
+ VSS gf180mcu_as_sc_mcu7t3v3__inv_2_242/VNW VSUBS gf180mcu_as_sc_mcu7t3v3__inv_2
Xgf180mcu_as_sc_mcu7t3v3__inv_2_1707 gf180mcu_as_sc_mcu7t3v3__nor2_2_6/VDD gf180mcu_as_sc_mcu7t3v3__nor2_2_6/VSS
+ VSS VSS gf180mcu_as_sc_mcu7t3v3__nor2_2_6/VNW VSUBS gf180mcu_as_sc_mcu7t3v3__inv_2
Xgf180mcu_as_sc_mcu7t3v3__inv_2_1718 gf180mcu_as_sc_mcu7t3v3__inv_2_1720/VDD VSS gf180mcu_as_sc_mcu7t3v3__inv_2_1718/Y
+ VSS gf180mcu_as_sc_mcu7t3v3__inv_2_1720/VNW VSUBS gf180mcu_as_sc_mcu7t3v3__inv_2
Xgf180mcu_as_sc_mcu7t3v3__inv_2_1515 VSS gf180mcu_as_sc_mcu7t3v3__inv_2_1523/VDD VSS
+ VSS gf180mcu_as_sc_mcu7t3v3__inv_2_1520/VNW VSUBS gf180mcu_as_sc_mcu7t3v3__inv_2
Xgf180mcu_as_sc_mcu7t3v3__inv_2_1526 VSS VSS VSS VSS gf180mcu_as_sc_mcu7t3v3__inv_2_1526/VNW
+ VSUBS gf180mcu_as_sc_mcu7t3v3__inv_2
Xgf180mcu_as_sc_mcu7t3v3__inv_2_1504 VSS gf180mcu_as_sc_mcu7t3v3__inv_2_1508/VDD VSS
+ VSS gf180mcu_as_sc_mcu7t3v3__inv_2_1506/VNW VSUBS gf180mcu_as_sc_mcu7t3v3__inv_2
Xgf180mcu_as_sc_mcu7t3v3__inv_2_1548 VSS gf180mcu_as_sc_mcu7t3v3__inv_2_1553/VDD VSS
+ VSS gf180mcu_as_sc_mcu7t3v3__inv_2_1550/VNW VSUBS gf180mcu_as_sc_mcu7t3v3__inv_2
Xgf180mcu_as_sc_mcu7t3v3__inv_2_1559 VSS gf180mcu_as_sc_mcu7t3v3__inv_2_1562/VDD VSS
+ VSS gf180mcu_as_sc_mcu7t3v3__inv_2_1559/VNW VSUBS gf180mcu_as_sc_mcu7t3v3__inv_2
Xgf180mcu_as_sc_mcu7t3v3__inv_2_1537 VSS gf180mcu_as_sc_mcu7t3v3__inv_2_1541/VDD gf180mcu_as_sc_mcu7t3v3__inv_2_1537/Y
+ VSS gf180mcu_as_sc_mcu7t3v3__inv_2_1538/VNW VSUBS gf180mcu_as_sc_mcu7t3v3__inv_2
Xgf180mcu_as_sc_mcu7t3v3__nand4_2_309 gf180mcu_as_sc_mcu7t3v3__inv_2_1058/VDD gf180mcu_as_sc_mcu7t3v3__inv_2_1058/VSS
+ VSS VSS VSS VSS VSS gf180mcu_as_sc_mcu7t3v3__inv_2_1058/VNW VSUBS gf180mcu_as_sc_mcu7t3v3__nand4_2
Xgf180mcu_as_sc_mcu7t3v3__nand2_2_3 gf180mcu_as_sc_mcu7t3v3__nor2_2_4/VDD gf180mcu_as_sc_mcu7t3v3__nand2_2_3/VSS
+ VSS VSS VSS gf180mcu_as_sc_mcu7t3v3__nor2_2_4/VNW VSUBS gf180mcu_as_sc_mcu7t3v3__nand2_2
Xu_t029_008 u_t029_008/c0_w0_bl u_t029_008/c0_w0_br u_t029_008/c0_w1_bl u_t029_008/c0_w1_br
+ u_t029_008/c0_r0_rbl u_t029_008/c0_r1_rbl u_t029_008/c1_w0_bl u_t029_008/c1_w0_br
+ u_t029_008/c1_w1_bl u_t029_008/c1_w1_br u_t029_008/c1_r0_rbl u_t029_008/c1_r1_rbl
+ u_t029_008/c2_w0_bl u_t029_008/c2_w0_br u_t029_008/c2_w1_bl u_t029_008/c2_w1_br
+ u_t029_008/c2_r0_rbl u_t029_008/c2_r1_rbl u_t029_008/c3_w0_bl u_t029_008/c3_w0_br
+ u_t029_008/c3_w1_bl u_t029_008/c3_w1_br u_t029_008/c3_r0_rbl u_t029_008/c3_r1_rbl
+ u_t029_008/r0_w0_wl u_t029_008/r0_w1_wl u_t029_008/r0_r0_rwl u_t029_008/r0_r1_rwl
+ u_t029_008/r1_w0_wl u_t029_008/r1_w1_wl u_t029_008/r1_r0_rwl u_t029_008/r1_r1_rwl
+ u_t029_008/r2_w0_wl u_t029_008/r2_w1_wl u_t029_008/r2_r0_rwl u_t029_008/r2_r1_rwl
+ u_t029_008/r3_w0_wl u_t029_008/r3_w1_wl u_t029_008/r3_r0_rwl u_t029_008/r3_r1_rwl
+ VSS VSS u_t029_008/m2_717_1265# u_t029_008/m2_603_2031# u_t029_008/m2_1290_336#
+ u_t029_008/m2_2000_2037# u_t029_008/m2_791_2909# u_t029_008/m2_7_2126# u_t029_008/m2_2154_2081#
+ u_t029_008/m2_1795_2037# u_t029_008/m2_871_303# u_t029_008/m2_431_438# u_t029_008/m2_1290_2898#
+ u_t029_008/m2_1714_1210# u_t029_008/m2_431_1982# u_t029_008/m2_512_1265# u_t029_008/m2_2573_2126#
+ u_t029_008/m2_603_1259# u_t029_008/m2_2074_2909# u_t029_008/m2_7_336# u_t029_008/m2_717_2037#
+ u_t029_008/m2_1886_2031# u_t029_008/m2_2573_336# u_t029_008/m2_7_2898# u_t029_008/m2_2000_1265#
+ u_t029_008/m2_512_2037# u_t029_008/m2_1795_1265# u_t029_008/m2_1714_1982# u_t029_008/m2_1886_1259#
+ u_t029_008/m2_1290_2126# u_t029_008/m2_1714_438# u_t029_008/m2_431_1210# u_t029_008/m2_2573_2898#
+ u_t029_008/m2_2154_303# u_t029_008/m2_871_2081# VSUBS detronyx_12t_2w2r_rc4_4x4_routed_5layer_direct
Xgf180mcu_as_sc_mcu7t3v3__inv_2_1301 VSS VSS VSS VSS gf180mcu_as_sc_mcu7t3v3__inv_2_1301/VNW
+ VSUBS gf180mcu_as_sc_mcu7t3v3__inv_2
Xgf180mcu_as_sc_mcu7t3v3__inv_2_1378 gf180mcu_as_sc_mcu7t3v3__inv_2_1378/VDD gf180mcu_as_sc_mcu7t3v3__inv_2_1382/VDD
+ gf180mcu_as_sc_mcu7t3v3__inv_2_1382/Y VSS gf180mcu_as_sc_mcu7t3v3__inv_2_1378/VNW
+ VSUBS gf180mcu_as_sc_mcu7t3v3__inv_2
Xgf180mcu_as_sc_mcu7t3v3__inv_2_1367 VSS gf180mcu_as_sc_mcu7t3v3__inv_2_1391/VDD VSS
+ gf180mcu_as_sc_mcu7t3v3__inv_2_1409/A gf180mcu_as_sc_mcu7t3v3__inv_2_1375/VNW VSUBS
+ gf180mcu_as_sc_mcu7t3v3__inv_2
Xgf180mcu_as_sc_mcu7t3v3__inv_2_1356 VSS gf180mcu_as_sc_mcu7t3v3__inv_2_1409/VDD VSS
+ gf180mcu_as_sc_mcu7t3v3__inv_2_1409/A gf180mcu_as_sc_mcu7t3v3__inv_2_1358/VNW VSUBS
+ gf180mcu_as_sc_mcu7t3v3__inv_2
Xgf180mcu_as_sc_mcu7t3v3__inv_2_1323 VSS gf180mcu_as_sc_mcu7t3v3__inv_2_1717/VDD gf180mcu_as_sc_mcu7t3v3__inv_2_1323/Y
+ gf180mcu_as_sc_mcu7t3v3__inv_2_1717/Y gf180mcu_as_sc_mcu7t3v3__inv_2_1324/VNW VSUBS
+ gf180mcu_as_sc_mcu7t3v3__inv_2
Xgf180mcu_as_sc_mcu7t3v3__inv_2_1345 gf180mcu_as_sc_mcu7t3v3__inv_2_1349/VDD gf180mcu_as_sc_mcu7t3v3__inv_2_1349/VSS
+ gf180mcu_as_sc_mcu7t3v3__inv_2_1345/Y gf180mcu_as_sc_mcu7t3v3__inv_2_1355/Y gf180mcu_as_sc_mcu7t3v3__inv_2_1349/VNW
+ VSUBS gf180mcu_as_sc_mcu7t3v3__inv_2
Xgf180mcu_as_sc_mcu7t3v3__inv_2_1312 VSS gf180mcu_as_sc_mcu7t3v3__inv_2_1316/VDD gf180mcu_as_sc_mcu7t3v3__inv_2_1355/Y
+ VSS gf180mcu_as_sc_mcu7t3v3__inv_2_1312/VNW VSUBS gf180mcu_as_sc_mcu7t3v3__inv_2
Xgf180mcu_as_sc_mcu7t3v3__inv_2_1334 VSS gf180mcu_as_sc_mcu7t3v3__inv_2_1340/VDD VSS
+ gf180mcu_as_sc_mcu7t3v3__inv_2_1340/Y gf180mcu_as_sc_mcu7t3v3__inv_2_1336/VNW VSUBS
+ gf180mcu_as_sc_mcu7t3v3__inv_2
Xgf180mcu_as_sc_mcu7t3v3__inv_2_1389 VSS gf180mcu_as_sc_mcu7t3v3__inv_2_1394/VDD gf180mcu_as_sc_mcu7t3v3__inv_2_1389/Y
+ gf180mcu_as_sc_mcu7t3v3__inv_2_1394/Y gf180mcu_as_sc_mcu7t3v3__inv_2_1390/VNW VSUBS
+ gf180mcu_as_sc_mcu7t3v3__inv_2
Xgf180mcu_as_sc_mcu7t3v3__inv_2_818 VSS VSS VSS VSS gf180mcu_as_sc_mcu7t3v3__inv_2_819/VNW
+ VSUBS gf180mcu_as_sc_mcu7t3v3__inv_2
Xgf180mcu_as_sc_mcu7t3v3__inv_2_807 VSS VSS VSS VSS gf180mcu_as_sc_mcu7t3v3__inv_2_848/VNW
+ VSUBS gf180mcu_as_sc_mcu7t3v3__inv_2
Xgf180mcu_as_sc_mcu7t3v3__inv_2_829 VSS VSS VSS VSS gf180mcu_as_sc_mcu7t3v3__inv_2_829/VNW
+ VSUBS gf180mcu_as_sc_mcu7t3v3__inv_2
Xgf180mcu_as_sc_mcu7t3v3__nand4_2_128 VSS VSS VSS VSS VSS VSS gf180mcu_as_sc_mcu7t3v3__nand4_2_128/Y
+ gf180mcu_as_sc_mcu7t3v3__inv_2_547/VNW VSUBS gf180mcu_as_sc_mcu7t3v3__nand4_2
Xgf180mcu_as_sc_mcu7t3v3__nand4_2_139 VSS VSS VSS VSS VSS VSS VSS gf180mcu_as_sc_mcu7t3v3__inv_2_536/VNW
+ VSUBS gf180mcu_as_sc_mcu7t3v3__nand4_2
Xgf180mcu_as_sc_mcu7t3v3__nand4_2_106 gf180mcu_as_sc_mcu7t3v3__inv_2_371/VDD gf180mcu_as_sc_mcu7t3v3__inv_2_371/VSS
+ VSS VSS VSS VSS VSS gf180mcu_as_sc_mcu7t3v3__inv_2_371/VNW VSUBS gf180mcu_as_sc_mcu7t3v3__nand4_2
Xgf180mcu_as_sc_mcu7t3v3__nand4_2_117 gf180mcu_as_sc_mcu7t3v3__inv_2_304/VSS VSS VSS
+ VSS VSS VSS VSS gf180mcu_as_sc_mcu7t3v3__inv_2_303/VNW VSUBS gf180mcu_as_sc_mcu7t3v3__nand4_2
Xgf180mcu_as_sc_mcu7t3v3__nand4_2_67 gf180mcu_as_sc_mcu7t3v3__inv_2_24/VDD VSS VSS
+ VSS VSS VSS VSS gf180mcu_as_sc_mcu7t3v3__inv_2_24/VNW VSUBS gf180mcu_as_sc_mcu7t3v3__nand4_2
Xgf180mcu_as_sc_mcu7t3v3__nand4_2_23 VSS gf180mcu_as_sc_mcu7t3v3__inv_2_152/VDD VSS
+ VSS VSS VSS VSS gf180mcu_as_sc_mcu7t3v3__inv_2_149/VNW VSUBS gf180mcu_as_sc_mcu7t3v3__nand4_2
Xgf180mcu_as_sc_mcu7t3v3__nand4_2_89 gf180mcu_as_sc_mcu7t3v3__inv_2_38/VDD VSS VSS
+ VSS VSS VSS VSS gf180mcu_as_sc_mcu7t3v3__inv_2_38/VNW VSUBS gf180mcu_as_sc_mcu7t3v3__nand4_2
Xgf180mcu_as_sc_mcu7t3v3__nand4_2_12 gf180mcu_as_sc_mcu7t3v3__inv_2_116/VDD gf180mcu_as_sc_mcu7t3v3__inv_2_122/VDD
+ VSS VSS VSS VSS gf180mcu_as_sc_mcu7t3v3__nand4_2_12/Y gf180mcu_as_sc_mcu7t3v3__inv_2_116/VNW
+ VSUBS gf180mcu_as_sc_mcu7t3v3__nand4_2
Xgf180mcu_as_sc_mcu7t3v3__nand4_2_34 gf180mcu_as_sc_mcu7t3v3__inv_2_163/VDD VSS VSS
+ VSS VSS VSS VSS gf180mcu_as_sc_mcu7t3v3__inv_2_163/VNW VSUBS gf180mcu_as_sc_mcu7t3v3__nand4_2
Xgf180mcu_as_sc_mcu7t3v3__nand4_2_45 VSS gf180mcu_as_sc_mcu7t3v3__inv_2_218/VDD VSS
+ VSS VSS VSS gf180mcu_as_sc_mcu7t3v3__nand4_2_45/Y gf180mcu_as_sc_mcu7t3v3__inv_2_215/VNW
+ VSUBS gf180mcu_as_sc_mcu7t3v3__nand4_2
Xgf180mcu_as_sc_mcu7t3v3__nand4_2_78 gf180mcu_as_sc_mcu7t3v3__inv_2_338/VDD gf180mcu_as_sc_mcu7t3v3__inv_2_341/VDD
+ VSS VSS VSS VSS VSS gf180mcu_as_sc_mcu7t3v3__inv_2_338/VNW VSUBS gf180mcu_as_sc_mcu7t3v3__nand4_2
Xgf180mcu_as_sc_mcu7t3v3__nand4_2_56 gf180mcu_as_sc_mcu7t3v3__inv_2_248/VDD gf180mcu_as_sc_mcu7t3v3__inv_2_251/VDD
+ VSS VSS VSS VSS gf180mcu_as_sc_mcu7t3v3__nand4_2_56/Y gf180mcu_as_sc_mcu7t3v3__inv_2_248/VNW
+ VSUBS gf180mcu_as_sc_mcu7t3v3__nand4_2
Xu_t025_000 VSS u_t025_000/c0_w0_br VSS u_t025_000/c0_w1_br u_t025_000/c0_r0_rbl u_t025_000/c0_r1_rbl
+ VSS VSS VSS VSS VSS VSS u_t025_000/c2_w0_bl u_t025_000/c2_w0_br u_t025_000/c2_w1_bl
+ u_t025_000/c2_w1_br u_t025_000/c2_r0_rbl u_t025_000/c2_r1_rbl u_t025_000/c3_w0_bl
+ u_t025_000/c3_w0_br u_t025_000/c3_w1_bl u_t025_000/c3_w1_br u_t025_000/c3_r0_rbl
+ u_t025_000/c3_r1_rbl VSS VSS VSS VSS VSS VSS VSS VSS VSS VSS VSS VSS VSS VSS VSS
+ VSS VSS VSS u_t025_000/m2_717_1265# VSS VSS VSS VSS u_t025_000/m2_7_2126# VSS VSS
+ VSS VSS VSS VSS VSS u_t025_000/m2_512_1265# u_t025_000/m2_2573_2126# VSS VSS VSS
+ VSS VSS u_t025_000/m2_2573_336# VSS u_t025_000/m2_2000_1265# VSS u_t025_000/m2_1795_1265#
+ VSS VSS u_t025_000/m2_1290_2126# VSS VSS u_t025_000/m2_2573_2898# VSS VSS VSUBS
+ detronyx_12t_2w2r_rc4_4x4_routed_5layer_direct
Xu_t025_011 u_t025_011/c0_w0_bl u_t025_011/c0_w0_br u_t025_011/c0_w1_bl u_t025_011/c0_w1_br
+ u_t025_011/c0_r0_rbl u_t025_011/c0_r1_rbl u_t025_011/c1_w0_bl u_t025_011/c1_w0_br
+ u_t025_011/c1_w1_bl u_t025_011/c1_w1_br u_t025_011/c1_r0_rbl u_t025_011/c1_r1_rbl
+ u_t025_011/c2_w0_bl u_t025_011/c2_w0_br u_t025_011/c2_w1_bl u_t025_011/c2_w1_br
+ u_t025_011/c2_r0_rbl u_t025_011/c2_r1_rbl u_t025_011/c3_w0_bl u_t025_011/c3_w0_br
+ u_t025_011/c3_w1_bl u_t025_011/c3_w1_br u_t025_011/c3_r0_rbl u_t025_011/c3_r1_rbl
+ u_t025_011/r0_w0_wl u_t025_011/r0_w1_wl u_t025_011/r0_r0_rwl u_t025_011/r0_r1_rwl
+ u_t025_011/r1_w0_wl u_t025_011/r1_w1_wl u_t025_011/r1_r0_rwl u_t025_011/r1_r1_rwl
+ u_t025_011/r2_w0_wl u_t025_011/r2_w1_wl u_t025_011/r2_r0_rwl u_t025_011/r2_r1_rwl
+ u_t025_011/r3_w0_wl u_t025_011/r3_w1_wl u_t025_011/r3_r0_rwl u_t025_011/r3_r1_rwl
+ u_t025_011/VDD VSS u_t025_011/m2_717_1265# u_t025_011/m2_603_2031# u_t025_011/m2_1290_336#
+ u_t025_011/m2_2000_2037# u_t025_011/m2_791_2909# u_t025_011/m2_7_2126# u_t025_011/m2_2154_2081#
+ u_t025_011/m2_1795_2037# u_t025_011/m2_871_303# u_t025_011/m2_431_438# u_t025_011/m2_1290_2898#
+ u_t025_011/m2_1714_1210# u_t025_011/m2_431_1982# u_t025_011/m2_512_1265# u_t025_011/m2_2573_2126#
+ u_t025_011/m2_603_1259# u_t025_011/m2_2074_2909# u_t025_011/m2_7_336# u_t025_011/m2_717_2037#
+ u_t025_011/m2_1886_2031# u_t025_011/m2_2573_336# u_t025_011/m2_7_2898# u_t025_011/m2_2000_1265#
+ u_t025_011/m2_512_2037# u_t025_011/m2_1795_1265# u_t025_011/m2_1714_1982# u_t025_011/m2_1886_1259#
+ u_t025_011/m2_1290_2126# u_t025_011/m2_1714_438# u_t025_011/m2_431_1210# u_t025_011/m2_2573_2898#
+ u_t025_011/m2_2154_303# u_t025_011/m2_871_2081# VSUBS detronyx_12t_2w2r_rc4_4x4_routed_5layer_direct
Xgf180mcu_as_sc_mcu7t3v3__inv_2_1197 gf180mcu_as_sc_mcu7t3v3__nor2_2_9/VDD gf180mcu_as_sc_mcu7t3v3__nand3_2_63/VSS
+ gf180mcu_as_sc_mcu7t3v3__inv_2_1197/Y VSS gf180mcu_as_sc_mcu7t3v3__nor2_2_9/VNW
+ VSUBS gf180mcu_as_sc_mcu7t3v3__inv_2
Xgf180mcu_as_sc_mcu7t3v3__inv_2_1131 gf180mcu_as_sc_mcu7t3v3__inv_2_1133/VDD VSS VSS
+ VSS gf180mcu_as_sc_mcu7t3v3__inv_2_1133/VNW VSUBS gf180mcu_as_sc_mcu7t3v3__inv_2
Xgf180mcu_as_sc_mcu7t3v3__inv_2_1186 VSS VSS VSS VSS gf180mcu_as_sc_mcu7t3v3__inv_2_1278/VNW
+ VSUBS gf180mcu_as_sc_mcu7t3v3__inv_2
Xgf180mcu_as_sc_mcu7t3v3__inv_2_1142 gf180mcu_as_sc_mcu7t3v3__inv_2_1142/VDD VSS gf180mcu_as_sc_mcu7t3v3__inv_2_1142/Y
+ VSS gf180mcu_as_sc_mcu7t3v3__inv_2_1142/VNW VSUBS gf180mcu_as_sc_mcu7t3v3__inv_2
Xgf180mcu_as_sc_mcu7t3v3__inv_2_1120 VSS VSS gf180mcu_as_sc_mcu7t3v3__inv_2_1120/Y
+ gf180mcu_as_sc_mcu7t3v3__inv_2_1121/Y gf180mcu_as_sc_mcu7t3v3__inv_2_1121/VNW VSUBS
+ gf180mcu_as_sc_mcu7t3v3__inv_2
Xgf180mcu_as_sc_mcu7t3v3__inv_2_1153 VSS VSS VSS VSS gf180mcu_as_sc_mcu7t3v3__inv_2_1263/VNW
+ VSUBS gf180mcu_as_sc_mcu7t3v3__inv_2
Xgf180mcu_as_sc_mcu7t3v3__inv_2_1164 VSS VSS VSS VSS gf180mcu_as_sc_mcu7t3v3__inv_2_1293/VNW
+ VSUBS gf180mcu_as_sc_mcu7t3v3__inv_2
Xgf180mcu_as_sc_mcu7t3v3__inv_2_1175 VSS VSS VSS VSS gf180mcu_as_sc_mcu7t3v3__inv_2_1301/VNW
+ VSUBS gf180mcu_as_sc_mcu7t3v3__inv_2
Xu_t016_011 u_t016_011/c0_w0_bl u_t016_011/c0_w0_br u_t016_011/c0_w1_bl u_t016_011/c0_w1_br
+ u_t016_011/c0_r0_rbl u_t016_011/c0_r1_rbl u_t016_011/c1_w0_bl u_t016_011/c1_w0_br
+ u_t016_011/c1_w1_bl u_t016_011/c1_w1_br u_t016_011/c1_r0_rbl u_t016_011/c1_r1_rbl
+ u_t016_011/c2_w0_bl u_t016_011/c2_w0_br u_t016_011/c2_w1_bl u_t016_011/c2_w1_br
+ u_t016_011/c2_r0_rbl u_t016_011/c2_r1_rbl u_t016_011/c3_w0_bl u_t016_011/c3_w0_br
+ u_t016_011/c3_w1_bl u_t016_011/c3_w1_br u_t016_011/c3_r0_rbl u_t016_011/c3_r1_rbl
+ u_t016_011/r0_w0_wl u_t016_011/r0_w1_wl u_t016_011/r0_r0_rwl u_t016_011/r0_r1_rwl
+ u_t016_011/r1_w0_wl u_t016_011/r1_w1_wl u_t016_011/r1_r0_rwl u_t016_011/r1_r1_rwl
+ u_t016_011/r2_w0_wl u_t016_011/r2_w1_wl u_t016_011/r2_r0_rwl u_t016_011/r2_r1_rwl
+ u_t016_011/r3_w0_wl u_t016_011/r3_w1_wl u_t016_011/r3_r0_rwl u_t016_011/r3_r1_rwl
+ u_t016_011/VDD u_t016_011/VSS u_t016_011/m2_717_1265# u_t016_011/m2_603_2031# u_t016_011/m2_1290_336#
+ u_t016_011/m2_2000_2037# u_t016_011/m2_791_2909# u_t016_011/m2_7_2126# u_t016_011/m2_2154_2081#
+ u_t016_011/m2_1795_2037# u_t016_011/m2_871_303# u_t016_011/m2_431_438# u_t016_011/m2_1290_2898#
+ u_t016_011/m2_1714_1210# u_t016_011/m2_431_1982# u_t016_011/m2_512_1265# u_t016_011/m2_2573_2126#
+ u_t016_011/m2_603_1259# u_t016_011/m2_2074_2909# u_t016_011/m2_7_336# u_t016_011/m2_717_2037#
+ u_t016_011/m2_1886_2031# u_t016_011/m2_2573_336# u_t016_011/m2_7_2898# u_t016_011/m2_2000_1265#
+ u_t016_011/m2_512_2037# u_t016_011/m2_1795_1265# u_t016_011/m2_1714_1982# u_t016_011/m2_1886_1259#
+ u_t016_011/m2_1290_2126# u_t016_011/m2_1714_438# u_t016_011/m2_431_1210# u_t016_011/m2_2573_2898#
+ u_t016_011/m2_2154_303# u_t016_011/m2_871_2081# VSUBS detronyx_12t_2w2r_rc4_4x4_routed_5layer_direct
Xgf180mcu_as_sc_mcu7t3v3__inv_2_637 gf180mcu_as_sc_mcu7t3v3__inv_2_637/VDD VSS gf180mcu_as_sc_mcu7t3v3__inv_2_637/Y
+ VSS gf180mcu_as_sc_mcu7t3v3__inv_2_637/VNW VSUBS gf180mcu_as_sc_mcu7t3v3__inv_2
Xgf180mcu_as_sc_mcu7t3v3__inv_2_604 gf180mcu_as_sc_mcu7t3v3__inv_2_606/VDD VSS gf180mcu_as_sc_mcu7t3v3__inv_2_604/Y
+ gf180mcu_as_sc_mcu7t3v3__inv_2_638/A gf180mcu_as_sc_mcu7t3v3__inv_2_606/VNW VSUBS
+ gf180mcu_as_sc_mcu7t3v3__inv_2
Xgf180mcu_as_sc_mcu7t3v3__inv_2_626 gf180mcu_as_sc_mcu7t3v3__inv_2_632/VDD gf180mcu_as_sc_mcu7t3v3__inv_2_632/VDD
+ gf180mcu_as_sc_mcu7t3v3__inv_2_626/Y gf180mcu_as_sc_mcu7t3v3__inv_2_634/A gf180mcu_as_sc_mcu7t3v3__inv_2_628/VNW
+ VSUBS gf180mcu_as_sc_mcu7t3v3__inv_2
Xgf180mcu_as_sc_mcu7t3v3__inv_2_615 gf180mcu_as_sc_mcu7t3v3__inv_2_854/VSS gf180mcu_as_sc_mcu7t3v3__inv_2_620/VDD
+ gf180mcu_as_sc_mcu7t3v3__inv_2_853/Y gf180mcu_as_sc_mcu7t3v3__inv_2_616/Y gf180mcu_as_sc_mcu7t3v3__inv_2_616/VNW
+ VSUBS gf180mcu_as_sc_mcu7t3v3__inv_2
Xgf180mcu_as_sc_mcu7t3v3__inv_2_659 VSS gf180mcu_as_sc_mcu7t3v3__inv_2_664/VDD gf180mcu_as_sc_mcu7t3v3__inv_2_659/Y
+ gf180mcu_as_sc_mcu7t3v3__inv_2_660/Y gf180mcu_as_sc_mcu7t3v3__inv_2_660/VNW VSUBS
+ gf180mcu_as_sc_mcu7t3v3__inv_2
Xgf180mcu_as_sc_mcu7t3v3__inv_2_648 VSS VSS gf180mcu_as_sc_mcu7t3v3__inv_2_648/Y gf180mcu_as_sc_mcu7t3v3__inv_2_662/A
+ gf180mcu_as_sc_mcu7t3v3__inv_2_650/VNW VSUBS gf180mcu_as_sc_mcu7t3v3__inv_2
Xu_t016_000 VSS u_t016_000/c0_w0_br VSS u_t016_000/c0_w1_br u_t016_000/c0_r0_rbl u_t016_000/c0_r1_rbl
+ VSS VSS VSS VSS VSS VSS u_t016_000/c2_w0_bl u_t016_000/c2_w0_br u_t016_000/c2_w1_bl
+ u_t016_000/c2_w1_br u_t016_000/c2_r0_rbl u_t016_000/c2_r1_rbl u_t016_000/c3_w0_bl
+ u_t016_000/c3_w0_br u_t016_000/c3_w1_bl u_t016_000/c3_w1_br u_t016_000/c3_r0_rbl
+ u_t016_000/c3_r1_rbl VSS VSS VSS VSS VSS VSS VSS VSS VSS VSS VSS VSS VSS VSS VSS
+ VSS VSS VSS VSS VSS VSS VSS VSS VSS VSS VSS VSS VSS u_t016_000/m2_1290_2898# VSS
+ VSS VSS u_t016_000/m2_2573_2126# VSS VSS VSS VSS VSS u_t016_000/m2_2573_336# u_t016_000/m2_7_2898#
+ VSS VSS VSS u_t016_000/m2_1714_1982# VSS VSS u_t016_000/m2_1714_438# VSS u_t016_000/m2_2573_2898#
+ VSS VSS VSUBS detronyx_12t_2w2r_rc4_4x4_routed_5layer_direct
Xu_t031_014 u_t031_014/c0_w0_bl u_t031_014/c0_w0_br u_t031_014/c0_w1_bl u_t031_014/c0_w1_br
+ u_t031_014/c0_r0_rbl u_t031_014/c0_r1_rbl u_t031_014/c1_w0_bl u_t031_014/c1_w0_br
+ u_t031_014/c1_w1_bl u_t031_014/c1_w1_br u_t031_014/c1_r0_rbl u_t031_014/c1_r1_rbl
+ u_t031_014/c2_w0_bl u_t031_014/c2_w0_br u_t031_014/c2_w1_bl u_t031_014/c2_w1_br
+ u_t031_014/c2_r0_rbl u_t031_014/c2_r1_rbl u_t031_014/c3_w0_bl u_t031_014/c3_w0_br
+ u_t031_014/c3_w1_bl u_t031_014/c3_w1_br u_t031_014/c3_r0_rbl u_t031_014/c3_r1_rbl
+ u_t031_014/r0_w0_wl u_t031_014/r0_w1_wl u_t031_014/r0_r0_rwl u_t031_014/r0_r1_rwl
+ u_t031_014/r1_w0_wl u_t031_014/r1_w1_wl u_t031_014/r1_r0_rwl u_t031_014/r1_r1_rwl
+ u_t031_014/r2_w0_wl u_t031_014/r2_w1_wl u_t031_014/r2_r0_rwl u_t031_014/r2_r1_rwl
+ u_t031_014/r3_w0_wl u_t031_014/r3_w1_wl u_t031_014/r3_r0_rwl u_t031_014/r3_r1_rwl
+ u_t031_014/VDD u_t031_015/VSS u_t031_014/m2_717_1265# u_t031_014/m2_603_2031# u_t031_014/m2_1290_336#
+ u_t031_014/m2_2000_2037# u_t031_014/m2_791_2909# u_t031_014/m2_7_2126# u_t031_014/m2_2154_2081#
+ u_t031_014/m2_1795_2037# u_t031_014/m2_871_303# u_t031_014/m2_431_438# u_t031_014/m2_1290_2898#
+ u_t031_014/m2_1714_1210# u_t031_014/m2_431_1982# u_t031_014/m2_512_1265# u_t031_014/m2_2573_2126#
+ u_t031_014/m2_603_1259# u_t031_014/m2_2074_2909# u_t031_014/m2_7_336# u_t031_014/m2_717_2037#
+ u_t031_014/m2_1886_2031# u_t031_014/m2_2573_336# u_t031_014/m2_7_2898# u_t031_014/m2_2000_1265#
+ u_t031_014/m2_512_2037# u_t031_014/m2_1795_1265# u_t031_014/m2_1714_1982# u_t031_014/m2_1886_1259#
+ u_t031_014/m2_1290_2126# u_t031_014/m2_1714_438# u_t031_014/m2_431_1210# u_t031_014/m2_2573_2898#
+ u_t031_014/m2_2154_303# u_t031_014/m2_871_2081# VSUBS detronyx_12t_2w2r_rc4_4x4_routed_5layer_direct
Xu_t031_003 u_t031_003/c0_w0_bl u_t031_003/c0_w0_br u_t031_003/c0_w1_bl u_t031_003/c0_w1_br
+ u_t031_003/c0_r0_rbl u_t031_003/c0_r1_rbl u_t031_003/c1_w0_bl u_t031_003/c1_w0_br
+ u_t031_003/c1_w1_bl u_t031_003/c1_w1_br u_t031_003/c1_r0_rbl u_t031_003/c1_r1_rbl
+ u_t031_003/c2_w0_bl u_t031_003/c2_w0_br u_t031_003/c2_w1_bl u_t031_003/c2_w1_br
+ u_t031_003/c2_r0_rbl u_t031_003/c2_r1_rbl u_t031_003/c3_w0_bl u_t031_003/c3_w0_br
+ u_t031_003/c3_w1_bl u_t031_003/c3_w1_br u_t031_003/c3_r0_rbl u_t031_003/c3_r1_rbl
+ u_t031_003/r0_w0_wl u_t031_003/r0_w1_wl u_t031_003/r0_r0_rwl u_t031_003/r0_r1_rwl
+ u_t031_003/r1_w0_wl u_t031_003/r1_w1_wl u_t031_003/r1_r0_rwl u_t031_003/r1_r1_rwl
+ u_t031_003/r2_w0_wl u_t031_003/r2_w1_wl u_t031_003/r2_r0_rwl u_t031_003/r2_r1_rwl
+ u_t031_003/r3_w0_wl u_t031_003/r3_w1_wl u_t031_003/r3_r0_rwl u_t031_003/r3_r1_rwl
+ u_t031_003/VDD u_t031_003/VSS u_t031_003/m2_717_1265# u_t031_003/m2_603_2031# u_t031_003/m2_1290_336#
+ u_t031_003/m2_2000_2037# u_t031_003/m2_791_2909# u_t031_003/m2_7_2126# u_t031_003/m2_2154_2081#
+ u_t031_003/m2_1795_2037# u_t031_003/m2_871_303# u_t031_003/m2_431_438# u_t031_003/m2_1290_2898#
+ u_t031_003/m2_1714_1210# u_t031_003/m2_431_1982# u_t031_003/m2_512_1265# u_t031_003/m2_2573_2126#
+ u_t031_003/m2_603_1259# u_t031_003/m2_2074_2909# u_t031_003/m2_7_336# u_t031_003/m2_717_2037#
+ u_t031_003/m2_1886_2031# u_t031_003/m2_2573_336# u_t031_003/m2_7_2898# u_t031_003/m2_2000_1265#
+ u_t031_003/m2_512_2037# u_t031_003/m2_1795_1265# u_t031_003/m2_1714_1982# u_t031_003/m2_1886_1259#
+ u_t031_003/m2_1290_2126# u_t031_003/m2_1714_438# u_t031_003/m2_431_1210# u_t031_003/m2_2573_2898#
+ u_t031_003/m2_2154_303# u_t031_003/m2_871_2081# VSUBS detronyx_12t_2w2r_rc4_4x4_routed_5layer_direct
Xu_t007_000 VSS u_t007_000/c0_w0_br VSS u_t007_000/c0_w1_br u_t007_000/c0_r0_rbl u_t007_000/c0_r1_rbl
+ VSS VSS VSS VSS VSS VSS u_t007_000/c2_w0_bl u_t007_000/c2_w0_br u_t007_000/c2_w1_bl
+ u_t007_000/c2_w1_br u_t007_000/c2_r0_rbl u_t007_000/c2_r1_rbl u_t007_000/c3_w0_bl
+ u_t007_000/c3_w0_br u_t007_000/c3_w1_bl u_t007_000/c3_w1_br u_t007_000/c3_r0_rbl
+ u_t007_000/c3_r1_rbl VSS VSS VSS VSS VSS VSS VSS VSS VSS VSS VSS VSS VSS VSS VSS
+ VSS VSS VSS u_t007_000/m2_717_1265# u_t007_000/m2_603_2031# u_t007_000/m2_1290_336#
+ u_t007_000/m2_2000_2037# u_t007_000/m2_791_2909# u_t007_000/m2_7_2126# u_t007_000/m2_2154_2081#
+ u_t007_000/m2_1795_2037# u_t007_000/m2_871_303# u_t007_000/m2_431_438# u_t007_000/m2_1290_2898#
+ u_t007_000/m2_1714_1210# u_t007_000/m2_431_1982# u_t007_000/m2_512_1265# u_t007_000/m2_2573_2126#
+ u_t007_000/m2_603_1259# u_t007_000/m2_2074_2909# u_t007_000/m2_7_336# u_t007_000/m2_717_2037#
+ u_t007_000/m2_1886_2031# u_t007_000/m2_2573_336# u_t007_000/m2_7_2898# u_t007_000/m2_2000_1265#
+ u_t007_000/m2_512_2037# u_t007_000/m2_1795_1265# u_t007_000/m2_1714_1982# u_t007_000/m2_1886_1259#
+ u_t007_000/m2_1290_2126# u_t007_000/m2_1714_438# u_t007_000/m2_431_1210# u_t007_000/m2_2573_2898#
+ u_t007_000/m2_2154_303# u_t007_000/m2_871_2081# VSUBS detronyx_12t_2w2r_rc4_4x4_routed_5layer_direct
Xu_t022_014 u_t022_014/c0_w0_bl u_t022_014/c0_w0_br u_t022_014/c0_w1_bl u_t022_014/c0_w1_br
+ u_t022_014/c0_r0_rbl u_t022_014/c0_r1_rbl u_t022_014/c1_w0_bl u_t022_014/c1_w0_br
+ u_t022_014/c1_w1_bl u_t022_014/c1_w1_br u_t022_014/c1_r0_rbl u_t022_014/c1_r1_rbl
+ u_t022_014/c2_w0_bl u_t022_014/c2_w0_br u_t022_014/c2_w1_bl u_t022_014/c2_w1_br
+ u_t022_014/c2_r0_rbl u_t022_014/c2_r1_rbl u_t022_014/c3_w0_bl u_t022_014/c3_w0_br
+ u_t022_014/c3_w1_bl u_t022_014/c3_w1_br u_t022_014/c3_r0_rbl u_t022_014/c3_r1_rbl
+ u_t022_014/r0_w0_wl u_t022_014/r0_w1_wl u_t022_014/r0_r0_rwl u_t022_014/r0_r1_rwl
+ u_t022_014/r1_w0_wl u_t022_014/r1_w1_wl u_t022_014/r1_r0_rwl u_t022_014/r1_r1_rwl
+ u_t022_014/r2_w0_wl u_t022_014/r2_w1_wl u_t022_014/r2_r0_rwl u_t022_014/r2_r1_rwl
+ u_t022_014/r3_w0_wl u_t022_014/r3_w1_wl u_t022_014/r3_r0_rwl u_t022_014/r3_r1_rwl
+ u_t022_014/VDD VSS u_t022_014/m2_717_1265# u_t022_014/m2_603_2031# u_t022_014/m2_1290_336#
+ u_t022_014/m2_2000_2037# u_t022_014/m2_791_2909# u_t022_014/m2_7_2126# u_t022_014/m2_2154_2081#
+ u_t022_014/m2_1795_2037# u_t022_014/m2_871_303# u_t022_014/m2_431_438# u_t022_014/m2_1290_2898#
+ u_t022_014/m2_1714_1210# u_t022_014/m2_431_1982# u_t022_014/m2_512_1265# u_t022_014/m2_2573_2126#
+ u_t022_014/m2_603_1259# u_t022_014/m2_2074_2909# u_t022_014/m2_7_336# u_t022_014/m2_717_2037#
+ u_t022_014/m2_1886_2031# u_t022_014/m2_2573_336# u_t022_014/m2_7_2898# u_t022_014/m2_2000_1265#
+ u_t022_014/m2_512_2037# u_t022_014/m2_1795_1265# u_t022_014/m2_1714_1982# u_t022_014/m2_1886_1259#
+ u_t022_014/m2_1290_2126# u_t022_014/m2_1714_438# u_t022_014/m2_431_1210# u_t022_014/m2_2573_2898#
+ u_t022_014/m2_2154_303# u_t022_014/m2_871_2081# VSUBS detronyx_12t_2w2r_rc4_4x4_routed_5layer_direct
Xu_t007_011 u_t007_011/c0_w0_bl u_t007_011/c0_w0_br u_t007_011/c0_w1_bl u_t007_011/c0_w1_br
+ u_t007_011/c0_r0_rbl u_t007_011/c0_r1_rbl u_t007_011/c1_w0_bl u_t007_011/c1_w0_br
+ u_t007_011/c1_w1_bl u_t007_011/c1_w1_br u_t007_011/c1_r0_rbl u_t007_011/c1_r1_rbl
+ u_t007_011/c2_w0_bl u_t007_011/c2_w0_br u_t007_011/c2_w1_bl u_t007_011/c2_w1_br
+ u_t007_011/c2_r0_rbl u_t007_011/c2_r1_rbl u_t007_011/c3_w0_bl u_t007_011/c3_w0_br
+ u_t007_011/c3_w1_bl u_t007_011/c3_w1_br u_t007_011/c3_r0_rbl u_t007_011/c3_r1_rbl
+ u_t007_011/r0_w0_wl u_t007_011/r0_w1_wl u_t007_011/r0_r0_rwl u_t007_011/r0_r1_rwl
+ u_t007_011/r1_w0_wl u_t007_011/r1_w1_wl u_t007_011/r1_r0_rwl u_t007_011/r1_r1_rwl
+ u_t007_011/r2_w0_wl u_t007_011/r2_w1_wl u_t007_011/r2_r0_rwl u_t007_011/r2_r1_rwl
+ u_t007_011/r3_w0_wl u_t007_011/r3_w1_wl u_t007_011/r3_r0_rwl u_t007_011/r3_r1_rwl
+ u_t008_011/VDD u_t007_011/VSS u_t007_011/m2_717_1265# u_t007_011/m2_603_2031# u_t007_011/m2_1290_336#
+ u_t007_011/m2_2000_2037# u_t007_011/m2_791_2909# u_t007_011/m2_7_2126# u_t007_011/m2_2154_2081#
+ u_t007_011/m2_1795_2037# u_t007_011/m2_871_303# u_t007_011/m2_431_438# u_t007_011/m2_1290_2898#
+ u_t007_011/m2_1714_1210# u_t007_011/m2_431_1982# u_t007_011/m2_512_1265# u_t007_011/m2_2573_2126#
+ u_t007_011/m2_603_1259# u_t007_011/m2_2074_2909# u_t007_011/m2_7_336# u_t007_011/m2_717_2037#
+ u_t007_011/m2_1886_2031# u_t007_011/m2_2573_336# u_t007_011/m2_7_2898# u_t007_011/m2_2000_1265#
+ u_t007_011/m2_512_2037# u_t007_011/m2_1795_1265# u_t007_011/m2_1714_1982# u_t007_011/m2_1886_1259#
+ u_t007_011/m2_1290_2126# u_t007_011/m2_1714_438# u_t007_011/m2_431_1210# u_t007_011/m2_2573_2898#
+ u_t007_011/m2_2154_303# u_t007_011/m2_871_2081# VSUBS detronyx_12t_2w2r_rc4_4x4_routed_5layer_direct
Xu_t022_003 u_t022_003/c0_w0_bl u_t022_003/c0_w0_br u_t022_003/c0_w1_bl u_t022_003/c0_w1_br
+ u_t022_003/c0_r0_rbl u_t022_003/c0_r1_rbl u_t022_003/c1_w0_bl u_t022_003/c1_w0_br
+ u_t022_003/c1_w1_bl u_t022_003/c1_w1_br u_t022_003/c1_r0_rbl u_t022_003/c1_r1_rbl
+ u_t022_003/c2_w0_bl u_t022_003/c2_w0_br u_t022_003/c2_w1_bl u_t022_003/c2_w1_br
+ u_t022_003/c2_r0_rbl u_t022_003/c2_r1_rbl u_t022_003/c3_w0_bl u_t022_003/c3_w0_br
+ u_t022_003/c3_w1_bl u_t022_003/c3_w1_br u_t022_003/c3_r0_rbl u_t022_003/c3_r1_rbl
+ u_t022_003/r0_w0_wl u_t022_003/r0_w1_wl u_t022_003/r0_r0_rwl u_t022_003/r0_r1_rwl
+ u_t022_003/r1_w0_wl u_t022_003/r1_w1_wl u_t022_003/r1_r0_rwl u_t022_003/r1_r1_rwl
+ u_t022_003/r2_w0_wl u_t022_003/r2_w1_wl u_t022_003/r2_r0_rwl u_t022_003/r2_r1_rwl
+ u_t022_003/r3_w0_wl u_t022_003/r3_w1_wl u_t022_003/r3_r0_rwl u_t022_003/r3_r1_rwl
+ u_t022_003/VDD VSS u_t022_003/m2_717_1265# u_t022_003/m2_603_2031# u_t022_003/m2_1290_336#
+ u_t022_003/m2_2000_2037# u_t022_003/m2_791_2909# u_t022_003/m2_7_2126# u_t022_003/m2_2154_2081#
+ u_t022_003/m2_1795_2037# u_t022_003/m2_871_303# u_t022_003/m2_431_438# u_t022_003/m2_1290_2898#
+ u_t022_003/m2_1714_1210# u_t022_003/m2_431_1982# u_t022_003/m2_512_1265# u_t022_003/m2_2573_2126#
+ u_t022_003/m2_603_1259# u_t022_003/m2_2074_2909# u_t022_003/m2_7_336# u_t022_003/m2_717_2037#
+ u_t022_003/m2_1886_2031# u_t022_003/m2_2573_336# u_t022_003/m2_7_2898# u_t022_003/m2_2000_1265#
+ u_t022_003/m2_512_2037# u_t022_003/m2_1795_1265# u_t022_003/m2_1714_1982# u_t022_003/m2_1886_1259#
+ u_t022_003/m2_1290_2126# u_t022_003/m2_1714_438# u_t022_003/m2_431_1210# u_t022_003/m2_2573_2898#
+ u_t022_003/m2_2154_303# u_t022_003/m2_871_2081# VSUBS detronyx_12t_2w2r_rc4_4x4_routed_5layer_direct
Xgf180mcu_as_sc_mcu7t3v3__nand4_2_481 gf180mcu_as_sc_mcu7t3v3__inv_2_1648/VDD VSS
+ VSS VSS VSS VSS VSS gf180mcu_as_sc_mcu7t3v3__inv_2_1648/VNW VSUBS gf180mcu_as_sc_mcu7t3v3__nand4_2
Xgf180mcu_as_sc_mcu7t3v3__nand4_2_492 VSS gf180mcu_as_sc_mcu7t3v3__inv_2_1691/VSS
+ VSS VSS VSS VSS VSS gf180mcu_as_sc_mcu7t3v3__inv_2_1691/VNW VSUBS gf180mcu_as_sc_mcu7t3v3__nand4_2
Xgf180mcu_as_sc_mcu7t3v3__nand4_2_470 VSS VSS VSS VSS VSS VSS VSS gf180mcu_as_sc_mcu7t3v3__inv_2_1386/VNW
+ VSUBS gf180mcu_as_sc_mcu7t3v3__nand4_2
Xu_t013_014 u_t013_014/c0_w0_bl u_t013_014/c0_w0_br u_t013_014/c0_w1_bl u_t013_014/c0_w1_br
+ u_t013_014/c0_r0_rbl u_t013_014/c0_r1_rbl u_t013_014/c1_w0_bl u_t013_014/c1_w0_br
+ u_t013_014/c1_w1_bl u_t013_014/c1_w1_br u_t013_014/c1_r0_rbl u_t013_014/c1_r1_rbl
+ u_t013_014/c2_w0_bl u_t013_014/c2_w0_br u_t013_014/c2_w1_bl u_t013_014/c2_w1_br
+ u_t013_014/c2_r0_rbl u_t013_014/c2_r1_rbl u_t013_014/c3_w0_bl u_t013_014/c3_w0_br
+ u_t013_014/c3_w1_bl u_t013_014/c3_w1_br u_t013_014/c3_r0_rbl u_t013_014/c3_r1_rbl
+ u_t013_014/r0_w0_wl u_t013_014/r0_w1_wl u_t013_014/r0_r0_rwl u_t013_014/r0_r1_rwl
+ u_t013_014/r1_w0_wl u_t013_014/r1_w1_wl u_t013_014/r1_r0_rwl u_t013_014/r1_r1_rwl
+ u_t013_014/r2_w0_wl u_t013_014/r2_w1_wl u_t013_014/r2_r0_rwl u_t013_014/r2_r1_rwl
+ u_t013_014/r3_w0_wl u_t013_014/r3_w1_wl u_t013_014/r3_r0_rwl u_t013_014/r3_r1_rwl
+ u_t013_014/VDD VSS u_t013_014/m2_717_1265# u_t013_014/m2_603_2031# u_t013_014/m2_1290_336#
+ u_t013_014/m2_2000_2037# u_t013_014/m2_791_2909# u_t013_014/m2_7_2126# u_t013_014/m2_2154_2081#
+ u_t013_014/m2_1795_2037# u_t013_014/m2_871_303# u_t013_014/m2_431_438# u_t013_014/m2_1290_2898#
+ u_t013_014/m2_1714_1210# u_t013_014/m2_431_1982# u_t013_014/m2_512_1265# u_t013_014/m2_2573_2126#
+ u_t013_014/m2_603_1259# u_t013_014/m2_2074_2909# u_t013_014/m2_7_336# u_t013_014/m2_717_2037#
+ u_t013_014/m2_1886_2031# u_t013_014/m2_2573_336# u_t013_014/m2_7_2898# u_t013_014/m2_2000_1265#
+ u_t013_014/m2_512_2037# u_t013_014/m2_1795_1265# u_t013_014/m2_1714_1982# u_t013_014/m2_1886_1259#
+ u_t013_014/m2_1290_2126# u_t013_014/m2_1714_438# u_t013_014/m2_431_1210# u_t013_014/m2_2573_2898#
+ u_t013_014/m2_2154_303# u_t013_014/m2_871_2081# VSUBS detronyx_12t_2w2r_rc4_4x4_routed_5layer_direct
Xu_t013_003 u_t013_003/c0_w0_bl u_t013_003/c0_w0_br u_t013_003/c0_w1_bl u_t013_003/c0_w1_br
+ u_t013_003/c0_r0_rbl u_t013_003/c0_r1_rbl u_t013_003/c1_w0_bl u_t013_003/c1_w0_br
+ u_t013_003/c1_w1_bl u_t013_003/c1_w1_br u_t013_003/c1_r0_rbl u_t013_003/c1_r1_rbl
+ u_t013_003/c2_w0_bl u_t013_003/c2_w0_br u_t013_003/c2_w1_bl u_t013_003/c2_w1_br
+ u_t013_003/c2_r0_rbl u_t013_003/c2_r1_rbl u_t013_003/c3_w0_bl u_t013_003/c3_w0_br
+ u_t013_003/c3_w1_bl u_t013_003/c3_w1_br u_t013_003/c3_r0_rbl u_t013_003/c3_r1_rbl
+ u_t013_003/r0_w0_wl u_t013_003/r0_w1_wl u_t013_003/r0_r0_rwl u_t013_003/r0_r1_rwl
+ u_t013_003/r1_w0_wl u_t013_003/r1_w1_wl u_t013_003/r1_r0_rwl u_t013_003/r1_r1_rwl
+ u_t013_003/r2_w0_wl u_t013_003/r2_w1_wl u_t013_003/r2_r0_rwl u_t013_003/r2_r1_rwl
+ u_t013_003/r3_w0_wl u_t013_003/r3_w1_wl u_t013_003/r3_r0_rwl u_t013_003/r3_r1_rwl
+ u_t013_003/VDD VSS u_t013_003/m2_717_1265# u_t013_003/m2_603_2031# u_t013_003/m2_1290_336#
+ u_t013_003/m2_2000_2037# u_t013_003/m2_791_2909# u_t013_003/m2_7_2126# u_t013_003/m2_2154_2081#
+ u_t013_003/m2_1795_2037# u_t013_003/m2_871_303# u_t013_003/m2_431_438# u_t013_003/m2_1290_2898#
+ u_t013_003/m2_1714_1210# u_t013_003/m2_431_1982# u_t013_003/m2_512_1265# u_t013_003/m2_2573_2126#
+ u_t013_003/m2_603_1259# u_t013_003/m2_2074_2909# u_t013_003/m2_7_336# u_t013_003/m2_717_2037#
+ u_t013_003/m2_1886_2031# u_t013_003/m2_2573_336# u_t013_003/m2_7_2898# u_t013_003/m2_2000_1265#
+ u_t013_003/m2_512_2037# u_t013_003/m2_1795_1265# u_t013_003/m2_1714_1982# u_t013_003/m2_1886_1259#
+ u_t013_003/m2_1290_2126# u_t013_003/m2_1714_438# u_t013_003/m2_431_1210# u_t013_003/m2_2573_2898#
+ u_t013_003/m2_2154_303# u_t013_003/m2_871_2081# VSUBS detronyx_12t_2w2r_rc4_4x4_routed_5layer_direct
Xu_t004_014 u_t004_014/c0_w0_bl u_t004_014/c0_w0_br u_t004_014/c0_w1_bl u_t004_014/c0_w1_br
+ u_t004_014/c0_r0_rbl u_t004_014/c0_r1_rbl u_t004_014/c1_w0_bl u_t004_014/c1_w0_br
+ u_t004_014/c1_w1_bl u_t004_014/c1_w1_br u_t004_014/c1_r0_rbl u_t004_014/c1_r1_rbl
+ u_t004_014/c2_w0_bl u_t004_014/c2_w0_br u_t004_014/c2_w1_bl u_t004_014/c2_w1_br
+ u_t004_014/c2_r0_rbl u_t004_014/c2_r1_rbl u_t004_014/c3_w0_bl u_t004_014/c3_w0_br
+ u_t004_014/c3_w1_bl u_t004_014/c3_w1_br u_t004_014/c3_r0_rbl u_t004_014/c3_r1_rbl
+ u_t004_014/r0_w0_wl u_t004_014/r0_w1_wl u_t004_014/r0_r0_rwl u_t004_014/r0_r1_rwl
+ u_t004_014/r1_w0_wl u_t004_014/r1_w1_wl u_t004_014/r1_r0_rwl u_t004_014/r1_r1_rwl
+ u_t004_014/r2_w0_wl u_t004_014/r2_w1_wl u_t004_014/r2_r0_rwl u_t004_014/r2_r1_rwl
+ u_t004_014/r3_w0_wl u_t004_014/r3_w1_wl u_t004_014/r3_r0_rwl u_t004_014/r3_r1_rwl
+ u_t004_014/VDD VSS u_t004_014/m2_717_1265# u_t004_014/m2_603_2031# u_t004_014/m2_1290_336#
+ u_t004_014/m2_2000_2037# u_t004_014/m2_791_2909# u_t004_014/m2_7_2126# u_t004_014/m2_2154_2081#
+ u_t004_014/m2_1795_2037# u_t004_014/m2_871_303# u_t004_014/m2_431_438# u_t004_014/m2_1290_2898#
+ u_t004_014/m2_1714_1210# u_t004_014/m2_431_1982# u_t004_014/m2_512_1265# u_t004_014/m2_2573_2126#
+ u_t004_014/m2_603_1259# u_t004_014/m2_2074_2909# u_t004_014/m2_7_336# u_t004_014/m2_717_2037#
+ u_t004_014/m2_1886_2031# u_t004_014/m2_2573_336# u_t004_014/m2_7_2898# u_t004_014/m2_2000_1265#
+ u_t004_014/m2_512_2037# u_t004_014/m2_1795_1265# u_t004_014/m2_1714_1982# u_t004_014/m2_1886_1259#
+ u_t004_014/m2_1290_2126# u_t004_014/m2_1714_438# u_t004_014/m2_431_1210# u_t004_014/m2_2573_2898#
+ u_t004_014/m2_2154_303# u_t004_014/m2_871_2081# VSUBS detronyx_12t_2w2r_rc4_4x4_routed_5layer_direct
Xu_t004_003 u_t004_003/c0_w0_bl u_t004_003/c0_w0_br u_t004_003/c0_w1_bl u_t004_003/c0_w1_br
+ u_t004_003/c0_r0_rbl u_t004_003/c0_r1_rbl u_t004_003/c1_w0_bl u_t004_003/c1_w0_br
+ u_t004_003/c1_w1_bl u_t004_003/c1_w1_br u_t004_003/c1_r0_rbl u_t004_003/c1_r1_rbl
+ u_t004_003/c2_w0_bl u_t004_003/c2_w0_br u_t004_003/c2_w1_bl u_t004_003/c2_w1_br
+ u_t004_003/c2_r0_rbl u_t004_003/c2_r1_rbl u_t004_003/c3_w0_bl u_t004_003/c3_w0_br
+ u_t004_003/c3_w1_bl u_t004_003/c3_w1_br u_t004_003/c3_r0_rbl u_t004_003/c3_r1_rbl
+ u_t004_003/r0_w0_wl u_t004_003/r0_w1_wl u_t004_003/r0_r0_rwl u_t004_003/r0_r1_rwl
+ u_t004_003/r1_w0_wl u_t004_003/r1_w1_wl u_t004_003/r1_r0_rwl u_t004_003/r1_r1_rwl
+ u_t004_003/r2_w0_wl u_t004_003/r2_w1_wl u_t004_003/r2_r0_rwl u_t004_003/r2_r1_rwl
+ u_t004_003/r3_w0_wl u_t004_003/r3_w1_wl u_t004_003/r3_r0_rwl u_t004_003/r3_r1_rwl
+ u_t004_003/VDD VSS u_t004_003/m2_717_1265# u_t004_003/m2_603_2031# u_t004_003/m2_1290_336#
+ u_t004_003/m2_2000_2037# u_t004_003/m2_791_2909# u_t004_003/m2_7_2126# u_t004_003/m2_2154_2081#
+ u_t004_003/m2_1795_2037# u_t004_003/m2_871_303# u_t004_003/m2_431_438# u_t004_003/m2_1290_2898#
+ u_t004_003/m2_1714_1210# u_t004_003/m2_431_1982# u_t004_003/m2_512_1265# u_t004_003/m2_2573_2126#
+ u_t004_003/m2_603_1259# u_t004_003/m2_2074_2909# u_t004_003/m2_7_336# u_t004_003/m2_717_2037#
+ u_t004_003/m2_1886_2031# u_t004_003/m2_2573_336# u_t004_003/m2_7_2898# u_t004_003/m2_2000_1265#
+ u_t004_003/m2_512_2037# u_t004_003/m2_1795_1265# u_t004_003/m2_1714_1982# u_t004_003/m2_1886_1259#
+ u_t004_003/m2_1290_2126# u_t004_003/m2_1714_438# u_t004_003/m2_431_1210# u_t004_003/m2_2573_2898#
+ u_t004_003/m2_2154_303# u_t004_003/m2_871_2081# VSUBS detronyx_12t_2w2r_rc4_4x4_routed_5layer_direct
Xgf180mcu_as_sc_mcu7t3v3__inv_2_445 VSS VSS VSS VSS gf180mcu_as_sc_mcu7t3v3__inv_2_544/VNW
+ VSUBS gf180mcu_as_sc_mcu7t3v3__inv_2
Xgf180mcu_as_sc_mcu7t3v3__inv_2_401 gf180mcu_as_sc_mcu7t3v3__nor2_2_6/VDD gf180mcu_as_sc_mcu7t3v3__nor2_2_6/VSS
+ VSS VSS gf180mcu_as_sc_mcu7t3v3__nor2_2_6/VNW VSUBS gf180mcu_as_sc_mcu7t3v3__inv_2
Xgf180mcu_as_sc_mcu7t3v3__inv_2_412 gf180mcu_as_sc_mcu7t3v3__nor2_2_6/VDD gf180mcu_as_sc_mcu7t3v3__nand3_2_4/VSS
+ VSS VSS gf180mcu_as_sc_mcu7t3v3__nor2_2_6/VNW VSUBS gf180mcu_as_sc_mcu7t3v3__inv_2
Xgf180mcu_as_sc_mcu7t3v3__inv_2_456 gf180mcu_as_sc_mcu7t3v3__nor2_2_6/VDD gf180mcu_as_sc_mcu7t3v3__nand3_2_4/VSS
+ VSS VSS gf180mcu_as_sc_mcu7t3v3__nor2_2_6/VNW VSUBS gf180mcu_as_sc_mcu7t3v3__inv_2
Xgf180mcu_as_sc_mcu7t3v3__inv_2_478 gf180mcu_as_sc_mcu7t3v3__nor2_2_4/VDD gf180mcu_as_sc_mcu7t3v3__nand2_2_3/VSS
+ gf180mcu_as_sc_mcu7t3v3__inv_2_478/Y VSS gf180mcu_as_sc_mcu7t3v3__nor2_2_4/VNW VSUBS
+ gf180mcu_as_sc_mcu7t3v3__inv_2
Xgf180mcu_as_sc_mcu7t3v3__inv_2_467 gf180mcu_as_sc_mcu7t3v3__nor2_2_4/VDD gf180mcu_as_sc_mcu7t3v3__nand2_2_3/VSS
+ VSS VSS gf180mcu_as_sc_mcu7t3v3__nor2_2_4/VNW VSUBS gf180mcu_as_sc_mcu7t3v3__inv_2
Xgf180mcu_as_sc_mcu7t3v3__inv_2_434 gf180mcu_as_sc_mcu7t3v3__nor2_2_4/VDD gf180mcu_as_sc_mcu7t3v3__nor2_2_4/VSS
+ VSS VSS gf180mcu_as_sc_mcu7t3v3__nor2_2_4/VNW VSUBS gf180mcu_as_sc_mcu7t3v3__inv_2
Xgf180mcu_as_sc_mcu7t3v3__inv_2_423 gf180mcu_as_sc_mcu7t3v3__nand3_2_9/VDD gf180mcu_as_sc_mcu7t3v3__nor2_2_4/VSS
+ gf180mcu_as_sc_mcu7t3v3__inv_2_423/Y VSS gf180mcu_as_sc_mcu7t3v3__nand3_2_9/VNW
+ VSUBS gf180mcu_as_sc_mcu7t3v3__inv_2
Xgf180mcu_as_sc_mcu7t3v3__inv_2_489 VSS VSS gf180mcu_as_sc_mcu7t3v3__inv_2_489/Y VSS
+ gf180mcu_as_sc_mcu7t3v3__inv_2_552/VNW VSUBS gf180mcu_as_sc_mcu7t3v3__inv_2
Xu_t010_006 u_t010_006/c0_w0_bl u_t010_006/c0_w0_br u_t010_006/c0_w1_bl u_t010_006/c0_w1_br
+ u_t010_006/c0_r0_rbl u_t010_006/c0_r1_rbl u_t010_006/c1_w0_bl u_t010_006/c1_w0_br
+ u_t010_006/c1_w1_bl u_t010_006/c1_w1_br u_t010_006/c1_r0_rbl u_t010_006/c1_r1_rbl
+ u_t010_006/c2_w0_bl u_t010_006/c2_w0_br u_t010_006/c2_w1_bl u_t010_006/c2_w1_br
+ u_t010_006/c2_r0_rbl u_t010_006/c2_r1_rbl u_t010_006/c3_w0_bl u_t010_006/c3_w0_br
+ u_t010_006/c3_w1_bl u_t010_006/c3_w1_br u_t010_006/c3_r0_rbl u_t010_006/c3_r1_rbl
+ u_t010_006/r0_w0_wl u_t010_006/r0_w1_wl u_t010_006/r0_r0_rwl u_t010_006/r0_r1_rwl
+ u_t010_006/r1_w0_wl u_t010_006/r1_w1_wl u_t010_006/r1_r0_rwl u_t010_006/r1_r1_rwl
+ u_t010_006/r2_w0_wl u_t010_006/r2_w1_wl u_t010_006/r2_r0_rwl u_t010_006/r2_r1_rwl
+ u_t010_006/r3_w0_wl u_t010_006/r3_w1_wl u_t010_006/r3_r0_rwl u_t010_006/r3_r1_rwl
+ u_t010_006/VDD u_t010_009/VSS u_t010_006/m2_717_1265# u_t010_006/m2_603_2031# u_t010_006/m2_1290_336#
+ u_t010_006/m2_2000_2037# u_t010_006/m2_791_2909# u_t010_006/m2_7_2126# u_t010_006/m2_2154_2081#
+ u_t010_006/m2_1795_2037# u_t010_006/m2_871_303# u_t010_006/m2_431_438# u_t010_006/m2_1290_2898#
+ u_t010_006/m2_1714_1210# u_t010_006/m2_431_1982# u_t010_006/m2_512_1265# u_t010_006/m2_2573_2126#
+ u_t010_006/m2_603_1259# u_t010_006/m2_2074_2909# u_t010_006/m2_7_336# u_t010_006/m2_717_2037#
+ u_t010_006/m2_1886_2031# u_t010_006/m2_2573_336# u_t010_006/m2_7_2898# u_t010_006/m2_2000_1265#
+ u_t010_006/m2_512_2037# u_t010_006/m2_1795_1265# u_t010_006/m2_1714_1982# u_t010_006/m2_1886_1259#
+ u_t010_006/m2_1290_2126# u_t010_006/m2_1714_438# u_t010_006/m2_431_1210# u_t010_006/m2_2573_2898#
+ u_t010_006/m2_2154_303# u_t010_006/m2_871_2081# VSUBS detronyx_12t_2w2r_rc4_4x4_routed_5layer_direct
Xgf180mcu_as_sc_mcu7t3v3__inv_2_990 VSS gf180mcu_as_sc_mcu7t3v3__inv_2_996/VDD VSS
+ gf180mcu_as_sc_mcu7t3v3__inv_2_998/A gf180mcu_as_sc_mcu7t3v3__inv_2_992/VNW VSUBS
+ gf180mcu_as_sc_mcu7t3v3__inv_2
Xu_t001_006 u_t001_006/c0_w0_bl u_t001_006/c0_w0_br u_t001_006/c0_w1_bl u_t001_006/c0_w1_br
+ u_t001_006/c0_r0_rbl u_t001_006/c0_r1_rbl u_t001_006/c1_w0_bl u_t001_006/c1_w0_br
+ u_t001_006/c1_w1_bl u_t001_006/c1_w1_br u_t001_006/c1_r0_rbl u_t001_006/c1_r1_rbl
+ u_t001_006/c2_w0_bl u_t001_006/c2_w0_br u_t001_006/c2_w1_bl u_t001_006/c2_w1_br
+ u_t001_006/c2_r0_rbl u_t001_006/c2_r1_rbl u_t001_006/c3_w0_bl u_t001_006/c3_w0_br
+ u_t001_006/c3_w1_bl u_t001_006/c3_w1_br u_t001_006/c3_r0_rbl u_t001_006/c3_r1_rbl
+ u_t001_006/r0_w0_wl u_t001_006/r0_w1_wl u_t001_006/r0_r0_rwl u_t001_006/r0_r1_rwl
+ u_t001_006/r1_w0_wl u_t001_006/r1_w1_wl u_t001_006/r1_r0_rwl u_t001_006/r1_r1_rwl
+ u_t001_006/r2_w0_wl u_t001_006/r2_w1_wl u_t001_006/r2_r0_rwl u_t001_006/r2_r1_rwl
+ u_t001_006/r3_w0_wl u_t001_006/r3_w1_wl u_t001_006/r3_r0_rwl u_t001_006/r3_r1_rwl
+ u_t001_006/VDD VSS u_t001_006/m2_717_1265# u_t001_006/m2_603_2031# u_t001_006/m2_1290_336#
+ u_t001_006/m2_2000_2037# u_t001_006/m2_791_2909# u_t001_006/m2_7_2126# u_t001_006/m2_2154_2081#
+ u_t001_006/m2_1795_2037# u_t001_006/m2_871_303# u_t001_006/m2_431_438# u_t001_006/m2_1290_2898#
+ u_t001_006/m2_1714_1210# u_t001_006/m2_431_1982# u_t001_006/m2_512_1265# u_t001_006/m2_2573_2126#
+ u_t001_006/m2_603_1259# u_t001_006/m2_2074_2909# u_t001_006/m2_7_336# u_t001_006/m2_717_2037#
+ u_t001_006/m2_1886_2031# u_t001_006/m2_2573_336# u_t001_006/m2_7_2898# u_t001_006/m2_2000_1265#
+ u_t001_006/m2_512_2037# u_t001_006/m2_1795_1265# u_t001_006/m2_1714_1982# u_t001_006/m2_1886_1259#
+ u_t001_006/m2_1290_2126# u_t001_006/m2_1714_438# u_t001_006/m2_431_1210# u_t001_006/m2_2573_2898#
+ u_t001_006/m2_2154_303# u_t001_006/m2_871_2081# VSUBS detronyx_12t_2w2r_rc4_4x4_routed_5layer_direct
Xgf180mcu_as_sc_mcu7t3v3__inv_2_1708 gf180mcu_as_sc_mcu7t3v3__nor2_2_6/VDD gf180mcu_as_sc_mcu7t3v3__nand3_2_4/VSS
+ VSS VSS gf180mcu_as_sc_mcu7t3v3__nor2_2_6/VNW VSUBS gf180mcu_as_sc_mcu7t3v3__inv_2
Xgf180mcu_as_sc_mcu7t3v3__inv_2_264 gf180mcu_as_sc_mcu7t3v3__inv_2_308/VSS VSS gf180mcu_as_sc_mcu7t3v3__inv_2_61/Y
+ VSS gf180mcu_as_sc_mcu7t3v3__inv_2_264/VNW VSUBS gf180mcu_as_sc_mcu7t3v3__inv_2
Xgf180mcu_as_sc_mcu7t3v3__inv_2_275 VSS VSS gf180mcu_as_sc_mcu7t3v3__inv_2_61/Y gf180mcu_as_sc_mcu7t3v3__inv_2_61/Y
+ gf180mcu_as_sc_mcu7t3v3__inv_2_280/VNW VSUBS gf180mcu_as_sc_mcu7t3v3__inv_2
Xgf180mcu_as_sc_mcu7t3v3__inv_2_286 VSS VSS gf180mcu_as_sc_mcu7t3v3__inv_2_301/Y gf180mcu_as_sc_mcu7t3v3__inv_2_301/Y
+ gf180mcu_as_sc_mcu7t3v3__inv_2_287/VNW VSUBS gf180mcu_as_sc_mcu7t3v3__inv_2
Xgf180mcu_as_sc_mcu7t3v3__inv_2_297 gf180mcu_as_sc_mcu7t3v3__inv_2_365/VSS gf180mcu_as_sc_mcu7t3v3__inv_2_307/VDD
+ gf180mcu_as_sc_mcu7t3v3__inv_2_365/Y VSS gf180mcu_as_sc_mcu7t3v3__inv_2_297/VNW
+ VSUBS gf180mcu_as_sc_mcu7t3v3__inv_2
Xgf180mcu_as_sc_mcu7t3v3__inv_2_220 VSS VSS VSS VSS gf180mcu_as_sc_mcu7t3v3__inv_2_221/VNW
+ VSUBS gf180mcu_as_sc_mcu7t3v3__inv_2
Xgf180mcu_as_sc_mcu7t3v3__inv_2_253 VSS gf180mcu_as_sc_mcu7t3v3__inv_2_257/VDD VSS
+ VSS gf180mcu_as_sc_mcu7t3v3__inv_2_254/VNW VSUBS gf180mcu_as_sc_mcu7t3v3__inv_2
Xgf180mcu_as_sc_mcu7t3v3__inv_2_242 gf180mcu_as_sc_mcu7t3v3__inv_2_242/VDD VSS VSS
+ VSS gf180mcu_as_sc_mcu7t3v3__inv_2_242/VNW VSUBS gf180mcu_as_sc_mcu7t3v3__inv_2
Xgf180mcu_as_sc_mcu7t3v3__inv_2_1719 gf180mcu_as_sc_mcu7t3v3__inv_2_1720/VDD VSS gf180mcu_as_sc_mcu7t3v3__inv_2_1719/Y
+ VSS gf180mcu_as_sc_mcu7t3v3__inv_2_1720/VNW VSUBS gf180mcu_as_sc_mcu7t3v3__inv_2
Xgf180mcu_as_sc_mcu7t3v3__inv_2_231 VSS VSS gf180mcu_as_sc_mcu7t3v3__inv_2_231/Y VSS
+ gf180mcu_as_sc_mcu7t3v3__inv_2_233/VNW VSUBS gf180mcu_as_sc_mcu7t3v3__inv_2
Xgf180mcu_as_sc_mcu7t3v3__inv_2_1549 VSS gf180mcu_as_sc_mcu7t3v3__inv_2_1553/VDD gf180mcu_as_sc_mcu7t3v3__inv_2_1549/Y
+ VSS gf180mcu_as_sc_mcu7t3v3__inv_2_1550/VNW VSUBS gf180mcu_as_sc_mcu7t3v3__inv_2
Xgf180mcu_as_sc_mcu7t3v3__inv_2_1527 VSS gf180mcu_as_sc_mcu7t3v3__inv_2_1532/VDD VSS
+ VSS gf180mcu_as_sc_mcu7t3v3__inv_2_1529/VNW VSUBS gf180mcu_as_sc_mcu7t3v3__inv_2
Xgf180mcu_as_sc_mcu7t3v3__inv_2_1516 VSS gf180mcu_as_sc_mcu7t3v3__inv_2_1523/VDD gf180mcu_as_sc_mcu7t3v3__inv_2_1516/Y
+ VSS gf180mcu_as_sc_mcu7t3v3__inv_2_1520/VNW VSUBS gf180mcu_as_sc_mcu7t3v3__inv_2
Xgf180mcu_as_sc_mcu7t3v3__inv_2_1538 VSS gf180mcu_as_sc_mcu7t3v3__inv_2_1541/VDD gf180mcu_as_sc_mcu7t3v3__inv_2_1538/Y
+ VSS gf180mcu_as_sc_mcu7t3v3__inv_2_1538/VNW VSUBS gf180mcu_as_sc_mcu7t3v3__inv_2
Xgf180mcu_as_sc_mcu7t3v3__inv_2_1505 VSS gf180mcu_as_sc_mcu7t3v3__inv_2_1508/VDD VSS
+ VSS gf180mcu_as_sc_mcu7t3v3__inv_2_1506/VNW VSUBS gf180mcu_as_sc_mcu7t3v3__inv_2
Xgf180mcu_as_sc_mcu7t3v3__nand2_2_4 gf180mcu_as_sc_mcu7t3v3__nor2_2_6/VDD gf180mcu_as_sc_mcu7t3v3__nand3_2_4/VSS
+ VSS VSS VSS gf180mcu_as_sc_mcu7t3v3__nor2_2_6/VNW VSUBS gf180mcu_as_sc_mcu7t3v3__nand2_2
Xu_t029_009 u_t029_009/c0_w0_bl u_t029_009/c0_w0_br u_t029_009/c0_w1_bl u_t029_009/c0_w1_br
+ u_t029_009/c0_r0_rbl u_t029_009/c0_r1_rbl u_t029_009/c1_w0_bl u_t029_009/c1_w0_br
+ u_t029_009/c1_w1_bl u_t029_009/c1_w1_br u_t029_009/c1_r0_rbl u_t029_009/c1_r1_rbl
+ u_t029_009/c2_w0_bl u_t029_009/c2_w0_br u_t029_009/c2_w1_bl u_t029_009/c2_w1_br
+ u_t029_009/c2_r0_rbl u_t029_009/c2_r1_rbl u_t029_009/c3_w0_bl u_t029_009/c3_w0_br
+ u_t029_009/c3_w1_bl u_t029_009/c3_w1_br u_t029_009/c3_r0_rbl u_t029_009/c3_r1_rbl
+ u_t029_009/r0_w0_wl u_t029_009/r0_w1_wl u_t029_009/r0_r0_rwl u_t029_009/r0_r1_rwl
+ u_t029_009/r1_w0_wl u_t029_009/r1_w1_wl u_t029_009/r1_r0_rwl u_t029_009/r1_r1_rwl
+ u_t029_009/r2_w0_wl u_t029_009/r2_w1_wl u_t029_009/r2_r0_rwl u_t029_009/r2_r1_rwl
+ u_t029_009/r3_w0_wl u_t029_009/r3_w1_wl u_t029_009/r3_r0_rwl u_t029_009/r3_r1_rwl
+ VSS VSS u_t029_009/m2_717_1265# u_t029_009/m2_603_2031# u_t029_009/m2_1290_336#
+ u_t029_009/m2_2000_2037# u_t029_009/m2_791_2909# u_t029_009/m2_7_2126# u_t029_009/m2_2154_2081#
+ u_t029_009/m2_1795_2037# u_t029_009/m2_871_303# u_t029_009/m2_431_438# u_t029_009/m2_1290_2898#
+ u_t029_009/m2_1714_1210# u_t029_009/m2_431_1982# u_t029_009/m2_512_1265# u_t029_009/m2_2573_2126#
+ u_t029_009/m2_603_1259# u_t029_009/m2_2074_2909# u_t029_009/m2_7_336# u_t029_009/m2_717_2037#
+ u_t029_009/m2_1886_2031# u_t029_009/m2_2573_336# u_t029_009/m2_7_2898# u_t029_009/m2_2000_1265#
+ u_t029_009/m2_512_2037# u_t029_009/m2_1795_1265# u_t029_009/m2_1714_1982# u_t029_009/m2_1886_1259#
+ u_t029_009/m2_1290_2126# u_t029_009/m2_1714_438# u_t029_009/m2_431_1210# u_t029_009/m2_2573_2898#
+ u_t029_009/m2_2154_303# u_t029_009/m2_871_2081# VSUBS detronyx_12t_2w2r_rc4_4x4_routed_5layer_direct
Xgf180mcu_as_sc_mcu7t3v3__inv_2_1368 gf180mcu_as_sc_mcu7t3v3__inv_2_1370/VDD VSS VSS
+ gf180mcu_as_sc_mcu7t3v3__inv_2_1694/Y gf180mcu_as_sc_mcu7t3v3__inv_2_1370/VNW VSUBS
+ gf180mcu_as_sc_mcu7t3v3__inv_2
Xgf180mcu_as_sc_mcu7t3v3__inv_2_1302 VSS VSS VSS VSS gf180mcu_as_sc_mcu7t3v3__inv_2_1304/VNW
+ VSUBS gf180mcu_as_sc_mcu7t3v3__inv_2
Xgf180mcu_as_sc_mcu7t3v3__inv_2_1379 gf180mcu_as_sc_mcu7t3v3__inv_2_1406/VSS VSS VSS
+ gf180mcu_as_sc_mcu7t3v3__inv_2_1409/A gf180mcu_as_sc_mcu7t3v3__inv_2_1395/VNW VSUBS
+ gf180mcu_as_sc_mcu7t3v3__inv_2
Xgf180mcu_as_sc_mcu7t3v3__inv_2_1357 VSS gf180mcu_as_sc_mcu7t3v3__inv_2_1409/VDD gf180mcu_as_sc_mcu7t3v3__inv_2_1409/A
+ gf180mcu_as_sc_mcu7t3v3__inv_2_1409/A gf180mcu_as_sc_mcu7t3v3__inv_2_1358/VNW VSUBS
+ gf180mcu_as_sc_mcu7t3v3__inv_2
Xgf180mcu_as_sc_mcu7t3v3__inv_2_1324 VSS gf180mcu_as_sc_mcu7t3v3__inv_2_1717/VDD gf180mcu_as_sc_mcu7t3v3__inv_2_1717/Y
+ VSS gf180mcu_as_sc_mcu7t3v3__inv_2_1324/VNW VSUBS gf180mcu_as_sc_mcu7t3v3__inv_2
Xgf180mcu_as_sc_mcu7t3v3__inv_2_1313 gf180mcu_as_sc_mcu7t3v3__inv_2_1349/VSS VSS gf180mcu_as_sc_mcu7t3v3__inv_2_1313/Y
+ gf180mcu_as_sc_mcu7t3v3__inv_2_1355/Y gf180mcu_as_sc_mcu7t3v3__inv_2_1317/VNW VSUBS
+ gf180mcu_as_sc_mcu7t3v3__inv_2
Xgf180mcu_as_sc_mcu7t3v3__inv_2_1346 VSS gf180mcu_as_sc_mcu7t3v3__inv_2_1352/VDD VSS
+ gf180mcu_as_sc_mcu7t3v3__inv_2_1355/Y gf180mcu_as_sc_mcu7t3v3__inv_2_1348/VNW VSUBS
+ gf180mcu_as_sc_mcu7t3v3__inv_2
Xgf180mcu_as_sc_mcu7t3v3__inv_2_1335 VSS gf180mcu_as_sc_mcu7t3v3__inv_2_1340/VDD gf180mcu_as_sc_mcu7t3v3__inv_2_1335/Y
+ gf180mcu_as_sc_mcu7t3v3__inv_2_1340/Y gf180mcu_as_sc_mcu7t3v3__inv_2_1336/VNW VSUBS
+ gf180mcu_as_sc_mcu7t3v3__inv_2
Xgf180mcu_as_sc_mcu7t3v3__inv_2_819 VSS VSS gf180mcu_as_sc_mcu7t3v3__inv_2_819/Y VSS
+ gf180mcu_as_sc_mcu7t3v3__inv_2_819/VNW VSUBS gf180mcu_as_sc_mcu7t3v3__inv_2
Xgf180mcu_as_sc_mcu7t3v3__inv_2_808 VSS VSS VSS VSS gf180mcu_as_sc_mcu7t3v3__inv_2_839/VNW
+ VSUBS gf180mcu_as_sc_mcu7t3v3__inv_2
Xgf180mcu_as_sc_mcu7t3v3__nand4_2_129 VSS VSS VSS VSS VSS VSS gf180mcu_as_sc_mcu7t3v3__nand4_2_129/Y
+ gf180mcu_as_sc_mcu7t3v3__inv_2_548/VNW VSUBS gf180mcu_as_sc_mcu7t3v3__nand4_2
Xgf180mcu_as_sc_mcu7t3v3__nand4_2_24 gf180mcu_as_sc_mcu7t3v3__inv_2_152/VDD gf180mcu_as_sc_mcu7t3v3__nand4_2_9/VDD
+ VSS VSS VSS VSS gf180mcu_as_sc_mcu7t3v3__nand4_2_24/Y gf180mcu_as_sc_mcu7t3v3__inv_2_152/VNW
+ VSUBS gf180mcu_as_sc_mcu7t3v3__nand4_2
Xgf180mcu_as_sc_mcu7t3v3__nand4_2_13 gf180mcu_as_sc_mcu7t3v3__inv_2_122/VDD gf180mcu_as_sc_mcu7t3v3__inv_2_122/VDD
+ VSS VSS VSS VSS VSS gf180mcu_as_sc_mcu7t3v3__inv_2_119/VNW VSUBS gf180mcu_as_sc_mcu7t3v3__nand4_2
Xgf180mcu_as_sc_mcu7t3v3__nand4_2_107 gf180mcu_as_sc_mcu7t3v3__inv_2_308/VSS VSS VSS
+ VSS VSS VSS VSS gf180mcu_as_sc_mcu7t3v3__inv_2_264/VNW VSUBS gf180mcu_as_sc_mcu7t3v3__nand4_2
Xgf180mcu_as_sc_mcu7t3v3__nand4_2_118 VSS VSS VSS VSS VSS VSS VSS gf180mcu_as_sc_mcu7t3v3__inv_2_287/VNW
+ VSUBS gf180mcu_as_sc_mcu7t3v3__nand4_2
Xgf180mcu_as_sc_mcu7t3v3__nand4_2_35 VSS gf180mcu_as_sc_mcu7t3v3__inv_2_190/VDD VSS
+ VSS VSS VSS VSS gf180mcu_as_sc_mcu7t3v3__inv_2_187/VNW VSUBS gf180mcu_as_sc_mcu7t3v3__nand4_2
Xgf180mcu_as_sc_mcu7t3v3__nand4_2_79 gf180mcu_as_sc_mcu7t3v3__inv_2_49/VDD gf180mcu_as_sc_mcu7t3v3__inv_2_66/VSS
+ VSS VSS VSS VSS VSS gf180mcu_as_sc_mcu7t3v3__inv_2_49/VNW VSUBS gf180mcu_as_sc_mcu7t3v3__nand4_2
Xgf180mcu_as_sc_mcu7t3v3__nand4_2_68 gf180mcu_as_sc_mcu7t3v3__inv_2_66/VSS gf180mcu_as_sc_mcu7t3v3__inv_2_32/VDD
+ VSS VSS VSS VSS VSS gf180mcu_as_sc_mcu7t3v3__inv_2_28/VNW VSUBS gf180mcu_as_sc_mcu7t3v3__nand4_2
Xgf180mcu_as_sc_mcu7t3v3__nand4_2_46 gf180mcu_as_sc_mcu7t3v3__inv_2_218/VDD VSS VSS
+ VSS VSS VSS gf180mcu_as_sc_mcu7t3v3__nand4_2_46/Y gf180mcu_as_sc_mcu7t3v3__inv_2_218/VNW
+ VSUBS gf180mcu_as_sc_mcu7t3v3__nand4_2
Xgf180mcu_as_sc_mcu7t3v3__nand4_2_57 gf180mcu_as_sc_mcu7t3v3__inv_2_251/VDD VSS VSS
+ VSS VSS VSS VSS gf180mcu_as_sc_mcu7t3v3__inv_2_251/VNW VSUBS gf180mcu_as_sc_mcu7t3v3__nand4_2
Xu_t025_012 u_t025_012/c0_w0_bl u_t025_012/c0_w0_br u_t025_012/c0_w1_bl u_t025_012/c0_w1_br
+ u_t025_012/c0_r0_rbl u_t025_012/c0_r1_rbl u_t025_012/c1_w0_bl u_t025_012/c1_w0_br
+ u_t025_012/c1_w1_bl u_t025_012/c1_w1_br u_t025_012/c1_r0_rbl u_t025_012/c1_r1_rbl
+ u_t025_012/c2_w0_bl u_t025_012/c2_w0_br u_t025_012/c2_w1_bl u_t025_012/c2_w1_br
+ u_t025_012/c2_r0_rbl u_t025_012/c2_r1_rbl u_t025_012/c3_w0_bl u_t025_012/c3_w0_br
+ u_t025_012/c3_w1_bl u_t025_012/c3_w1_br u_t025_012/c3_r0_rbl u_t025_012/c3_r1_rbl
+ u_t025_012/r0_w0_wl u_t025_012/r0_w1_wl u_t025_012/r0_r0_rwl u_t025_012/r0_r1_rwl
+ u_t025_012/r1_w0_wl u_t025_012/r1_w1_wl u_t025_012/r1_r0_rwl u_t025_012/r1_r1_rwl
+ u_t025_012/r2_w0_wl u_t025_012/r2_w1_wl u_t025_012/r2_r0_rwl u_t025_012/r2_r1_rwl
+ u_t025_012/r3_w0_wl u_t025_012/r3_w1_wl u_t025_012/r3_r0_rwl u_t025_012/r3_r1_rwl
+ u_t025_012/VDD VSS u_t025_012/m2_717_1265# u_t025_012/m2_603_2031# u_t025_012/m2_1290_336#
+ u_t025_012/m2_2000_2037# u_t025_012/m2_791_2909# u_t025_012/m2_7_2126# u_t025_012/m2_2154_2081#
+ u_t025_012/m2_1795_2037# u_t025_012/m2_871_303# u_t025_012/m2_431_438# u_t025_012/m2_1290_2898#
+ u_t025_012/m2_1714_1210# u_t025_012/m2_431_1982# u_t025_012/m2_512_1265# u_t025_012/m2_2573_2126#
+ u_t025_012/m2_603_1259# u_t025_012/m2_2074_2909# u_t025_012/m2_7_336# u_t025_012/m2_717_2037#
+ u_t025_012/m2_1886_2031# u_t025_012/m2_2573_336# u_t025_012/m2_7_2898# u_t025_012/m2_2000_1265#
+ u_t025_012/m2_512_2037# u_t025_012/m2_1795_1265# u_t025_012/m2_1714_1982# u_t025_012/m2_1886_1259#
+ u_t025_012/m2_1290_2126# u_t025_012/m2_1714_438# u_t025_012/m2_431_1210# u_t025_012/m2_2573_2898#
+ u_t025_012/m2_2154_303# u_t025_012/m2_871_2081# VSUBS detronyx_12t_2w2r_rc4_4x4_routed_5layer_direct
Xu_t025_001 u_t025_001/c0_w0_bl u_t025_001/c0_w0_br u_t025_001/c0_w1_bl u_t025_001/c0_w1_br
+ u_t025_001/c0_r0_rbl u_t025_001/c0_r1_rbl u_t025_001/c1_w0_bl u_t025_001/c1_w0_br
+ u_t025_001/c1_w1_bl u_t025_001/c1_w1_br u_t025_001/c1_r0_rbl u_t025_001/c1_r1_rbl
+ u_t025_001/c2_w0_bl u_t025_001/c2_w0_br u_t025_001/c2_w1_bl u_t025_001/c2_w1_br
+ u_t025_001/c2_r0_rbl u_t025_001/c2_r1_rbl u_t025_001/c3_w0_bl u_t025_001/c3_w0_br
+ u_t025_001/c3_w1_bl u_t025_001/c3_w1_br u_t025_001/c3_r0_rbl u_t025_001/c3_r1_rbl
+ u_t025_001/r0_w0_wl u_t025_001/r0_w1_wl u_t025_001/r0_r0_rwl u_t025_001/r0_r1_rwl
+ u_t025_001/r1_w0_wl u_t025_001/r1_w1_wl u_t025_001/r1_r0_rwl u_t025_001/r1_r1_rwl
+ u_t025_001/r2_w0_wl u_t025_001/r2_w1_wl u_t025_001/r2_r0_rwl u_t025_001/r2_r1_rwl
+ u_t025_001/r3_w0_wl u_t025_001/r3_w1_wl u_t025_001/r3_r0_rwl u_t025_001/r3_r1_rwl
+ VSS VSS u_t025_001/m2_717_1265# u_t025_001/m2_603_2031# u_t025_001/m2_1290_336#
+ u_t025_001/m2_2000_2037# u_t025_001/m2_791_2909# u_t025_001/m2_7_2126# u_t025_001/m2_2154_2081#
+ u_t025_001/m2_1795_2037# u_t025_001/m2_871_303# u_t025_001/m2_431_438# u_t025_001/m2_1290_2898#
+ u_t025_001/m2_1714_1210# u_t025_001/m2_431_1982# u_t025_001/m2_512_1265# u_t025_001/m2_2573_2126#
+ u_t025_001/m2_603_1259# u_t025_001/m2_2074_2909# u_t025_001/m2_7_336# u_t025_001/m2_717_2037#
+ u_t025_001/m2_1886_2031# u_t025_001/m2_2573_336# u_t025_001/m2_7_2898# u_t025_001/m2_2000_1265#
+ u_t025_001/m2_512_2037# u_t025_001/m2_1795_1265# u_t025_001/m2_1714_1982# u_t025_001/m2_1886_1259#
+ u_t025_001/m2_1290_2126# u_t025_001/m2_1714_438# u_t025_001/m2_431_1210# u_t025_001/m2_2573_2898#
+ u_t025_001/m2_2154_303# u_t025_001/m2_871_2081# VSUBS detronyx_12t_2w2r_rc4_4x4_routed_5layer_direct
Xgf180mcu_as_sc_mcu7t3v3__inv_2_1110 VSS gf180mcu_as_sc_mcu7t3v3__inv_2_1111/VSS gf180mcu_as_sc_mcu7t3v3__inv_2_1110/Y
+ gf180mcu_as_sc_mcu7t3v3__inv_2_1111/Y gf180mcu_as_sc_mcu7t3v3__inv_2_1111/VNW VSUBS
+ gf180mcu_as_sc_mcu7t3v3__inv_2
Xgf180mcu_as_sc_mcu7t3v3__inv_2_1132 gf180mcu_as_sc_mcu7t3v3__inv_2_1133/VDD VSS VSS
+ gf180mcu_as_sc_mcu7t3v3__inv_2_1133/Y gf180mcu_as_sc_mcu7t3v3__inv_2_1133/VNW VSUBS
+ gf180mcu_as_sc_mcu7t3v3__inv_2
Xgf180mcu_as_sc_mcu7t3v3__inv_2_1187 VSS VSS VSS VSS gf180mcu_as_sc_mcu7t3v3__inv_2_1279/VNW
+ VSUBS gf180mcu_as_sc_mcu7t3v3__inv_2
Xgf180mcu_as_sc_mcu7t3v3__inv_2_1143 VSS gf180mcu_as_sc_mcu7t3v3__inv_2_1148/VDD VSS
+ VSS gf180mcu_as_sc_mcu7t3v3__inv_2_1145/VNW VSUBS gf180mcu_as_sc_mcu7t3v3__inv_2
Xgf180mcu_as_sc_mcu7t3v3__inv_2_1198 VSS VSS gf180mcu_as_sc_mcu7t3v3__inv_2_1198/Y
+ VSS gf180mcu_as_sc_mcu7t3v3__inv_2_1280/VNW VSUBS gf180mcu_as_sc_mcu7t3v3__inv_2
Xgf180mcu_as_sc_mcu7t3v3__inv_2_1121 VSS VSS gf180mcu_as_sc_mcu7t3v3__inv_2_1121/Y
+ VSS gf180mcu_as_sc_mcu7t3v3__inv_2_1121/VNW VSUBS gf180mcu_as_sc_mcu7t3v3__inv_2
Xgf180mcu_as_sc_mcu7t3v3__inv_2_1154 VSS VSS gf180mcu_as_sc_mcu7t3v3__inv_2_1154/Y
+ VSS gf180mcu_as_sc_mcu7t3v3__inv_2_1263/VNW VSUBS gf180mcu_as_sc_mcu7t3v3__inv_2
Xgf180mcu_as_sc_mcu7t3v3__inv_2_1176 VSS VSS VSS VSS gf180mcu_as_sc_mcu7t3v3__inv_2_1296/VNW
+ VSUBS gf180mcu_as_sc_mcu7t3v3__inv_2
Xgf180mcu_as_sc_mcu7t3v3__inv_2_1165 VSS VSS VSS VSS gf180mcu_as_sc_mcu7t3v3__inv_2_1299/VNW
+ VSUBS gf180mcu_as_sc_mcu7t3v3__inv_2
Xu_t031_015 u_t031_015/c0_w0_bl u_t031_015/c0_w0_br u_t031_015/c0_w1_bl u_t031_015/c0_w1_br
+ u_t031_015/c0_r0_rbl u_t031_015/c0_r1_rbl u_t031_015/c1_w0_bl u_t031_015/c1_w0_br
+ u_t031_015/c1_w1_bl u_t031_015/c1_w1_br u_t031_015/c1_r0_rbl u_t031_015/c1_r1_rbl
+ u_t031_015/c2_w0_bl u_t031_015/c2_w0_br u_t031_015/c2_w1_bl u_t031_015/c2_w1_br
+ u_t031_015/c2_r0_rbl u_t031_015/c2_r1_rbl u_t031_015/c3_w0_bl u_t031_015/c3_w0_br
+ u_t031_015/c3_w1_bl u_t031_015/c3_w1_br u_t031_015/c3_r0_rbl u_t031_015/c3_r1_rbl
+ u_t031_015/r0_w0_wl u_t031_015/r0_w1_wl u_t031_015/r0_r0_rwl u_t031_015/r0_r1_rwl
+ u_t031_015/r1_w0_wl u_t031_015/r1_w1_wl u_t031_015/r1_r0_rwl u_t031_015/r1_r1_rwl
+ u_t031_015/r2_w0_wl u_t031_015/r2_w1_wl u_t031_015/r2_r0_rwl u_t031_015/r2_r1_rwl
+ u_t031_015/r3_w0_wl u_t031_015/r3_w1_wl u_t031_015/r3_r0_rwl u_t031_015/r3_r1_rwl
+ VSS u_t031_015/VSS u_t031_015/m2_717_1265# u_t031_015/m2_603_2031# u_t031_015/m2_1290_336#
+ u_t031_015/m2_2000_2037# u_t031_015/m2_791_2909# u_t031_015/m2_7_2126# u_t031_015/m2_2154_2081#
+ u_t031_015/m2_1795_2037# u_t031_015/m2_871_303# u_t031_015/m2_431_438# u_t031_015/m2_1290_2898#
+ u_t031_015/m2_1714_1210# u_t031_015/m2_431_1982# u_t031_015/m2_512_1265# u_t031_015/m2_2573_2126#
+ u_t031_015/m2_603_1259# u_t031_015/m2_2074_2909# u_t031_015/m2_7_336# u_t031_015/m2_717_2037#
+ u_t031_015/m2_1886_2031# u_t031_015/m2_2573_336# u_t031_015/m2_7_2898# u_t031_015/m2_2000_1265#
+ u_t031_015/m2_512_2037# u_t031_015/m2_1795_1265# u_t031_015/m2_1714_1982# u_t031_015/m2_1886_1259#
+ u_t031_015/m2_1290_2126# u_t031_015/m2_1714_438# u_t031_015/m2_431_1210# u_t031_015/m2_2573_2898#
+ u_t031_015/m2_2154_303# u_t031_015/m2_871_2081# VSUBS detronyx_12t_2w2r_rc4_4x4_routed_5layer_direct
Xu_t016_012 u_t016_012/c0_w0_bl u_t016_012/c0_w0_br u_t016_012/c0_w1_bl u_t016_012/c0_w1_br
+ u_t016_012/c0_r0_rbl u_t016_012/c0_r1_rbl u_t016_012/c1_w0_bl u_t016_012/c1_w0_br
+ u_t016_012/c1_w1_bl u_t016_012/c1_w1_br u_t016_012/c1_r0_rbl u_t016_012/c1_r1_rbl
+ u_t016_012/c2_w0_bl u_t016_012/c2_w0_br u_t016_012/c2_w1_bl u_t016_012/c2_w1_br
+ u_t016_012/c2_r0_rbl u_t016_012/c2_r1_rbl u_t016_012/c3_w0_bl u_t016_012/c3_w0_br
+ u_t016_012/c3_w1_bl u_t016_012/c3_w1_br u_t016_012/c3_r0_rbl u_t016_012/c3_r1_rbl
+ u_t016_012/r0_w0_wl u_t016_012/r0_w1_wl u_t016_012/r0_r0_rwl u_t016_012/r0_r1_rwl
+ u_t016_012/r1_w0_wl u_t016_012/r1_w1_wl u_t016_012/r1_r0_rwl u_t016_012/r1_r1_rwl
+ u_t016_012/r2_w0_wl u_t016_012/r2_w1_wl u_t016_012/r2_r0_rwl u_t016_012/r2_r1_rwl
+ u_t016_012/r3_w0_wl u_t016_012/r3_w1_wl u_t016_012/r3_r0_rwl u_t016_012/r3_r1_rwl
+ u_t016_012/VDD u_t016_012/VSS u_t016_012/m2_717_1265# u_t016_012/m2_603_2031# u_t016_012/m2_1290_336#
+ u_t016_012/m2_2000_2037# u_t016_012/m2_791_2909# u_t016_012/m2_7_2126# u_t016_012/m2_2154_2081#
+ u_t016_012/m2_1795_2037# u_t016_012/m2_871_303# u_t016_012/m2_431_438# u_t016_012/m2_1290_2898#
+ u_t016_012/m2_1714_1210# u_t016_012/m2_431_1982# u_t016_012/m2_512_1265# u_t016_012/m2_2573_2126#
+ u_t016_012/m2_603_1259# u_t016_012/m2_2074_2909# u_t016_012/m2_7_336# u_t016_012/m2_717_2037#
+ u_t016_012/m2_1886_2031# u_t016_012/m2_2573_336# u_t016_012/m2_7_2898# u_t016_012/m2_2000_1265#
+ u_t016_012/m2_512_2037# u_t016_012/m2_1795_1265# u_t016_012/m2_1714_1982# u_t016_012/m2_1886_1259#
+ u_t016_012/m2_1290_2126# u_t016_012/m2_1714_438# u_t016_012/m2_431_1210# u_t016_012/m2_2573_2898#
+ u_t016_012/m2_2154_303# u_t016_012/m2_871_2081# VSUBS detronyx_12t_2w2r_rc4_4x4_routed_5layer_direct
Xu_t031_004 u_t031_004/c0_w0_bl u_t031_004/c0_w0_br u_t031_004/c0_w1_bl u_t031_004/c0_w1_br
+ u_t031_004/c0_r0_rbl u_t031_004/c0_r1_rbl u_t031_004/c1_w0_bl u_t031_004/c1_w0_br
+ u_t031_004/c1_w1_bl u_t031_004/c1_w1_br u_t031_004/c1_r0_rbl u_t031_004/c1_r1_rbl
+ u_t031_004/c2_w0_bl u_t031_004/c2_w0_br u_t031_004/c2_w1_bl u_t031_004/c2_w1_br
+ u_t031_004/c2_r0_rbl u_t031_004/c2_r1_rbl u_t031_004/c3_w0_bl u_t031_004/c3_w0_br
+ u_t031_004/c3_w1_bl u_t031_004/c3_w1_br u_t031_004/c3_r0_rbl u_t031_004/c3_r1_rbl
+ u_t031_004/r0_w0_wl u_t031_004/r0_w1_wl u_t031_004/r0_r0_rwl u_t031_004/r0_r1_rwl
+ u_t031_004/r1_w0_wl u_t031_004/r1_w1_wl u_t031_004/r1_r0_rwl u_t031_004/r1_r1_rwl
+ u_t031_004/r2_w0_wl u_t031_004/r2_w1_wl u_t031_004/r2_r0_rwl u_t031_004/r2_r1_rwl
+ u_t031_004/r3_w0_wl u_t031_004/r3_w1_wl u_t031_004/r3_r0_rwl u_t031_004/r3_r1_rwl
+ u_t031_004/VDD u_t031_004/VSS u_t031_004/m2_717_1265# u_t031_004/m2_603_2031# u_t031_004/m2_1290_336#
+ u_t031_004/m2_2000_2037# u_t031_004/m2_791_2909# u_t031_004/m2_7_2126# u_t031_004/m2_2154_2081#
+ u_t031_004/m2_1795_2037# u_t031_004/m2_871_303# u_t031_004/m2_431_438# u_t031_004/m2_1290_2898#
+ u_t031_004/m2_1714_1210# u_t031_004/m2_431_1982# u_t031_004/m2_512_1265# u_t031_004/m2_2573_2126#
+ u_t031_004/m2_603_1259# u_t031_004/m2_2074_2909# u_t031_004/m2_7_336# u_t031_004/m2_717_2037#
+ u_t031_004/m2_1886_2031# u_t031_004/m2_2573_336# u_t031_004/m2_7_2898# u_t031_004/m2_2000_1265#
+ u_t031_004/m2_512_2037# u_t031_004/m2_1795_1265# u_t031_004/m2_1714_1982# u_t031_004/m2_1886_1259#
+ u_t031_004/m2_1290_2126# u_t031_004/m2_1714_438# u_t031_004/m2_431_1210# u_t031_004/m2_2573_2898#
+ u_t031_004/m2_2154_303# u_t031_004/m2_871_2081# VSUBS detronyx_12t_2w2r_rc4_4x4_routed_5layer_direct
Xu_t016_001 u_t016_001/c0_w0_bl u_t016_001/c0_w0_br u_t016_001/c0_w1_bl u_t016_001/c0_w1_br
+ u_t016_001/c0_r0_rbl u_t016_001/c0_r1_rbl u_t016_001/c1_w0_bl u_t016_001/c1_w0_br
+ u_t016_001/c1_w1_bl u_t016_001/c1_w1_br u_t016_001/c1_r0_rbl u_t016_001/c1_r1_rbl
+ u_t016_001/c2_w0_bl u_t016_001/c2_w0_br u_t016_001/c2_w1_bl u_t016_001/c2_w1_br
+ u_t016_001/c2_r0_rbl u_t016_001/c2_r1_rbl u_t016_001/c3_w0_bl u_t016_001/c3_w0_br
+ u_t016_001/c3_w1_bl u_t016_001/c3_w1_br u_t016_001/c3_r0_rbl u_t016_001/c3_r1_rbl
+ u_t016_001/r0_w0_wl u_t016_001/r0_w1_wl u_t016_001/r0_r0_rwl u_t016_001/r0_r1_rwl
+ u_t016_001/r1_w0_wl u_t016_001/r1_w1_wl u_t016_001/r1_r0_rwl u_t016_001/r1_r1_rwl
+ u_t016_001/r2_w0_wl u_t016_001/r2_w1_wl u_t016_001/r2_r0_rwl u_t016_001/r2_r1_rwl
+ u_t016_001/r3_w0_wl u_t016_001/r3_w1_wl u_t016_001/r3_r0_rwl u_t016_001/r3_r1_rwl
+ VSS VSS u_t016_001/m2_717_1265# u_t016_001/m2_603_2031# u_t016_001/m2_1290_336#
+ u_t016_001/m2_2000_2037# u_t016_001/m2_791_2909# u_t016_001/m2_7_2126# u_t016_001/m2_2154_2081#
+ u_t016_001/m2_1795_2037# u_t016_001/m2_871_303# u_t016_001/m2_431_438# u_t016_001/m2_1290_2898#
+ u_t016_001/m2_1714_1210# u_t016_001/m2_431_1982# u_t016_001/m2_512_1265# u_t016_001/m2_2573_2126#
+ u_t016_001/m2_603_1259# u_t016_001/m2_2074_2909# u_t016_001/m2_7_336# u_t016_001/m2_717_2037#
+ u_t016_001/m2_1886_2031# u_t016_001/m2_2573_336# u_t016_001/m2_7_2898# u_t016_001/m2_2000_1265#
+ u_t016_001/m2_512_2037# u_t016_001/m2_1795_1265# u_t016_001/m2_1714_1982# u_t016_001/m2_1886_1259#
+ u_t016_001/m2_1290_2126# u_t016_001/m2_1714_438# u_t016_001/m2_431_1210# u_t016_001/m2_2573_2898#
+ u_t016_001/m2_2154_303# u_t016_001/m2_871_2081# VSUBS detronyx_12t_2w2r_rc4_4x4_routed_5layer_direct
Xgf180mcu_as_sc_mcu7t3v3__inv_2_638 gf180mcu_as_sc_mcu7t3v3__inv_2_638/VSS gf180mcu_as_sc_mcu7t3v3__inv_2_638/VSS
+ gf180mcu_as_sc_mcu7t3v3__inv_2_638/Y gf180mcu_as_sc_mcu7t3v3__inv_2_638/A gf180mcu_as_sc_mcu7t3v3__inv_2_638/VNW
+ VSUBS gf180mcu_as_sc_mcu7t3v3__inv_2
Xgf180mcu_as_sc_mcu7t3v3__inv_2_605 gf180mcu_as_sc_mcu7t3v3__inv_2_606/VDD VSS gf180mcu_as_sc_mcu7t3v3__inv_2_638/A
+ gf180mcu_as_sc_mcu7t3v3__inv_2_606/Y gf180mcu_as_sc_mcu7t3v3__inv_2_606/VNW VSUBS
+ gf180mcu_as_sc_mcu7t3v3__inv_2
Xgf180mcu_as_sc_mcu7t3v3__inv_2_627 gf180mcu_as_sc_mcu7t3v3__inv_2_632/VDD gf180mcu_as_sc_mcu7t3v3__inv_2_632/VDD
+ gf180mcu_as_sc_mcu7t3v3__inv_2_634/A gf180mcu_as_sc_mcu7t3v3__inv_2_628/Y gf180mcu_as_sc_mcu7t3v3__inv_2_628/VNW
+ VSUBS gf180mcu_as_sc_mcu7t3v3__inv_2
Xgf180mcu_as_sc_mcu7t3v3__inv_2_616 gf180mcu_as_sc_mcu7t3v3__inv_2_854/VSS gf180mcu_as_sc_mcu7t3v3__inv_2_620/VDD
+ gf180mcu_as_sc_mcu7t3v3__inv_2_616/Y VSS gf180mcu_as_sc_mcu7t3v3__inv_2_616/VNW
+ VSUBS gf180mcu_as_sc_mcu7t3v3__inv_2
Xgf180mcu_as_sc_mcu7t3v3__inv_2_649 VSS VSS gf180mcu_as_sc_mcu7t3v3__inv_2_662/A gf180mcu_as_sc_mcu7t3v3__inv_2_650/Y
+ gf180mcu_as_sc_mcu7t3v3__inv_2_650/VNW VSUBS gf180mcu_as_sc_mcu7t3v3__inv_2
Xu_t007_012 u_t007_012/c0_w0_bl u_t007_012/c0_w0_br u_t007_012/c0_w1_bl u_t007_012/c0_w1_br
+ u_t007_012/c0_r0_rbl u_t007_012/c0_r1_rbl u_t007_012/c1_w0_bl u_t007_012/c1_w0_br
+ u_t007_012/c1_w1_bl u_t007_012/c1_w1_br u_t007_012/c1_r0_rbl u_t007_012/c1_r1_rbl
+ u_t007_012/c2_w0_bl u_t007_012/c2_w0_br u_t007_012/c2_w1_bl u_t007_012/c2_w1_br
+ u_t007_012/c2_r0_rbl u_t007_012/c2_r1_rbl u_t007_012/c3_w0_bl u_t007_012/c3_w0_br
+ u_t007_012/c3_w1_bl u_t007_012/c3_w1_br u_t007_012/c3_r0_rbl u_t007_012/c3_r1_rbl
+ u_t007_012/r0_w0_wl u_t007_012/r0_w1_wl u_t007_012/r0_r0_rwl u_t007_012/r0_r1_rwl
+ u_t007_012/r1_w0_wl u_t007_012/r1_w1_wl u_t007_012/r1_r0_rwl u_t007_012/r1_r1_rwl
+ u_t007_012/r2_w0_wl u_t007_012/r2_w1_wl u_t007_012/r2_r0_rwl u_t007_012/r2_r1_rwl
+ u_t007_012/r3_w0_wl u_t007_012/r3_w1_wl u_t007_012/r3_r0_rwl u_t007_012/r3_r1_rwl
+ u_t008_012/VDD u_t007_012/VSS u_t007_012/m2_717_1265# u_t007_012/m2_603_2031# u_t007_012/m2_1290_336#
+ u_t007_012/m2_2000_2037# u_t007_012/m2_791_2909# u_t007_012/m2_7_2126# u_t007_012/m2_2154_2081#
+ u_t007_012/m2_1795_2037# u_t007_012/m2_871_303# u_t007_012/m2_431_438# u_t007_012/m2_1290_2898#
+ u_t007_012/m2_1714_1210# u_t007_012/m2_431_1982# u_t007_012/m2_512_1265# u_t007_012/m2_2573_2126#
+ u_t007_012/m2_603_1259# u_t007_012/m2_2074_2909# u_t007_012/m2_7_336# u_t007_012/m2_717_2037#
+ u_t007_012/m2_1886_2031# u_t007_012/m2_2573_336# u_t007_012/m2_7_2898# u_t007_012/m2_2000_1265#
+ u_t007_012/m2_512_2037# u_t007_012/m2_1795_1265# u_t007_012/m2_1714_1982# u_t007_012/m2_1886_1259#
+ u_t007_012/m2_1290_2126# u_t007_012/m2_1714_438# u_t007_012/m2_431_1210# u_t007_012/m2_2573_2898#
+ u_t007_012/m2_2154_303# u_t007_012/m2_871_2081# VSUBS detronyx_12t_2w2r_rc4_4x4_routed_5layer_direct
Xu_t007_001 u_t007_001/c0_w0_bl u_t007_001/c0_w0_br u_t007_001/c0_w1_bl u_t007_001/c0_w1_br
+ u_t007_001/c0_r0_rbl u_t007_001/c0_r1_rbl u_t007_001/c1_w0_bl u_t007_001/c1_w0_br
+ u_t007_001/c1_w1_bl u_t007_001/c1_w1_br u_t007_001/c1_r0_rbl u_t007_001/c1_r1_rbl
+ u_t007_001/c2_w0_bl u_t007_001/c2_w0_br u_t007_001/c2_w1_bl u_t007_001/c2_w1_br
+ u_t007_001/c2_r0_rbl u_t007_001/c2_r1_rbl u_t007_001/c3_w0_bl u_t007_001/c3_w0_br
+ u_t007_001/c3_w1_bl u_t007_001/c3_w1_br u_t007_001/c3_r0_rbl u_t007_001/c3_r1_rbl
+ u_t007_001/r0_w0_wl u_t007_001/r0_w1_wl u_t007_001/r0_r0_rwl u_t007_001/r0_r1_rwl
+ u_t007_001/r1_w0_wl u_t007_001/r1_w1_wl u_t007_001/r1_r0_rwl u_t007_001/r1_r1_rwl
+ u_t007_001/r2_w0_wl u_t007_001/r2_w1_wl u_t007_001/r2_r0_rwl u_t007_001/r2_r1_rwl
+ u_t007_001/r3_w0_wl u_t007_001/r3_w1_wl u_t007_001/r3_r0_rwl u_t007_001/r3_r1_rwl
+ VSS VSS u_t007_001/m2_717_1265# u_t007_001/m2_603_2031# u_t007_001/m2_1290_336#
+ u_t007_001/m2_2000_2037# u_t007_001/m2_791_2909# u_t007_001/m2_7_2126# u_t007_001/m2_2154_2081#
+ u_t007_001/m2_1795_2037# u_t007_001/m2_871_303# u_t007_001/m2_431_438# u_t007_001/m2_1290_2898#
+ u_t007_001/m2_1714_1210# u_t007_001/m2_431_1982# u_t007_001/m2_512_1265# u_t007_001/m2_2573_2126#
+ u_t007_001/m2_603_1259# u_t007_001/m2_2074_2909# u_t007_001/m2_7_336# u_t007_001/m2_717_2037#
+ u_t007_001/m2_1886_2031# u_t007_001/m2_2573_336# u_t007_001/m2_7_2898# u_t007_001/m2_2000_1265#
+ u_t007_001/m2_512_2037# u_t007_001/m2_1795_1265# u_t007_001/m2_1714_1982# u_t007_001/m2_1886_1259#
+ u_t007_001/m2_1290_2126# u_t007_001/m2_1714_438# u_t007_001/m2_431_1210# u_t007_001/m2_2573_2898#
+ u_t007_001/m2_2154_303# u_t007_001/m2_871_2081# VSUBS detronyx_12t_2w2r_rc4_4x4_routed_5layer_direct
Xu_t022_015 u_t022_015/c0_w0_bl u_t022_015/c0_w0_br u_t022_015/c0_w1_bl u_t022_015/c0_w1_br
+ u_t022_015/c0_r0_rbl u_t022_015/c0_r1_rbl u_t022_015/c1_w0_bl u_t022_015/c1_w0_br
+ u_t022_015/c1_w1_bl u_t022_015/c1_w1_br u_t022_015/c1_r0_rbl u_t022_015/c1_r1_rbl
+ u_t022_015/c2_w0_bl u_t022_015/c2_w0_br u_t022_015/c2_w1_bl u_t022_015/c2_w1_br
+ u_t022_015/c2_r0_rbl u_t022_015/c2_r1_rbl u_t022_015/c3_w0_bl u_t022_015/c3_w0_br
+ u_t022_015/c3_w1_bl u_t022_015/c3_w1_br u_t022_015/c3_r0_rbl u_t022_015/c3_r1_rbl
+ u_t022_015/r0_w0_wl u_t022_015/r0_w1_wl u_t022_015/r0_r0_rwl u_t022_015/r0_r1_rwl
+ u_t022_015/r1_w0_wl u_t022_015/r1_w1_wl u_t022_015/r1_r0_rwl u_t022_015/r1_r1_rwl
+ u_t022_015/r2_w0_wl u_t022_015/r2_w1_wl u_t022_015/r2_r0_rwl u_t022_015/r2_r1_rwl
+ u_t022_015/r3_w0_wl u_t022_015/r3_w1_wl u_t022_015/r3_r0_rwl u_t022_015/r3_r1_rwl
+ VSS VSS u_t022_015/m2_717_1265# u_t022_015/m2_603_2031# u_t022_015/m2_1290_336#
+ u_t022_015/m2_2000_2037# u_t022_015/m2_791_2909# u_t022_015/m2_7_2126# u_t022_015/m2_2154_2081#
+ u_t022_015/m2_1795_2037# u_t022_015/m2_871_303# u_t022_015/m2_431_438# u_t022_015/m2_1290_2898#
+ u_t022_015/m2_1714_1210# u_t022_015/m2_431_1982# u_t022_015/m2_512_1265# u_t022_015/m2_2573_2126#
+ u_t022_015/m2_603_1259# u_t022_015/m2_2074_2909# u_t022_015/m2_7_336# u_t022_015/m2_717_2037#
+ u_t022_015/m2_1886_2031# u_t022_015/m2_2573_336# u_t022_015/m2_7_2898# u_t022_015/m2_2000_1265#
+ u_t022_015/m2_512_2037# u_t022_015/m2_1795_1265# u_t022_015/m2_1714_1982# u_t022_015/m2_1886_1259#
+ u_t022_015/m2_1290_2126# u_t022_015/m2_1714_438# u_t022_015/m2_431_1210# u_t022_015/m2_2573_2898#
+ u_t022_015/m2_2154_303# u_t022_015/m2_871_2081# VSUBS detronyx_12t_2w2r_rc4_4x4_routed_5layer_direct
Xu_t022_004 u_t022_004/c0_w0_bl u_t022_004/c0_w0_br u_t022_004/c0_w1_bl u_t022_004/c0_w1_br
+ u_t022_004/c0_r0_rbl u_t022_004/c0_r1_rbl u_t022_004/c1_w0_bl u_t022_004/c1_w0_br
+ u_t022_004/c1_w1_bl u_t022_004/c1_w1_br u_t022_004/c1_r0_rbl u_t022_004/c1_r1_rbl
+ u_t022_004/c2_w0_bl u_t022_004/c2_w0_br u_t022_004/c2_w1_bl u_t022_004/c2_w1_br
+ u_t022_004/c2_r0_rbl u_t022_004/c2_r1_rbl u_t022_004/c3_w0_bl u_t022_004/c3_w0_br
+ u_t022_004/c3_w1_bl u_t022_004/c3_w1_br u_t022_004/c3_r0_rbl u_t022_004/c3_r1_rbl
+ u_t022_004/r0_w0_wl u_t022_004/r0_w1_wl u_t022_004/r0_r0_rwl u_t022_004/r0_r1_rwl
+ u_t022_004/r1_w0_wl u_t022_004/r1_w1_wl u_t022_004/r1_r0_rwl u_t022_004/r1_r1_rwl
+ u_t022_004/r2_w0_wl u_t022_004/r2_w1_wl u_t022_004/r2_r0_rwl u_t022_004/r2_r1_rwl
+ u_t022_004/r3_w0_wl u_t022_004/r3_w1_wl u_t022_004/r3_r0_rwl u_t022_004/r3_r1_rwl
+ u_t022_004/VDD VSS u_t022_004/m2_717_1265# u_t022_004/m2_603_2031# u_t022_004/m2_1290_336#
+ u_t022_004/m2_2000_2037# u_t022_004/m2_791_2909# u_t022_004/m2_7_2126# u_t022_004/m2_2154_2081#
+ u_t022_004/m2_1795_2037# u_t022_004/m2_871_303# u_t022_004/m2_431_438# u_t022_004/m2_1290_2898#
+ u_t022_004/m2_1714_1210# u_t022_004/m2_431_1982# u_t022_004/m2_512_1265# u_t022_004/m2_2573_2126#
+ u_t022_004/m2_603_1259# u_t022_004/m2_2074_2909# u_t022_004/m2_7_336# u_t022_004/m2_717_2037#
+ u_t022_004/m2_1886_2031# u_t022_004/m2_2573_336# u_t022_004/m2_7_2898# u_t022_004/m2_2000_1265#
+ u_t022_004/m2_512_2037# u_t022_004/m2_1795_1265# u_t022_004/m2_1714_1982# u_t022_004/m2_1886_1259#
+ u_t022_004/m2_1290_2126# u_t022_004/m2_1714_438# u_t022_004/m2_431_1210# u_t022_004/m2_2573_2898#
+ u_t022_004/m2_2154_303# u_t022_004/m2_871_2081# VSUBS detronyx_12t_2w2r_rc4_4x4_routed_5layer_direct
Xgf180mcu_as_sc_mcu7t3v3__nand4_2_471 VSS gf180mcu_as_sc_mcu7t3v3__inv_2_1394/VDD
+ VSS VSS VSS VSS VSS gf180mcu_as_sc_mcu7t3v3__inv_2_1390/VNW VSUBS gf180mcu_as_sc_mcu7t3v3__nand4_2
Xgf180mcu_as_sc_mcu7t3v3__nand4_2_460 gf180mcu_as_sc_mcu7t3v3__inv_2_1349/VDD gf180mcu_as_sc_mcu7t3v3__inv_2_1349/VSS
+ VSS VSS VSS VSS VSS gf180mcu_as_sc_mcu7t3v3__inv_2_1349/VNW VSUBS gf180mcu_as_sc_mcu7t3v3__nand4_2
Xu_t013_015 u_t013_015/c0_w0_bl u_t013_015/c0_w0_br u_t013_015/c0_w1_bl u_t013_015/c0_w1_br
+ u_t013_015/c0_r0_rbl u_t013_015/c0_r1_rbl u_t013_015/c1_w0_bl u_t013_015/c1_w0_br
+ u_t013_015/c1_w1_bl u_t013_015/c1_w1_br u_t013_015/c1_r0_rbl u_t013_015/c1_r1_rbl
+ u_t013_015/c2_w0_bl u_t013_015/c2_w0_br u_t013_015/c2_w1_bl u_t013_015/c2_w1_br
+ u_t013_015/c2_r0_rbl u_t013_015/c2_r1_rbl u_t013_015/c3_w0_bl u_t013_015/c3_w0_br
+ u_t013_015/c3_w1_bl u_t013_015/c3_w1_br u_t013_015/c3_r0_rbl u_t013_015/c3_r1_rbl
+ u_t013_015/r0_w0_wl u_t013_015/r0_w1_wl u_t013_015/r0_r0_rwl u_t013_015/r0_r1_rwl
+ u_t013_015/r1_w0_wl u_t013_015/r1_w1_wl u_t013_015/r1_r0_rwl u_t013_015/r1_r1_rwl
+ u_t013_015/r2_w0_wl u_t013_015/r2_w1_wl u_t013_015/r2_r0_rwl u_t013_015/r2_r1_rwl
+ u_t013_015/r3_w0_wl u_t013_015/r3_w1_wl u_t013_015/r3_r0_rwl u_t013_015/r3_r1_rwl
+ VSS VSS u_t013_015/m2_717_1265# u_t013_015/m2_603_2031# u_t013_015/m2_1290_336#
+ u_t013_015/m2_2000_2037# u_t013_015/m2_791_2909# u_t013_015/m2_7_2126# u_t013_015/m2_2154_2081#
+ u_t013_015/m2_1795_2037# u_t013_015/m2_871_303# u_t013_015/m2_431_438# u_t013_015/m2_1290_2898#
+ u_t013_015/m2_1714_1210# u_t013_015/m2_431_1982# u_t013_015/m2_512_1265# u_t013_015/m2_2573_2126#
+ u_t013_015/m2_603_1259# u_t013_015/m2_2074_2909# u_t013_015/m2_7_336# u_t013_015/m2_717_2037#
+ u_t013_015/m2_1886_2031# u_t013_015/m2_2573_336# u_t013_015/m2_7_2898# u_t013_015/m2_2000_1265#
+ u_t013_015/m2_512_2037# u_t013_015/m2_1795_1265# u_t013_015/m2_1714_1982# u_t013_015/m2_1886_1259#
+ u_t013_015/m2_1290_2126# u_t013_015/m2_1714_438# u_t013_015/m2_431_1210# u_t013_015/m2_2573_2898#
+ u_t013_015/m2_2154_303# u_t013_015/m2_871_2081# VSUBS detronyx_12t_2w2r_rc4_4x4_routed_5layer_direct
Xu_t013_004 u_t013_004/c0_w0_bl u_t013_004/c0_w0_br u_t013_004/c0_w1_bl u_t013_004/c0_w1_br
+ u_t013_004/c0_r0_rbl u_t013_004/c0_r1_rbl u_t013_004/c1_w0_bl u_t013_004/c1_w0_br
+ u_t013_004/c1_w1_bl u_t013_004/c1_w1_br u_t013_004/c1_r0_rbl u_t013_004/c1_r1_rbl
+ u_t013_004/c2_w0_bl u_t013_004/c2_w0_br u_t013_004/c2_w1_bl u_t013_004/c2_w1_br
+ u_t013_004/c2_r0_rbl u_t013_004/c2_r1_rbl u_t013_004/c3_w0_bl u_t013_004/c3_w0_br
+ u_t013_004/c3_w1_bl u_t013_004/c3_w1_br u_t013_004/c3_r0_rbl u_t013_004/c3_r1_rbl
+ u_t013_004/r0_w0_wl u_t013_004/r0_w1_wl u_t013_004/r0_r0_rwl u_t013_004/r0_r1_rwl
+ u_t013_004/r1_w0_wl u_t013_004/r1_w1_wl u_t013_004/r1_r0_rwl u_t013_004/r1_r1_rwl
+ u_t013_004/r2_w0_wl u_t013_004/r2_w1_wl u_t013_004/r2_r0_rwl u_t013_004/r2_r1_rwl
+ u_t013_004/r3_w0_wl u_t013_004/r3_w1_wl u_t013_004/r3_r0_rwl u_t013_004/r3_r1_rwl
+ u_t013_004/VDD VSS u_t013_004/m2_717_1265# u_t013_004/m2_603_2031# u_t013_004/m2_1290_336#
+ u_t013_004/m2_2000_2037# u_t013_004/m2_791_2909# u_t013_004/m2_7_2126# u_t013_004/m2_2154_2081#
+ u_t013_004/m2_1795_2037# u_t013_004/m2_871_303# u_t013_004/m2_431_438# u_t013_004/m2_1290_2898#
+ u_t013_004/m2_1714_1210# u_t013_004/m2_431_1982# u_t013_004/m2_512_1265# u_t013_004/m2_2573_2126#
+ u_t013_004/m2_603_1259# u_t013_004/m2_2074_2909# u_t013_004/m2_7_336# u_t013_004/m2_717_2037#
+ u_t013_004/m2_1886_2031# u_t013_004/m2_2573_336# u_t013_004/m2_7_2898# u_t013_004/m2_2000_1265#
+ u_t013_004/m2_512_2037# u_t013_004/m2_1795_1265# u_t013_004/m2_1714_1982# u_t013_004/m2_1886_1259#
+ u_t013_004/m2_1290_2126# u_t013_004/m2_1714_438# u_t013_004/m2_431_1210# u_t013_004/m2_2573_2898#
+ u_t013_004/m2_2154_303# u_t013_004/m2_871_2081# VSUBS detronyx_12t_2w2r_rc4_4x4_routed_5layer_direct
Xgf180mcu_as_sc_mcu7t3v3__nand4_2_482 VSS gf180mcu_as_sc_mcu7t3v3__inv_2_1656/VDD
+ VSS VSS VSS VSS VSS gf180mcu_as_sc_mcu7t3v3__inv_2_1652/VNW VSUBS gf180mcu_as_sc_mcu7t3v3__nand4_2
Xgf180mcu_as_sc_mcu7t3v3__nand4_2_493 gf180mcu_as_sc_mcu7t3v3__inv_2_1691/VSS gf180mcu_as_sc_mcu7t3v3__inv_2_1694/VDD
+ VSS VSS VSS VSS VSS gf180mcu_as_sc_mcu7t3v3__inv_2_1610/VNW VSUBS gf180mcu_as_sc_mcu7t3v3__nand4_2
Xgf180mcu_as_sc_mcu7t3v3__inv_2_402 gf180mcu_as_sc_mcu7t3v3__nor2_2_6/VDD gf180mcu_as_sc_mcu7t3v3__nand3_2_4/VSS
+ VSS VSS gf180mcu_as_sc_mcu7t3v3__nor2_2_6/VNW VSUBS gf180mcu_as_sc_mcu7t3v3__inv_2
Xu_t004_015 u_t004_015/c0_w0_bl u_t004_015/c0_w0_br u_t004_015/c0_w1_bl u_t004_015/c0_w1_br
+ u_t004_015/c0_r0_rbl u_t004_015/c0_r1_rbl u_t004_015/c1_w0_bl u_t004_015/c1_w0_br
+ u_t004_015/c1_w1_bl u_t004_015/c1_w1_br u_t004_015/c1_r0_rbl u_t004_015/c1_r1_rbl
+ u_t004_015/c2_w0_bl u_t004_015/c2_w0_br u_t004_015/c2_w1_bl u_t004_015/c2_w1_br
+ u_t004_015/c2_r0_rbl u_t004_015/c2_r1_rbl u_t004_015/c3_w0_bl u_t004_015/c3_w0_br
+ u_t004_015/c3_w1_bl u_t004_015/c3_w1_br u_t004_015/c3_r0_rbl u_t004_015/c3_r1_rbl
+ u_t004_015/r0_w0_wl u_t004_015/r0_w1_wl u_t004_015/r0_r0_rwl u_t004_015/r0_r1_rwl
+ u_t004_015/r1_w0_wl u_t004_015/r1_w1_wl u_t004_015/r1_r0_rwl u_t004_015/r1_r1_rwl
+ u_t004_015/r2_w0_wl u_t004_015/r2_w1_wl u_t004_015/r2_r0_rwl u_t004_015/r2_r1_rwl
+ u_t004_015/r3_w0_wl u_t004_015/r3_w1_wl u_t004_015/r3_r0_rwl u_t004_015/r3_r1_rwl
+ VSS VSS u_t004_015/m2_717_1265# u_t004_015/m2_603_2031# u_t004_015/m2_1290_336#
+ u_t004_015/m2_2000_2037# u_t004_015/m2_791_2909# u_t004_015/m2_7_2126# u_t004_015/m2_2154_2081#
+ u_t004_015/m2_1795_2037# u_t004_015/m2_871_303# u_t004_015/m2_431_438# u_t004_015/m2_1290_2898#
+ u_t004_015/m2_1714_1210# u_t004_015/m2_431_1982# u_t004_015/m2_512_1265# u_t004_015/m2_2573_2126#
+ u_t004_015/m2_603_1259# u_t004_015/m2_2074_2909# u_t004_015/m2_7_336# u_t004_015/m2_717_2037#
+ u_t004_015/m2_1886_2031# u_t004_015/m2_2573_336# u_t004_015/m2_7_2898# u_t004_015/m2_2000_1265#
+ u_t004_015/m2_512_2037# u_t004_015/m2_1795_1265# u_t004_015/m2_1714_1982# u_t004_015/m2_1886_1259#
+ u_t004_015/m2_1290_2126# u_t004_015/m2_1714_438# u_t004_015/m2_431_1210# u_t004_015/m2_2573_2898#
+ u_t004_015/m2_2154_303# u_t004_015/m2_871_2081# VSUBS detronyx_12t_2w2r_rc4_4x4_routed_5layer_direct
Xu_t004_004 u_t004_004/c0_w0_bl u_t004_004/c0_w0_br u_t004_004/c0_w1_bl u_t004_004/c0_w1_br
+ u_t004_004/c0_r0_rbl u_t004_004/c0_r1_rbl u_t004_004/c1_w0_bl u_t004_004/c1_w0_br
+ u_t004_004/c1_w1_bl u_t004_004/c1_w1_br u_t004_004/c1_r0_rbl u_t004_004/c1_r1_rbl
+ u_t004_004/c2_w0_bl u_t004_004/c2_w0_br u_t004_004/c2_w1_bl u_t004_004/c2_w1_br
+ u_t004_004/c2_r0_rbl u_t004_004/c2_r1_rbl u_t004_004/c3_w0_bl u_t004_004/c3_w0_br
+ u_t004_004/c3_w1_bl u_t004_004/c3_w1_br u_t004_004/c3_r0_rbl u_t004_004/c3_r1_rbl
+ u_t004_004/r0_w0_wl u_t004_004/r0_w1_wl u_t004_004/r0_r0_rwl u_t004_004/r0_r1_rwl
+ u_t004_004/r1_w0_wl u_t004_004/r1_w1_wl u_t004_004/r1_r0_rwl u_t004_004/r1_r1_rwl
+ u_t004_004/r2_w0_wl u_t004_004/r2_w1_wl u_t004_004/r2_r0_rwl u_t004_004/r2_r1_rwl
+ u_t004_004/r3_w0_wl u_t004_004/r3_w1_wl u_t004_004/r3_r0_rwl u_t004_004/r3_r1_rwl
+ u_t004_004/VDD VSS u_t004_004/m2_717_1265# u_t004_004/m2_603_2031# u_t004_004/m2_1290_336#
+ u_t004_004/m2_2000_2037# u_t004_004/m2_791_2909# u_t004_004/m2_7_2126# u_t004_004/m2_2154_2081#
+ u_t004_004/m2_1795_2037# u_t004_004/m2_871_303# u_t004_004/m2_431_438# u_t004_004/m2_1290_2898#
+ u_t004_004/m2_1714_1210# u_t004_004/m2_431_1982# u_t004_004/m2_512_1265# u_t004_004/m2_2573_2126#
+ u_t004_004/m2_603_1259# u_t004_004/m2_2074_2909# u_t004_004/m2_7_336# u_t004_004/m2_717_2037#
+ u_t004_004/m2_1886_2031# u_t004_004/m2_2573_336# u_t004_004/m2_7_2898# u_t004_004/m2_2000_1265#
+ u_t004_004/m2_512_2037# u_t004_004/m2_1795_1265# u_t004_004/m2_1714_1982# u_t004_004/m2_1886_1259#
+ u_t004_004/m2_1290_2126# u_t004_004/m2_1714_438# u_t004_004/m2_431_1210# u_t004_004/m2_2573_2898#
+ u_t004_004/m2_2154_303# u_t004_004/m2_871_2081# VSUBS detronyx_12t_2w2r_rc4_4x4_routed_5layer_direct
Xgf180mcu_as_sc_mcu7t3v3__inv_2_413 gf180mcu_as_sc_mcu7t3v3__nor2_2_7/VDD gf180mcu_as_sc_mcu7t3v3__nand3_2_4/VSS
+ VSS VSS gf180mcu_as_sc_mcu7t3v3__nor2_2_7/VNW VSUBS gf180mcu_as_sc_mcu7t3v3__inv_2
Xgf180mcu_as_sc_mcu7t3v3__inv_2_424 gf180mcu_as_sc_mcu7t3v3__nor2_2_6/VDD gf180mcu_as_sc_mcu7t3v3__nor2_2_6/VSS
+ gf180mcu_as_sc_mcu7t3v3__inv_2_424/Y VSS gf180mcu_as_sc_mcu7t3v3__nor2_2_6/VNW VSUBS
+ gf180mcu_as_sc_mcu7t3v3__inv_2
Xgf180mcu_as_sc_mcu7t3v3__inv_2_479 gf180mcu_as_sc_mcu7t3v3__nor2_2_6/VDD gf180mcu_as_sc_mcu7t3v3__nor2_2_6/VSS
+ gf180mcu_as_sc_mcu7t3v3__inv_2_479/Y VSS gf180mcu_as_sc_mcu7t3v3__nor2_2_6/VNW VSUBS
+ gf180mcu_as_sc_mcu7t3v3__inv_2
Xgf180mcu_as_sc_mcu7t3v3__inv_2_457 gf180mcu_as_sc_mcu7t3v3__nor2_2_7/VDD gf180mcu_as_sc_mcu7t3v3__nand3_2_4/VSS
+ VSS VSS gf180mcu_as_sc_mcu7t3v3__nor2_2_7/VNW VSUBS gf180mcu_as_sc_mcu7t3v3__inv_2
Xgf180mcu_as_sc_mcu7t3v3__inv_2_446 gf180mcu_as_sc_mcu7t3v3__nor2_2_7/VDD gf180mcu_as_sc_mcu7t3v3__nand3_2_4/VSS
+ VSS VSS gf180mcu_as_sc_mcu7t3v3__nor2_2_7/VNW VSUBS gf180mcu_as_sc_mcu7t3v3__inv_2
Xgf180mcu_as_sc_mcu7t3v3__inv_2_435 gf180mcu_as_sc_mcu7t3v3__nor2_2_4/VDD gf180mcu_as_sc_mcu7t3v3__nand2_2_3/VSS
+ VSS VSS gf180mcu_as_sc_mcu7t3v3__nor2_2_4/VNW VSUBS gf180mcu_as_sc_mcu7t3v3__inv_2
Xgf180mcu_as_sc_mcu7t3v3__inv_2_468 gf180mcu_as_sc_mcu7t3v3__nand3_2_9/VDD gf180mcu_as_sc_mcu7t3v3__nor2_2_7/VSS
+ VSS VSS gf180mcu_as_sc_mcu7t3v3__nand3_2_9/VNW VSUBS gf180mcu_as_sc_mcu7t3v3__inv_2
Xu_t010_007 u_t010_007/c0_w0_bl u_t010_007/c0_w0_br u_t010_007/c0_w1_bl u_t010_007/c0_w1_br
+ u_t010_007/c0_r0_rbl u_t010_007/c0_r1_rbl u_t010_007/c1_w0_bl u_t010_007/c1_w0_br
+ u_t010_007/c1_w1_bl u_t010_007/c1_w1_br u_t010_007/c1_r0_rbl u_t010_007/c1_r1_rbl
+ u_t010_007/c2_w0_bl u_t010_007/c2_w0_br u_t010_007/c2_w1_bl u_t010_007/c2_w1_br
+ u_t010_007/c2_r0_rbl u_t010_007/c2_r1_rbl u_t010_007/c3_w0_bl u_t010_007/c3_w0_br
+ u_t010_007/c3_w1_bl u_t010_007/c3_w1_br u_t010_007/c3_r0_rbl u_t010_007/c3_r1_rbl
+ u_t010_007/r0_w0_wl u_t010_007/r0_w1_wl u_t010_007/r0_r0_rwl u_t010_007/r0_r1_rwl
+ u_t010_007/r1_w0_wl u_t010_007/r1_w1_wl u_t010_007/r1_r0_rwl u_t010_007/r1_r1_rwl
+ u_t010_007/r2_w0_wl u_t010_007/r2_w1_wl u_t010_007/r2_r0_rwl u_t010_007/r2_r1_rwl
+ u_t010_007/r3_w0_wl u_t010_007/r3_w1_wl u_t010_007/r3_r0_rwl u_t010_007/r3_r1_rwl
+ VSS u_t010_009/VSS u_t010_007/m2_717_1265# u_t010_007/m2_603_2031# u_t010_007/m2_1290_336#
+ u_t010_007/m2_2000_2037# u_t010_007/m2_791_2909# u_t010_007/m2_7_2126# u_t010_007/m2_2154_2081#
+ u_t010_007/m2_1795_2037# u_t010_007/m2_871_303# u_t010_007/m2_431_438# u_t010_007/m2_1290_2898#
+ u_t010_007/m2_1714_1210# u_t010_007/m2_431_1982# u_t010_007/m2_512_1265# u_t010_007/m2_2573_2126#
+ u_t010_007/m2_603_1259# u_t010_007/m2_2074_2909# u_t010_007/m2_7_336# u_t010_007/m2_717_2037#
+ u_t010_007/m2_1886_2031# u_t010_007/m2_2573_336# u_t010_007/m2_7_2898# u_t010_007/m2_2000_1265#
+ u_t010_007/m2_512_2037# u_t010_007/m2_1795_1265# u_t010_007/m2_1714_1982# u_t010_007/m2_1886_1259#
+ u_t010_007/m2_1290_2126# u_t010_007/m2_1714_438# u_t010_007/m2_431_1210# u_t010_007/m2_2573_2898#
+ u_t010_007/m2_2154_303# u_t010_007/m2_871_2081# VSUBS detronyx_12t_2w2r_rc4_4x4_routed_5layer_direct
Xgf180mcu_as_sc_mcu7t3v3__inv_2_980 VSS gf180mcu_as_sc_mcu7t3v3__inv_2_984/VDD gf180mcu_as_sc_mcu7t3v3__inv_2_980/Y
+ VSS gf180mcu_as_sc_mcu7t3v3__inv_2_980/VNW VSUBS gf180mcu_as_sc_mcu7t3v3__inv_2
Xgf180mcu_as_sc_mcu7t3v3__inv_2_991 VSS gf180mcu_as_sc_mcu7t3v3__inv_2_996/VDD gf180mcu_as_sc_mcu7t3v3__inv_2_998/A
+ gf180mcu_as_sc_mcu7t3v3__inv_2_992/Y gf180mcu_as_sc_mcu7t3v3__inv_2_992/VNW VSUBS
+ gf180mcu_as_sc_mcu7t3v3__inv_2
Xgf180mcu_as_sc_mcu7t3v3__nand4_2_290 gf180mcu_as_sc_mcu7t3v3__inv_2_984/VDD gf180mcu_as_sc_mcu7t3v3__inv_2_988/VDD
+ VSS VSS VSS VSS VSS gf180mcu_as_sc_mcu7t3v3__inv_2_984/VNW VSUBS gf180mcu_as_sc_mcu7t3v3__nand4_2
Xu_t001_007 u_t001_007/c0_w0_bl u_t001_007/c0_w0_br u_t001_007/c0_w1_bl u_t001_007/c0_w1_br
+ u_t001_007/c0_r0_rbl u_t001_007/c0_r1_rbl u_t001_007/c1_w0_bl u_t001_007/c1_w0_br
+ u_t001_007/c1_w1_bl u_t001_007/c1_w1_br u_t001_007/c1_r0_rbl u_t001_007/c1_r1_rbl
+ u_t001_007/c2_w0_bl u_t001_007/c2_w0_br u_t001_007/c2_w1_bl u_t001_007/c2_w1_br
+ u_t001_007/c2_r0_rbl u_t001_007/c2_r1_rbl u_t001_007/c3_w0_bl u_t001_007/c3_w0_br
+ u_t001_007/c3_w1_bl u_t001_007/c3_w1_br u_t001_007/c3_r0_rbl u_t001_007/c3_r1_rbl
+ u_t001_007/r0_w0_wl u_t001_007/r0_w1_wl u_t001_007/r0_r0_rwl u_t001_007/r0_r1_rwl
+ u_t001_007/r1_w0_wl u_t001_007/r1_w1_wl u_t001_007/r1_r0_rwl u_t001_007/r1_r1_rwl
+ u_t001_007/r2_w0_wl u_t001_007/r2_w1_wl u_t001_007/r2_r0_rwl u_t001_007/r2_r1_rwl
+ u_t001_007/r3_w0_wl u_t001_007/r3_w1_wl u_t001_007/r3_r0_rwl u_t001_007/r3_r1_rwl
+ VSS VSS u_t001_007/m2_717_1265# u_t001_007/m2_603_2031# u_t001_007/m2_1290_336#
+ u_t001_007/m2_2000_2037# u_t001_007/m2_791_2909# u_t001_007/m2_7_2126# u_t001_007/m2_2154_2081#
+ u_t001_007/m2_1795_2037# u_t001_007/m2_871_303# u_t001_007/m2_431_438# u_t001_007/m2_1290_2898#
+ u_t001_007/m2_1714_1210# u_t001_007/m2_431_1982# u_t001_007/m2_512_1265# u_t001_007/m2_2573_2126#
+ u_t001_007/m2_603_1259# u_t001_007/m2_2074_2909# u_t001_007/m2_7_336# u_t001_007/m2_717_2037#
+ u_t001_007/m2_1886_2031# u_t001_007/m2_2573_336# u_t001_007/m2_7_2898# u_t001_007/m2_2000_1265#
+ u_t001_007/m2_512_2037# u_t001_007/m2_1795_1265# u_t001_007/m2_1714_1982# u_t001_007/m2_1886_1259#
+ u_t001_007/m2_1290_2126# u_t001_007/m2_1714_438# u_t001_007/m2_431_1210# u_t001_007/m2_2573_2898#
+ u_t001_007/m2_2154_303# u_t001_007/m2_871_2081# VSUBS detronyx_12t_2w2r_rc4_4x4_routed_5layer_direct
Xgf180mcu_as_sc_mcu7t3v3__inv_2_221 VSS VSS VSS VSS gf180mcu_as_sc_mcu7t3v3__inv_2_221/VNW
+ VSUBS gf180mcu_as_sc_mcu7t3v3__inv_2
Xgf180mcu_as_sc_mcu7t3v3__inv_2_210 VSS VSS gf180mcu_as_sc_mcu7t3v3__inv_2_210/Y VSS
+ gf180mcu_as_sc_mcu7t3v3__inv_2_212/VNW VSUBS gf180mcu_as_sc_mcu7t3v3__inv_2
Xgf180mcu_as_sc_mcu7t3v3__inv_2_243 VSS gf180mcu_as_sc_mcu7t3v3__inv_2_248/VDD gf180mcu_as_sc_mcu7t3v3__inv_2_243/Y
+ VSS gf180mcu_as_sc_mcu7t3v3__inv_2_245/VNW VSUBS gf180mcu_as_sc_mcu7t3v3__inv_2
Xgf180mcu_as_sc_mcu7t3v3__inv_2_232 VSS VSS VSS VSS gf180mcu_as_sc_mcu7t3v3__inv_2_233/VNW
+ VSUBS gf180mcu_as_sc_mcu7t3v3__inv_2
Xgf180mcu_as_sc_mcu7t3v3__inv_2_1709 gf180mcu_as_sc_mcu7t3v3__nor2_2_7/VDD gf180mcu_as_sc_mcu7t3v3__nand3_2_4/VSS
+ VSS VSS gf180mcu_as_sc_mcu7t3v3__nor2_2_7/VNW VSUBS gf180mcu_as_sc_mcu7t3v3__inv_2
Xgf180mcu_as_sc_mcu7t3v3__inv_2_265 gf180mcu_as_sc_mcu7t3v3__inv_2_308/VDD gf180mcu_as_sc_mcu7t3v3__inv_2_308/VSS
+ gf180mcu_as_sc_mcu7t3v3__inv_2_61/Y VSS gf180mcu_as_sc_mcu7t3v3__inv_2_308/VNW VSUBS
+ gf180mcu_as_sc_mcu7t3v3__inv_2
Xgf180mcu_as_sc_mcu7t3v3__inv_2_287 VSS VSS gf180mcu_as_sc_mcu7t3v3__inv_2_301/Y VSS
+ gf180mcu_as_sc_mcu7t3v3__inv_2_287/VNW VSUBS gf180mcu_as_sc_mcu7t3v3__inv_2
Xgf180mcu_as_sc_mcu7t3v3__inv_2_298 VSS gf180mcu_as_sc_mcu7t3v3__inv_2_301/VDD gf180mcu_as_sc_mcu7t3v3__inv_2_298/Y
+ gf180mcu_as_sc_mcu7t3v3__inv_2_301/Y gf180mcu_as_sc_mcu7t3v3__inv_2_298/VNW VSUBS
+ gf180mcu_as_sc_mcu7t3v3__inv_2
Xgf180mcu_as_sc_mcu7t3v3__inv_2_276 gf180mcu_as_sc_mcu7t3v3__inv_2_279/VDD VSS VSS
+ gf180mcu_as_sc_mcu7t3v3__inv_2_365/Y gf180mcu_as_sc_mcu7t3v3__inv_2_279/VNW VSUBS
+ gf180mcu_as_sc_mcu7t3v3__inv_2
Xgf180mcu_as_sc_mcu7t3v3__inv_2_254 VSS gf180mcu_as_sc_mcu7t3v3__inv_2_257/VDD VSS
+ VSS gf180mcu_as_sc_mcu7t3v3__inv_2_254/VNW VSUBS gf180mcu_as_sc_mcu7t3v3__inv_2
Xgf180mcu_as_sc_mcu7t3v3__inv_2_1517 gf180mcu_as_sc_mcu7t3v3__inv_2_1562/VSS VSS VSS
+ VSS gf180mcu_as_sc_mcu7t3v3__inv_2_1519/VNW VSUBS gf180mcu_as_sc_mcu7t3v3__inv_2
Xgf180mcu_as_sc_mcu7t3v3__inv_2_1528 VSS gf180mcu_as_sc_mcu7t3v3__inv_2_1532/VDD gf180mcu_as_sc_mcu7t3v3__inv_2_1528/Y
+ VSS gf180mcu_as_sc_mcu7t3v3__inv_2_1529/VNW VSUBS gf180mcu_as_sc_mcu7t3v3__inv_2
Xgf180mcu_as_sc_mcu7t3v3__inv_2_1539 gf180mcu_as_sc_mcu7t3v3__inv_2_1541/VDD gf180mcu_as_sc_mcu7t3v3__inv_2_1697/VDD
+ VSS VSS gf180mcu_as_sc_mcu7t3v3__inv_2_1541/VNW VSUBS gf180mcu_as_sc_mcu7t3v3__inv_2
Xgf180mcu_as_sc_mcu7t3v3__inv_2_1506 VSS gf180mcu_as_sc_mcu7t3v3__inv_2_1508/VDD VSS
+ VSS gf180mcu_as_sc_mcu7t3v3__inv_2_1506/VNW VSUBS gf180mcu_as_sc_mcu7t3v3__inv_2
Xgf180mcu_as_sc_mcu7t3v3__nand2_2_5 gf180mcu_as_sc_mcu7t3v3__nor2_2_7/VDD gf180mcu_as_sc_mcu7t3v3__nand3_2_4/VSS
+ VSS VSS VSS gf180mcu_as_sc_mcu7t3v3__nor2_2_7/VNW VSUBS gf180mcu_as_sc_mcu7t3v3__nand2_2
Xgf180mcu_as_sc_mcu7t3v3__nor2_2_0 gf180mcu_as_sc_mcu7t3v3__nor2_2_4/VDD gf180mcu_as_sc_mcu7t3v3__nor2_2_4/VSS
+ VSS VSS VSS gf180mcu_as_sc_mcu7t3v3__nor2_2_4/VNW VSUBS gf180mcu_as_sc_mcu7t3v3__nor2_2
Xgf180mcu_as_sc_mcu7t3v3__inv_2_1369 gf180mcu_as_sc_mcu7t3v3__inv_2_1370/VDD VSS gf180mcu_as_sc_mcu7t3v3__inv_2_1694/Y
+ gf180mcu_as_sc_mcu7t3v3__inv_2_1694/Y gf180mcu_as_sc_mcu7t3v3__inv_2_1370/VNW VSUBS
+ gf180mcu_as_sc_mcu7t3v3__inv_2
Xgf180mcu_as_sc_mcu7t3v3__inv_2_1303 VSS VSS VSS VSS gf180mcu_as_sc_mcu7t3v3__inv_2_1304/VNW
+ VSUBS gf180mcu_as_sc_mcu7t3v3__inv_2
Xgf180mcu_as_sc_mcu7t3v3__inv_2_1358 VSS gf180mcu_as_sc_mcu7t3v3__inv_2_1409/VDD gf180mcu_as_sc_mcu7t3v3__inv_2_1409/A
+ VSS gf180mcu_as_sc_mcu7t3v3__inv_2_1358/VNW VSUBS gf180mcu_as_sc_mcu7t3v3__inv_2
Xgf180mcu_as_sc_mcu7t3v3__inv_2_1325 VSS gf180mcu_as_sc_mcu7t3v3__inv_2_1349/VDD VSS
+ gf180mcu_as_sc_mcu7t3v3__inv_2_1355/Y gf180mcu_as_sc_mcu7t3v3__inv_2_1333/VNW VSUBS
+ gf180mcu_as_sc_mcu7t3v3__inv_2
Xgf180mcu_as_sc_mcu7t3v3__inv_2_1314 gf180mcu_as_sc_mcu7t3v3__inv_2_1316/VDD gf180mcu_as_sc_mcu7t3v3__inv_2_1320/VDD
+ VSS gf180mcu_as_sc_mcu7t3v3__inv_2_1355/Y gf180mcu_as_sc_mcu7t3v3__inv_2_1316/VNW
+ VSUBS gf180mcu_as_sc_mcu7t3v3__inv_2
Xgf180mcu_as_sc_mcu7t3v3__inv_2_1347 VSS gf180mcu_as_sc_mcu7t3v3__inv_2_1352/VDD gf180mcu_as_sc_mcu7t3v3__inv_2_1347/Y
+ gf180mcu_as_sc_mcu7t3v3__inv_2_1355/Y gf180mcu_as_sc_mcu7t3v3__inv_2_1348/VNW VSUBS
+ gf180mcu_as_sc_mcu7t3v3__inv_2
Xgf180mcu_as_sc_mcu7t3v3__inv_2_1336 VSS gf180mcu_as_sc_mcu7t3v3__inv_2_1340/VDD gf180mcu_as_sc_mcu7t3v3__inv_2_1340/Y
+ VSS gf180mcu_as_sc_mcu7t3v3__inv_2_1336/VNW VSUBS gf180mcu_as_sc_mcu7t3v3__inv_2
Xu_t028_010 u_t028_010/c0_w0_bl u_t028_010/c0_w0_br u_t028_010/c0_w1_bl u_t028_010/c0_w1_br
+ u_t028_010/c0_r0_rbl u_t028_010/c0_r1_rbl u_t028_010/c1_w0_bl u_t028_010/c1_w0_br
+ u_t028_010/c1_w1_bl u_t028_010/c1_w1_br u_t028_010/c1_r0_rbl u_t028_010/c1_r1_rbl
+ u_t028_010/c2_w0_bl u_t028_010/c2_w0_br u_t028_010/c2_w1_bl u_t028_010/c2_w1_br
+ u_t028_010/c2_r0_rbl u_t028_010/c2_r1_rbl u_t028_010/c3_w0_bl u_t028_010/c3_w0_br
+ u_t028_010/c3_w1_bl u_t028_010/c3_w1_br u_t028_010/c3_r0_rbl u_t028_010/c3_r1_rbl
+ u_t028_010/r0_w0_wl u_t028_010/r0_w1_wl u_t028_010/r0_r0_rwl u_t028_010/r0_r1_rwl
+ u_t028_010/r1_w0_wl u_t028_010/r1_w1_wl u_t028_010/r1_r0_rwl u_t028_010/r1_r1_rwl
+ u_t028_010/r2_w0_wl u_t028_010/r2_w1_wl u_t028_010/r2_r0_rwl u_t028_010/r2_r1_rwl
+ u_t028_010/r3_w0_wl u_t028_010/r3_w1_wl u_t028_010/r3_r0_rwl u_t028_010/r3_r1_rwl
+ VSS u_t028_010/VSS u_t028_010/m2_717_1265# u_t028_010/m2_603_2031# u_t028_010/m2_1290_336#
+ u_t028_010/m2_2000_2037# u_t028_010/m2_791_2909# u_t028_010/m2_7_2126# u_t028_010/m2_2154_2081#
+ u_t028_010/m2_1795_2037# u_t028_010/m2_871_303# u_t028_010/m2_431_438# u_t028_010/m2_1290_2898#
+ u_t028_010/m2_1714_1210# u_t028_010/m2_431_1982# u_t028_010/m2_512_1265# u_t028_010/m2_2573_2126#
+ u_t028_010/m2_603_1259# u_t028_010/m2_2074_2909# u_t028_010/m2_7_336# u_t028_010/m2_717_2037#
+ u_t028_010/m2_1886_2031# u_t028_010/m2_2573_336# u_t028_010/m2_7_2898# u_t028_010/m2_2000_1265#
+ u_t028_010/m2_512_2037# u_t028_010/m2_1795_1265# u_t028_010/m2_1714_1982# u_t028_010/m2_1886_1259#
+ u_t028_010/m2_1290_2126# u_t028_010/m2_1714_438# u_t028_010/m2_431_1210# u_t028_010/m2_2573_2898#
+ u_t028_010/m2_2154_303# u_t028_010/m2_871_2081# VSUBS detronyx_12t_2w2r_rc4_4x4_routed_5layer_direct
Xgf180mcu_as_sc_mcu7t3v3__inv_2_809 VSS VSS gf180mcu_as_sc_mcu7t3v3__inv_2_809/Y VSS
+ gf180mcu_as_sc_mcu7t3v3__inv_2_839/VNW VSUBS gf180mcu_as_sc_mcu7t3v3__inv_2
Xgf180mcu_as_sc_mcu7t3v3__nand4_2_108 VSS gf180mcu_as_sc_mcu7t3v3__inv_2_281/VDD VSS
+ VSS VSS VSS VSS gf180mcu_as_sc_mcu7t3v3__inv_2_268/VNW VSUBS gf180mcu_as_sc_mcu7t3v3__nand4_2
Xu_t019_010 u_t019_010/c0_w0_bl u_t019_010/c0_w0_br u_t019_010/c0_w1_bl u_t019_010/c0_w1_br
+ u_t019_010/c0_r0_rbl u_t019_010/c0_r1_rbl u_t019_010/c1_w0_bl u_t019_010/c1_w0_br
+ u_t019_010/c1_w1_bl u_t019_010/c1_w1_br u_t019_010/c1_r0_rbl u_t019_010/c1_r1_rbl
+ u_t019_010/c2_w0_bl u_t019_010/c2_w0_br u_t019_010/c2_w1_bl u_t019_010/c2_w1_br
+ u_t019_010/c2_r0_rbl u_t019_010/c2_r1_rbl u_t019_010/c3_w0_bl u_t019_010/c3_w0_br
+ u_t019_010/c3_w1_bl u_t019_010/c3_w1_br u_t019_010/c3_r0_rbl u_t019_010/c3_r1_rbl
+ u_t019_010/r0_w0_wl u_t019_010/r0_w1_wl u_t019_010/r0_r0_rwl u_t019_010/r0_r1_rwl
+ u_t019_010/r1_w0_wl u_t019_010/r1_w1_wl u_t019_010/r1_r0_rwl u_t019_010/r1_r1_rwl
+ u_t019_010/r2_w0_wl u_t019_010/r2_w1_wl u_t019_010/r2_r0_rwl u_t019_010/r2_r1_rwl
+ u_t019_010/r3_w0_wl u_t019_010/r3_w1_wl u_t019_010/r3_r0_rwl u_t019_010/r3_r1_rwl
+ VSS u_t019_010/VSS u_t019_010/m2_717_1265# u_t019_010/m2_603_2031# u_t019_010/m2_1290_336#
+ u_t019_010/m2_2000_2037# u_t019_010/m2_791_2909# u_t019_010/m2_7_2126# u_t019_010/m2_2154_2081#
+ u_t019_010/m2_1795_2037# u_t019_010/m2_871_303# u_t019_010/m2_431_438# u_t019_010/m2_1290_2898#
+ u_t019_010/m2_1714_1210# u_t019_010/m2_431_1982# u_t019_010/m2_512_1265# u_t019_010/m2_2573_2126#
+ u_t019_010/m2_603_1259# u_t019_010/m2_2074_2909# u_t019_010/m2_7_336# u_t019_010/m2_717_2037#
+ u_t019_010/m2_1886_2031# u_t019_010/m2_2573_336# u_t019_010/m2_7_2898# u_t019_010/m2_2000_1265#
+ u_t019_010/m2_512_2037# u_t019_010/m2_1795_1265# u_t019_010/m2_1714_1982# u_t019_010/m2_1886_1259#
+ u_t019_010/m2_1290_2126# u_t019_010/m2_1714_438# u_t019_010/m2_431_1210# u_t019_010/m2_2573_2898#
+ u_t019_010/m2_2154_303# u_t019_010/m2_871_2081# VSUBS detronyx_12t_2w2r_rc4_4x4_routed_5layer_direct
Xgf180mcu_as_sc_mcu7t3v3__nand4_2_25 VSS VSS VSS VSS VSS VSS VSS gf180mcu_as_sc_mcu7t3v3__inv_2_155/VNW
+ VSUBS gf180mcu_as_sc_mcu7t3v3__nand4_2
Xgf180mcu_as_sc_mcu7t3v3__nand4_2_14 gf180mcu_as_sc_mcu7t3v3__inv_2_122/VDD gf180mcu_as_sc_mcu7t3v3__inv_2_125/VDD
+ VSS VSS VSS VSS gf180mcu_as_sc_mcu7t3v3__nand4_2_14/Y gf180mcu_as_sc_mcu7t3v3__inv_2_122/VNW
+ VSUBS gf180mcu_as_sc_mcu7t3v3__nand4_2
Xgf180mcu_as_sc_mcu7t3v3__nand4_2_119 VSS gf180mcu_as_sc_mcu7t3v3__inv_2_301/VDD VSS
+ VSS VSS VSS VSS gf180mcu_as_sc_mcu7t3v3__inv_2_298/VNW VSUBS gf180mcu_as_sc_mcu7t3v3__nand4_2
Xgf180mcu_as_sc_mcu7t3v3__nand4_2_36 gf180mcu_as_sc_mcu7t3v3__inv_2_190/VDD gf180mcu_as_sc_mcu7t3v3__inv_2_193/VDD
+ VSS VSS VSS VSS gf180mcu_as_sc_mcu7t3v3__nand4_2_36/Y gf180mcu_as_sc_mcu7t3v3__inv_2_190/VNW
+ VSUBS gf180mcu_as_sc_mcu7t3v3__nand4_2
Xgf180mcu_as_sc_mcu7t3v3__nand4_2_47 VSS VSS VSS VSS VSS VSS VSS gf180mcu_as_sc_mcu7t3v3__inv_2_221/VNW
+ VSUBS gf180mcu_as_sc_mcu7t3v3__nand4_2
Xgf180mcu_as_sc_mcu7t3v3__nand4_2_58 VSS gf180mcu_as_sc_mcu7t3v3__inv_2_257/VDD VSS
+ VSS VSS VSS VSS gf180mcu_as_sc_mcu7t3v3__inv_2_254/VNW VSUBS gf180mcu_as_sc_mcu7t3v3__nand4_2
Xgf180mcu_as_sc_mcu7t3v3__nand4_2_69 gf180mcu_as_sc_mcu7t3v3__inv_2_32/VDD gf180mcu_as_sc_mcu7t3v3__inv_2_4/VDD
+ VSS VSS VSS VSS VSS gf180mcu_as_sc_mcu7t3v3__inv_2_32/VNW VSUBS gf180mcu_as_sc_mcu7t3v3__nand4_2
Xu_t025_013 u_t025_013/c0_w0_bl u_t025_013/c0_w0_br u_t025_013/c0_w1_bl u_t025_013/c0_w1_br
+ u_t025_013/c0_r0_rbl u_t025_013/c0_r1_rbl u_t025_013/c1_w0_bl u_t025_013/c1_w0_br
+ u_t025_013/c1_w1_bl u_t025_013/c1_w1_br u_t025_013/c1_r0_rbl u_t025_013/c1_r1_rbl
+ u_t025_013/c2_w0_bl u_t025_013/c2_w0_br u_t025_013/c2_w1_bl u_t025_013/c2_w1_br
+ u_t025_013/c2_r0_rbl u_t025_013/c2_r1_rbl u_t025_013/c3_w0_bl u_t025_013/c3_w0_br
+ u_t025_013/c3_w1_bl u_t025_013/c3_w1_br u_t025_013/c3_r0_rbl u_t025_013/c3_r1_rbl
+ u_t025_013/r0_w0_wl u_t025_013/r0_w1_wl u_t025_013/r0_r0_rwl u_t025_013/r0_r1_rwl
+ u_t025_013/r1_w0_wl u_t025_013/r1_w1_wl u_t025_013/r1_r0_rwl u_t025_013/r1_r1_rwl
+ u_t025_013/r2_w0_wl u_t025_013/r2_w1_wl u_t025_013/r2_r0_rwl u_t025_013/r2_r1_rwl
+ u_t025_013/r3_w0_wl u_t025_013/r3_w1_wl u_t025_013/r3_r0_rwl u_t025_013/r3_r1_rwl
+ u_t025_013/VDD VSS u_t025_013/m2_717_1265# u_t025_013/m2_603_2031# u_t025_013/m2_1290_336#
+ u_t025_013/m2_2000_2037# u_t025_013/m2_791_2909# u_t025_013/m2_7_2126# u_t025_013/m2_2154_2081#
+ u_t025_013/m2_1795_2037# u_t025_013/m2_871_303# u_t025_013/m2_431_438# u_t025_013/m2_1290_2898#
+ u_t025_013/m2_1714_1210# u_t025_013/m2_431_1982# u_t025_013/m2_512_1265# u_t025_013/m2_2573_2126#
+ u_t025_013/m2_603_1259# u_t025_013/m2_2074_2909# u_t025_013/m2_7_336# u_t025_013/m2_717_2037#
+ u_t025_013/m2_1886_2031# u_t025_013/m2_2573_336# u_t025_013/m2_7_2898# u_t025_013/m2_2000_1265#
+ u_t025_013/m2_512_2037# u_t025_013/m2_1795_1265# u_t025_013/m2_1714_1982# u_t025_013/m2_1886_1259#
+ u_t025_013/m2_1290_2126# u_t025_013/m2_1714_438# u_t025_013/m2_431_1210# u_t025_013/m2_2573_2898#
+ u_t025_013/m2_2154_303# u_t025_013/m2_871_2081# VSUBS detronyx_12t_2w2r_rc4_4x4_routed_5layer_direct
Xu_t025_002 u_t025_002/c0_w0_bl u_t025_002/c0_w0_br u_t025_002/c0_w1_bl u_t025_002/c0_w1_br
+ u_t025_002/c0_r0_rbl u_t025_002/c0_r1_rbl u_t025_002/c1_w0_bl u_t025_002/c1_w0_br
+ u_t025_002/c1_w1_bl u_t025_002/c1_w1_br u_t025_002/c1_r0_rbl u_t025_002/c1_r1_rbl
+ u_t025_002/c2_w0_bl u_t025_002/c2_w0_br u_t025_002/c2_w1_bl u_t025_002/c2_w1_br
+ u_t025_002/c2_r0_rbl u_t025_002/c2_r1_rbl u_t025_002/c3_w0_bl u_t025_002/c3_w0_br
+ u_t025_002/c3_w1_bl u_t025_002/c3_w1_br u_t025_002/c3_r0_rbl u_t025_002/c3_r1_rbl
+ u_t025_002/r0_w0_wl u_t025_002/r0_w1_wl u_t025_002/r0_r0_rwl u_t025_002/r0_r1_rwl
+ u_t025_002/r1_w0_wl u_t025_002/r1_w1_wl u_t025_002/r1_r0_rwl u_t025_002/r1_r1_rwl
+ u_t025_002/r2_w0_wl u_t025_002/r2_w1_wl u_t025_002/r2_r0_rwl u_t025_002/r2_r1_rwl
+ u_t025_002/r3_w0_wl u_t025_002/r3_w1_wl u_t025_002/r3_r0_rwl u_t025_002/r3_r1_rwl
+ VSS VSS u_t025_002/m2_717_1265# u_t025_002/m2_603_2031# u_t025_002/m2_1290_336#
+ u_t025_002/m2_2000_2037# u_t025_002/m2_791_2909# u_t025_002/m2_7_2126# u_t025_002/m2_2154_2081#
+ u_t025_002/m2_1795_2037# u_t025_002/m2_871_303# u_t025_002/m2_431_438# u_t025_002/m2_1290_2898#
+ u_t025_002/m2_1714_1210# u_t025_002/m2_431_1982# u_t025_002/m2_512_1265# u_t025_002/m2_2573_2126#
+ u_t025_002/m2_603_1259# u_t025_002/m2_2074_2909# u_t025_002/m2_7_336# u_t025_002/m2_717_2037#
+ u_t025_002/m2_1886_2031# u_t025_002/m2_2573_336# u_t025_002/m2_7_2898# u_t025_002/m2_2000_1265#
+ u_t025_002/m2_512_2037# u_t025_002/m2_1795_1265# u_t025_002/m2_1714_1982# u_t025_002/m2_1886_1259#
+ u_t025_002/m2_1290_2126# u_t025_002/m2_1714_438# u_t025_002/m2_431_1210# u_t025_002/m2_2573_2898#
+ u_t025_002/m2_2154_303# u_t025_002/m2_871_2081# VSUBS detronyx_12t_2w2r_rc4_4x4_routed_5layer_direct
Xgf180mcu_as_sc_mcu7t3v3__inv_2_1133 gf180mcu_as_sc_mcu7t3v3__inv_2_1133/VDD VSS gf180mcu_as_sc_mcu7t3v3__inv_2_1133/Y
+ VSS gf180mcu_as_sc_mcu7t3v3__inv_2_1133/VNW VSUBS gf180mcu_as_sc_mcu7t3v3__inv_2
Xgf180mcu_as_sc_mcu7t3v3__inv_2_1144 VSS gf180mcu_as_sc_mcu7t3v3__inv_2_1148/VDD VSS
+ gf180mcu_as_sc_mcu7t3v3__inv_2_1145/Y gf180mcu_as_sc_mcu7t3v3__inv_2_1145/VNW VSUBS
+ gf180mcu_as_sc_mcu7t3v3__inv_2
Xgf180mcu_as_sc_mcu7t3v3__inv_2_1100 VSS gf180mcu_as_sc_mcu7t3v3__inv_2_1100/VSS gf180mcu_as_sc_mcu7t3v3__inv_2_1100/Y
+ gf180mcu_as_sc_mcu7t3v3__inv_2_1100/A gf180mcu_as_sc_mcu7t3v3__inv_2_1100/VNW VSUBS
+ gf180mcu_as_sc_mcu7t3v3__inv_2
Xgf180mcu_as_sc_mcu7t3v3__inv_2_1122 VSS VSS VSS gf180mcu_as_sc_mcu7t3v3__inv_2_1122/A
+ gf180mcu_as_sc_mcu7t3v3__inv_2_1124/VNW VSUBS gf180mcu_as_sc_mcu7t3v3__inv_2
Xgf180mcu_as_sc_mcu7t3v3__inv_2_1111 VSS gf180mcu_as_sc_mcu7t3v3__inv_2_1111/VSS gf180mcu_as_sc_mcu7t3v3__inv_2_1111/Y
+ VSS gf180mcu_as_sc_mcu7t3v3__inv_2_1111/VNW VSUBS gf180mcu_as_sc_mcu7t3v3__inv_2
Xgf180mcu_as_sc_mcu7t3v3__inv_2_1188 VSS VSS VSS VSS gf180mcu_as_sc_mcu7t3v3__inv_2_1279/VNW
+ VSUBS gf180mcu_as_sc_mcu7t3v3__inv_2
Xgf180mcu_as_sc_mcu7t3v3__inv_2_1199 VSS VSS VSS VSS gf180mcu_as_sc_mcu7t3v3__inv_2_1272/VNW
+ VSUBS gf180mcu_as_sc_mcu7t3v3__inv_2
Xgf180mcu_as_sc_mcu7t3v3__inv_2_1166 VSS VSS VSS VSS gf180mcu_as_sc_mcu7t3v3__inv_2_1294/VNW
+ VSUBS gf180mcu_as_sc_mcu7t3v3__inv_2
Xgf180mcu_as_sc_mcu7t3v3__inv_2_1177 VSS VSS VSS VSS gf180mcu_as_sc_mcu7t3v3__inv_2_1296/VNW
+ VSUBS gf180mcu_as_sc_mcu7t3v3__inv_2
Xgf180mcu_as_sc_mcu7t3v3__inv_2_1155 VSS VSS gf180mcu_as_sc_mcu7t3v3__inv_2_1155/Y
+ VSS gf180mcu_as_sc_mcu7t3v3__inv_2_1298/VNW VSUBS gf180mcu_as_sc_mcu7t3v3__inv_2
Xu_t016_013 u_t016_013/c0_w0_bl u_t016_013/c0_w0_br u_t016_013/c0_w1_bl u_t016_013/c0_w1_br
+ u_t016_013/c0_r0_rbl u_t016_013/c0_r1_rbl u_t016_013/c1_w0_bl u_t016_013/c1_w0_br
+ u_t016_013/c1_w1_bl u_t016_013/c1_w1_br u_t016_013/c1_r0_rbl u_t016_013/c1_r1_rbl
+ u_t016_013/c2_w0_bl u_t016_013/c2_w0_br u_t016_013/c2_w1_bl u_t016_013/c2_w1_br
+ u_t016_013/c2_r0_rbl u_t016_013/c2_r1_rbl u_t016_013/c3_w0_bl u_t016_013/c3_w0_br
+ u_t016_013/c3_w1_bl u_t016_013/c3_w1_br u_t016_013/c3_r0_rbl u_t016_013/c3_r1_rbl
+ u_t016_013/r0_w0_wl u_t016_013/r0_w1_wl u_t016_013/r0_r0_rwl u_t016_013/r0_r1_rwl
+ u_t016_013/r1_w0_wl u_t016_013/r1_w1_wl u_t016_013/r1_r0_rwl u_t016_013/r1_r1_rwl
+ u_t016_013/r2_w0_wl u_t016_013/r2_w1_wl u_t016_013/r2_r0_rwl u_t016_013/r2_r1_rwl
+ u_t016_013/r3_w0_wl u_t016_013/r3_w1_wl u_t016_013/r3_r0_rwl u_t016_013/r3_r1_rwl
+ u_t016_013/VDD u_t016_013/VSS u_t016_013/m2_717_1265# u_t016_013/m2_603_2031# u_t016_013/m2_1290_336#
+ u_t016_013/m2_2000_2037# u_t016_013/m2_791_2909# u_t016_013/m2_7_2126# u_t016_013/m2_2154_2081#
+ u_t016_013/m2_1795_2037# u_t016_013/m2_871_303# u_t016_013/m2_431_438# u_t016_013/m2_1290_2898#
+ u_t016_013/m2_1714_1210# u_t016_013/m2_431_1982# u_t016_013/m2_512_1265# u_t016_013/m2_2573_2126#
+ u_t016_013/m2_603_1259# u_t016_013/m2_2074_2909# u_t016_013/m2_7_336# u_t016_013/m2_717_2037#
+ u_t016_013/m2_1886_2031# u_t016_013/m2_2573_336# u_t016_013/m2_7_2898# u_t016_013/m2_2000_1265#
+ u_t016_013/m2_512_2037# u_t016_013/m2_1795_1265# u_t016_013/m2_1714_1982# u_t016_013/m2_1886_1259#
+ u_t016_013/m2_1290_2126# u_t016_013/m2_1714_438# u_t016_013/m2_431_1210# u_t016_013/m2_2573_2898#
+ u_t016_013/m2_2154_303# u_t016_013/m2_871_2081# VSUBS detronyx_12t_2w2r_rc4_4x4_routed_5layer_direct
Xu_t031_005 u_t031_005/c0_w0_bl u_t031_005/c0_w0_br u_t031_005/c0_w1_bl u_t031_005/c0_w1_br
+ u_t031_005/c0_r0_rbl u_t031_005/c0_r1_rbl u_t031_005/c1_w0_bl u_t031_005/c1_w0_br
+ u_t031_005/c1_w1_bl u_t031_005/c1_w1_br u_t031_005/c1_r0_rbl u_t031_005/c1_r1_rbl
+ u_t031_005/c2_w0_bl u_t031_005/c2_w0_br u_t031_005/c2_w1_bl u_t031_005/c2_w1_br
+ u_t031_005/c2_r0_rbl u_t031_005/c2_r1_rbl u_t031_005/c3_w0_bl u_t031_005/c3_w0_br
+ u_t031_005/c3_w1_bl u_t031_005/c3_w1_br u_t031_005/c3_r0_rbl u_t031_005/c3_r1_rbl
+ u_t031_005/r0_w0_wl u_t031_005/r0_w1_wl u_t031_005/r0_r0_rwl u_t031_005/r0_r1_rwl
+ u_t031_005/r1_w0_wl u_t031_005/r1_w1_wl u_t031_005/r1_r0_rwl u_t031_005/r1_r1_rwl
+ u_t031_005/r2_w0_wl u_t031_005/r2_w1_wl u_t031_005/r2_r0_rwl u_t031_005/r2_r1_rwl
+ u_t031_005/r3_w0_wl u_t031_005/r3_w1_wl u_t031_005/r3_r0_rwl u_t031_005/r3_r1_rwl
+ u_t031_005/VDD u_t031_005/VSS u_t031_005/m2_717_1265# u_t031_005/m2_603_2031# u_t031_005/m2_1290_336#
+ u_t031_005/m2_2000_2037# u_t031_005/m2_791_2909# u_t031_005/m2_7_2126# u_t031_005/m2_2154_2081#
+ u_t031_005/m2_1795_2037# u_t031_005/m2_871_303# u_t031_005/m2_431_438# u_t031_005/m2_1290_2898#
+ u_t031_005/m2_1714_1210# u_t031_005/m2_431_1982# u_t031_005/m2_512_1265# u_t031_005/m2_2573_2126#
+ u_t031_005/m2_603_1259# u_t031_005/m2_2074_2909# u_t031_005/m2_7_336# u_t031_005/m2_717_2037#
+ u_t031_005/m2_1886_2031# u_t031_005/m2_2573_336# u_t031_005/m2_7_2898# u_t031_005/m2_2000_1265#
+ u_t031_005/m2_512_2037# u_t031_005/m2_1795_1265# u_t031_005/m2_1714_1982# u_t031_005/m2_1886_1259#
+ u_t031_005/m2_1290_2126# u_t031_005/m2_1714_438# u_t031_005/m2_431_1210# u_t031_005/m2_2573_2898#
+ u_t031_005/m2_2154_303# u_t031_005/m2_871_2081# VSUBS detronyx_12t_2w2r_rc4_4x4_routed_5layer_direct
Xu_t016_002 u_t016_002/c0_w0_bl u_t016_002/c0_w0_br u_t016_002/c0_w1_bl u_t016_002/c0_w1_br
+ u_t016_002/c0_r0_rbl u_t016_002/c0_r1_rbl u_t016_002/c1_w0_bl u_t016_002/c1_w0_br
+ u_t016_002/c1_w1_bl u_t016_002/c1_w1_br u_t016_002/c1_r0_rbl u_t016_002/c1_r1_rbl
+ u_t016_002/c2_w0_bl u_t016_002/c2_w0_br u_t016_002/c2_w1_bl u_t016_002/c2_w1_br
+ u_t016_002/c2_r0_rbl u_t016_002/c2_r1_rbl u_t016_002/c3_w0_bl u_t016_002/c3_w0_br
+ u_t016_002/c3_w1_bl u_t016_002/c3_w1_br u_t016_002/c3_r0_rbl u_t016_002/c3_r1_rbl
+ u_t016_002/r0_w0_wl u_t016_002/r0_w1_wl u_t016_002/r0_r0_rwl u_t016_002/r0_r1_rwl
+ u_t016_002/r1_w0_wl u_t016_002/r1_w1_wl u_t016_002/r1_r0_rwl u_t016_002/r1_r1_rwl
+ u_t016_002/r2_w0_wl u_t016_002/r2_w1_wl u_t016_002/r2_r0_rwl u_t016_002/r2_r1_rwl
+ u_t016_002/r3_w0_wl u_t016_002/r3_w1_wl u_t016_002/r3_r0_rwl u_t016_002/r3_r1_rwl
+ VSS VSS u_t016_002/m2_717_1265# u_t016_002/m2_603_2031# u_t016_002/m2_1290_336#
+ u_t016_002/m2_2000_2037# u_t016_002/m2_791_2909# u_t016_002/m2_7_2126# u_t016_002/m2_2154_2081#
+ u_t016_002/m2_1795_2037# u_t016_002/m2_871_303# u_t016_002/m2_431_438# u_t016_002/m2_1290_2898#
+ u_t016_002/m2_1714_1210# u_t016_002/m2_431_1982# u_t016_002/m2_512_1265# u_t016_002/m2_2573_2126#
+ u_t016_002/m2_603_1259# u_t016_002/m2_2074_2909# u_t016_002/m2_7_336# u_t016_002/m2_717_2037#
+ u_t016_002/m2_1886_2031# u_t016_002/m2_2573_336# u_t016_002/m2_7_2898# u_t016_002/m2_2000_1265#
+ u_t016_002/m2_512_2037# u_t016_002/m2_1795_1265# u_t016_002/m2_1714_1982# u_t016_002/m2_1886_1259#
+ u_t016_002/m2_1290_2126# u_t016_002/m2_1714_438# u_t016_002/m2_431_1210# u_t016_002/m2_2573_2898#
+ u_t016_002/m2_2154_303# u_t016_002/m2_871_2081# VSUBS detronyx_12t_2w2r_rc4_4x4_routed_5layer_direct
Xgf180mcu_as_sc_mcu7t3v3__inv_2_639 VSS VSS gf180mcu_as_sc_mcu7t3v3__inv_2_639/Y gf180mcu_as_sc_mcu7t3v3__inv_2_640/Y
+ gf180mcu_as_sc_mcu7t3v3__inv_2_641/VNW VSUBS gf180mcu_as_sc_mcu7t3v3__inv_2
Xgf180mcu_as_sc_mcu7t3v3__inv_2_617 gf180mcu_as_sc_mcu7t3v3__inv_2_617/VDD gf180mcu_as_sc_mcu7t3v3__inv_2_633/VDD
+ gf180mcu_as_sc_mcu7t3v3__inv_2_617/Y VSS gf180mcu_as_sc_mcu7t3v3__inv_2_617/VNW
+ VSUBS gf180mcu_as_sc_mcu7t3v3__inv_2
Xgf180mcu_as_sc_mcu7t3v3__inv_2_606 gf180mcu_as_sc_mcu7t3v3__inv_2_606/VDD VSS gf180mcu_as_sc_mcu7t3v3__inv_2_606/Y
+ VSS gf180mcu_as_sc_mcu7t3v3__inv_2_606/VNW VSUBS gf180mcu_as_sc_mcu7t3v3__inv_2
Xgf180mcu_as_sc_mcu7t3v3__inv_2_628 gf180mcu_as_sc_mcu7t3v3__inv_2_632/VDD gf180mcu_as_sc_mcu7t3v3__inv_2_632/VDD
+ gf180mcu_as_sc_mcu7t3v3__inv_2_628/Y VSS gf180mcu_as_sc_mcu7t3v3__inv_2_628/VNW
+ VSUBS gf180mcu_as_sc_mcu7t3v3__inv_2
Xu_t007_013 u_t007_013/c0_w0_bl u_t007_013/c0_w0_br u_t007_013/c0_w1_bl u_t007_013/c0_w1_br
+ u_t007_013/c0_r0_rbl u_t007_013/c0_r1_rbl u_t007_013/c1_w0_bl u_t007_013/c1_w0_br
+ u_t007_013/c1_w1_bl u_t007_013/c1_w1_br u_t007_013/c1_r0_rbl u_t007_013/c1_r1_rbl
+ u_t007_013/c2_w0_bl u_t007_013/c2_w0_br u_t007_013/c2_w1_bl u_t007_013/c2_w1_br
+ u_t007_013/c2_r0_rbl u_t007_013/c2_r1_rbl u_t007_013/c3_w0_bl u_t007_013/c3_w0_br
+ u_t007_013/c3_w1_bl u_t007_013/c3_w1_br u_t007_013/c3_r0_rbl u_t007_013/c3_r1_rbl
+ u_t007_013/r0_w0_wl u_t007_013/r0_w1_wl u_t007_013/r0_r0_rwl u_t007_013/r0_r1_rwl
+ u_t007_013/r1_w0_wl u_t007_013/r1_w1_wl u_t007_013/r1_r0_rwl u_t007_013/r1_r1_rwl
+ u_t007_013/r2_w0_wl u_t007_013/r2_w1_wl u_t007_013/r2_r0_rwl u_t007_013/r2_r1_rwl
+ u_t007_013/r3_w0_wl u_t007_013/r3_w1_wl u_t007_013/r3_r0_rwl u_t007_013/r3_r1_rwl
+ u_t008_013/VDD u_t007_013/VSS u_t007_013/m2_717_1265# u_t007_013/m2_603_2031# u_t007_013/m2_1290_336#
+ u_t007_013/m2_2000_2037# u_t007_013/m2_791_2909# u_t007_013/m2_7_2126# u_t007_013/m2_2154_2081#
+ u_t007_013/m2_1795_2037# u_t007_013/m2_871_303# u_t007_013/m2_431_438# u_t007_013/m2_1290_2898#
+ u_t007_013/m2_1714_1210# u_t007_013/m2_431_1982# u_t007_013/m2_512_1265# u_t007_013/m2_2573_2126#
+ u_t007_013/m2_603_1259# u_t007_013/m2_2074_2909# u_t007_013/m2_7_336# u_t007_013/m2_717_2037#
+ u_t007_013/m2_1886_2031# u_t007_013/m2_2573_336# u_t007_013/m2_7_2898# u_t007_013/m2_2000_1265#
+ u_t007_013/m2_512_2037# u_t007_013/m2_1795_1265# u_t007_013/m2_1714_1982# u_t007_013/m2_1886_1259#
+ u_t007_013/m2_1290_2126# u_t007_013/m2_1714_438# u_t007_013/m2_431_1210# u_t007_013/m2_2573_2898#
+ u_t007_013/m2_2154_303# u_t007_013/m2_871_2081# VSUBS detronyx_12t_2w2r_rc4_4x4_routed_5layer_direct
Xu_t007_002 u_t007_002/c0_w0_bl u_t007_002/c0_w0_br u_t007_002/c0_w1_bl u_t007_002/c0_w1_br
+ u_t007_002/c0_r0_rbl u_t007_002/c0_r1_rbl u_t007_002/c1_w0_bl u_t007_002/c1_w0_br
+ u_t007_002/c1_w1_bl u_t007_002/c1_w1_br u_t007_002/c1_r0_rbl u_t007_002/c1_r1_rbl
+ u_t007_002/c2_w0_bl u_t007_002/c2_w0_br u_t007_002/c2_w1_bl u_t007_002/c2_w1_br
+ u_t007_002/c2_r0_rbl u_t007_002/c2_r1_rbl u_t007_002/c3_w0_bl u_t007_002/c3_w0_br
+ u_t007_002/c3_w1_bl u_t007_002/c3_w1_br u_t007_002/c3_r0_rbl u_t007_002/c3_r1_rbl
+ u_t007_002/r0_w0_wl u_t007_002/r0_w1_wl u_t007_002/r0_r0_rwl u_t007_002/r0_r1_rwl
+ u_t007_002/r1_w0_wl u_t007_002/r1_w1_wl u_t007_002/r1_r0_rwl u_t007_002/r1_r1_rwl
+ u_t007_002/r2_w0_wl u_t007_002/r2_w1_wl u_t007_002/r2_r0_rwl u_t007_002/r2_r1_rwl
+ u_t007_002/r3_w0_wl u_t007_002/r3_w1_wl u_t007_002/r3_r0_rwl u_t007_002/r3_r1_rwl
+ VSS VSS u_t007_002/m2_717_1265# u_t007_002/m2_603_2031# u_t007_002/m2_1290_336#
+ u_t007_002/m2_2000_2037# u_t007_002/m2_791_2909# u_t007_002/m2_7_2126# u_t007_002/m2_2154_2081#
+ u_t007_002/m2_1795_2037# u_t007_002/m2_871_303# u_t007_002/m2_431_438# u_t007_002/m2_1290_2898#
+ u_t007_002/m2_1714_1210# u_t007_002/m2_431_1982# u_t007_002/m2_512_1265# u_t007_002/m2_2573_2126#
+ u_t007_002/m2_603_1259# u_t007_002/m2_2074_2909# u_t007_002/m2_7_336# u_t007_002/m2_717_2037#
+ u_t007_002/m2_1886_2031# u_t007_002/m2_2573_336# u_t007_002/m2_7_2898# u_t007_002/m2_2000_1265#
+ u_t007_002/m2_512_2037# u_t007_002/m2_1795_1265# u_t007_002/m2_1714_1982# u_t007_002/m2_1886_1259#
+ u_t007_002/m2_1290_2126# u_t007_002/m2_1714_438# u_t007_002/m2_431_1210# u_t007_002/m2_2573_2898#
+ u_t007_002/m2_2154_303# u_t007_002/m2_871_2081# VSUBS detronyx_12t_2w2r_rc4_4x4_routed_5layer_direct
Xu_t022_005 u_t022_005/c0_w0_bl u_t022_005/c0_w0_br u_t022_005/c0_w1_bl u_t022_005/c0_w1_br
+ u_t022_005/c0_r0_rbl u_t022_005/c0_r1_rbl u_t022_005/c1_w0_bl u_t022_005/c1_w0_br
+ u_t022_005/c1_w1_bl u_t022_005/c1_w1_br u_t022_005/c1_r0_rbl u_t022_005/c1_r1_rbl
+ u_t022_005/c2_w0_bl u_t022_005/c2_w0_br u_t022_005/c2_w1_bl u_t022_005/c2_w1_br
+ u_t022_005/c2_r0_rbl u_t022_005/c2_r1_rbl u_t022_005/c3_w0_bl u_t022_005/c3_w0_br
+ u_t022_005/c3_w1_bl u_t022_005/c3_w1_br u_t022_005/c3_r0_rbl u_t022_005/c3_r1_rbl
+ u_t022_005/r0_w0_wl u_t022_005/r0_w1_wl u_t022_005/r0_r0_rwl u_t022_005/r0_r1_rwl
+ u_t022_005/r1_w0_wl u_t022_005/r1_w1_wl u_t022_005/r1_r0_rwl u_t022_005/r1_r1_rwl
+ u_t022_005/r2_w0_wl u_t022_005/r2_w1_wl u_t022_005/r2_r0_rwl u_t022_005/r2_r1_rwl
+ u_t022_005/r3_w0_wl u_t022_005/r3_w1_wl u_t022_005/r3_r0_rwl u_t022_005/r3_r1_rwl
+ u_t022_005/VDD VSS u_t022_005/m2_717_1265# u_t022_005/m2_603_2031# u_t022_005/m2_1290_336#
+ u_t022_005/m2_2000_2037# u_t022_005/m2_791_2909# u_t022_005/m2_7_2126# u_t022_005/m2_2154_2081#
+ u_t022_005/m2_1795_2037# u_t022_005/m2_871_303# u_t022_005/m2_431_438# u_t022_005/m2_1290_2898#
+ u_t022_005/m2_1714_1210# u_t022_005/m2_431_1982# u_t022_005/m2_512_1265# u_t022_005/m2_2573_2126#
+ u_t022_005/m2_603_1259# u_t022_005/m2_2074_2909# u_t022_005/m2_7_336# u_t022_005/m2_717_2037#
+ u_t022_005/m2_1886_2031# u_t022_005/m2_2573_336# u_t022_005/m2_7_2898# u_t022_005/m2_2000_1265#
+ u_t022_005/m2_512_2037# u_t022_005/m2_1795_1265# u_t022_005/m2_1714_1982# u_t022_005/m2_1886_1259#
+ u_t022_005/m2_1290_2126# u_t022_005/m2_1714_438# u_t022_005/m2_431_1210# u_t022_005/m2_2573_2898#
+ u_t022_005/m2_2154_303# u_t022_005/m2_871_2081# VSUBS detronyx_12t_2w2r_rc4_4x4_routed_5layer_direct
Xgf180mcu_as_sc_mcu7t3v3__nand4_2_494 gf180mcu_as_sc_mcu7t3v3__inv_2_1614/VDD gf180mcu_as_sc_mcu7t3v3__inv_2_1618/VDD
+ VSS VSS VSS VSS VSS gf180mcu_as_sc_mcu7t3v3__inv_2_1614/VNW VSUBS gf180mcu_as_sc_mcu7t3v3__nand4_2
Xgf180mcu_as_sc_mcu7t3v3__nand4_2_483 gf180mcu_as_sc_mcu7t3v3__inv_2_1656/VDD gf180mcu_as_sc_mcu7t3v3__inv_2_1660/VDD
+ VSS VSS VSS VSS VSS gf180mcu_as_sc_mcu7t3v3__inv_2_1656/VNW VSUBS gf180mcu_as_sc_mcu7t3v3__nand4_2
Xgf180mcu_as_sc_mcu7t3v3__nand4_2_472 gf180mcu_as_sc_mcu7t3v3__inv_2_1394/VDD VSS
+ VSS VSS VSS VSS VSS gf180mcu_as_sc_mcu7t3v3__inv_2_1394/VNW VSUBS gf180mcu_as_sc_mcu7t3v3__nand4_2
Xgf180mcu_as_sc_mcu7t3v3__nand4_2_461 gf180mcu_as_sc_mcu7t3v3__inv_2_1349/VSS VSS
+ VSS VSS VSS VSS VSS gf180mcu_as_sc_mcu7t3v3__inv_2_1317/VNW VSUBS gf180mcu_as_sc_mcu7t3v3__nand4_2
Xgf180mcu_as_sc_mcu7t3v3__nand4_2_450 VSS gf180mcu_as_sc_mcu7t3v3__inv_2_1340/VDD
+ VSS VSS VSS VSS VSS gf180mcu_as_sc_mcu7t3v3__inv_2_1336/VNW VSUBS gf180mcu_as_sc_mcu7t3v3__nand4_2
Xu_t013_005 u_t013_005/c0_w0_bl u_t013_005/c0_w0_br u_t013_005/c0_w1_bl u_t013_005/c0_w1_br
+ u_t013_005/c0_r0_rbl u_t013_005/c0_r1_rbl u_t013_005/c1_w0_bl u_t013_005/c1_w0_br
+ u_t013_005/c1_w1_bl u_t013_005/c1_w1_br u_t013_005/c1_r0_rbl u_t013_005/c1_r1_rbl
+ u_t013_005/c2_w0_bl u_t013_005/c2_w0_br u_t013_005/c2_w1_bl u_t013_005/c2_w1_br
+ u_t013_005/c2_r0_rbl u_t013_005/c2_r1_rbl u_t013_005/c3_w0_bl u_t013_005/c3_w0_br
+ u_t013_005/c3_w1_bl u_t013_005/c3_w1_br u_t013_005/c3_r0_rbl u_t013_005/c3_r1_rbl
+ u_t013_005/r0_w0_wl u_t013_005/r0_w1_wl u_t013_005/r0_r0_rwl u_t013_005/r0_r1_rwl
+ u_t013_005/r1_w0_wl u_t013_005/r1_w1_wl u_t013_005/r1_r0_rwl u_t013_005/r1_r1_rwl
+ u_t013_005/r2_w0_wl u_t013_005/r2_w1_wl u_t013_005/r2_r0_rwl u_t013_005/r2_r1_rwl
+ u_t013_005/r3_w0_wl u_t013_005/r3_w1_wl u_t013_005/r3_r0_rwl u_t013_005/r3_r1_rwl
+ u_t013_005/VDD VSS u_t013_005/m2_717_1265# u_t013_005/m2_603_2031# u_t013_005/m2_1290_336#
+ u_t013_005/m2_2000_2037# u_t013_005/m2_791_2909# u_t013_005/m2_7_2126# u_t013_005/m2_2154_2081#
+ u_t013_005/m2_1795_2037# u_t013_005/m2_871_303# u_t013_005/m2_431_438# u_t013_005/m2_1290_2898#
+ u_t013_005/m2_1714_1210# u_t013_005/m2_431_1982# u_t013_005/m2_512_1265# u_t013_005/m2_2573_2126#
+ u_t013_005/m2_603_1259# u_t013_005/m2_2074_2909# u_t013_005/m2_7_336# u_t013_005/m2_717_2037#
+ u_t013_005/m2_1886_2031# u_t013_005/m2_2573_336# u_t013_005/m2_7_2898# u_t013_005/m2_2000_1265#
+ u_t013_005/m2_512_2037# u_t013_005/m2_1795_1265# u_t013_005/m2_1714_1982# u_t013_005/m2_1886_1259#
+ u_t013_005/m2_1290_2126# u_t013_005/m2_1714_438# u_t013_005/m2_431_1210# u_t013_005/m2_2573_2898#
+ u_t013_005/m2_2154_303# u_t013_005/m2_871_2081# VSUBS detronyx_12t_2w2r_rc4_4x4_routed_5layer_direct
Xgf180mcu_as_sc_mcu7t3v3__inv_2_403 gf180mcu_as_sc_mcu7t3v3__nor2_2_7/VDD gf180mcu_as_sc_mcu7t3v3__nand3_2_4/VSS
+ VSS VSS gf180mcu_as_sc_mcu7t3v3__nor2_2_7/VNW VSUBS gf180mcu_as_sc_mcu7t3v3__inv_2
Xgf180mcu_as_sc_mcu7t3v3__inv_2_425 gf180mcu_as_sc_mcu7t3v3__nor2_2_6/VDD gf180mcu_as_sc_mcu7t3v3__nand3_2_4/VSS
+ gf180mcu_as_sc_mcu7t3v3__inv_2_425/Y VSS gf180mcu_as_sc_mcu7t3v3__nor2_2_6/VNW VSUBS
+ gf180mcu_as_sc_mcu7t3v3__inv_2
Xgf180mcu_as_sc_mcu7t3v3__inv_2_414 gf180mcu_as_sc_mcu7t3v3__nor2_2_7/VDD gf180mcu_as_sc_mcu7t3v3__nor2_2_7/VSS
+ VSS VSS gf180mcu_as_sc_mcu7t3v3__nor2_2_7/VNW VSUBS gf180mcu_as_sc_mcu7t3v3__inv_2
Xgf180mcu_as_sc_mcu7t3v3__inv_2_436 gf180mcu_as_sc_mcu7t3v3__nor2_2_4/VDD gf180mcu_as_sc_mcu7t3v3__nand2_2_3/VSS
+ VSS VSS gf180mcu_as_sc_mcu7t3v3__nor2_2_4/VNW VSUBS gf180mcu_as_sc_mcu7t3v3__inv_2
Xu_t004_005 u_t004_005/c0_w0_bl u_t004_005/c0_w0_br u_t004_005/c0_w1_bl u_t004_005/c0_w1_br
+ u_t004_005/c0_r0_rbl u_t004_005/c0_r1_rbl u_t004_005/c1_w0_bl u_t004_005/c1_w0_br
+ u_t004_005/c1_w1_bl u_t004_005/c1_w1_br u_t004_005/c1_r0_rbl u_t004_005/c1_r1_rbl
+ u_t004_005/c2_w0_bl u_t004_005/c2_w0_br u_t004_005/c2_w1_bl u_t004_005/c2_w1_br
+ u_t004_005/c2_r0_rbl u_t004_005/c2_r1_rbl u_t004_005/c3_w0_bl u_t004_005/c3_w0_br
+ u_t004_005/c3_w1_bl u_t004_005/c3_w1_br u_t004_005/c3_r0_rbl u_t004_005/c3_r1_rbl
+ u_t004_005/r0_w0_wl u_t004_005/r0_w1_wl u_t004_005/r0_r0_rwl u_t004_005/r0_r1_rwl
+ u_t004_005/r1_w0_wl u_t004_005/r1_w1_wl u_t004_005/r1_r0_rwl u_t004_005/r1_r1_rwl
+ u_t004_005/r2_w0_wl u_t004_005/r2_w1_wl u_t004_005/r2_r0_rwl u_t004_005/r2_r1_rwl
+ u_t004_005/r3_w0_wl u_t004_005/r3_w1_wl u_t004_005/r3_r0_rwl u_t004_005/r3_r1_rwl
+ u_t004_005/VDD VSS u_t004_005/m2_717_1265# u_t004_005/m2_603_2031# u_t004_005/m2_1290_336#
+ u_t004_005/m2_2000_2037# u_t004_005/m2_791_2909# u_t004_005/m2_7_2126# u_t004_005/m2_2154_2081#
+ u_t004_005/m2_1795_2037# u_t004_005/m2_871_303# u_t004_005/m2_431_438# u_t004_005/m2_1290_2898#
+ u_t004_005/m2_1714_1210# u_t004_005/m2_431_1982# u_t004_005/m2_512_1265# u_t004_005/m2_2573_2126#
+ u_t004_005/m2_603_1259# u_t004_005/m2_2074_2909# u_t004_005/m2_7_336# u_t004_005/m2_717_2037#
+ u_t004_005/m2_1886_2031# u_t004_005/m2_2573_336# u_t004_005/m2_7_2898# u_t004_005/m2_2000_1265#
+ u_t004_005/m2_512_2037# u_t004_005/m2_1795_1265# u_t004_005/m2_1714_1982# u_t004_005/m2_1886_1259#
+ u_t004_005/m2_1290_2126# u_t004_005/m2_1714_438# u_t004_005/m2_431_1210# u_t004_005/m2_2573_2898#
+ u_t004_005/m2_2154_303# u_t004_005/m2_871_2081# VSUBS detronyx_12t_2w2r_rc4_4x4_routed_5layer_direct
Xgf180mcu_as_sc_mcu7t3v3__inv_2_458 gf180mcu_as_sc_mcu7t3v3__nor2_2_7/VDD gf180mcu_as_sc_mcu7t3v3__nor2_2_7/VSS
+ VSS VSS gf180mcu_as_sc_mcu7t3v3__nor2_2_7/VNW VSUBS gf180mcu_as_sc_mcu7t3v3__inv_2
Xgf180mcu_as_sc_mcu7t3v3__inv_2_469 gf180mcu_as_sc_mcu7t3v3__nand3_2_9/VDD gf180mcu_as_sc_mcu7t3v3__nor2_2_4/VSS
+ VSS VSS gf180mcu_as_sc_mcu7t3v3__nand3_2_9/VNW VSUBS gf180mcu_as_sc_mcu7t3v3__inv_2
Xgf180mcu_as_sc_mcu7t3v3__inv_2_447 gf180mcu_as_sc_mcu7t3v3__nor2_2_7/VDD gf180mcu_as_sc_mcu7t3v3__nor2_2_7/VSS
+ VSS VSS gf180mcu_as_sc_mcu7t3v3__nor2_2_7/VNW VSUBS gf180mcu_as_sc_mcu7t3v3__inv_2
Xgf180mcu_as_sc_mcu7t3v3__inv_2_981 gf180mcu_as_sc_mcu7t3v3__inv_2_985/VDD VSS gf180mcu_as_sc_mcu7t3v3__inv_2_981/Y
+ gf180mcu_as_sc_mcu7t3v3__inv_2_985/Y gf180mcu_as_sc_mcu7t3v3__inv_2_985/VNW VSUBS
+ gf180mcu_as_sc_mcu7t3v3__inv_2
Xgf180mcu_as_sc_mcu7t3v3__inv_2_970 VSS gf180mcu_as_sc_mcu7t3v3__inv_2_985/VDD VSS
+ gf180mcu_as_sc_mcu7t3v3__inv_2_977/A gf180mcu_as_sc_mcu7t3v3__inv_2_972/VNW VSUBS
+ gf180mcu_as_sc_mcu7t3v3__inv_2
Xu_t010_008 u_t010_008/c0_w0_bl u_t010_008/c0_w0_br u_t010_008/c0_w1_bl u_t010_008/c0_w1_br
+ u_t010_008/c0_r0_rbl u_t010_008/c0_r1_rbl u_t010_008/c1_w0_bl u_t010_008/c1_w0_br
+ u_t010_008/c1_w1_bl u_t010_008/c1_w1_br u_t010_008/c1_r0_rbl u_t010_008/c1_r1_rbl
+ u_t010_008/c2_w0_bl u_t010_008/c2_w0_br u_t010_008/c2_w1_bl u_t010_008/c2_w1_br
+ u_t010_008/c2_r0_rbl u_t010_008/c2_r1_rbl u_t010_008/c3_w0_bl u_t010_008/c3_w0_br
+ u_t010_008/c3_w1_bl u_t010_008/c3_w1_br u_t010_008/c3_r0_rbl u_t010_008/c3_r1_rbl
+ u_t010_008/r0_w0_wl u_t010_008/r0_w1_wl u_t010_008/r0_r0_rwl u_t010_008/r0_r1_rwl
+ u_t010_008/r1_w0_wl u_t010_008/r1_w1_wl u_t010_008/r1_r0_rwl u_t010_008/r1_r1_rwl
+ u_t010_008/r2_w0_wl u_t010_008/r2_w1_wl u_t010_008/r2_r0_rwl u_t010_008/r2_r1_rwl
+ u_t010_008/r3_w0_wl u_t010_008/r3_w1_wl u_t010_008/r3_r0_rwl u_t010_008/r3_r1_rwl
+ VSS u_t010_009/VSS u_t010_008/m2_717_1265# u_t010_008/m2_603_2031# u_t010_008/m2_1290_336#
+ u_t010_008/m2_2000_2037# u_t010_008/m2_791_2909# u_t010_008/m2_7_2126# u_t010_008/m2_2154_2081#
+ u_t010_008/m2_1795_2037# u_t010_008/m2_871_303# u_t010_008/m2_431_438# u_t010_008/m2_1290_2898#
+ u_t010_008/m2_1714_1210# u_t010_008/m2_431_1982# u_t010_008/m2_512_1265# u_t010_008/m2_2573_2126#
+ u_t010_008/m2_603_1259# u_t010_008/m2_2074_2909# u_t010_008/m2_7_336# u_t010_008/m2_717_2037#
+ u_t010_008/m2_1886_2031# u_t010_008/m2_2573_336# u_t010_008/m2_7_2898# u_t010_008/m2_2000_1265#
+ u_t010_008/m2_512_2037# u_t010_008/m2_1795_1265# u_t010_008/m2_1714_1982# u_t010_008/m2_1886_1259#
+ u_t010_008/m2_1290_2126# u_t010_008/m2_1714_438# u_t010_008/m2_431_1210# u_t010_008/m2_2573_2898#
+ u_t010_008/m2_2154_303# u_t010_008/m2_871_2081# VSUBS detronyx_12t_2w2r_rc4_4x4_routed_5layer_direct
Xgf180mcu_as_sc_mcu7t3v3__inv_2_992 VSS gf180mcu_as_sc_mcu7t3v3__inv_2_996/VDD gf180mcu_as_sc_mcu7t3v3__inv_2_992/Y
+ VSS gf180mcu_as_sc_mcu7t3v3__inv_2_992/VNW VSUBS gf180mcu_as_sc_mcu7t3v3__inv_2
Xgf180mcu_as_sc_mcu7t3v3__nand4_2_280 VSS VSS VSS VSS VSS VSS gf180mcu_as_sc_mcu7t3v3__nand4_2_280/Y
+ gf180mcu_as_sc_mcu7t3v3__inv_2_947/VNW VSUBS gf180mcu_as_sc_mcu7t3v3__nand4_2
Xgf180mcu_as_sc_mcu7t3v3__nand4_2_291 gf180mcu_as_sc_mcu7t3v3__inv_2_988/VDD VSS VSS
+ VSS VSS VSS VSS gf180mcu_as_sc_mcu7t3v3__inv_2_988/VNW VSUBS gf180mcu_as_sc_mcu7t3v3__nand4_2
Xu_t001_008 u_t001_008/c0_w0_bl u_t001_008/c0_w0_br u_t001_008/c0_w1_bl u_t001_008/c0_w1_br
+ u_t001_008/c0_r0_rbl u_t001_008/c0_r1_rbl u_t001_008/c1_w0_bl u_t001_008/c1_w0_br
+ u_t001_008/c1_w1_bl u_t001_008/c1_w1_br u_t001_008/c1_r0_rbl u_t001_008/c1_r1_rbl
+ u_t001_008/c2_w0_bl u_t001_008/c2_w0_br u_t001_008/c2_w1_bl u_t001_008/c2_w1_br
+ u_t001_008/c2_r0_rbl u_t001_008/c2_r1_rbl u_t001_008/c3_w0_bl u_t001_008/c3_w0_br
+ u_t001_008/c3_w1_bl u_t001_008/c3_w1_br u_t001_008/c3_r0_rbl u_t001_008/c3_r1_rbl
+ u_t001_008/r0_w0_wl u_t001_008/r0_w1_wl u_t001_008/r0_r0_rwl u_t001_008/r0_r1_rwl
+ u_t001_008/r1_w0_wl u_t001_008/r1_w1_wl u_t001_008/r1_r0_rwl u_t001_008/r1_r1_rwl
+ u_t001_008/r2_w0_wl u_t001_008/r2_w1_wl u_t001_008/r2_r0_rwl u_t001_008/r2_r1_rwl
+ u_t001_008/r3_w0_wl u_t001_008/r3_w1_wl u_t001_008/r3_r0_rwl u_t001_008/r3_r1_rwl
+ VSS VSS u_t001_008/m2_717_1265# u_t001_008/m2_603_2031# u_t001_008/m2_1290_336#
+ u_t001_008/m2_2000_2037# u_t001_008/m2_791_2909# u_t001_008/m2_7_2126# u_t001_008/m2_2154_2081#
+ u_t001_008/m2_1795_2037# u_t001_008/m2_871_303# u_t001_008/m2_431_438# u_t001_008/m2_1290_2898#
+ u_t001_008/m2_1714_1210# u_t001_008/m2_431_1982# u_t001_008/m2_512_1265# u_t001_008/m2_2573_2126#
+ u_t001_008/m2_603_1259# u_t001_008/m2_2074_2909# u_t001_008/m2_7_336# u_t001_008/m2_717_2037#
+ u_t001_008/m2_1886_2031# u_t001_008/m2_2573_336# u_t001_008/m2_7_2898# u_t001_008/m2_2000_1265#
+ u_t001_008/m2_512_2037# u_t001_008/m2_1795_1265# u_t001_008/m2_1714_1982# u_t001_008/m2_1886_1259#
+ u_t001_008/m2_1290_2126# u_t001_008/m2_1714_438# u_t001_008/m2_431_1210# u_t001_008/m2_2573_2898#
+ u_t001_008/m2_2154_303# u_t001_008/m2_871_2081# VSUBS detronyx_12t_2w2r_rc4_4x4_routed_5layer_direct
Xgf180mcu_as_sc_mcu7t3v3__inv_2_277 gf180mcu_as_sc_mcu7t3v3__inv_2_281/VDD VSS gf180mcu_as_sc_mcu7t3v3__inv_2_277/Y
+ gf180mcu_as_sc_mcu7t3v3__inv_2_61/Y gf180mcu_as_sc_mcu7t3v3__inv_2_281/VNW VSUBS
+ gf180mcu_as_sc_mcu7t3v3__inv_2
Xgf180mcu_as_sc_mcu7t3v3__inv_2_266 VSS gf180mcu_as_sc_mcu7t3v3__inv_2_281/VDD VSS
+ gf180mcu_as_sc_mcu7t3v3__inv_2_61/Y gf180mcu_as_sc_mcu7t3v3__inv_2_268/VNW VSUBS
+ gf180mcu_as_sc_mcu7t3v3__inv_2
Xgf180mcu_as_sc_mcu7t3v3__inv_2_200 VSS VSS VSS VSS gf180mcu_as_sc_mcu7t3v3__inv_2_200/VNW
+ VSUBS gf180mcu_as_sc_mcu7t3v3__inv_2
Xgf180mcu_as_sc_mcu7t3v3__inv_2_222 VSS VSS gf180mcu_as_sc_mcu7t3v3__inv_2_222/Y VSS
+ gf180mcu_as_sc_mcu7t3v3__inv_2_224/VNW VSUBS gf180mcu_as_sc_mcu7t3v3__inv_2
Xgf180mcu_as_sc_mcu7t3v3__inv_2_211 VSS VSS VSS VSS gf180mcu_as_sc_mcu7t3v3__inv_2_212/VNW
+ VSUBS gf180mcu_as_sc_mcu7t3v3__inv_2
Xgf180mcu_as_sc_mcu7t3v3__inv_2_255 gf180mcu_as_sc_mcu7t3v3__inv_2_257/VDD gf180mcu_as_sc_mcu7t3v3__inv_2_257/VSS
+ gf180mcu_as_sc_mcu7t3v3__inv_2_255/Y VSS gf180mcu_as_sc_mcu7t3v3__inv_2_257/VNW
+ VSUBS gf180mcu_as_sc_mcu7t3v3__inv_2
Xgf180mcu_as_sc_mcu7t3v3__inv_2_244 VSS gf180mcu_as_sc_mcu7t3v3__inv_2_248/VDD gf180mcu_as_sc_mcu7t3v3__inv_2_244/Y
+ VSS gf180mcu_as_sc_mcu7t3v3__inv_2_245/VNW VSUBS gf180mcu_as_sc_mcu7t3v3__inv_2
Xgf180mcu_as_sc_mcu7t3v3__inv_2_233 VSS VSS VSS VSS gf180mcu_as_sc_mcu7t3v3__inv_2_233/VNW
+ VSUBS gf180mcu_as_sc_mcu7t3v3__inv_2
Xgf180mcu_as_sc_mcu7t3v3__inv_2_299 gf180mcu_as_sc_mcu7t3v3__inv_2_304/VDD gf180mcu_as_sc_mcu7t3v3__inv_2_304/VSS
+ VSS gf180mcu_as_sc_mcu7t3v3__inv_2_304/A gf180mcu_as_sc_mcu7t3v3__inv_2_304/VNW
+ VSUBS gf180mcu_as_sc_mcu7t3v3__inv_2
Xgf180mcu_as_sc_mcu7t3v3__inv_2_288 VSS gf180mcu_as_sc_mcu7t3v3__inv_2_304/VDD gf180mcu_as_sc_mcu7t3v3__inv_2_304/A
+ VSS gf180mcu_as_sc_mcu7t3v3__inv_2_288/VNW VSUBS gf180mcu_as_sc_mcu7t3v3__inv_2
Xgf180mcu_as_sc_mcu7t3v3__inv_2_1518 gf180mcu_as_sc_mcu7t3v3__inv_2_1562/VSS VSS gf180mcu_as_sc_mcu7t3v3__inv_2_1518/Y
+ VSS gf180mcu_as_sc_mcu7t3v3__inv_2_1519/VNW VSUBS gf180mcu_as_sc_mcu7t3v3__inv_2
Xgf180mcu_as_sc_mcu7t3v3__inv_2_1529 VSS gf180mcu_as_sc_mcu7t3v3__inv_2_1532/VDD gf180mcu_as_sc_mcu7t3v3__inv_2_1529/Y
+ VSS gf180mcu_as_sc_mcu7t3v3__inv_2_1529/VNW VSUBS gf180mcu_as_sc_mcu7t3v3__inv_2
Xgf180mcu_as_sc_mcu7t3v3__inv_2_1507 gf180mcu_as_sc_mcu7t3v3__inv_2_1508/VDD gf180mcu_as_sc_mcu7t3v3__inv_2_1508/VSS
+ VSS VSS gf180mcu_as_sc_mcu7t3v3__inv_2_1508/VNW VSUBS gf180mcu_as_sc_mcu7t3v3__inv_2
Xgf180mcu_as_sc_mcu7t3v3__nor2_2_1 gf180mcu_as_sc_mcu7t3v3__nor2_2_6/VDD gf180mcu_as_sc_mcu7t3v3__nor2_2_6/VSS
+ VSS VSS VSS gf180mcu_as_sc_mcu7t3v3__nor2_2_6/VNW VSUBS gf180mcu_as_sc_mcu7t3v3__nor2_2
Xgf180mcu_as_sc_mcu7t3v3__nand2_2_6 gf180mcu_as_sc_mcu7t3v3__nand3_2_9/VDD gf180mcu_as_sc_mcu7t3v3__nor2_2_7/VSS
+ VSS VSS VSS gf180mcu_as_sc_mcu7t3v3__nand3_2_9/VNW VSUBS gf180mcu_as_sc_mcu7t3v3__nand2_2
Xgf180mcu_as_sc_mcu7t3v3__inv_2_1304 VSS VSS VSS VSS gf180mcu_as_sc_mcu7t3v3__inv_2_1304/VNW
+ VSUBS gf180mcu_as_sc_mcu7t3v3__inv_2
Xgf180mcu_as_sc_mcu7t3v3__inv_2_1315 gf180mcu_as_sc_mcu7t3v3__inv_2_1316/VDD gf180mcu_as_sc_mcu7t3v3__inv_2_1320/VDD
+ gf180mcu_as_sc_mcu7t3v3__inv_2_1315/Y gf180mcu_as_sc_mcu7t3v3__inv_2_1355/Y gf180mcu_as_sc_mcu7t3v3__inv_2_1316/VNW
+ VSUBS gf180mcu_as_sc_mcu7t3v3__inv_2
Xgf180mcu_as_sc_mcu7t3v3__inv_2_1326 gf180mcu_as_sc_mcu7t3v3__inv_2_1409/VSS VSS VSS
+ gf180mcu_as_sc_mcu7t3v3__inv_2_1409/A gf180mcu_as_sc_mcu7t3v3__inv_2_1328/VNW VSUBS
+ gf180mcu_as_sc_mcu7t3v3__inv_2
Xgf180mcu_as_sc_mcu7t3v3__inv_2_1359 gf180mcu_as_sc_mcu7t3v3__inv_2_1406/VSS VSS gf180mcu_as_sc_mcu7t3v3__inv_2_1409/A
+ VSS gf180mcu_as_sc_mcu7t3v3__inv_2_1395/VNW VSUBS gf180mcu_as_sc_mcu7t3v3__inv_2
Xgf180mcu_as_sc_mcu7t3v3__inv_2_1337 VSS VSS VSS gf180mcu_as_sc_mcu7t3v3__inv_2_1717/Y
+ gf180mcu_as_sc_mcu7t3v3__inv_2_1353/VNW VSUBS gf180mcu_as_sc_mcu7t3v3__inv_2
Xgf180mcu_as_sc_mcu7t3v3__inv_2_1348 VSS gf180mcu_as_sc_mcu7t3v3__inv_2_1352/VDD gf180mcu_as_sc_mcu7t3v3__inv_2_1355/Y
+ VSS gf180mcu_as_sc_mcu7t3v3__inv_2_1348/VNW VSUBS gf180mcu_as_sc_mcu7t3v3__inv_2
Xu_t028_011 u_t028_011/c0_w0_bl u_t028_011/c0_w0_br u_t028_011/c0_w1_bl u_t028_011/c0_w1_br
+ u_t028_011/c0_r0_rbl u_t028_011/c0_r1_rbl u_t028_011/c1_w0_bl u_t028_011/c1_w0_br
+ u_t028_011/c1_w1_bl u_t028_011/c1_w1_br u_t028_011/c1_r0_rbl u_t028_011/c1_r1_rbl
+ u_t028_011/c2_w0_bl u_t028_011/c2_w0_br u_t028_011/c2_w1_bl u_t028_011/c2_w1_br
+ u_t028_011/c2_r0_rbl u_t028_011/c2_r1_rbl u_t028_011/c3_w0_bl u_t028_011/c3_w0_br
+ u_t028_011/c3_w1_bl u_t028_011/c3_w1_br u_t028_011/c3_r0_rbl u_t028_011/c3_r1_rbl
+ u_t028_011/r0_w0_wl u_t028_011/r0_w1_wl u_t028_011/r0_r0_rwl u_t028_011/r0_r1_rwl
+ u_t028_011/r1_w0_wl u_t028_011/r1_w1_wl u_t028_011/r1_r0_rwl u_t028_011/r1_r1_rwl
+ u_t028_011/r2_w0_wl u_t028_011/r2_w1_wl u_t028_011/r2_r0_rwl u_t028_011/r2_r1_rwl
+ u_t028_011/r3_w0_wl u_t028_011/r3_w1_wl u_t028_011/r3_r0_rwl u_t028_011/r3_r1_rwl
+ u_t029_011/VDD u_t028_011/VSS u_t028_011/m2_717_1265# u_t028_011/m2_603_2031# u_t028_011/m2_1290_336#
+ u_t028_011/m2_2000_2037# u_t028_011/m2_791_2909# u_t028_011/m2_7_2126# u_t028_011/m2_2154_2081#
+ u_t028_011/m2_1795_2037# u_t028_011/m2_871_303# u_t028_011/m2_431_438# u_t028_011/m2_1290_2898#
+ u_t028_011/m2_1714_1210# u_t028_011/m2_431_1982# u_t028_011/m2_512_1265# u_t028_011/m2_2573_2126#
+ u_t028_011/m2_603_1259# u_t028_011/m2_2074_2909# u_t028_011/m2_7_336# u_t028_011/m2_717_2037#
+ u_t028_011/m2_1886_2031# u_t028_011/m2_2573_336# u_t028_011/m2_7_2898# u_t028_011/m2_2000_1265#
+ u_t028_011/m2_512_2037# u_t028_011/m2_1795_1265# u_t028_011/m2_1714_1982# u_t028_011/m2_1886_1259#
+ u_t028_011/m2_1290_2126# u_t028_011/m2_1714_438# u_t028_011/m2_431_1210# u_t028_011/m2_2573_2898#
+ u_t028_011/m2_2154_303# u_t028_011/m2_871_2081# VSUBS detronyx_12t_2w2r_rc4_4x4_routed_5layer_direct
Xu_t028_000 VSS u_t028_000/c0_w0_br VSS u_t028_000/c0_w1_br u_t028_000/c0_r0_rbl u_t028_000/c0_r1_rbl
+ VSS VSS VSS VSS VSS VSS u_t028_000/c2_w0_bl u_t028_000/c2_w0_br u_t028_000/c2_w1_bl
+ u_t028_000/c2_w1_br u_t028_000/c2_r0_rbl u_t028_000/c2_r1_rbl u_t028_000/c3_w0_bl
+ u_t028_000/c3_w0_br u_t028_000/c3_w1_bl u_t028_000/c3_w1_br u_t028_000/c3_r0_rbl
+ u_t028_000/c3_r1_rbl VSS VSS VSS VSS VSS VSS VSS VSS VSS VSS VSS VSS VSS VSS VSS
+ VSS VSS VSS u_t028_000/m2_717_1265# VSS VSS VSS VSS u_t028_000/m2_7_2126# VSS VSS
+ VSS VSS VSS VSS VSS u_t028_000/m2_512_1265# VSS u_t028_000/m2_603_1259# VSS VSS
+ VSS VSS VSS VSS u_t028_000/m2_2000_1265# VSS u_t028_000/m2_1795_1265# VSS u_t028_000/m2_1886_1259#
+ u_t028_000/m2_1290_2126# VSS VSS VSS VSS VSS VSUBS detronyx_12t_2w2r_rc4_4x4_routed_5layer_direct
Xgf180mcu_as_sc_mcu7t3v3__nand4_2_109 gf180mcu_as_sc_mcu7t3v3__inv_2_281/VDD VSS VSS
+ VSS VSS VSS VSS gf180mcu_as_sc_mcu7t3v3__inv_2_281/VNW VSUBS gf180mcu_as_sc_mcu7t3v3__nand4_2
Xu_t019_011 u_t019_011/c0_w0_bl u_t019_011/c0_w0_br u_t019_011/c0_w1_bl u_t019_011/c0_w1_br
+ u_t019_011/c0_r0_rbl u_t019_011/c0_r1_rbl u_t019_011/c1_w0_bl u_t019_011/c1_w0_br
+ u_t019_011/c1_w1_bl u_t019_011/c1_w1_br u_t019_011/c1_r0_rbl u_t019_011/c1_r1_rbl
+ u_t019_011/c2_w0_bl u_t019_011/c2_w0_br u_t019_011/c2_w1_bl u_t019_011/c2_w1_br
+ u_t019_011/c2_r0_rbl u_t019_011/c2_r1_rbl u_t019_011/c3_w0_bl u_t019_011/c3_w0_br
+ u_t019_011/c3_w1_bl u_t019_011/c3_w1_br u_t019_011/c3_r0_rbl u_t019_011/c3_r1_rbl
+ u_t019_011/r0_w0_wl u_t019_011/r0_w1_wl u_t019_011/r0_r0_rwl u_t019_011/r0_r1_rwl
+ u_t019_011/r1_w0_wl u_t019_011/r1_w1_wl u_t019_011/r1_r0_rwl u_t019_011/r1_r1_rwl
+ u_t019_011/r2_w0_wl u_t019_011/r2_w1_wl u_t019_011/r2_r0_rwl u_t019_011/r2_r1_rwl
+ u_t019_011/r3_w0_wl u_t019_011/r3_w1_wl u_t019_011/r3_r0_rwl u_t019_011/r3_r1_rwl
+ u_t019_011/VDD u_t019_011/VSS u_t019_011/m2_717_1265# u_t019_011/m2_603_2031# u_t019_011/m2_1290_336#
+ u_t019_011/m2_2000_2037# u_t019_011/m2_791_2909# u_t019_011/m2_7_2126# u_t019_011/m2_2154_2081#
+ u_t019_011/m2_1795_2037# u_t019_011/m2_871_303# u_t019_011/m2_431_438# u_t019_011/m2_1290_2898#
+ u_t019_011/m2_1714_1210# u_t019_011/m2_431_1982# u_t019_011/m2_512_1265# u_t019_011/m2_2573_2126#
+ u_t019_011/m2_603_1259# u_t019_011/m2_2074_2909# u_t019_011/m2_7_336# u_t019_011/m2_717_2037#
+ u_t019_011/m2_1886_2031# u_t019_011/m2_2573_336# u_t019_011/m2_7_2898# u_t019_011/m2_2000_1265#
+ u_t019_011/m2_512_2037# u_t019_011/m2_1795_1265# u_t019_011/m2_1714_1982# u_t019_011/m2_1886_1259#
+ u_t019_011/m2_1290_2126# u_t019_011/m2_1714_438# u_t019_011/m2_431_1210# u_t019_011/m2_2573_2898#
+ u_t019_011/m2_2154_303# u_t019_011/m2_871_2081# VSUBS detronyx_12t_2w2r_rc4_4x4_routed_5layer_direct
Xgf180mcu_as_sc_mcu7t3v3__nand4_2_15 gf180mcu_as_sc_mcu7t3v3__inv_2_125/VDD gf180mcu_as_sc_mcu7t3v3__inv_2_131/VDD
+ VSS VSS VSS VSS gf180mcu_as_sc_mcu7t3v3__nand4_2_15/Y gf180mcu_as_sc_mcu7t3v3__inv_2_125/VNW
+ VSUBS gf180mcu_as_sc_mcu7t3v3__nand4_2
Xgf180mcu_as_sc_mcu7t3v3__nand4_2_37 gf180mcu_as_sc_mcu7t3v3__inv_2_193/VDD VSS VSS
+ VSS VSS VSS gf180mcu_as_sc_mcu7t3v3__nand4_2_37/Y gf180mcu_as_sc_mcu7t3v3__inv_2_193/VNW
+ VSUBS gf180mcu_as_sc_mcu7t3v3__nand4_2
Xgf180mcu_as_sc_mcu7t3v3__nand4_2_26 gf180mcu_as_sc_mcu7t3v3__inv_2_177/VDD gf180mcu_as_sc_mcu7t3v3__inv_2_177/VSS
+ VSS VSS VSS VSS VSS gf180mcu_as_sc_mcu7t3v3__inv_2_177/VNW VSUBS gf180mcu_as_sc_mcu7t3v3__nand4_2
Xgf180mcu_as_sc_mcu7t3v3__nand4_2_48 VSS VSS VSS VSS VSS VSS gf180mcu_as_sc_mcu7t3v3__nand4_2_48/Y
+ gf180mcu_as_sc_mcu7t3v3__inv_2_224/VNW VSUBS gf180mcu_as_sc_mcu7t3v3__nand4_2
Xgf180mcu_as_sc_mcu7t3v3__nand4_2_59 gf180mcu_as_sc_mcu7t3v3__inv_2_257/VDD gf180mcu_as_sc_mcu7t3v3__inv_2_257/VSS
+ VSS VSS VSS VSS gf180mcu_as_sc_mcu7t3v3__nand4_2_59/Y gf180mcu_as_sc_mcu7t3v3__inv_2_257/VNW
+ VSUBS gf180mcu_as_sc_mcu7t3v3__nand4_2
Xu_t019_000 VSS u_t019_000/c0_w0_br VSS u_t019_000/c0_w1_br u_t019_000/c0_r0_rbl u_t019_000/c0_r1_rbl
+ VSS VSS VSS VSS VSS VSS u_t019_000/c2_w0_bl u_t019_000/c2_w0_br u_t019_000/c2_w1_bl
+ u_t019_000/c2_w1_br u_t019_000/c2_r0_rbl u_t019_000/c2_r1_rbl u_t019_000/c3_w0_bl
+ u_t019_000/c3_w0_br u_t019_000/c3_w1_bl u_t019_000/c3_w1_br u_t019_000/c3_r0_rbl
+ u_t019_000/c3_r1_rbl VSS VSS VSS VSS VSS VSS VSS VSS VSS VSS VSS VSS VSS VSS VSS
+ VSS VSS VSS VSS VSS VSS VSS VSS VSS VSS VSS VSS VSS VSS VSS VSS VSS u_t019_000/m2_2573_2126#
+ VSS VSS VSS VSS VSS u_t019_000/m2_2573_336# VSS VSS VSS VSS u_t019_000/m2_1714_1982#
+ VSS VSS u_t019_000/m2_1714_438# VSS u_t019_000/m2_2573_2898# VSS VSS VSUBS detronyx_12t_2w2r_rc4_4x4_routed_5layer_direct
Xu_t025_014 u_t025_014/c0_w0_bl u_t025_014/c0_w0_br u_t025_014/c0_w1_bl u_t025_014/c0_w1_br
+ u_t025_014/c0_r0_rbl u_t025_014/c0_r1_rbl u_t025_014/c1_w0_bl u_t025_014/c1_w0_br
+ u_t025_014/c1_w1_bl u_t025_014/c1_w1_br u_t025_014/c1_r0_rbl u_t025_014/c1_r1_rbl
+ u_t025_014/c2_w0_bl u_t025_014/c2_w0_br u_t025_014/c2_w1_bl u_t025_014/c2_w1_br
+ u_t025_014/c2_r0_rbl u_t025_014/c2_r1_rbl u_t025_014/c3_w0_bl u_t025_014/c3_w0_br
+ u_t025_014/c3_w1_bl u_t025_014/c3_w1_br u_t025_014/c3_r0_rbl u_t025_014/c3_r1_rbl
+ u_t025_014/r0_w0_wl u_t025_014/r0_w1_wl u_t025_014/r0_r0_rwl u_t025_014/r0_r1_rwl
+ u_t025_014/r1_w0_wl u_t025_014/r1_w1_wl u_t025_014/r1_r0_rwl u_t025_014/r1_r1_rwl
+ u_t025_014/r2_w0_wl u_t025_014/r2_w1_wl u_t025_014/r2_r0_rwl u_t025_014/r2_r1_rwl
+ u_t025_014/r3_w0_wl u_t025_014/r3_w1_wl u_t025_014/r3_r0_rwl u_t025_014/r3_r1_rwl
+ u_t025_014/VDD VSS u_t025_014/m2_717_1265# u_t025_014/m2_603_2031# u_t025_014/m2_1290_336#
+ u_t025_014/m2_2000_2037# u_t025_014/m2_791_2909# u_t025_014/m2_7_2126# u_t025_014/m2_2154_2081#
+ u_t025_014/m2_1795_2037# u_t025_014/m2_871_303# u_t025_014/m2_431_438# u_t025_014/m2_1290_2898#
+ u_t025_014/m2_1714_1210# u_t025_014/m2_431_1982# u_t025_014/m2_512_1265# u_t025_014/m2_2573_2126#
+ u_t025_014/m2_603_1259# u_t025_014/m2_2074_2909# u_t025_014/m2_7_336# u_t025_014/m2_717_2037#
+ u_t025_014/m2_1886_2031# u_t025_014/m2_2573_336# u_t025_014/m2_7_2898# u_t025_014/m2_2000_1265#
+ u_t025_014/m2_512_2037# u_t025_014/m2_1795_1265# u_t025_014/m2_1714_1982# u_t025_014/m2_1886_1259#
+ u_t025_014/m2_1290_2126# u_t025_014/m2_1714_438# u_t025_014/m2_431_1210# u_t025_014/m2_2573_2898#
+ u_t025_014/m2_2154_303# u_t025_014/m2_871_2081# VSUBS detronyx_12t_2w2r_rc4_4x4_routed_5layer_direct
Xu_t025_003 u_t025_003/c0_w0_bl u_t025_003/c0_w0_br u_t025_003/c0_w1_bl u_t025_003/c0_w1_br
+ u_t025_003/c0_r0_rbl u_t025_003/c0_r1_rbl u_t025_003/c1_w0_bl u_t025_003/c1_w0_br
+ u_t025_003/c1_w1_bl u_t025_003/c1_w1_br u_t025_003/c1_r0_rbl u_t025_003/c1_r1_rbl
+ u_t025_003/c2_w0_bl u_t025_003/c2_w0_br u_t025_003/c2_w1_bl u_t025_003/c2_w1_br
+ u_t025_003/c2_r0_rbl u_t025_003/c2_r1_rbl u_t025_003/c3_w0_bl u_t025_003/c3_w0_br
+ u_t025_003/c3_w1_bl u_t025_003/c3_w1_br u_t025_003/c3_r0_rbl u_t025_003/c3_r1_rbl
+ u_t025_003/r0_w0_wl u_t025_003/r0_w1_wl u_t025_003/r0_r0_rwl u_t025_003/r0_r1_rwl
+ u_t025_003/r1_w0_wl u_t025_003/r1_w1_wl u_t025_003/r1_r0_rwl u_t025_003/r1_r1_rwl
+ u_t025_003/r2_w0_wl u_t025_003/r2_w1_wl u_t025_003/r2_r0_rwl u_t025_003/r2_r1_rwl
+ u_t025_003/r3_w0_wl u_t025_003/r3_w1_wl u_t025_003/r3_r0_rwl u_t025_003/r3_r1_rwl
+ u_t025_003/VDD VSS u_t025_003/m2_717_1265# u_t025_003/m2_603_2031# u_t025_003/m2_1290_336#
+ u_t025_003/m2_2000_2037# u_t025_003/m2_791_2909# u_t025_003/m2_7_2126# u_t025_003/m2_2154_2081#
+ u_t025_003/m2_1795_2037# u_t025_003/m2_871_303# u_t025_003/m2_431_438# u_t025_003/m2_1290_2898#
+ u_t025_003/m2_1714_1210# u_t025_003/m2_431_1982# u_t025_003/m2_512_1265# u_t025_003/m2_2573_2126#
+ u_t025_003/m2_603_1259# u_t025_003/m2_2074_2909# u_t025_003/m2_7_336# u_t025_003/m2_717_2037#
+ u_t025_003/m2_1886_2031# u_t025_003/m2_2573_336# u_t025_003/m2_7_2898# u_t025_003/m2_2000_1265#
+ u_t025_003/m2_512_2037# u_t025_003/m2_1795_1265# u_t025_003/m2_1714_1982# u_t025_003/m2_1886_1259#
+ u_t025_003/m2_1290_2126# u_t025_003/m2_1714_438# u_t025_003/m2_431_1210# u_t025_003/m2_2573_2898#
+ u_t025_003/m2_2154_303# u_t025_003/m2_871_2081# VSUBS detronyx_12t_2w2r_rc4_4x4_routed_5layer_direct
Xgf180mcu_as_sc_mcu7t3v3__inv_2_1134 VSS gf180mcu_as_sc_mcu7t3v3__inv_2_1139/VDD VSS
+ VSS gf180mcu_as_sc_mcu7t3v3__inv_2_1136/VNW VSUBS gf180mcu_as_sc_mcu7t3v3__inv_2
Xgf180mcu_as_sc_mcu7t3v3__inv_2_1145 VSS gf180mcu_as_sc_mcu7t3v3__inv_2_1148/VDD gf180mcu_as_sc_mcu7t3v3__inv_2_1145/Y
+ VSS gf180mcu_as_sc_mcu7t3v3__inv_2_1145/VNW VSUBS gf180mcu_as_sc_mcu7t3v3__inv_2
Xgf180mcu_as_sc_mcu7t3v3__inv_2_1123 VSS VSS gf180mcu_as_sc_mcu7t3v3__inv_2_1123/Y
+ gf180mcu_as_sc_mcu7t3v3__inv_2_1124/Y gf180mcu_as_sc_mcu7t3v3__inv_2_1124/VNW VSUBS
+ gf180mcu_as_sc_mcu7t3v3__inv_2
Xgf180mcu_as_sc_mcu7t3v3__inv_2_1156 VSS VSS VSS VSS gf180mcu_as_sc_mcu7t3v3__inv_2_1290/VNW
+ VSUBS gf180mcu_as_sc_mcu7t3v3__inv_2
Xgf180mcu_as_sc_mcu7t3v3__inv_2_1101 gf180mcu_as_sc_mcu7t3v3__inv_2_1103/VDD VSS VSS
+ gf180mcu_as_sc_mcu7t3v3__inv_2_1101/A gf180mcu_as_sc_mcu7t3v3__inv_2_1103/VNW VSUBS
+ gf180mcu_as_sc_mcu7t3v3__inv_2
Xgf180mcu_as_sc_mcu7t3v3__inv_2_1167 VSS VSS VSS VSS gf180mcu_as_sc_mcu7t3v3__inv_2_1287/VNW
+ VSUBS gf180mcu_as_sc_mcu7t3v3__inv_2
Xgf180mcu_as_sc_mcu7t3v3__inv_2_1112 gf180mcu_as_sc_mcu7t3v3__inv_2_1112/VDD VSS gf180mcu_as_sc_mcu7t3v3__inv_2_1112/Y
+ VSS gf180mcu_as_sc_mcu7t3v3__inv_2_1112/VNW VSUBS gf180mcu_as_sc_mcu7t3v3__inv_2
Xgf180mcu_as_sc_mcu7t3v3__inv_2_1189 VSS VSS VSS VSS gf180mcu_as_sc_mcu7t3v3__inv_2_1268/VNW
+ VSUBS gf180mcu_as_sc_mcu7t3v3__inv_2
Xgf180mcu_as_sc_mcu7t3v3__inv_2_1178 VSS VSS VSS VSS gf180mcu_as_sc_mcu7t3v3__inv_2_1288/VNW
+ VSUBS gf180mcu_as_sc_mcu7t3v3__inv_2
Xu_t016_014 u_t016_014/c0_w0_bl u_t016_014/c0_w0_br u_t016_014/c0_w1_bl u_t016_014/c0_w1_br
+ u_t016_014/c0_r0_rbl u_t016_014/c0_r1_rbl u_t016_014/c1_w0_bl u_t016_014/c1_w0_br
+ u_t016_014/c1_w1_bl u_t016_014/c1_w1_br u_t016_014/c1_r0_rbl u_t016_014/c1_r1_rbl
+ u_t016_014/c2_w0_bl u_t016_014/c2_w0_br u_t016_014/c2_w1_bl u_t016_014/c2_w1_br
+ u_t016_014/c2_r0_rbl u_t016_014/c2_r1_rbl u_t016_014/c3_w0_bl u_t016_014/c3_w0_br
+ u_t016_014/c3_w1_bl u_t016_014/c3_w1_br u_t016_014/c3_r0_rbl u_t016_014/c3_r1_rbl
+ u_t016_014/r0_w0_wl u_t016_014/r0_w1_wl u_t016_014/r0_r0_rwl u_t016_014/r0_r1_rwl
+ u_t016_014/r1_w0_wl u_t016_014/r1_w1_wl u_t016_014/r1_r0_rwl u_t016_014/r1_r1_rwl
+ u_t016_014/r2_w0_wl u_t016_014/r2_w1_wl u_t016_014/r2_r0_rwl u_t016_014/r2_r1_rwl
+ u_t016_014/r3_w0_wl u_t016_014/r3_w1_wl u_t016_014/r3_r0_rwl u_t016_014/r3_r1_rwl
+ u_t016_014/VDD u_t016_015/VSS u_t016_014/m2_717_1265# u_t016_014/m2_603_2031# u_t016_014/m2_1290_336#
+ u_t016_014/m2_2000_2037# u_t016_014/m2_791_2909# u_t016_014/m2_7_2126# u_t016_014/m2_2154_2081#
+ u_t016_014/m2_1795_2037# u_t016_014/m2_871_303# u_t016_014/m2_431_438# u_t016_014/m2_1290_2898#
+ u_t016_014/m2_1714_1210# u_t016_014/m2_431_1982# u_t016_014/m2_512_1265# u_t016_014/m2_2573_2126#
+ u_t016_014/m2_603_1259# u_t016_014/m2_2074_2909# u_t016_014/m2_7_336# u_t016_014/m2_717_2037#
+ u_t016_014/m2_1886_2031# u_t016_014/m2_2573_336# u_t016_014/m2_7_2898# u_t016_014/m2_2000_1265#
+ u_t016_014/m2_512_2037# u_t016_014/m2_1795_1265# u_t016_014/m2_1714_1982# u_t016_014/m2_1886_1259#
+ u_t016_014/m2_1290_2126# u_t016_014/m2_1714_438# u_t016_014/m2_431_1210# u_t016_014/m2_2573_2898#
+ u_t016_014/m2_2154_303# u_t016_014/m2_871_2081# VSUBS detronyx_12t_2w2r_rc4_4x4_routed_5layer_direct
Xu_t016_003 u_t016_003/c0_w0_bl u_t016_003/c0_w0_br u_t016_003/c0_w1_bl u_t016_003/c0_w1_br
+ u_t016_003/c0_r0_rbl u_t016_003/c0_r1_rbl u_t016_003/c1_w0_bl u_t016_003/c1_w0_br
+ u_t016_003/c1_w1_bl u_t016_003/c1_w1_br u_t016_003/c1_r0_rbl u_t016_003/c1_r1_rbl
+ u_t016_003/c2_w0_bl u_t016_003/c2_w0_br u_t016_003/c2_w1_bl u_t016_003/c2_w1_br
+ u_t016_003/c2_r0_rbl u_t016_003/c2_r1_rbl u_t016_003/c3_w0_bl u_t016_003/c3_w0_br
+ u_t016_003/c3_w1_bl u_t016_003/c3_w1_br u_t016_003/c3_r0_rbl u_t016_003/c3_r1_rbl
+ u_t016_003/r0_w0_wl u_t016_003/r0_w1_wl u_t016_003/r0_r0_rwl u_t016_003/r0_r1_rwl
+ u_t016_003/r1_w0_wl u_t016_003/r1_w1_wl u_t016_003/r1_r0_rwl u_t016_003/r1_r1_rwl
+ u_t016_003/r2_w0_wl u_t016_003/r2_w1_wl u_t016_003/r2_r0_rwl u_t016_003/r2_r1_rwl
+ u_t016_003/r3_w0_wl u_t016_003/r3_w1_wl u_t016_003/r3_r0_rwl u_t016_003/r3_r1_rwl
+ u_t016_003/VDD u_t016_003/VSS u_t016_003/m2_717_1265# u_t016_003/m2_603_2031# u_t016_003/m2_1290_336#
+ u_t016_003/m2_2000_2037# u_t016_003/m2_791_2909# u_t016_003/m2_7_2126# u_t016_003/m2_2154_2081#
+ u_t016_003/m2_1795_2037# u_t016_003/m2_871_303# u_t016_003/m2_431_438# u_t016_003/m2_1290_2898#
+ u_t016_003/m2_1714_1210# u_t016_003/m2_431_1982# u_t016_003/m2_512_1265# u_t016_003/m2_2573_2126#
+ u_t016_003/m2_603_1259# u_t016_003/m2_2074_2909# u_t016_003/m2_7_336# u_t016_003/m2_717_2037#
+ u_t016_003/m2_1886_2031# u_t016_003/m2_2573_336# u_t016_003/m2_7_2898# u_t016_003/m2_2000_1265#
+ u_t016_003/m2_512_2037# u_t016_003/m2_1795_1265# u_t016_003/m2_1714_1982# u_t016_003/m2_1886_1259#
+ u_t016_003/m2_1290_2126# u_t016_003/m2_1714_438# u_t016_003/m2_431_1210# u_t016_003/m2_2573_2898#
+ u_t016_003/m2_2154_303# u_t016_003/m2_871_2081# VSUBS detronyx_12t_2w2r_rc4_4x4_routed_5layer_direct
Xgf180mcu_as_sc_mcu7t3v3__inv_2_607 gf180mcu_as_sc_mcu7t3v3__inv_2_607/VDD gf180mcu_as_sc_mcu7t3v3__inv_2_637/VDD
+ gf180mcu_as_sc_mcu7t3v3__inv_2_607/Y gf180mcu_as_sc_mcu7t3v3__inv_2_638/A gf180mcu_as_sc_mcu7t3v3__inv_2_607/VNW
+ VSUBS gf180mcu_as_sc_mcu7t3v3__inv_2
Xgf180mcu_as_sc_mcu7t3v3__inv_2_618 gf180mcu_as_sc_mcu7t3v3__inv_2_620/VDD gf180mcu_as_sc_mcu7t3v3__inv_2_624/VDD
+ gf180mcu_as_sc_mcu7t3v3__inv_2_618/Y gf180mcu_as_sc_mcu7t3v3__inv_2_853/Y gf180mcu_as_sc_mcu7t3v3__inv_2_620/VNW
+ VSUBS gf180mcu_as_sc_mcu7t3v3__inv_2
Xu_t031_006 u_t031_006/c0_w0_bl u_t031_006/c0_w0_br u_t031_006/c0_w1_bl u_t031_006/c0_w1_br
+ u_t031_006/c0_r0_rbl u_t031_006/c0_r1_rbl u_t031_006/c1_w0_bl u_t031_006/c1_w0_br
+ u_t031_006/c1_w1_bl u_t031_006/c1_w1_br u_t031_006/c1_r0_rbl u_t031_006/c1_r1_rbl
+ u_t031_006/c2_w0_bl u_t031_006/c2_w0_br u_t031_006/c2_w1_bl u_t031_006/c2_w1_br
+ u_t031_006/c2_r0_rbl u_t031_006/c2_r1_rbl u_t031_006/c3_w0_bl u_t031_006/c3_w0_br
+ u_t031_006/c3_w1_bl u_t031_006/c3_w1_br u_t031_006/c3_r0_rbl u_t031_006/c3_r1_rbl
+ u_t031_006/r0_w0_wl u_t031_006/r0_w1_wl u_t031_006/r0_r0_rwl u_t031_006/r0_r1_rwl
+ u_t031_006/r1_w0_wl u_t031_006/r1_w1_wl u_t031_006/r1_r0_rwl u_t031_006/r1_r1_rwl
+ u_t031_006/r2_w0_wl u_t031_006/r2_w1_wl u_t031_006/r2_r0_rwl u_t031_006/r2_r1_rwl
+ u_t031_006/r3_w0_wl u_t031_006/r3_w1_wl u_t031_006/r3_r0_rwl u_t031_006/r3_r1_rwl
+ u_t031_006/VDD u_t031_009/VSS u_t031_006/m2_717_1265# u_t031_006/m2_603_2031# u_t031_006/m2_1290_336#
+ u_t031_006/m2_2000_2037# u_t031_006/m2_791_2909# u_t031_006/m2_7_2126# u_t031_006/m2_2154_2081#
+ u_t031_006/m2_1795_2037# u_t031_006/m2_871_303# u_t031_006/m2_431_438# u_t031_006/m2_1290_2898#
+ u_t031_006/m2_1714_1210# u_t031_006/m2_431_1982# u_t031_006/m2_512_1265# u_t031_006/m2_2573_2126#
+ u_t031_006/m2_603_1259# u_t031_006/m2_2074_2909# u_t031_006/m2_7_336# u_t031_006/m2_717_2037#
+ u_t031_006/m2_1886_2031# u_t031_006/m2_2573_336# u_t031_006/m2_7_2898# u_t031_006/m2_2000_1265#
+ u_t031_006/m2_512_2037# u_t031_006/m2_1795_1265# u_t031_006/m2_1714_1982# u_t031_006/m2_1886_1259#
+ u_t031_006/m2_1290_2126# u_t031_006/m2_1714_438# u_t031_006/m2_431_1210# u_t031_006/m2_2573_2898#
+ u_t031_006/m2_2154_303# u_t031_006/m2_871_2081# VSUBS detronyx_12t_2w2r_rc4_4x4_routed_5layer_direct
Xgf180mcu_as_sc_mcu7t3v3__inv_2_629 gf180mcu_as_sc_mcu7t3v3__inv_2_633/VDD VSS gf180mcu_as_sc_mcu7t3v3__inv_2_638/A
+ gf180mcu_as_sc_mcu7t3v3__inv_2_633/Y gf180mcu_as_sc_mcu7t3v3__inv_2_633/VNW VSUBS
+ gf180mcu_as_sc_mcu7t3v3__inv_2
Xgf180mcu_as_sc_mcu7t3v3__inv_2_1690 VSS gf180mcu_as_sc_mcu7t3v3__inv_2_1691/VSS VSS
+ gf180mcu_as_sc_mcu7t3v3__inv_2_1694/Y gf180mcu_as_sc_mcu7t3v3__inv_2_1691/VNW VSUBS
+ gf180mcu_as_sc_mcu7t3v3__inv_2
Xu_t007_014 u_t007_014/c0_w0_bl u_t007_014/c0_w0_br u_t007_014/c0_w1_bl u_t007_014/c0_w1_br
+ u_t007_014/c0_r0_rbl u_t007_014/c0_r1_rbl u_t007_014/c1_w0_bl u_t007_014/c1_w0_br
+ u_t007_014/c1_w1_bl u_t007_014/c1_w1_br u_t007_014/c1_r0_rbl u_t007_014/c1_r1_rbl
+ u_t007_014/c2_w0_bl u_t007_014/c2_w0_br u_t007_014/c2_w1_bl u_t007_014/c2_w1_br
+ u_t007_014/c2_r0_rbl u_t007_014/c2_r1_rbl u_t007_014/c3_w0_bl u_t007_014/c3_w0_br
+ u_t007_014/c3_w1_bl u_t007_014/c3_w1_br u_t007_014/c3_r0_rbl u_t007_014/c3_r1_rbl
+ u_t007_014/r0_w0_wl u_t007_014/r0_w1_wl u_t007_014/r0_r0_rwl u_t007_014/r0_r1_rwl
+ u_t007_014/r1_w0_wl u_t007_014/r1_w1_wl u_t007_014/r1_r0_rwl u_t007_014/r1_r1_rwl
+ u_t007_014/r2_w0_wl u_t007_014/r2_w1_wl u_t007_014/r2_r0_rwl u_t007_014/r2_r1_rwl
+ u_t007_014/r3_w0_wl u_t007_014/r3_w1_wl u_t007_014/r3_r0_rwl u_t007_014/r3_r1_rwl
+ u_t008_014/VDD u_t007_015/VSS u_t007_014/m2_717_1265# u_t007_014/m2_603_2031# u_t007_014/m2_1290_336#
+ u_t007_014/m2_2000_2037# u_t007_014/m2_791_2909# u_t007_014/m2_7_2126# u_t007_014/m2_2154_2081#
+ u_t007_014/m2_1795_2037# u_t007_014/m2_871_303# u_t007_014/m2_431_438# u_t007_014/m2_1290_2898#
+ u_t007_014/m2_1714_1210# u_t007_014/m2_431_1982# u_t007_014/m2_512_1265# u_t007_014/m2_2573_2126#
+ u_t007_014/m2_603_1259# u_t007_014/m2_2074_2909# u_t007_014/m2_7_336# u_t007_014/m2_717_2037#
+ u_t007_014/m2_1886_2031# u_t007_014/m2_2573_336# u_t007_014/m2_7_2898# u_t007_014/m2_2000_1265#
+ u_t007_014/m2_512_2037# u_t007_014/m2_1795_1265# u_t007_014/m2_1714_1982# u_t007_014/m2_1886_1259#
+ u_t007_014/m2_1290_2126# u_t007_014/m2_1714_438# u_t007_014/m2_431_1210# u_t007_014/m2_2573_2898#
+ u_t007_014/m2_2154_303# u_t007_014/m2_871_2081# VSUBS detronyx_12t_2w2r_rc4_4x4_routed_5layer_direct
Xu_t022_006 u_t022_006/c0_w0_bl u_t022_006/c0_w0_br u_t022_006/c0_w1_bl u_t022_006/c0_w1_br
+ u_t022_006/c0_r0_rbl u_t022_006/c0_r1_rbl u_t022_006/c1_w0_bl u_t022_006/c1_w0_br
+ u_t022_006/c1_w1_bl u_t022_006/c1_w1_br u_t022_006/c1_r0_rbl u_t022_006/c1_r1_rbl
+ u_t022_006/c2_w0_bl u_t022_006/c2_w0_br u_t022_006/c2_w1_bl u_t022_006/c2_w1_br
+ u_t022_006/c2_r0_rbl u_t022_006/c2_r1_rbl u_t022_006/c3_w0_bl u_t022_006/c3_w0_br
+ u_t022_006/c3_w1_bl u_t022_006/c3_w1_br u_t022_006/c3_r0_rbl u_t022_006/c3_r1_rbl
+ u_t022_006/r0_w0_wl u_t022_006/r0_w1_wl u_t022_006/r0_r0_rwl u_t022_006/r0_r1_rwl
+ u_t022_006/r1_w0_wl u_t022_006/r1_w1_wl u_t022_006/r1_r0_rwl u_t022_006/r1_r1_rwl
+ u_t022_006/r2_w0_wl u_t022_006/r2_w1_wl u_t022_006/r2_r0_rwl u_t022_006/r2_r1_rwl
+ u_t022_006/r3_w0_wl u_t022_006/r3_w1_wl u_t022_006/r3_r0_rwl u_t022_006/r3_r1_rwl
+ u_t022_006/VDD VSS u_t022_006/m2_717_1265# u_t022_006/m2_603_2031# u_t022_006/m2_1290_336#
+ u_t022_006/m2_2000_2037# u_t022_006/m2_791_2909# u_t022_006/m2_7_2126# u_t022_006/m2_2154_2081#
+ u_t022_006/m2_1795_2037# u_t022_006/m2_871_303# u_t022_006/m2_431_438# u_t022_006/m2_1290_2898#
+ u_t022_006/m2_1714_1210# u_t022_006/m2_431_1982# u_t022_006/m2_512_1265# u_t022_006/m2_2573_2126#
+ u_t022_006/m2_603_1259# u_t022_006/m2_2074_2909# u_t022_006/m2_7_336# u_t022_006/m2_717_2037#
+ u_t022_006/m2_1886_2031# u_t022_006/m2_2573_336# u_t022_006/m2_7_2898# u_t022_006/m2_2000_1265#
+ u_t022_006/m2_512_2037# u_t022_006/m2_1795_1265# u_t022_006/m2_1714_1982# u_t022_006/m2_1886_1259#
+ u_t022_006/m2_1290_2126# u_t022_006/m2_1714_438# u_t022_006/m2_431_1210# u_t022_006/m2_2573_2898#
+ u_t022_006/m2_2154_303# u_t022_006/m2_871_2081# VSUBS detronyx_12t_2w2r_rc4_4x4_routed_5layer_direct
Xu_t007_003 u_t007_003/c0_w0_bl u_t007_003/c0_w0_br u_t007_003/c0_w1_bl u_t007_003/c0_w1_br
+ u_t007_003/c0_r0_rbl u_t007_003/c0_r1_rbl u_t007_003/c1_w0_bl u_t007_003/c1_w0_br
+ u_t007_003/c1_w1_bl u_t007_003/c1_w1_br u_t007_003/c1_r0_rbl u_t007_003/c1_r1_rbl
+ u_t007_003/c2_w0_bl u_t007_003/c2_w0_br u_t007_003/c2_w1_bl u_t007_003/c2_w1_br
+ u_t007_003/c2_r0_rbl u_t007_003/c2_r1_rbl u_t007_003/c3_w0_bl u_t007_003/c3_w0_br
+ u_t007_003/c3_w1_bl u_t007_003/c3_w1_br u_t007_003/c3_r0_rbl u_t007_003/c3_r1_rbl
+ u_t007_003/r0_w0_wl u_t007_003/r0_w1_wl u_t007_003/r0_r0_rwl u_t007_003/r0_r1_rwl
+ u_t007_003/r1_w0_wl u_t007_003/r1_w1_wl u_t007_003/r1_r0_rwl u_t007_003/r1_r1_rwl
+ u_t007_003/r2_w0_wl u_t007_003/r2_w1_wl u_t007_003/r2_r0_rwl u_t007_003/r2_r1_rwl
+ u_t007_003/r3_w0_wl u_t007_003/r3_w1_wl u_t007_003/r3_r0_rwl u_t007_003/r3_r1_rwl
+ u_t008_003/VDD u_t007_003/VSS u_t007_003/m2_717_1265# u_t007_003/m2_603_2031# u_t007_003/m2_1290_336#
+ u_t007_003/m2_2000_2037# u_t007_003/m2_791_2909# u_t007_003/m2_7_2126# u_t007_003/m2_2154_2081#
+ u_t007_003/m2_1795_2037# u_t007_003/m2_871_303# u_t007_003/m2_431_438# u_t007_003/m2_1290_2898#
+ u_t007_003/m2_1714_1210# u_t007_003/m2_431_1982# u_t007_003/m2_512_1265# u_t007_003/m2_2573_2126#
+ u_t007_003/m2_603_1259# u_t007_003/m2_2074_2909# u_t007_003/m2_7_336# u_t007_003/m2_717_2037#
+ u_t007_003/m2_1886_2031# u_t007_003/m2_2573_336# u_t007_003/m2_7_2898# u_t007_003/m2_2000_1265#
+ u_t007_003/m2_512_2037# u_t007_003/m2_1795_1265# u_t007_003/m2_1714_1982# u_t007_003/m2_1886_1259#
+ u_t007_003/m2_1290_2126# u_t007_003/m2_1714_438# u_t007_003/m2_431_1210# u_t007_003/m2_2573_2898#
+ u_t007_003/m2_2154_303# u_t007_003/m2_871_2081# VSUBS detronyx_12t_2w2r_rc4_4x4_routed_5layer_direct
Xgf180mcu_as_sc_mcu7t3v3__nand4_2_440 gf180mcu_as_sc_mcu7t3v3__inv_2_1591/VDD gf180mcu_as_sc_mcu7t3v3__inv_2_1594/VDD
+ VSS VSS VSS VSS gf180mcu_as_sc_mcu7t3v3__nand4_2_440/Y gf180mcu_as_sc_mcu7t3v3__inv_2_1591/VNW
+ VSUBS gf180mcu_as_sc_mcu7t3v3__nand4_2
Xgf180mcu_as_sc_mcu7t3v3__nand4_2_495 gf180mcu_as_sc_mcu7t3v3__inv_2_1618/VDD VSS
+ VSS VSS VSS VSS VSS gf180mcu_as_sc_mcu7t3v3__inv_2_1618/VNW VSUBS gf180mcu_as_sc_mcu7t3v3__nand4_2
Xgf180mcu_as_sc_mcu7t3v3__nand4_2_484 gf180mcu_as_sc_mcu7t3v3__inv_2_1660/VDD VSS
+ VSS VSS VSS VSS VSS gf180mcu_as_sc_mcu7t3v3__inv_2_1660/VNW VSUBS gf180mcu_as_sc_mcu7t3v3__nand4_2
Xgf180mcu_as_sc_mcu7t3v3__nand4_2_473 VSS VSS VSS VSS VSS VSS VSS gf180mcu_as_sc_mcu7t3v3__inv_2_1398/VNW
+ VSUBS gf180mcu_as_sc_mcu7t3v3__nand4_2
Xgf180mcu_as_sc_mcu7t3v3__nand4_2_462 VSS VSS VSS VSS VSS VSS VSS gf180mcu_as_sc_mcu7t3v3__inv_2_1353/VNW
+ VSUBS gf180mcu_as_sc_mcu7t3v3__nand4_2
Xgf180mcu_as_sc_mcu7t3v3__nand4_2_451 gf180mcu_as_sc_mcu7t3v3__inv_2_1340/VDD VSS
+ VSS VSS VSS VSS VSS gf180mcu_as_sc_mcu7t3v3__inv_2_1340/VNW VSUBS gf180mcu_as_sc_mcu7t3v3__nand4_2
Xu_t013_006 u_t013_006/c0_w0_bl u_t013_006/c0_w0_br u_t013_006/c0_w1_bl u_t013_006/c0_w1_br
+ u_t013_006/c0_r0_rbl u_t013_006/c0_r1_rbl u_t013_006/c1_w0_bl u_t013_006/c1_w0_br
+ u_t013_006/c1_w1_bl u_t013_006/c1_w1_br u_t013_006/c1_r0_rbl u_t013_006/c1_r1_rbl
+ u_t013_006/c2_w0_bl u_t013_006/c2_w0_br u_t013_006/c2_w1_bl u_t013_006/c2_w1_br
+ u_t013_006/c2_r0_rbl u_t013_006/c2_r1_rbl u_t013_006/c3_w0_bl u_t013_006/c3_w0_br
+ u_t013_006/c3_w1_bl u_t013_006/c3_w1_br u_t013_006/c3_r0_rbl u_t013_006/c3_r1_rbl
+ u_t013_006/r0_w0_wl u_t013_006/r0_w1_wl u_t013_006/r0_r0_rwl u_t013_006/r0_r1_rwl
+ u_t013_006/r1_w0_wl u_t013_006/r1_w1_wl u_t013_006/r1_r0_rwl u_t013_006/r1_r1_rwl
+ u_t013_006/r2_w0_wl u_t013_006/r2_w1_wl u_t013_006/r2_r0_rwl u_t013_006/r2_r1_rwl
+ u_t013_006/r3_w0_wl u_t013_006/r3_w1_wl u_t013_006/r3_r0_rwl u_t013_006/r3_r1_rwl
+ u_t013_006/VDD VSS u_t013_006/m2_717_1265# u_t013_006/m2_603_2031# u_t013_006/m2_1290_336#
+ u_t013_006/m2_2000_2037# u_t013_006/m2_791_2909# u_t013_006/m2_7_2126# u_t013_006/m2_2154_2081#
+ u_t013_006/m2_1795_2037# u_t013_006/m2_871_303# u_t013_006/m2_431_438# u_t013_006/m2_1290_2898#
+ u_t013_006/m2_1714_1210# u_t013_006/m2_431_1982# u_t013_006/m2_512_1265# u_t013_006/m2_2573_2126#
+ u_t013_006/m2_603_1259# u_t013_006/m2_2074_2909# u_t013_006/m2_7_336# u_t013_006/m2_717_2037#
+ u_t013_006/m2_1886_2031# u_t013_006/m2_2573_336# u_t013_006/m2_7_2898# u_t013_006/m2_2000_1265#
+ u_t013_006/m2_512_2037# u_t013_006/m2_1795_1265# u_t013_006/m2_1714_1982# u_t013_006/m2_1886_1259#
+ u_t013_006/m2_1290_2126# u_t013_006/m2_1714_438# u_t013_006/m2_431_1210# u_t013_006/m2_2573_2898#
+ u_t013_006/m2_2154_303# u_t013_006/m2_871_2081# VSUBS detronyx_12t_2w2r_rc4_4x4_routed_5layer_direct
Xu_t004_006 u_t004_006/c0_w0_bl u_t004_006/c0_w0_br u_t004_006/c0_w1_bl u_t004_006/c0_w1_br
+ u_t004_006/c0_r0_rbl u_t004_006/c0_r1_rbl u_t004_006/c1_w0_bl u_t004_006/c1_w0_br
+ u_t004_006/c1_w1_bl u_t004_006/c1_w1_br u_t004_006/c1_r0_rbl u_t004_006/c1_r1_rbl
+ u_t004_006/c2_w0_bl u_t004_006/c2_w0_br u_t004_006/c2_w1_bl u_t004_006/c2_w1_br
+ u_t004_006/c2_r0_rbl u_t004_006/c2_r1_rbl u_t004_006/c3_w0_bl u_t004_006/c3_w0_br
+ u_t004_006/c3_w1_bl u_t004_006/c3_w1_br u_t004_006/c3_r0_rbl u_t004_006/c3_r1_rbl
+ u_t004_006/r0_w0_wl u_t004_006/r0_w1_wl u_t004_006/r0_r0_rwl u_t004_006/r0_r1_rwl
+ u_t004_006/r1_w0_wl u_t004_006/r1_w1_wl u_t004_006/r1_r0_rwl u_t004_006/r1_r1_rwl
+ u_t004_006/r2_w0_wl u_t004_006/r2_w1_wl u_t004_006/r2_r0_rwl u_t004_006/r2_r1_rwl
+ u_t004_006/r3_w0_wl u_t004_006/r3_w1_wl u_t004_006/r3_r0_rwl u_t004_006/r3_r1_rwl
+ u_t004_006/VDD VSS u_t004_006/m2_717_1265# u_t004_006/m2_603_2031# u_t004_006/m2_1290_336#
+ u_t004_006/m2_2000_2037# u_t004_006/m2_791_2909# u_t004_006/m2_7_2126# u_t004_006/m2_2154_2081#
+ u_t004_006/m2_1795_2037# u_t004_006/m2_871_303# u_t004_006/m2_431_438# u_t004_006/m2_1290_2898#
+ u_t004_006/m2_1714_1210# u_t004_006/m2_431_1982# u_t004_006/m2_512_1265# u_t004_006/m2_2573_2126#
+ u_t004_006/m2_603_1259# u_t004_006/m2_2074_2909# u_t004_006/m2_7_336# u_t004_006/m2_717_2037#
+ u_t004_006/m2_1886_2031# u_t004_006/m2_2573_336# u_t004_006/m2_7_2898# u_t004_006/m2_2000_1265#
+ u_t004_006/m2_512_2037# u_t004_006/m2_1795_1265# u_t004_006/m2_1714_1982# u_t004_006/m2_1886_1259#
+ u_t004_006/m2_1290_2126# u_t004_006/m2_1714_438# u_t004_006/m2_431_1210# u_t004_006/m2_2573_2898#
+ u_t004_006/m2_2154_303# u_t004_006/m2_871_2081# VSUBS detronyx_12t_2w2r_rc4_4x4_routed_5layer_direct
Xgf180mcu_as_sc_mcu7t3v3__inv_2_448 VSS VSS VSS VSS gf180mcu_as_sc_mcu7t3v3__inv_2_546/VNW
+ VSUBS gf180mcu_as_sc_mcu7t3v3__inv_2
Xgf180mcu_as_sc_mcu7t3v3__inv_2_459 VSS VSS gf180mcu_as_sc_mcu7t3v3__inv_2_459/Y VSS
+ gf180mcu_as_sc_mcu7t3v3__inv_2_544/VNW VSUBS gf180mcu_as_sc_mcu7t3v3__inv_2
Xgf180mcu_as_sc_mcu7t3v3__inv_2_426 gf180mcu_as_sc_mcu7t3v3__nor2_2_6/VDD gf180mcu_as_sc_mcu7t3v3__nor2_2_6/VSS
+ VSS VSS gf180mcu_as_sc_mcu7t3v3__nor2_2_6/VNW VSUBS gf180mcu_as_sc_mcu7t3v3__inv_2
Xgf180mcu_as_sc_mcu7t3v3__inv_2_404 gf180mcu_as_sc_mcu7t3v3__nor2_2_7/VDD gf180mcu_as_sc_mcu7t3v3__nor2_2_7/VSS
+ VSS VSS gf180mcu_as_sc_mcu7t3v3__nor2_2_7/VNW VSUBS gf180mcu_as_sc_mcu7t3v3__inv_2
Xgf180mcu_as_sc_mcu7t3v3__inv_2_415 gf180mcu_as_sc_mcu7t3v3__nand3_2_9/VDD gf180mcu_as_sc_mcu7t3v3__nor2_2_7/VSS
+ VSS VSS gf180mcu_as_sc_mcu7t3v3__nand3_2_9/VNW VSUBS gf180mcu_as_sc_mcu7t3v3__inv_2
Xgf180mcu_as_sc_mcu7t3v3__inv_2_437 gf180mcu_as_sc_mcu7t3v3__nor2_2_4/VDD gf180mcu_as_sc_mcu7t3v3__nor2_2_4/VSS
+ VSS VSS gf180mcu_as_sc_mcu7t3v3__nor2_2_4/VNW VSUBS gf180mcu_as_sc_mcu7t3v3__inv_2
Xgf180mcu_as_sc_mcu7t3v3__inv_2_960 VSS gf180mcu_as_sc_mcu7t3v3__inv_2_960/VSS gf180mcu_as_sc_mcu7t3v3__inv_2_960/Y
+ VSS gf180mcu_as_sc_mcu7t3v3__inv_2_960/VNW VSUBS gf180mcu_as_sc_mcu7t3v3__inv_2
Xgf180mcu_as_sc_mcu7t3v3__inv_2_982 gf180mcu_as_sc_mcu7t3v3__inv_2_984/VDD gf180mcu_as_sc_mcu7t3v3__inv_2_988/VDD
+ VSS gf180mcu_as_sc_mcu7t3v3__inv_2_998/A gf180mcu_as_sc_mcu7t3v3__inv_2_984/VNW
+ VSUBS gf180mcu_as_sc_mcu7t3v3__inv_2
Xgf180mcu_as_sc_mcu7t3v3__inv_2_993 VSS VSS VSS gf180mcu_as_sc_mcu7t3v3__inv_2_998/A
+ gf180mcu_as_sc_mcu7t3v3__inv_2_997/VNW VSUBS gf180mcu_as_sc_mcu7t3v3__inv_2
Xgf180mcu_as_sc_mcu7t3v3__inv_2_971 VSS gf180mcu_as_sc_mcu7t3v3__inv_2_985/VDD gf180mcu_as_sc_mcu7t3v3__inv_2_971/Y
+ gf180mcu_as_sc_mcu7t3v3__inv_2_972/Y gf180mcu_as_sc_mcu7t3v3__inv_2_972/VNW VSUBS
+ gf180mcu_as_sc_mcu7t3v3__inv_2
Xu_t010_009 u_t010_009/c0_w0_bl u_t010_009/c0_w0_br u_t010_009/c0_w1_bl u_t010_009/c0_w1_br
+ u_t010_009/c0_r0_rbl u_t010_009/c0_r1_rbl u_t010_009/c1_w0_bl u_t010_009/c1_w0_br
+ u_t010_009/c1_w1_bl u_t010_009/c1_w1_br u_t010_009/c1_r0_rbl u_t010_009/c1_r1_rbl
+ u_t010_009/c2_w0_bl u_t010_009/c2_w0_br u_t010_009/c2_w1_bl u_t010_009/c2_w1_br
+ u_t010_009/c2_r0_rbl u_t010_009/c2_r1_rbl u_t010_009/c3_w0_bl u_t010_009/c3_w0_br
+ u_t010_009/c3_w1_bl u_t010_009/c3_w1_br u_t010_009/c3_r0_rbl u_t010_009/c3_r1_rbl
+ u_t010_009/r0_w0_wl u_t010_009/r0_w1_wl u_t010_009/r0_r0_rwl u_t010_009/r0_r1_rwl
+ u_t010_009/r1_w0_wl u_t010_009/r1_w1_wl u_t010_009/r1_r0_rwl u_t010_009/r1_r1_rwl
+ u_t010_009/r2_w0_wl u_t010_009/r2_w1_wl u_t010_009/r2_r0_rwl u_t010_009/r2_r1_rwl
+ u_t010_009/r3_w0_wl u_t010_009/r3_w1_wl u_t010_009/r3_r0_rwl u_t010_009/r3_r1_rwl
+ VSS u_t010_009/VSS u_t010_009/m2_717_1265# u_t010_009/m2_603_2031# u_t010_009/m2_1290_336#
+ u_t010_009/m2_2000_2037# u_t010_009/m2_791_2909# u_t010_009/m2_7_2126# u_t010_009/m2_2154_2081#
+ u_t010_009/m2_1795_2037# u_t010_009/m2_871_303# u_t010_009/m2_431_438# u_t010_009/m2_1290_2898#
+ u_t010_009/m2_1714_1210# u_t010_009/m2_431_1982# u_t010_009/m2_512_1265# u_t010_009/m2_2573_2126#
+ u_t010_009/m2_603_1259# u_t010_009/m2_2074_2909# u_t010_009/m2_7_336# u_t010_009/m2_717_2037#
+ u_t010_009/m2_1886_2031# u_t010_009/m2_2573_336# u_t010_009/m2_7_2898# u_t010_009/m2_2000_1265#
+ u_t010_009/m2_512_2037# u_t010_009/m2_1795_1265# u_t010_009/m2_1714_1982# u_t010_009/m2_1886_1259#
+ u_t010_009/m2_1290_2126# u_t010_009/m2_1714_438# u_t010_009/m2_431_1210# u_t010_009/m2_2573_2898#
+ u_t010_009/m2_2154_303# u_t010_009/m2_871_2081# VSUBS detronyx_12t_2w2r_rc4_4x4_routed_5layer_direct
Xgf180mcu_as_sc_mcu7t3v3__nand4_2_281 VSS VSS VSS VSS VSS VSS VSS gf180mcu_as_sc_mcu7t3v3__inv_2_948/VNW
+ VSUBS gf180mcu_as_sc_mcu7t3v3__nand4_2
Xgf180mcu_as_sc_mcu7t3v3__nand4_2_270 VSS VSS VSS VSS VSS VSS gf180mcu_as_sc_mcu7t3v3__nand4_2_270/Y
+ gf180mcu_as_sc_mcu7t3v3__inv_2_950/VNW VSUBS gf180mcu_as_sc_mcu7t3v3__nand4_2
Xgf180mcu_as_sc_mcu7t3v3__nand4_2_292 VSS gf180mcu_as_sc_mcu7t3v3__inv_2_996/VDD VSS
+ VSS VSS VSS VSS gf180mcu_as_sc_mcu7t3v3__inv_2_992/VNW VSUBS gf180mcu_as_sc_mcu7t3v3__nand4_2
Xu_t001_009 u_t001_009/c0_w0_bl u_t001_009/c0_w0_br u_t001_009/c0_w1_bl u_t001_009/c0_w1_br
+ u_t001_009/c0_r0_rbl u_t001_009/c0_r1_rbl u_t001_009/c1_w0_bl u_t001_009/c1_w0_br
+ u_t001_009/c1_w1_bl u_t001_009/c1_w1_br u_t001_009/c1_r0_rbl u_t001_009/c1_r1_rbl
+ u_t001_009/c2_w0_bl u_t001_009/c2_w0_br u_t001_009/c2_w1_bl u_t001_009/c2_w1_br
+ u_t001_009/c2_r0_rbl u_t001_009/c2_r1_rbl u_t001_009/c3_w0_bl u_t001_009/c3_w0_br
+ u_t001_009/c3_w1_bl u_t001_009/c3_w1_br u_t001_009/c3_r0_rbl u_t001_009/c3_r1_rbl
+ u_t001_009/r0_w0_wl u_t001_009/r0_w1_wl u_t001_009/r0_r0_rwl u_t001_009/r0_r1_rwl
+ u_t001_009/r1_w0_wl u_t001_009/r1_w1_wl u_t001_009/r1_r0_rwl u_t001_009/r1_r1_rwl
+ u_t001_009/r2_w0_wl u_t001_009/r2_w1_wl u_t001_009/r2_r0_rwl u_t001_009/r2_r1_rwl
+ u_t001_009/r3_w0_wl u_t001_009/r3_w1_wl u_t001_009/r3_r0_rwl u_t001_009/r3_r1_rwl
+ VSS VSS u_t001_009/m2_717_1265# u_t001_009/m2_603_2031# u_t001_009/m2_1290_336#
+ u_t001_009/m2_2000_2037# u_t001_009/m2_791_2909# u_t001_009/m2_7_2126# u_t001_009/m2_2154_2081#
+ u_t001_009/m2_1795_2037# u_t001_009/m2_871_303# u_t001_009/m2_431_438# u_t001_009/m2_1290_2898#
+ u_t001_009/m2_1714_1210# u_t001_009/m2_431_1982# u_t001_009/m2_512_1265# u_t001_009/m2_2573_2126#
+ u_t001_009/m2_603_1259# u_t001_009/m2_2074_2909# u_t001_009/m2_7_336# u_t001_009/m2_717_2037#
+ u_t001_009/m2_1886_2031# u_t001_009/m2_2573_336# u_t001_009/m2_7_2898# u_t001_009/m2_2000_1265#
+ u_t001_009/m2_512_2037# u_t001_009/m2_1795_1265# u_t001_009/m2_1714_1982# u_t001_009/m2_1886_1259#
+ u_t001_009/m2_1290_2126# u_t001_009/m2_1714_438# u_t001_009/m2_431_1210# u_t001_009/m2_2573_2898#
+ u_t001_009/m2_2154_303# u_t001_009/m2_871_2081# VSUBS detronyx_12t_2w2r_rc4_4x4_routed_5layer_direct
Xgf180mcu_as_sc_mcu7t3v3__inv_2_267 VSS gf180mcu_as_sc_mcu7t3v3__inv_2_281/VDD gf180mcu_as_sc_mcu7t3v3__inv_2_61/Y
+ gf180mcu_as_sc_mcu7t3v3__inv_2_61/Y gf180mcu_as_sc_mcu7t3v3__inv_2_268/VNW VSUBS
+ gf180mcu_as_sc_mcu7t3v3__inv_2
Xgf180mcu_as_sc_mcu7t3v3__inv_2_201 VSS gf180mcu_as_sc_mcu7t3v3__inv_2_203/VSS gf180mcu_as_sc_mcu7t3v3__inv_2_201/Y
+ VSS gf180mcu_as_sc_mcu7t3v3__inv_2_203/VNW VSUBS gf180mcu_as_sc_mcu7t3v3__inv_2
Xgf180mcu_as_sc_mcu7t3v3__inv_2_278 gf180mcu_as_sc_mcu7t3v3__inv_2_279/VDD VSS gf180mcu_as_sc_mcu7t3v3__inv_2_365/Y
+ gf180mcu_as_sc_mcu7t3v3__inv_2_365/Y gf180mcu_as_sc_mcu7t3v3__inv_2_279/VNW VSUBS
+ gf180mcu_as_sc_mcu7t3v3__inv_2
Xgf180mcu_as_sc_mcu7t3v3__inv_2_289 gf180mcu_as_sc_mcu7t3v3__inv_2_365/VSS gf180mcu_as_sc_mcu7t3v3__inv_2_307/VDD
+ VSS gf180mcu_as_sc_mcu7t3v3__inv_2_365/Y gf180mcu_as_sc_mcu7t3v3__inv_2_297/VNW
+ VSUBS gf180mcu_as_sc_mcu7t3v3__inv_2
Xgf180mcu_as_sc_mcu7t3v3__inv_2_223 VSS VSS gf180mcu_as_sc_mcu7t3v3__inv_2_223/Y VSS
+ gf180mcu_as_sc_mcu7t3v3__inv_2_224/VNW VSUBS gf180mcu_as_sc_mcu7t3v3__inv_2
Xgf180mcu_as_sc_mcu7t3v3__inv_2_212 VSS VSS VSS VSS gf180mcu_as_sc_mcu7t3v3__inv_2_212/VNW
+ VSUBS gf180mcu_as_sc_mcu7t3v3__inv_2
Xgf180mcu_as_sc_mcu7t3v3__inv_2_256 gf180mcu_as_sc_mcu7t3v3__inv_2_257/VDD gf180mcu_as_sc_mcu7t3v3__inv_2_257/VSS
+ gf180mcu_as_sc_mcu7t3v3__inv_2_256/Y VSS gf180mcu_as_sc_mcu7t3v3__inv_2_257/VNW
+ VSUBS gf180mcu_as_sc_mcu7t3v3__inv_2
Xgf180mcu_as_sc_mcu7t3v3__inv_2_245 VSS gf180mcu_as_sc_mcu7t3v3__inv_2_248/VDD gf180mcu_as_sc_mcu7t3v3__inv_2_245/Y
+ VSS gf180mcu_as_sc_mcu7t3v3__inv_2_245/VNW VSUBS gf180mcu_as_sc_mcu7t3v3__inv_2
Xgf180mcu_as_sc_mcu7t3v3__inv_2_234 VSS gf180mcu_as_sc_mcu7t3v3__inv_2_239/VDD gf180mcu_as_sc_mcu7t3v3__inv_2_234/Y
+ VSS gf180mcu_as_sc_mcu7t3v3__inv_2_236/VNW VSUBS gf180mcu_as_sc_mcu7t3v3__inv_2
Xgf180mcu_as_sc_mcu7t3v3__inv_2_790 VSS VSS VSS VSS gf180mcu_as_sc_mcu7t3v3__inv_2_843/VNW
+ VSUBS gf180mcu_as_sc_mcu7t3v3__inv_2
Xgf180mcu_as_sc_mcu7t3v3__inv_2_1508 gf180mcu_as_sc_mcu7t3v3__inv_2_1508/VDD gf180mcu_as_sc_mcu7t3v3__inv_2_1508/VSS
+ gf180mcu_as_sc_mcu7t3v3__inv_2_1508/Y VSS gf180mcu_as_sc_mcu7t3v3__inv_2_1508/VNW
+ VSUBS gf180mcu_as_sc_mcu7t3v3__inv_2
Xgf180mcu_as_sc_mcu7t3v3__inv_2_1519 gf180mcu_as_sc_mcu7t3v3__inv_2_1562/VSS VSS gf180mcu_as_sc_mcu7t3v3__inv_2_1519/Y
+ VSS gf180mcu_as_sc_mcu7t3v3__inv_2_1519/VNW VSUBS gf180mcu_as_sc_mcu7t3v3__inv_2
Xgf180mcu_as_sc_mcu7t3v3__nand2_2_7 gf180mcu_as_sc_mcu7t3v3__nand3_2_9/VDD gf180mcu_as_sc_mcu7t3v3__nor2_2_7/VSS
+ VSS VSS VSS gf180mcu_as_sc_mcu7t3v3__nand3_2_9/VNW VSUBS gf180mcu_as_sc_mcu7t3v3__nand2_2
Xgf180mcu_as_sc_mcu7t3v3__nor2_2_2 gf180mcu_as_sc_mcu7t3v3__nor2_2_7/VDD gf180mcu_as_sc_mcu7t3v3__nor2_2_7/VSS
+ VSS VSS VSS gf180mcu_as_sc_mcu7t3v3__nor2_2_7/VNW VSUBS gf180mcu_as_sc_mcu7t3v3__nor2_2
Xgf180mcu_as_sc_mcu7t3v3__inv_2_1305 VSS VSS VSS gf180mcu_as_sc_mcu7t3v3__inv_2_1306/Y
+ gf180mcu_as_sc_mcu7t3v3__inv_2_1307/VNW VSUBS gf180mcu_as_sc_mcu7t3v3__inv_2
Xgf180mcu_as_sc_mcu7t3v3__inv_2_1349 gf180mcu_as_sc_mcu7t3v3__inv_2_1349/VDD gf180mcu_as_sc_mcu7t3v3__inv_2_1349/VSS
+ gf180mcu_as_sc_mcu7t3v3__inv_2_1355/Y VSS gf180mcu_as_sc_mcu7t3v3__inv_2_1349/VNW
+ VSUBS gf180mcu_as_sc_mcu7t3v3__inv_2
Xgf180mcu_as_sc_mcu7t3v3__inv_2_1316 gf180mcu_as_sc_mcu7t3v3__inv_2_1316/VDD gf180mcu_as_sc_mcu7t3v3__inv_2_1320/VDD
+ gf180mcu_as_sc_mcu7t3v3__inv_2_1355/Y VSS gf180mcu_as_sc_mcu7t3v3__inv_2_1316/VNW
+ VSUBS gf180mcu_as_sc_mcu7t3v3__inv_2
Xgf180mcu_as_sc_mcu7t3v3__inv_2_1338 gf180mcu_as_sc_mcu7t3v3__inv_2_1340/VDD VSS VSS
+ gf180mcu_as_sc_mcu7t3v3__inv_2_1340/Y gf180mcu_as_sc_mcu7t3v3__inv_2_1340/VNW VSUBS
+ gf180mcu_as_sc_mcu7t3v3__inv_2
Xgf180mcu_as_sc_mcu7t3v3__inv_2_1327 gf180mcu_as_sc_mcu7t3v3__inv_2_1409/VSS VSS gf180mcu_as_sc_mcu7t3v3__inv_2_1327/Y
+ gf180mcu_as_sc_mcu7t3v3__inv_2_1409/A gf180mcu_as_sc_mcu7t3v3__inv_2_1328/VNW VSUBS
+ gf180mcu_as_sc_mcu7t3v3__inv_2
Xu_t028_012 u_t028_012/c0_w0_bl u_t028_012/c0_w0_br u_t028_012/c0_w1_bl u_t028_012/c0_w1_br
+ u_t028_012/c0_r0_rbl u_t028_012/c0_r1_rbl u_t028_012/c1_w0_bl u_t028_012/c1_w0_br
+ u_t028_012/c1_w1_bl u_t028_012/c1_w1_br u_t028_012/c1_r0_rbl u_t028_012/c1_r1_rbl
+ u_t028_012/c2_w0_bl u_t028_012/c2_w0_br u_t028_012/c2_w1_bl u_t028_012/c2_w1_br
+ u_t028_012/c2_r0_rbl u_t028_012/c2_r1_rbl u_t028_012/c3_w0_bl u_t028_012/c3_w0_br
+ u_t028_012/c3_w1_bl u_t028_012/c3_w1_br u_t028_012/c3_r0_rbl u_t028_012/c3_r1_rbl
+ u_t028_012/r0_w0_wl u_t028_012/r0_w1_wl u_t028_012/r0_r0_rwl u_t028_012/r0_r1_rwl
+ u_t028_012/r1_w0_wl u_t028_012/r1_w1_wl u_t028_012/r1_r0_rwl u_t028_012/r1_r1_rwl
+ u_t028_012/r2_w0_wl u_t028_012/r2_w1_wl u_t028_012/r2_r0_rwl u_t028_012/r2_r1_rwl
+ u_t028_012/r3_w0_wl u_t028_012/r3_w1_wl u_t028_012/r3_r0_rwl u_t028_012/r3_r1_rwl
+ u_t029_012/VDD u_t028_012/VSS u_t028_012/m2_717_1265# u_t028_012/m2_603_2031# u_t028_012/m2_1290_336#
+ u_t028_012/m2_2000_2037# u_t028_012/m2_791_2909# u_t028_012/m2_7_2126# u_t028_012/m2_2154_2081#
+ u_t028_012/m2_1795_2037# u_t028_012/m2_871_303# u_t028_012/m2_431_438# u_t028_012/m2_1290_2898#
+ u_t028_012/m2_1714_1210# u_t028_012/m2_431_1982# u_t028_012/m2_512_1265# u_t028_012/m2_2573_2126#
+ u_t028_012/m2_603_1259# u_t028_012/m2_2074_2909# u_t028_012/m2_7_336# u_t028_012/m2_717_2037#
+ u_t028_012/m2_1886_2031# u_t028_012/m2_2573_336# u_t028_012/m2_7_2898# u_t028_012/m2_2000_1265#
+ u_t028_012/m2_512_2037# u_t028_012/m2_1795_1265# u_t028_012/m2_1714_1982# u_t028_012/m2_1886_1259#
+ u_t028_012/m2_1290_2126# u_t028_012/m2_1714_438# u_t028_012/m2_431_1210# u_t028_012/m2_2573_2898#
+ u_t028_012/m2_2154_303# u_t028_012/m2_871_2081# VSUBS detronyx_12t_2w2r_rc4_4x4_routed_5layer_direct
Xu_t028_001 u_t028_001/c0_w0_bl u_t028_001/c0_w0_br u_t028_001/c0_w1_bl u_t028_001/c0_w1_br
+ u_t028_001/c0_r0_rbl u_t028_001/c0_r1_rbl u_t028_001/c1_w0_bl u_t028_001/c1_w0_br
+ u_t028_001/c1_w1_bl u_t028_001/c1_w1_br u_t028_001/c1_r0_rbl u_t028_001/c1_r1_rbl
+ u_t028_001/c2_w0_bl u_t028_001/c2_w0_br u_t028_001/c2_w1_bl u_t028_001/c2_w1_br
+ u_t028_001/c2_r0_rbl u_t028_001/c2_r1_rbl u_t028_001/c3_w0_bl u_t028_001/c3_w0_br
+ u_t028_001/c3_w1_bl u_t028_001/c3_w1_br u_t028_001/c3_r0_rbl u_t028_001/c3_r1_rbl
+ u_t028_001/r0_w0_wl u_t028_001/r0_w1_wl u_t028_001/r0_r0_rwl u_t028_001/r0_r1_rwl
+ u_t028_001/r1_w0_wl u_t028_001/r1_w1_wl u_t028_001/r1_r0_rwl u_t028_001/r1_r1_rwl
+ u_t028_001/r2_w0_wl u_t028_001/r2_w1_wl u_t028_001/r2_r0_rwl u_t028_001/r2_r1_rwl
+ u_t028_001/r3_w0_wl u_t028_001/r3_w1_wl u_t028_001/r3_r0_rwl u_t028_001/r3_r1_rwl
+ VSS VSS u_t028_001/m2_717_1265# u_t028_001/m2_603_2031# u_t028_001/m2_1290_336#
+ u_t028_001/m2_2000_2037# u_t028_001/m2_791_2909# u_t028_001/m2_7_2126# u_t028_001/m2_2154_2081#
+ u_t028_001/m2_1795_2037# u_t028_001/m2_871_303# u_t028_001/m2_431_438# u_t028_001/m2_1290_2898#
+ u_t028_001/m2_1714_1210# u_t028_001/m2_431_1982# u_t028_001/m2_512_1265# u_t028_001/m2_2573_2126#
+ u_t028_001/m2_603_1259# u_t028_001/m2_2074_2909# u_t028_001/m2_7_336# u_t028_001/m2_717_2037#
+ u_t028_001/m2_1886_2031# u_t028_001/m2_2573_336# u_t028_001/m2_7_2898# u_t028_001/m2_2000_1265#
+ u_t028_001/m2_512_2037# u_t028_001/m2_1795_1265# u_t028_001/m2_1714_1982# u_t028_001/m2_1886_1259#
+ u_t028_001/m2_1290_2126# u_t028_001/m2_1714_438# u_t028_001/m2_431_1210# u_t028_001/m2_2573_2898#
+ u_t028_001/m2_2154_303# u_t028_001/m2_871_2081# VSUBS detronyx_12t_2w2r_rc4_4x4_routed_5layer_direct
Xu_t019_012 u_t019_012/c0_w0_bl u_t019_012/c0_w0_br u_t019_012/c0_w1_bl u_t019_012/c0_w1_br
+ u_t019_012/c0_r0_rbl u_t019_012/c0_r1_rbl u_t019_012/c1_w0_bl u_t019_012/c1_w0_br
+ u_t019_012/c1_w1_bl u_t019_012/c1_w1_br u_t019_012/c1_r0_rbl u_t019_012/c1_r1_rbl
+ u_t019_012/c2_w0_bl u_t019_012/c2_w0_br u_t019_012/c2_w1_bl u_t019_012/c2_w1_br
+ u_t019_012/c2_r0_rbl u_t019_012/c2_r1_rbl u_t019_012/c3_w0_bl u_t019_012/c3_w0_br
+ u_t019_012/c3_w1_bl u_t019_012/c3_w1_br u_t019_012/c3_r0_rbl u_t019_012/c3_r1_rbl
+ u_t019_012/r0_w0_wl u_t019_012/r0_w1_wl u_t019_012/r0_r0_rwl u_t019_012/r0_r1_rwl
+ u_t019_012/r1_w0_wl u_t019_012/r1_w1_wl u_t019_012/r1_r0_rwl u_t019_012/r1_r1_rwl
+ u_t019_012/r2_w0_wl u_t019_012/r2_w1_wl u_t019_012/r2_r0_rwl u_t019_012/r2_r1_rwl
+ u_t019_012/r3_w0_wl u_t019_012/r3_w1_wl u_t019_012/r3_r0_rwl u_t019_012/r3_r1_rwl
+ u_t019_012/VDD u_t019_012/VSS u_t019_012/m2_717_1265# u_t019_012/m2_603_2031# u_t019_012/m2_1290_336#
+ u_t019_012/m2_2000_2037# u_t019_012/m2_791_2909# u_t019_012/m2_7_2126# u_t019_012/m2_2154_2081#
+ u_t019_012/m2_1795_2037# u_t019_012/m2_871_303# u_t019_012/m2_431_438# u_t019_012/m2_1290_2898#
+ u_t019_012/m2_1714_1210# u_t019_012/m2_431_1982# u_t019_012/m2_512_1265# u_t019_012/m2_2573_2126#
+ u_t019_012/m2_603_1259# u_t019_012/m2_2074_2909# u_t019_012/m2_7_336# u_t019_012/m2_717_2037#
+ u_t019_012/m2_1886_2031# u_t019_012/m2_2573_336# u_t019_012/m2_7_2898# u_t019_012/m2_2000_1265#
+ u_t019_012/m2_512_2037# u_t019_012/m2_1795_1265# u_t019_012/m2_1714_1982# u_t019_012/m2_1886_1259#
+ u_t019_012/m2_1290_2126# u_t019_012/m2_1714_438# u_t019_012/m2_431_1210# u_t019_012/m2_2573_2898#
+ u_t019_012/m2_2154_303# u_t019_012/m2_871_2081# VSUBS detronyx_12t_2w2r_rc4_4x4_routed_5layer_direct
Xu_t019_001 u_t019_001/c0_w0_bl u_t019_001/c0_w0_br u_t019_001/c0_w1_bl u_t019_001/c0_w1_br
+ u_t019_001/c0_r0_rbl u_t019_001/c0_r1_rbl u_t019_001/c1_w0_bl u_t019_001/c1_w0_br
+ u_t019_001/c1_w1_bl u_t019_001/c1_w1_br u_t019_001/c1_r0_rbl u_t019_001/c1_r1_rbl
+ u_t019_001/c2_w0_bl u_t019_001/c2_w0_br u_t019_001/c2_w1_bl u_t019_001/c2_w1_br
+ u_t019_001/c2_r0_rbl u_t019_001/c2_r1_rbl u_t019_001/c3_w0_bl u_t019_001/c3_w0_br
+ u_t019_001/c3_w1_bl u_t019_001/c3_w1_br u_t019_001/c3_r0_rbl u_t019_001/c3_r1_rbl
+ u_t019_001/r0_w0_wl u_t019_001/r0_w1_wl u_t019_001/r0_r0_rwl u_t019_001/r0_r1_rwl
+ u_t019_001/r1_w0_wl u_t019_001/r1_w1_wl u_t019_001/r1_r0_rwl u_t019_001/r1_r1_rwl
+ u_t019_001/r2_w0_wl u_t019_001/r2_w1_wl u_t019_001/r2_r0_rwl u_t019_001/r2_r1_rwl
+ u_t019_001/r3_w0_wl u_t019_001/r3_w1_wl u_t019_001/r3_r0_rwl u_t019_001/r3_r1_rwl
+ VSS VSS u_t019_001/m2_717_1265# u_t019_001/m2_603_2031# u_t019_001/m2_1290_336#
+ u_t019_001/m2_2000_2037# u_t019_001/m2_791_2909# u_t019_001/m2_7_2126# u_t019_001/m2_2154_2081#
+ u_t019_001/m2_1795_2037# u_t019_001/m2_871_303# u_t019_001/m2_431_438# u_t019_001/m2_1290_2898#
+ u_t019_001/m2_1714_1210# u_t019_001/m2_431_1982# u_t019_001/m2_512_1265# u_t019_001/m2_2573_2126#
+ u_t019_001/m2_603_1259# u_t019_001/m2_2074_2909# u_t019_001/m2_7_336# u_t019_001/m2_717_2037#
+ u_t019_001/m2_1886_2031# u_t019_001/m2_2573_336# u_t019_001/m2_7_2898# u_t019_001/m2_2000_1265#
+ u_t019_001/m2_512_2037# u_t019_001/m2_1795_1265# u_t019_001/m2_1714_1982# u_t019_001/m2_1886_1259#
+ u_t019_001/m2_1290_2126# u_t019_001/m2_1714_438# u_t019_001/m2_431_1210# u_t019_001/m2_2573_2898#
+ u_t019_001/m2_2154_303# u_t019_001/m2_871_2081# VSUBS detronyx_12t_2w2r_rc4_4x4_routed_5layer_direct
Xgf180mcu_as_sc_mcu7t3v3__nand4_2_16 gf180mcu_as_sc_mcu7t3v3__inv_2_131/VDD gf180mcu_as_sc_mcu7t3v3__inv_2_131/VDD
+ VSS VSS VSS VSS VSS gf180mcu_as_sc_mcu7t3v3__inv_2_128/VNW VSUBS gf180mcu_as_sc_mcu7t3v3__nand4_2
Xgf180mcu_as_sc_mcu7t3v3__nand4_2_38 VSS VSS VSS VSS VSS VSS VSS gf180mcu_as_sc_mcu7t3v3__inv_2_196/VNW
+ VSUBS gf180mcu_as_sc_mcu7t3v3__nand4_2
Xgf180mcu_as_sc_mcu7t3v3__nand4_2_27 gf180mcu_as_sc_mcu7t3v3__inv_2_177/VSS gf180mcu_as_sc_mcu7t3v3__inv_2_163/VDD
+ VSS VSS VSS VSS gf180mcu_as_sc_mcu7t3v3__nand4_2_27/Y gf180mcu_as_sc_mcu7t3v3__inv_2_160/VNW
+ VSUBS gf180mcu_as_sc_mcu7t3v3__nand4_2
Xgf180mcu_as_sc_mcu7t3v3__nand4_2_49 VSS gf180mcu_as_sc_mcu7t3v3__inv_2_260/VDD VSS
+ VSS VSS VSS gf180mcu_as_sc_mcu7t3v3__nand4_2_49/Y gf180mcu_as_sc_mcu7t3v3__inv_2_227/VNW
+ VSUBS gf180mcu_as_sc_mcu7t3v3__nand4_2
Xu_t025_015 u_t025_015/c0_w0_bl u_t025_015/c0_w0_br u_t025_015/c0_w1_bl u_t025_015/c0_w1_br
+ u_t025_015/c0_r0_rbl u_t025_015/c0_r1_rbl u_t025_015/c1_w0_bl u_t025_015/c1_w0_br
+ u_t025_015/c1_w1_bl u_t025_015/c1_w1_br u_t025_015/c1_r0_rbl u_t025_015/c1_r1_rbl
+ u_t025_015/c2_w0_bl u_t025_015/c2_w0_br u_t025_015/c2_w1_bl u_t025_015/c2_w1_br
+ u_t025_015/c2_r0_rbl u_t025_015/c2_r1_rbl u_t025_015/c3_w0_bl u_t025_015/c3_w0_br
+ u_t025_015/c3_w1_bl u_t025_015/c3_w1_br u_t025_015/c3_r0_rbl u_t025_015/c3_r1_rbl
+ u_t025_015/r0_w0_wl u_t025_015/r0_w1_wl u_t025_015/r0_r0_rwl u_t025_015/r0_r1_rwl
+ u_t025_015/r1_w0_wl u_t025_015/r1_w1_wl u_t025_015/r1_r0_rwl u_t025_015/r1_r1_rwl
+ u_t025_015/r2_w0_wl u_t025_015/r2_w1_wl u_t025_015/r2_r0_rwl u_t025_015/r2_r1_rwl
+ u_t025_015/r3_w0_wl u_t025_015/r3_w1_wl u_t025_015/r3_r0_rwl u_t025_015/r3_r1_rwl
+ VSS VSS u_t025_015/m2_717_1265# u_t025_015/m2_603_2031# u_t025_015/m2_1290_336#
+ u_t025_015/m2_2000_2037# u_t025_015/m2_791_2909# u_t025_015/m2_7_2126# u_t025_015/m2_2154_2081#
+ u_t025_015/m2_1795_2037# u_t025_015/m2_871_303# u_t025_015/m2_431_438# u_t025_015/m2_1290_2898#
+ u_t025_015/m2_1714_1210# u_t025_015/m2_431_1982# u_t025_015/m2_512_1265# u_t025_015/m2_2573_2126#
+ u_t025_015/m2_603_1259# u_t025_015/m2_2074_2909# u_t025_015/m2_7_336# u_t025_015/m2_717_2037#
+ u_t025_015/m2_1886_2031# u_t025_015/m2_2573_336# u_t025_015/m2_7_2898# u_t025_015/m2_2000_1265#
+ u_t025_015/m2_512_2037# u_t025_015/m2_1795_1265# u_t025_015/m2_1714_1982# u_t025_015/m2_1886_1259#
+ u_t025_015/m2_1290_2126# u_t025_015/m2_1714_438# u_t025_015/m2_431_1210# u_t025_015/m2_2573_2898#
+ u_t025_015/m2_2154_303# u_t025_015/m2_871_2081# VSUBS detronyx_12t_2w2r_rc4_4x4_routed_5layer_direct
Xu_t025_004 u_t025_004/c0_w0_bl u_t025_004/c0_w0_br u_t025_004/c0_w1_bl u_t025_004/c0_w1_br
+ u_t025_004/c0_r0_rbl u_t025_004/c0_r1_rbl u_t025_004/c1_w0_bl u_t025_004/c1_w0_br
+ u_t025_004/c1_w1_bl u_t025_004/c1_w1_br u_t025_004/c1_r0_rbl u_t025_004/c1_r1_rbl
+ u_t025_004/c2_w0_bl u_t025_004/c2_w0_br u_t025_004/c2_w1_bl u_t025_004/c2_w1_br
+ u_t025_004/c2_r0_rbl u_t025_004/c2_r1_rbl u_t025_004/c3_w0_bl u_t025_004/c3_w0_br
+ u_t025_004/c3_w1_bl u_t025_004/c3_w1_br u_t025_004/c3_r0_rbl u_t025_004/c3_r1_rbl
+ u_t025_004/r0_w0_wl u_t025_004/r0_w1_wl u_t025_004/r0_r0_rwl u_t025_004/r0_r1_rwl
+ u_t025_004/r1_w0_wl u_t025_004/r1_w1_wl u_t025_004/r1_r0_rwl u_t025_004/r1_r1_rwl
+ u_t025_004/r2_w0_wl u_t025_004/r2_w1_wl u_t025_004/r2_r0_rwl u_t025_004/r2_r1_rwl
+ u_t025_004/r3_w0_wl u_t025_004/r3_w1_wl u_t025_004/r3_r0_rwl u_t025_004/r3_r1_rwl
+ u_t025_004/VDD VSS u_t025_004/m2_717_1265# u_t025_004/m2_603_2031# u_t025_004/m2_1290_336#
+ u_t025_004/m2_2000_2037# u_t025_004/m2_791_2909# u_t025_004/m2_7_2126# u_t025_004/m2_2154_2081#
+ u_t025_004/m2_1795_2037# u_t025_004/m2_871_303# u_t025_004/m2_431_438# u_t025_004/m2_1290_2898#
+ u_t025_004/m2_1714_1210# u_t025_004/m2_431_1982# u_t025_004/m2_512_1265# u_t025_004/m2_2573_2126#
+ u_t025_004/m2_603_1259# u_t025_004/m2_2074_2909# u_t025_004/m2_7_336# u_t025_004/m2_717_2037#
+ u_t025_004/m2_1886_2031# u_t025_004/m2_2573_336# u_t025_004/m2_7_2898# u_t025_004/m2_2000_1265#
+ u_t025_004/m2_512_2037# u_t025_004/m2_1795_1265# u_t025_004/m2_1714_1982# u_t025_004/m2_1886_1259#
+ u_t025_004/m2_1290_2126# u_t025_004/m2_1714_438# u_t025_004/m2_431_1210# u_t025_004/m2_2573_2898#
+ u_t025_004/m2_2154_303# u_t025_004/m2_871_2081# VSUBS detronyx_12t_2w2r_rc4_4x4_routed_5layer_direct
Xgf180mcu_as_sc_mcu7t3v3__inv_2_1135 VSS gf180mcu_as_sc_mcu7t3v3__inv_2_1139/VDD VSS
+ gf180mcu_as_sc_mcu7t3v3__inv_2_1136/Y gf180mcu_as_sc_mcu7t3v3__inv_2_1136/VNW VSUBS
+ gf180mcu_as_sc_mcu7t3v3__inv_2
Xgf180mcu_as_sc_mcu7t3v3__inv_2_1113 gf180mcu_as_sc_mcu7t3v3__inv_2_1148/VSS VSS VSS
+ VSS gf180mcu_as_sc_mcu7t3v3__inv_2_1115/VNW VSUBS gf180mcu_as_sc_mcu7t3v3__inv_2
Xgf180mcu_as_sc_mcu7t3v3__inv_2_1146 gf180mcu_as_sc_mcu7t3v3__inv_2_1148/VDD gf180mcu_as_sc_mcu7t3v3__inv_2_1148/VSS
+ VSS VSS gf180mcu_as_sc_mcu7t3v3__inv_2_1148/VNW VSUBS gf180mcu_as_sc_mcu7t3v3__inv_2
Xgf180mcu_as_sc_mcu7t3v3__inv_2_1124 VSS VSS gf180mcu_as_sc_mcu7t3v3__inv_2_1124/Y
+ VSS gf180mcu_as_sc_mcu7t3v3__inv_2_1124/VNW VSUBS gf180mcu_as_sc_mcu7t3v3__inv_2
Xgf180mcu_as_sc_mcu7t3v3__inv_2_1157 VSS VSS gf180mcu_as_sc_mcu7t3v3__inv_2_1157/Y
+ VSS gf180mcu_as_sc_mcu7t3v3__inv_2_1290/VNW VSUBS gf180mcu_as_sc_mcu7t3v3__inv_2
Xgf180mcu_as_sc_mcu7t3v3__inv_2_1102 gf180mcu_as_sc_mcu7t3v3__inv_2_1103/VDD VSS gf180mcu_as_sc_mcu7t3v3__inv_2_1102/Y
+ gf180mcu_as_sc_mcu7t3v3__inv_2_1103/Y gf180mcu_as_sc_mcu7t3v3__inv_2_1103/VNW VSUBS
+ gf180mcu_as_sc_mcu7t3v3__inv_2
Xgf180mcu_as_sc_mcu7t3v3__inv_2_1168 VSS VSS gf180mcu_as_sc_mcu7t3v3__inv_2_1168/Y
+ VSS gf180mcu_as_sc_mcu7t3v3__inv_2_1301/VNW VSUBS gf180mcu_as_sc_mcu7t3v3__inv_2
Xgf180mcu_as_sc_mcu7t3v3__inv_2_1179 VSS VSS gf180mcu_as_sc_mcu7t3v3__inv_2_1179/Y
+ VSS gf180mcu_as_sc_mcu7t3v3__inv_2_1288/VNW VSUBS gf180mcu_as_sc_mcu7t3v3__inv_2
Xu_t016_015 u_t016_015/c0_w0_bl u_t016_015/c0_w0_br u_t016_015/c0_w1_bl u_t016_015/c0_w1_br
+ u_t016_015/c0_r0_rbl u_t016_015/c0_r1_rbl u_t016_015/c1_w0_bl u_t016_015/c1_w0_br
+ u_t016_015/c1_w1_bl u_t016_015/c1_w1_br u_t016_015/c1_r0_rbl u_t016_015/c1_r1_rbl
+ u_t016_015/c2_w0_bl u_t016_015/c2_w0_br u_t016_015/c2_w1_bl u_t016_015/c2_w1_br
+ u_t016_015/c2_r0_rbl u_t016_015/c2_r1_rbl u_t016_015/c3_w0_bl u_t016_015/c3_w0_br
+ u_t016_015/c3_w1_bl u_t016_015/c3_w1_br u_t016_015/c3_r0_rbl u_t016_015/c3_r1_rbl
+ u_t016_015/r0_w0_wl u_t016_015/r0_w1_wl u_t016_015/r0_r0_rwl u_t016_015/r0_r1_rwl
+ u_t016_015/r1_w0_wl u_t016_015/r1_w1_wl u_t016_015/r1_r0_rwl u_t016_015/r1_r1_rwl
+ u_t016_015/r2_w0_wl u_t016_015/r2_w1_wl u_t016_015/r2_r0_rwl u_t016_015/r2_r1_rwl
+ u_t016_015/r3_w0_wl u_t016_015/r3_w1_wl u_t016_015/r3_r0_rwl u_t016_015/r3_r1_rwl
+ VSS u_t016_015/VSS u_t016_015/m2_717_1265# u_t016_015/m2_603_2031# u_t016_015/m2_1290_336#
+ u_t016_015/m2_2000_2037# u_t016_015/m2_791_2909# u_t016_015/m2_7_2126# u_t016_015/m2_2154_2081#
+ u_t016_015/m2_1795_2037# u_t016_015/m2_871_303# u_t016_015/m2_431_438# u_t016_015/m2_1290_2898#
+ u_t016_015/m2_1714_1210# u_t016_015/m2_431_1982# u_t016_015/m2_512_1265# u_t016_015/m2_2573_2126#
+ u_t016_015/m2_603_1259# u_t016_015/m2_2074_2909# u_t016_015/m2_7_336# u_t016_015/m2_717_2037#
+ u_t016_015/m2_1886_2031# u_t016_015/m2_2573_336# u_t016_015/m2_7_2898# u_t016_015/m2_2000_1265#
+ u_t016_015/m2_512_2037# u_t016_015/m2_1795_1265# u_t016_015/m2_1714_1982# u_t016_015/m2_1886_1259#
+ u_t016_015/m2_1290_2126# u_t016_015/m2_1714_438# u_t016_015/m2_431_1210# u_t016_015/m2_2573_2898#
+ u_t016_015/m2_2154_303# u_t016_015/m2_871_2081# VSUBS detronyx_12t_2w2r_rc4_4x4_routed_5layer_direct
Xu_t016_004 u_t016_004/c0_w0_bl u_t016_004/c0_w0_br u_t016_004/c0_w1_bl u_t016_004/c0_w1_br
+ u_t016_004/c0_r0_rbl u_t016_004/c0_r1_rbl u_t016_004/c1_w0_bl u_t016_004/c1_w0_br
+ u_t016_004/c1_w1_bl u_t016_004/c1_w1_br u_t016_004/c1_r0_rbl u_t016_004/c1_r1_rbl
+ u_t016_004/c2_w0_bl u_t016_004/c2_w0_br u_t016_004/c2_w1_bl u_t016_004/c2_w1_br
+ u_t016_004/c2_r0_rbl u_t016_004/c2_r1_rbl u_t016_004/c3_w0_bl u_t016_004/c3_w0_br
+ u_t016_004/c3_w1_bl u_t016_004/c3_w1_br u_t016_004/c3_r0_rbl u_t016_004/c3_r1_rbl
+ u_t016_004/r0_w0_wl u_t016_004/r0_w1_wl u_t016_004/r0_r0_rwl u_t016_004/r0_r1_rwl
+ u_t016_004/r1_w0_wl u_t016_004/r1_w1_wl u_t016_004/r1_r0_rwl u_t016_004/r1_r1_rwl
+ u_t016_004/r2_w0_wl u_t016_004/r2_w1_wl u_t016_004/r2_r0_rwl u_t016_004/r2_r1_rwl
+ u_t016_004/r3_w0_wl u_t016_004/r3_w1_wl u_t016_004/r3_r0_rwl u_t016_004/r3_r1_rwl
+ u_t016_004/VDD u_t016_004/VSS u_t016_004/m2_717_1265# u_t016_004/m2_603_2031# u_t016_004/m2_1290_336#
+ u_t016_004/m2_2000_2037# u_t016_004/m2_791_2909# u_t016_004/m2_7_2126# u_t016_004/m2_2154_2081#
+ u_t016_004/m2_1795_2037# u_t016_004/m2_871_303# u_t016_004/m2_431_438# u_t016_004/m2_1290_2898#
+ u_t016_004/m2_1714_1210# u_t016_004/m2_431_1982# u_t016_004/m2_512_1265# u_t016_004/m2_2573_2126#
+ u_t016_004/m2_603_1259# u_t016_004/m2_2074_2909# u_t016_004/m2_7_336# u_t016_004/m2_717_2037#
+ u_t016_004/m2_1886_2031# u_t016_004/m2_2573_336# u_t016_004/m2_7_2898# u_t016_004/m2_2000_1265#
+ u_t016_004/m2_512_2037# u_t016_004/m2_1795_1265# u_t016_004/m2_1714_1982# u_t016_004/m2_1886_1259#
+ u_t016_004/m2_1290_2126# u_t016_004/m2_1714_438# u_t016_004/m2_431_1210# u_t016_004/m2_2573_2898#
+ u_t016_004/m2_2154_303# u_t016_004/m2_871_2081# VSUBS detronyx_12t_2w2r_rc4_4x4_routed_5layer_direct
Xgf180mcu_as_sc_mcu7t3v3__nand3_2_60 gf180mcu_as_sc_mcu7t3v3__nand3_2_65/VDD gf180mcu_as_sc_mcu7t3v3__nor2_2_9/VSS
+ VSS VSS VSS VSS gf180mcu_as_sc_mcu7t3v3__nand3_2_65/VNW VSUBS gf180mcu_as_sc_mcu7t3v3__nand3_2
Xgf180mcu_as_sc_mcu7t3v3__inv_2_608 VSS gf180mcu_as_sc_mcu7t3v3__inv_2_617/VDD gf180mcu_as_sc_mcu7t3v3__inv_2_608/Y
+ gf180mcu_as_sc_mcu7t3v3__inv_2_638/A gf180mcu_as_sc_mcu7t3v3__inv_2_610/VNW VSUBS
+ gf180mcu_as_sc_mcu7t3v3__inv_2
Xgf180mcu_as_sc_mcu7t3v3__inv_2_619 gf180mcu_as_sc_mcu7t3v3__inv_2_620/VDD gf180mcu_as_sc_mcu7t3v3__inv_2_624/VDD
+ gf180mcu_as_sc_mcu7t3v3__inv_2_619/Y gf180mcu_as_sc_mcu7t3v3__inv_2_620/Y gf180mcu_as_sc_mcu7t3v3__inv_2_620/VNW
+ VSUBS gf180mcu_as_sc_mcu7t3v3__inv_2
Xu_t031_007 u_t031_007/c0_w0_bl u_t031_007/c0_w0_br u_t031_007/c0_w1_bl u_t031_007/c0_w1_br
+ u_t031_007/c0_r0_rbl u_t031_007/c0_r1_rbl u_t031_007/c1_w0_bl u_t031_007/c1_w0_br
+ u_t031_007/c1_w1_bl u_t031_007/c1_w1_br u_t031_007/c1_r0_rbl u_t031_007/c1_r1_rbl
+ u_t031_007/c2_w0_bl u_t031_007/c2_w0_br u_t031_007/c2_w1_bl u_t031_007/c2_w1_br
+ u_t031_007/c2_r0_rbl u_t031_007/c2_r1_rbl u_t031_007/c3_w0_bl u_t031_007/c3_w0_br
+ u_t031_007/c3_w1_bl u_t031_007/c3_w1_br u_t031_007/c3_r0_rbl u_t031_007/c3_r1_rbl
+ u_t031_007/r0_w0_wl u_t031_007/r0_w1_wl u_t031_007/r0_r0_rwl u_t031_007/r0_r1_rwl
+ u_t031_007/r1_w0_wl u_t031_007/r1_w1_wl u_t031_007/r1_r0_rwl u_t031_007/r1_r1_rwl
+ u_t031_007/r2_w0_wl u_t031_007/r2_w1_wl u_t031_007/r2_r0_rwl u_t031_007/r2_r1_rwl
+ u_t031_007/r3_w0_wl u_t031_007/r3_w1_wl u_t031_007/r3_r0_rwl u_t031_007/r3_r1_rwl
+ VSS u_t031_009/VSS u_t031_007/m2_717_1265# u_t031_007/m2_603_2031# u_t031_007/m2_1290_336#
+ u_t031_007/m2_2000_2037# u_t031_007/m2_791_2909# u_t031_007/m2_7_2126# u_t031_007/m2_2154_2081#
+ u_t031_007/m2_1795_2037# u_t031_007/m2_871_303# u_t031_007/m2_431_438# u_t031_007/m2_1290_2898#
+ u_t031_007/m2_1714_1210# u_t031_007/m2_431_1982# u_t031_007/m2_512_1265# u_t031_007/m2_2573_2126#
+ u_t031_007/m2_603_1259# u_t031_007/m2_2074_2909# u_t031_007/m2_7_336# u_t031_007/m2_717_2037#
+ u_t031_007/m2_1886_2031# u_t031_007/m2_2573_336# u_t031_007/m2_7_2898# u_t031_007/m2_2000_1265#
+ u_t031_007/m2_512_2037# u_t031_007/m2_1795_1265# u_t031_007/m2_1714_1982# u_t031_007/m2_1886_1259#
+ u_t031_007/m2_1290_2126# u_t031_007/m2_1714_438# u_t031_007/m2_431_1210# u_t031_007/m2_2573_2898#
+ u_t031_007/m2_2154_303# u_t031_007/m2_871_2081# VSUBS detronyx_12t_2w2r_rc4_4x4_routed_5layer_direct
Xgf180mcu_as_sc_mcu7t3v3__inv_2_1680 VSS gf180mcu_as_sc_mcu7t3v3__inv_2_1684/VDD gf180mcu_as_sc_mcu7t3v3__inv_2_1684/Y
+ VSS gf180mcu_as_sc_mcu7t3v3__inv_2_1680/VNW VSUBS gf180mcu_as_sc_mcu7t3v3__inv_2
Xgf180mcu_as_sc_mcu7t3v3__inv_2_1691 VSS gf180mcu_as_sc_mcu7t3v3__inv_2_1691/VSS gf180mcu_as_sc_mcu7t3v3__inv_2_1691/Y
+ gf180mcu_as_sc_mcu7t3v3__inv_2_1694/Y gf180mcu_as_sc_mcu7t3v3__inv_2_1691/VNW VSUBS
+ gf180mcu_as_sc_mcu7t3v3__inv_2
Xu_t007_015 u_t007_015/c0_w0_bl u_t007_015/c0_w0_br u_t007_015/c0_w1_bl u_t007_015/c0_w1_br
+ u_t007_015/c0_r0_rbl u_t007_015/c0_r1_rbl u_t007_015/c1_w0_bl u_t007_015/c1_w0_br
+ u_t007_015/c1_w1_bl u_t007_015/c1_w1_br u_t007_015/c1_r0_rbl u_t007_015/c1_r1_rbl
+ u_t007_015/c2_w0_bl u_t007_015/c2_w0_br u_t007_015/c2_w1_bl u_t007_015/c2_w1_br
+ u_t007_015/c2_r0_rbl u_t007_015/c2_r1_rbl u_t007_015/c3_w0_bl u_t007_015/c3_w0_br
+ u_t007_015/c3_w1_bl u_t007_015/c3_w1_br u_t007_015/c3_r0_rbl u_t007_015/c3_r1_rbl
+ u_t007_015/r0_w0_wl u_t007_015/r0_w1_wl u_t007_015/r0_r0_rwl u_t007_015/r0_r1_rwl
+ u_t007_015/r1_w0_wl u_t007_015/r1_w1_wl u_t007_015/r1_r0_rwl u_t007_015/r1_r1_rwl
+ u_t007_015/r2_w0_wl u_t007_015/r2_w1_wl u_t007_015/r2_r0_rwl u_t007_015/r2_r1_rwl
+ u_t007_015/r3_w0_wl u_t007_015/r3_w1_wl u_t007_015/r3_r0_rwl u_t007_015/r3_r1_rwl
+ VSS u_t007_015/VSS u_t007_015/m2_717_1265# u_t007_015/m2_603_2031# u_t007_015/m2_1290_336#
+ u_t007_015/m2_2000_2037# u_t007_015/m2_791_2909# u_t007_015/m2_7_2126# u_t007_015/m2_2154_2081#
+ u_t007_015/m2_1795_2037# u_t007_015/m2_871_303# u_t007_015/m2_431_438# u_t007_015/m2_1290_2898#
+ u_t007_015/m2_1714_1210# u_t007_015/m2_431_1982# u_t007_015/m2_512_1265# u_t007_015/m2_2573_2126#
+ u_t007_015/m2_603_1259# u_t007_015/m2_2074_2909# u_t007_015/m2_7_336# u_t007_015/m2_717_2037#
+ u_t007_015/m2_1886_2031# u_t007_015/m2_2573_336# u_t007_015/m2_7_2898# u_t007_015/m2_2000_1265#
+ u_t007_015/m2_512_2037# u_t007_015/m2_1795_1265# u_t007_015/m2_1714_1982# u_t007_015/m2_1886_1259#
+ u_t007_015/m2_1290_2126# u_t007_015/m2_1714_438# u_t007_015/m2_431_1210# u_t007_015/m2_2573_2898#
+ u_t007_015/m2_2154_303# u_t007_015/m2_871_2081# VSUBS detronyx_12t_2w2r_rc4_4x4_routed_5layer_direct
Xu_t022_007 u_t022_007/c0_w0_bl u_t022_007/c0_w0_br u_t022_007/c0_w1_bl u_t022_007/c0_w1_br
+ u_t022_007/c0_r0_rbl u_t022_007/c0_r1_rbl u_t022_007/c1_w0_bl u_t022_007/c1_w0_br
+ u_t022_007/c1_w1_bl u_t022_007/c1_w1_br u_t022_007/c1_r0_rbl u_t022_007/c1_r1_rbl
+ u_t022_007/c2_w0_bl u_t022_007/c2_w0_br u_t022_007/c2_w1_bl u_t022_007/c2_w1_br
+ u_t022_007/c2_r0_rbl u_t022_007/c2_r1_rbl u_t022_007/c3_w0_bl u_t022_007/c3_w0_br
+ u_t022_007/c3_w1_bl u_t022_007/c3_w1_br u_t022_007/c3_r0_rbl u_t022_007/c3_r1_rbl
+ u_t022_007/r0_w0_wl u_t022_007/r0_w1_wl u_t022_007/r0_r0_rwl u_t022_007/r0_r1_rwl
+ u_t022_007/r1_w0_wl u_t022_007/r1_w1_wl u_t022_007/r1_r0_rwl u_t022_007/r1_r1_rwl
+ u_t022_007/r2_w0_wl u_t022_007/r2_w1_wl u_t022_007/r2_r0_rwl u_t022_007/r2_r1_rwl
+ u_t022_007/r3_w0_wl u_t022_007/r3_w1_wl u_t022_007/r3_r0_rwl u_t022_007/r3_r1_rwl
+ VSS VSS u_t022_007/m2_717_1265# u_t022_007/m2_603_2031# u_t022_007/m2_1290_336#
+ u_t022_007/m2_2000_2037# u_t022_007/m2_791_2909# u_t022_007/m2_7_2126# u_t022_007/m2_2154_2081#
+ u_t022_007/m2_1795_2037# u_t022_007/m2_871_303# u_t022_007/m2_431_438# u_t022_007/m2_1290_2898#
+ u_t022_007/m2_1714_1210# u_t022_007/m2_431_1982# u_t022_007/m2_512_1265# u_t022_007/m2_2573_2126#
+ u_t022_007/m2_603_1259# u_t022_007/m2_2074_2909# u_t022_007/m2_7_336# u_t022_007/m2_717_2037#
+ u_t022_007/m2_1886_2031# u_t022_007/m2_2573_336# u_t022_007/m2_7_2898# u_t022_007/m2_2000_1265#
+ u_t022_007/m2_512_2037# u_t022_007/m2_1795_1265# u_t022_007/m2_1714_1982# u_t022_007/m2_1886_1259#
+ u_t022_007/m2_1290_2126# u_t022_007/m2_1714_438# u_t022_007/m2_431_1210# u_t022_007/m2_2573_2898#
+ u_t022_007/m2_2154_303# u_t022_007/m2_871_2081# VSUBS detronyx_12t_2w2r_rc4_4x4_routed_5layer_direct
Xu_t007_004 u_t007_004/c0_w0_bl u_t007_004/c0_w0_br u_t007_004/c0_w1_bl u_t007_004/c0_w1_br
+ u_t007_004/c0_r0_rbl u_t007_004/c0_r1_rbl u_t007_004/c1_w0_bl u_t007_004/c1_w0_br
+ u_t007_004/c1_w1_bl u_t007_004/c1_w1_br u_t007_004/c1_r0_rbl u_t007_004/c1_r1_rbl
+ u_t007_004/c2_w0_bl u_t007_004/c2_w0_br u_t007_004/c2_w1_bl u_t007_004/c2_w1_br
+ u_t007_004/c2_r0_rbl u_t007_004/c2_r1_rbl u_t007_004/c3_w0_bl u_t007_004/c3_w0_br
+ u_t007_004/c3_w1_bl u_t007_004/c3_w1_br u_t007_004/c3_r0_rbl u_t007_004/c3_r1_rbl
+ u_t007_004/r0_w0_wl u_t007_004/r0_w1_wl u_t007_004/r0_r0_rwl u_t007_004/r0_r1_rwl
+ u_t007_004/r1_w0_wl u_t007_004/r1_w1_wl u_t007_004/r1_r0_rwl u_t007_004/r1_r1_rwl
+ u_t007_004/r2_w0_wl u_t007_004/r2_w1_wl u_t007_004/r2_r0_rwl u_t007_004/r2_r1_rwl
+ u_t007_004/r3_w0_wl u_t007_004/r3_w1_wl u_t007_004/r3_r0_rwl u_t007_004/r3_r1_rwl
+ u_t008_004/VDD u_t007_004/VSS u_t007_004/m2_717_1265# u_t007_004/m2_603_2031# u_t007_004/m2_1290_336#
+ u_t007_004/m2_2000_2037# u_t007_004/m2_791_2909# u_t007_004/m2_7_2126# u_t007_004/m2_2154_2081#
+ u_t007_004/m2_1795_2037# u_t007_004/m2_871_303# u_t007_004/m2_431_438# u_t007_004/m2_1290_2898#
+ u_t007_004/m2_1714_1210# u_t007_004/m2_431_1982# u_t007_004/m2_512_1265# u_t007_004/m2_2573_2126#
+ u_t007_004/m2_603_1259# u_t007_004/m2_2074_2909# u_t007_004/m2_7_336# u_t007_004/m2_717_2037#
+ u_t007_004/m2_1886_2031# u_t007_004/m2_2573_336# u_t007_004/m2_7_2898# u_t007_004/m2_2000_1265#
+ u_t007_004/m2_512_2037# u_t007_004/m2_1795_1265# u_t007_004/m2_1714_1982# u_t007_004/m2_1886_1259#
+ u_t007_004/m2_1290_2126# u_t007_004/m2_1714_438# u_t007_004/m2_431_1210# u_t007_004/m2_2573_2898#
+ u_t007_004/m2_2154_303# u_t007_004/m2_871_2081# VSUBS detronyx_12t_2w2r_rc4_4x4_routed_5layer_direct
Xgf180mcu_as_sc_mcu7t3v3__nand4_2_441 gf180mcu_as_sc_mcu7t3v3__inv_2_1594/VDD VSS
+ VSS VSS VSS VSS VSS gf180mcu_as_sc_mcu7t3v3__inv_2_1594/VNW VSUBS gf180mcu_as_sc_mcu7t3v3__nand4_2
Xgf180mcu_as_sc_mcu7t3v3__nand4_2_496 VSS gf180mcu_as_sc_mcu7t3v3__inv_2_1626/VDD
+ VSS VSS VSS VSS VSS gf180mcu_as_sc_mcu7t3v3__inv_2_1622/VNW VSUBS gf180mcu_as_sc_mcu7t3v3__nand4_2
Xgf180mcu_as_sc_mcu7t3v3__nand4_2_485 VSS VSS VSS VSS VSS VSS VSS gf180mcu_as_sc_mcu7t3v3__inv_2_1664/VNW
+ VSUBS gf180mcu_as_sc_mcu7t3v3__nand4_2
Xgf180mcu_as_sc_mcu7t3v3__nand4_2_430 gf180mcu_as_sc_mcu7t3v3__inv_2_1562/VDD gf180mcu_as_sc_mcu7t3v3__inv_2_1562/VSS
+ VSS VSS VSS VSS gf180mcu_as_sc_mcu7t3v3__nand4_2_430/Y gf180mcu_as_sc_mcu7t3v3__inv_2_1562/VNW
+ VSUBS gf180mcu_as_sc_mcu7t3v3__nand4_2
Xgf180mcu_as_sc_mcu7t3v3__nand4_2_474 VSS gf180mcu_as_sc_mcu7t3v3__inv_2_1406/VDD
+ VSS VSS VSS VSS VSS gf180mcu_as_sc_mcu7t3v3__inv_2_1402/VNW VSUBS gf180mcu_as_sc_mcu7t3v3__nand4_2
Xgf180mcu_as_sc_mcu7t3v3__nand4_2_452 VSS VSS VSS VSS VSS VSS VSS gf180mcu_as_sc_mcu7t3v3__inv_2_1344/VNW
+ VSUBS gf180mcu_as_sc_mcu7t3v3__nand4_2
Xgf180mcu_as_sc_mcu7t3v3__nand4_2_463 VSS gf180mcu_as_sc_mcu7t3v3__inv_2_1409/VDD
+ VSS VSS VSS VSS VSS gf180mcu_as_sc_mcu7t3v3__inv_2_1358/VNW VSUBS gf180mcu_as_sc_mcu7t3v3__nand4_2
Xu_t013_007 u_t013_007/c0_w0_bl u_t013_007/c0_w0_br u_t013_007/c0_w1_bl u_t013_007/c0_w1_br
+ u_t013_007/c0_r0_rbl u_t013_007/c0_r1_rbl u_t013_007/c1_w0_bl u_t013_007/c1_w0_br
+ u_t013_007/c1_w1_bl u_t013_007/c1_w1_br u_t013_007/c1_r0_rbl u_t013_007/c1_r1_rbl
+ u_t013_007/c2_w0_bl u_t013_007/c2_w0_br u_t013_007/c2_w1_bl u_t013_007/c2_w1_br
+ u_t013_007/c2_r0_rbl u_t013_007/c2_r1_rbl u_t013_007/c3_w0_bl u_t013_007/c3_w0_br
+ u_t013_007/c3_w1_bl u_t013_007/c3_w1_br u_t013_007/c3_r0_rbl u_t013_007/c3_r1_rbl
+ u_t013_007/r0_w0_wl u_t013_007/r0_w1_wl u_t013_007/r0_r0_rwl u_t013_007/r0_r1_rwl
+ u_t013_007/r1_w0_wl u_t013_007/r1_w1_wl u_t013_007/r1_r0_rwl u_t013_007/r1_r1_rwl
+ u_t013_007/r2_w0_wl u_t013_007/r2_w1_wl u_t013_007/r2_r0_rwl u_t013_007/r2_r1_rwl
+ u_t013_007/r3_w0_wl u_t013_007/r3_w1_wl u_t013_007/r3_r0_rwl u_t013_007/r3_r1_rwl
+ VSS VSS u_t013_007/m2_717_1265# u_t013_007/m2_603_2031# u_t013_007/m2_1290_336#
+ u_t013_007/m2_2000_2037# u_t013_007/m2_791_2909# u_t013_007/m2_7_2126# u_t013_007/m2_2154_2081#
+ u_t013_007/m2_1795_2037# u_t013_007/m2_871_303# u_t013_007/m2_431_438# u_t013_007/m2_1290_2898#
+ u_t013_007/m2_1714_1210# u_t013_007/m2_431_1982# u_t013_007/m2_512_1265# u_t013_007/m2_2573_2126#
+ u_t013_007/m2_603_1259# u_t013_007/m2_2074_2909# u_t013_007/m2_7_336# u_t013_007/m2_717_2037#
+ u_t013_007/m2_1886_2031# u_t013_007/m2_2573_336# u_t013_007/m2_7_2898# u_t013_007/m2_2000_1265#
+ u_t013_007/m2_512_2037# u_t013_007/m2_1795_1265# u_t013_007/m2_1714_1982# u_t013_007/m2_1886_1259#
+ u_t013_007/m2_1290_2126# u_t013_007/m2_1714_438# u_t013_007/m2_431_1210# u_t013_007/m2_2573_2898#
+ u_t013_007/m2_2154_303# u_t013_007/m2_871_2081# VSUBS detronyx_12t_2w2r_rc4_4x4_routed_5layer_direct
Xu_t004_007 u_t004_007/c0_w0_bl u_t004_007/c0_w0_br u_t004_007/c0_w1_bl u_t004_007/c0_w1_br
+ u_t004_007/c0_r0_rbl u_t004_007/c0_r1_rbl u_t004_007/c1_w0_bl u_t004_007/c1_w0_br
+ u_t004_007/c1_w1_bl u_t004_007/c1_w1_br u_t004_007/c1_r0_rbl u_t004_007/c1_r1_rbl
+ u_t004_007/c2_w0_bl u_t004_007/c2_w0_br u_t004_007/c2_w1_bl u_t004_007/c2_w1_br
+ u_t004_007/c2_r0_rbl u_t004_007/c2_r1_rbl u_t004_007/c3_w0_bl u_t004_007/c3_w0_br
+ u_t004_007/c3_w1_bl u_t004_007/c3_w1_br u_t004_007/c3_r0_rbl u_t004_007/c3_r1_rbl
+ u_t004_007/r0_w0_wl u_t004_007/r0_w1_wl u_t004_007/r0_r0_rwl u_t004_007/r0_r1_rwl
+ u_t004_007/r1_w0_wl u_t004_007/r1_w1_wl u_t004_007/r1_r0_rwl u_t004_007/r1_r1_rwl
+ u_t004_007/r2_w0_wl u_t004_007/r2_w1_wl u_t004_007/r2_r0_rwl u_t004_007/r2_r1_rwl
+ u_t004_007/r3_w0_wl u_t004_007/r3_w1_wl u_t004_007/r3_r0_rwl u_t004_007/r3_r1_rwl
+ VSS VSS u_t004_007/m2_717_1265# u_t004_007/m2_603_2031# u_t004_007/m2_1290_336#
+ u_t004_007/m2_2000_2037# u_t004_007/m2_791_2909# u_t004_007/m2_7_2126# u_t004_007/m2_2154_2081#
+ u_t004_007/m2_1795_2037# u_t004_007/m2_871_303# u_t004_007/m2_431_438# u_t004_007/m2_1290_2898#
+ u_t004_007/m2_1714_1210# u_t004_007/m2_431_1982# u_t004_007/m2_512_1265# u_t004_007/m2_2573_2126#
+ u_t004_007/m2_603_1259# u_t004_007/m2_2074_2909# u_t004_007/m2_7_336# u_t004_007/m2_717_2037#
+ u_t004_007/m2_1886_2031# u_t004_007/m2_2573_336# u_t004_007/m2_7_2898# u_t004_007/m2_2000_1265#
+ u_t004_007/m2_512_2037# u_t004_007/m2_1795_1265# u_t004_007/m2_1714_1982# u_t004_007/m2_1886_1259#
+ u_t004_007/m2_1290_2126# u_t004_007/m2_1714_438# u_t004_007/m2_431_1210# u_t004_007/m2_2573_2898#
+ u_t004_007/m2_2154_303# u_t004_007/m2_871_2081# VSUBS detronyx_12t_2w2r_rc4_4x4_routed_5layer_direct
Xgf180mcu_as_sc_mcu7t3v3__inv_2_438 VSS VSS VSS VSS gf180mcu_as_sc_mcu7t3v3__inv_2_551/VNW
+ VSUBS gf180mcu_as_sc_mcu7t3v3__inv_2
Xgf180mcu_as_sc_mcu7t3v3__inv_2_427 gf180mcu_as_sc_mcu7t3v3__nor2_2_6/VDD gf180mcu_as_sc_mcu7t3v3__nand3_2_4/VSS
+ VSS VSS gf180mcu_as_sc_mcu7t3v3__nor2_2_6/VNW VSUBS gf180mcu_as_sc_mcu7t3v3__inv_2
Xgf180mcu_as_sc_mcu7t3v3__inv_2_405 gf180mcu_as_sc_mcu7t3v3__nand3_2_9/VDD gf180mcu_as_sc_mcu7t3v3__nor2_2_7/VSS
+ VSS VSS gf180mcu_as_sc_mcu7t3v3__nand3_2_9/VNW VSUBS gf180mcu_as_sc_mcu7t3v3__inv_2
Xgf180mcu_as_sc_mcu7t3v3__inv_2_416 gf180mcu_as_sc_mcu7t3v3__nand3_2_9/VDD gf180mcu_as_sc_mcu7t3v3__nor2_2_4/VSS
+ VSS VSS gf180mcu_as_sc_mcu7t3v3__nand3_2_9/VNW VSUBS gf180mcu_as_sc_mcu7t3v3__inv_2
Xgf180mcu_as_sc_mcu7t3v3__inv_2_449 gf180mcu_as_sc_mcu7t3v3__nand3_2_9/VDD gf180mcu_as_sc_mcu7t3v3__nor2_2_7/VSS
+ VSS VSS gf180mcu_as_sc_mcu7t3v3__nand3_2_9/VNW VSUBS gf180mcu_as_sc_mcu7t3v3__inv_2
Xgf180mcu_as_sc_mcu7t3v3__inv_2_950 VSS VSS VSS VSS gf180mcu_as_sc_mcu7t3v3__inv_2_950/VNW
+ VSUBS gf180mcu_as_sc_mcu7t3v3__inv_2
Xgf180mcu_as_sc_mcu7t3v3__inv_2_994 gf180mcu_as_sc_mcu7t3v3__inv_2_996/VDD gf180mcu_as_sc_mcu7t3v3__inv_2_999/VDD
+ VSS gf180mcu_as_sc_mcu7t3v3__inv_2_998/A gf180mcu_as_sc_mcu7t3v3__inv_2_996/VNW
+ VSUBS gf180mcu_as_sc_mcu7t3v3__inv_2
Xgf180mcu_as_sc_mcu7t3v3__inv_2_983 gf180mcu_as_sc_mcu7t3v3__inv_2_984/VDD gf180mcu_as_sc_mcu7t3v3__inv_2_988/VDD
+ gf180mcu_as_sc_mcu7t3v3__inv_2_983/Y gf180mcu_as_sc_mcu7t3v3__inv_2_984/Y gf180mcu_as_sc_mcu7t3v3__inv_2_984/VNW
+ VSUBS gf180mcu_as_sc_mcu7t3v3__inv_2
Xgf180mcu_as_sc_mcu7t3v3__inv_2_961 VSS gf180mcu_as_sc_mcu7t3v3__inv_2_989/VDD VSS
+ gf180mcu_as_sc_mcu7t3v3__inv_2_998/A gf180mcu_as_sc_mcu7t3v3__inv_2_969/VNW VSUBS
+ gf180mcu_as_sc_mcu7t3v3__inv_2
Xgf180mcu_as_sc_mcu7t3v3__inv_2_972 VSS gf180mcu_as_sc_mcu7t3v3__inv_2_985/VDD gf180mcu_as_sc_mcu7t3v3__inv_2_972/Y
+ VSS gf180mcu_as_sc_mcu7t3v3__inv_2_972/VNW VSUBS gf180mcu_as_sc_mcu7t3v3__inv_2
Xgf180mcu_as_sc_mcu7t3v3__nand4_2_271 VSS VSS VSS VSS VSS VSS VSS gf180mcu_as_sc_mcu7t3v3__inv_2_951/VNW
+ VSUBS gf180mcu_as_sc_mcu7t3v3__nand4_2
Xgf180mcu_as_sc_mcu7t3v3__nand4_2_260 VSS VSS VSS VSS VSS VSS gf180mcu_as_sc_mcu7t3v3__nand4_2_260/Y
+ gf180mcu_as_sc_mcu7t3v3__inv_2_931/VNW VSUBS gf180mcu_as_sc_mcu7t3v3__nand4_2
Xgf180mcu_as_sc_mcu7t3v3__nand4_2_282 VSS VSS VSS VSS VSS VSS VSS gf180mcu_as_sc_mcu7t3v3__inv_2_955/VNW
+ VSUBS gf180mcu_as_sc_mcu7t3v3__nand4_2
Xgf180mcu_as_sc_mcu7t3v3__nand4_2_293 gf180mcu_as_sc_mcu7t3v3__inv_2_996/VDD gf180mcu_as_sc_mcu7t3v3__inv_2_999/VDD
+ VSS VSS VSS VSS VSS gf180mcu_as_sc_mcu7t3v3__inv_2_996/VNW VSUBS gf180mcu_as_sc_mcu7t3v3__nand4_2
Xgf180mcu_as_sc_mcu7t3v3__inv_2_268 VSS gf180mcu_as_sc_mcu7t3v3__inv_2_281/VDD gf180mcu_as_sc_mcu7t3v3__inv_2_61/Y
+ VSS gf180mcu_as_sc_mcu7t3v3__inv_2_268/VNW VSUBS gf180mcu_as_sc_mcu7t3v3__inv_2
Xgf180mcu_as_sc_mcu7t3v3__inv_2_202 VSS gf180mcu_as_sc_mcu7t3v3__inv_2_203/VSS gf180mcu_as_sc_mcu7t3v3__inv_2_202/Y
+ VSS gf180mcu_as_sc_mcu7t3v3__inv_2_203/VNW VSUBS gf180mcu_as_sc_mcu7t3v3__inv_2
Xgf180mcu_as_sc_mcu7t3v3__inv_2_279 gf180mcu_as_sc_mcu7t3v3__inv_2_279/VDD VSS gf180mcu_as_sc_mcu7t3v3__inv_2_365/Y
+ VSS gf180mcu_as_sc_mcu7t3v3__inv_2_279/VNW VSUBS gf180mcu_as_sc_mcu7t3v3__inv_2
Xgf180mcu_as_sc_mcu7t3v3__inv_2_224 VSS VSS gf180mcu_as_sc_mcu7t3v3__inv_2_224/Y VSS
+ gf180mcu_as_sc_mcu7t3v3__inv_2_224/VNW VSUBS gf180mcu_as_sc_mcu7t3v3__inv_2
Xgf180mcu_as_sc_mcu7t3v3__inv_2_213 VSS gf180mcu_as_sc_mcu7t3v3__inv_2_218/VDD gf180mcu_as_sc_mcu7t3v3__inv_2_213/Y
+ VSS gf180mcu_as_sc_mcu7t3v3__inv_2_215/VNW VSUBS gf180mcu_as_sc_mcu7t3v3__inv_2
Xgf180mcu_as_sc_mcu7t3v3__inv_2_257 gf180mcu_as_sc_mcu7t3v3__inv_2_257/VDD gf180mcu_as_sc_mcu7t3v3__inv_2_257/VSS
+ gf180mcu_as_sc_mcu7t3v3__inv_2_257/Y VSS gf180mcu_as_sc_mcu7t3v3__inv_2_257/VNW
+ VSUBS gf180mcu_as_sc_mcu7t3v3__inv_2
Xgf180mcu_as_sc_mcu7t3v3__inv_2_246 gf180mcu_as_sc_mcu7t3v3__inv_2_248/VDD gf180mcu_as_sc_mcu7t3v3__inv_2_251/VDD
+ gf180mcu_as_sc_mcu7t3v3__inv_2_246/Y VSS gf180mcu_as_sc_mcu7t3v3__inv_2_248/VNW
+ VSUBS gf180mcu_as_sc_mcu7t3v3__inv_2
Xgf180mcu_as_sc_mcu7t3v3__inv_2_235 VSS gf180mcu_as_sc_mcu7t3v3__inv_2_239/VDD gf180mcu_as_sc_mcu7t3v3__inv_2_235/Y
+ VSS gf180mcu_as_sc_mcu7t3v3__inv_2_236/VNW VSUBS gf180mcu_as_sc_mcu7t3v3__inv_2
Xu_t000_010 u_t000_010/c0_w0_bl u_t000_010/c0_w0_br u_t000_010/c0_w1_bl u_t000_010/c0_w1_br
+ u_t000_010/c0_r0_rbl u_t000_010/c0_r1_rbl u_t000_010/c1_w0_bl u_t000_010/c1_w0_br
+ u_t000_010/c1_w1_bl u_t000_010/c1_w1_br u_t000_010/c1_r0_rbl u_t000_010/c1_r1_rbl
+ u_t000_010/c2_w0_bl u_t000_010/c2_w0_br u_t000_010/c2_w1_bl u_t000_010/c2_w1_br
+ u_t000_010/c2_r0_rbl u_t000_010/c2_r1_rbl u_t000_010/c3_w0_bl u_t000_010/c3_w0_br
+ u_t000_010/c3_w1_bl u_t000_010/c3_w1_br u_t000_010/c3_r0_rbl u_t000_010/c3_r1_rbl
+ u_t000_010/r0_w0_wl u_t000_010/r0_w1_wl u_t000_010/r0_r0_rwl u_t000_010/r0_r1_rwl
+ u_t000_010/r1_w0_wl u_t000_010/r1_w1_wl u_t000_010/r1_r0_rwl u_t000_010/r1_r1_rwl
+ u_t000_010/r2_w0_wl u_t000_010/r2_w1_wl u_t000_010/r2_r0_rwl u_t000_010/r2_r1_rwl
+ u_t000_010/r3_w0_wl u_t000_010/r3_w1_wl u_t000_010/r3_r0_rwl u_t000_010/r3_r1_rwl
+ VSS VSS u_t000_010/m2_717_1265# u_t000_010/m2_603_2031# u_t000_010/m2_1290_336#
+ u_t000_010/m2_2000_2037# u_t000_010/m2_791_2909# u_t000_010/m2_7_2126# u_t000_010/m2_2154_2081#
+ u_t000_010/m2_1795_2037# u_t000_010/m2_871_303# u_t000_010/m2_431_438# u_t000_010/m2_1290_2898#
+ u_t000_010/m2_1714_1210# u_t000_010/m2_431_1982# u_t000_010/m2_512_1265# u_t000_010/m2_2573_2126#
+ u_t000_010/m2_603_1259# u_t000_010/m2_2074_2909# u_t000_010/m2_7_336# u_t000_010/m2_717_2037#
+ u_t000_010/m2_1886_2031# u_t000_010/m2_2573_336# u_t000_010/m2_7_2898# u_t000_010/m2_2000_1265#
+ u_t000_010/m2_512_2037# u_t000_010/m2_1795_1265# u_t000_010/m2_1714_1982# u_t000_010/m2_1886_1259#
+ u_t000_010/m2_1290_2126# u_t000_010/m2_1714_438# u_t000_010/m2_431_1210# u_t000_010/m2_2573_2898#
+ u_t000_010/m2_2154_303# u_t000_010/m2_871_2081# VSUBS detronyx_12t_2w2r_rc4_4x4_routed_5layer_direct
Xgf180mcu_as_sc_mcu7t3v3__inv_2_780 VSS VSS VSS VSS gf180mcu_as_sc_mcu7t3v3__inv_2_828/VNW
+ VSUBS gf180mcu_as_sc_mcu7t3v3__inv_2
Xgf180mcu_as_sc_mcu7t3v3__inv_2_791 VSS VSS gf180mcu_as_sc_mcu7t3v3__inv_2_791/Y VSS
+ gf180mcu_as_sc_mcu7t3v3__inv_2_849/VNW VSUBS gf180mcu_as_sc_mcu7t3v3__inv_2
Xgf180mcu_as_sc_mcu7t3v3__inv_2_1509 gf180mcu_as_sc_mcu7t3v3__inv_2_1511/VDD gf180mcu_as_sc_mcu7t3v3__inv_2_1511/VSS
+ VSS VSS gf180mcu_as_sc_mcu7t3v3__inv_2_1511/VNW VSUBS gf180mcu_as_sc_mcu7t3v3__inv_2
Xgf180mcu_as_sc_mcu7t3v3__nand2_2_8 gf180mcu_as_sc_mcu7t3v3__nand3_2_9/VDD gf180mcu_as_sc_mcu7t3v3__nor2_2_4/VSS
+ VSS VSS VSS gf180mcu_as_sc_mcu7t3v3__nand3_2_9/VNW VSUBS gf180mcu_as_sc_mcu7t3v3__nand2_2
Xgf180mcu_as_sc_mcu7t3v3__nor2_2_3 gf180mcu_as_sc_mcu7t3v3__nor2_2_7/VDD gf180mcu_as_sc_mcu7t3v3__nor2_2_7/VSS
+ VSS VSS VSS gf180mcu_as_sc_mcu7t3v3__nor2_2_7/VNW VSUBS gf180mcu_as_sc_mcu7t3v3__nor2_2
Xgf180mcu_as_sc_mcu7t3v3__inv_2_1306 VSS VSS gf180mcu_as_sc_mcu7t3v3__inv_2_1306/Y
+ gf180mcu_as_sc_mcu7t3v3__inv_2_1307/Y gf180mcu_as_sc_mcu7t3v3__inv_2_1307/VNW VSUBS
+ gf180mcu_as_sc_mcu7t3v3__inv_2
Xgf180mcu_as_sc_mcu7t3v3__inv_2_1317 gf180mcu_as_sc_mcu7t3v3__inv_2_1349/VSS VSS gf180mcu_as_sc_mcu7t3v3__inv_2_1355/Y
+ VSS gf180mcu_as_sc_mcu7t3v3__inv_2_1317/VNW VSUBS gf180mcu_as_sc_mcu7t3v3__inv_2
Xgf180mcu_as_sc_mcu7t3v3__inv_2_1339 gf180mcu_as_sc_mcu7t3v3__inv_2_1340/VDD VSS gf180mcu_as_sc_mcu7t3v3__inv_2_1339/Y
+ gf180mcu_as_sc_mcu7t3v3__inv_2_1340/Y gf180mcu_as_sc_mcu7t3v3__inv_2_1340/VNW VSUBS
+ gf180mcu_as_sc_mcu7t3v3__inv_2
Xgf180mcu_as_sc_mcu7t3v3__inv_2_1328 gf180mcu_as_sc_mcu7t3v3__inv_2_1409/VSS VSS gf180mcu_as_sc_mcu7t3v3__inv_2_1409/A
+ VSS gf180mcu_as_sc_mcu7t3v3__inv_2_1328/VNW VSUBS gf180mcu_as_sc_mcu7t3v3__inv_2
Xu_t028_013 u_t028_013/c0_w0_bl u_t028_013/c0_w0_br u_t028_013/c0_w1_bl u_t028_013/c0_w1_br
+ u_t028_013/c0_r0_rbl u_t028_013/c0_r1_rbl u_t028_013/c1_w0_bl u_t028_013/c1_w0_br
+ u_t028_013/c1_w1_bl u_t028_013/c1_w1_br u_t028_013/c1_r0_rbl u_t028_013/c1_r1_rbl
+ u_t028_013/c2_w0_bl u_t028_013/c2_w0_br u_t028_013/c2_w1_bl u_t028_013/c2_w1_br
+ u_t028_013/c2_r0_rbl u_t028_013/c2_r1_rbl u_t028_013/c3_w0_bl u_t028_013/c3_w0_br
+ u_t028_013/c3_w1_bl u_t028_013/c3_w1_br u_t028_013/c3_r0_rbl u_t028_013/c3_r1_rbl
+ u_t028_013/r0_w0_wl u_t028_013/r0_w1_wl u_t028_013/r0_r0_rwl u_t028_013/r0_r1_rwl
+ u_t028_013/r1_w0_wl u_t028_013/r1_w1_wl u_t028_013/r1_r0_rwl u_t028_013/r1_r1_rwl
+ u_t028_013/r2_w0_wl u_t028_013/r2_w1_wl u_t028_013/r2_r0_rwl u_t028_013/r2_r1_rwl
+ u_t028_013/r3_w0_wl u_t028_013/r3_w1_wl u_t028_013/r3_r0_rwl u_t028_013/r3_r1_rwl
+ u_t029_013/VDD u_t028_013/VSS u_t028_013/m2_717_1265# u_t028_013/m2_603_2031# u_t028_013/m2_1290_336#
+ u_t028_013/m2_2000_2037# u_t028_013/m2_791_2909# u_t028_013/m2_7_2126# u_t028_013/m2_2154_2081#
+ u_t028_013/m2_1795_2037# u_t028_013/m2_871_303# u_t028_013/m2_431_438# u_t028_013/m2_1290_2898#
+ u_t028_013/m2_1714_1210# u_t028_013/m2_431_1982# u_t028_013/m2_512_1265# u_t028_013/m2_2573_2126#
+ u_t028_013/m2_603_1259# u_t028_013/m2_2074_2909# u_t028_013/m2_7_336# u_t028_013/m2_717_2037#
+ u_t028_013/m2_1886_2031# u_t028_013/m2_2573_336# u_t028_013/m2_7_2898# u_t028_013/m2_2000_1265#
+ u_t028_013/m2_512_2037# u_t028_013/m2_1795_1265# u_t028_013/m2_1714_1982# u_t028_013/m2_1886_1259#
+ u_t028_013/m2_1290_2126# u_t028_013/m2_1714_438# u_t028_013/m2_431_1210# u_t028_013/m2_2573_2898#
+ u_t028_013/m2_2154_303# u_t028_013/m2_871_2081# VSUBS detronyx_12t_2w2r_rc4_4x4_routed_5layer_direct
Xu_t028_002 u_t028_002/c0_w0_bl u_t028_002/c0_w0_br u_t028_002/c0_w1_bl u_t028_002/c0_w1_br
+ u_t028_002/c0_r0_rbl u_t028_002/c0_r1_rbl u_t028_002/c1_w0_bl u_t028_002/c1_w0_br
+ u_t028_002/c1_w1_bl u_t028_002/c1_w1_br u_t028_002/c1_r0_rbl u_t028_002/c1_r1_rbl
+ u_t028_002/c2_w0_bl u_t028_002/c2_w0_br u_t028_002/c2_w1_bl u_t028_002/c2_w1_br
+ u_t028_002/c2_r0_rbl u_t028_002/c2_r1_rbl u_t028_002/c3_w0_bl u_t028_002/c3_w0_br
+ u_t028_002/c3_w1_bl u_t028_002/c3_w1_br u_t028_002/c3_r0_rbl u_t028_002/c3_r1_rbl
+ u_t028_002/r0_w0_wl u_t028_002/r0_w1_wl u_t028_002/r0_r0_rwl u_t028_002/r0_r1_rwl
+ u_t028_002/r1_w0_wl u_t028_002/r1_w1_wl u_t028_002/r1_r0_rwl u_t028_002/r1_r1_rwl
+ u_t028_002/r2_w0_wl u_t028_002/r2_w1_wl u_t028_002/r2_r0_rwl u_t028_002/r2_r1_rwl
+ u_t028_002/r3_w0_wl u_t028_002/r3_w1_wl u_t028_002/r3_r0_rwl u_t028_002/r3_r1_rwl
+ VSS VSS u_t028_002/m2_717_1265# u_t028_002/m2_603_2031# u_t028_002/m2_1290_336#
+ u_t028_002/m2_2000_2037# u_t028_002/m2_791_2909# u_t028_002/m2_7_2126# u_t028_002/m2_2154_2081#
+ u_t028_002/m2_1795_2037# u_t028_002/m2_871_303# u_t028_002/m2_431_438# u_t028_002/m2_1290_2898#
+ u_t028_002/m2_1714_1210# u_t028_002/m2_431_1982# u_t028_002/m2_512_1265# u_t028_002/m2_2573_2126#
+ u_t028_002/m2_603_1259# u_t028_002/m2_2074_2909# u_t028_002/m2_7_336# u_t028_002/m2_717_2037#
+ u_t028_002/m2_1886_2031# u_t028_002/m2_2573_336# u_t028_002/m2_7_2898# u_t028_002/m2_2000_1265#
+ u_t028_002/m2_512_2037# u_t028_002/m2_1795_1265# u_t028_002/m2_1714_1982# u_t028_002/m2_1886_1259#
+ u_t028_002/m2_1290_2126# u_t028_002/m2_1714_438# u_t028_002/m2_431_1210# u_t028_002/m2_2573_2898#
+ u_t028_002/m2_2154_303# u_t028_002/m2_871_2081# VSUBS detronyx_12t_2w2r_rc4_4x4_routed_5layer_direct
Xu_t019_013 u_t019_013/c0_w0_bl u_t019_013/c0_w0_br u_t019_013/c0_w1_bl u_t019_013/c0_w1_br
+ u_t019_013/c0_r0_rbl u_t019_013/c0_r1_rbl u_t019_013/c1_w0_bl u_t019_013/c1_w0_br
+ u_t019_013/c1_w1_bl u_t019_013/c1_w1_br u_t019_013/c1_r0_rbl u_t019_013/c1_r1_rbl
+ u_t019_013/c2_w0_bl u_t019_013/c2_w0_br u_t019_013/c2_w1_bl u_t019_013/c2_w1_br
+ u_t019_013/c2_r0_rbl u_t019_013/c2_r1_rbl u_t019_013/c3_w0_bl u_t019_013/c3_w0_br
+ u_t019_013/c3_w1_bl u_t019_013/c3_w1_br u_t019_013/c3_r0_rbl u_t019_013/c3_r1_rbl
+ u_t019_013/r0_w0_wl u_t019_013/r0_w1_wl u_t019_013/r0_r0_rwl u_t019_013/r0_r1_rwl
+ u_t019_013/r1_w0_wl u_t019_013/r1_w1_wl u_t019_013/r1_r0_rwl u_t019_013/r1_r1_rwl
+ u_t019_013/r2_w0_wl u_t019_013/r2_w1_wl u_t019_013/r2_r0_rwl u_t019_013/r2_r1_rwl
+ u_t019_013/r3_w0_wl u_t019_013/r3_w1_wl u_t019_013/r3_r0_rwl u_t019_013/r3_r1_rwl
+ u_t019_013/VDD u_t019_013/VSS u_t019_013/m2_717_1265# u_t019_013/m2_603_2031# u_t019_013/m2_1290_336#
+ u_t019_013/m2_2000_2037# u_t019_013/m2_791_2909# u_t019_013/m2_7_2126# u_t019_013/m2_2154_2081#
+ u_t019_013/m2_1795_2037# u_t019_013/m2_871_303# u_t019_013/m2_431_438# u_t019_013/m2_1290_2898#
+ u_t019_013/m2_1714_1210# u_t019_013/m2_431_1982# u_t019_013/m2_512_1265# u_t019_013/m2_2573_2126#
+ u_t019_013/m2_603_1259# u_t019_013/m2_2074_2909# u_t019_013/m2_7_336# u_t019_013/m2_717_2037#
+ u_t019_013/m2_1886_2031# u_t019_013/m2_2573_336# u_t019_013/m2_7_2898# u_t019_013/m2_2000_1265#
+ u_t019_013/m2_512_2037# u_t019_013/m2_1795_1265# u_t019_013/m2_1714_1982# u_t019_013/m2_1886_1259#
+ u_t019_013/m2_1290_2126# u_t019_013/m2_1714_438# u_t019_013/m2_431_1210# u_t019_013/m2_2573_2898#
+ u_t019_013/m2_2154_303# u_t019_013/m2_871_2081# VSUBS detronyx_12t_2w2r_rc4_4x4_routed_5layer_direct
Xu_t019_002 u_t019_002/c0_w0_bl u_t019_002/c0_w0_br u_t019_002/c0_w1_bl u_t019_002/c0_w1_br
+ u_t019_002/c0_r0_rbl u_t019_002/c0_r1_rbl u_t019_002/c1_w0_bl u_t019_002/c1_w0_br
+ u_t019_002/c1_w1_bl u_t019_002/c1_w1_br u_t019_002/c1_r0_rbl u_t019_002/c1_r1_rbl
+ u_t019_002/c2_w0_bl u_t019_002/c2_w0_br u_t019_002/c2_w1_bl u_t019_002/c2_w1_br
+ u_t019_002/c2_r0_rbl u_t019_002/c2_r1_rbl u_t019_002/c3_w0_bl u_t019_002/c3_w0_br
+ u_t019_002/c3_w1_bl u_t019_002/c3_w1_br u_t019_002/c3_r0_rbl u_t019_002/c3_r1_rbl
+ u_t019_002/r0_w0_wl u_t019_002/r0_w1_wl u_t019_002/r0_r0_rwl u_t019_002/r0_r1_rwl
+ u_t019_002/r1_w0_wl u_t019_002/r1_w1_wl u_t019_002/r1_r0_rwl u_t019_002/r1_r1_rwl
+ u_t019_002/r2_w0_wl u_t019_002/r2_w1_wl u_t019_002/r2_r0_rwl u_t019_002/r2_r1_rwl
+ u_t019_002/r3_w0_wl u_t019_002/r3_w1_wl u_t019_002/r3_r0_rwl u_t019_002/r3_r1_rwl
+ VSS VSS u_t019_002/m2_717_1265# u_t019_002/m2_603_2031# u_t019_002/m2_1290_336#
+ u_t019_002/m2_2000_2037# u_t019_002/m2_791_2909# u_t019_002/m2_7_2126# u_t019_002/m2_2154_2081#
+ u_t019_002/m2_1795_2037# u_t019_002/m2_871_303# u_t019_002/m2_431_438# u_t019_002/m2_1290_2898#
+ u_t019_002/m2_1714_1210# u_t019_002/m2_431_1982# u_t019_002/m2_512_1265# u_t019_002/m2_2573_2126#
+ u_t019_002/m2_603_1259# u_t019_002/m2_2074_2909# u_t019_002/m2_7_336# u_t019_002/m2_717_2037#
+ u_t019_002/m2_1886_2031# u_t019_002/m2_2573_336# u_t019_002/m2_7_2898# u_t019_002/m2_2000_1265#
+ u_t019_002/m2_512_2037# u_t019_002/m2_1795_1265# u_t019_002/m2_1714_1982# u_t019_002/m2_1886_1259#
+ u_t019_002/m2_1290_2126# u_t019_002/m2_1714_438# u_t019_002/m2_431_1210# u_t019_002/m2_2573_2898#
+ u_t019_002/m2_2154_303# u_t019_002/m2_871_2081# VSUBS detronyx_12t_2w2r_rc4_4x4_routed_5layer_direct
Xgf180mcu_as_sc_mcu7t3v3__nand4_2_17 gf180mcu_as_sc_mcu7t3v3__inv_2_131/VDD gf180mcu_as_sc_mcu7t3v3__inv_2_134/VDD
+ VSS VSS VSS VSS gf180mcu_as_sc_mcu7t3v3__nand4_2_17/Y gf180mcu_as_sc_mcu7t3v3__inv_2_131/VNW
+ VSUBS gf180mcu_as_sc_mcu7t3v3__nand4_2
Xgf180mcu_as_sc_mcu7t3v3__nand4_2_39 gf180mcu_as_sc_mcu7t3v3__inv_2_203/VSS VSS VSS
+ VSS VSS VSS gf180mcu_as_sc_mcu7t3v3__nand4_2_39/Y gf180mcu_as_sc_mcu7t3v3__inv_2_197/VNW
+ VSUBS gf180mcu_as_sc_mcu7t3v3__nand4_2
Xgf180mcu_as_sc_mcu7t3v3__nand4_2_28 gf180mcu_as_sc_mcu7t3v3__inv_2_206/VSS gf180mcu_as_sc_mcu7t3v3__inv_2_177/VDD
+ VSS VSS VSS VSS VSS gf180mcu_as_sc_mcu7t3v3__inv_2_165/VNW VSUBS gf180mcu_as_sc_mcu7t3v3__nand4_2
Xu_t025_005 u_t025_005/c0_w0_bl u_t025_005/c0_w0_br u_t025_005/c0_w1_bl u_t025_005/c0_w1_br
+ u_t025_005/c0_r0_rbl u_t025_005/c0_r1_rbl u_t025_005/c1_w0_bl u_t025_005/c1_w0_br
+ u_t025_005/c1_w1_bl u_t025_005/c1_w1_br u_t025_005/c1_r0_rbl u_t025_005/c1_r1_rbl
+ u_t025_005/c2_w0_bl u_t025_005/c2_w0_br u_t025_005/c2_w1_bl u_t025_005/c2_w1_br
+ u_t025_005/c2_r0_rbl u_t025_005/c2_r1_rbl u_t025_005/c3_w0_bl u_t025_005/c3_w0_br
+ u_t025_005/c3_w1_bl u_t025_005/c3_w1_br u_t025_005/c3_r0_rbl u_t025_005/c3_r1_rbl
+ u_t025_005/r0_w0_wl u_t025_005/r0_w1_wl u_t025_005/r0_r0_rwl u_t025_005/r0_r1_rwl
+ u_t025_005/r1_w0_wl u_t025_005/r1_w1_wl u_t025_005/r1_r0_rwl u_t025_005/r1_r1_rwl
+ u_t025_005/r2_w0_wl u_t025_005/r2_w1_wl u_t025_005/r2_r0_rwl u_t025_005/r2_r1_rwl
+ u_t025_005/r3_w0_wl u_t025_005/r3_w1_wl u_t025_005/r3_r0_rwl u_t025_005/r3_r1_rwl
+ u_t025_005/VDD VSS u_t025_005/m2_717_1265# u_t025_005/m2_603_2031# u_t025_005/m2_1290_336#
+ u_t025_005/m2_2000_2037# u_t025_005/m2_791_2909# u_t025_005/m2_7_2126# u_t025_005/m2_2154_2081#
+ u_t025_005/m2_1795_2037# u_t025_005/m2_871_303# u_t025_005/m2_431_438# u_t025_005/m2_1290_2898#
+ u_t025_005/m2_1714_1210# u_t025_005/m2_431_1982# u_t025_005/m2_512_1265# u_t025_005/m2_2573_2126#
+ u_t025_005/m2_603_1259# u_t025_005/m2_2074_2909# u_t025_005/m2_7_336# u_t025_005/m2_717_2037#
+ u_t025_005/m2_1886_2031# u_t025_005/m2_2573_336# u_t025_005/m2_7_2898# u_t025_005/m2_2000_1265#
+ u_t025_005/m2_512_2037# u_t025_005/m2_1795_1265# u_t025_005/m2_1714_1982# u_t025_005/m2_1886_1259#
+ u_t025_005/m2_1290_2126# u_t025_005/m2_1714_438# u_t025_005/m2_431_1210# u_t025_005/m2_2573_2898#
+ u_t025_005/m2_2154_303# u_t025_005/m2_871_2081# VSUBS detronyx_12t_2w2r_rc4_4x4_routed_5layer_direct
Xgf180mcu_as_sc_mcu7t3v3__inv_2_1136 VSS gf180mcu_as_sc_mcu7t3v3__inv_2_1139/VDD gf180mcu_as_sc_mcu7t3v3__inv_2_1136/Y
+ VSS gf180mcu_as_sc_mcu7t3v3__inv_2_1136/VNW VSUBS gf180mcu_as_sc_mcu7t3v3__inv_2
Xgf180mcu_as_sc_mcu7t3v3__inv_2_1114 gf180mcu_as_sc_mcu7t3v3__inv_2_1148/VSS VSS gf180mcu_as_sc_mcu7t3v3__inv_2_1114/Y
+ gf180mcu_as_sc_mcu7t3v3__inv_2_1115/Y gf180mcu_as_sc_mcu7t3v3__inv_2_1115/VNW VSUBS
+ gf180mcu_as_sc_mcu7t3v3__inv_2
Xgf180mcu_as_sc_mcu7t3v3__inv_2_1147 gf180mcu_as_sc_mcu7t3v3__inv_2_1148/VDD gf180mcu_as_sc_mcu7t3v3__inv_2_1148/VSS
+ gf180mcu_as_sc_mcu7t3v3__inv_2_1147/Y gf180mcu_as_sc_mcu7t3v3__inv_2_1148/Y gf180mcu_as_sc_mcu7t3v3__inv_2_1148/VNW
+ VSUBS gf180mcu_as_sc_mcu7t3v3__inv_2
Xgf180mcu_as_sc_mcu7t3v3__inv_2_1125 VSS VSS VSS gf180mcu_as_sc_mcu7t3v3__inv_2_1149/A
+ gf180mcu_as_sc_mcu7t3v3__inv_2_1130/VNW VSUBS gf180mcu_as_sc_mcu7t3v3__inv_2
Xgf180mcu_as_sc_mcu7t3v3__inv_2_1158 VSS VSS VSS VSS gf180mcu_as_sc_mcu7t3v3__inv_2_1291/VNW
+ VSUBS gf180mcu_as_sc_mcu7t3v3__inv_2
Xgf180mcu_as_sc_mcu7t3v3__inv_2_1103 gf180mcu_as_sc_mcu7t3v3__inv_2_1103/VDD VSS gf180mcu_as_sc_mcu7t3v3__inv_2_1103/Y
+ VSS gf180mcu_as_sc_mcu7t3v3__inv_2_1103/VNW VSUBS gf180mcu_as_sc_mcu7t3v3__inv_2
Xgf180mcu_as_sc_mcu7t3v3__inv_2_1169 VSS VSS gf180mcu_as_sc_mcu7t3v3__inv_2_1169/Y
+ VSS gf180mcu_as_sc_mcu7t3v3__inv_2_1287/VNW VSUBS gf180mcu_as_sc_mcu7t3v3__inv_2
Xu_t031_008 u_t031_008/c0_w0_bl u_t031_008/c0_w0_br u_t031_008/c0_w1_bl u_t031_008/c0_w1_br
+ u_t031_008/c0_r0_rbl u_t031_008/c0_r1_rbl u_t031_008/c1_w0_bl u_t031_008/c1_w0_br
+ u_t031_008/c1_w1_bl u_t031_008/c1_w1_br u_t031_008/c1_r0_rbl u_t031_008/c1_r1_rbl
+ u_t031_008/c2_w0_bl u_t031_008/c2_w0_br u_t031_008/c2_w1_bl u_t031_008/c2_w1_br
+ u_t031_008/c2_r0_rbl u_t031_008/c2_r1_rbl u_t031_008/c3_w0_bl u_t031_008/c3_w0_br
+ u_t031_008/c3_w1_bl u_t031_008/c3_w1_br u_t031_008/c3_r0_rbl u_t031_008/c3_r1_rbl
+ u_t031_008/r0_w0_wl u_t031_008/r0_w1_wl u_t031_008/r0_r0_rwl u_t031_008/r0_r1_rwl
+ u_t031_008/r1_w0_wl u_t031_008/r1_w1_wl u_t031_008/r1_r0_rwl u_t031_008/r1_r1_rwl
+ u_t031_008/r2_w0_wl u_t031_008/r2_w1_wl u_t031_008/r2_r0_rwl u_t031_008/r2_r1_rwl
+ u_t031_008/r3_w0_wl u_t031_008/r3_w1_wl u_t031_008/r3_r0_rwl u_t031_008/r3_r1_rwl
+ VSS u_t031_009/VSS u_t031_008/m2_717_1265# u_t031_008/m2_603_2031# u_t031_008/m2_1290_336#
+ u_t031_008/m2_2000_2037# u_t031_008/m2_791_2909# u_t031_008/m2_7_2126# u_t031_008/m2_2154_2081#
+ u_t031_008/m2_1795_2037# u_t031_008/m2_871_303# u_t031_008/m2_431_438# u_t031_008/m2_1290_2898#
+ u_t031_008/m2_1714_1210# u_t031_008/m2_431_1982# u_t031_008/m2_512_1265# u_t031_008/m2_2573_2126#
+ u_t031_008/m2_603_1259# u_t031_008/m2_2074_2909# u_t031_008/m2_7_336# u_t031_008/m2_717_2037#
+ u_t031_008/m2_1886_2031# u_t031_008/m2_2573_336# u_t031_008/m2_7_2898# u_t031_008/m2_2000_1265#
+ u_t031_008/m2_512_2037# u_t031_008/m2_1795_1265# u_t031_008/m2_1714_1982# u_t031_008/m2_1886_1259#
+ u_t031_008/m2_1290_2126# u_t031_008/m2_1714_438# u_t031_008/m2_431_1210# u_t031_008/m2_2573_2898#
+ u_t031_008/m2_2154_303# u_t031_008/m2_871_2081# VSUBS detronyx_12t_2w2r_rc4_4x4_routed_5layer_direct
Xu_t016_005 u_t016_005/c0_w0_bl u_t016_005/c0_w0_br u_t016_005/c0_w1_bl u_t016_005/c0_w1_br
+ u_t016_005/c0_r0_rbl u_t016_005/c0_r1_rbl u_t016_005/c1_w0_bl u_t016_005/c1_w0_br
+ u_t016_005/c1_w1_bl u_t016_005/c1_w1_br u_t016_005/c1_r0_rbl u_t016_005/c1_r1_rbl
+ u_t016_005/c2_w0_bl u_t016_005/c2_w0_br u_t016_005/c2_w1_bl u_t016_005/c2_w1_br
+ u_t016_005/c2_r0_rbl u_t016_005/c2_r1_rbl u_t016_005/c3_w0_bl u_t016_005/c3_w0_br
+ u_t016_005/c3_w1_bl u_t016_005/c3_w1_br u_t016_005/c3_r0_rbl u_t016_005/c3_r1_rbl
+ u_t016_005/r0_w0_wl u_t016_005/r0_w1_wl u_t016_005/r0_r0_rwl u_t016_005/r0_r1_rwl
+ u_t016_005/r1_w0_wl u_t016_005/r1_w1_wl u_t016_005/r1_r0_rwl u_t016_005/r1_r1_rwl
+ u_t016_005/r2_w0_wl u_t016_005/r2_w1_wl u_t016_005/r2_r0_rwl u_t016_005/r2_r1_rwl
+ u_t016_005/r3_w0_wl u_t016_005/r3_w1_wl u_t016_005/r3_r0_rwl u_t016_005/r3_r1_rwl
+ u_t016_005/VDD u_t016_005/VSS u_t016_005/m2_717_1265# u_t016_005/m2_603_2031# u_t016_005/m2_1290_336#
+ u_t016_005/m2_2000_2037# u_t016_005/m2_791_2909# u_t016_005/m2_7_2126# u_t016_005/m2_2154_2081#
+ u_t016_005/m2_1795_2037# u_t016_005/m2_871_303# u_t016_005/m2_431_438# u_t016_005/m2_1290_2898#
+ u_t016_005/m2_1714_1210# u_t016_005/m2_431_1982# u_t016_005/m2_512_1265# u_t016_005/m2_2573_2126#
+ u_t016_005/m2_603_1259# u_t016_005/m2_2074_2909# u_t016_005/m2_7_336# u_t016_005/m2_717_2037#
+ u_t016_005/m2_1886_2031# u_t016_005/m2_2573_336# u_t016_005/m2_7_2898# u_t016_005/m2_2000_1265#
+ u_t016_005/m2_512_2037# u_t016_005/m2_1795_1265# u_t016_005/m2_1714_1982# u_t016_005/m2_1886_1259#
+ u_t016_005/m2_1290_2126# u_t016_005/m2_1714_438# u_t016_005/m2_431_1210# u_t016_005/m2_2573_2898#
+ u_t016_005/m2_2154_303# u_t016_005/m2_871_2081# VSUBS detronyx_12t_2w2r_rc4_4x4_routed_5layer_direct
Xgf180mcu_as_sc_mcu7t3v3__nand3_2_50 gf180mcu_as_sc_mcu7t3v3__nor2_2_9/VDD gf180mcu_as_sc_mcu7t3v3__nor2_2_9/VSS
+ VSS VSS VSS VSS gf180mcu_as_sc_mcu7t3v3__nor2_2_9/VNW VSUBS gf180mcu_as_sc_mcu7t3v3__nand3_2
Xgf180mcu_as_sc_mcu7t3v3__nand3_2_61 gf180mcu_as_sc_mcu7t3v3__nand3_2_65/VDD gf180mcu_as_sc_mcu7t3v3__nand3_2_62/VSS
+ VSS VSS VSS VSS gf180mcu_as_sc_mcu7t3v3__nand3_2_65/VNW VSUBS gf180mcu_as_sc_mcu7t3v3__nand3_2
Xgf180mcu_as_sc_mcu7t3v3__inv_2_609 VSS gf180mcu_as_sc_mcu7t3v3__inv_2_617/VDD gf180mcu_as_sc_mcu7t3v3__inv_2_638/A
+ gf180mcu_as_sc_mcu7t3v3__inv_2_610/Y gf180mcu_as_sc_mcu7t3v3__inv_2_610/VNW VSUBS
+ gf180mcu_as_sc_mcu7t3v3__inv_2
Xgf180mcu_as_sc_mcu7t3v3__inv_2_1681 VSS gf180mcu_as_sc_mcu7t3v3__inv_2_1689/VDD gf180mcu_as_sc_mcu7t3v3__inv_2_1689/A
+ VSS gf180mcu_as_sc_mcu7t3v3__inv_2_1681/VNW VSUBS gf180mcu_as_sc_mcu7t3v3__inv_2
Xgf180mcu_as_sc_mcu7t3v3__inv_2_1670 gf180mcu_as_sc_mcu7t3v3__inv_2_1672/VDD VSS VSS
+ gf180mcu_as_sc_mcu7t3v3__inv_2_1672/Y gf180mcu_as_sc_mcu7t3v3__inv_2_1672/VNW VSUBS
+ gf180mcu_as_sc_mcu7t3v3__inv_2
Xgf180mcu_as_sc_mcu7t3v3__inv_2_1692 gf180mcu_as_sc_mcu7t3v3__inv_2_1694/VDD VSS VSS
+ gf180mcu_as_sc_mcu7t3v3__inv_2_1694/Y gf180mcu_as_sc_mcu7t3v3__inv_2_1694/VNW VSUBS
+ gf180mcu_as_sc_mcu7t3v3__inv_2
Xu_t007_005 u_t007_005/c0_w0_bl u_t007_005/c0_w0_br u_t007_005/c0_w1_bl u_t007_005/c0_w1_br
+ u_t007_005/c0_r0_rbl u_t007_005/c0_r1_rbl u_t007_005/c1_w0_bl u_t007_005/c1_w0_br
+ u_t007_005/c1_w1_bl u_t007_005/c1_w1_br u_t007_005/c1_r0_rbl u_t007_005/c1_r1_rbl
+ u_t007_005/c2_w0_bl u_t007_005/c2_w0_br u_t007_005/c2_w1_bl u_t007_005/c2_w1_br
+ u_t007_005/c2_r0_rbl u_t007_005/c2_r1_rbl u_t007_005/c3_w0_bl u_t007_005/c3_w0_br
+ u_t007_005/c3_w1_bl u_t007_005/c3_w1_br u_t007_005/c3_r0_rbl u_t007_005/c3_r1_rbl
+ u_t007_005/r0_w0_wl u_t007_005/r0_w1_wl u_t007_005/r0_r0_rwl u_t007_005/r0_r1_rwl
+ u_t007_005/r1_w0_wl u_t007_005/r1_w1_wl u_t007_005/r1_r0_rwl u_t007_005/r1_r1_rwl
+ u_t007_005/r2_w0_wl u_t007_005/r2_w1_wl u_t007_005/r2_r0_rwl u_t007_005/r2_r1_rwl
+ u_t007_005/r3_w0_wl u_t007_005/r3_w1_wl u_t007_005/r3_r0_rwl u_t007_005/r3_r1_rwl
+ u_t008_005/VDD u_t007_005/VSS u_t007_005/m2_717_1265# u_t007_005/m2_603_2031# u_t007_005/m2_1290_336#
+ u_t007_005/m2_2000_2037# u_t007_005/m2_791_2909# u_t007_005/m2_7_2126# u_t007_005/m2_2154_2081#
+ u_t007_005/m2_1795_2037# u_t007_005/m2_871_303# u_t007_005/m2_431_438# u_t007_005/m2_1290_2898#
+ u_t007_005/m2_1714_1210# u_t007_005/m2_431_1982# u_t007_005/m2_512_1265# u_t007_005/m2_2573_2126#
+ u_t007_005/m2_603_1259# u_t007_005/m2_2074_2909# u_t007_005/m2_7_336# u_t007_005/m2_717_2037#
+ u_t007_005/m2_1886_2031# u_t007_005/m2_2573_336# u_t007_005/m2_7_2898# u_t007_005/m2_2000_1265#
+ u_t007_005/m2_512_2037# u_t007_005/m2_1795_1265# u_t007_005/m2_1714_1982# u_t007_005/m2_1886_1259#
+ u_t007_005/m2_1290_2126# u_t007_005/m2_1714_438# u_t007_005/m2_431_1210# u_t007_005/m2_2573_2898#
+ u_t007_005/m2_2154_303# u_t007_005/m2_871_2081# VSUBS detronyx_12t_2w2r_rc4_4x4_routed_5layer_direct
Xu_t022_008 u_t022_008/c0_w0_bl u_t022_008/c0_w0_br u_t022_008/c0_w1_bl u_t022_008/c0_w1_br
+ u_t022_008/c0_r0_rbl u_t022_008/c0_r1_rbl u_t022_008/c1_w0_bl u_t022_008/c1_w0_br
+ u_t022_008/c1_w1_bl u_t022_008/c1_w1_br u_t022_008/c1_r0_rbl u_t022_008/c1_r1_rbl
+ u_t022_008/c2_w0_bl u_t022_008/c2_w0_br u_t022_008/c2_w1_bl u_t022_008/c2_w1_br
+ u_t022_008/c2_r0_rbl u_t022_008/c2_r1_rbl u_t022_008/c3_w0_bl u_t022_008/c3_w0_br
+ u_t022_008/c3_w1_bl u_t022_008/c3_w1_br u_t022_008/c3_r0_rbl u_t022_008/c3_r1_rbl
+ u_t022_008/r0_w0_wl u_t022_008/r0_w1_wl u_t022_008/r0_r0_rwl u_t022_008/r0_r1_rwl
+ u_t022_008/r1_w0_wl u_t022_008/r1_w1_wl u_t022_008/r1_r0_rwl u_t022_008/r1_r1_rwl
+ u_t022_008/r2_w0_wl u_t022_008/r2_w1_wl u_t022_008/r2_r0_rwl u_t022_008/r2_r1_rwl
+ u_t022_008/r3_w0_wl u_t022_008/r3_w1_wl u_t022_008/r3_r0_rwl u_t022_008/r3_r1_rwl
+ VSS VSS u_t022_008/m2_717_1265# u_t022_008/m2_603_2031# u_t022_008/m2_1290_336#
+ u_t022_008/m2_2000_2037# u_t022_008/m2_791_2909# u_t022_008/m2_7_2126# u_t022_008/m2_2154_2081#
+ u_t022_008/m2_1795_2037# u_t022_008/m2_871_303# u_t022_008/m2_431_438# u_t022_008/m2_1290_2898#
+ u_t022_008/m2_1714_1210# u_t022_008/m2_431_1982# u_t022_008/m2_512_1265# u_t022_008/m2_2573_2126#
+ u_t022_008/m2_603_1259# u_t022_008/m2_2074_2909# u_t022_008/m2_7_336# u_t022_008/m2_717_2037#
+ u_t022_008/m2_1886_2031# u_t022_008/m2_2573_336# u_t022_008/m2_7_2898# u_t022_008/m2_2000_1265#
+ u_t022_008/m2_512_2037# u_t022_008/m2_1795_1265# u_t022_008/m2_1714_1982# u_t022_008/m2_1886_1259#
+ u_t022_008/m2_1290_2126# u_t022_008/m2_1714_438# u_t022_008/m2_431_1210# u_t022_008/m2_2573_2898#
+ u_t022_008/m2_2154_303# u_t022_008/m2_871_2081# VSUBS detronyx_12t_2w2r_rc4_4x4_routed_5layer_direct
Xgf180mcu_as_sc_mcu7t3v3__nand4_2_442 VSS gf180mcu_as_sc_mcu7t3v3__inv_2_1598/VDD
+ VSS VSS VSS VSS VSS gf180mcu_as_sc_mcu7t3v3__inv_2_1597/VNW VSUBS gf180mcu_as_sc_mcu7t3v3__nand4_2
Xgf180mcu_as_sc_mcu7t3v3__nand4_2_431 gf180mcu_as_sc_mcu7t3v3__inv_2_1598/VDD gf180mcu_as_sc_mcu7t3v3__inv_2_1598/VSS
+ VSS VSS VSS VSS gf180mcu_as_sc_mcu7t3v3__nand4_2_431/Y gf180mcu_as_sc_mcu7t3v3__inv_2_1598/VNW
+ VSUBS gf180mcu_as_sc_mcu7t3v3__nand4_2
Xgf180mcu_as_sc_mcu7t3v3__nand4_2_420 gf180mcu_as_sc_mcu7t3v3__inv_2_1532/VDD VSS
+ VSS VSS VSS VSS gf180mcu_as_sc_mcu7t3v3__nand4_2_420/Y gf180mcu_as_sc_mcu7t3v3__inv_2_1532/VNW
+ VSUBS gf180mcu_as_sc_mcu7t3v3__nand4_2
Xgf180mcu_as_sc_mcu7t3v3__nand4_2_453 VSS gf180mcu_as_sc_mcu7t3v3__inv_2_1352/VDD
+ VSS VSS VSS VSS VSS gf180mcu_as_sc_mcu7t3v3__inv_2_1348/VNW VSUBS gf180mcu_as_sc_mcu7t3v3__nand4_2
Xgf180mcu_as_sc_mcu7t3v3__nand4_2_497 gf180mcu_as_sc_mcu7t3v3__inv_2_1626/VDD gf180mcu_as_sc_mcu7t3v3__inv_2_1648/VDD
+ VSS VSS VSS VSS VSS gf180mcu_as_sc_mcu7t3v3__inv_2_1626/VNW VSUBS gf180mcu_as_sc_mcu7t3v3__nand4_2
Xgf180mcu_as_sc_mcu7t3v3__nand4_2_486 VSS gf180mcu_as_sc_mcu7t3v3__inv_2_1672/VDD
+ VSS VSS VSS VSS VSS gf180mcu_as_sc_mcu7t3v3__inv_2_1668/VNW VSUBS gf180mcu_as_sc_mcu7t3v3__nand4_2
Xgf180mcu_as_sc_mcu7t3v3__nand4_2_464 VSS gf180mcu_as_sc_mcu7t3v3__inv_2_1366/VDD
+ VSS VSS VSS VSS VSS gf180mcu_as_sc_mcu7t3v3__inv_2_1362/VNW VSUBS gf180mcu_as_sc_mcu7t3v3__nand4_2
Xgf180mcu_as_sc_mcu7t3v3__nand4_2_475 gf180mcu_as_sc_mcu7t3v3__inv_2_1406/VDD gf180mcu_as_sc_mcu7t3v3__inv_2_1406/VSS
+ VSS VSS VSS VSS VSS gf180mcu_as_sc_mcu7t3v3__inv_2_1406/VNW VSUBS gf180mcu_as_sc_mcu7t3v3__nand4_2
Xu_t013_008 u_t013_008/c0_w0_bl u_t013_008/c0_w0_br u_t013_008/c0_w1_bl u_t013_008/c0_w1_br
+ u_t013_008/c0_r0_rbl u_t013_008/c0_r1_rbl u_t013_008/c1_w0_bl u_t013_008/c1_w0_br
+ u_t013_008/c1_w1_bl u_t013_008/c1_w1_br u_t013_008/c1_r0_rbl u_t013_008/c1_r1_rbl
+ u_t013_008/c2_w0_bl u_t013_008/c2_w0_br u_t013_008/c2_w1_bl u_t013_008/c2_w1_br
+ u_t013_008/c2_r0_rbl u_t013_008/c2_r1_rbl u_t013_008/c3_w0_bl u_t013_008/c3_w0_br
+ u_t013_008/c3_w1_bl u_t013_008/c3_w1_br u_t013_008/c3_r0_rbl u_t013_008/c3_r1_rbl
+ u_t013_008/r0_w0_wl u_t013_008/r0_w1_wl u_t013_008/r0_r0_rwl u_t013_008/r0_r1_rwl
+ u_t013_008/r1_w0_wl u_t013_008/r1_w1_wl u_t013_008/r1_r0_rwl u_t013_008/r1_r1_rwl
+ u_t013_008/r2_w0_wl u_t013_008/r2_w1_wl u_t013_008/r2_r0_rwl u_t013_008/r2_r1_rwl
+ u_t013_008/r3_w0_wl u_t013_008/r3_w1_wl u_t013_008/r3_r0_rwl u_t013_008/r3_r1_rwl
+ VSS VSS u_t013_008/m2_717_1265# u_t013_008/m2_603_2031# u_t013_008/m2_1290_336#
+ u_t013_008/m2_2000_2037# u_t013_008/m2_791_2909# u_t013_008/m2_7_2126# u_t013_008/m2_2154_2081#
+ u_t013_008/m2_1795_2037# u_t013_008/m2_871_303# u_t013_008/m2_431_438# u_t013_008/m2_1290_2898#
+ u_t013_008/m2_1714_1210# u_t013_008/m2_431_1982# u_t013_008/m2_512_1265# u_t013_008/m2_2573_2126#
+ u_t013_008/m2_603_1259# u_t013_008/m2_2074_2909# u_t013_008/m2_7_336# u_t013_008/m2_717_2037#
+ u_t013_008/m2_1886_2031# u_t013_008/m2_2573_336# u_t013_008/m2_7_2898# u_t013_008/m2_2000_1265#
+ u_t013_008/m2_512_2037# u_t013_008/m2_1795_1265# u_t013_008/m2_1714_1982# u_t013_008/m2_1886_1259#
+ u_t013_008/m2_1290_2126# u_t013_008/m2_1714_438# u_t013_008/m2_431_1210# u_t013_008/m2_2573_2898#
+ u_t013_008/m2_2154_303# u_t013_008/m2_871_2081# VSUBS detronyx_12t_2w2r_rc4_4x4_routed_5layer_direct
Xu_t004_008 u_t004_008/c0_w0_bl u_t004_008/c0_w0_br u_t004_008/c0_w1_bl u_t004_008/c0_w1_br
+ u_t004_008/c0_r0_rbl u_t004_008/c0_r1_rbl u_t004_008/c1_w0_bl u_t004_008/c1_w0_br
+ u_t004_008/c1_w1_bl u_t004_008/c1_w1_br u_t004_008/c1_r0_rbl u_t004_008/c1_r1_rbl
+ u_t004_008/c2_w0_bl u_t004_008/c2_w0_br u_t004_008/c2_w1_bl u_t004_008/c2_w1_br
+ u_t004_008/c2_r0_rbl u_t004_008/c2_r1_rbl u_t004_008/c3_w0_bl u_t004_008/c3_w0_br
+ u_t004_008/c3_w1_bl u_t004_008/c3_w1_br u_t004_008/c3_r0_rbl u_t004_008/c3_r1_rbl
+ u_t004_008/r0_w0_wl u_t004_008/r0_w1_wl u_t004_008/r0_r0_rwl u_t004_008/r0_r1_rwl
+ u_t004_008/r1_w0_wl u_t004_008/r1_w1_wl u_t004_008/r1_r0_rwl u_t004_008/r1_r1_rwl
+ u_t004_008/r2_w0_wl u_t004_008/r2_w1_wl u_t004_008/r2_r0_rwl u_t004_008/r2_r1_rwl
+ u_t004_008/r3_w0_wl u_t004_008/r3_w1_wl u_t004_008/r3_r0_rwl u_t004_008/r3_r1_rwl
+ VSS VSS u_t004_008/m2_717_1265# u_t004_008/m2_603_2031# u_t004_008/m2_1290_336#
+ u_t004_008/m2_2000_2037# u_t004_008/m2_791_2909# u_t004_008/m2_7_2126# u_t004_008/m2_2154_2081#
+ u_t004_008/m2_1795_2037# u_t004_008/m2_871_303# u_t004_008/m2_431_438# u_t004_008/m2_1290_2898#
+ u_t004_008/m2_1714_1210# u_t004_008/m2_431_1982# u_t004_008/m2_512_1265# u_t004_008/m2_2573_2126#
+ u_t004_008/m2_603_1259# u_t004_008/m2_2074_2909# u_t004_008/m2_7_336# u_t004_008/m2_717_2037#
+ u_t004_008/m2_1886_2031# u_t004_008/m2_2573_336# u_t004_008/m2_7_2898# u_t004_008/m2_2000_1265#
+ u_t004_008/m2_512_2037# u_t004_008/m2_1795_1265# u_t004_008/m2_1714_1982# u_t004_008/m2_1886_1259#
+ u_t004_008/m2_1290_2126# u_t004_008/m2_1714_438# u_t004_008/m2_431_1210# u_t004_008/m2_2573_2898#
+ u_t004_008/m2_2154_303# u_t004_008/m2_871_2081# VSUBS detronyx_12t_2w2r_rc4_4x4_routed_5layer_direct
Xgf180mcu_as_sc_mcu7t3v3__inv_2_439 VSS VSS VSS VSS gf180mcu_as_sc_mcu7t3v3__inv_2_549/VNW
+ VSUBS gf180mcu_as_sc_mcu7t3v3__inv_2
Xgf180mcu_as_sc_mcu7t3v3__inv_2_428 gf180mcu_as_sc_mcu7t3v3__nor2_2_7/VDD gf180mcu_as_sc_mcu7t3v3__nand3_2_4/VSS
+ VSS VSS gf180mcu_as_sc_mcu7t3v3__nor2_2_7/VNW VSUBS gf180mcu_as_sc_mcu7t3v3__inv_2
Xgf180mcu_as_sc_mcu7t3v3__inv_2_406 gf180mcu_as_sc_mcu7t3v3__nand3_2_9/VDD gf180mcu_as_sc_mcu7t3v3__nor2_2_4/VSS
+ VSS VSS gf180mcu_as_sc_mcu7t3v3__nand3_2_9/VNW VSUBS gf180mcu_as_sc_mcu7t3v3__inv_2
Xgf180mcu_as_sc_mcu7t3v3__inv_2_417 gf180mcu_as_sc_mcu7t3v3__nor2_2_4/VDD gf180mcu_as_sc_mcu7t3v3__nor2_2_4/VSS
+ VSS VSS gf180mcu_as_sc_mcu7t3v3__nor2_2_4/VNW VSUBS gf180mcu_as_sc_mcu7t3v3__inv_2
Xgf180mcu_as_sc_mcu7t3v3__inv_2_940 VSS VSS VSS VSS gf180mcu_as_sc_mcu7t3v3__inv_2_940/VNW
+ VSUBS gf180mcu_as_sc_mcu7t3v3__inv_2
Xgf180mcu_as_sc_mcu7t3v3__inv_2_951 VSS VSS VSS VSS gf180mcu_as_sc_mcu7t3v3__inv_2_951/VNW
+ VSUBS gf180mcu_as_sc_mcu7t3v3__inv_2
Xgf180mcu_as_sc_mcu7t3v3__inv_2_995 gf180mcu_as_sc_mcu7t3v3__inv_2_996/VDD gf180mcu_as_sc_mcu7t3v3__inv_2_999/VDD
+ gf180mcu_as_sc_mcu7t3v3__inv_2_995/Y gf180mcu_as_sc_mcu7t3v3__inv_2_996/Y gf180mcu_as_sc_mcu7t3v3__inv_2_996/VNW
+ VSUBS gf180mcu_as_sc_mcu7t3v3__inv_2
Xgf180mcu_as_sc_mcu7t3v3__inv_2_984 gf180mcu_as_sc_mcu7t3v3__inv_2_984/VDD gf180mcu_as_sc_mcu7t3v3__inv_2_988/VDD
+ gf180mcu_as_sc_mcu7t3v3__inv_2_984/Y VSS gf180mcu_as_sc_mcu7t3v3__inv_2_984/VNW
+ VSUBS gf180mcu_as_sc_mcu7t3v3__inv_2
Xgf180mcu_as_sc_mcu7t3v3__inv_2_973 gf180mcu_as_sc_mcu7t3v3__inv_2_989/VDD gf180mcu_as_sc_mcu7t3v3__inv_2_989/VSS
+ gf180mcu_as_sc_mcu7t3v3__inv_2_973/Y VSS gf180mcu_as_sc_mcu7t3v3__inv_2_989/VNW
+ VSUBS gf180mcu_as_sc_mcu7t3v3__inv_2
Xgf180mcu_as_sc_mcu7t3v3__inv_2_962 gf180mcu_as_sc_mcu7t3v3__inv_2_964/VDD VSS VSS
+ gf180mcu_as_sc_mcu7t3v3__inv_2_962/A gf180mcu_as_sc_mcu7t3v3__inv_2_964/VNW VSUBS
+ gf180mcu_as_sc_mcu7t3v3__inv_2
Xgf180mcu_as_sc_mcu7t3v3__nand4_2_272 VSS VSS VSS VSS VSS VSS gf180mcu_as_sc_mcu7t3v3__nand4_2_272/Y
+ gf180mcu_as_sc_mcu7t3v3__inv_2_952/VNW VSUBS gf180mcu_as_sc_mcu7t3v3__nand4_2
Xgf180mcu_as_sc_mcu7t3v3__nand4_2_294 gf180mcu_as_sc_mcu7t3v3__inv_2_999/VDD VSS VSS
+ VSS VSS VSS VSS gf180mcu_as_sc_mcu7t3v3__inv_2_999/VNW VSUBS gf180mcu_as_sc_mcu7t3v3__nand4_2
Xgf180mcu_as_sc_mcu7t3v3__nand4_2_250 VSS VSS VSS VSS VSS VSS VSS gf180mcu_as_sc_mcu7t3v3__inv_2_936/VNW
+ VSUBS gf180mcu_as_sc_mcu7t3v3__nand4_2
Xgf180mcu_as_sc_mcu7t3v3__nand4_2_261 VSS VSS VSS VSS VSS VSS VSS gf180mcu_as_sc_mcu7t3v3__inv_2_932/VNW
+ VSUBS gf180mcu_as_sc_mcu7t3v3__nand4_2
Xgf180mcu_as_sc_mcu7t3v3__nand4_2_283 VSS VSS VSS VSS VSS VSS gf180mcu_as_sc_mcu7t3v3__nand4_2_283/Y
+ gf180mcu_as_sc_mcu7t3v3__inv_2_959/VNW VSUBS gf180mcu_as_sc_mcu7t3v3__nand4_2
Xgf180mcu_as_sc_mcu7t3v3__inv_2_203 VSS gf180mcu_as_sc_mcu7t3v3__inv_2_203/VSS gf180mcu_as_sc_mcu7t3v3__inv_2_203/Y
+ VSS gf180mcu_as_sc_mcu7t3v3__inv_2_203/VNW VSUBS gf180mcu_as_sc_mcu7t3v3__inv_2
Xgf180mcu_as_sc_mcu7t3v3__inv_2_225 VSS gf180mcu_as_sc_mcu7t3v3__inv_2_260/VDD gf180mcu_as_sc_mcu7t3v3__inv_2_225/Y
+ VSS gf180mcu_as_sc_mcu7t3v3__inv_2_227/VNW VSUBS gf180mcu_as_sc_mcu7t3v3__inv_2
Xgf180mcu_as_sc_mcu7t3v3__inv_2_214 VSS gf180mcu_as_sc_mcu7t3v3__inv_2_218/VDD gf180mcu_as_sc_mcu7t3v3__inv_2_214/Y
+ VSS gf180mcu_as_sc_mcu7t3v3__inv_2_215/VNW VSUBS gf180mcu_as_sc_mcu7t3v3__inv_2
Xu_t000_011 u_t000_011/c0_w0_bl u_t000_011/c0_w0_br u_t000_011/c0_w1_bl u_t000_011/c0_w1_br
+ u_t000_011/c0_r0_rbl u_t000_011/c0_r1_rbl u_t000_011/c1_w0_bl u_t000_011/c1_w0_br
+ u_t000_011/c1_w1_bl u_t000_011/c1_w1_br u_t000_011/c1_r0_rbl u_t000_011/c1_r1_rbl
+ u_t000_011/c2_w0_bl u_t000_011/c2_w0_br u_t000_011/c2_w1_bl u_t000_011/c2_w1_br
+ u_t000_011/c2_r0_rbl u_t000_011/c2_r1_rbl u_t000_011/c3_w0_bl u_t000_011/c3_w0_br
+ u_t000_011/c3_w1_bl u_t000_011/c3_w1_br u_t000_011/c3_r0_rbl u_t000_011/c3_r1_rbl
+ u_t000_011/r0_w0_wl u_t000_011/r0_w1_wl u_t000_011/r0_r0_rwl u_t000_011/r0_r1_rwl
+ u_t000_011/r1_w0_wl u_t000_011/r1_w1_wl u_t000_011/r1_r0_rwl u_t000_011/r1_r1_rwl
+ u_t000_011/r2_w0_wl u_t000_011/r2_w1_wl u_t000_011/r2_r0_rwl u_t000_011/r2_r1_rwl
+ u_t000_011/r3_w0_wl u_t000_011/r3_w1_wl u_t000_011/r3_r0_rwl u_t000_011/r3_r1_rwl
+ u_t000_011/VDD VSS u_t000_011/m2_717_1265# u_t000_011/m2_603_2031# u_t000_011/m2_1290_336#
+ u_t000_011/m2_2000_2037# u_t000_011/m2_791_2909# u_t000_011/m2_7_2126# u_t000_011/m2_2154_2081#
+ u_t000_011/m2_1795_2037# u_t000_011/m2_871_303# u_t000_011/m2_431_438# u_t000_011/m2_1290_2898#
+ u_t000_011/m2_1714_1210# u_t000_011/m2_431_1982# u_t000_011/m2_512_1265# u_t000_011/m2_2573_2126#
+ u_t000_011/m2_603_1259# u_t000_011/m2_2074_2909# u_t000_011/m2_7_336# u_t000_011/m2_717_2037#
+ u_t000_011/m2_1886_2031# u_t000_011/m2_2573_336# u_t000_011/m2_7_2898# u_t000_011/m2_2000_1265#
+ u_t000_011/m2_512_2037# u_t000_011/m2_1795_1265# u_t000_011/m2_1714_1982# u_t000_011/m2_1886_1259#
+ u_t000_011/m2_1290_2126# u_t000_011/m2_1714_438# u_t000_011/m2_431_1210# u_t000_011/m2_2573_2898#
+ u_t000_011/m2_2154_303# u_t000_011/m2_871_2081# VSUBS detronyx_12t_2w2r_rc4_4x4_routed_5layer_direct
Xu_t000_000 VSS u_t000_000/c0_w0_br VSS u_t000_000/c0_w1_br u_t000_000/c0_r0_rbl u_t000_000/c0_r1_rbl
+ VSS VSS VSS VSS VSS VSS u_t000_000/c2_w0_bl u_t000_000/c2_w0_br u_t000_000/c2_w1_bl
+ u_t000_000/c2_w1_br u_t000_000/c2_r0_rbl u_t000_000/c2_r1_rbl u_t000_000/c3_w0_bl
+ u_t000_000/c3_w0_br u_t000_000/c3_w1_bl u_t000_000/c3_w1_br u_t000_000/c3_r0_rbl
+ u_t000_000/c3_r1_rbl VSS VSS VSS VSS VSS VSS VSS VSS VSS VSS VSS VSS VSS VSS VSS
+ VSS VSS VSS u_t000_000/m2_717_1265# u_t000_000/m2_603_2031# u_t000_000/m2_1290_336#
+ u_t000_000/m2_2000_2037# u_t000_000/m2_791_2909# u_t000_000/m2_7_2126# u_t000_000/m2_2154_2081#
+ u_t000_000/m2_1795_2037# u_t000_000/m2_871_303# u_t000_000/m2_431_438# u_t000_000/m2_1290_2898#
+ u_t000_000/m2_1714_1210# u_t000_000/m2_431_1982# u_t000_000/m2_512_1265# u_t000_000/m2_2573_2126#
+ u_t000_000/m2_603_1259# u_t000_000/m2_2074_2909# u_t000_000/m2_7_336# u_t000_000/m2_717_2037#
+ u_t000_000/m2_1886_2031# u_t000_000/m2_2573_336# u_t000_000/m2_7_2898# u_t000_000/m2_2000_1265#
+ u_t000_000/m2_512_2037# u_t000_000/m2_1795_1265# u_t000_000/m2_1714_1982# u_t000_000/m2_1886_1259#
+ u_t000_000/m2_1290_2126# u_t000_000/m2_1714_438# u_t000_000/m2_431_1210# u_t000_000/m2_2573_2898#
+ u_t000_000/m2_2154_303# u_t000_000/m2_871_2081# VSUBS detronyx_12t_2w2r_rc4_4x4_routed_5layer_direct
Xgf180mcu_as_sc_mcu7t3v3__inv_2_269 gf180mcu_as_sc_mcu7t3v3__inv_2_301/VDD VSS VSS
+ gf180mcu_as_sc_mcu7t3v3__inv_2_301/Y gf180mcu_as_sc_mcu7t3v3__inv_2_301/VNW VSUBS
+ gf180mcu_as_sc_mcu7t3v3__inv_2
Xgf180mcu_as_sc_mcu7t3v3__inv_2_258 gf180mcu_as_sc_mcu7t3v3__inv_2_260/VDD gf180mcu_as_sc_mcu7t3v3__inv_2_260/VSS
+ gf180mcu_as_sc_mcu7t3v3__inv_2_258/Y VSS gf180mcu_as_sc_mcu7t3v3__inv_2_260/VNW
+ VSUBS gf180mcu_as_sc_mcu7t3v3__inv_2
Xgf180mcu_as_sc_mcu7t3v3__inv_2_247 gf180mcu_as_sc_mcu7t3v3__inv_2_248/VDD gf180mcu_as_sc_mcu7t3v3__inv_2_251/VDD
+ gf180mcu_as_sc_mcu7t3v3__inv_2_247/Y VSS gf180mcu_as_sc_mcu7t3v3__inv_2_248/VNW
+ VSUBS gf180mcu_as_sc_mcu7t3v3__inv_2
Xgf180mcu_as_sc_mcu7t3v3__inv_2_236 VSS gf180mcu_as_sc_mcu7t3v3__inv_2_239/VDD gf180mcu_as_sc_mcu7t3v3__inv_2_236/Y
+ VSS gf180mcu_as_sc_mcu7t3v3__inv_2_236/VNW VSUBS gf180mcu_as_sc_mcu7t3v3__inv_2
Xgf180mcu_as_sc_mcu7t3v3__inv_2_770 VSS VSS VSS VSS gf180mcu_as_sc_mcu7t3v3__inv_2_824/VNW
+ VSUBS gf180mcu_as_sc_mcu7t3v3__inv_2
Xgf180mcu_as_sc_mcu7t3v3__inv_2_781 VSS VSS gf180mcu_as_sc_mcu7t3v3__inv_2_781/Y VSS
+ gf180mcu_as_sc_mcu7t3v3__inv_2_851/VNW VSUBS gf180mcu_as_sc_mcu7t3v3__inv_2
Xgf180mcu_as_sc_mcu7t3v3__inv_2_792 VSS VSS VSS VSS gf180mcu_as_sc_mcu7t3v3__inv_2_844/VNW
+ VSUBS gf180mcu_as_sc_mcu7t3v3__inv_2
Xgf180mcu_as_sc_mcu7t3v3__nor2_2_4 gf180mcu_as_sc_mcu7t3v3__nor2_2_4/VDD gf180mcu_as_sc_mcu7t3v3__nor2_2_4/VSS
+ VSS VSS VSS gf180mcu_as_sc_mcu7t3v3__nor2_2_4/VNW VSUBS gf180mcu_as_sc_mcu7t3v3__nor2_2
Xgf180mcu_as_sc_mcu7t3v3__nand2_2_9 gf180mcu_as_sc_mcu7t3v3__nand3_2_9/VDD gf180mcu_as_sc_mcu7t3v3__nor2_2_4/VSS
+ VSS VSS VSS gf180mcu_as_sc_mcu7t3v3__nand3_2_9/VNW VSUBS gf180mcu_as_sc_mcu7t3v3__nand2_2
Xgf180mcu_as_sc_mcu7t3v3__inv_2_1307 VSS VSS gf180mcu_as_sc_mcu7t3v3__inv_2_1307/Y
+ VSS gf180mcu_as_sc_mcu7t3v3__inv_2_1307/VNW VSUBS gf180mcu_as_sc_mcu7t3v3__inv_2
Xgf180mcu_as_sc_mcu7t3v3__inv_2_1329 VSS gf180mcu_as_sc_mcu7t3v3__inv_2_1349/VDD gf180mcu_as_sc_mcu7t3v3__inv_2_1355/Y
+ gf180mcu_as_sc_mcu7t3v3__inv_2_1355/Y gf180mcu_as_sc_mcu7t3v3__inv_2_1333/VNW VSUBS
+ gf180mcu_as_sc_mcu7t3v3__inv_2
Xgf180mcu_as_sc_mcu7t3v3__inv_2_1318 gf180mcu_as_sc_mcu7t3v3__inv_2_1320/VDD VSS VSS
+ gf180mcu_as_sc_mcu7t3v3__inv_2_1355/Y gf180mcu_as_sc_mcu7t3v3__inv_2_1320/VNW VSUBS
+ gf180mcu_as_sc_mcu7t3v3__inv_2
Xu_t028_014 u_t028_014/c0_w0_bl u_t028_014/c0_w0_br u_t028_014/c0_w1_bl u_t028_014/c0_w1_br
+ u_t028_014/c0_r0_rbl u_t028_014/c0_r1_rbl u_t028_014/c1_w0_bl u_t028_014/c1_w0_br
+ u_t028_014/c1_w1_bl u_t028_014/c1_w1_br u_t028_014/c1_r0_rbl u_t028_014/c1_r1_rbl
+ u_t028_014/c2_w0_bl u_t028_014/c2_w0_br u_t028_014/c2_w1_bl u_t028_014/c2_w1_br
+ u_t028_014/c2_r0_rbl u_t028_014/c2_r1_rbl u_t028_014/c3_w0_bl u_t028_014/c3_w0_br
+ u_t028_014/c3_w1_bl u_t028_014/c3_w1_br u_t028_014/c3_r0_rbl u_t028_014/c3_r1_rbl
+ u_t028_014/r0_w0_wl u_t028_014/r0_w1_wl u_t028_014/r0_r0_rwl u_t028_014/r0_r1_rwl
+ u_t028_014/r1_w0_wl u_t028_014/r1_w1_wl u_t028_014/r1_r0_rwl u_t028_014/r1_r1_rwl
+ u_t028_014/r2_w0_wl u_t028_014/r2_w1_wl u_t028_014/r2_r0_rwl u_t028_014/r2_r1_rwl
+ u_t028_014/r3_w0_wl u_t028_014/r3_w1_wl u_t028_014/r3_r0_rwl u_t028_014/r3_r1_rwl
+ u_t029_014/VDD u_t028_015/VSS u_t028_014/m2_717_1265# u_t028_014/m2_603_2031# u_t028_014/m2_1290_336#
+ u_t028_014/m2_2000_2037# u_t028_014/m2_791_2909# u_t028_014/m2_7_2126# u_t028_014/m2_2154_2081#
+ u_t028_014/m2_1795_2037# u_t028_014/m2_871_303# u_t028_014/m2_431_438# u_t028_014/m2_1290_2898#
+ u_t028_014/m2_1714_1210# u_t028_014/m2_431_1982# u_t028_014/m2_512_1265# u_t028_014/m2_2573_2126#
+ u_t028_014/m2_603_1259# u_t028_014/m2_2074_2909# u_t028_014/m2_7_336# u_t028_014/m2_717_2037#
+ u_t028_014/m2_1886_2031# u_t028_014/m2_2573_336# u_t028_014/m2_7_2898# u_t028_014/m2_2000_1265#
+ u_t028_014/m2_512_2037# u_t028_014/m2_1795_1265# u_t028_014/m2_1714_1982# u_t028_014/m2_1886_1259#
+ u_t028_014/m2_1290_2126# u_t028_014/m2_1714_438# u_t028_014/m2_431_1210# u_t028_014/m2_2573_2898#
+ u_t028_014/m2_2154_303# u_t028_014/m2_871_2081# VSUBS detronyx_12t_2w2r_rc4_4x4_routed_5layer_direct
Xu_t028_003 u_t028_003/c0_w0_bl u_t028_003/c0_w0_br u_t028_003/c0_w1_bl u_t028_003/c0_w1_br
+ u_t028_003/c0_r0_rbl u_t028_003/c0_r1_rbl u_t028_003/c1_w0_bl u_t028_003/c1_w0_br
+ u_t028_003/c1_w1_bl u_t028_003/c1_w1_br u_t028_003/c1_r0_rbl u_t028_003/c1_r1_rbl
+ u_t028_003/c2_w0_bl u_t028_003/c2_w0_br u_t028_003/c2_w1_bl u_t028_003/c2_w1_br
+ u_t028_003/c2_r0_rbl u_t028_003/c2_r1_rbl u_t028_003/c3_w0_bl u_t028_003/c3_w0_br
+ u_t028_003/c3_w1_bl u_t028_003/c3_w1_br u_t028_003/c3_r0_rbl u_t028_003/c3_r1_rbl
+ u_t028_003/r0_w0_wl u_t028_003/r0_w1_wl u_t028_003/r0_r0_rwl u_t028_003/r0_r1_rwl
+ u_t028_003/r1_w0_wl u_t028_003/r1_w1_wl u_t028_003/r1_r0_rwl u_t028_003/r1_r1_rwl
+ u_t028_003/r2_w0_wl u_t028_003/r2_w1_wl u_t028_003/r2_r0_rwl u_t028_003/r2_r1_rwl
+ u_t028_003/r3_w0_wl u_t028_003/r3_w1_wl u_t028_003/r3_r0_rwl u_t028_003/r3_r1_rwl
+ u_t029_003/VDD u_t028_003/VSS u_t028_003/m2_717_1265# u_t028_003/m2_603_2031# u_t028_003/m2_1290_336#
+ u_t028_003/m2_2000_2037# u_t028_003/m2_791_2909# u_t028_003/m2_7_2126# u_t028_003/m2_2154_2081#
+ u_t028_003/m2_1795_2037# u_t028_003/m2_871_303# u_t028_003/m2_431_438# u_t028_003/m2_1290_2898#
+ u_t028_003/m2_1714_1210# u_t028_003/m2_431_1982# u_t028_003/m2_512_1265# u_t028_003/m2_2573_2126#
+ u_t028_003/m2_603_1259# u_t028_003/m2_2074_2909# u_t028_003/m2_7_336# u_t028_003/m2_717_2037#
+ u_t028_003/m2_1886_2031# u_t028_003/m2_2573_336# u_t028_003/m2_7_2898# u_t028_003/m2_2000_1265#
+ u_t028_003/m2_512_2037# u_t028_003/m2_1795_1265# u_t028_003/m2_1714_1982# u_t028_003/m2_1886_1259#
+ u_t028_003/m2_1290_2126# u_t028_003/m2_1714_438# u_t028_003/m2_431_1210# u_t028_003/m2_2573_2898#
+ u_t028_003/m2_2154_303# u_t028_003/m2_871_2081# VSUBS detronyx_12t_2w2r_rc4_4x4_routed_5layer_direct
Xu_t019_014 u_t019_014/c0_w0_bl u_t019_014/c0_w0_br u_t019_014/c0_w1_bl u_t019_014/c0_w1_br
+ u_t019_014/c0_r0_rbl u_t019_014/c0_r1_rbl u_t019_014/c1_w0_bl u_t019_014/c1_w0_br
+ u_t019_014/c1_w1_bl u_t019_014/c1_w1_br u_t019_014/c1_r0_rbl u_t019_014/c1_r1_rbl
+ u_t019_014/c2_w0_bl u_t019_014/c2_w0_br u_t019_014/c2_w1_bl u_t019_014/c2_w1_br
+ u_t019_014/c2_r0_rbl u_t019_014/c2_r1_rbl u_t019_014/c3_w0_bl u_t019_014/c3_w0_br
+ u_t019_014/c3_w1_bl u_t019_014/c3_w1_br u_t019_014/c3_r0_rbl u_t019_014/c3_r1_rbl
+ u_t019_014/r0_w0_wl u_t019_014/r0_w1_wl u_t019_014/r0_r0_rwl u_t019_014/r0_r1_rwl
+ u_t019_014/r1_w0_wl u_t019_014/r1_w1_wl u_t019_014/r1_r0_rwl u_t019_014/r1_r1_rwl
+ u_t019_014/r2_w0_wl u_t019_014/r2_w1_wl u_t019_014/r2_r0_rwl u_t019_014/r2_r1_rwl
+ u_t019_014/r3_w0_wl u_t019_014/r3_w1_wl u_t019_014/r3_r0_rwl u_t019_014/r3_r1_rwl
+ u_t019_014/VDD u_t019_015/VSS u_t019_014/m2_717_1265# u_t019_014/m2_603_2031# u_t019_014/m2_1290_336#
+ u_t019_014/m2_2000_2037# u_t019_014/m2_791_2909# u_t019_014/m2_7_2126# u_t019_014/m2_2154_2081#
+ u_t019_014/m2_1795_2037# u_t019_014/m2_871_303# u_t019_014/m2_431_438# u_t019_014/m2_1290_2898#
+ u_t019_014/m2_1714_1210# u_t019_014/m2_431_1982# u_t019_014/m2_512_1265# u_t019_014/m2_2573_2126#
+ u_t019_014/m2_603_1259# u_t019_014/m2_2074_2909# u_t019_014/m2_7_336# u_t019_014/m2_717_2037#
+ u_t019_014/m2_1886_2031# u_t019_014/m2_2573_336# u_t019_014/m2_7_2898# u_t019_014/m2_2000_1265#
+ u_t019_014/m2_512_2037# u_t019_014/m2_1795_1265# u_t019_014/m2_1714_1982# u_t019_014/m2_1886_1259#
+ u_t019_014/m2_1290_2126# u_t019_014/m2_1714_438# u_t019_014/m2_431_1210# u_t019_014/m2_2573_2898#
+ u_t019_014/m2_2154_303# u_t019_014/m2_871_2081# VSUBS detronyx_12t_2w2r_rc4_4x4_routed_5layer_direct
Xu_t019_003 u_t019_003/c0_w0_bl u_t019_003/c0_w0_br u_t019_003/c0_w1_bl u_t019_003/c0_w1_br
+ u_t019_003/c0_r0_rbl u_t019_003/c0_r1_rbl u_t019_003/c1_w0_bl u_t019_003/c1_w0_br
+ u_t019_003/c1_w1_bl u_t019_003/c1_w1_br u_t019_003/c1_r0_rbl u_t019_003/c1_r1_rbl
+ u_t019_003/c2_w0_bl u_t019_003/c2_w0_br u_t019_003/c2_w1_bl u_t019_003/c2_w1_br
+ u_t019_003/c2_r0_rbl u_t019_003/c2_r1_rbl u_t019_003/c3_w0_bl u_t019_003/c3_w0_br
+ u_t019_003/c3_w1_bl u_t019_003/c3_w1_br u_t019_003/c3_r0_rbl u_t019_003/c3_r1_rbl
+ u_t019_003/r0_w0_wl u_t019_003/r0_w1_wl u_t019_003/r0_r0_rwl u_t019_003/r0_r1_rwl
+ u_t019_003/r1_w0_wl u_t019_003/r1_w1_wl u_t019_003/r1_r0_rwl u_t019_003/r1_r1_rwl
+ u_t019_003/r2_w0_wl u_t019_003/r2_w1_wl u_t019_003/r2_r0_rwl u_t019_003/r2_r1_rwl
+ u_t019_003/r3_w0_wl u_t019_003/r3_w1_wl u_t019_003/r3_r0_rwl u_t019_003/r3_r1_rwl
+ u_t019_003/VDD u_t019_003/VSS u_t019_003/m2_717_1265# u_t019_003/m2_603_2031# u_t019_003/m2_1290_336#
+ u_t019_003/m2_2000_2037# u_t019_003/m2_791_2909# u_t019_003/m2_7_2126# u_t019_003/m2_2154_2081#
+ u_t019_003/m2_1795_2037# u_t019_003/m2_871_303# u_t019_003/m2_431_438# u_t019_003/m2_1290_2898#
+ u_t019_003/m2_1714_1210# u_t019_003/m2_431_1982# u_t019_003/m2_512_1265# u_t019_003/m2_2573_2126#
+ u_t019_003/m2_603_1259# u_t019_003/m2_2074_2909# u_t019_003/m2_7_336# u_t019_003/m2_717_2037#
+ u_t019_003/m2_1886_2031# u_t019_003/m2_2573_336# u_t019_003/m2_7_2898# u_t019_003/m2_2000_1265#
+ u_t019_003/m2_512_2037# u_t019_003/m2_1795_1265# u_t019_003/m2_1714_1982# u_t019_003/m2_1886_1259#
+ u_t019_003/m2_1290_2126# u_t019_003/m2_1714_438# u_t019_003/m2_431_1210# u_t019_003/m2_2573_2898#
+ u_t019_003/m2_2154_303# u_t019_003/m2_871_2081# VSUBS detronyx_12t_2w2r_rc4_4x4_routed_5layer_direct
Xgf180mcu_as_sc_mcu7t3v3__nand4_2_18 gf180mcu_as_sc_mcu7t3v3__inv_2_134/VDD gf180mcu_as_sc_mcu7t3v3__inv_2_137/VDD
+ VSS VSS VSS VSS gf180mcu_as_sc_mcu7t3v3__nand4_2_18/Y gf180mcu_as_sc_mcu7t3v3__inv_2_134/VNW
+ VSUBS gf180mcu_as_sc_mcu7t3v3__nand4_2
Xgf180mcu_as_sc_mcu7t3v3__nand4_2_29 VSS gf180mcu_as_sc_mcu7t3v3__inv_2_171/VDD VSS
+ VSS VSS VSS gf180mcu_as_sc_mcu7t3v3__nand4_2_29/Y gf180mcu_as_sc_mcu7t3v3__inv_2_168/VNW
+ VSUBS gf180mcu_as_sc_mcu7t3v3__nand4_2
Xu_t025_006 u_t025_006/c0_w0_bl u_t025_006/c0_w0_br u_t025_006/c0_w1_bl u_t025_006/c0_w1_br
+ u_t025_006/c0_r0_rbl u_t025_006/c0_r1_rbl u_t025_006/c1_w0_bl u_t025_006/c1_w0_br
+ u_t025_006/c1_w1_bl u_t025_006/c1_w1_br u_t025_006/c1_r0_rbl u_t025_006/c1_r1_rbl
+ u_t025_006/c2_w0_bl u_t025_006/c2_w0_br u_t025_006/c2_w1_bl u_t025_006/c2_w1_br
+ u_t025_006/c2_r0_rbl u_t025_006/c2_r1_rbl u_t025_006/c3_w0_bl u_t025_006/c3_w0_br
+ u_t025_006/c3_w1_bl u_t025_006/c3_w1_br u_t025_006/c3_r0_rbl u_t025_006/c3_r1_rbl
+ u_t025_006/r0_w0_wl u_t025_006/r0_w1_wl u_t025_006/r0_r0_rwl u_t025_006/r0_r1_rwl
+ u_t025_006/r1_w0_wl u_t025_006/r1_w1_wl u_t025_006/r1_r0_rwl u_t025_006/r1_r1_rwl
+ u_t025_006/r2_w0_wl u_t025_006/r2_w1_wl u_t025_006/r2_r0_rwl u_t025_006/r2_r1_rwl
+ u_t025_006/r3_w0_wl u_t025_006/r3_w1_wl u_t025_006/r3_r0_rwl u_t025_006/r3_r1_rwl
+ u_t025_006/VDD VSS u_t025_006/m2_717_1265# u_t025_006/m2_603_2031# u_t025_006/m2_1290_336#
+ u_t025_006/m2_2000_2037# u_t025_006/m2_791_2909# u_t025_006/m2_7_2126# u_t025_006/m2_2154_2081#
+ u_t025_006/m2_1795_2037# u_t025_006/m2_871_303# u_t025_006/m2_431_438# u_t025_006/m2_1290_2898#
+ u_t025_006/m2_1714_1210# u_t025_006/m2_431_1982# u_t025_006/m2_512_1265# u_t025_006/m2_2573_2126#
+ u_t025_006/m2_603_1259# u_t025_006/m2_2074_2909# u_t025_006/m2_7_336# u_t025_006/m2_717_2037#
+ u_t025_006/m2_1886_2031# u_t025_006/m2_2573_336# u_t025_006/m2_7_2898# u_t025_006/m2_2000_1265#
+ u_t025_006/m2_512_2037# u_t025_006/m2_1795_1265# u_t025_006/m2_1714_1982# u_t025_006/m2_1886_1259#
+ u_t025_006/m2_1290_2126# u_t025_006/m2_1714_438# u_t025_006/m2_431_1210# u_t025_006/m2_2573_2898#
+ u_t025_006/m2_2154_303# u_t025_006/m2_871_2081# VSUBS detronyx_12t_2w2r_rc4_4x4_routed_5layer_direct
Xgf180mcu_as_sc_mcu7t3v3__inv_2_1115 gf180mcu_as_sc_mcu7t3v3__inv_2_1148/VSS VSS gf180mcu_as_sc_mcu7t3v3__inv_2_1115/Y
+ VSS gf180mcu_as_sc_mcu7t3v3__inv_2_1115/VNW VSUBS gf180mcu_as_sc_mcu7t3v3__inv_2
Xgf180mcu_as_sc_mcu7t3v3__inv_2_1126 VSS VSS gf180mcu_as_sc_mcu7t3v3__inv_2_1149/A
+ gf180mcu_as_sc_mcu7t3v3__inv_2_1130/Y gf180mcu_as_sc_mcu7t3v3__inv_2_1130/VNW VSUBS
+ gf180mcu_as_sc_mcu7t3v3__inv_2
Xgf180mcu_as_sc_mcu7t3v3__inv_2_1104 gf180mcu_as_sc_mcu7t3v3__inv_2_1112/VDD VSS VSS
+ gf180mcu_as_sc_mcu7t3v3__inv_2_1306/Y gf180mcu_as_sc_mcu7t3v3__inv_2_1112/VNW VSUBS
+ gf180mcu_as_sc_mcu7t3v3__inv_2
Xgf180mcu_as_sc_mcu7t3v3__inv_2_1137 gf180mcu_as_sc_mcu7t3v3__inv_2_1139/VDD gf180mcu_as_sc_mcu7t3v3__inv_2_1142/VDD
+ VSS VSS gf180mcu_as_sc_mcu7t3v3__inv_2_1139/VNW VSUBS gf180mcu_as_sc_mcu7t3v3__inv_2
Xgf180mcu_as_sc_mcu7t3v3__inv_2_1148 gf180mcu_as_sc_mcu7t3v3__inv_2_1148/VDD gf180mcu_as_sc_mcu7t3v3__inv_2_1148/VSS
+ gf180mcu_as_sc_mcu7t3v3__inv_2_1148/Y VSS gf180mcu_as_sc_mcu7t3v3__inv_2_1148/VNW
+ VSUBS gf180mcu_as_sc_mcu7t3v3__inv_2
Xgf180mcu_as_sc_mcu7t3v3__inv_2_1159 VSS VSS gf180mcu_as_sc_mcu7t3v3__inv_2_1159/Y
+ VSS gf180mcu_as_sc_mcu7t3v3__inv_2_1291/VNW VSUBS gf180mcu_as_sc_mcu7t3v3__inv_2
Xu_t031_009 u_t031_009/c0_w0_bl u_t031_009/c0_w0_br u_t031_009/c0_w1_bl u_t031_009/c0_w1_br
+ u_t031_009/c0_r0_rbl u_t031_009/c0_r1_rbl u_t031_009/c1_w0_bl u_t031_009/c1_w0_br
+ u_t031_009/c1_w1_bl u_t031_009/c1_w1_br u_t031_009/c1_r0_rbl u_t031_009/c1_r1_rbl
+ u_t031_009/c2_w0_bl u_t031_009/c2_w0_br u_t031_009/c2_w1_bl u_t031_009/c2_w1_br
+ u_t031_009/c2_r0_rbl u_t031_009/c2_r1_rbl u_t031_009/c3_w0_bl u_t031_009/c3_w0_br
+ u_t031_009/c3_w1_bl u_t031_009/c3_w1_br u_t031_009/c3_r0_rbl u_t031_009/c3_r1_rbl
+ u_t031_009/r0_w0_wl u_t031_009/r0_w1_wl u_t031_009/r0_r0_rwl u_t031_009/r0_r1_rwl
+ u_t031_009/r1_w0_wl u_t031_009/r1_w1_wl u_t031_009/r1_r0_rwl u_t031_009/r1_r1_rwl
+ u_t031_009/r2_w0_wl u_t031_009/r2_w1_wl u_t031_009/r2_r0_rwl u_t031_009/r2_r1_rwl
+ u_t031_009/r3_w0_wl u_t031_009/r3_w1_wl u_t031_009/r3_r0_rwl u_t031_009/r3_r1_rwl
+ VSS u_t031_009/VSS u_t031_009/m2_717_1265# u_t031_009/m2_603_2031# u_t031_009/m2_1290_336#
+ u_t031_009/m2_2000_2037# u_t031_009/m2_791_2909# u_t031_009/m2_7_2126# u_t031_009/m2_2154_2081#
+ u_t031_009/m2_1795_2037# u_t031_009/m2_871_303# u_t031_009/m2_431_438# u_t031_009/m2_1290_2898#
+ u_t031_009/m2_1714_1210# u_t031_009/m2_431_1982# u_t031_009/m2_512_1265# u_t031_009/m2_2573_2126#
+ u_t031_009/m2_603_1259# u_t031_009/m2_2074_2909# u_t031_009/m2_7_336# u_t031_009/m2_717_2037#
+ u_t031_009/m2_1886_2031# u_t031_009/m2_2573_336# u_t031_009/m2_7_2898# u_t031_009/m2_2000_1265#
+ u_t031_009/m2_512_2037# u_t031_009/m2_1795_1265# u_t031_009/m2_1714_1982# u_t031_009/m2_1886_1259#
+ u_t031_009/m2_1290_2126# u_t031_009/m2_1714_438# u_t031_009/m2_431_1210# u_t031_009/m2_2573_2898#
+ u_t031_009/m2_2154_303# u_t031_009/m2_871_2081# VSUBS detronyx_12t_2w2r_rc4_4x4_routed_5layer_direct
Xu_t016_006 u_t016_006/c0_w0_bl u_t016_006/c0_w0_br u_t016_006/c0_w1_bl u_t016_006/c0_w1_br
+ u_t016_006/c0_r0_rbl u_t016_006/c0_r1_rbl u_t016_006/c1_w0_bl u_t016_006/c1_w0_br
+ u_t016_006/c1_w1_bl u_t016_006/c1_w1_br u_t016_006/c1_r0_rbl u_t016_006/c1_r1_rbl
+ u_t016_006/c2_w0_bl u_t016_006/c2_w0_br u_t016_006/c2_w1_bl u_t016_006/c2_w1_br
+ u_t016_006/c2_r0_rbl u_t016_006/c2_r1_rbl u_t016_006/c3_w0_bl u_t016_006/c3_w0_br
+ u_t016_006/c3_w1_bl u_t016_006/c3_w1_br u_t016_006/c3_r0_rbl u_t016_006/c3_r1_rbl
+ u_t016_006/r0_w0_wl u_t016_006/r0_w1_wl u_t016_006/r0_r0_rwl u_t016_006/r0_r1_rwl
+ u_t016_006/r1_w0_wl u_t016_006/r1_w1_wl u_t016_006/r1_r0_rwl u_t016_006/r1_r1_rwl
+ u_t016_006/r2_w0_wl u_t016_006/r2_w1_wl u_t016_006/r2_r0_rwl u_t016_006/r2_r1_rwl
+ u_t016_006/r3_w0_wl u_t016_006/r3_w1_wl u_t016_006/r3_r0_rwl u_t016_006/r3_r1_rwl
+ u_t016_006/VDD u_t016_009/VSS u_t016_006/m2_717_1265# u_t016_006/m2_603_2031# u_t016_006/m2_1290_336#
+ u_t016_006/m2_2000_2037# u_t016_006/m2_791_2909# u_t016_006/m2_7_2126# u_t016_006/m2_2154_2081#
+ u_t016_006/m2_1795_2037# u_t016_006/m2_871_303# u_t016_006/m2_431_438# u_t016_006/m2_1290_2898#
+ u_t016_006/m2_1714_1210# u_t016_006/m2_431_1982# u_t016_006/m2_512_1265# u_t016_006/m2_2573_2126#
+ u_t016_006/m2_603_1259# u_t016_006/m2_2074_2909# u_t016_006/m2_7_336# u_t016_006/m2_717_2037#
+ u_t016_006/m2_1886_2031# u_t016_006/m2_2573_336# u_t016_006/m2_7_2898# u_t016_006/m2_2000_1265#
+ u_t016_006/m2_512_2037# u_t016_006/m2_1795_1265# u_t016_006/m2_1714_1982# u_t016_006/m2_1886_1259#
+ u_t016_006/m2_1290_2126# u_t016_006/m2_1714_438# u_t016_006/m2_431_1210# u_t016_006/m2_2573_2898#
+ u_t016_006/m2_2154_303# u_t016_006/m2_871_2081# VSUBS detronyx_12t_2w2r_rc4_4x4_routed_5layer_direct
Xgf180mcu_as_sc_mcu7t3v3__nand3_2_51 gf180mcu_as_sc_mcu7t3v3__nand3_2_65/VDD gf180mcu_as_sc_mcu7t3v3__nor2_2_9/VSS
+ VSS VSS VSS VSS gf180mcu_as_sc_mcu7t3v3__nand3_2_65/VNW VSUBS gf180mcu_as_sc_mcu7t3v3__nand3_2
Xgf180mcu_as_sc_mcu7t3v3__nand3_2_62 gf180mcu_as_sc_mcu7t3v3__nand3_2_65/VDD gf180mcu_as_sc_mcu7t3v3__nand3_2_62/VSS
+ VSS VSS VSS VSS gf180mcu_as_sc_mcu7t3v3__nand3_2_65/VNW VSUBS gf180mcu_as_sc_mcu7t3v3__nand3_2
Xgf180mcu_as_sc_mcu7t3v3__nand3_2_40 gf180mcu_as_sc_mcu7t3v3__nand3_2_9/VDD gf180mcu_as_sc_mcu7t3v3__nor2_2_7/VSS
+ VSS VSS VSS VSS gf180mcu_as_sc_mcu7t3v3__nand3_2_9/VNW VSUBS gf180mcu_as_sc_mcu7t3v3__nand3_2
Xgf180mcu_as_sc_mcu7t3v3__inv_2_1660 gf180mcu_as_sc_mcu7t3v3__inv_2_1660/VDD VSS gf180mcu_as_sc_mcu7t3v3__inv_2_1669/A
+ VSS gf180mcu_as_sc_mcu7t3v3__inv_2_1660/VNW VSUBS gf180mcu_as_sc_mcu7t3v3__inv_2
Xgf180mcu_as_sc_mcu7t3v3__inv_2_1671 gf180mcu_as_sc_mcu7t3v3__inv_2_1672/VDD VSS gf180mcu_as_sc_mcu7t3v3__inv_2_1671/Y
+ gf180mcu_as_sc_mcu7t3v3__inv_2_1672/Y gf180mcu_as_sc_mcu7t3v3__inv_2_1672/VNW VSUBS
+ gf180mcu_as_sc_mcu7t3v3__inv_2
Xgf180mcu_as_sc_mcu7t3v3__inv_2_1682 gf180mcu_as_sc_mcu7t3v3__inv_2_1684/VDD VSS VSS
+ gf180mcu_as_sc_mcu7t3v3__inv_2_1684/Y gf180mcu_as_sc_mcu7t3v3__inv_2_1684/VNW VSUBS
+ gf180mcu_as_sc_mcu7t3v3__inv_2
Xgf180mcu_as_sc_mcu7t3v3__inv_2_1693 gf180mcu_as_sc_mcu7t3v3__inv_2_1694/VDD VSS gf180mcu_as_sc_mcu7t3v3__inv_2_1694/Y
+ gf180mcu_as_sc_mcu7t3v3__inv_2_1694/Y gf180mcu_as_sc_mcu7t3v3__inv_2_1694/VNW VSUBS
+ gf180mcu_as_sc_mcu7t3v3__inv_2
Xu_t007_006 u_t007_006/c0_w0_bl u_t007_006/c0_w0_br u_t007_006/c0_w1_bl u_t007_006/c0_w1_br
+ u_t007_006/c0_r0_rbl u_t007_006/c0_r1_rbl u_t007_006/c1_w0_bl u_t007_006/c1_w0_br
+ u_t007_006/c1_w1_bl u_t007_006/c1_w1_br u_t007_006/c1_r0_rbl u_t007_006/c1_r1_rbl
+ u_t007_006/c2_w0_bl u_t007_006/c2_w0_br u_t007_006/c2_w1_bl u_t007_006/c2_w1_br
+ u_t007_006/c2_r0_rbl u_t007_006/c2_r1_rbl u_t007_006/c3_w0_bl u_t007_006/c3_w0_br
+ u_t007_006/c3_w1_bl u_t007_006/c3_w1_br u_t007_006/c3_r0_rbl u_t007_006/c3_r1_rbl
+ u_t007_006/r0_w0_wl u_t007_006/r0_w1_wl u_t007_006/r0_r0_rwl u_t007_006/r0_r1_rwl
+ u_t007_006/r1_w0_wl u_t007_006/r1_w1_wl u_t007_006/r1_r0_rwl u_t007_006/r1_r1_rwl
+ u_t007_006/r2_w0_wl u_t007_006/r2_w1_wl u_t007_006/r2_r0_rwl u_t007_006/r2_r1_rwl
+ u_t007_006/r3_w0_wl u_t007_006/r3_w1_wl u_t007_006/r3_r0_rwl u_t007_006/r3_r1_rwl
+ u_t008_006/VDD u_t007_009/VSS u_t007_006/m2_717_1265# u_t007_006/m2_603_2031# u_t007_006/m2_1290_336#
+ u_t007_006/m2_2000_2037# u_t007_006/m2_791_2909# u_t007_006/m2_7_2126# u_t007_006/m2_2154_2081#
+ u_t007_006/m2_1795_2037# u_t007_006/m2_871_303# u_t007_006/m2_431_438# u_t007_006/m2_1290_2898#
+ u_t007_006/m2_1714_1210# u_t007_006/m2_431_1982# u_t007_006/m2_512_1265# u_t007_006/m2_2573_2126#
+ u_t007_006/m2_603_1259# u_t007_006/m2_2074_2909# u_t007_006/m2_7_336# u_t007_006/m2_717_2037#
+ u_t007_006/m2_1886_2031# u_t007_006/m2_2573_336# u_t007_006/m2_7_2898# u_t007_006/m2_2000_1265#
+ u_t007_006/m2_512_2037# u_t007_006/m2_1795_1265# u_t007_006/m2_1714_1982# u_t007_006/m2_1886_1259#
+ u_t007_006/m2_1290_2126# u_t007_006/m2_1714_438# u_t007_006/m2_431_1210# u_t007_006/m2_2573_2898#
+ u_t007_006/m2_2154_303# u_t007_006/m2_871_2081# VSUBS detronyx_12t_2w2r_rc4_4x4_routed_5layer_direct
Xu_t022_009 u_t022_009/c0_w0_bl u_t022_009/c0_w0_br u_t022_009/c0_w1_bl u_t022_009/c0_w1_br
+ u_t022_009/c0_r0_rbl u_t022_009/c0_r1_rbl u_t022_009/c1_w0_bl u_t022_009/c1_w0_br
+ u_t022_009/c1_w1_bl u_t022_009/c1_w1_br u_t022_009/c1_r0_rbl u_t022_009/c1_r1_rbl
+ u_t022_009/c2_w0_bl u_t022_009/c2_w0_br u_t022_009/c2_w1_bl u_t022_009/c2_w1_br
+ u_t022_009/c2_r0_rbl u_t022_009/c2_r1_rbl u_t022_009/c3_w0_bl u_t022_009/c3_w0_br
+ u_t022_009/c3_w1_bl u_t022_009/c3_w1_br u_t022_009/c3_r0_rbl u_t022_009/c3_r1_rbl
+ u_t022_009/r0_w0_wl u_t022_009/r0_w1_wl u_t022_009/r0_r0_rwl u_t022_009/r0_r1_rwl
+ u_t022_009/r1_w0_wl u_t022_009/r1_w1_wl u_t022_009/r1_r0_rwl u_t022_009/r1_r1_rwl
+ u_t022_009/r2_w0_wl u_t022_009/r2_w1_wl u_t022_009/r2_r0_rwl u_t022_009/r2_r1_rwl
+ u_t022_009/r3_w0_wl u_t022_009/r3_w1_wl u_t022_009/r3_r0_rwl u_t022_009/r3_r1_rwl
+ VSS VSS u_t022_009/m2_717_1265# u_t022_009/m2_603_2031# u_t022_009/m2_1290_336#
+ u_t022_009/m2_2000_2037# u_t022_009/m2_791_2909# u_t022_009/m2_7_2126# u_t022_009/m2_2154_2081#
+ u_t022_009/m2_1795_2037# u_t022_009/m2_871_303# u_t022_009/m2_431_438# u_t022_009/m2_1290_2898#
+ u_t022_009/m2_1714_1210# u_t022_009/m2_431_1982# u_t022_009/m2_512_1265# u_t022_009/m2_2573_2126#
+ u_t022_009/m2_603_1259# u_t022_009/m2_2074_2909# u_t022_009/m2_7_336# u_t022_009/m2_717_2037#
+ u_t022_009/m2_1886_2031# u_t022_009/m2_2573_336# u_t022_009/m2_7_2898# u_t022_009/m2_2000_1265#
+ u_t022_009/m2_512_2037# u_t022_009/m2_1795_1265# u_t022_009/m2_1714_1982# u_t022_009/m2_1886_1259#
+ u_t022_009/m2_1290_2126# u_t022_009/m2_1714_438# u_t022_009/m2_431_1210# u_t022_009/m2_2573_2898#
+ u_t022_009/m2_2154_303# u_t022_009/m2_871_2081# VSUBS detronyx_12t_2w2r_rc4_4x4_routed_5layer_direct
Xgf180mcu_as_sc_mcu7t3v3__nand4_2_432 VSS gf180mcu_as_sc_mcu7t3v3__inv_2_1588/VSS
+ VSS VSS VSS VSS VSS gf180mcu_as_sc_mcu7t3v3__inv_2_1588/VNW VSUBS gf180mcu_as_sc_mcu7t3v3__nand4_2
Xgf180mcu_as_sc_mcu7t3v3__nand4_2_443 VSS VSS VSS VSS VSS VSS gf180mcu_as_sc_mcu7t3v3__nand4_2_443/Y
+ gf180mcu_as_sc_mcu7t3v3__inv_2_1601/VNW VSUBS gf180mcu_as_sc_mcu7t3v3__nand4_2
Xgf180mcu_as_sc_mcu7t3v3__nand4_2_487 gf180mcu_as_sc_mcu7t3v3__inv_2_1672/VDD VSS
+ VSS VSS VSS VSS VSS gf180mcu_as_sc_mcu7t3v3__inv_2_1672/VNW VSUBS gf180mcu_as_sc_mcu7t3v3__nand4_2
Xgf180mcu_as_sc_mcu7t3v3__nand4_2_421 VSS VSS VSS VSS VSS VSS VSS gf180mcu_as_sc_mcu7t3v3__inv_2_1535/VNW
+ VSUBS gf180mcu_as_sc_mcu7t3v3__nand4_2
Xgf180mcu_as_sc_mcu7t3v3__nand4_2_465 gf180mcu_as_sc_mcu7t3v3__inv_2_1366/VDD gf180mcu_as_sc_mcu7t3v3__inv_2_1370/VDD
+ VSS VSS VSS VSS VSS gf180mcu_as_sc_mcu7t3v3__inv_2_1366/VNW VSUBS gf180mcu_as_sc_mcu7t3v3__nand4_2
Xgf180mcu_as_sc_mcu7t3v3__nand4_2_476 gf180mcu_as_sc_mcu7t3v3__inv_2_1406/VSS VSS
+ VSS VSS VSS VSS VSS gf180mcu_as_sc_mcu7t3v3__inv_2_1395/VNW VSUBS gf180mcu_as_sc_mcu7t3v3__nand4_2
Xgf180mcu_as_sc_mcu7t3v3__nand4_2_410 gf180mcu_as_sc_mcu7t3v3__inv_2_1500/VDD gf180mcu_as_sc_mcu7t3v3__inv_2_1503/VDD
+ VSS VSS VSS VSS gf180mcu_as_sc_mcu7t3v3__nand4_2_410/Y gf180mcu_as_sc_mcu7t3v3__inv_2_1500/VNW
+ VSUBS gf180mcu_as_sc_mcu7t3v3__nand4_2
Xgf180mcu_as_sc_mcu7t3v3__nand4_2_454 gf180mcu_as_sc_mcu7t3v3__inv_2_1352/VDD gf180mcu_as_sc_mcu7t3v3__inv_2_1355/VDD
+ VSS VSS VSS VSS VSS gf180mcu_as_sc_mcu7t3v3__inv_2_1352/VNW VSUBS gf180mcu_as_sc_mcu7t3v3__nand4_2
Xu_t013_009 u_t013_009/c0_w0_bl u_t013_009/c0_w0_br u_t013_009/c0_w1_bl u_t013_009/c0_w1_br
+ u_t013_009/c0_r0_rbl u_t013_009/c0_r1_rbl u_t013_009/c1_w0_bl u_t013_009/c1_w0_br
+ u_t013_009/c1_w1_bl u_t013_009/c1_w1_br u_t013_009/c1_r0_rbl u_t013_009/c1_r1_rbl
+ u_t013_009/c2_w0_bl u_t013_009/c2_w0_br u_t013_009/c2_w1_bl u_t013_009/c2_w1_br
+ u_t013_009/c2_r0_rbl u_t013_009/c2_r1_rbl u_t013_009/c3_w0_bl u_t013_009/c3_w0_br
+ u_t013_009/c3_w1_bl u_t013_009/c3_w1_br u_t013_009/c3_r0_rbl u_t013_009/c3_r1_rbl
+ u_t013_009/r0_w0_wl u_t013_009/r0_w1_wl u_t013_009/r0_r0_rwl u_t013_009/r0_r1_rwl
+ u_t013_009/r1_w0_wl u_t013_009/r1_w1_wl u_t013_009/r1_r0_rwl u_t013_009/r1_r1_rwl
+ u_t013_009/r2_w0_wl u_t013_009/r2_w1_wl u_t013_009/r2_r0_rwl u_t013_009/r2_r1_rwl
+ u_t013_009/r3_w0_wl u_t013_009/r3_w1_wl u_t013_009/r3_r0_rwl u_t013_009/r3_r1_rwl
+ VSS VSS u_t013_009/m2_717_1265# u_t013_009/m2_603_2031# u_t013_009/m2_1290_336#
+ u_t013_009/m2_2000_2037# u_t013_009/m2_791_2909# u_t013_009/m2_7_2126# u_t013_009/m2_2154_2081#
+ u_t013_009/m2_1795_2037# u_t013_009/m2_871_303# u_t013_009/m2_431_438# u_t013_009/m2_1290_2898#
+ u_t013_009/m2_1714_1210# u_t013_009/m2_431_1982# u_t013_009/m2_512_1265# u_t013_009/m2_2573_2126#
+ u_t013_009/m2_603_1259# u_t013_009/m2_2074_2909# u_t013_009/m2_7_336# u_t013_009/m2_717_2037#
+ u_t013_009/m2_1886_2031# u_t013_009/m2_2573_336# u_t013_009/m2_7_2898# u_t013_009/m2_2000_1265#
+ u_t013_009/m2_512_2037# u_t013_009/m2_1795_1265# u_t013_009/m2_1714_1982# u_t013_009/m2_1886_1259#
+ u_t013_009/m2_1290_2126# u_t013_009/m2_1714_438# u_t013_009/m2_431_1210# u_t013_009/m2_2573_2898#
+ u_t013_009/m2_2154_303# u_t013_009/m2_871_2081# VSUBS detronyx_12t_2w2r_rc4_4x4_routed_5layer_direct
Xgf180mcu_as_sc_mcu7t3v3__nand4_2_498 gf180mcu_as_sc_mcu7t3v3__inv_2_1697/VDD VSS
+ VSS VSS VSS VSS VSS gf180mcu_as_sc_mcu7t3v3__inv_2_1697/VNW VSUBS gf180mcu_as_sc_mcu7t3v3__nand4_2
Xgf180mcu_as_sc_mcu7t3v3__inv_2_0 VSS gf180mcu_as_sc_mcu7t3v3__inv_2_0/VSS gf180mcu_as_sc_mcu7t3v3__inv_2_9/Y
+ VSS gf180mcu_as_sc_mcu7t3v3__inv_2_0/VNW VSUBS gf180mcu_as_sc_mcu7t3v3__inv_2
Xgf180mcu_as_sc_mcu7t3v3__inv_2_418 gf180mcu_as_sc_mcu7t3v3__nor2_2_4/VDD gf180mcu_as_sc_mcu7t3v3__nand2_2_3/VSS
+ VSS VSS gf180mcu_as_sc_mcu7t3v3__nor2_2_4/VNW VSUBS gf180mcu_as_sc_mcu7t3v3__inv_2
Xgf180mcu_as_sc_mcu7t3v3__inv_2_407 gf180mcu_as_sc_mcu7t3v3__nand3_2_9/VDD gf180mcu_as_sc_mcu7t3v3__nor2_2_7/VSS
+ gf180mcu_as_sc_mcu7t3v3__inv_2_407/Y VSS gf180mcu_as_sc_mcu7t3v3__nand3_2_9/VNW
+ VSUBS gf180mcu_as_sc_mcu7t3v3__inv_2
Xu_t004_009 u_t004_009/c0_w0_bl u_t004_009/c0_w0_br u_t004_009/c0_w1_bl u_t004_009/c0_w1_br
+ u_t004_009/c0_r0_rbl u_t004_009/c0_r1_rbl u_t004_009/c1_w0_bl u_t004_009/c1_w0_br
+ u_t004_009/c1_w1_bl u_t004_009/c1_w1_br u_t004_009/c1_r0_rbl u_t004_009/c1_r1_rbl
+ u_t004_009/c2_w0_bl u_t004_009/c2_w0_br u_t004_009/c2_w1_bl u_t004_009/c2_w1_br
+ u_t004_009/c2_r0_rbl u_t004_009/c2_r1_rbl u_t004_009/c3_w0_bl u_t004_009/c3_w0_br
+ u_t004_009/c3_w1_bl u_t004_009/c3_w1_br u_t004_009/c3_r0_rbl u_t004_009/c3_r1_rbl
+ u_t004_009/r0_w0_wl u_t004_009/r0_w1_wl u_t004_009/r0_r0_rwl u_t004_009/r0_r1_rwl
+ u_t004_009/r1_w0_wl u_t004_009/r1_w1_wl u_t004_009/r1_r0_rwl u_t004_009/r1_r1_rwl
+ u_t004_009/r2_w0_wl u_t004_009/r2_w1_wl u_t004_009/r2_r0_rwl u_t004_009/r2_r1_rwl
+ u_t004_009/r3_w0_wl u_t004_009/r3_w1_wl u_t004_009/r3_r0_rwl u_t004_009/r3_r1_rwl
+ VSS VSS u_t004_009/m2_717_1265# u_t004_009/m2_603_2031# u_t004_009/m2_1290_336#
+ u_t004_009/m2_2000_2037# u_t004_009/m2_791_2909# u_t004_009/m2_7_2126# u_t004_009/m2_2154_2081#
+ u_t004_009/m2_1795_2037# u_t004_009/m2_871_303# u_t004_009/m2_431_438# u_t004_009/m2_1290_2898#
+ u_t004_009/m2_1714_1210# u_t004_009/m2_431_1982# u_t004_009/m2_512_1265# u_t004_009/m2_2573_2126#
+ u_t004_009/m2_603_1259# u_t004_009/m2_2074_2909# u_t004_009/m2_7_336# u_t004_009/m2_717_2037#
+ u_t004_009/m2_1886_2031# u_t004_009/m2_2573_336# u_t004_009/m2_7_2898# u_t004_009/m2_2000_1265#
+ u_t004_009/m2_512_2037# u_t004_009/m2_1795_1265# u_t004_009/m2_1714_1982# u_t004_009/m2_1886_1259#
+ u_t004_009/m2_1290_2126# u_t004_009/m2_1714_438# u_t004_009/m2_431_1210# u_t004_009/m2_2573_2898#
+ u_t004_009/m2_2154_303# u_t004_009/m2_871_2081# VSUBS detronyx_12t_2w2r_rc4_4x4_routed_5layer_direct
Xgf180mcu_as_sc_mcu7t3v3__inv_2_429 gf180mcu_as_sc_mcu7t3v3__nor2_2_7/VDD gf180mcu_as_sc_mcu7t3v3__nor2_2_7/VSS
+ VSS VSS gf180mcu_as_sc_mcu7t3v3__nor2_2_7/VNW VSUBS gf180mcu_as_sc_mcu7t3v3__inv_2
Xgf180mcu_as_sc_mcu7t3v3__inv_2_1490 gf180mcu_as_sc_mcu7t3v3__inv_2_1491/VDD VSS gf180mcu_as_sc_mcu7t3v3__inv_2_1490/Y
+ VSS gf180mcu_as_sc_mcu7t3v3__inv_2_1491/VNW VSUBS gf180mcu_as_sc_mcu7t3v3__inv_2
Xgf180mcu_as_sc_mcu7t3v3__inv_2_952 VSS VSS VSS VSS gf180mcu_as_sc_mcu7t3v3__inv_2_952/VNW
+ VSUBS gf180mcu_as_sc_mcu7t3v3__inv_2
Xgf180mcu_as_sc_mcu7t3v3__inv_2_930 VSS VSS VSS VSS gf180mcu_as_sc_mcu7t3v3__inv_2_930/VNW
+ VSUBS gf180mcu_as_sc_mcu7t3v3__inv_2
Xgf180mcu_as_sc_mcu7t3v3__inv_2_963 gf180mcu_as_sc_mcu7t3v3__inv_2_964/VDD VSS gf180mcu_as_sc_mcu7t3v3__inv_2_963/Y
+ gf180mcu_as_sc_mcu7t3v3__inv_2_964/Y gf180mcu_as_sc_mcu7t3v3__inv_2_964/VNW VSUBS
+ gf180mcu_as_sc_mcu7t3v3__inv_2
Xgf180mcu_as_sc_mcu7t3v3__inv_2_941 VSS VSS VSS VSS gf180mcu_as_sc_mcu7t3v3__inv_2_941/VNW
+ VSUBS gf180mcu_as_sc_mcu7t3v3__inv_2
Xgf180mcu_as_sc_mcu7t3v3__inv_2_996 gf180mcu_as_sc_mcu7t3v3__inv_2_996/VDD gf180mcu_as_sc_mcu7t3v3__inv_2_999/VDD
+ gf180mcu_as_sc_mcu7t3v3__inv_2_996/Y VSS gf180mcu_as_sc_mcu7t3v3__inv_2_996/VNW
+ VSUBS gf180mcu_as_sc_mcu7t3v3__inv_2
Xgf180mcu_as_sc_mcu7t3v3__inv_2_974 gf180mcu_as_sc_mcu7t3v3__inv_2_989/VSS VSS VSS
+ gf180mcu_as_sc_mcu7t3v3__inv_2_998/A gf180mcu_as_sc_mcu7t3v3__inv_2_976/VNW VSUBS
+ gf180mcu_as_sc_mcu7t3v3__inv_2
Xgf180mcu_as_sc_mcu7t3v3__inv_2_985 gf180mcu_as_sc_mcu7t3v3__inv_2_985/VDD VSS gf180mcu_as_sc_mcu7t3v3__inv_2_985/Y
+ VSS gf180mcu_as_sc_mcu7t3v3__inv_2_985/VNW VSUBS gf180mcu_as_sc_mcu7t3v3__inv_2
Xgf180mcu_as_sc_mcu7t3v3__nand4_2_284 gf180mcu_as_sc_mcu7t3v3__inv_2_1053/VDD VSS
+ VSS VSS VSS VSS VSS gf180mcu_as_sc_mcu7t3v3__inv_2_1053/VNW VSUBS gf180mcu_as_sc_mcu7t3v3__nand4_2
Xgf180mcu_as_sc_mcu7t3v3__nand4_2_273 VSS VSS VSS VSS VSS VSS gf180mcu_as_sc_mcu7t3v3__nand4_2_273/Y
+ gf180mcu_as_sc_mcu7t3v3__inv_2_956/VNW VSUBS gf180mcu_as_sc_mcu7t3v3__nand4_2
Xgf180mcu_as_sc_mcu7t3v3__nand4_2_240 VSS VSS VSS VSS VSS VSS VSS gf180mcu_as_sc_mcu7t3v3__inv_2_847/VNW
+ VSUBS gf180mcu_as_sc_mcu7t3v3__nand4_2
Xgf180mcu_as_sc_mcu7t3v3__nand4_2_295 VSS VSS VSS VSS VSS VSS VSS gf180mcu_as_sc_mcu7t3v3__inv_2_1004/VNW
+ VSUBS gf180mcu_as_sc_mcu7t3v3__nand4_2
Xgf180mcu_as_sc_mcu7t3v3__nand4_2_251 VSS VSS VSS VSS VSS VSS gf180mcu_as_sc_mcu7t3v3__nand4_2_251/Y
+ gf180mcu_as_sc_mcu7t3v3__inv_2_937/VNW VSUBS gf180mcu_as_sc_mcu7t3v3__nand4_2
Xgf180mcu_as_sc_mcu7t3v3__nand4_2_262 VSS VSS VSS VSS VSS VSS VSS gf180mcu_as_sc_mcu7t3v3__inv_2_933/VNW
+ VSUBS gf180mcu_as_sc_mcu7t3v3__nand4_2
Xgf180mcu_as_sc_mcu7t3v3__inv_2_204 gf180mcu_as_sc_mcu7t3v3__inv_2_260/VSS gf180mcu_as_sc_mcu7t3v3__inv_2_206/VSS
+ gf180mcu_as_sc_mcu7t3v3__inv_2_204/Y VSS gf180mcu_as_sc_mcu7t3v3__inv_2_206/VNW
+ VSUBS gf180mcu_as_sc_mcu7t3v3__inv_2
Xgf180mcu_as_sc_mcu7t3v3__inv_2_259 gf180mcu_as_sc_mcu7t3v3__inv_2_260/VDD gf180mcu_as_sc_mcu7t3v3__inv_2_260/VSS
+ gf180mcu_as_sc_mcu7t3v3__inv_2_259/Y VSS gf180mcu_as_sc_mcu7t3v3__inv_2_260/VNW
+ VSUBS gf180mcu_as_sc_mcu7t3v3__inv_2
Xgf180mcu_as_sc_mcu7t3v3__inv_2_226 VSS gf180mcu_as_sc_mcu7t3v3__inv_2_260/VDD gf180mcu_as_sc_mcu7t3v3__inv_2_226/Y
+ VSS gf180mcu_as_sc_mcu7t3v3__inv_2_227/VNW VSUBS gf180mcu_as_sc_mcu7t3v3__inv_2
Xgf180mcu_as_sc_mcu7t3v3__inv_2_215 VSS gf180mcu_as_sc_mcu7t3v3__inv_2_218/VDD gf180mcu_as_sc_mcu7t3v3__inv_2_215/Y
+ VSS gf180mcu_as_sc_mcu7t3v3__inv_2_215/VNW VSUBS gf180mcu_as_sc_mcu7t3v3__inv_2
Xgf180mcu_as_sc_mcu7t3v3__inv_2_248 gf180mcu_as_sc_mcu7t3v3__inv_2_248/VDD gf180mcu_as_sc_mcu7t3v3__inv_2_251/VDD
+ gf180mcu_as_sc_mcu7t3v3__inv_2_248/Y VSS gf180mcu_as_sc_mcu7t3v3__inv_2_248/VNW
+ VSUBS gf180mcu_as_sc_mcu7t3v3__inv_2
Xgf180mcu_as_sc_mcu7t3v3__inv_2_237 gf180mcu_as_sc_mcu7t3v3__inv_2_239/VDD gf180mcu_as_sc_mcu7t3v3__inv_2_242/VDD
+ gf180mcu_as_sc_mcu7t3v3__inv_2_237/Y VSS gf180mcu_as_sc_mcu7t3v3__inv_2_239/VNW
+ VSUBS gf180mcu_as_sc_mcu7t3v3__inv_2
Xu_t000_012 u_t000_012/c0_w0_bl u_t000_012/c0_w0_br u_t000_012/c0_w1_bl u_t000_012/c0_w1_br
+ u_t000_012/c0_r0_rbl u_t000_012/c0_r1_rbl u_t000_012/c1_w0_bl u_t000_012/c1_w0_br
+ u_t000_012/c1_w1_bl u_t000_012/c1_w1_br u_t000_012/c1_r0_rbl u_t000_012/c1_r1_rbl
+ u_t000_012/c2_w0_bl u_t000_012/c2_w0_br u_t000_012/c2_w1_bl u_t000_012/c2_w1_br
+ u_t000_012/c2_r0_rbl u_t000_012/c2_r1_rbl u_t000_012/c3_w0_bl u_t000_012/c3_w0_br
+ u_t000_012/c3_w1_bl u_t000_012/c3_w1_br u_t000_012/c3_r0_rbl u_t000_012/c3_r1_rbl
+ u_t000_012/r0_w0_wl u_t000_012/r0_w1_wl u_t000_012/r0_r0_rwl u_t000_012/r0_r1_rwl
+ u_t000_012/r1_w0_wl u_t000_012/r1_w1_wl u_t000_012/r1_r0_rwl u_t000_012/r1_r1_rwl
+ u_t000_012/r2_w0_wl u_t000_012/r2_w1_wl u_t000_012/r2_r0_rwl u_t000_012/r2_r1_rwl
+ u_t000_012/r3_w0_wl u_t000_012/r3_w1_wl u_t000_012/r3_r0_rwl u_t000_012/r3_r1_rwl
+ u_t000_012/VDD VSS u_t000_012/m2_717_1265# u_t000_012/m2_603_2031# u_t000_012/m2_1290_336#
+ u_t000_012/m2_2000_2037# u_t000_012/m2_791_2909# u_t000_012/m2_7_2126# u_t000_012/m2_2154_2081#
+ u_t000_012/m2_1795_2037# u_t000_012/m2_871_303# u_t000_012/m2_431_438# u_t000_012/m2_1290_2898#
+ u_t000_012/m2_1714_1210# u_t000_012/m2_431_1982# u_t000_012/m2_512_1265# u_t000_012/m2_2573_2126#
+ u_t000_012/m2_603_1259# u_t000_012/m2_2074_2909# u_t000_012/m2_7_336# u_t000_012/m2_717_2037#
+ u_t000_012/m2_1886_2031# u_t000_012/m2_2573_336# u_t000_012/m2_7_2898# u_t000_012/m2_2000_1265#
+ u_t000_012/m2_512_2037# u_t000_012/m2_1795_1265# u_t000_012/m2_1714_1982# u_t000_012/m2_1886_1259#
+ u_t000_012/m2_1290_2126# u_t000_012/m2_1714_438# u_t000_012/m2_431_1210# u_t000_012/m2_2573_2898#
+ u_t000_012/m2_2154_303# u_t000_012/m2_871_2081# VSUBS detronyx_12t_2w2r_rc4_4x4_routed_5layer_direct
Xu_t000_001 u_t000_001/c0_w0_bl u_t000_001/c0_w0_br u_t000_001/c0_w1_bl u_t000_001/c0_w1_br
+ u_t000_001/c0_r0_rbl u_t000_001/c0_r1_rbl u_t000_001/c1_w0_bl u_t000_001/c1_w0_br
+ u_t000_001/c1_w1_bl u_t000_001/c1_w1_br u_t000_001/c1_r0_rbl u_t000_001/c1_r1_rbl
+ u_t000_001/c2_w0_bl u_t000_001/c2_w0_br u_t000_001/c2_w1_bl u_t000_001/c2_w1_br
+ u_t000_001/c2_r0_rbl u_t000_001/c2_r1_rbl u_t000_001/c3_w0_bl u_t000_001/c3_w0_br
+ u_t000_001/c3_w1_bl u_t000_001/c3_w1_br u_t000_001/c3_r0_rbl u_t000_001/c3_r1_rbl
+ u_t000_001/r0_w0_wl u_t000_001/r0_w1_wl u_t000_001/r0_r0_rwl u_t000_001/r0_r1_rwl
+ u_t000_001/r1_w0_wl u_t000_001/r1_w1_wl u_t000_001/r1_r0_rwl u_t000_001/r1_r1_rwl
+ u_t000_001/r2_w0_wl u_t000_001/r2_w1_wl u_t000_001/r2_r0_rwl u_t000_001/r2_r1_rwl
+ u_t000_001/r3_w0_wl u_t000_001/r3_w1_wl u_t000_001/r3_r0_rwl u_t000_001/r3_r1_rwl
+ VSS VSS u_t000_001/m2_717_1265# u_t000_001/m2_603_2031# u_t000_001/m2_1290_336#
+ u_t000_001/m2_2000_2037# u_t000_001/m2_791_2909# u_t000_001/m2_7_2126# u_t000_001/m2_2154_2081#
+ u_t000_001/m2_1795_2037# u_t000_001/m2_871_303# u_t000_001/m2_431_438# u_t000_001/m2_1290_2898#
+ u_t000_001/m2_1714_1210# u_t000_001/m2_431_1982# u_t000_001/m2_512_1265# u_t000_001/m2_2573_2126#
+ u_t000_001/m2_603_1259# u_t000_001/m2_2074_2909# u_t000_001/m2_7_336# u_t000_001/m2_717_2037#
+ u_t000_001/m2_1886_2031# u_t000_001/m2_2573_336# u_t000_001/m2_7_2898# u_t000_001/m2_2000_1265#
+ u_t000_001/m2_512_2037# u_t000_001/m2_1795_1265# u_t000_001/m2_1714_1982# u_t000_001/m2_1886_1259#
+ u_t000_001/m2_1290_2126# u_t000_001/m2_1714_438# u_t000_001/m2_431_1210# u_t000_001/m2_2573_2898#
+ u_t000_001/m2_2154_303# u_t000_001/m2_871_2081# VSUBS detronyx_12t_2w2r_rc4_4x4_routed_5layer_direct
Xgf180mcu_as_sc_mcu7t3v3__inv_2_771 VSS VSS gf180mcu_as_sc_mcu7t3v3__inv_2_771/Y VSS
+ gf180mcu_as_sc_mcu7t3v3__inv_2_833/VNW VSUBS gf180mcu_as_sc_mcu7t3v3__inv_2
Xgf180mcu_as_sc_mcu7t3v3__inv_2_760 VSS VSS VSS VSS gf180mcu_as_sc_mcu7t3v3__inv_2_832/VNW
+ VSUBS gf180mcu_as_sc_mcu7t3v3__inv_2
Xgf180mcu_as_sc_mcu7t3v3__inv_2_782 VSS VSS VSS VSS gf180mcu_as_sc_mcu7t3v3__inv_2_815/VNW
+ VSUBS gf180mcu_as_sc_mcu7t3v3__inv_2
Xgf180mcu_as_sc_mcu7t3v3__inv_2_793 VSS VSS VSS VSS gf180mcu_as_sc_mcu7t3v3__inv_2_844/VNW
+ VSUBS gf180mcu_as_sc_mcu7t3v3__inv_2
Xgf180mcu_as_sc_mcu7t3v3__inv_2_590 gf180mcu_as_sc_mcu7t3v3__inv_2_590/VSS gf180mcu_as_sc_mcu7t3v3__inv_2_590/VSS
+ gf180mcu_as_sc_mcu7t3v3__inv_2_590/Y gf180mcu_as_sc_mcu7t3v3__inv_2_590/A gf180mcu_as_sc_mcu7t3v3__inv_2_590/VNW
+ VSUBS gf180mcu_as_sc_mcu7t3v3__inv_2
Xgf180mcu_as_sc_mcu7t3v3__nor2_2_5 gf180mcu_as_sc_mcu7t3v3__nor2_2_6/VDD gf180mcu_as_sc_mcu7t3v3__nor2_2_6/VSS
+ VSS VSS VSS gf180mcu_as_sc_mcu7t3v3__nor2_2_6/VNW VSUBS gf180mcu_as_sc_mcu7t3v3__nor2_2
Xgf180mcu_as_sc_mcu7t3v3__inv_2_1308 gf180mcu_as_sc_mcu7t3v3__inv_2_1355/VDD VSS gf180mcu_as_sc_mcu7t3v3__inv_2_1355/Y
+ VSS gf180mcu_as_sc_mcu7t3v3__inv_2_1355/VNW VSUBS gf180mcu_as_sc_mcu7t3v3__inv_2
Xgf180mcu_as_sc_mcu7t3v3__inv_2_1319 gf180mcu_as_sc_mcu7t3v3__inv_2_1320/VDD VSS gf180mcu_as_sc_mcu7t3v3__inv_2_1355/Y
+ gf180mcu_as_sc_mcu7t3v3__inv_2_1355/Y gf180mcu_as_sc_mcu7t3v3__inv_2_1320/VNW VSUBS
+ gf180mcu_as_sc_mcu7t3v3__inv_2
Xu_t028_015 u_t028_015/c0_w0_bl u_t028_015/c0_w0_br u_t028_015/c0_w1_bl u_t028_015/c0_w1_br
+ u_t028_015/c0_r0_rbl u_t028_015/c0_r1_rbl u_t028_015/c1_w0_bl u_t028_015/c1_w0_br
+ u_t028_015/c1_w1_bl u_t028_015/c1_w1_br u_t028_015/c1_r0_rbl u_t028_015/c1_r1_rbl
+ u_t028_015/c2_w0_bl u_t028_015/c2_w0_br u_t028_015/c2_w1_bl u_t028_015/c2_w1_br
+ u_t028_015/c2_r0_rbl u_t028_015/c2_r1_rbl u_t028_015/c3_w0_bl u_t028_015/c3_w0_br
+ u_t028_015/c3_w1_bl u_t028_015/c3_w1_br u_t028_015/c3_r0_rbl u_t028_015/c3_r1_rbl
+ u_t028_015/r0_w0_wl u_t028_015/r0_w1_wl u_t028_015/r0_r0_rwl u_t028_015/r0_r1_rwl
+ u_t028_015/r1_w0_wl u_t028_015/r1_w1_wl u_t028_015/r1_r0_rwl u_t028_015/r1_r1_rwl
+ u_t028_015/r2_w0_wl u_t028_015/r2_w1_wl u_t028_015/r2_r0_rwl u_t028_015/r2_r1_rwl
+ u_t028_015/r3_w0_wl u_t028_015/r3_w1_wl u_t028_015/r3_r0_rwl u_t028_015/r3_r1_rwl
+ VSS u_t028_015/VSS u_t028_015/m2_717_1265# u_t028_015/m2_603_2031# u_t028_015/m2_1290_336#
+ u_t028_015/m2_2000_2037# u_t028_015/m2_791_2909# u_t028_015/m2_7_2126# u_t028_015/m2_2154_2081#
+ u_t028_015/m2_1795_2037# u_t028_015/m2_871_303# u_t028_015/m2_431_438# u_t028_015/m2_1290_2898#
+ u_t028_015/m2_1714_1210# u_t028_015/m2_431_1982# u_t028_015/m2_512_1265# u_t028_015/m2_2573_2126#
+ u_t028_015/m2_603_1259# u_t028_015/m2_2074_2909# u_t028_015/m2_7_336# u_t028_015/m2_717_2037#
+ u_t028_015/m2_1886_2031# u_t028_015/m2_2573_336# u_t028_015/m2_7_2898# u_t028_015/m2_2000_1265#
+ u_t028_015/m2_512_2037# u_t028_015/m2_1795_1265# u_t028_015/m2_1714_1982# u_t028_015/m2_1886_1259#
+ u_t028_015/m2_1290_2126# u_t028_015/m2_1714_438# u_t028_015/m2_431_1210# u_t028_015/m2_2573_2898#
+ u_t028_015/m2_2154_303# u_t028_015/m2_871_2081# VSUBS detronyx_12t_2w2r_rc4_4x4_routed_5layer_direct
Xu_t028_004 u_t028_004/c0_w0_bl u_t028_004/c0_w0_br u_t028_004/c0_w1_bl u_t028_004/c0_w1_br
+ u_t028_004/c0_r0_rbl u_t028_004/c0_r1_rbl u_t028_004/c1_w0_bl u_t028_004/c1_w0_br
+ u_t028_004/c1_w1_bl u_t028_004/c1_w1_br u_t028_004/c1_r0_rbl u_t028_004/c1_r1_rbl
+ u_t028_004/c2_w0_bl u_t028_004/c2_w0_br u_t028_004/c2_w1_bl u_t028_004/c2_w1_br
+ u_t028_004/c2_r0_rbl u_t028_004/c2_r1_rbl u_t028_004/c3_w0_bl u_t028_004/c3_w0_br
+ u_t028_004/c3_w1_bl u_t028_004/c3_w1_br u_t028_004/c3_r0_rbl u_t028_004/c3_r1_rbl
+ u_t028_004/r0_w0_wl u_t028_004/r0_w1_wl u_t028_004/r0_r0_rwl u_t028_004/r0_r1_rwl
+ u_t028_004/r1_w0_wl u_t028_004/r1_w1_wl u_t028_004/r1_r0_rwl u_t028_004/r1_r1_rwl
+ u_t028_004/r2_w0_wl u_t028_004/r2_w1_wl u_t028_004/r2_r0_rwl u_t028_004/r2_r1_rwl
+ u_t028_004/r3_w0_wl u_t028_004/r3_w1_wl u_t028_004/r3_r0_rwl u_t028_004/r3_r1_rwl
+ u_t029_004/VDD u_t028_004/VSS u_t028_004/m2_717_1265# u_t028_004/m2_603_2031# u_t028_004/m2_1290_336#
+ u_t028_004/m2_2000_2037# u_t028_004/m2_791_2909# u_t028_004/m2_7_2126# u_t028_004/m2_2154_2081#
+ u_t028_004/m2_1795_2037# u_t028_004/m2_871_303# u_t028_004/m2_431_438# u_t028_004/m2_1290_2898#
+ u_t028_004/m2_1714_1210# u_t028_004/m2_431_1982# u_t028_004/m2_512_1265# u_t028_004/m2_2573_2126#
+ u_t028_004/m2_603_1259# u_t028_004/m2_2074_2909# u_t028_004/m2_7_336# u_t028_004/m2_717_2037#
+ u_t028_004/m2_1886_2031# u_t028_004/m2_2573_336# u_t028_004/m2_7_2898# u_t028_004/m2_2000_1265#
+ u_t028_004/m2_512_2037# u_t028_004/m2_1795_1265# u_t028_004/m2_1714_1982# u_t028_004/m2_1886_1259#
+ u_t028_004/m2_1290_2126# u_t028_004/m2_1714_438# u_t028_004/m2_431_1210# u_t028_004/m2_2573_2898#
+ u_t028_004/m2_2154_303# u_t028_004/m2_871_2081# VSUBS detronyx_12t_2w2r_rc4_4x4_routed_5layer_direct
Xu_t019_015 u_t019_015/c0_w0_bl u_t019_015/c0_w0_br u_t019_015/c0_w1_bl u_t019_015/c0_w1_br
+ u_t019_015/c0_r0_rbl u_t019_015/c0_r1_rbl u_t019_015/c1_w0_bl u_t019_015/c1_w0_br
+ u_t019_015/c1_w1_bl u_t019_015/c1_w1_br u_t019_015/c1_r0_rbl u_t019_015/c1_r1_rbl
+ u_t019_015/c2_w0_bl u_t019_015/c2_w0_br u_t019_015/c2_w1_bl u_t019_015/c2_w1_br
+ u_t019_015/c2_r0_rbl u_t019_015/c2_r1_rbl u_t019_015/c3_w0_bl u_t019_015/c3_w0_br
+ u_t019_015/c3_w1_bl u_t019_015/c3_w1_br u_t019_015/c3_r0_rbl u_t019_015/c3_r1_rbl
+ u_t019_015/r0_w0_wl u_t019_015/r0_w1_wl u_t019_015/r0_r0_rwl u_t019_015/r0_r1_rwl
+ u_t019_015/r1_w0_wl u_t019_015/r1_w1_wl u_t019_015/r1_r0_rwl u_t019_015/r1_r1_rwl
+ u_t019_015/r2_w0_wl u_t019_015/r2_w1_wl u_t019_015/r2_r0_rwl u_t019_015/r2_r1_rwl
+ u_t019_015/r3_w0_wl u_t019_015/r3_w1_wl u_t019_015/r3_r0_rwl u_t019_015/r3_r1_rwl
+ VSS u_t019_015/VSS u_t019_015/m2_717_1265# u_t019_015/m2_603_2031# u_t019_015/m2_1290_336#
+ u_t019_015/m2_2000_2037# u_t019_015/m2_791_2909# u_t019_015/m2_7_2126# u_t019_015/m2_2154_2081#
+ u_t019_015/m2_1795_2037# u_t019_015/m2_871_303# u_t019_015/m2_431_438# u_t019_015/m2_1290_2898#
+ u_t019_015/m2_1714_1210# u_t019_015/m2_431_1982# u_t019_015/m2_512_1265# u_t019_015/m2_2573_2126#
+ u_t019_015/m2_603_1259# u_t019_015/m2_2074_2909# u_t019_015/m2_7_336# u_t019_015/m2_717_2037#
+ u_t019_015/m2_1886_2031# u_t019_015/m2_2573_336# u_t019_015/m2_7_2898# u_t019_015/m2_2000_1265#
+ u_t019_015/m2_512_2037# u_t019_015/m2_1795_1265# u_t019_015/m2_1714_1982# u_t019_015/m2_1886_1259#
+ u_t019_015/m2_1290_2126# u_t019_015/m2_1714_438# u_t019_015/m2_431_1210# u_t019_015/m2_2573_2898#
+ u_t019_015/m2_2154_303# u_t019_015/m2_871_2081# VSUBS detronyx_12t_2w2r_rc4_4x4_routed_5layer_direct
Xu_t019_004 u_t019_004/c0_w0_bl u_t019_004/c0_w0_br u_t019_004/c0_w1_bl u_t019_004/c0_w1_br
+ u_t019_004/c0_r0_rbl u_t019_004/c0_r1_rbl u_t019_004/c1_w0_bl u_t019_004/c1_w0_br
+ u_t019_004/c1_w1_bl u_t019_004/c1_w1_br u_t019_004/c1_r0_rbl u_t019_004/c1_r1_rbl
+ u_t019_004/c2_w0_bl u_t019_004/c2_w0_br u_t019_004/c2_w1_bl u_t019_004/c2_w1_br
+ u_t019_004/c2_r0_rbl u_t019_004/c2_r1_rbl u_t019_004/c3_w0_bl u_t019_004/c3_w0_br
+ u_t019_004/c3_w1_bl u_t019_004/c3_w1_br u_t019_004/c3_r0_rbl u_t019_004/c3_r1_rbl
+ u_t019_004/r0_w0_wl u_t019_004/r0_w1_wl u_t019_004/r0_r0_rwl u_t019_004/r0_r1_rwl
+ u_t019_004/r1_w0_wl u_t019_004/r1_w1_wl u_t019_004/r1_r0_rwl u_t019_004/r1_r1_rwl
+ u_t019_004/r2_w0_wl u_t019_004/r2_w1_wl u_t019_004/r2_r0_rwl u_t019_004/r2_r1_rwl
+ u_t019_004/r3_w0_wl u_t019_004/r3_w1_wl u_t019_004/r3_r0_rwl u_t019_004/r3_r1_rwl
+ u_t019_004/VDD u_t019_004/VSS u_t019_004/m2_717_1265# u_t019_004/m2_603_2031# u_t019_004/m2_1290_336#
+ u_t019_004/m2_2000_2037# u_t019_004/m2_791_2909# u_t019_004/m2_7_2126# u_t019_004/m2_2154_2081#
+ u_t019_004/m2_1795_2037# u_t019_004/m2_871_303# u_t019_004/m2_431_438# u_t019_004/m2_1290_2898#
+ u_t019_004/m2_1714_1210# u_t019_004/m2_431_1982# u_t019_004/m2_512_1265# u_t019_004/m2_2573_2126#
+ u_t019_004/m2_603_1259# u_t019_004/m2_2074_2909# u_t019_004/m2_7_336# u_t019_004/m2_717_2037#
+ u_t019_004/m2_1886_2031# u_t019_004/m2_2573_336# u_t019_004/m2_7_2898# u_t019_004/m2_2000_1265#
+ u_t019_004/m2_512_2037# u_t019_004/m2_1795_1265# u_t019_004/m2_1714_1982# u_t019_004/m2_1886_1259#
+ u_t019_004/m2_1290_2126# u_t019_004/m2_1714_438# u_t019_004/m2_431_1210# u_t019_004/m2_2573_2898#
+ u_t019_004/m2_2154_303# u_t019_004/m2_871_2081# VSUBS detronyx_12t_2w2r_rc4_4x4_routed_5layer_direct
Xgf180mcu_as_sc_mcu7t3v3__nand4_2_19 gf180mcu_as_sc_mcu7t3v3__inv_2_137/VDD VSS VSS
+ VSS VSS VSS VSS gf180mcu_as_sc_mcu7t3v3__inv_2_137/VNW VSUBS gf180mcu_as_sc_mcu7t3v3__nand4_2
Xu_t025_007 u_t025_007/c0_w0_bl u_t025_007/c0_w0_br u_t025_007/c0_w1_bl u_t025_007/c0_w1_br
+ u_t025_007/c0_r0_rbl u_t025_007/c0_r1_rbl u_t025_007/c1_w0_bl u_t025_007/c1_w0_br
+ u_t025_007/c1_w1_bl u_t025_007/c1_w1_br u_t025_007/c1_r0_rbl u_t025_007/c1_r1_rbl
+ u_t025_007/c2_w0_bl u_t025_007/c2_w0_br u_t025_007/c2_w1_bl u_t025_007/c2_w1_br
+ u_t025_007/c2_r0_rbl u_t025_007/c2_r1_rbl u_t025_007/c3_w0_bl u_t025_007/c3_w0_br
+ u_t025_007/c3_w1_bl u_t025_007/c3_w1_br u_t025_007/c3_r0_rbl u_t025_007/c3_r1_rbl
+ u_t025_007/r0_w0_wl u_t025_007/r0_w1_wl u_t025_007/r0_r0_rwl u_t025_007/r0_r1_rwl
+ u_t025_007/r1_w0_wl u_t025_007/r1_w1_wl u_t025_007/r1_r0_rwl u_t025_007/r1_r1_rwl
+ u_t025_007/r2_w0_wl u_t025_007/r2_w1_wl u_t025_007/r2_r0_rwl u_t025_007/r2_r1_rwl
+ u_t025_007/r3_w0_wl u_t025_007/r3_w1_wl u_t025_007/r3_r0_rwl u_t025_007/r3_r1_rwl
+ VSS VSS u_t025_007/m2_717_1265# u_t025_007/m2_603_2031# u_t025_007/m2_1290_336#
+ u_t025_007/m2_2000_2037# u_t025_007/m2_791_2909# u_t025_007/m2_7_2126# u_t025_007/m2_2154_2081#
+ u_t025_007/m2_1795_2037# u_t025_007/m2_871_303# u_t025_007/m2_431_438# u_t025_007/m2_1290_2898#
+ u_t025_007/m2_1714_1210# u_t025_007/m2_431_1982# u_t025_007/m2_512_1265# u_t025_007/m2_2573_2126#
+ u_t025_007/m2_603_1259# u_t025_007/m2_2074_2909# u_t025_007/m2_7_336# u_t025_007/m2_717_2037#
+ u_t025_007/m2_1886_2031# u_t025_007/m2_2573_336# u_t025_007/m2_7_2898# u_t025_007/m2_2000_1265#
+ u_t025_007/m2_512_2037# u_t025_007/m2_1795_1265# u_t025_007/m2_1714_1982# u_t025_007/m2_1886_1259#
+ u_t025_007/m2_1290_2126# u_t025_007/m2_1714_438# u_t025_007/m2_431_1210# u_t025_007/m2_2573_2898#
+ u_t025_007/m2_2154_303# u_t025_007/m2_871_2081# VSUBS detronyx_12t_2w2r_rc4_4x4_routed_5layer_direct
Xgf180mcu_as_sc_mcu7t3v3__inv_2_1127 gf180mcu_as_sc_mcu7t3v3__inv_2_1129/VDD gf180mcu_as_sc_mcu7t3v3__inv_2_1133/VDD
+ VSS VSS gf180mcu_as_sc_mcu7t3v3__inv_2_1129/VNW VSUBS gf180mcu_as_sc_mcu7t3v3__inv_2
Xgf180mcu_as_sc_mcu7t3v3__inv_2_1138 gf180mcu_as_sc_mcu7t3v3__inv_2_1139/VDD gf180mcu_as_sc_mcu7t3v3__inv_2_1142/VDD
+ gf180mcu_as_sc_mcu7t3v3__inv_2_1138/Y gf180mcu_as_sc_mcu7t3v3__inv_2_1139/Y gf180mcu_as_sc_mcu7t3v3__inv_2_1139/VNW
+ VSUBS gf180mcu_as_sc_mcu7t3v3__inv_2
Xgf180mcu_as_sc_mcu7t3v3__inv_2_1116 VSS VSS VSS gf180mcu_as_sc_mcu7t3v3__inv_2_1122/A
+ gf180mcu_as_sc_mcu7t3v3__inv_2_1118/VNW VSUBS gf180mcu_as_sc_mcu7t3v3__inv_2
Xgf180mcu_as_sc_mcu7t3v3__inv_2_1149 VSS VSS VSS gf180mcu_as_sc_mcu7t3v3__inv_2_1149/A
+ gf180mcu_as_sc_mcu7t3v3__inv_2_1151/VNW VSUBS gf180mcu_as_sc_mcu7t3v3__inv_2
Xgf180mcu_as_sc_mcu7t3v3__inv_2_1105 VSS VSS VSS gf180mcu_as_sc_mcu7t3v3__inv_2_1109/A
+ gf180mcu_as_sc_mcu7t3v3__inv_2_1107/VNW VSUBS gf180mcu_as_sc_mcu7t3v3__inv_2
Xu_t016_007 u_t016_007/c0_w0_bl u_t016_007/c0_w0_br u_t016_007/c0_w1_bl u_t016_007/c0_w1_br
+ u_t016_007/c0_r0_rbl u_t016_007/c0_r1_rbl u_t016_007/c1_w0_bl u_t016_007/c1_w0_br
+ u_t016_007/c1_w1_bl u_t016_007/c1_w1_br u_t016_007/c1_r0_rbl u_t016_007/c1_r1_rbl
+ u_t016_007/c2_w0_bl u_t016_007/c2_w0_br u_t016_007/c2_w1_bl u_t016_007/c2_w1_br
+ u_t016_007/c2_r0_rbl u_t016_007/c2_r1_rbl u_t016_007/c3_w0_bl u_t016_007/c3_w0_br
+ u_t016_007/c3_w1_bl u_t016_007/c3_w1_br u_t016_007/c3_r0_rbl u_t016_007/c3_r1_rbl
+ u_t016_007/r0_w0_wl u_t016_007/r0_w1_wl u_t016_007/r0_r0_rwl u_t016_007/r0_r1_rwl
+ u_t016_007/r1_w0_wl u_t016_007/r1_w1_wl u_t016_007/r1_r0_rwl u_t016_007/r1_r1_rwl
+ u_t016_007/r2_w0_wl u_t016_007/r2_w1_wl u_t016_007/r2_r0_rwl u_t016_007/r2_r1_rwl
+ u_t016_007/r3_w0_wl u_t016_007/r3_w1_wl u_t016_007/r3_r0_rwl u_t016_007/r3_r1_rwl
+ VSS u_t016_009/VSS u_t016_007/m2_717_1265# u_t016_007/m2_603_2031# u_t016_007/m2_1290_336#
+ u_t016_007/m2_2000_2037# u_t016_007/m2_791_2909# u_t016_007/m2_7_2126# u_t016_007/m2_2154_2081#
+ u_t016_007/m2_1795_2037# u_t016_007/m2_871_303# u_t016_007/m2_431_438# u_t016_007/m2_1290_2898#
+ u_t016_007/m2_1714_1210# u_t016_007/m2_431_1982# u_t016_007/m2_512_1265# u_t016_007/m2_2573_2126#
+ u_t016_007/m2_603_1259# u_t016_007/m2_2074_2909# u_t016_007/m2_7_336# u_t016_007/m2_717_2037#
+ u_t016_007/m2_1886_2031# u_t016_007/m2_2573_336# u_t016_007/m2_7_2898# u_t016_007/m2_2000_1265#
+ u_t016_007/m2_512_2037# u_t016_007/m2_1795_1265# u_t016_007/m2_1714_1982# u_t016_007/m2_1886_1259#
+ u_t016_007/m2_1290_2126# u_t016_007/m2_1714_438# u_t016_007/m2_431_1210# u_t016_007/m2_2573_2898#
+ u_t016_007/m2_2154_303# u_t016_007/m2_871_2081# VSUBS detronyx_12t_2w2r_rc4_4x4_routed_5layer_direct
Xgf180mcu_as_sc_mcu7t3v3__nand3_2_30 gf180mcu_as_sc_mcu7t3v3__nor2_2_7/VDD gf180mcu_as_sc_mcu7t3v3__nand3_2_4/VSS
+ VSS VSS VSS VSS gf180mcu_as_sc_mcu7t3v3__nor2_2_7/VNW VSUBS gf180mcu_as_sc_mcu7t3v3__nand3_2
Xgf180mcu_as_sc_mcu7t3v3__nand3_2_63 gf180mcu_as_sc_mcu7t3v3__nor2_2_9/VDD gf180mcu_as_sc_mcu7t3v3__nand3_2_63/VSS
+ VSS VSS VSS VSS gf180mcu_as_sc_mcu7t3v3__nor2_2_9/VNW VSUBS gf180mcu_as_sc_mcu7t3v3__nand3_2
Xgf180mcu_as_sc_mcu7t3v3__nand3_2_52 gf180mcu_as_sc_mcu7t3v3__nand3_2_65/VDD gf180mcu_as_sc_mcu7t3v3__nand3_2_62/VSS
+ VSS VSS VSS VSS gf180mcu_as_sc_mcu7t3v3__nand3_2_65/VNW VSUBS gf180mcu_as_sc_mcu7t3v3__nand3_2
Xgf180mcu_as_sc_mcu7t3v3__nand3_2_41 gf180mcu_as_sc_mcu7t3v3__nor2_2_4/VDD gf180mcu_as_sc_mcu7t3v3__nor2_2_4/VSS
+ VSS VSS VSS VSS gf180mcu_as_sc_mcu7t3v3__nor2_2_4/VNW VSUBS gf180mcu_as_sc_mcu7t3v3__nand3_2
Xgf180mcu_as_sc_mcu7t3v3__inv_2_1661 gf180mcu_as_sc_mcu7t3v3__inv_2_1665/VDD VSS gf180mcu_as_sc_mcu7t3v3__inv_2_1689/A
+ gf180mcu_as_sc_mcu7t3v3__inv_2_1689/A gf180mcu_as_sc_mcu7t3v3__inv_2_1665/VNW VSUBS
+ gf180mcu_as_sc_mcu7t3v3__inv_2
Xgf180mcu_as_sc_mcu7t3v3__inv_2_1650 VSS gf180mcu_as_sc_mcu7t3v3__inv_2_1656/VDD VSS
+ gf180mcu_as_sc_mcu7t3v3__inv_2_1669/A gf180mcu_as_sc_mcu7t3v3__inv_2_1652/VNW VSUBS
+ gf180mcu_as_sc_mcu7t3v3__inv_2
Xgf180mcu_as_sc_mcu7t3v3__inv_2_1672 gf180mcu_as_sc_mcu7t3v3__inv_2_1672/VDD VSS gf180mcu_as_sc_mcu7t3v3__inv_2_1672/Y
+ VSS gf180mcu_as_sc_mcu7t3v3__inv_2_1672/VNW VSUBS gf180mcu_as_sc_mcu7t3v3__inv_2
Xgf180mcu_as_sc_mcu7t3v3__inv_2_1683 gf180mcu_as_sc_mcu7t3v3__inv_2_1684/VDD VSS gf180mcu_as_sc_mcu7t3v3__inv_2_1683/Y
+ gf180mcu_as_sc_mcu7t3v3__inv_2_1684/Y gf180mcu_as_sc_mcu7t3v3__inv_2_1684/VNW VSUBS
+ gf180mcu_as_sc_mcu7t3v3__inv_2
Xgf180mcu_as_sc_mcu7t3v3__inv_2_1694 gf180mcu_as_sc_mcu7t3v3__inv_2_1694/VDD VSS gf180mcu_as_sc_mcu7t3v3__inv_2_1694/Y
+ VSS gf180mcu_as_sc_mcu7t3v3__inv_2_1694/VNW VSUBS gf180mcu_as_sc_mcu7t3v3__inv_2
Xu_t007_007 u_t007_007/c0_w0_bl u_t007_007/c0_w0_br u_t007_007/c0_w1_bl u_t007_007/c0_w1_br
+ u_t007_007/c0_r0_rbl u_t007_007/c0_r1_rbl u_t007_007/c1_w0_bl u_t007_007/c1_w0_br
+ u_t007_007/c1_w1_bl u_t007_007/c1_w1_br u_t007_007/c1_r0_rbl u_t007_007/c1_r1_rbl
+ u_t007_007/c2_w0_bl u_t007_007/c2_w0_br u_t007_007/c2_w1_bl u_t007_007/c2_w1_br
+ u_t007_007/c2_r0_rbl u_t007_007/c2_r1_rbl u_t007_007/c3_w0_bl u_t007_007/c3_w0_br
+ u_t007_007/c3_w1_bl u_t007_007/c3_w1_br u_t007_007/c3_r0_rbl u_t007_007/c3_r1_rbl
+ u_t007_007/r0_w0_wl u_t007_007/r0_w1_wl u_t007_007/r0_r0_rwl u_t007_007/r0_r1_rwl
+ u_t007_007/r1_w0_wl u_t007_007/r1_w1_wl u_t007_007/r1_r0_rwl u_t007_007/r1_r1_rwl
+ u_t007_007/r2_w0_wl u_t007_007/r2_w1_wl u_t007_007/r2_r0_rwl u_t007_007/r2_r1_rwl
+ u_t007_007/r3_w0_wl u_t007_007/r3_w1_wl u_t007_007/r3_r0_rwl u_t007_007/r3_r1_rwl
+ VSS u_t007_009/VSS u_t007_007/m2_717_1265# u_t007_007/m2_603_2031# u_t007_007/m2_1290_336#
+ u_t007_007/m2_2000_2037# u_t007_007/m2_791_2909# u_t007_007/m2_7_2126# u_t007_007/m2_2154_2081#
+ u_t007_007/m2_1795_2037# u_t007_007/m2_871_303# u_t007_007/m2_431_438# u_t007_007/m2_1290_2898#
+ u_t007_007/m2_1714_1210# u_t007_007/m2_431_1982# u_t007_007/m2_512_1265# u_t007_007/m2_2573_2126#
+ u_t007_007/m2_603_1259# u_t007_007/m2_2074_2909# u_t007_007/m2_7_336# u_t007_007/m2_717_2037#
+ u_t007_007/m2_1886_2031# u_t007_007/m2_2573_336# u_t007_007/m2_7_2898# u_t007_007/m2_2000_1265#
+ u_t007_007/m2_512_2037# u_t007_007/m2_1795_1265# u_t007_007/m2_1714_1982# u_t007_007/m2_1886_1259#
+ u_t007_007/m2_1290_2126# u_t007_007/m2_1714_438# u_t007_007/m2_431_1210# u_t007_007/m2_2573_2898#
+ u_t007_007/m2_2154_303# u_t007_007/m2_871_2081# VSUBS detronyx_12t_2w2r_rc4_4x4_routed_5layer_direct
Xu_t030_010 u_t030_010/c0_w0_bl u_t030_010/c0_w0_br u_t030_010/c0_w1_bl u_t030_010/c0_w1_br
+ u_t030_010/c0_r0_rbl u_t030_010/c0_r1_rbl u_t030_010/c1_w0_bl u_t030_010/c1_w0_br
+ u_t030_010/c1_w1_bl u_t030_010/c1_w1_br u_t030_010/c1_r0_rbl u_t030_010/c1_r1_rbl
+ u_t030_010/c2_w0_bl u_t030_010/c2_w0_br u_t030_010/c2_w1_bl u_t030_010/c2_w1_br
+ u_t030_010/c2_r0_rbl u_t030_010/c2_r1_rbl u_t030_010/c3_w0_bl u_t030_010/c3_w0_br
+ u_t030_010/c3_w1_bl u_t030_010/c3_w1_br u_t030_010/c3_r0_rbl u_t030_010/c3_r1_rbl
+ u_t030_010/r0_w0_wl u_t030_010/r0_w1_wl u_t030_010/r0_r0_rwl u_t030_010/r0_r1_rwl
+ u_t030_010/r1_w0_wl u_t030_010/r1_w1_wl u_t030_010/r1_r0_rwl u_t030_010/r1_r1_rwl
+ u_t030_010/r2_w0_wl u_t030_010/r2_w1_wl u_t030_010/r2_r0_rwl u_t030_010/r2_r1_rwl
+ u_t030_010/r3_w0_wl u_t030_010/r3_w1_wl u_t030_010/r3_r0_rwl u_t030_010/r3_r1_rwl
+ VSS VSS u_t030_010/m2_717_1265# u_t030_010/m2_603_2031# u_t030_010/m2_1290_336#
+ u_t030_010/m2_2000_2037# u_t030_010/m2_791_2909# u_t030_010/m2_7_2126# u_t030_010/m2_2154_2081#
+ u_t030_010/m2_1795_2037# u_t030_010/m2_871_303# u_t030_010/m2_431_438# u_t030_010/m2_1290_2898#
+ u_t030_010/m2_1714_1210# u_t030_010/m2_431_1982# u_t030_010/m2_512_1265# u_t030_010/m2_2573_2126#
+ u_t030_010/m2_603_1259# u_t030_010/m2_2074_2909# u_t030_010/m2_7_336# u_t030_010/m2_717_2037#
+ u_t030_010/m2_1886_2031# u_t030_010/m2_2573_336# u_t030_010/m2_7_2898# u_t030_010/m2_2000_1265#
+ u_t030_010/m2_512_2037# u_t030_010/m2_1795_1265# u_t030_010/m2_1714_1982# u_t030_010/m2_1886_1259#
+ u_t030_010/m2_1290_2126# u_t030_010/m2_1714_438# u_t030_010/m2_431_1210# u_t030_010/m2_2573_2898#
+ u_t030_010/m2_2154_303# u_t030_010/m2_871_2081# VSUBS detronyx_12t_2w2r_rc4_4x4_routed_5layer_direct
Xgf180mcu_as_sc_mcu7t3v3__nand4_2_499 gf180mcu_as_sc_mcu7t3v3__inv_2_1634/VDD gf180mcu_as_sc_mcu7t3v3__inv_2_1638/VDD
+ VSS VSS VSS VSS VSS gf180mcu_as_sc_mcu7t3v3__inv_2_1634/VNW VSUBS gf180mcu_as_sc_mcu7t3v3__nand4_2
Xgf180mcu_as_sc_mcu7t3v3__nand4_2_433 gf180mcu_as_sc_mcu7t3v3__inv_2_1588/VSS gf180mcu_as_sc_mcu7t3v3__inv_2_1573/VDD
+ VSS VSS VSS VSS gf180mcu_as_sc_mcu7t3v3__nand4_2_433/Y gf180mcu_as_sc_mcu7t3v3__inv_2_1570/VNW
+ VSUBS gf180mcu_as_sc_mcu7t3v3__nand4_2
Xgf180mcu_as_sc_mcu7t3v3__nand4_2_444 VSS VSS VSS VSS VSS VSS VSS gf180mcu_as_sc_mcu7t3v3__inv_2_1669/VNW
+ VSUBS gf180mcu_as_sc_mcu7t3v3__nand4_2
Xgf180mcu_as_sc_mcu7t3v3__nand4_2_488 VSS VSS VSS VSS VSS VSS VSS gf180mcu_as_sc_mcu7t3v3__inv_2_1676/VNW
+ VSUBS gf180mcu_as_sc_mcu7t3v3__nand4_2
Xgf180mcu_as_sc_mcu7t3v3__nand4_2_422 VSS gf180mcu_as_sc_mcu7t3v3__inv_2_1541/VDD
+ VSS VSS VSS VSS gf180mcu_as_sc_mcu7t3v3__nand4_2_422/Y gf180mcu_as_sc_mcu7t3v3__inv_2_1538/VNW
+ VSUBS gf180mcu_as_sc_mcu7t3v3__nand4_2
Xgf180mcu_as_sc_mcu7t3v3__nand4_2_466 gf180mcu_as_sc_mcu7t3v3__inv_2_1370/VDD VSS
+ VSS VSS VSS VSS VSS gf180mcu_as_sc_mcu7t3v3__inv_2_1370/VNW VSUBS gf180mcu_as_sc_mcu7t3v3__nand4_2
Xgf180mcu_as_sc_mcu7t3v3__nand4_2_400 gf180mcu_as_sc_mcu7t3v3__inv_2_1470/VDD gf180mcu_as_sc_mcu7t3v3__inv_2_1473/VDD
+ VSS VSS VSS VSS gf180mcu_as_sc_mcu7t3v3__nand4_2_400/Y gf180mcu_as_sc_mcu7t3v3__inv_2_1470/VNW
+ VSUBS gf180mcu_as_sc_mcu7t3v3__nand4_2
Xgf180mcu_as_sc_mcu7t3v3__nand4_2_477 VSS gf180mcu_as_sc_mcu7t3v3__inv_2_1391/VDD
+ VSS VSS VSS VSS VSS gf180mcu_as_sc_mcu7t3v3__inv_2_1375/VNW VSUBS gf180mcu_as_sc_mcu7t3v3__nand4_2
Xgf180mcu_as_sc_mcu7t3v3__nand4_2_411 gf180mcu_as_sc_mcu7t3v3__inv_2_1503/VDD VSS
+ VSS VSS VSS VSS VSS gf180mcu_as_sc_mcu7t3v3__inv_2_1503/VNW VSUBS gf180mcu_as_sc_mcu7t3v3__nand4_2
Xgf180mcu_as_sc_mcu7t3v3__nand4_2_455 gf180mcu_as_sc_mcu7t3v3__inv_2_1355/VDD VSS
+ VSS VSS VSS VSS VSS gf180mcu_as_sc_mcu7t3v3__inv_2_1355/VNW VSUBS gf180mcu_as_sc_mcu7t3v3__nand4_2
Xu_t021_010 u_t021_010/c0_w0_bl u_t021_010/c0_w0_br u_t021_010/c0_w1_bl u_t021_010/c0_w1_br
+ u_t021_010/c0_r0_rbl u_t021_010/c0_r1_rbl u_t021_010/c1_w0_bl u_t021_010/c1_w0_br
+ u_t021_010/c1_w1_bl u_t021_010/c1_w1_br u_t021_010/c1_r0_rbl u_t021_010/c1_r1_rbl
+ u_t021_010/c2_w0_bl u_t021_010/c2_w0_br u_t021_010/c2_w1_bl u_t021_010/c2_w1_br
+ u_t021_010/c2_r0_rbl u_t021_010/c2_r1_rbl u_t021_010/c3_w0_bl u_t021_010/c3_w0_br
+ u_t021_010/c3_w1_bl u_t021_010/c3_w1_br u_t021_010/c3_r0_rbl u_t021_010/c3_r1_rbl
+ u_t021_010/r0_w0_wl u_t021_010/r0_w1_wl u_t021_010/r0_r0_rwl u_t021_010/r0_r1_rwl
+ u_t021_010/r1_w0_wl u_t021_010/r1_w1_wl u_t021_010/r1_r0_rwl u_t021_010/r1_r1_rwl
+ u_t021_010/r2_w0_wl u_t021_010/r2_w1_wl u_t021_010/r2_r0_rwl u_t021_010/r2_r1_rwl
+ u_t021_010/r3_w0_wl u_t021_010/r3_w1_wl u_t021_010/r3_r0_rwl u_t021_010/r3_r1_rwl
+ VSS VSS u_t021_010/m2_717_1265# u_t021_010/m2_603_2031# u_t021_010/m2_1290_336#
+ u_t021_010/m2_2000_2037# u_t021_010/m2_791_2909# u_t021_010/m2_7_2126# u_t021_010/m2_2154_2081#
+ u_t021_010/m2_1795_2037# u_t021_010/m2_871_303# u_t021_010/m2_431_438# u_t021_010/m2_1290_2898#
+ u_t021_010/m2_1714_1210# u_t021_010/m2_431_1982# u_t021_010/m2_512_1265# u_t021_010/m2_2573_2126#
+ u_t021_010/m2_603_1259# u_t021_010/m2_2074_2909# u_t021_010/m2_7_336# u_t021_010/m2_717_2037#
+ u_t021_010/m2_1886_2031# u_t021_010/m2_2573_336# u_t021_010/m2_7_2898# u_t021_010/m2_2000_1265#
+ u_t021_010/m2_512_2037# u_t021_010/m2_1795_1265# u_t021_010/m2_1714_1982# u_t021_010/m2_1886_1259#
+ u_t021_010/m2_1290_2126# u_t021_010/m2_1714_438# u_t021_010/m2_431_1210# u_t021_010/m2_2573_2898#
+ u_t021_010/m2_2154_303# u_t021_010/m2_871_2081# VSUBS detronyx_12t_2w2r_rc4_4x4_routed_5layer_direct
Xgf180mcu_as_sc_mcu7t3v3__inv_2_1 gf180mcu_as_sc_mcu7t3v3__inv_2_9/VDD gf180mcu_as_sc_mcu7t3v3__inv_2_9/VSS
+ VSS gf180mcu_as_sc_mcu7t3v3__inv_2_9/Y gf180mcu_as_sc_mcu7t3v3__inv_2_9/VNW VSUBS
+ gf180mcu_as_sc_mcu7t3v3__inv_2
Xgf180mcu_as_sc_mcu7t3v3__inv_2_419 gf180mcu_as_sc_mcu7t3v3__nor2_2_6/VDD gf180mcu_as_sc_mcu7t3v3__nor2_2_6/VSS
+ gf180mcu_as_sc_mcu7t3v3__inv_2_419/Y VSS gf180mcu_as_sc_mcu7t3v3__nor2_2_6/VNW VSUBS
+ gf180mcu_as_sc_mcu7t3v3__inv_2
Xgf180mcu_as_sc_mcu7t3v3__inv_2_408 gf180mcu_as_sc_mcu7t3v3__nand3_2_9/VDD gf180mcu_as_sc_mcu7t3v3__nor2_2_4/VSS
+ gf180mcu_as_sc_mcu7t3v3__inv_2_408/Y VSS gf180mcu_as_sc_mcu7t3v3__nand3_2_9/VNW
+ VSUBS gf180mcu_as_sc_mcu7t3v3__inv_2
Xu_t012_010 u_t012_010/c0_w0_bl u_t012_010/c0_w0_br u_t012_010/c0_w1_bl u_t012_010/c0_w1_br
+ u_t012_010/c0_r0_rbl u_t012_010/c0_r1_rbl u_t012_010/c1_w0_bl u_t012_010/c1_w0_br
+ u_t012_010/c1_w1_bl u_t012_010/c1_w1_br u_t012_010/c1_r0_rbl u_t012_010/c1_r1_rbl
+ u_t012_010/c2_w0_bl u_t012_010/c2_w0_br u_t012_010/c2_w1_bl u_t012_010/c2_w1_br
+ u_t012_010/c2_r0_rbl u_t012_010/c2_r1_rbl u_t012_010/c3_w0_bl u_t012_010/c3_w0_br
+ u_t012_010/c3_w1_bl u_t012_010/c3_w1_br u_t012_010/c3_r0_rbl u_t012_010/c3_r1_rbl
+ u_t012_010/r0_w0_wl u_t012_010/r0_w1_wl u_t012_010/r0_r0_rwl u_t012_010/r0_r1_rwl
+ u_t012_010/r1_w0_wl u_t012_010/r1_w1_wl u_t012_010/r1_r0_rwl u_t012_010/r1_r1_rwl
+ u_t012_010/r2_w0_wl u_t012_010/r2_w1_wl u_t012_010/r2_r0_rwl u_t012_010/r2_r1_rwl
+ u_t012_010/r3_w0_wl u_t012_010/r3_w1_wl u_t012_010/r3_r0_rwl u_t012_010/r3_r1_rwl
+ VSS VSS u_t012_010/m2_717_1265# u_t012_010/m2_603_2031# u_t012_010/m2_1290_336#
+ u_t012_010/m2_2000_2037# u_t012_010/m2_791_2909# u_t012_010/m2_7_2126# u_t012_010/m2_2154_2081#
+ u_t012_010/m2_1795_2037# u_t012_010/m2_871_303# u_t012_010/m2_431_438# u_t012_010/m2_1290_2898#
+ u_t012_010/m2_1714_1210# u_t012_010/m2_431_1982# u_t012_010/m2_512_1265# u_t012_010/m2_2573_2126#
+ u_t012_010/m2_603_1259# u_t012_010/m2_2074_2909# u_t012_010/m2_7_336# u_t012_010/m2_717_2037#
+ u_t012_010/m2_1886_2031# u_t012_010/m2_2573_336# u_t012_010/m2_7_2898# u_t012_010/m2_2000_1265#
+ u_t012_010/m2_512_2037# u_t012_010/m2_1795_1265# u_t012_010/m2_1714_1982# u_t012_010/m2_1886_1259#
+ u_t012_010/m2_1290_2126# u_t012_010/m2_1714_438# u_t012_010/m2_431_1210# u_t012_010/m2_2573_2898#
+ u_t012_010/m2_2154_303# u_t012_010/m2_871_2081# VSUBS detronyx_12t_2w2r_rc4_4x4_routed_5layer_direct
Xgf180mcu_as_sc_mcu7t3v3__inv_2_1480 gf180mcu_as_sc_mcu7t3v3__inv_2_1482/VDD VSS VSS
+ VSS gf180mcu_as_sc_mcu7t3v3__inv_2_1482/VNW VSUBS gf180mcu_as_sc_mcu7t3v3__inv_2
Xgf180mcu_as_sc_mcu7t3v3__inv_2_1491 gf180mcu_as_sc_mcu7t3v3__inv_2_1491/VDD VSS gf180mcu_as_sc_mcu7t3v3__inv_2_1491/Y
+ VSS gf180mcu_as_sc_mcu7t3v3__inv_2_1491/VNW VSUBS gf180mcu_as_sc_mcu7t3v3__inv_2
Xu_t003_010 u_t003_010/c0_w0_bl u_t003_010/c0_w0_br u_t003_010/c0_w1_bl u_t003_010/c0_w1_br
+ u_t003_010/c0_r0_rbl u_t003_010/c0_r1_rbl u_t003_010/c1_w0_bl u_t003_010/c1_w0_br
+ u_t003_010/c1_w1_bl u_t003_010/c1_w1_br u_t003_010/c1_r0_rbl u_t003_010/c1_r1_rbl
+ u_t003_010/c2_w0_bl u_t003_010/c2_w0_br u_t003_010/c2_w1_bl u_t003_010/c2_w1_br
+ u_t003_010/c2_r0_rbl u_t003_010/c2_r1_rbl u_t003_010/c3_w0_bl u_t003_010/c3_w0_br
+ u_t003_010/c3_w1_bl u_t003_010/c3_w1_br u_t003_010/c3_r0_rbl u_t003_010/c3_r1_rbl
+ u_t003_010/r0_w0_wl u_t003_010/r0_w1_wl u_t003_010/r0_r0_rwl u_t003_010/r0_r1_rwl
+ u_t003_010/r1_w0_wl u_t003_010/r1_w1_wl u_t003_010/r1_r0_rwl u_t003_010/r1_r1_rwl
+ u_t003_010/r2_w0_wl u_t003_010/r2_w1_wl u_t003_010/r2_r0_rwl u_t003_010/r2_r1_rwl
+ u_t003_010/r3_w0_wl u_t003_010/r3_w1_wl u_t003_010/r3_r0_rwl u_t003_010/r3_r1_rwl
+ VSS u_t003_010/VSS u_t003_010/m2_717_1265# u_t003_010/m2_603_2031# u_t003_010/m2_1290_336#
+ u_t003_010/m2_2000_2037# u_t003_010/m2_791_2909# u_t003_010/m2_7_2126# u_t003_010/m2_2154_2081#
+ u_t003_010/m2_1795_2037# u_t003_010/m2_871_303# u_t003_010/m2_431_438# u_t003_010/m2_1290_2898#
+ u_t003_010/m2_1714_1210# u_t003_010/m2_431_1982# u_t003_010/m2_512_1265# u_t003_010/m2_2573_2126#
+ u_t003_010/m2_603_1259# u_t003_010/m2_2074_2909# u_t003_010/m2_7_336# u_t003_010/m2_717_2037#
+ u_t003_010/m2_1886_2031# u_t003_010/m2_2573_336# u_t003_010/m2_7_2898# u_t003_010/m2_2000_1265#
+ u_t003_010/m2_512_2037# u_t003_010/m2_1795_1265# u_t003_010/m2_1714_1982# u_t003_010/m2_1886_1259#
+ u_t003_010/m2_1290_2126# u_t003_010/m2_1714_438# u_t003_010/m2_431_1210# u_t003_010/m2_2573_2898#
+ u_t003_010/m2_2154_303# u_t003_010/m2_871_2081# VSUBS detronyx_12t_2w2r_rc4_4x4_routed_5layer_direct
Xgf180mcu_as_sc_mcu7t3v3__inv_2_920 VSS VSS gf180mcu_as_sc_mcu7t3v3__inv_2_920/Y VSS
+ gf180mcu_as_sc_mcu7t3v3__inv_2_947/VNW VSUBS gf180mcu_as_sc_mcu7t3v3__inv_2
Xgf180mcu_as_sc_mcu7t3v3__inv_2_953 VSS VSS VSS VSS gf180mcu_as_sc_mcu7t3v3__inv_2_953/VNW
+ VSUBS gf180mcu_as_sc_mcu7t3v3__inv_2
Xgf180mcu_as_sc_mcu7t3v3__inv_2_986 gf180mcu_as_sc_mcu7t3v3__inv_2_988/VDD VSS VSS
+ gf180mcu_as_sc_mcu7t3v3__inv_2_998/A gf180mcu_as_sc_mcu7t3v3__inv_2_988/VNW VSUBS
+ gf180mcu_as_sc_mcu7t3v3__inv_2
Xgf180mcu_as_sc_mcu7t3v3__inv_2_997 VSS VSS gf180mcu_as_sc_mcu7t3v3__inv_2_998/A gf180mcu_as_sc_mcu7t3v3__inv_2_997/A
+ gf180mcu_as_sc_mcu7t3v3__inv_2_997/VNW VSUBS gf180mcu_as_sc_mcu7t3v3__inv_2
Xgf180mcu_as_sc_mcu7t3v3__inv_2_975 gf180mcu_as_sc_mcu7t3v3__inv_2_989/VSS VSS gf180mcu_as_sc_mcu7t3v3__inv_2_998/A
+ gf180mcu_as_sc_mcu7t3v3__inv_2_976/Y gf180mcu_as_sc_mcu7t3v3__inv_2_976/VNW VSUBS
+ gf180mcu_as_sc_mcu7t3v3__inv_2
Xgf180mcu_as_sc_mcu7t3v3__inv_2_931 VSS VSS VSS VSS gf180mcu_as_sc_mcu7t3v3__inv_2_931/VNW
+ VSUBS gf180mcu_as_sc_mcu7t3v3__inv_2
Xgf180mcu_as_sc_mcu7t3v3__inv_2_964 gf180mcu_as_sc_mcu7t3v3__inv_2_964/VDD VSS gf180mcu_as_sc_mcu7t3v3__inv_2_964/Y
+ VSS gf180mcu_as_sc_mcu7t3v3__inv_2_964/VNW VSUBS gf180mcu_as_sc_mcu7t3v3__inv_2
Xgf180mcu_as_sc_mcu7t3v3__inv_2_942 VSS VSS VSS VSS gf180mcu_as_sc_mcu7t3v3__inv_2_942/VNW
+ VSUBS gf180mcu_as_sc_mcu7t3v3__inv_2
Xgf180mcu_as_sc_mcu7t3v3__nand4_2_285 gf180mcu_as_sc_mcu7t3v3__inv_2_1036/VSS VSS
+ VSS VSS VSS VSS VSS gf180mcu_as_sc_mcu7t3v3__inv_2_1012/VNW VSUBS gf180mcu_as_sc_mcu7t3v3__nand4_2
Xgf180mcu_as_sc_mcu7t3v3__nand4_2_274 VSS VSS VSS VSS VSS VSS gf180mcu_as_sc_mcu7t3v3__nand4_2_274/Y
+ gf180mcu_as_sc_mcu7t3v3__inv_2_953/VNW VSUBS gf180mcu_as_sc_mcu7t3v3__nand4_2
Xgf180mcu_as_sc_mcu7t3v3__nand4_2_230 VSS VSS VSS VSS VSS VSS gf180mcu_as_sc_mcu7t3v3__nand4_2_230/Y
+ gf180mcu_as_sc_mcu7t3v3__inv_2_851/VNW VSUBS gf180mcu_as_sc_mcu7t3v3__nand4_2
Xgf180mcu_as_sc_mcu7t3v3__nand4_2_241 VSS VSS VSS VSS VSS VSS VSS gf180mcu_as_sc_mcu7t3v3__inv_2_837/VNW
+ VSUBS gf180mcu_as_sc_mcu7t3v3__nand4_2
Xgf180mcu_as_sc_mcu7t3v3__nand4_2_296 VSS gf180mcu_as_sc_mcu7t3v3__inv_2_960/VSS VSS
+ VSS VSS VSS VSS gf180mcu_as_sc_mcu7t3v3__inv_2_960/VNW VSUBS gf180mcu_as_sc_mcu7t3v3__nand4_2
Xgf180mcu_as_sc_mcu7t3v3__nand4_2_252 VSS VSS VSS VSS VSS VSS gf180mcu_as_sc_mcu7t3v3__nand4_2_252/Y
+ gf180mcu_as_sc_mcu7t3v3__inv_2_938/VNW VSUBS gf180mcu_as_sc_mcu7t3v3__nand4_2
Xgf180mcu_as_sc_mcu7t3v3__nand4_2_263 VSS VSS VSS VSS VSS VSS gf180mcu_as_sc_mcu7t3v3__nand4_2_263/Y
+ gf180mcu_as_sc_mcu7t3v3__inv_2_934/VNW VSUBS gf180mcu_as_sc_mcu7t3v3__nand4_2
Xgf180mcu_as_sc_mcu7t3v3__inv_2_205 gf180mcu_as_sc_mcu7t3v3__inv_2_260/VSS gf180mcu_as_sc_mcu7t3v3__inv_2_206/VSS
+ gf180mcu_as_sc_mcu7t3v3__inv_2_205/Y VSS gf180mcu_as_sc_mcu7t3v3__inv_2_206/VNW
+ VSUBS gf180mcu_as_sc_mcu7t3v3__inv_2
Xgf180mcu_as_sc_mcu7t3v3__inv_2_227 VSS gf180mcu_as_sc_mcu7t3v3__inv_2_260/VDD gf180mcu_as_sc_mcu7t3v3__inv_2_227/Y
+ VSS gf180mcu_as_sc_mcu7t3v3__inv_2_227/VNW VSUBS gf180mcu_as_sc_mcu7t3v3__inv_2
Xgf180mcu_as_sc_mcu7t3v3__inv_2_216 gf180mcu_as_sc_mcu7t3v3__inv_2_218/VDD VSS gf180mcu_as_sc_mcu7t3v3__inv_2_216/Y
+ VSS gf180mcu_as_sc_mcu7t3v3__inv_2_218/VNW VSUBS gf180mcu_as_sc_mcu7t3v3__inv_2
Xgf180mcu_as_sc_mcu7t3v3__inv_2_249 gf180mcu_as_sc_mcu7t3v3__inv_2_251/VDD VSS VSS
+ VSS gf180mcu_as_sc_mcu7t3v3__inv_2_251/VNW VSUBS gf180mcu_as_sc_mcu7t3v3__inv_2
Xgf180mcu_as_sc_mcu7t3v3__inv_2_238 gf180mcu_as_sc_mcu7t3v3__inv_2_239/VDD gf180mcu_as_sc_mcu7t3v3__inv_2_242/VDD
+ gf180mcu_as_sc_mcu7t3v3__inv_2_238/Y VSS gf180mcu_as_sc_mcu7t3v3__inv_2_239/VNW
+ VSUBS gf180mcu_as_sc_mcu7t3v3__inv_2
Xu_t000_013 u_t000_013/c0_w0_bl u_t000_013/c0_w0_br u_t000_013/c0_w1_bl u_t000_013/c0_w1_br
+ u_t000_013/c0_r0_rbl u_t000_013/c0_r1_rbl u_t000_013/c1_w0_bl u_t000_013/c1_w0_br
+ u_t000_013/c1_w1_bl u_t000_013/c1_w1_br u_t000_013/c1_r0_rbl u_t000_013/c1_r1_rbl
+ u_t000_013/c2_w0_bl u_t000_013/c2_w0_br u_t000_013/c2_w1_bl u_t000_013/c2_w1_br
+ u_t000_013/c2_r0_rbl u_t000_013/c2_r1_rbl u_t000_013/c3_w0_bl u_t000_013/c3_w0_br
+ u_t000_013/c3_w1_bl u_t000_013/c3_w1_br u_t000_013/c3_r0_rbl u_t000_013/c3_r1_rbl
+ u_t000_013/r0_w0_wl u_t000_013/r0_w1_wl u_t000_013/r0_r0_rwl u_t000_013/r0_r1_rwl
+ u_t000_013/r1_w0_wl u_t000_013/r1_w1_wl u_t000_013/r1_r0_rwl u_t000_013/r1_r1_rwl
+ u_t000_013/r2_w0_wl u_t000_013/r2_w1_wl u_t000_013/r2_r0_rwl u_t000_013/r2_r1_rwl
+ u_t000_013/r3_w0_wl u_t000_013/r3_w1_wl u_t000_013/r3_r0_rwl u_t000_013/r3_r1_rwl
+ u_t000_013/VDD VSS u_t000_013/m2_717_1265# u_t000_013/m2_603_2031# u_t000_013/m2_1290_336#
+ u_t000_013/m2_2000_2037# u_t000_013/m2_791_2909# u_t000_013/m2_7_2126# u_t000_013/m2_2154_2081#
+ u_t000_013/m2_1795_2037# u_t000_013/m2_871_303# u_t000_013/m2_431_438# u_t000_013/m2_1290_2898#
+ u_t000_013/m2_1714_1210# u_t000_013/m2_431_1982# u_t000_013/m2_512_1265# u_t000_013/m2_2573_2126#
+ u_t000_013/m2_603_1259# u_t000_013/m2_2074_2909# u_t000_013/m2_7_336# u_t000_013/m2_717_2037#
+ u_t000_013/m2_1886_2031# u_t000_013/m2_2573_336# u_t000_013/m2_7_2898# u_t000_013/m2_2000_1265#
+ u_t000_013/m2_512_2037# u_t000_013/m2_1795_1265# u_t000_013/m2_1714_1982# u_t000_013/m2_1886_1259#
+ u_t000_013/m2_1290_2126# u_t000_013/m2_1714_438# u_t000_013/m2_431_1210# u_t000_013/m2_2573_2898#
+ u_t000_013/m2_2154_303# u_t000_013/m2_871_2081# VSUBS detronyx_12t_2w2r_rc4_4x4_routed_5layer_direct
Xu_t000_002 u_t000_002/c0_w0_bl u_t000_002/c0_w0_br u_t000_002/c0_w1_bl u_t000_002/c0_w1_br
+ u_t000_002/c0_r0_rbl u_t000_002/c0_r1_rbl u_t000_002/c1_w0_bl u_t000_002/c1_w0_br
+ u_t000_002/c1_w1_bl u_t000_002/c1_w1_br u_t000_002/c1_r0_rbl u_t000_002/c1_r1_rbl
+ u_t000_002/c2_w0_bl u_t000_002/c2_w0_br u_t000_002/c2_w1_bl u_t000_002/c2_w1_br
+ u_t000_002/c2_r0_rbl u_t000_002/c2_r1_rbl u_t000_002/c3_w0_bl u_t000_002/c3_w0_br
+ u_t000_002/c3_w1_bl u_t000_002/c3_w1_br u_t000_002/c3_r0_rbl u_t000_002/c3_r1_rbl
+ u_t000_002/r0_w0_wl u_t000_002/r0_w1_wl u_t000_002/r0_r0_rwl u_t000_002/r0_r1_rwl
+ u_t000_002/r1_w0_wl u_t000_002/r1_w1_wl u_t000_002/r1_r0_rwl u_t000_002/r1_r1_rwl
+ u_t000_002/r2_w0_wl u_t000_002/r2_w1_wl u_t000_002/r2_r0_rwl u_t000_002/r2_r1_rwl
+ u_t000_002/r3_w0_wl u_t000_002/r3_w1_wl u_t000_002/r3_r0_rwl u_t000_002/r3_r1_rwl
+ VSS VSS u_t000_002/m2_717_1265# u_t000_002/m2_603_2031# u_t000_002/m2_1290_336#
+ u_t000_002/m2_2000_2037# u_t000_002/m2_791_2909# u_t000_002/m2_7_2126# u_t000_002/m2_2154_2081#
+ u_t000_002/m2_1795_2037# u_t000_002/m2_871_303# u_t000_002/m2_431_438# u_t000_002/m2_1290_2898#
+ u_t000_002/m2_1714_1210# u_t000_002/m2_431_1982# u_t000_002/m2_512_1265# u_t000_002/m2_2573_2126#
+ u_t000_002/m2_603_1259# u_t000_002/m2_2074_2909# u_t000_002/m2_7_336# u_t000_002/m2_717_2037#
+ u_t000_002/m2_1886_2031# u_t000_002/m2_2573_336# u_t000_002/m2_7_2898# u_t000_002/m2_2000_1265#
+ u_t000_002/m2_512_2037# u_t000_002/m2_1795_1265# u_t000_002/m2_1714_1982# u_t000_002/m2_1886_1259#
+ u_t000_002/m2_1290_2126# u_t000_002/m2_1714_438# u_t000_002/m2_431_1210# u_t000_002/m2_2573_2898#
+ u_t000_002/m2_2154_303# u_t000_002/m2_871_2081# VSUBS detronyx_12t_2w2r_rc4_4x4_routed_5layer_direct
Xgf180mcu_as_sc_mcu7t3v3__inv_2_772 VSS VSS VSS VSS gf180mcu_as_sc_mcu7t3v3__inv_2_825/VNW
+ VSUBS gf180mcu_as_sc_mcu7t3v3__inv_2
Xgf180mcu_as_sc_mcu7t3v3__inv_2_761 VSS VSS VSS VSS gf180mcu_as_sc_mcu7t3v3__inv_2_821/VNW
+ VSUBS gf180mcu_as_sc_mcu7t3v3__inv_2
Xgf180mcu_as_sc_mcu7t3v3__inv_2_750 VSS VSS VSS VSS gf180mcu_as_sc_mcu7t3v3__inv_2_830/VNW
+ VSUBS gf180mcu_as_sc_mcu7t3v3__inv_2
Xgf180mcu_as_sc_mcu7t3v3__inv_2_783 VSS VSS gf180mcu_as_sc_mcu7t3v3__inv_2_783/Y VSS
+ gf180mcu_as_sc_mcu7t3v3__inv_2_815/VNW VSUBS gf180mcu_as_sc_mcu7t3v3__inv_2
Xgf180mcu_as_sc_mcu7t3v3__inv_2_794 VSS VSS VSS VSS gf180mcu_as_sc_mcu7t3v3__inv_2_845/VNW
+ VSUBS gf180mcu_as_sc_mcu7t3v3__inv_2
Xgf180mcu_as_sc_mcu7t3v3__inv_2_591 gf180mcu_as_sc_mcu7t3v3__inv_2_607/VDD gf180mcu_as_sc_mcu7t3v3__inv_2_637/VDD
+ gf180mcu_as_sc_mcu7t3v3__inv_2_591/Y gf180mcu_as_sc_mcu7t3v3__inv_2_592/Y gf180mcu_as_sc_mcu7t3v3__inv_2_607/VNW
+ VSUBS gf180mcu_as_sc_mcu7t3v3__inv_2
Xgf180mcu_as_sc_mcu7t3v3__inv_2_580 VSS gf180mcu_as_sc_mcu7t3v3__inv_2_588/VDD gf180mcu_as_sc_mcu7t3v3__inv_2_581/A
+ VSS gf180mcu_as_sc_mcu7t3v3__inv_2_585/VNW VSUBS gf180mcu_as_sc_mcu7t3v3__inv_2
Xgf180mcu_as_sc_mcu7t3v3__nor2_2_6 gf180mcu_as_sc_mcu7t3v3__nor2_2_6/VDD gf180mcu_as_sc_mcu7t3v3__nor2_2_6/VSS
+ VSS VSS VSS gf180mcu_as_sc_mcu7t3v3__nor2_2_6/VNW VSUBS gf180mcu_as_sc_mcu7t3v3__nor2_2
Xgf180mcu_as_sc_mcu7t3v3__inv_2_1309 gf180mcu_as_sc_mcu7t3v3__inv_2_1349/VSS VSS VSS
+ gf180mcu_as_sc_mcu7t3v3__inv_2_1355/Y gf180mcu_as_sc_mcu7t3v3__inv_2_1317/VNW VSUBS
+ gf180mcu_as_sc_mcu7t3v3__inv_2
Xu_t028_005 u_t028_005/c0_w0_bl u_t028_005/c0_w0_br u_t028_005/c0_w1_bl u_t028_005/c0_w1_br
+ u_t028_005/c0_r0_rbl u_t028_005/c0_r1_rbl u_t028_005/c1_w0_bl u_t028_005/c1_w0_br
+ u_t028_005/c1_w1_bl u_t028_005/c1_w1_br u_t028_005/c1_r0_rbl u_t028_005/c1_r1_rbl
+ u_t028_005/c2_w0_bl u_t028_005/c2_w0_br u_t028_005/c2_w1_bl u_t028_005/c2_w1_br
+ u_t028_005/c2_r0_rbl u_t028_005/c2_r1_rbl u_t028_005/c3_w0_bl u_t028_005/c3_w0_br
+ u_t028_005/c3_w1_bl u_t028_005/c3_w1_br u_t028_005/c3_r0_rbl u_t028_005/c3_r1_rbl
+ u_t028_005/r0_w0_wl u_t028_005/r0_w1_wl u_t028_005/r0_r0_rwl u_t028_005/r0_r1_rwl
+ u_t028_005/r1_w0_wl u_t028_005/r1_w1_wl u_t028_005/r1_r0_rwl u_t028_005/r1_r1_rwl
+ u_t028_005/r2_w0_wl u_t028_005/r2_w1_wl u_t028_005/r2_r0_rwl u_t028_005/r2_r1_rwl
+ u_t028_005/r3_w0_wl u_t028_005/r3_w1_wl u_t028_005/r3_r0_rwl u_t028_005/r3_r1_rwl
+ u_t029_005/VDD u_t028_005/VSS u_t028_005/m2_717_1265# u_t028_005/m2_603_2031# u_t028_005/m2_1290_336#
+ u_t028_005/m2_2000_2037# u_t028_005/m2_791_2909# u_t028_005/m2_7_2126# u_t028_005/m2_2154_2081#
+ u_t028_005/m2_1795_2037# u_t028_005/m2_871_303# u_t028_005/m2_431_438# u_t028_005/m2_1290_2898#
+ u_t028_005/m2_1714_1210# u_t028_005/m2_431_1982# u_t028_005/m2_512_1265# u_t028_005/m2_2573_2126#
+ u_t028_005/m2_603_1259# u_t028_005/m2_2074_2909# u_t028_005/m2_7_336# u_t028_005/m2_717_2037#
+ u_t028_005/m2_1886_2031# u_t028_005/m2_2573_336# u_t028_005/m2_7_2898# u_t028_005/m2_2000_1265#
+ u_t028_005/m2_512_2037# u_t028_005/m2_1795_1265# u_t028_005/m2_1714_1982# u_t028_005/m2_1886_1259#
+ u_t028_005/m2_1290_2126# u_t028_005/m2_1714_438# u_t028_005/m2_431_1210# u_t028_005/m2_2573_2898#
+ u_t028_005/m2_2154_303# u_t028_005/m2_871_2081# VSUBS detronyx_12t_2w2r_rc4_4x4_routed_5layer_direct
Xu_t019_005 u_t019_005/c0_w0_bl u_t019_005/c0_w0_br u_t019_005/c0_w1_bl u_t019_005/c0_w1_br
+ u_t019_005/c0_r0_rbl u_t019_005/c0_r1_rbl u_t019_005/c1_w0_bl u_t019_005/c1_w0_br
+ u_t019_005/c1_w1_bl u_t019_005/c1_w1_br u_t019_005/c1_r0_rbl u_t019_005/c1_r1_rbl
+ u_t019_005/c2_w0_bl u_t019_005/c2_w0_br u_t019_005/c2_w1_bl u_t019_005/c2_w1_br
+ u_t019_005/c2_r0_rbl u_t019_005/c2_r1_rbl u_t019_005/c3_w0_bl u_t019_005/c3_w0_br
+ u_t019_005/c3_w1_bl u_t019_005/c3_w1_br u_t019_005/c3_r0_rbl u_t019_005/c3_r1_rbl
+ u_t019_005/r0_w0_wl u_t019_005/r0_w1_wl u_t019_005/r0_r0_rwl u_t019_005/r0_r1_rwl
+ u_t019_005/r1_w0_wl u_t019_005/r1_w1_wl u_t019_005/r1_r0_rwl u_t019_005/r1_r1_rwl
+ u_t019_005/r2_w0_wl u_t019_005/r2_w1_wl u_t019_005/r2_r0_rwl u_t019_005/r2_r1_rwl
+ u_t019_005/r3_w0_wl u_t019_005/r3_w1_wl u_t019_005/r3_r0_rwl u_t019_005/r3_r1_rwl
+ u_t019_005/VDD u_t019_005/VSS u_t019_005/m2_717_1265# u_t019_005/m2_603_2031# u_t019_005/m2_1290_336#
+ u_t019_005/m2_2000_2037# u_t019_005/m2_791_2909# u_t019_005/m2_7_2126# u_t019_005/m2_2154_2081#
+ u_t019_005/m2_1795_2037# u_t019_005/m2_871_303# u_t019_005/m2_431_438# u_t019_005/m2_1290_2898#
+ u_t019_005/m2_1714_1210# u_t019_005/m2_431_1982# u_t019_005/m2_512_1265# u_t019_005/m2_2573_2126#
+ u_t019_005/m2_603_1259# u_t019_005/m2_2074_2909# u_t019_005/m2_7_336# u_t019_005/m2_717_2037#
+ u_t019_005/m2_1886_2031# u_t019_005/m2_2573_336# u_t019_005/m2_7_2898# u_t019_005/m2_2000_1265#
+ u_t019_005/m2_512_2037# u_t019_005/m2_1795_1265# u_t019_005/m2_1714_1982# u_t019_005/m2_1886_1259#
+ u_t019_005/m2_1290_2126# u_t019_005/m2_1714_438# u_t019_005/m2_431_1210# u_t019_005/m2_2573_2898#
+ u_t019_005/m2_2154_303# u_t019_005/m2_871_2081# VSUBS detronyx_12t_2w2r_rc4_4x4_routed_5layer_direct
Xu_t025_008 u_t025_008/c0_w0_bl u_t025_008/c0_w0_br u_t025_008/c0_w1_bl u_t025_008/c0_w1_br
+ u_t025_008/c0_r0_rbl u_t025_008/c0_r1_rbl u_t025_008/c1_w0_bl u_t025_008/c1_w0_br
+ u_t025_008/c1_w1_bl u_t025_008/c1_w1_br u_t025_008/c1_r0_rbl u_t025_008/c1_r1_rbl
+ u_t025_008/c2_w0_bl u_t025_008/c2_w0_br u_t025_008/c2_w1_bl u_t025_008/c2_w1_br
+ u_t025_008/c2_r0_rbl u_t025_008/c2_r1_rbl u_t025_008/c3_w0_bl u_t025_008/c3_w0_br
+ u_t025_008/c3_w1_bl u_t025_008/c3_w1_br u_t025_008/c3_r0_rbl u_t025_008/c3_r1_rbl
+ u_t025_008/r0_w0_wl u_t025_008/r0_w1_wl u_t025_008/r0_r0_rwl u_t025_008/r0_r1_rwl
+ u_t025_008/r1_w0_wl u_t025_008/r1_w1_wl u_t025_008/r1_r0_rwl u_t025_008/r1_r1_rwl
+ u_t025_008/r2_w0_wl u_t025_008/r2_w1_wl u_t025_008/r2_r0_rwl u_t025_008/r2_r1_rwl
+ u_t025_008/r3_w0_wl u_t025_008/r3_w1_wl u_t025_008/r3_r0_rwl u_t025_008/r3_r1_rwl
+ VSS VSS u_t025_008/m2_717_1265# u_t025_008/m2_603_2031# u_t025_008/m2_1290_336#
+ u_t025_008/m2_2000_2037# u_t025_008/m2_791_2909# u_t025_008/m2_7_2126# u_t025_008/m2_2154_2081#
+ u_t025_008/m2_1795_2037# u_t025_008/m2_871_303# u_t025_008/m2_431_438# u_t025_008/m2_1290_2898#
+ u_t025_008/m2_1714_1210# u_t025_008/m2_431_1982# u_t025_008/m2_512_1265# u_t025_008/m2_2573_2126#
+ u_t025_008/m2_603_1259# u_t025_008/m2_2074_2909# u_t025_008/m2_7_336# u_t025_008/m2_717_2037#
+ u_t025_008/m2_1886_2031# u_t025_008/m2_2573_336# u_t025_008/m2_7_2898# u_t025_008/m2_2000_1265#
+ u_t025_008/m2_512_2037# u_t025_008/m2_1795_1265# u_t025_008/m2_1714_1982# u_t025_008/m2_1886_1259#
+ u_t025_008/m2_1290_2126# u_t025_008/m2_1714_438# u_t025_008/m2_431_1210# u_t025_008/m2_2573_2898#
+ u_t025_008/m2_2154_303# u_t025_008/m2_871_2081# VSUBS detronyx_12t_2w2r_rc4_4x4_routed_5layer_direct
Xgf180mcu_as_sc_mcu7t3v3__inv_2_1128 gf180mcu_as_sc_mcu7t3v3__inv_2_1129/VDD gf180mcu_as_sc_mcu7t3v3__inv_2_1133/VDD
+ gf180mcu_as_sc_mcu7t3v3__inv_2_1128/Y gf180mcu_as_sc_mcu7t3v3__inv_2_1129/Y gf180mcu_as_sc_mcu7t3v3__inv_2_1129/VNW
+ VSUBS gf180mcu_as_sc_mcu7t3v3__inv_2
Xgf180mcu_as_sc_mcu7t3v3__inv_2_1139 gf180mcu_as_sc_mcu7t3v3__inv_2_1139/VDD gf180mcu_as_sc_mcu7t3v3__inv_2_1142/VDD
+ gf180mcu_as_sc_mcu7t3v3__inv_2_1139/Y VSS gf180mcu_as_sc_mcu7t3v3__inv_2_1139/VNW
+ VSUBS gf180mcu_as_sc_mcu7t3v3__inv_2
Xgf180mcu_as_sc_mcu7t3v3__inv_2_1117 VSS VSS gf180mcu_as_sc_mcu7t3v3__inv_2_1122/A
+ gf180mcu_as_sc_mcu7t3v3__inv_2_1118/Y gf180mcu_as_sc_mcu7t3v3__inv_2_1118/VNW VSUBS
+ gf180mcu_as_sc_mcu7t3v3__inv_2
Xgf180mcu_as_sc_mcu7t3v3__inv_2_1106 VSS VSS gf180mcu_as_sc_mcu7t3v3__inv_2_1109/A
+ gf180mcu_as_sc_mcu7t3v3__inv_2_1107/Y gf180mcu_as_sc_mcu7t3v3__inv_2_1107/VNW VSUBS
+ gf180mcu_as_sc_mcu7t3v3__inv_2
Xu_t016_008 u_t016_008/c0_w0_bl u_t016_008/c0_w0_br u_t016_008/c0_w1_bl u_t016_008/c0_w1_br
+ u_t016_008/c0_r0_rbl u_t016_008/c0_r1_rbl u_t016_008/c1_w0_bl u_t016_008/c1_w0_br
+ u_t016_008/c1_w1_bl u_t016_008/c1_w1_br u_t016_008/c1_r0_rbl u_t016_008/c1_r1_rbl
+ u_t016_008/c2_w0_bl u_t016_008/c2_w0_br u_t016_008/c2_w1_bl u_t016_008/c2_w1_br
+ u_t016_008/c2_r0_rbl u_t016_008/c2_r1_rbl u_t016_008/c3_w0_bl u_t016_008/c3_w0_br
+ u_t016_008/c3_w1_bl u_t016_008/c3_w1_br u_t016_008/c3_r0_rbl u_t016_008/c3_r1_rbl
+ u_t016_008/r0_w0_wl u_t016_008/r0_w1_wl u_t016_008/r0_r0_rwl u_t016_008/r0_r1_rwl
+ u_t016_008/r1_w0_wl u_t016_008/r1_w1_wl u_t016_008/r1_r0_rwl u_t016_008/r1_r1_rwl
+ u_t016_008/r2_w0_wl u_t016_008/r2_w1_wl u_t016_008/r2_r0_rwl u_t016_008/r2_r1_rwl
+ u_t016_008/r3_w0_wl u_t016_008/r3_w1_wl u_t016_008/r3_r0_rwl u_t016_008/r3_r1_rwl
+ VSS u_t016_009/VSS u_t016_008/m2_717_1265# u_t016_008/m2_603_2031# u_t016_008/m2_1290_336#
+ u_t016_008/m2_2000_2037# u_t016_008/m2_791_2909# u_t016_008/m2_7_2126# u_t016_008/m2_2154_2081#
+ u_t016_008/m2_1795_2037# u_t016_008/m2_871_303# u_t016_008/m2_431_438# u_t016_008/m2_1290_2898#
+ u_t016_008/m2_1714_1210# u_t016_008/m2_431_1982# u_t016_008/m2_512_1265# u_t016_008/m2_2573_2126#
+ u_t016_008/m2_603_1259# u_t016_008/m2_2074_2909# u_t016_008/m2_7_336# u_t016_008/m2_717_2037#
+ u_t016_008/m2_1886_2031# u_t016_008/m2_2573_336# u_t016_008/m2_7_2898# u_t016_008/m2_2000_1265#
+ u_t016_008/m2_512_2037# u_t016_008/m2_1795_1265# u_t016_008/m2_1714_1982# u_t016_008/m2_1886_1259#
+ u_t016_008/m2_1290_2126# u_t016_008/m2_1714_438# u_t016_008/m2_431_1210# u_t016_008/m2_2573_2898#
+ u_t016_008/m2_2154_303# u_t016_008/m2_871_2081# VSUBS detronyx_12t_2w2r_rc4_4x4_routed_5layer_direct
Xgf180mcu_as_sc_mcu7t3v3__nand3_2_53 gf180mcu_as_sc_mcu7t3v3__nor2_2_9/VDD gf180mcu_as_sc_mcu7t3v3__nand3_2_63/VSS
+ VSS VSS VSS VSS gf180mcu_as_sc_mcu7t3v3__nor2_2_9/VNW VSUBS gf180mcu_as_sc_mcu7t3v3__nand3_2
Xgf180mcu_as_sc_mcu7t3v3__nand3_2_64 gf180mcu_as_sc_mcu7t3v3__nor2_2_9/VDD gf180mcu_as_sc_mcu7t3v3__nor2_2_9/VSS
+ VSS VSS VSS VSS gf180mcu_as_sc_mcu7t3v3__nor2_2_9/VNW VSUBS gf180mcu_as_sc_mcu7t3v3__nand3_2
Xgf180mcu_as_sc_mcu7t3v3__nand3_2_20 gf180mcu_as_sc_mcu7t3v3__nor2_2_4/VDD gf180mcu_as_sc_mcu7t3v3__nand2_2_3/VSS
+ VSS VSS VSS VSS gf180mcu_as_sc_mcu7t3v3__nor2_2_4/VNW VSUBS gf180mcu_as_sc_mcu7t3v3__nand3_2
Xgf180mcu_as_sc_mcu7t3v3__nand3_2_42 gf180mcu_as_sc_mcu7t3v3__nor2_2_4/VDD gf180mcu_as_sc_mcu7t3v3__nand2_2_3/VSS
+ VSS VSS VSS VSS gf180mcu_as_sc_mcu7t3v3__nor2_2_4/VNW VSUBS gf180mcu_as_sc_mcu7t3v3__nand3_2
Xgf180mcu_as_sc_mcu7t3v3__nand3_2_31 gf180mcu_as_sc_mcu7t3v3__nor2_2_7/VDD gf180mcu_as_sc_mcu7t3v3__nor2_2_7/VSS
+ VSS VSS VSS VSS gf180mcu_as_sc_mcu7t3v3__nor2_2_7/VNW VSUBS gf180mcu_as_sc_mcu7t3v3__nand3_2
Xgf180mcu_as_sc_mcu7t3v3__inv_2_1640 VSS gf180mcu_as_sc_mcu7t3v3__inv_2_1649/VDD VSS
+ gf180mcu_as_sc_mcu7t3v3__inv_2_1689/A gf180mcu_as_sc_mcu7t3v3__inv_2_1642/VNW VSUBS
+ gf180mcu_as_sc_mcu7t3v3__inv_2
Xgf180mcu_as_sc_mcu7t3v3__inv_2_1673 VSS gf180mcu_as_sc_mcu7t3v3__inv_2_1689/VDD VSS
+ gf180mcu_as_sc_mcu7t3v3__inv_2_1689/A gf180mcu_as_sc_mcu7t3v3__inv_2_1681/VNW VSUBS
+ gf180mcu_as_sc_mcu7t3v3__inv_2
Xgf180mcu_as_sc_mcu7t3v3__inv_2_1651 VSS gf180mcu_as_sc_mcu7t3v3__inv_2_1656/VDD gf180mcu_as_sc_mcu7t3v3__inv_2_1669/A
+ gf180mcu_as_sc_mcu7t3v3__inv_2_1669/A gf180mcu_as_sc_mcu7t3v3__inv_2_1652/VNW VSUBS
+ gf180mcu_as_sc_mcu7t3v3__inv_2
Xgf180mcu_as_sc_mcu7t3v3__inv_2_1662 VSS VSS VSS gf180mcu_as_sc_mcu7t3v3__inv_2_1672/Y
+ gf180mcu_as_sc_mcu7t3v3__inv_2_1664/VNW VSUBS gf180mcu_as_sc_mcu7t3v3__inv_2
Xgf180mcu_as_sc_mcu7t3v3__inv_2_1684 gf180mcu_as_sc_mcu7t3v3__inv_2_1684/VDD VSS gf180mcu_as_sc_mcu7t3v3__inv_2_1684/Y
+ VSS gf180mcu_as_sc_mcu7t3v3__inv_2_1684/VNW VSUBS gf180mcu_as_sc_mcu7t3v3__inv_2
Xgf180mcu_as_sc_mcu7t3v3__inv_2_1695 gf180mcu_as_sc_mcu7t3v3__inv_2_1697/VDD VSS VSS
+ VSS gf180mcu_as_sc_mcu7t3v3__inv_2_1697/VNW VSUBS gf180mcu_as_sc_mcu7t3v3__inv_2
Xu_t007_008 u_t007_008/c0_w0_bl u_t007_008/c0_w0_br u_t007_008/c0_w1_bl u_t007_008/c0_w1_br
+ u_t007_008/c0_r0_rbl u_t007_008/c0_r1_rbl u_t007_008/c1_w0_bl u_t007_008/c1_w0_br
+ u_t007_008/c1_w1_bl u_t007_008/c1_w1_br u_t007_008/c1_r0_rbl u_t007_008/c1_r1_rbl
+ u_t007_008/c2_w0_bl u_t007_008/c2_w0_br u_t007_008/c2_w1_bl u_t007_008/c2_w1_br
+ u_t007_008/c2_r0_rbl u_t007_008/c2_r1_rbl u_t007_008/c3_w0_bl u_t007_008/c3_w0_br
+ u_t007_008/c3_w1_bl u_t007_008/c3_w1_br u_t007_008/c3_r0_rbl u_t007_008/c3_r1_rbl
+ u_t007_008/r0_w0_wl u_t007_008/r0_w1_wl u_t007_008/r0_r0_rwl u_t007_008/r0_r1_rwl
+ u_t007_008/r1_w0_wl u_t007_008/r1_w1_wl u_t007_008/r1_r0_rwl u_t007_008/r1_r1_rwl
+ u_t007_008/r2_w0_wl u_t007_008/r2_w1_wl u_t007_008/r2_r0_rwl u_t007_008/r2_r1_rwl
+ u_t007_008/r3_w0_wl u_t007_008/r3_w1_wl u_t007_008/r3_r0_rwl u_t007_008/r3_r1_rwl
+ VSS u_t007_009/VSS u_t007_008/m2_717_1265# u_t007_008/m2_603_2031# u_t007_008/m2_1290_336#
+ u_t007_008/m2_2000_2037# u_t007_008/m2_791_2909# u_t007_008/m2_7_2126# u_t007_008/m2_2154_2081#
+ u_t007_008/m2_1795_2037# u_t007_008/m2_871_303# u_t007_008/m2_431_438# u_t007_008/m2_1290_2898#
+ u_t007_008/m2_1714_1210# u_t007_008/m2_431_1982# u_t007_008/m2_512_1265# u_t007_008/m2_2573_2126#
+ u_t007_008/m2_603_1259# u_t007_008/m2_2074_2909# u_t007_008/m2_7_336# u_t007_008/m2_717_2037#
+ u_t007_008/m2_1886_2031# u_t007_008/m2_2573_336# u_t007_008/m2_7_2898# u_t007_008/m2_2000_1265#
+ u_t007_008/m2_512_2037# u_t007_008/m2_1795_1265# u_t007_008/m2_1714_1982# u_t007_008/m2_1886_1259#
+ u_t007_008/m2_1290_2126# u_t007_008/m2_1714_438# u_t007_008/m2_431_1210# u_t007_008/m2_2573_2898#
+ u_t007_008/m2_2154_303# u_t007_008/m2_871_2081# VSUBS detronyx_12t_2w2r_rc4_4x4_routed_5layer_direct
Xu_t030_011 u_t030_011/c0_w0_bl u_t030_011/c0_w0_br u_t030_011/c0_w1_bl u_t030_011/c0_w1_br
+ u_t030_011/c0_r0_rbl u_t030_011/c0_r1_rbl u_t030_011/c1_w0_bl u_t030_011/c1_w0_br
+ u_t030_011/c1_w1_bl u_t030_011/c1_w1_br u_t030_011/c1_r0_rbl u_t030_011/c1_r1_rbl
+ u_t030_011/c2_w0_bl u_t030_011/c2_w0_br u_t030_011/c2_w1_bl u_t030_011/c2_w1_br
+ u_t030_011/c2_r0_rbl u_t030_011/c2_r1_rbl u_t030_011/c3_w0_bl u_t030_011/c3_w0_br
+ u_t030_011/c3_w1_bl u_t030_011/c3_w1_br u_t030_011/c3_r0_rbl u_t030_011/c3_r1_rbl
+ u_t030_011/r0_w0_wl u_t030_011/r0_w1_wl u_t030_011/r0_r0_rwl u_t030_011/r0_r1_rwl
+ u_t030_011/r1_w0_wl u_t030_011/r1_w1_wl u_t030_011/r1_r0_rwl u_t030_011/r1_r1_rwl
+ u_t030_011/r2_w0_wl u_t030_011/r2_w1_wl u_t030_011/r2_r0_rwl u_t030_011/r2_r1_rwl
+ u_t030_011/r3_w0_wl u_t030_011/r3_w1_wl u_t030_011/r3_r0_rwl u_t030_011/r3_r1_rwl
+ u_t030_011/VDD VSS u_t030_011/m2_717_1265# u_t030_011/m2_603_2031# u_t030_011/m2_1290_336#
+ u_t030_011/m2_2000_2037# u_t030_011/m2_791_2909# u_t030_011/m2_7_2126# u_t030_011/m2_2154_2081#
+ u_t030_011/m2_1795_2037# u_t030_011/m2_871_303# u_t030_011/m2_431_438# u_t030_011/m2_1290_2898#
+ u_t030_011/m2_1714_1210# u_t030_011/m2_431_1982# u_t030_011/m2_512_1265# u_t030_011/m2_2573_2126#
+ u_t030_011/m2_603_1259# u_t030_011/m2_2074_2909# u_t030_011/m2_7_336# u_t030_011/m2_717_2037#
+ u_t030_011/m2_1886_2031# u_t030_011/m2_2573_336# u_t030_011/m2_7_2898# u_t030_011/m2_2000_1265#
+ u_t030_011/m2_512_2037# u_t030_011/m2_1795_1265# u_t030_011/m2_1714_1982# u_t030_011/m2_1886_1259#
+ u_t030_011/m2_1290_2126# u_t030_011/m2_1714_438# u_t030_011/m2_431_1210# u_t030_011/m2_2573_2898#
+ u_t030_011/m2_2154_303# u_t030_011/m2_871_2081# VSUBS detronyx_12t_2w2r_rc4_4x4_routed_5layer_direct
Xu_t030_000 VSS u_t030_000/c0_w0_br VSS u_t030_000/c0_w1_br u_t030_000/c0_r0_rbl u_t030_000/c0_r1_rbl
+ VSS VSS VSS VSS VSS VSS u_t030_000/c2_w0_bl u_t030_000/c2_w0_br u_t030_000/c2_w1_bl
+ u_t030_000/c2_w1_br u_t030_000/c2_r0_rbl u_t030_000/c2_r1_rbl u_t030_000/c3_w0_bl
+ u_t030_000/c3_w0_br u_t030_000/c3_w1_bl u_t030_000/c3_w1_br u_t030_000/c3_r0_rbl
+ u_t030_000/c3_r1_rbl VSS VSS VSS VSS VSS VSS VSS VSS VSS VSS VSS VSS VSS VSS VSS
+ VSS VSS VSS u_t030_000/m2_717_1265# VSS VSS VSS VSS u_t030_000/m2_7_2126# VSS VSS
+ VSS VSS VSS VSS VSS u_t030_000/m2_512_1265# VSS u_t030_000/m2_603_1259# VSS VSS
+ VSS VSS VSS VSS u_t030_000/m2_2000_1265# VSS u_t030_000/m2_1795_1265# VSS u_t030_000/m2_1886_1259#
+ u_t030_000/m2_1290_2126# VSS VSS VSS VSS VSS VSUBS detronyx_12t_2w2r_rc4_4x4_routed_5layer_direct
Xgf180mcu_as_sc_mcu7t3v3__nand4_2_401 gf180mcu_as_sc_mcu7t3v3__inv_2_1473/VDD VSS
+ VSS VSS VSS VSS VSS gf180mcu_as_sc_mcu7t3v3__inv_2_1473/VNW VSUBS gf180mcu_as_sc_mcu7t3v3__nand4_2
Xgf180mcu_as_sc_mcu7t3v3__nand4_2_434 gf180mcu_as_sc_mcu7t3v3__inv_2_1573/VDD VSS
+ VSS VSS VSS VSS gf180mcu_as_sc_mcu7t3v3__nand4_2_434/Y gf180mcu_as_sc_mcu7t3v3__inv_2_1573/VNW
+ VSUBS gf180mcu_as_sc_mcu7t3v3__nand4_2
Xgf180mcu_as_sc_mcu7t3v3__nand4_2_445 VSS gf180mcu_as_sc_mcu7t3v3__inv_2_1614/VDD
+ VSS VSS VSS VSS VSS gf180mcu_as_sc_mcu7t3v3__inv_2_1606/VNW VSUBS gf180mcu_as_sc_mcu7t3v3__nand4_2
Xgf180mcu_as_sc_mcu7t3v3__nand4_2_489 VSS gf180mcu_as_sc_mcu7t3v3__inv_2_1684/VDD
+ VSS VSS VSS VSS VSS gf180mcu_as_sc_mcu7t3v3__inv_2_1680/VNW VSUBS gf180mcu_as_sc_mcu7t3v3__nand4_2
Xgf180mcu_as_sc_mcu7t3v3__nand4_2_423 gf180mcu_as_sc_mcu7t3v3__inv_2_1541/VDD gf180mcu_as_sc_mcu7t3v3__inv_2_1697/VDD
+ VSS VSS VSS VSS gf180mcu_as_sc_mcu7t3v3__nand4_2_423/Y gf180mcu_as_sc_mcu7t3v3__inv_2_1541/VNW
+ VSUBS gf180mcu_as_sc_mcu7t3v3__nand4_2
Xgf180mcu_as_sc_mcu7t3v3__nand4_2_467 VSS gf180mcu_as_sc_mcu7t3v3__inv_2_1378/VDD
+ VSS VSS VSS VSS VSS gf180mcu_as_sc_mcu7t3v3__inv_2_1374/VNW VSUBS gf180mcu_as_sc_mcu7t3v3__nand4_2
Xgf180mcu_as_sc_mcu7t3v3__nand4_2_478 gf180mcu_as_sc_mcu7t3v3__inv_2_1391/VDD gf180mcu_as_sc_mcu7t3v3__inv_2_1403/VDD
+ VSS VSS VSS VSS VSS gf180mcu_as_sc_mcu7t3v3__inv_2_1391/VNW VSUBS gf180mcu_as_sc_mcu7t3v3__nand4_2
Xgf180mcu_as_sc_mcu7t3v3__nand4_2_412 VSS gf180mcu_as_sc_mcu7t3v3__inv_2_1508/VDD
+ VSS VSS VSS VSS VSS gf180mcu_as_sc_mcu7t3v3__inv_2_1506/VNW VSUBS gf180mcu_as_sc_mcu7t3v3__nand4_2
Xgf180mcu_as_sc_mcu7t3v3__inv_2_2 gf180mcu_as_sc_mcu7t3v3__inv_2_4/VDD gf180mcu_as_sc_mcu7t3v3__inv_2_8/VDD
+ VSS gf180mcu_as_sc_mcu7t3v3__inv_2_8/Y gf180mcu_as_sc_mcu7t3v3__inv_2_4/VNW VSUBS
+ gf180mcu_as_sc_mcu7t3v3__inv_2
Xgf180mcu_as_sc_mcu7t3v3__nand4_2_456 VSS gf180mcu_as_sc_mcu7t3v3__inv_2_1316/VDD
+ VSS VSS VSS VSS VSS gf180mcu_as_sc_mcu7t3v3__inv_2_1312/VNW VSUBS gf180mcu_as_sc_mcu7t3v3__nand4_2
Xu_t021_011 u_t021_011/c0_w0_bl u_t021_011/c0_w0_br u_t021_011/c0_w1_bl u_t021_011/c0_w1_br
+ u_t021_011/c0_r0_rbl u_t021_011/c0_r1_rbl u_t021_011/c1_w0_bl u_t021_011/c1_w0_br
+ u_t021_011/c1_w1_bl u_t021_011/c1_w1_br u_t021_011/c1_r0_rbl u_t021_011/c1_r1_rbl
+ u_t021_011/c2_w0_bl u_t021_011/c2_w0_br u_t021_011/c2_w1_bl u_t021_011/c2_w1_br
+ u_t021_011/c2_r0_rbl u_t021_011/c2_r1_rbl u_t021_011/c3_w0_bl u_t021_011/c3_w0_br
+ u_t021_011/c3_w1_bl u_t021_011/c3_w1_br u_t021_011/c3_r0_rbl u_t021_011/c3_r1_rbl
+ u_t021_011/r0_w0_wl u_t021_011/r0_w1_wl u_t021_011/r0_r0_rwl u_t021_011/r0_r1_rwl
+ u_t021_011/r1_w0_wl u_t021_011/r1_w1_wl u_t021_011/r1_r0_rwl u_t021_011/r1_r1_rwl
+ u_t021_011/r2_w0_wl u_t021_011/r2_w1_wl u_t021_011/r2_r0_rwl u_t021_011/r2_r1_rwl
+ u_t021_011/r3_w0_wl u_t021_011/r3_w1_wl u_t021_011/r3_r0_rwl u_t021_011/r3_r1_rwl
+ u_t021_011/VDD VSS u_t021_011/m2_717_1265# u_t021_011/m2_603_2031# u_t021_011/m2_1290_336#
+ u_t021_011/m2_2000_2037# u_t021_011/m2_791_2909# u_t021_011/m2_7_2126# u_t021_011/m2_2154_2081#
+ u_t021_011/m2_1795_2037# u_t021_011/m2_871_303# u_t021_011/m2_431_438# u_t021_011/m2_1290_2898#
+ u_t021_011/m2_1714_1210# u_t021_011/m2_431_1982# u_t021_011/m2_512_1265# u_t021_011/m2_2573_2126#
+ u_t021_011/m2_603_1259# u_t021_011/m2_2074_2909# u_t021_011/m2_7_336# u_t021_011/m2_717_2037#
+ u_t021_011/m2_1886_2031# u_t021_011/m2_2573_336# u_t021_011/m2_7_2898# u_t021_011/m2_2000_1265#
+ u_t021_011/m2_512_2037# u_t021_011/m2_1795_1265# u_t021_011/m2_1714_1982# u_t021_011/m2_1886_1259#
+ u_t021_011/m2_1290_2126# u_t021_011/m2_1714_438# u_t021_011/m2_431_1210# u_t021_011/m2_2573_2898#
+ u_t021_011/m2_2154_303# u_t021_011/m2_871_2081# VSUBS detronyx_12t_2w2r_rc4_4x4_routed_5layer_direct
Xu_t021_000 VSS u_t021_000/c0_w0_br VSS u_t021_000/c0_w1_br u_t021_000/c0_r0_rbl u_t021_000/c0_r1_rbl
+ VSS VSS VSS VSS VSS VSS u_t021_000/c2_w0_bl u_t021_000/c2_w0_br u_t021_000/c2_w1_bl
+ u_t021_000/c2_w1_br u_t021_000/c2_r0_rbl u_t021_000/c2_r1_rbl u_t021_000/c3_w0_bl
+ u_t021_000/c3_w0_br u_t021_000/c3_w1_bl u_t021_000/c3_w1_br u_t021_000/c3_r0_rbl
+ u_t021_000/c3_r1_rbl VSS VSS VSS VSS VSS VSS VSS VSS VSS VSS VSS VSS VSS VSS VSS
+ VSS VSS VSS u_t021_000/m2_717_1265# VSS VSS VSS VSS VSS VSS VSS VSS VSS VSS VSS
+ VSS u_t021_000/m2_512_1265# u_t021_000/m2_2573_2126# VSS VSS VSS VSS VSS u_t021_000/m2_2573_336#
+ VSS u_t021_000/m2_2000_1265# VSS u_t021_000/m2_1795_1265# VSS VSS VSS VSS VSS u_t021_000/m2_2573_2898#
+ VSS VSS VSUBS detronyx_12t_2w2r_rc4_4x4_routed_5layer_direct
Xgf180mcu_as_sc_mcu7t3v3__inv_2_409 gf180mcu_as_sc_mcu7t3v3__nor2_2_4/VDD gf180mcu_as_sc_mcu7t3v3__nor2_2_4/VSS
+ VSS VSS gf180mcu_as_sc_mcu7t3v3__nor2_2_4/VNW VSUBS gf180mcu_as_sc_mcu7t3v3__inv_2
Xu_t012_011 u_t012_011/c0_w0_bl u_t012_011/c0_w0_br u_t012_011/c0_w1_bl u_t012_011/c0_w1_br
+ u_t012_011/c0_r0_rbl u_t012_011/c0_r1_rbl u_t012_011/c1_w0_bl u_t012_011/c1_w0_br
+ u_t012_011/c1_w1_bl u_t012_011/c1_w1_br u_t012_011/c1_r0_rbl u_t012_011/c1_r1_rbl
+ u_t012_011/c2_w0_bl u_t012_011/c2_w0_br u_t012_011/c2_w1_bl u_t012_011/c2_w1_br
+ u_t012_011/c2_r0_rbl u_t012_011/c2_r1_rbl u_t012_011/c3_w0_bl u_t012_011/c3_w0_br
+ u_t012_011/c3_w1_bl u_t012_011/c3_w1_br u_t012_011/c3_r0_rbl u_t012_011/c3_r1_rbl
+ u_t012_011/r0_w0_wl u_t012_011/r0_w1_wl u_t012_011/r0_r0_rwl u_t012_011/r0_r1_rwl
+ u_t012_011/r1_w0_wl u_t012_011/r1_w1_wl u_t012_011/r1_r0_rwl u_t012_011/r1_r1_rwl
+ u_t012_011/r2_w0_wl u_t012_011/r2_w1_wl u_t012_011/r2_r0_rwl u_t012_011/r2_r1_rwl
+ u_t012_011/r3_w0_wl u_t012_011/r3_w1_wl u_t012_011/r3_r0_rwl u_t012_011/r3_r1_rwl
+ u_t012_011/VDD VSS u_t012_011/m2_717_1265# u_t012_011/m2_603_2031# u_t012_011/m2_1290_336#
+ u_t012_011/m2_2000_2037# u_t012_011/m2_791_2909# u_t012_011/m2_7_2126# u_t012_011/m2_2154_2081#
+ u_t012_011/m2_1795_2037# u_t012_011/m2_871_303# u_t012_011/m2_431_438# u_t012_011/m2_1290_2898#
+ u_t012_011/m2_1714_1210# u_t012_011/m2_431_1982# u_t012_011/m2_512_1265# u_t012_011/m2_2573_2126#
+ u_t012_011/m2_603_1259# u_t012_011/m2_2074_2909# u_t012_011/m2_7_336# u_t012_011/m2_717_2037#
+ u_t012_011/m2_1886_2031# u_t012_011/m2_2573_336# u_t012_011/m2_7_2898# u_t012_011/m2_2000_1265#
+ u_t012_011/m2_512_2037# u_t012_011/m2_1795_1265# u_t012_011/m2_1714_1982# u_t012_011/m2_1886_1259#
+ u_t012_011/m2_1290_2126# u_t012_011/m2_1714_438# u_t012_011/m2_431_1210# u_t012_011/m2_2573_2898#
+ u_t012_011/m2_2154_303# u_t012_011/m2_871_2081# VSUBS detronyx_12t_2w2r_rc4_4x4_routed_5layer_direct
Xu_t012_000 VSS u_t012_000/c0_w0_br VSS u_t012_000/c0_w1_br u_t012_000/c0_r0_rbl u_t012_000/c0_r1_rbl
+ VSS VSS VSS VSS VSS VSS u_t012_000/c2_w0_bl u_t012_000/c2_w0_br u_t012_000/c2_w1_bl
+ u_t012_000/c2_w1_br u_t012_000/c2_r0_rbl u_t012_000/c2_r1_rbl u_t012_000/c3_w0_bl
+ u_t012_000/c3_w0_br u_t012_000/c3_w1_bl u_t012_000/c3_w1_br u_t012_000/c3_r0_rbl
+ u_t012_000/c3_r1_rbl VSS VSS VSS VSS VSS VSS VSS VSS VSS VSS VSS VSS VSS VSS VSS
+ VSS VSS VSS u_t012_000/m2_717_1265# u_t012_000/m2_603_2031# u_t012_000/m2_1290_336#
+ u_t012_000/m2_2000_2037# u_t012_000/m2_791_2909# u_t012_000/m2_7_2126# u_t012_000/m2_2154_2081#
+ u_t012_000/m2_1795_2037# u_t012_000/m2_871_303# u_t012_000/m2_431_438# u_t012_000/m2_1290_2898#
+ u_t012_000/m2_1714_1210# u_t012_000/m2_431_1982# u_t012_000/m2_512_1265# u_t012_000/m2_2573_2126#
+ u_t012_000/m2_603_1259# u_t012_000/m2_2074_2909# u_t012_000/m2_7_336# u_t012_000/m2_717_2037#
+ u_t012_000/m2_1886_2031# u_t012_000/m2_2573_336# u_t012_000/m2_7_2898# u_t012_000/m2_2000_1265#
+ u_t012_000/m2_512_2037# u_t012_000/m2_1795_1265# u_t012_000/m2_1714_1982# u_t012_000/m2_1886_1259#
+ u_t012_000/m2_1290_2126# u_t012_000/m2_1714_438# u_t012_000/m2_431_1210# u_t012_000/m2_2573_2898#
+ u_t012_000/m2_2154_303# u_t012_000/m2_871_2081# VSUBS detronyx_12t_2w2r_rc4_4x4_routed_5layer_direct
Xgf180mcu_as_sc_mcu7t3v3__inv_2_1470 gf180mcu_as_sc_mcu7t3v3__inv_2_1470/VDD gf180mcu_as_sc_mcu7t3v3__inv_2_1473/VDD
+ gf180mcu_as_sc_mcu7t3v3__inv_2_1470/Y VSS gf180mcu_as_sc_mcu7t3v3__inv_2_1470/VNW
+ VSUBS gf180mcu_as_sc_mcu7t3v3__inv_2
Xgf180mcu_as_sc_mcu7t3v3__inv_2_1481 gf180mcu_as_sc_mcu7t3v3__inv_2_1482/VDD VSS gf180mcu_as_sc_mcu7t3v3__inv_2_1481/Y
+ VSS gf180mcu_as_sc_mcu7t3v3__inv_2_1482/VNW VSUBS gf180mcu_as_sc_mcu7t3v3__inv_2
Xgf180mcu_as_sc_mcu7t3v3__inv_2_1492 VSS VSS VSS VSS gf180mcu_as_sc_mcu7t3v3__inv_2_1494/VNW
+ VSUBS gf180mcu_as_sc_mcu7t3v3__inv_2
Xu_t003_011 u_t003_011/c0_w0_bl u_t003_011/c0_w0_br u_t003_011/c0_w1_bl u_t003_011/c0_w1_br
+ u_t003_011/c0_r0_rbl u_t003_011/c0_r1_rbl u_t003_011/c1_w0_bl u_t003_011/c1_w0_br
+ u_t003_011/c1_w1_bl u_t003_011/c1_w1_br u_t003_011/c1_r0_rbl u_t003_011/c1_r1_rbl
+ u_t003_011/c2_w0_bl u_t003_011/c2_w0_br u_t003_011/c2_w1_bl u_t003_011/c2_w1_br
+ u_t003_011/c2_r0_rbl u_t003_011/c2_r1_rbl u_t003_011/c3_w0_bl u_t003_011/c3_w0_br
+ u_t003_011/c3_w1_bl u_t003_011/c3_w1_br u_t003_011/c3_r0_rbl u_t003_011/c3_r1_rbl
+ u_t003_011/r0_w0_wl u_t003_011/r0_w1_wl u_t003_011/r0_r0_rwl u_t003_011/r0_r1_rwl
+ u_t003_011/r1_w0_wl u_t003_011/r1_w1_wl u_t003_011/r1_r0_rwl u_t003_011/r1_r1_rwl
+ u_t003_011/r2_w0_wl u_t003_011/r2_w1_wl u_t003_011/r2_r0_rwl u_t003_011/r2_r1_rwl
+ u_t003_011/r3_w0_wl u_t003_011/r3_w1_wl u_t003_011/r3_r0_rwl u_t003_011/r3_r1_rwl
+ u_t004_011/VDD u_t003_011/VSS u_t003_011/m2_717_1265# u_t003_011/m2_603_2031# u_t003_011/m2_1290_336#
+ u_t003_011/m2_2000_2037# u_t003_011/m2_791_2909# u_t003_011/m2_7_2126# u_t003_011/m2_2154_2081#
+ u_t003_011/m2_1795_2037# u_t003_011/m2_871_303# u_t003_011/m2_431_438# u_t003_011/m2_1290_2898#
+ u_t003_011/m2_1714_1210# u_t003_011/m2_431_1982# u_t003_011/m2_512_1265# u_t003_011/m2_2573_2126#
+ u_t003_011/m2_603_1259# u_t003_011/m2_2074_2909# u_t003_011/m2_7_336# u_t003_011/m2_717_2037#
+ u_t003_011/m2_1886_2031# u_t003_011/m2_2573_336# u_t003_011/m2_7_2898# u_t003_011/m2_2000_1265#
+ u_t003_011/m2_512_2037# u_t003_011/m2_1795_1265# u_t003_011/m2_1714_1982# u_t003_011/m2_1886_1259#
+ u_t003_011/m2_1290_2126# u_t003_011/m2_1714_438# u_t003_011/m2_431_1210# u_t003_011/m2_2573_2898#
+ u_t003_011/m2_2154_303# u_t003_011/m2_871_2081# VSUBS detronyx_12t_2w2r_rc4_4x4_routed_5layer_direct
Xgf180mcu_as_sc_mcu7t3v3__inv_2_954 VSS VSS VSS VSS gf180mcu_as_sc_mcu7t3v3__inv_2_954/VNW
+ VSUBS gf180mcu_as_sc_mcu7t3v3__inv_2
Xgf180mcu_as_sc_mcu7t3v3__inv_2_910 VSS VSS VSS VSS gf180mcu_as_sc_mcu7t3v3__inv_2_954/VNW
+ VSUBS gf180mcu_as_sc_mcu7t3v3__inv_2
Xgf180mcu_as_sc_mcu7t3v3__inv_2_921 VSS VSS VSS VSS gf180mcu_as_sc_mcu7t3v3__inv_2_955/VNW
+ VSUBS gf180mcu_as_sc_mcu7t3v3__inv_2
Xu_t003_000 VSS u_t003_000/c0_w0_br VSS u_t003_000/c0_w1_br u_t003_000/c0_r0_rbl u_t003_000/c0_r1_rbl
+ VSS VSS VSS VSS VSS VSS u_t003_000/c2_w0_bl u_t003_000/c2_w0_br u_t003_000/c2_w1_bl
+ u_t003_000/c2_w1_br u_t003_000/c2_r0_rbl u_t003_000/c2_r1_rbl u_t003_000/c3_w0_bl
+ u_t003_000/c3_w0_br u_t003_000/c3_w1_bl u_t003_000/c3_w1_br u_t003_000/c3_r0_rbl
+ u_t003_000/c3_r1_rbl VSS VSS VSS VSS VSS VSS VSS VSS VSS VSS VSS VSS VSS VSS VSS
+ VSS VSS VSS u_t003_000/m2_717_1265# u_t003_000/m2_603_2031# u_t003_000/m2_1290_336#
+ u_t003_000/m2_2000_2037# u_t003_000/m2_791_2909# u_t003_000/m2_7_2126# u_t003_000/m2_2154_2081#
+ u_t003_000/m2_1795_2037# u_t003_000/m2_871_303# u_t003_000/m2_431_438# u_t003_000/m2_1290_2898#
+ u_t003_000/m2_1714_1210# u_t003_000/m2_431_1982# u_t003_000/m2_512_1265# u_t003_000/m2_2573_2126#
+ u_t003_000/m2_603_1259# u_t003_000/m2_2074_2909# u_t003_000/m2_7_336# u_t003_000/m2_717_2037#
+ u_t003_000/m2_1886_2031# u_t003_000/m2_2573_336# u_t003_000/m2_7_2898# u_t003_000/m2_2000_1265#
+ u_t003_000/m2_512_2037# u_t003_000/m2_1795_1265# u_t003_000/m2_1714_1982# u_t003_000/m2_1886_1259#
+ u_t003_000/m2_1290_2126# u_t003_000/m2_1714_438# u_t003_000/m2_431_1210# u_t003_000/m2_2573_2898#
+ u_t003_000/m2_2154_303# u_t003_000/m2_871_2081# VSUBS detronyx_12t_2w2r_rc4_4x4_routed_5layer_direct
Xgf180mcu_as_sc_mcu7t3v3__inv_2_998 gf180mcu_as_sc_mcu7t3v3__inv_2_999/VDD VSS VSS
+ gf180mcu_as_sc_mcu7t3v3__inv_2_998/A gf180mcu_as_sc_mcu7t3v3__inv_2_999/VNW VSUBS
+ gf180mcu_as_sc_mcu7t3v3__inv_2
Xgf180mcu_as_sc_mcu7t3v3__inv_2_987 gf180mcu_as_sc_mcu7t3v3__inv_2_988/VDD VSS gf180mcu_as_sc_mcu7t3v3__inv_2_998/A
+ gf180mcu_as_sc_mcu7t3v3__inv_2_988/Y gf180mcu_as_sc_mcu7t3v3__inv_2_988/VNW VSUBS
+ gf180mcu_as_sc_mcu7t3v3__inv_2
Xgf180mcu_as_sc_mcu7t3v3__inv_2_976 gf180mcu_as_sc_mcu7t3v3__inv_2_989/VSS VSS gf180mcu_as_sc_mcu7t3v3__inv_2_976/Y
+ VSS gf180mcu_as_sc_mcu7t3v3__inv_2_976/VNW VSUBS gf180mcu_as_sc_mcu7t3v3__inv_2
Xgf180mcu_as_sc_mcu7t3v3__inv_2_965 VSS gf180mcu_as_sc_mcu7t3v3__inv_2_989/VDD gf180mcu_as_sc_mcu7t3v3__inv_2_965/Y
+ gf180mcu_as_sc_mcu7t3v3__inv_2_969/Y gf180mcu_as_sc_mcu7t3v3__inv_2_969/VNW VSUBS
+ gf180mcu_as_sc_mcu7t3v3__inv_2
Xgf180mcu_as_sc_mcu7t3v3__inv_2_932 VSS VSS VSS VSS gf180mcu_as_sc_mcu7t3v3__inv_2_932/VNW
+ VSUBS gf180mcu_as_sc_mcu7t3v3__inv_2
Xgf180mcu_as_sc_mcu7t3v3__inv_2_943 VSS VSS VSS VSS gf180mcu_as_sc_mcu7t3v3__inv_2_943/VNW
+ VSUBS gf180mcu_as_sc_mcu7t3v3__inv_2
Xgf180mcu_as_sc_mcu7t3v3__nand4_2_220 VSS VSS VSS VSS VSS VSS VSS gf180mcu_as_sc_mcu7t3v3__inv_2_821/VNW
+ VSUBS gf180mcu_as_sc_mcu7t3v3__nand4_2
Xgf180mcu_as_sc_mcu7t3v3__nand4_2_231 VSS VSS VSS VSS VSS VSS VSS gf180mcu_as_sc_mcu7t3v3__inv_2_850/VNW
+ VSUBS gf180mcu_as_sc_mcu7t3v3__nand4_2
Xgf180mcu_as_sc_mcu7t3v3__nand4_2_242 VSS VSS VSS VSS VSS VSS gf180mcu_as_sc_mcu7t3v3__nand4_2_242/Y
+ gf180mcu_as_sc_mcu7t3v3__inv_2_838/VNW VSUBS gf180mcu_as_sc_mcu7t3v3__nand4_2
Xgf180mcu_as_sc_mcu7t3v3__nand4_2_253 VSS VSS VSS VSS VSS VSS VSS gf180mcu_as_sc_mcu7t3v3__inv_2_942/VNW
+ VSUBS gf180mcu_as_sc_mcu7t3v3__nand4_2
Xgf180mcu_as_sc_mcu7t3v3__nand4_2_286 VSS gf180mcu_as_sc_mcu7t3v3__inv_2_1028/VDD
+ VSS VSS VSS VSS VSS gf180mcu_as_sc_mcu7t3v3__inv_2_1016/VNW VSUBS gf180mcu_as_sc_mcu7t3v3__nand4_2
Xgf180mcu_as_sc_mcu7t3v3__nand4_2_297 gf180mcu_as_sc_mcu7t3v3__inv_2_964/VDD VSS VSS
+ VSS VSS VSS VSS gf180mcu_as_sc_mcu7t3v3__inv_2_964/VNW VSUBS gf180mcu_as_sc_mcu7t3v3__nand4_2
Xgf180mcu_as_sc_mcu7t3v3__nand4_2_264 VSS VSS VSS VSS VSS VSS gf180mcu_as_sc_mcu7t3v3__nand4_2_264/Y
+ gf180mcu_as_sc_mcu7t3v3__inv_2_941/VNW VSUBS gf180mcu_as_sc_mcu7t3v3__nand4_2
Xgf180mcu_as_sc_mcu7t3v3__nand4_2_275 VSS VSS VSS VSS VSS VSS VSS gf180mcu_as_sc_mcu7t3v3__inv_2_957/VNW
+ VSUBS gf180mcu_as_sc_mcu7t3v3__nand4_2
Xgf180mcu_as_sc_mcu7t3v3__inv_2_206 gf180mcu_as_sc_mcu7t3v3__inv_2_260/VSS gf180mcu_as_sc_mcu7t3v3__inv_2_206/VSS
+ gf180mcu_as_sc_mcu7t3v3__inv_2_206/Y VSS gf180mcu_as_sc_mcu7t3v3__inv_2_206/VNW
+ VSUBS gf180mcu_as_sc_mcu7t3v3__inv_2
Xgf180mcu_as_sc_mcu7t3v3__inv_2_228 gf180mcu_as_sc_mcu7t3v3__inv_2_260/VDD gf180mcu_as_sc_mcu7t3v3__inv_2_260/VDD
+ gf180mcu_as_sc_mcu7t3v3__inv_2_228/Y VSS gf180mcu_as_sc_mcu7t3v3__inv_2_230/VNW
+ VSUBS gf180mcu_as_sc_mcu7t3v3__inv_2
Xgf180mcu_as_sc_mcu7t3v3__inv_2_217 gf180mcu_as_sc_mcu7t3v3__inv_2_218/VDD VSS gf180mcu_as_sc_mcu7t3v3__inv_2_217/Y
+ VSS gf180mcu_as_sc_mcu7t3v3__inv_2_218/VNW VSUBS gf180mcu_as_sc_mcu7t3v3__inv_2
Xgf180mcu_as_sc_mcu7t3v3__inv_2_239 gf180mcu_as_sc_mcu7t3v3__inv_2_239/VDD gf180mcu_as_sc_mcu7t3v3__inv_2_242/VDD
+ gf180mcu_as_sc_mcu7t3v3__inv_2_239/Y VSS gf180mcu_as_sc_mcu7t3v3__inv_2_239/VNW
+ VSUBS gf180mcu_as_sc_mcu7t3v3__inv_2
Xu_t000_014 u_t000_014/c0_w0_bl u_t000_014/c0_w0_br u_t000_014/c0_w1_bl u_t000_014/c0_w1_br
+ u_t000_014/c0_r0_rbl u_t000_014/c0_r1_rbl u_t000_014/c1_w0_bl u_t000_014/c1_w0_br
+ u_t000_014/c1_w1_bl u_t000_014/c1_w1_br u_t000_014/c1_r0_rbl u_t000_014/c1_r1_rbl
+ u_t000_014/c2_w0_bl u_t000_014/c2_w0_br u_t000_014/c2_w1_bl u_t000_014/c2_w1_br
+ u_t000_014/c2_r0_rbl u_t000_014/c2_r1_rbl u_t000_014/c3_w0_bl u_t000_014/c3_w0_br
+ u_t000_014/c3_w1_bl u_t000_014/c3_w1_br u_t000_014/c3_r0_rbl u_t000_014/c3_r1_rbl
+ u_t000_014/r0_w0_wl u_t000_014/r0_w1_wl u_t000_014/r0_r0_rwl u_t000_014/r0_r1_rwl
+ u_t000_014/r1_w0_wl u_t000_014/r1_w1_wl u_t000_014/r1_r0_rwl u_t000_014/r1_r1_rwl
+ u_t000_014/r2_w0_wl u_t000_014/r2_w1_wl u_t000_014/r2_r0_rwl u_t000_014/r2_r1_rwl
+ u_t000_014/r3_w0_wl u_t000_014/r3_w1_wl u_t000_014/r3_r0_rwl u_t000_014/r3_r1_rwl
+ u_t000_014/VDD VSS u_t000_014/m2_717_1265# u_t000_014/m2_603_2031# u_t000_014/m2_1290_336#
+ u_t000_014/m2_2000_2037# u_t000_014/m2_791_2909# u_t000_014/m2_7_2126# u_t000_014/m2_2154_2081#
+ u_t000_014/m2_1795_2037# u_t000_014/m2_871_303# u_t000_014/m2_431_438# u_t000_014/m2_1290_2898#
+ u_t000_014/m2_1714_1210# u_t000_014/m2_431_1982# u_t000_014/m2_512_1265# u_t000_014/m2_2573_2126#
+ u_t000_014/m2_603_1259# u_t000_014/m2_2074_2909# u_t000_014/m2_7_336# u_t000_014/m2_717_2037#
+ u_t000_014/m2_1886_2031# u_t000_014/m2_2573_336# u_t000_014/m2_7_2898# u_t000_014/m2_2000_1265#
+ u_t000_014/m2_512_2037# u_t000_014/m2_1795_1265# u_t000_014/m2_1714_1982# u_t000_014/m2_1886_1259#
+ u_t000_014/m2_1290_2126# u_t000_014/m2_1714_438# u_t000_014/m2_431_1210# u_t000_014/m2_2573_2898#
+ u_t000_014/m2_2154_303# u_t000_014/m2_871_2081# VSUBS detronyx_12t_2w2r_rc4_4x4_routed_5layer_direct
Xu_t000_003 u_t000_003/c0_w0_bl u_t000_003/c0_w0_br u_t000_003/c0_w1_bl u_t000_003/c0_w1_br
+ u_t000_003/c0_r0_rbl u_t000_003/c0_r1_rbl u_t000_003/c1_w0_bl u_t000_003/c1_w0_br
+ u_t000_003/c1_w1_bl u_t000_003/c1_w1_br u_t000_003/c1_r0_rbl u_t000_003/c1_r1_rbl
+ u_t000_003/c2_w0_bl u_t000_003/c2_w0_br u_t000_003/c2_w1_bl u_t000_003/c2_w1_br
+ u_t000_003/c2_r0_rbl u_t000_003/c2_r1_rbl u_t000_003/c3_w0_bl u_t000_003/c3_w0_br
+ u_t000_003/c3_w1_bl u_t000_003/c3_w1_br u_t000_003/c3_r0_rbl u_t000_003/c3_r1_rbl
+ u_t000_003/r0_w0_wl u_t000_003/r0_w1_wl u_t000_003/r0_r0_rwl u_t000_003/r0_r1_rwl
+ u_t000_003/r1_w0_wl u_t000_003/r1_w1_wl u_t000_003/r1_r0_rwl u_t000_003/r1_r1_rwl
+ u_t000_003/r2_w0_wl u_t000_003/r2_w1_wl u_t000_003/r2_r0_rwl u_t000_003/r2_r1_rwl
+ u_t000_003/r3_w0_wl u_t000_003/r3_w1_wl u_t000_003/r3_r0_rwl u_t000_003/r3_r1_rwl
+ u_t000_003/VDD VSS u_t000_003/m2_717_1265# u_t000_003/m2_603_2031# u_t000_003/m2_1290_336#
+ u_t000_003/m2_2000_2037# u_t000_003/m2_791_2909# u_t000_003/m2_7_2126# u_t000_003/m2_2154_2081#
+ u_t000_003/m2_1795_2037# u_t000_003/m2_871_303# u_t000_003/m2_431_438# u_t000_003/m2_1290_2898#
+ u_t000_003/m2_1714_1210# u_t000_003/m2_431_1982# u_t000_003/m2_512_1265# u_t000_003/m2_2573_2126#
+ u_t000_003/m2_603_1259# u_t000_003/m2_2074_2909# u_t000_003/m2_7_336# u_t000_003/m2_717_2037#
+ u_t000_003/m2_1886_2031# u_t000_003/m2_2573_336# u_t000_003/m2_7_2898# u_t000_003/m2_2000_1265#
+ u_t000_003/m2_512_2037# u_t000_003/m2_1795_1265# u_t000_003/m2_1714_1982# u_t000_003/m2_1886_1259#
+ u_t000_003/m2_1290_2126# u_t000_003/m2_1714_438# u_t000_003/m2_431_1210# u_t000_003/m2_2573_2898#
+ u_t000_003/m2_2154_303# u_t000_003/m2_871_2081# VSUBS detronyx_12t_2w2r_rc4_4x4_routed_5layer_direct
Xgf180mcu_as_sc_mcu7t3v3__inv_2_773 VSS VSS VSS VSS gf180mcu_as_sc_mcu7t3v3__inv_2_825/VNW
+ VSUBS gf180mcu_as_sc_mcu7t3v3__inv_2
Xgf180mcu_as_sc_mcu7t3v3__inv_2_762 VSS VSS VSS VSS gf180mcu_as_sc_mcu7t3v3__inv_2_821/VNW
+ VSUBS gf180mcu_as_sc_mcu7t3v3__inv_2
Xgf180mcu_as_sc_mcu7t3v3__inv_2_751 VSS VSS gf180mcu_as_sc_mcu7t3v3__inv_2_751/Y VSS
+ gf180mcu_as_sc_mcu7t3v3__inv_2_830/VNW VSUBS gf180mcu_as_sc_mcu7t3v3__inv_2
Xgf180mcu_as_sc_mcu7t3v3__inv_2_795 VSS VSS gf180mcu_as_sc_mcu7t3v3__inv_2_795/Y VSS
+ gf180mcu_as_sc_mcu7t3v3__inv_2_845/VNW VSUBS gf180mcu_as_sc_mcu7t3v3__inv_2
Xgf180mcu_as_sc_mcu7t3v3__inv_2_784 VSS VSS VSS VSS gf180mcu_as_sc_mcu7t3v3__inv_2_842/VNW
+ VSUBS gf180mcu_as_sc_mcu7t3v3__inv_2
Xgf180mcu_as_sc_mcu7t3v3__inv_2_740 VSS gf180mcu_as_sc_mcu7t3v3__inv_2_743/VDD gf180mcu_as_sc_mcu7t3v3__inv_2_740/Y
+ VSS gf180mcu_as_sc_mcu7t3v3__inv_2_740/VNW VSUBS gf180mcu_as_sc_mcu7t3v3__inv_2
Xgf180mcu_as_sc_mcu7t3v3__inv_2_581 VSS gf180mcu_as_sc_mcu7t3v3__inv_2_588/VDD gf180mcu_as_sc_mcu7t3v3__inv_2_581/Y
+ gf180mcu_as_sc_mcu7t3v3__inv_2_581/A gf180mcu_as_sc_mcu7t3v3__inv_2_585/VNW VSUBS
+ gf180mcu_as_sc_mcu7t3v3__inv_2
Xgf180mcu_as_sc_mcu7t3v3__inv_2_570 gf180mcu_as_sc_mcu7t3v3__inv_2_570/VDD gf180mcu_as_sc_mcu7t3v3__inv_2_576/VDD
+ gf180mcu_as_sc_mcu7t3v3__inv_2_570/Y VSS gf180mcu_as_sc_mcu7t3v3__inv_2_570/VNW
+ VSUBS gf180mcu_as_sc_mcu7t3v3__inv_2
Xgf180mcu_as_sc_mcu7t3v3__inv_2_592 gf180mcu_as_sc_mcu7t3v3__inv_2_607/VDD gf180mcu_as_sc_mcu7t3v3__inv_2_637/VDD
+ gf180mcu_as_sc_mcu7t3v3__inv_2_592/Y VSS gf180mcu_as_sc_mcu7t3v3__inv_2_607/VNW
+ VSUBS gf180mcu_as_sc_mcu7t3v3__inv_2
Xgf180mcu_as_sc_mcu7t3v3__nor2_2_7 gf180mcu_as_sc_mcu7t3v3__nor2_2_7/VDD gf180mcu_as_sc_mcu7t3v3__nor2_2_7/VSS
+ VSS VSS VSS gf180mcu_as_sc_mcu7t3v3__nor2_2_7/VNW VSUBS gf180mcu_as_sc_mcu7t3v3__nor2_2
Xu_t028_006 u_t028_006/c0_w0_bl u_t028_006/c0_w0_br u_t028_006/c0_w1_bl u_t028_006/c0_w1_br
+ u_t028_006/c0_r0_rbl u_t028_006/c0_r1_rbl u_t028_006/c1_w0_bl u_t028_006/c1_w0_br
+ u_t028_006/c1_w1_bl u_t028_006/c1_w1_br u_t028_006/c1_r0_rbl u_t028_006/c1_r1_rbl
+ u_t028_006/c2_w0_bl u_t028_006/c2_w0_br u_t028_006/c2_w1_bl u_t028_006/c2_w1_br
+ u_t028_006/c2_r0_rbl u_t028_006/c2_r1_rbl u_t028_006/c3_w0_bl u_t028_006/c3_w0_br
+ u_t028_006/c3_w1_bl u_t028_006/c3_w1_br u_t028_006/c3_r0_rbl u_t028_006/c3_r1_rbl
+ u_t028_006/r0_w0_wl u_t028_006/r0_w1_wl u_t028_006/r0_r0_rwl u_t028_006/r0_r1_rwl
+ u_t028_006/r1_w0_wl u_t028_006/r1_w1_wl u_t028_006/r1_r0_rwl u_t028_006/r1_r1_rwl
+ u_t028_006/r2_w0_wl u_t028_006/r2_w1_wl u_t028_006/r2_r0_rwl u_t028_006/r2_r1_rwl
+ u_t028_006/r3_w0_wl u_t028_006/r3_w1_wl u_t028_006/r3_r0_rwl u_t028_006/r3_r1_rwl
+ u_t029_006/VDD u_t028_009/VSS u_t028_006/m2_717_1265# u_t028_006/m2_603_2031# u_t028_006/m2_1290_336#
+ u_t028_006/m2_2000_2037# u_t028_006/m2_791_2909# u_t028_006/m2_7_2126# u_t028_006/m2_2154_2081#
+ u_t028_006/m2_1795_2037# u_t028_006/m2_871_303# u_t028_006/m2_431_438# u_t028_006/m2_1290_2898#
+ u_t028_006/m2_1714_1210# u_t028_006/m2_431_1982# u_t028_006/m2_512_1265# u_t028_006/m2_2573_2126#
+ u_t028_006/m2_603_1259# u_t028_006/m2_2074_2909# u_t028_006/m2_7_336# u_t028_006/m2_717_2037#
+ u_t028_006/m2_1886_2031# u_t028_006/m2_2573_336# u_t028_006/m2_7_2898# u_t028_006/m2_2000_1265#
+ u_t028_006/m2_512_2037# u_t028_006/m2_1795_1265# u_t028_006/m2_1714_1982# u_t028_006/m2_1886_1259#
+ u_t028_006/m2_1290_2126# u_t028_006/m2_1714_438# u_t028_006/m2_431_1210# u_t028_006/m2_2573_2898#
+ u_t028_006/m2_2154_303# u_t028_006/m2_871_2081# VSUBS detronyx_12t_2w2r_rc4_4x4_routed_5layer_direct
Xu_t019_006 u_t019_006/c0_w0_bl u_t019_006/c0_w0_br u_t019_006/c0_w1_bl u_t019_006/c0_w1_br
+ u_t019_006/c0_r0_rbl u_t019_006/c0_r1_rbl u_t019_006/c1_w0_bl u_t019_006/c1_w0_br
+ u_t019_006/c1_w1_bl u_t019_006/c1_w1_br u_t019_006/c1_r0_rbl u_t019_006/c1_r1_rbl
+ u_t019_006/c2_w0_bl u_t019_006/c2_w0_br u_t019_006/c2_w1_bl u_t019_006/c2_w1_br
+ u_t019_006/c2_r0_rbl u_t019_006/c2_r1_rbl u_t019_006/c3_w0_bl u_t019_006/c3_w0_br
+ u_t019_006/c3_w1_bl u_t019_006/c3_w1_br u_t019_006/c3_r0_rbl u_t019_006/c3_r1_rbl
+ u_t019_006/r0_w0_wl u_t019_006/r0_w1_wl u_t019_006/r0_r0_rwl u_t019_006/r0_r1_rwl
+ u_t019_006/r1_w0_wl u_t019_006/r1_w1_wl u_t019_006/r1_r0_rwl u_t019_006/r1_r1_rwl
+ u_t019_006/r2_w0_wl u_t019_006/r2_w1_wl u_t019_006/r2_r0_rwl u_t019_006/r2_r1_rwl
+ u_t019_006/r3_w0_wl u_t019_006/r3_w1_wl u_t019_006/r3_r0_rwl u_t019_006/r3_r1_rwl
+ u_t019_006/VDD u_t019_009/VSS u_t019_006/m2_717_1265# u_t019_006/m2_603_2031# u_t019_006/m2_1290_336#
+ u_t019_006/m2_2000_2037# u_t019_006/m2_791_2909# u_t019_006/m2_7_2126# u_t019_006/m2_2154_2081#
+ u_t019_006/m2_1795_2037# u_t019_006/m2_871_303# u_t019_006/m2_431_438# u_t019_006/m2_1290_2898#
+ u_t019_006/m2_1714_1210# u_t019_006/m2_431_1982# u_t019_006/m2_512_1265# u_t019_006/m2_2573_2126#
+ u_t019_006/m2_603_1259# u_t019_006/m2_2074_2909# u_t019_006/m2_7_336# u_t019_006/m2_717_2037#
+ u_t019_006/m2_1886_2031# u_t019_006/m2_2573_336# u_t019_006/m2_7_2898# u_t019_006/m2_2000_1265#
+ u_t019_006/m2_512_2037# u_t019_006/m2_1795_1265# u_t019_006/m2_1714_1982# u_t019_006/m2_1886_1259#
+ u_t019_006/m2_1290_2126# u_t019_006/m2_1714_438# u_t019_006/m2_431_1210# u_t019_006/m2_2573_2898#
+ u_t019_006/m2_2154_303# u_t019_006/m2_871_2081# VSUBS detronyx_12t_2w2r_rc4_4x4_routed_5layer_direct
Xu_t025_009 u_t025_009/c0_w0_bl u_t025_009/c0_w0_br u_t025_009/c0_w1_bl u_t025_009/c0_w1_br
+ u_t025_009/c0_r0_rbl u_t025_009/c0_r1_rbl u_t025_009/c1_w0_bl u_t025_009/c1_w0_br
+ u_t025_009/c1_w1_bl u_t025_009/c1_w1_br u_t025_009/c1_r0_rbl u_t025_009/c1_r1_rbl
+ u_t025_009/c2_w0_bl u_t025_009/c2_w0_br u_t025_009/c2_w1_bl u_t025_009/c2_w1_br
+ u_t025_009/c2_r0_rbl u_t025_009/c2_r1_rbl u_t025_009/c3_w0_bl u_t025_009/c3_w0_br
+ u_t025_009/c3_w1_bl u_t025_009/c3_w1_br u_t025_009/c3_r0_rbl u_t025_009/c3_r1_rbl
+ u_t025_009/r0_w0_wl u_t025_009/r0_w1_wl u_t025_009/r0_r0_rwl u_t025_009/r0_r1_rwl
+ u_t025_009/r1_w0_wl u_t025_009/r1_w1_wl u_t025_009/r1_r0_rwl u_t025_009/r1_r1_rwl
+ u_t025_009/r2_w0_wl u_t025_009/r2_w1_wl u_t025_009/r2_r0_rwl u_t025_009/r2_r1_rwl
+ u_t025_009/r3_w0_wl u_t025_009/r3_w1_wl u_t025_009/r3_r0_rwl u_t025_009/r3_r1_rwl
+ VSS VSS u_t025_009/m2_717_1265# u_t025_009/m2_603_2031# u_t025_009/m2_1290_336#
+ u_t025_009/m2_2000_2037# u_t025_009/m2_791_2909# u_t025_009/m2_7_2126# u_t025_009/m2_2154_2081#
+ u_t025_009/m2_1795_2037# u_t025_009/m2_871_303# u_t025_009/m2_431_438# u_t025_009/m2_1290_2898#
+ u_t025_009/m2_1714_1210# u_t025_009/m2_431_1982# u_t025_009/m2_512_1265# u_t025_009/m2_2573_2126#
+ u_t025_009/m2_603_1259# u_t025_009/m2_2074_2909# u_t025_009/m2_7_336# u_t025_009/m2_717_2037#
+ u_t025_009/m2_1886_2031# u_t025_009/m2_2573_336# u_t025_009/m2_7_2898# u_t025_009/m2_2000_1265#
+ u_t025_009/m2_512_2037# u_t025_009/m2_1795_1265# u_t025_009/m2_1714_1982# u_t025_009/m2_1886_1259#
+ u_t025_009/m2_1290_2126# u_t025_009/m2_1714_438# u_t025_009/m2_431_1210# u_t025_009/m2_2573_2898#
+ u_t025_009/m2_2154_303# u_t025_009/m2_871_2081# VSUBS detronyx_12t_2w2r_rc4_4x4_routed_5layer_direct
Xgf180mcu_as_sc_mcu7t3v3__inv_2_1129 gf180mcu_as_sc_mcu7t3v3__inv_2_1129/VDD gf180mcu_as_sc_mcu7t3v3__inv_2_1133/VDD
+ gf180mcu_as_sc_mcu7t3v3__inv_2_1129/Y VSS gf180mcu_as_sc_mcu7t3v3__inv_2_1129/VNW
+ VSUBS gf180mcu_as_sc_mcu7t3v3__inv_2
Xgf180mcu_as_sc_mcu7t3v3__inv_2_1118 VSS VSS gf180mcu_as_sc_mcu7t3v3__inv_2_1118/Y
+ VSS gf180mcu_as_sc_mcu7t3v3__inv_2_1118/VNW VSUBS gf180mcu_as_sc_mcu7t3v3__inv_2
Xgf180mcu_as_sc_mcu7t3v3__inv_2_1107 VSS VSS gf180mcu_as_sc_mcu7t3v3__inv_2_1107/Y
+ VSS gf180mcu_as_sc_mcu7t3v3__inv_2_1107/VNW VSUBS gf180mcu_as_sc_mcu7t3v3__inv_2
Xu_t016_009 u_t016_009/c0_w0_bl u_t016_009/c0_w0_br u_t016_009/c0_w1_bl u_t016_009/c0_w1_br
+ u_t016_009/c0_r0_rbl u_t016_009/c0_r1_rbl u_t016_009/c1_w0_bl u_t016_009/c1_w0_br
+ u_t016_009/c1_w1_bl u_t016_009/c1_w1_br u_t016_009/c1_r0_rbl u_t016_009/c1_r1_rbl
+ u_t016_009/c2_w0_bl u_t016_009/c2_w0_br u_t016_009/c2_w1_bl u_t016_009/c2_w1_br
+ u_t016_009/c2_r0_rbl u_t016_009/c2_r1_rbl u_t016_009/c3_w0_bl u_t016_009/c3_w0_br
+ u_t016_009/c3_w1_bl u_t016_009/c3_w1_br u_t016_009/c3_r0_rbl u_t016_009/c3_r1_rbl
+ u_t016_009/r0_w0_wl u_t016_009/r0_w1_wl u_t016_009/r0_r0_rwl u_t016_009/r0_r1_rwl
+ u_t016_009/r1_w0_wl u_t016_009/r1_w1_wl u_t016_009/r1_r0_rwl u_t016_009/r1_r1_rwl
+ u_t016_009/r2_w0_wl u_t016_009/r2_w1_wl u_t016_009/r2_r0_rwl u_t016_009/r2_r1_rwl
+ u_t016_009/r3_w0_wl u_t016_009/r3_w1_wl u_t016_009/r3_r0_rwl u_t016_009/r3_r1_rwl
+ VSS u_t016_009/VSS u_t016_009/m2_717_1265# u_t016_009/m2_603_2031# u_t016_009/m2_1290_336#
+ u_t016_009/m2_2000_2037# u_t016_009/m2_791_2909# u_t016_009/m2_7_2126# u_t016_009/m2_2154_2081#
+ u_t016_009/m2_1795_2037# u_t016_009/m2_871_303# u_t016_009/m2_431_438# u_t016_009/m2_1290_2898#
+ u_t016_009/m2_1714_1210# u_t016_009/m2_431_1982# u_t016_009/m2_512_1265# u_t016_009/m2_2573_2126#
+ u_t016_009/m2_603_1259# u_t016_009/m2_2074_2909# u_t016_009/m2_7_336# u_t016_009/m2_717_2037#
+ u_t016_009/m2_1886_2031# u_t016_009/m2_2573_336# u_t016_009/m2_7_2898# u_t016_009/m2_2000_1265#
+ u_t016_009/m2_512_2037# u_t016_009/m2_1795_1265# u_t016_009/m2_1714_1982# u_t016_009/m2_1886_1259#
+ u_t016_009/m2_1290_2126# u_t016_009/m2_1714_438# u_t016_009/m2_431_1210# u_t016_009/m2_2573_2898#
+ u_t016_009/m2_2154_303# u_t016_009/m2_871_2081# VSUBS detronyx_12t_2w2r_rc4_4x4_routed_5layer_direct
Xgf180mcu_as_sc_mcu7t3v3__nand3_2_65 gf180mcu_as_sc_mcu7t3v3__nand3_2_65/VDD gf180mcu_as_sc_mcu7t3v3__nor2_2_9/VSS
+ VSS VSS VSS VSS gf180mcu_as_sc_mcu7t3v3__nand3_2_65/VNW VSUBS gf180mcu_as_sc_mcu7t3v3__nand3_2
Xgf180mcu_as_sc_mcu7t3v3__nand3_2_54 gf180mcu_as_sc_mcu7t3v3__nor2_2_9/VDD gf180mcu_as_sc_mcu7t3v3__nor2_2_9/VSS
+ VSS VSS VSS VSS gf180mcu_as_sc_mcu7t3v3__nor2_2_9/VNW VSUBS gf180mcu_as_sc_mcu7t3v3__nand3_2
Xgf180mcu_as_sc_mcu7t3v3__nand3_2_21 gf180mcu_as_sc_mcu7t3v3__nand3_2_9/VDD gf180mcu_as_sc_mcu7t3v3__nor2_2_4/VSS
+ VSS VSS VSS VSS gf180mcu_as_sc_mcu7t3v3__nand3_2_9/VNW VSUBS gf180mcu_as_sc_mcu7t3v3__nand3_2
Xgf180mcu_as_sc_mcu7t3v3__nand3_2_43 gf180mcu_as_sc_mcu7t3v3__nand3_2_9/VDD gf180mcu_as_sc_mcu7t3v3__nor2_2_4/VSS
+ VSS VSS VSS VSS gf180mcu_as_sc_mcu7t3v3__nand3_2_9/VNW VSUBS gf180mcu_as_sc_mcu7t3v3__nand3_2
Xgf180mcu_as_sc_mcu7t3v3__nand3_2_32 gf180mcu_as_sc_mcu7t3v3__nand3_2_9/VDD gf180mcu_as_sc_mcu7t3v3__nor2_2_7/VSS
+ VSS VSS VSS VSS gf180mcu_as_sc_mcu7t3v3__nand3_2_9/VNW VSUBS gf180mcu_as_sc_mcu7t3v3__nand3_2
Xgf180mcu_as_sc_mcu7t3v3__nand3_2_10 gf180mcu_as_sc_mcu7t3v3__nand3_2_9/VDD gf180mcu_as_sc_mcu7t3v3__nor2_2_7/VSS
+ VSS VSS VSS VSS gf180mcu_as_sc_mcu7t3v3__nand3_2_9/VNW VSUBS gf180mcu_as_sc_mcu7t3v3__nand3_2
Xgf180mcu_as_sc_mcu7t3v3__inv_2_1630 VSS VSS gf180mcu_as_sc_mcu7t3v3__inv_2_1685/A
+ gf180mcu_as_sc_mcu7t3v3__inv_2_1685/A gf180mcu_as_sc_mcu7t3v3__inv_2_1631/VNW VSUBS
+ gf180mcu_as_sc_mcu7t3v3__inv_2
Xgf180mcu_as_sc_mcu7t3v3__inv_2_1641 VSS gf180mcu_as_sc_mcu7t3v3__inv_2_1649/VDD gf180mcu_as_sc_mcu7t3v3__inv_2_1689/A
+ gf180mcu_as_sc_mcu7t3v3__inv_2_1689/A gf180mcu_as_sc_mcu7t3v3__inv_2_1642/VNW VSUBS
+ gf180mcu_as_sc_mcu7t3v3__inv_2
Xgf180mcu_as_sc_mcu7t3v3__inv_2_1685 gf180mcu_as_sc_mcu7t3v3__inv_2_1685/VDD VSS VSS
+ gf180mcu_as_sc_mcu7t3v3__inv_2_1685/A gf180mcu_as_sc_mcu7t3v3__inv_2_1685/VNW VSUBS
+ gf180mcu_as_sc_mcu7t3v3__inv_2
Xgf180mcu_as_sc_mcu7t3v3__inv_2_1652 VSS gf180mcu_as_sc_mcu7t3v3__inv_2_1656/VDD gf180mcu_as_sc_mcu7t3v3__inv_2_1669/A
+ VSS gf180mcu_as_sc_mcu7t3v3__inv_2_1652/VNW VSUBS gf180mcu_as_sc_mcu7t3v3__inv_2
Xgf180mcu_as_sc_mcu7t3v3__inv_2_1663 VSS VSS gf180mcu_as_sc_mcu7t3v3__inv_2_1672/Y
+ gf180mcu_as_sc_mcu7t3v3__inv_2_1672/Y gf180mcu_as_sc_mcu7t3v3__inv_2_1664/VNW VSUBS
+ gf180mcu_as_sc_mcu7t3v3__inv_2
Xgf180mcu_as_sc_mcu7t3v3__inv_2_1674 VSS VSS VSS gf180mcu_as_sc_mcu7t3v3__inv_2_1684/Y
+ gf180mcu_as_sc_mcu7t3v3__inv_2_1676/VNW VSUBS gf180mcu_as_sc_mcu7t3v3__inv_2
Xgf180mcu_as_sc_mcu7t3v3__inv_2_1696 gf180mcu_as_sc_mcu7t3v3__inv_2_1697/VDD VSS VSS
+ VSS gf180mcu_as_sc_mcu7t3v3__inv_2_1697/VNW VSUBS gf180mcu_as_sc_mcu7t3v3__inv_2
Xu_t030_012 u_t030_012/c0_w0_bl u_t030_012/c0_w0_br u_t030_012/c0_w1_bl u_t030_012/c0_w1_br
+ u_t030_012/c0_r0_rbl u_t030_012/c0_r1_rbl u_t030_012/c1_w0_bl u_t030_012/c1_w0_br
+ u_t030_012/c1_w1_bl u_t030_012/c1_w1_br u_t030_012/c1_r0_rbl u_t030_012/c1_r1_rbl
+ u_t030_012/c2_w0_bl u_t030_012/c2_w0_br u_t030_012/c2_w1_bl u_t030_012/c2_w1_br
+ u_t030_012/c2_r0_rbl u_t030_012/c2_r1_rbl u_t030_012/c3_w0_bl u_t030_012/c3_w0_br
+ u_t030_012/c3_w1_bl u_t030_012/c3_w1_br u_t030_012/c3_r0_rbl u_t030_012/c3_r1_rbl
+ u_t030_012/r0_w0_wl u_t030_012/r0_w1_wl u_t030_012/r0_r0_rwl u_t030_012/r0_r1_rwl
+ u_t030_012/r1_w0_wl u_t030_012/r1_w1_wl u_t030_012/r1_r0_rwl u_t030_012/r1_r1_rwl
+ u_t030_012/r2_w0_wl u_t030_012/r2_w1_wl u_t030_012/r2_r0_rwl u_t030_012/r2_r1_rwl
+ u_t030_012/r3_w0_wl u_t030_012/r3_w1_wl u_t030_012/r3_r0_rwl u_t030_012/r3_r1_rwl
+ u_t030_012/VDD VSS u_t030_012/m2_717_1265# u_t030_012/m2_603_2031# u_t030_012/m2_1290_336#
+ u_t030_012/m2_2000_2037# u_t030_012/m2_791_2909# u_t030_012/m2_7_2126# u_t030_012/m2_2154_2081#
+ u_t030_012/m2_1795_2037# u_t030_012/m2_871_303# u_t030_012/m2_431_438# u_t030_012/m2_1290_2898#
+ u_t030_012/m2_1714_1210# u_t030_012/m2_431_1982# u_t030_012/m2_512_1265# u_t030_012/m2_2573_2126#
+ u_t030_012/m2_603_1259# u_t030_012/m2_2074_2909# u_t030_012/m2_7_336# u_t030_012/m2_717_2037#
+ u_t030_012/m2_1886_2031# u_t030_012/m2_2573_336# u_t030_012/m2_7_2898# u_t030_012/m2_2000_1265#
+ u_t030_012/m2_512_2037# u_t030_012/m2_1795_1265# u_t030_012/m2_1714_1982# u_t030_012/m2_1886_1259#
+ u_t030_012/m2_1290_2126# u_t030_012/m2_1714_438# u_t030_012/m2_431_1210# u_t030_012/m2_2573_2898#
+ u_t030_012/m2_2154_303# u_t030_012/m2_871_2081# VSUBS detronyx_12t_2w2r_rc4_4x4_routed_5layer_direct
Xu_t007_009 u_t007_009/c0_w0_bl u_t007_009/c0_w0_br u_t007_009/c0_w1_bl u_t007_009/c0_w1_br
+ u_t007_009/c0_r0_rbl u_t007_009/c0_r1_rbl u_t007_009/c1_w0_bl u_t007_009/c1_w0_br
+ u_t007_009/c1_w1_bl u_t007_009/c1_w1_br u_t007_009/c1_r0_rbl u_t007_009/c1_r1_rbl
+ u_t007_009/c2_w0_bl u_t007_009/c2_w0_br u_t007_009/c2_w1_bl u_t007_009/c2_w1_br
+ u_t007_009/c2_r0_rbl u_t007_009/c2_r1_rbl u_t007_009/c3_w0_bl u_t007_009/c3_w0_br
+ u_t007_009/c3_w1_bl u_t007_009/c3_w1_br u_t007_009/c3_r0_rbl u_t007_009/c3_r1_rbl
+ u_t007_009/r0_w0_wl u_t007_009/r0_w1_wl u_t007_009/r0_r0_rwl u_t007_009/r0_r1_rwl
+ u_t007_009/r1_w0_wl u_t007_009/r1_w1_wl u_t007_009/r1_r0_rwl u_t007_009/r1_r1_rwl
+ u_t007_009/r2_w0_wl u_t007_009/r2_w1_wl u_t007_009/r2_r0_rwl u_t007_009/r2_r1_rwl
+ u_t007_009/r3_w0_wl u_t007_009/r3_w1_wl u_t007_009/r3_r0_rwl u_t007_009/r3_r1_rwl
+ VSS u_t007_009/VSS u_t007_009/m2_717_1265# u_t007_009/m2_603_2031# u_t007_009/m2_1290_336#
+ u_t007_009/m2_2000_2037# u_t007_009/m2_791_2909# u_t007_009/m2_7_2126# u_t007_009/m2_2154_2081#
+ u_t007_009/m2_1795_2037# u_t007_009/m2_871_303# u_t007_009/m2_431_438# u_t007_009/m2_1290_2898#
+ u_t007_009/m2_1714_1210# u_t007_009/m2_431_1982# u_t007_009/m2_512_1265# u_t007_009/m2_2573_2126#
+ u_t007_009/m2_603_1259# u_t007_009/m2_2074_2909# u_t007_009/m2_7_336# u_t007_009/m2_717_2037#
+ u_t007_009/m2_1886_2031# u_t007_009/m2_2573_336# u_t007_009/m2_7_2898# u_t007_009/m2_2000_1265#
+ u_t007_009/m2_512_2037# u_t007_009/m2_1795_1265# u_t007_009/m2_1714_1982# u_t007_009/m2_1886_1259#
+ u_t007_009/m2_1290_2126# u_t007_009/m2_1714_438# u_t007_009/m2_431_1210# u_t007_009/m2_2573_2898#
+ u_t007_009/m2_2154_303# u_t007_009/m2_871_2081# VSUBS detronyx_12t_2w2r_rc4_4x4_routed_5layer_direct
Xu_t030_001 u_t030_001/c0_w0_bl u_t030_001/c0_w0_br u_t030_001/c0_w1_bl u_t030_001/c0_w1_br
+ u_t030_001/c0_r0_rbl u_t030_001/c0_r1_rbl u_t030_001/c1_w0_bl u_t030_001/c1_w0_br
+ u_t030_001/c1_w1_bl u_t030_001/c1_w1_br u_t030_001/c1_r0_rbl u_t030_001/c1_r1_rbl
+ u_t030_001/c2_w0_bl u_t030_001/c2_w0_br u_t030_001/c2_w1_bl u_t030_001/c2_w1_br
+ u_t030_001/c2_r0_rbl u_t030_001/c2_r1_rbl u_t030_001/c3_w0_bl u_t030_001/c3_w0_br
+ u_t030_001/c3_w1_bl u_t030_001/c3_w1_br u_t030_001/c3_r0_rbl u_t030_001/c3_r1_rbl
+ u_t030_001/r0_w0_wl u_t030_001/r0_w1_wl u_t030_001/r0_r0_rwl u_t030_001/r0_r1_rwl
+ u_t030_001/r1_w0_wl u_t030_001/r1_w1_wl u_t030_001/r1_r0_rwl u_t030_001/r1_r1_rwl
+ u_t030_001/r2_w0_wl u_t030_001/r2_w1_wl u_t030_001/r2_r0_rwl u_t030_001/r2_r1_rwl
+ u_t030_001/r3_w0_wl u_t030_001/r3_w1_wl u_t030_001/r3_r0_rwl u_t030_001/r3_r1_rwl
+ VSS VSS u_t030_001/m2_717_1265# u_t030_001/m2_603_2031# u_t030_001/m2_1290_336#
+ u_t030_001/m2_2000_2037# u_t030_001/m2_791_2909# u_t030_001/m2_7_2126# u_t030_001/m2_2154_2081#
+ u_t030_001/m2_1795_2037# u_t030_001/m2_871_303# u_t030_001/m2_431_438# u_t030_001/m2_1290_2898#
+ u_t030_001/m2_1714_1210# u_t030_001/m2_431_1982# u_t030_001/m2_512_1265# u_t030_001/m2_2573_2126#
+ u_t030_001/m2_603_1259# u_t030_001/m2_2074_2909# u_t030_001/m2_7_336# u_t030_001/m2_717_2037#
+ u_t030_001/m2_1886_2031# u_t030_001/m2_2573_336# u_t030_001/m2_7_2898# u_t030_001/m2_2000_1265#
+ u_t030_001/m2_512_2037# u_t030_001/m2_1795_1265# u_t030_001/m2_1714_1982# u_t030_001/m2_1886_1259#
+ u_t030_001/m2_1290_2126# u_t030_001/m2_1714_438# u_t030_001/m2_431_1210# u_t030_001/m2_2573_2898#
+ u_t030_001/m2_2154_303# u_t030_001/m2_871_2081# VSUBS detronyx_12t_2w2r_rc4_4x4_routed_5layer_direct
Xgf180mcu_as_sc_mcu7t3v3__nand4_2_435 VSS VSS VSS VSS VSS VSS VSS gf180mcu_as_sc_mcu7t3v3__inv_2_1576/VNW
+ VSUBS gf180mcu_as_sc_mcu7t3v3__nand4_2
Xgf180mcu_as_sc_mcu7t3v3__nand4_2_424 VSS gf180mcu_as_sc_mcu7t3v3__inv_2_1547/VDD
+ VSS VSS VSS VSS gf180mcu_as_sc_mcu7t3v3__nand4_2_424/Y gf180mcu_as_sc_mcu7t3v3__inv_2_1544/VNW
+ VSUBS gf180mcu_as_sc_mcu7t3v3__nand4_2
Xgf180mcu_as_sc_mcu7t3v3__nand4_2_402 VSS gf180mcu_as_sc_mcu7t3v3__inv_2_1476/VSS
+ VSS VSS VSS VSS VSS gf180mcu_as_sc_mcu7t3v3__inv_2_1476/VNW VSUBS gf180mcu_as_sc_mcu7t3v3__nand4_2
Xgf180mcu_as_sc_mcu7t3v3__nand4_2_413 gf180mcu_as_sc_mcu7t3v3__inv_2_1511/VDD gf180mcu_as_sc_mcu7t3v3__inv_2_1511/VSS
+ VSS VSS VSS VSS gf180mcu_as_sc_mcu7t3v3__nand4_2_413/Y gf180mcu_as_sc_mcu7t3v3__inv_2_1511/VNW
+ VSUBS gf180mcu_as_sc_mcu7t3v3__nand4_2
Xgf180mcu_as_sc_mcu7t3v3__nand4_2_446 gf180mcu_as_sc_mcu7t3v3__inv_2_1694/VDD VSS
+ VSS VSS VSS VSS VSS gf180mcu_as_sc_mcu7t3v3__inv_2_1694/VNW VSUBS gf180mcu_as_sc_mcu7t3v3__nand4_2
Xgf180mcu_as_sc_mcu7t3v3__nand4_2_468 gf180mcu_as_sc_mcu7t3v3__inv_2_1378/VDD gf180mcu_as_sc_mcu7t3v3__inv_2_1382/VDD
+ VSS VSS VSS VSS VSS gf180mcu_as_sc_mcu7t3v3__inv_2_1378/VNW VSUBS gf180mcu_as_sc_mcu7t3v3__nand4_2
Xgf180mcu_as_sc_mcu7t3v3__inv_2_3 gf180mcu_as_sc_mcu7t3v3__inv_2_4/VDD gf180mcu_as_sc_mcu7t3v3__inv_2_8/VDD
+ gf180mcu_as_sc_mcu7t3v3__inv_2_3/Y gf180mcu_as_sc_mcu7t3v3__inv_2_8/Y gf180mcu_as_sc_mcu7t3v3__inv_2_4/VNW
+ VSUBS gf180mcu_as_sc_mcu7t3v3__inv_2
Xgf180mcu_as_sc_mcu7t3v3__nand4_2_457 gf180mcu_as_sc_mcu7t3v3__inv_2_1316/VDD gf180mcu_as_sc_mcu7t3v3__inv_2_1320/VDD
+ VSS VSS VSS VSS VSS gf180mcu_as_sc_mcu7t3v3__inv_2_1316/VNW VSUBS gf180mcu_as_sc_mcu7t3v3__nand4_2
Xgf180mcu_as_sc_mcu7t3v3__nand4_2_479 gf180mcu_as_sc_mcu7t3v3__inv_2_1403/VDD VSS
+ VSS VSS VSS VSS VSS gf180mcu_as_sc_mcu7t3v3__inv_2_1403/VNW VSUBS gf180mcu_as_sc_mcu7t3v3__nand4_2
Xu_t021_012 u_t021_012/c0_w0_bl u_t021_012/c0_w0_br u_t021_012/c0_w1_bl u_t021_012/c0_w1_br
+ u_t021_012/c0_r0_rbl u_t021_012/c0_r1_rbl u_t021_012/c1_w0_bl u_t021_012/c1_w0_br
+ u_t021_012/c1_w1_bl u_t021_012/c1_w1_br u_t021_012/c1_r0_rbl u_t021_012/c1_r1_rbl
+ u_t021_012/c2_w0_bl u_t021_012/c2_w0_br u_t021_012/c2_w1_bl u_t021_012/c2_w1_br
+ u_t021_012/c2_r0_rbl u_t021_012/c2_r1_rbl u_t021_012/c3_w0_bl u_t021_012/c3_w0_br
+ u_t021_012/c3_w1_bl u_t021_012/c3_w1_br u_t021_012/c3_r0_rbl u_t021_012/c3_r1_rbl
+ u_t021_012/r0_w0_wl u_t021_012/r0_w1_wl u_t021_012/r0_r0_rwl u_t021_012/r0_r1_rwl
+ u_t021_012/r1_w0_wl u_t021_012/r1_w1_wl u_t021_012/r1_r0_rwl u_t021_012/r1_r1_rwl
+ u_t021_012/r2_w0_wl u_t021_012/r2_w1_wl u_t021_012/r2_r0_rwl u_t021_012/r2_r1_rwl
+ u_t021_012/r3_w0_wl u_t021_012/r3_w1_wl u_t021_012/r3_r0_rwl u_t021_012/r3_r1_rwl
+ u_t021_012/VDD VSS u_t021_012/m2_717_1265# u_t021_012/m2_603_2031# u_t021_012/m2_1290_336#
+ u_t021_012/m2_2000_2037# u_t021_012/m2_791_2909# u_t021_012/m2_7_2126# u_t021_012/m2_2154_2081#
+ u_t021_012/m2_1795_2037# u_t021_012/m2_871_303# u_t021_012/m2_431_438# u_t021_012/m2_1290_2898#
+ u_t021_012/m2_1714_1210# u_t021_012/m2_431_1982# u_t021_012/m2_512_1265# u_t021_012/m2_2573_2126#
+ u_t021_012/m2_603_1259# u_t021_012/m2_2074_2909# u_t021_012/m2_7_336# u_t021_012/m2_717_2037#
+ u_t021_012/m2_1886_2031# u_t021_012/m2_2573_336# u_t021_012/m2_7_2898# u_t021_012/m2_2000_1265#
+ u_t021_012/m2_512_2037# u_t021_012/m2_1795_1265# u_t021_012/m2_1714_1982# u_t021_012/m2_1886_1259#
+ u_t021_012/m2_1290_2126# u_t021_012/m2_1714_438# u_t021_012/m2_431_1210# u_t021_012/m2_2573_2898#
+ u_t021_012/m2_2154_303# u_t021_012/m2_871_2081# VSUBS detronyx_12t_2w2r_rc4_4x4_routed_5layer_direct
Xu_t021_001 u_t021_001/c0_w0_bl u_t021_001/c0_w0_br u_t021_001/c0_w1_bl u_t021_001/c0_w1_br
+ u_t021_001/c0_r0_rbl u_t021_001/c0_r1_rbl u_t021_001/c1_w0_bl u_t021_001/c1_w0_br
+ u_t021_001/c1_w1_bl u_t021_001/c1_w1_br u_t021_001/c1_r0_rbl u_t021_001/c1_r1_rbl
+ u_t021_001/c2_w0_bl u_t021_001/c2_w0_br u_t021_001/c2_w1_bl u_t021_001/c2_w1_br
+ u_t021_001/c2_r0_rbl u_t021_001/c2_r1_rbl u_t021_001/c3_w0_bl u_t021_001/c3_w0_br
+ u_t021_001/c3_w1_bl u_t021_001/c3_w1_br u_t021_001/c3_r0_rbl u_t021_001/c3_r1_rbl
+ u_t021_001/r0_w0_wl u_t021_001/r0_w1_wl u_t021_001/r0_r0_rwl u_t021_001/r0_r1_rwl
+ u_t021_001/r1_w0_wl u_t021_001/r1_w1_wl u_t021_001/r1_r0_rwl u_t021_001/r1_r1_rwl
+ u_t021_001/r2_w0_wl u_t021_001/r2_w1_wl u_t021_001/r2_r0_rwl u_t021_001/r2_r1_rwl
+ u_t021_001/r3_w0_wl u_t021_001/r3_w1_wl u_t021_001/r3_r0_rwl u_t021_001/r3_r1_rwl
+ VSS VSS u_t021_001/m2_717_1265# u_t021_001/m2_603_2031# u_t021_001/m2_1290_336#
+ u_t021_001/m2_2000_2037# u_t021_001/m2_791_2909# u_t021_001/m2_7_2126# u_t021_001/m2_2154_2081#
+ u_t021_001/m2_1795_2037# u_t021_001/m2_871_303# u_t021_001/m2_431_438# u_t021_001/m2_1290_2898#
+ u_t021_001/m2_1714_1210# u_t021_001/m2_431_1982# u_t021_001/m2_512_1265# u_t021_001/m2_2573_2126#
+ u_t021_001/m2_603_1259# u_t021_001/m2_2074_2909# u_t021_001/m2_7_336# u_t021_001/m2_717_2037#
+ u_t021_001/m2_1886_2031# u_t021_001/m2_2573_336# u_t021_001/m2_7_2898# u_t021_001/m2_2000_1265#
+ u_t021_001/m2_512_2037# u_t021_001/m2_1795_1265# u_t021_001/m2_1714_1982# u_t021_001/m2_1886_1259#
+ u_t021_001/m2_1290_2126# u_t021_001/m2_1714_438# u_t021_001/m2_431_1210# u_t021_001/m2_2573_2898#
+ u_t021_001/m2_2154_303# u_t021_001/m2_871_2081# VSUBS detronyx_12t_2w2r_rc4_4x4_routed_5layer_direct
Xu_t012_012 u_t012_012/c0_w0_bl u_t012_012/c0_w0_br u_t012_012/c0_w1_bl u_t012_012/c0_w1_br
+ u_t012_012/c0_r0_rbl u_t012_012/c0_r1_rbl u_t012_012/c1_w0_bl u_t012_012/c1_w0_br
+ u_t012_012/c1_w1_bl u_t012_012/c1_w1_br u_t012_012/c1_r0_rbl u_t012_012/c1_r1_rbl
+ u_t012_012/c2_w0_bl u_t012_012/c2_w0_br u_t012_012/c2_w1_bl u_t012_012/c2_w1_br
+ u_t012_012/c2_r0_rbl u_t012_012/c2_r1_rbl u_t012_012/c3_w0_bl u_t012_012/c3_w0_br
+ u_t012_012/c3_w1_bl u_t012_012/c3_w1_br u_t012_012/c3_r0_rbl u_t012_012/c3_r1_rbl
+ u_t012_012/r0_w0_wl u_t012_012/r0_w1_wl u_t012_012/r0_r0_rwl u_t012_012/r0_r1_rwl
+ u_t012_012/r1_w0_wl u_t012_012/r1_w1_wl u_t012_012/r1_r0_rwl u_t012_012/r1_r1_rwl
+ u_t012_012/r2_w0_wl u_t012_012/r2_w1_wl u_t012_012/r2_r0_rwl u_t012_012/r2_r1_rwl
+ u_t012_012/r3_w0_wl u_t012_012/r3_w1_wl u_t012_012/r3_r0_rwl u_t012_012/r3_r1_rwl
+ u_t012_012/VDD VSS u_t012_012/m2_717_1265# u_t012_012/m2_603_2031# u_t012_012/m2_1290_336#
+ u_t012_012/m2_2000_2037# u_t012_012/m2_791_2909# u_t012_012/m2_7_2126# u_t012_012/m2_2154_2081#
+ u_t012_012/m2_1795_2037# u_t012_012/m2_871_303# u_t012_012/m2_431_438# u_t012_012/m2_1290_2898#
+ u_t012_012/m2_1714_1210# u_t012_012/m2_431_1982# u_t012_012/m2_512_1265# u_t012_012/m2_2573_2126#
+ u_t012_012/m2_603_1259# u_t012_012/m2_2074_2909# u_t012_012/m2_7_336# u_t012_012/m2_717_2037#
+ u_t012_012/m2_1886_2031# u_t012_012/m2_2573_336# u_t012_012/m2_7_2898# u_t012_012/m2_2000_1265#
+ u_t012_012/m2_512_2037# u_t012_012/m2_1795_1265# u_t012_012/m2_1714_1982# u_t012_012/m2_1886_1259#
+ u_t012_012/m2_1290_2126# u_t012_012/m2_1714_438# u_t012_012/m2_431_1210# u_t012_012/m2_2573_2898#
+ u_t012_012/m2_2154_303# u_t012_012/m2_871_2081# VSUBS detronyx_12t_2w2r_rc4_4x4_routed_5layer_direct
Xu_t012_001 u_t012_001/c0_w0_bl u_t012_001/c0_w0_br u_t012_001/c0_w1_bl u_t012_001/c0_w1_br
+ u_t012_001/c0_r0_rbl u_t012_001/c0_r1_rbl u_t012_001/c1_w0_bl u_t012_001/c1_w0_br
+ u_t012_001/c1_w1_bl u_t012_001/c1_w1_br u_t012_001/c1_r0_rbl u_t012_001/c1_r1_rbl
+ u_t012_001/c2_w0_bl u_t012_001/c2_w0_br u_t012_001/c2_w1_bl u_t012_001/c2_w1_br
+ u_t012_001/c2_r0_rbl u_t012_001/c2_r1_rbl u_t012_001/c3_w0_bl u_t012_001/c3_w0_br
+ u_t012_001/c3_w1_bl u_t012_001/c3_w1_br u_t012_001/c3_r0_rbl u_t012_001/c3_r1_rbl
+ u_t012_001/r0_w0_wl u_t012_001/r0_w1_wl u_t012_001/r0_r0_rwl u_t012_001/r0_r1_rwl
+ u_t012_001/r1_w0_wl u_t012_001/r1_w1_wl u_t012_001/r1_r0_rwl u_t012_001/r1_r1_rwl
+ u_t012_001/r2_w0_wl u_t012_001/r2_w1_wl u_t012_001/r2_r0_rwl u_t012_001/r2_r1_rwl
+ u_t012_001/r3_w0_wl u_t012_001/r3_w1_wl u_t012_001/r3_r0_rwl u_t012_001/r3_r1_rwl
+ VSS VSS u_t012_001/m2_717_1265# u_t012_001/m2_603_2031# u_t012_001/m2_1290_336#
+ u_t012_001/m2_2000_2037# u_t012_001/m2_791_2909# u_t012_001/m2_7_2126# u_t012_001/m2_2154_2081#
+ u_t012_001/m2_1795_2037# u_t012_001/m2_871_303# u_t012_001/m2_431_438# u_t012_001/m2_1290_2898#
+ u_t012_001/m2_1714_1210# u_t012_001/m2_431_1982# u_t012_001/m2_512_1265# u_t012_001/m2_2573_2126#
+ u_t012_001/m2_603_1259# u_t012_001/m2_2074_2909# u_t012_001/m2_7_336# u_t012_001/m2_717_2037#
+ u_t012_001/m2_1886_2031# u_t012_001/m2_2573_336# u_t012_001/m2_7_2898# u_t012_001/m2_2000_1265#
+ u_t012_001/m2_512_2037# u_t012_001/m2_1795_1265# u_t012_001/m2_1714_1982# u_t012_001/m2_1886_1259#
+ u_t012_001/m2_1290_2126# u_t012_001/m2_1714_438# u_t012_001/m2_431_1210# u_t012_001/m2_2573_2898#
+ u_t012_001/m2_2154_303# u_t012_001/m2_871_2081# VSUBS detronyx_12t_2w2r_rc4_4x4_routed_5layer_direct
Xgf180mcu_as_sc_mcu7t3v3__inv_2_1471 gf180mcu_as_sc_mcu7t3v3__inv_2_1473/VDD VSS VSS
+ VSS gf180mcu_as_sc_mcu7t3v3__inv_2_1473/VNW VSUBS gf180mcu_as_sc_mcu7t3v3__inv_2
Xgf180mcu_as_sc_mcu7t3v3__inv_2_1460 VSS gf180mcu_as_sc_mcu7t3v3__inv_2_1511/VDD VSS
+ VSS gf180mcu_as_sc_mcu7t3v3__inv_2_1461/VNW VSUBS gf180mcu_as_sc_mcu7t3v3__inv_2
Xgf180mcu_as_sc_mcu7t3v3__inv_2_1482 gf180mcu_as_sc_mcu7t3v3__inv_2_1482/VDD VSS gf180mcu_as_sc_mcu7t3v3__inv_2_1482/Y
+ VSS gf180mcu_as_sc_mcu7t3v3__inv_2_1482/VNW VSUBS gf180mcu_as_sc_mcu7t3v3__inv_2
Xgf180mcu_as_sc_mcu7t3v3__inv_2_1493 VSS VSS VSS VSS gf180mcu_as_sc_mcu7t3v3__inv_2_1494/VNW
+ VSUBS gf180mcu_as_sc_mcu7t3v3__inv_2
Xgf180mcu_as_sc_mcu7t3v3__inv_2_911 VSS VSS VSS VSS gf180mcu_as_sc_mcu7t3v3__inv_2_944/VNW
+ VSUBS gf180mcu_as_sc_mcu7t3v3__inv_2
Xgf180mcu_as_sc_mcu7t3v3__inv_2_922 VSS VSS VSS VSS gf180mcu_as_sc_mcu7t3v3__inv_2_948/VNW
+ VSUBS gf180mcu_as_sc_mcu7t3v3__inv_2
Xgf180mcu_as_sc_mcu7t3v3__inv_2_900 VSS VSS gf180mcu_as_sc_mcu7t3v3__inv_2_900/Y VSS
+ gf180mcu_as_sc_mcu7t3v3__inv_2_950/VNW VSUBS gf180mcu_as_sc_mcu7t3v3__inv_2
Xu_t003_012 u_t003_012/c0_w0_bl u_t003_012/c0_w0_br u_t003_012/c0_w1_bl u_t003_012/c0_w1_br
+ u_t003_012/c0_r0_rbl u_t003_012/c0_r1_rbl u_t003_012/c1_w0_bl u_t003_012/c1_w0_br
+ u_t003_012/c1_w1_bl u_t003_012/c1_w1_br u_t003_012/c1_r0_rbl u_t003_012/c1_r1_rbl
+ u_t003_012/c2_w0_bl u_t003_012/c2_w0_br u_t003_012/c2_w1_bl u_t003_012/c2_w1_br
+ u_t003_012/c2_r0_rbl u_t003_012/c2_r1_rbl u_t003_012/c3_w0_bl u_t003_012/c3_w0_br
+ u_t003_012/c3_w1_bl u_t003_012/c3_w1_br u_t003_012/c3_r0_rbl u_t003_012/c3_r1_rbl
+ u_t003_012/r0_w0_wl u_t003_012/r0_w1_wl u_t003_012/r0_r0_rwl u_t003_012/r0_r1_rwl
+ u_t003_012/r1_w0_wl u_t003_012/r1_w1_wl u_t003_012/r1_r0_rwl u_t003_012/r1_r1_rwl
+ u_t003_012/r2_w0_wl u_t003_012/r2_w1_wl u_t003_012/r2_r0_rwl u_t003_012/r2_r1_rwl
+ u_t003_012/r3_w0_wl u_t003_012/r3_w1_wl u_t003_012/r3_r0_rwl u_t003_012/r3_r1_rwl
+ u_t004_012/VDD u_t003_012/VSS u_t003_012/m2_717_1265# u_t003_012/m2_603_2031# u_t003_012/m2_1290_336#
+ u_t003_012/m2_2000_2037# u_t003_012/m2_791_2909# u_t003_012/m2_7_2126# u_t003_012/m2_2154_2081#
+ u_t003_012/m2_1795_2037# u_t003_012/m2_871_303# u_t003_012/m2_431_438# u_t003_012/m2_1290_2898#
+ u_t003_012/m2_1714_1210# u_t003_012/m2_431_1982# u_t003_012/m2_512_1265# u_t003_012/m2_2573_2126#
+ u_t003_012/m2_603_1259# u_t003_012/m2_2074_2909# u_t003_012/m2_7_336# u_t003_012/m2_717_2037#
+ u_t003_012/m2_1886_2031# u_t003_012/m2_2573_336# u_t003_012/m2_7_2898# u_t003_012/m2_2000_1265#
+ u_t003_012/m2_512_2037# u_t003_012/m2_1795_1265# u_t003_012/m2_1714_1982# u_t003_012/m2_1886_1259#
+ u_t003_012/m2_1290_2126# u_t003_012/m2_1714_438# u_t003_012/m2_431_1210# u_t003_012/m2_2573_2898#
+ u_t003_012/m2_2154_303# u_t003_012/m2_871_2081# VSUBS detronyx_12t_2w2r_rc4_4x4_routed_5layer_direct
Xu_t003_001 u_t003_001/c0_w0_bl u_t003_001/c0_w0_br u_t003_001/c0_w1_bl u_t003_001/c0_w1_br
+ u_t003_001/c0_r0_rbl u_t003_001/c0_r1_rbl u_t003_001/c1_w0_bl u_t003_001/c1_w0_br
+ u_t003_001/c1_w1_bl u_t003_001/c1_w1_br u_t003_001/c1_r0_rbl u_t003_001/c1_r1_rbl
+ u_t003_001/c2_w0_bl u_t003_001/c2_w0_br u_t003_001/c2_w1_bl u_t003_001/c2_w1_br
+ u_t003_001/c2_r0_rbl u_t003_001/c2_r1_rbl u_t003_001/c3_w0_bl u_t003_001/c3_w0_br
+ u_t003_001/c3_w1_bl u_t003_001/c3_w1_br u_t003_001/c3_r0_rbl u_t003_001/c3_r1_rbl
+ u_t003_001/r0_w0_wl u_t003_001/r0_w1_wl u_t003_001/r0_r0_rwl u_t003_001/r0_r1_rwl
+ u_t003_001/r1_w0_wl u_t003_001/r1_w1_wl u_t003_001/r1_r0_rwl u_t003_001/r1_r1_rwl
+ u_t003_001/r2_w0_wl u_t003_001/r2_w1_wl u_t003_001/r2_r0_rwl u_t003_001/r2_r1_rwl
+ u_t003_001/r3_w0_wl u_t003_001/r3_w1_wl u_t003_001/r3_r0_rwl u_t003_001/r3_r1_rwl
+ VSS VSS u_t003_001/m2_717_1265# u_t003_001/m2_603_2031# u_t003_001/m2_1290_336#
+ u_t003_001/m2_2000_2037# u_t003_001/m2_791_2909# u_t003_001/m2_7_2126# u_t003_001/m2_2154_2081#
+ u_t003_001/m2_1795_2037# u_t003_001/m2_871_303# u_t003_001/m2_431_438# u_t003_001/m2_1290_2898#
+ u_t003_001/m2_1714_1210# u_t003_001/m2_431_1982# u_t003_001/m2_512_1265# u_t003_001/m2_2573_2126#
+ u_t003_001/m2_603_1259# u_t003_001/m2_2074_2909# u_t003_001/m2_7_336# u_t003_001/m2_717_2037#
+ u_t003_001/m2_1886_2031# u_t003_001/m2_2573_336# u_t003_001/m2_7_2898# u_t003_001/m2_2000_1265#
+ u_t003_001/m2_512_2037# u_t003_001/m2_1795_1265# u_t003_001/m2_1714_1982# u_t003_001/m2_1886_1259#
+ u_t003_001/m2_1290_2126# u_t003_001/m2_1714_438# u_t003_001/m2_431_1210# u_t003_001/m2_2573_2898#
+ u_t003_001/m2_2154_303# u_t003_001/m2_871_2081# VSUBS detronyx_12t_2w2r_rc4_4x4_routed_5layer_direct
Xgf180mcu_as_sc_mcu7t3v3__inv_2_944 VSS VSS VSS VSS gf180mcu_as_sc_mcu7t3v3__inv_2_944/VNW
+ VSUBS gf180mcu_as_sc_mcu7t3v3__inv_2
Xgf180mcu_as_sc_mcu7t3v3__inv_2_955 VSS VSS VSS VSS gf180mcu_as_sc_mcu7t3v3__inv_2_955/VNW
+ VSUBS gf180mcu_as_sc_mcu7t3v3__inv_2
Xgf180mcu_as_sc_mcu7t3v3__inv_2_999 gf180mcu_as_sc_mcu7t3v3__inv_2_999/VDD VSS gf180mcu_as_sc_mcu7t3v3__inv_2_999/Y
+ gf180mcu_as_sc_mcu7t3v3__inv_2_999/A gf180mcu_as_sc_mcu7t3v3__inv_2_999/VNW VSUBS
+ gf180mcu_as_sc_mcu7t3v3__inv_2
Xgf180mcu_as_sc_mcu7t3v3__inv_2_988 gf180mcu_as_sc_mcu7t3v3__inv_2_988/VDD VSS gf180mcu_as_sc_mcu7t3v3__inv_2_988/Y
+ VSS gf180mcu_as_sc_mcu7t3v3__inv_2_988/VNW VSUBS gf180mcu_as_sc_mcu7t3v3__inv_2
Xgf180mcu_as_sc_mcu7t3v3__inv_2_933 VSS VSS VSS VSS gf180mcu_as_sc_mcu7t3v3__inv_2_933/VNW
+ VSUBS gf180mcu_as_sc_mcu7t3v3__inv_2
Xgf180mcu_as_sc_mcu7t3v3__inv_2_977 gf180mcu_as_sc_mcu7t3v3__inv_2_985/VDD VSS VSS
+ gf180mcu_as_sc_mcu7t3v3__inv_2_977/A gf180mcu_as_sc_mcu7t3v3__inv_2_985/VNW VSUBS
+ gf180mcu_as_sc_mcu7t3v3__inv_2
Xgf180mcu_as_sc_mcu7t3v3__inv_2_966 VSS VSS VSS gf180mcu_as_sc_mcu7t3v3__inv_2_977/A
+ gf180mcu_as_sc_mcu7t3v3__inv_2_968/VNW VSUBS gf180mcu_as_sc_mcu7t3v3__inv_2
Xgf180mcu_as_sc_mcu7t3v3__nand4_2_276 VSS VSS VSS VSS VSS VSS VSS gf180mcu_as_sc_mcu7t3v3__inv_2_944/VNW
+ VSUBS gf180mcu_as_sc_mcu7t3v3__nand4_2
Xgf180mcu_as_sc_mcu7t3v3__nand4_2_221 VSS VSS VSS VSS VSS VSS VSS gf180mcu_as_sc_mcu7t3v3__inv_2_832/VNW
+ VSUBS gf180mcu_as_sc_mcu7t3v3__nand4_2
Xgf180mcu_as_sc_mcu7t3v3__nand4_2_210 gf180mcu_as_sc_mcu7t3v3__inv_2_689/VDD gf180mcu_as_sc_mcu7t3v3__inv_2_689/VSS
+ VSS VSS VSS VSS VSS gf180mcu_as_sc_mcu7t3v3__inv_2_689/VNW VSUBS gf180mcu_as_sc_mcu7t3v3__nand4_2
Xgf180mcu_as_sc_mcu7t3v3__nand4_2_232 VSS VSS VSS VSS VSS VSS gf180mcu_as_sc_mcu7t3v3__nand4_2_232/Y
+ gf180mcu_as_sc_mcu7t3v3__inv_2_815/VNW VSUBS gf180mcu_as_sc_mcu7t3v3__nand4_2
Xgf180mcu_as_sc_mcu7t3v3__nand4_2_243 VSS VSS VSS VSS VSS VSS gf180mcu_as_sc_mcu7t3v3__nand4_2_243/Y
+ gf180mcu_as_sc_mcu7t3v3__inv_2_839/VNW VSUBS gf180mcu_as_sc_mcu7t3v3__nand4_2
Xgf180mcu_as_sc_mcu7t3v3__nand4_2_254 VSS VSS VSS VSS VSS VSS VSS gf180mcu_as_sc_mcu7t3v3__inv_2_939/VNW
+ VSUBS gf180mcu_as_sc_mcu7t3v3__nand4_2
Xgf180mcu_as_sc_mcu7t3v3__nand4_2_265 VSS VSS VSS VSS VSS VSS VSS gf180mcu_as_sc_mcu7t3v3__inv_2_935/VNW
+ VSUBS gf180mcu_as_sc_mcu7t3v3__nand4_2
Xgf180mcu_as_sc_mcu7t3v3__nand4_2_287 gf180mcu_as_sc_mcu7t3v3__inv_2_1061/VDD gf180mcu_as_sc_mcu7t3v3__inv_2_964/VDD
+ VSS VSS VSS VSS VSS gf180mcu_as_sc_mcu7t3v3__inv_2_1061/VNW VSUBS gf180mcu_as_sc_mcu7t3v3__nand4_2
Xgf180mcu_as_sc_mcu7t3v3__nand4_2_298 VSS VSS VSS VSS VSS VSS VSS gf180mcu_as_sc_mcu7t3v3__inv_2_968/VNW
+ VSUBS gf180mcu_as_sc_mcu7t3v3__nand4_2
Xgf180mcu_as_sc_mcu7t3v3__inv_2_207 gf180mcu_as_sc_mcu7t3v3__inv_2_257/VSS VSS gf180mcu_as_sc_mcu7t3v3__inv_2_207/Y
+ VSS gf180mcu_as_sc_mcu7t3v3__inv_2_209/VNW VSUBS gf180mcu_as_sc_mcu7t3v3__inv_2
Xu_t000_004 u_t000_004/c0_w0_bl u_t000_004/c0_w0_br u_t000_004/c0_w1_bl u_t000_004/c0_w1_br
+ u_t000_004/c0_r0_rbl u_t000_004/c0_r1_rbl u_t000_004/c1_w0_bl u_t000_004/c1_w0_br
+ u_t000_004/c1_w1_bl u_t000_004/c1_w1_br u_t000_004/c1_r0_rbl u_t000_004/c1_r1_rbl
+ u_t000_004/c2_w0_bl u_t000_004/c2_w0_br u_t000_004/c2_w1_bl u_t000_004/c2_w1_br
+ u_t000_004/c2_r0_rbl u_t000_004/c2_r1_rbl u_t000_004/c3_w0_bl u_t000_004/c3_w0_br
+ u_t000_004/c3_w1_bl u_t000_004/c3_w1_br u_t000_004/c3_r0_rbl u_t000_004/c3_r1_rbl
+ u_t000_004/r0_w0_wl u_t000_004/r0_w1_wl u_t000_004/r0_r0_rwl u_t000_004/r0_r1_rwl
+ u_t000_004/r1_w0_wl u_t000_004/r1_w1_wl u_t000_004/r1_r0_rwl u_t000_004/r1_r1_rwl
+ u_t000_004/r2_w0_wl u_t000_004/r2_w1_wl u_t000_004/r2_r0_rwl u_t000_004/r2_r1_rwl
+ u_t000_004/r3_w0_wl u_t000_004/r3_w1_wl u_t000_004/r3_r0_rwl u_t000_004/r3_r1_rwl
+ u_t000_004/VDD VSS u_t000_004/m2_717_1265# u_t000_004/m2_603_2031# u_t000_004/m2_1290_336#
+ u_t000_004/m2_2000_2037# u_t000_004/m2_791_2909# u_t000_004/m2_7_2126# u_t000_004/m2_2154_2081#
+ u_t000_004/m2_1795_2037# u_t000_004/m2_871_303# u_t000_004/m2_431_438# u_t000_004/m2_1290_2898#
+ u_t000_004/m2_1714_1210# u_t000_004/m2_431_1982# u_t000_004/m2_512_1265# u_t000_004/m2_2573_2126#
+ u_t000_004/m2_603_1259# u_t000_004/m2_2074_2909# u_t000_004/m2_7_336# u_t000_004/m2_717_2037#
+ u_t000_004/m2_1886_2031# u_t000_004/m2_2573_336# u_t000_004/m2_7_2898# u_t000_004/m2_2000_1265#
+ u_t000_004/m2_512_2037# u_t000_004/m2_1795_1265# u_t000_004/m2_1714_1982# u_t000_004/m2_1886_1259#
+ u_t000_004/m2_1290_2126# u_t000_004/m2_1714_438# u_t000_004/m2_431_1210# u_t000_004/m2_2573_2898#
+ u_t000_004/m2_2154_303# u_t000_004/m2_871_2081# VSUBS detronyx_12t_2w2r_rc4_4x4_routed_5layer_direct
Xgf180mcu_as_sc_mcu7t3v3__inv_2_229 gf180mcu_as_sc_mcu7t3v3__inv_2_260/VDD gf180mcu_as_sc_mcu7t3v3__inv_2_260/VDD
+ VSS VSS gf180mcu_as_sc_mcu7t3v3__inv_2_230/VNW VSUBS gf180mcu_as_sc_mcu7t3v3__inv_2
Xgf180mcu_as_sc_mcu7t3v3__inv_2_218 gf180mcu_as_sc_mcu7t3v3__inv_2_218/VDD VSS gf180mcu_as_sc_mcu7t3v3__inv_2_218/Y
+ VSS gf180mcu_as_sc_mcu7t3v3__inv_2_218/VNW VSUBS gf180mcu_as_sc_mcu7t3v3__inv_2
Xu_t000_015 u_t000_015/c0_w0_bl u_t000_015/c0_w0_br u_t000_015/c0_w1_bl u_t000_015/c0_w1_br
+ u_t000_015/c0_r0_rbl u_t000_015/c0_r1_rbl u_t000_015/c1_w0_bl u_t000_015/c1_w0_br
+ u_t000_015/c1_w1_bl u_t000_015/c1_w1_br u_t000_015/c1_r0_rbl u_t000_015/c1_r1_rbl
+ u_t000_015/c2_w0_bl u_t000_015/c2_w0_br u_t000_015/c2_w1_bl u_t000_015/c2_w1_br
+ u_t000_015/c2_r0_rbl u_t000_015/c2_r1_rbl u_t000_015/c3_w0_bl u_t000_015/c3_w0_br
+ u_t000_015/c3_w1_bl u_t000_015/c3_w1_br u_t000_015/c3_r0_rbl u_t000_015/c3_r1_rbl
+ u_t000_015/r0_w0_wl u_t000_015/r0_w1_wl u_t000_015/r0_r0_rwl u_t000_015/r0_r1_rwl
+ u_t000_015/r1_w0_wl u_t000_015/r1_w1_wl u_t000_015/r1_r0_rwl u_t000_015/r1_r1_rwl
+ u_t000_015/r2_w0_wl u_t000_015/r2_w1_wl u_t000_015/r2_r0_rwl u_t000_015/r2_r1_rwl
+ u_t000_015/r3_w0_wl u_t000_015/r3_w1_wl u_t000_015/r3_r0_rwl u_t000_015/r3_r1_rwl
+ VSS VSS u_t000_015/m2_717_1265# u_t000_015/m2_603_2031# u_t000_015/m2_1290_336#
+ u_t000_015/m2_2000_2037# u_t000_015/m2_791_2909# u_t000_015/m2_7_2126# u_t000_015/m2_2154_2081#
+ u_t000_015/m2_1795_2037# u_t000_015/m2_871_303# u_t000_015/m2_431_438# u_t000_015/m2_1290_2898#
+ u_t000_015/m2_1714_1210# u_t000_015/m2_431_1982# u_t000_015/m2_512_1265# u_t000_015/m2_2573_2126#
+ u_t000_015/m2_603_1259# u_t000_015/m2_2074_2909# u_t000_015/m2_7_336# u_t000_015/m2_717_2037#
+ u_t000_015/m2_1886_2031# u_t000_015/m2_2573_336# u_t000_015/m2_7_2898# u_t000_015/m2_2000_1265#
+ u_t000_015/m2_512_2037# u_t000_015/m2_1795_1265# u_t000_015/m2_1714_1982# u_t000_015/m2_1886_1259#
+ u_t000_015/m2_1290_2126# u_t000_015/m2_1714_438# u_t000_015/m2_431_1210# u_t000_015/m2_2573_2898#
+ u_t000_015/m2_2154_303# u_t000_015/m2_871_2081# VSUBS detronyx_12t_2w2r_rc4_4x4_routed_5layer_direct
Xgf180mcu_as_sc_mcu7t3v3__inv_2_1290 VSS VSS VSS VSS gf180mcu_as_sc_mcu7t3v3__inv_2_1290/VNW
+ VSUBS gf180mcu_as_sc_mcu7t3v3__inv_2
Xgf180mcu_as_sc_mcu7t3v3__inv_2_763 VSS VSS VSS VSS gf180mcu_as_sc_mcu7t3v3__inv_2_822/VNW
+ VSUBS gf180mcu_as_sc_mcu7t3v3__inv_2
Xgf180mcu_as_sc_mcu7t3v3__inv_2_752 VSS VSS VSS VSS gf180mcu_as_sc_mcu7t3v3__inv_2_836/VNW
+ VSUBS gf180mcu_as_sc_mcu7t3v3__inv_2
Xgf180mcu_as_sc_mcu7t3v3__inv_2_730 gf180mcu_as_sc_mcu7t3v3__inv_2_730/VDD VSS gf180mcu_as_sc_mcu7t3v3__inv_2_730/Y
+ VSS gf180mcu_as_sc_mcu7t3v3__inv_2_730/VNW VSUBS gf180mcu_as_sc_mcu7t3v3__inv_2
Xgf180mcu_as_sc_mcu7t3v3__inv_2_741 gf180mcu_as_sc_mcu7t3v3__inv_2_741/VDD VSS VSS
+ gf180mcu_as_sc_mcu7t3v3__inv_2_742/A gf180mcu_as_sc_mcu7t3v3__inv_2_741/VNW VSUBS
+ gf180mcu_as_sc_mcu7t3v3__inv_2
Xgf180mcu_as_sc_mcu7t3v3__inv_2_774 VSS VSS VSS VSS gf180mcu_as_sc_mcu7t3v3__inv_2_826/VNW
+ VSUBS gf180mcu_as_sc_mcu7t3v3__inv_2
Xgf180mcu_as_sc_mcu7t3v3__inv_2_785 VSS VSS VSS VSS gf180mcu_as_sc_mcu7t3v3__inv_2_816/VNW
+ VSUBS gf180mcu_as_sc_mcu7t3v3__inv_2
Xgf180mcu_as_sc_mcu7t3v3__inv_2_796 VSS VSS VSS VSS gf180mcu_as_sc_mcu7t3v3__inv_2_851/VNW
+ VSUBS gf180mcu_as_sc_mcu7t3v3__inv_2
Xgf180mcu_as_sc_mcu7t3v3__inv_2_571 gf180mcu_as_sc_mcu7t3v3__inv_2_576/VDD gf180mcu_as_sc_mcu7t3v3__inv_2_576/VDD
+ gf180mcu_as_sc_mcu7t3v3__inv_2_571/Y VSS gf180mcu_as_sc_mcu7t3v3__inv_2_573/VNW
+ VSUBS gf180mcu_as_sc_mcu7t3v3__inv_2
Xgf180mcu_as_sc_mcu7t3v3__inv_2_582 gf180mcu_as_sc_mcu7t3v3__inv_2_584/VDD VSS gf180mcu_as_sc_mcu7t3v3__inv_2_582/Y
+ VSS gf180mcu_as_sc_mcu7t3v3__inv_2_584/VNW VSUBS gf180mcu_as_sc_mcu7t3v3__inv_2
Xgf180mcu_as_sc_mcu7t3v3__inv_2_593 gf180mcu_as_sc_mcu7t3v3__inv_2_638/VSS gf180mcu_as_sc_mcu7t3v3__inv_2_638/VSS
+ gf180mcu_as_sc_mcu7t3v3__inv_2_638/A gf180mcu_as_sc_mcu7t3v3__inv_2_594/Y gf180mcu_as_sc_mcu7t3v3__inv_2_638/VNW
+ VSUBS gf180mcu_as_sc_mcu7t3v3__inv_2
Xgf180mcu_as_sc_mcu7t3v3__inv_2_560 VSS VSS VSS VSS gf180mcu_as_sc_mcu7t3v3__inv_2_560/VNW
+ VSUBS gf180mcu_as_sc_mcu7t3v3__inv_2
Xgf180mcu_as_sc_mcu7t3v3__nor2_2_8 gf180mcu_as_sc_mcu7t3v3__nor2_2_9/VDD gf180mcu_as_sc_mcu7t3v3__nor2_2_9/VSS
+ VSS VSS VSS gf180mcu_as_sc_mcu7t3v3__nor2_2_9/VNW VSUBS gf180mcu_as_sc_mcu7t3v3__nor2_2
Xu_t028_007 u_t028_007/c0_w0_bl u_t028_007/c0_w0_br u_t028_007/c0_w1_bl u_t028_007/c0_w1_br
+ u_t028_007/c0_r0_rbl u_t028_007/c0_r1_rbl u_t028_007/c1_w0_bl u_t028_007/c1_w0_br
+ u_t028_007/c1_w1_bl u_t028_007/c1_w1_br u_t028_007/c1_r0_rbl u_t028_007/c1_r1_rbl
+ u_t028_007/c2_w0_bl u_t028_007/c2_w0_br u_t028_007/c2_w1_bl u_t028_007/c2_w1_br
+ u_t028_007/c2_r0_rbl u_t028_007/c2_r1_rbl u_t028_007/c3_w0_bl u_t028_007/c3_w0_br
+ u_t028_007/c3_w1_bl u_t028_007/c3_w1_br u_t028_007/c3_r0_rbl u_t028_007/c3_r1_rbl
+ u_t028_007/r0_w0_wl u_t028_007/r0_w1_wl u_t028_007/r0_r0_rwl u_t028_007/r0_r1_rwl
+ u_t028_007/r1_w0_wl u_t028_007/r1_w1_wl u_t028_007/r1_r0_rwl u_t028_007/r1_r1_rwl
+ u_t028_007/r2_w0_wl u_t028_007/r2_w1_wl u_t028_007/r2_r0_rwl u_t028_007/r2_r1_rwl
+ u_t028_007/r3_w0_wl u_t028_007/r3_w1_wl u_t028_007/r3_r0_rwl u_t028_007/r3_r1_rwl
+ VSS u_t028_009/VSS u_t028_007/m2_717_1265# u_t028_007/m2_603_2031# u_t028_007/m2_1290_336#
+ u_t028_007/m2_2000_2037# u_t028_007/m2_791_2909# u_t028_007/m2_7_2126# u_t028_007/m2_2154_2081#
+ u_t028_007/m2_1795_2037# u_t028_007/m2_871_303# u_t028_007/m2_431_438# u_t028_007/m2_1290_2898#
+ u_t028_007/m2_1714_1210# u_t028_007/m2_431_1982# u_t028_007/m2_512_1265# u_t028_007/m2_2573_2126#
+ u_t028_007/m2_603_1259# u_t028_007/m2_2074_2909# u_t028_007/m2_7_336# u_t028_007/m2_717_2037#
+ u_t028_007/m2_1886_2031# u_t028_007/m2_2573_336# u_t028_007/m2_7_2898# u_t028_007/m2_2000_1265#
+ u_t028_007/m2_512_2037# u_t028_007/m2_1795_1265# u_t028_007/m2_1714_1982# u_t028_007/m2_1886_1259#
+ u_t028_007/m2_1290_2126# u_t028_007/m2_1714_438# u_t028_007/m2_431_1210# u_t028_007/m2_2573_2898#
+ u_t028_007/m2_2154_303# u_t028_007/m2_871_2081# VSUBS detronyx_12t_2w2r_rc4_4x4_routed_5layer_direct
Xgf180mcu_as_sc_mcu7t3v3__inv_2_390 gf180mcu_as_sc_mcu7t3v3__nand3_2_9/VDD gf180mcu_as_sc_mcu7t3v3__nor2_2_4/VSS
+ VSS VSS gf180mcu_as_sc_mcu7t3v3__nand3_2_9/VNW VSUBS gf180mcu_as_sc_mcu7t3v3__inv_2
Xu_t019_007 u_t019_007/c0_w0_bl u_t019_007/c0_w0_br u_t019_007/c0_w1_bl u_t019_007/c0_w1_br
+ u_t019_007/c0_r0_rbl u_t019_007/c0_r1_rbl u_t019_007/c1_w0_bl u_t019_007/c1_w0_br
+ u_t019_007/c1_w1_bl u_t019_007/c1_w1_br u_t019_007/c1_r0_rbl u_t019_007/c1_r1_rbl
+ u_t019_007/c2_w0_bl u_t019_007/c2_w0_br u_t019_007/c2_w1_bl u_t019_007/c2_w1_br
+ u_t019_007/c2_r0_rbl u_t019_007/c2_r1_rbl u_t019_007/c3_w0_bl u_t019_007/c3_w0_br
+ u_t019_007/c3_w1_bl u_t019_007/c3_w1_br u_t019_007/c3_r0_rbl u_t019_007/c3_r1_rbl
+ u_t019_007/r0_w0_wl u_t019_007/r0_w1_wl u_t019_007/r0_r0_rwl u_t019_007/r0_r1_rwl
+ u_t019_007/r1_w0_wl u_t019_007/r1_w1_wl u_t019_007/r1_r0_rwl u_t019_007/r1_r1_rwl
+ u_t019_007/r2_w0_wl u_t019_007/r2_w1_wl u_t019_007/r2_r0_rwl u_t019_007/r2_r1_rwl
+ u_t019_007/r3_w0_wl u_t019_007/r3_w1_wl u_t019_007/r3_r0_rwl u_t019_007/r3_r1_rwl
+ VSS u_t019_009/VSS u_t019_007/m2_717_1265# u_t019_007/m2_603_2031# u_t019_007/m2_1290_336#
+ u_t019_007/m2_2000_2037# u_t019_007/m2_791_2909# u_t019_007/m2_7_2126# u_t019_007/m2_2154_2081#
+ u_t019_007/m2_1795_2037# u_t019_007/m2_871_303# u_t019_007/m2_431_438# u_t019_007/m2_1290_2898#
+ u_t019_007/m2_1714_1210# u_t019_007/m2_431_1982# u_t019_007/m2_512_1265# u_t019_007/m2_2573_2126#
+ u_t019_007/m2_603_1259# u_t019_007/m2_2074_2909# u_t019_007/m2_7_336# u_t019_007/m2_717_2037#
+ u_t019_007/m2_1886_2031# u_t019_007/m2_2573_336# u_t019_007/m2_7_2898# u_t019_007/m2_2000_1265#
+ u_t019_007/m2_512_2037# u_t019_007/m2_1795_1265# u_t019_007/m2_1714_1982# u_t019_007/m2_1886_1259#
+ u_t019_007/m2_1290_2126# u_t019_007/m2_1714_438# u_t019_007/m2_431_1210# u_t019_007/m2_2573_2898#
+ u_t019_007/m2_2154_303# u_t019_007/m2_871_2081# VSUBS detronyx_12t_2w2r_rc4_4x4_routed_5layer_direct
Xgf180mcu_as_sc_mcu7t3v3__inv_2_1108 gf180mcu_as_sc_mcu7t3v3__inv_2_1112/VDD VSS gf180mcu_as_sc_mcu7t3v3__inv_2_1108/Y
+ gf180mcu_as_sc_mcu7t3v3__inv_2_1112/Y gf180mcu_as_sc_mcu7t3v3__inv_2_1112/VNW VSUBS
+ gf180mcu_as_sc_mcu7t3v3__inv_2
Xgf180mcu_as_sc_mcu7t3v3__inv_2_1119 VSS VSS VSS gf180mcu_as_sc_mcu7t3v3__inv_2_1122/A
+ gf180mcu_as_sc_mcu7t3v3__inv_2_1121/VNW VSUBS gf180mcu_as_sc_mcu7t3v3__inv_2
Xu_t024_010 u_t024_010/c0_w0_bl u_t024_010/c0_w0_br u_t024_010/c0_w1_bl u_t024_010/c0_w1_br
+ u_t024_010/c0_r0_rbl u_t024_010/c0_r1_rbl u_t024_010/c1_w0_bl u_t024_010/c1_w0_br
+ u_t024_010/c1_w1_bl u_t024_010/c1_w1_br u_t024_010/c1_r0_rbl u_t024_010/c1_r1_rbl
+ u_t024_010/c2_w0_bl u_t024_010/c2_w0_br u_t024_010/c2_w1_bl u_t024_010/c2_w1_br
+ u_t024_010/c2_r0_rbl u_t024_010/c2_r1_rbl u_t024_010/c3_w0_bl u_t024_010/c3_w0_br
+ u_t024_010/c3_w1_bl u_t024_010/c3_w1_br u_t024_010/c3_r0_rbl u_t024_010/c3_r1_rbl
+ u_t024_010/r0_w0_wl u_t024_010/r0_w1_wl u_t024_010/r0_r0_rwl u_t024_010/r0_r1_rwl
+ u_t024_010/r1_w0_wl u_t024_010/r1_w1_wl u_t024_010/r1_r0_rwl u_t024_010/r1_r1_rwl
+ u_t024_010/r2_w0_wl u_t024_010/r2_w1_wl u_t024_010/r2_r0_rwl u_t024_010/r2_r1_rwl
+ u_t024_010/r3_w0_wl u_t024_010/r3_w1_wl u_t024_010/r3_r0_rwl u_t024_010/r3_r1_rwl
+ VSS u_t024_010/VSS u_t024_010/m2_717_1265# u_t024_010/m2_603_2031# u_t024_010/m2_1290_336#
+ u_t024_010/m2_2000_2037# u_t024_010/m2_791_2909# u_t024_010/m2_7_2126# u_t024_010/m2_2154_2081#
+ u_t024_010/m2_1795_2037# u_t024_010/m2_871_303# u_t024_010/m2_431_438# u_t024_010/m2_1290_2898#
+ u_t024_010/m2_1714_1210# u_t024_010/m2_431_1982# u_t024_010/m2_512_1265# u_t024_010/m2_2573_2126#
+ u_t024_010/m2_603_1259# u_t024_010/m2_2074_2909# u_t024_010/m2_7_336# u_t024_010/m2_717_2037#
+ u_t024_010/m2_1886_2031# u_t024_010/m2_2573_336# u_t024_010/m2_7_2898# u_t024_010/m2_2000_1265#
+ u_t024_010/m2_512_2037# u_t024_010/m2_1795_1265# u_t024_010/m2_1714_1982# u_t024_010/m2_1886_1259#
+ u_t024_010/m2_1290_2126# u_t024_010/m2_1714_438# u_t024_010/m2_431_1210# u_t024_010/m2_2573_2898#
+ u_t024_010/m2_2154_303# u_t024_010/m2_871_2081# VSUBS detronyx_12t_2w2r_rc4_4x4_routed_5layer_direct
Xgf180mcu_as_sc_mcu7t3v3__nand3_2_55 gf180mcu_as_sc_mcu7t3v3__nand3_2_65/VDD gf180mcu_as_sc_mcu7t3v3__nor2_2_9/VSS
+ VSS VSS VSS VSS gf180mcu_as_sc_mcu7t3v3__nand3_2_65/VNW VSUBS gf180mcu_as_sc_mcu7t3v3__nand3_2
Xgf180mcu_as_sc_mcu7t3v3__nand3_2_44 gf180mcu_as_sc_mcu7t3v3__nand3_2_65/VDD gf180mcu_as_sc_mcu7t3v3__nand3_2_62/VSS
+ VSS VSS VSS VSS gf180mcu_as_sc_mcu7t3v3__nand3_2_65/VNW VSUBS gf180mcu_as_sc_mcu7t3v3__nand3_2
Xgf180mcu_as_sc_mcu7t3v3__nand3_2_33 gf180mcu_as_sc_mcu7t3v3__nand3_2_9/VDD gf180mcu_as_sc_mcu7t3v3__nor2_2_4/VSS
+ VSS VSS VSS VSS gf180mcu_as_sc_mcu7t3v3__nand3_2_9/VNW VSUBS gf180mcu_as_sc_mcu7t3v3__nand3_2
Xgf180mcu_as_sc_mcu7t3v3__nand3_2_22 gf180mcu_as_sc_mcu7t3v3__nand3_2_9/VDD gf180mcu_as_sc_mcu7t3v3__nor2_2_7/VSS
+ VSS VSS VSS VSS gf180mcu_as_sc_mcu7t3v3__nand3_2_9/VNW VSUBS gf180mcu_as_sc_mcu7t3v3__nand3_2
Xgf180mcu_as_sc_mcu7t3v3__nand3_2_11 gf180mcu_as_sc_mcu7t3v3__nor2_2_4/VDD gf180mcu_as_sc_mcu7t3v3__nor2_2_4/VSS
+ VSS VSS VSS VSS gf180mcu_as_sc_mcu7t3v3__nor2_2_4/VNW VSUBS gf180mcu_as_sc_mcu7t3v3__nand3_2
Xgf180mcu_as_sc_mcu7t3v3__inv_2_1642 VSS gf180mcu_as_sc_mcu7t3v3__inv_2_1649/VDD gf180mcu_as_sc_mcu7t3v3__inv_2_1689/A
+ VSS gf180mcu_as_sc_mcu7t3v3__inv_2_1642/VNW VSUBS gf180mcu_as_sc_mcu7t3v3__inv_2
Xgf180mcu_as_sc_mcu7t3v3__inv_2_1631 VSS VSS gf180mcu_as_sc_mcu7t3v3__inv_2_1685/A
+ VSS gf180mcu_as_sc_mcu7t3v3__inv_2_1631/VNW VSUBS gf180mcu_as_sc_mcu7t3v3__inv_2
Xgf180mcu_as_sc_mcu7t3v3__inv_2_1653 VSS gf180mcu_as_sc_mcu7t3v3__inv_2_1685/VDD gf180mcu_as_sc_mcu7t3v3__inv_2_1685/A
+ VSS gf180mcu_as_sc_mcu7t3v3__inv_2_1653/VNW VSUBS gf180mcu_as_sc_mcu7t3v3__inv_2
Xgf180mcu_as_sc_mcu7t3v3__inv_2_1620 VSS gf180mcu_as_sc_mcu7t3v3__inv_2_1626/VDD VSS
+ gf180mcu_as_sc_mcu7t3v3__inv_2_1669/A gf180mcu_as_sc_mcu7t3v3__inv_2_1622/VNW VSUBS
+ gf180mcu_as_sc_mcu7t3v3__inv_2
Xgf180mcu_as_sc_mcu7t3v3__inv_2_1664 VSS VSS gf180mcu_as_sc_mcu7t3v3__inv_2_1672/Y
+ VSS gf180mcu_as_sc_mcu7t3v3__inv_2_1664/VNW VSUBS gf180mcu_as_sc_mcu7t3v3__inv_2
Xgf180mcu_as_sc_mcu7t3v3__inv_2_1675 VSS VSS gf180mcu_as_sc_mcu7t3v3__inv_2_1684/Y
+ gf180mcu_as_sc_mcu7t3v3__inv_2_1684/Y gf180mcu_as_sc_mcu7t3v3__inv_2_1676/VNW VSUBS
+ gf180mcu_as_sc_mcu7t3v3__inv_2
Xgf180mcu_as_sc_mcu7t3v3__inv_2_1686 VSS VSS VSS gf180mcu_as_sc_mcu7t3v3__inv_2_1694/Y
+ gf180mcu_as_sc_mcu7t3v3__inv_2_1688/VNW VSUBS gf180mcu_as_sc_mcu7t3v3__inv_2
Xgf180mcu_as_sc_mcu7t3v3__inv_2_1697 gf180mcu_as_sc_mcu7t3v3__inv_2_1697/VDD VSS VSS
+ VSS gf180mcu_as_sc_mcu7t3v3__inv_2_1697/VNW VSUBS gf180mcu_as_sc_mcu7t3v3__inv_2
Xu_t030_013 u_t030_013/c0_w0_bl u_t030_013/c0_w0_br u_t030_013/c0_w1_bl u_t030_013/c0_w1_br
+ u_t030_013/c0_r0_rbl u_t030_013/c0_r1_rbl u_t030_013/c1_w0_bl u_t030_013/c1_w0_br
+ u_t030_013/c1_w1_bl u_t030_013/c1_w1_br u_t030_013/c1_r0_rbl u_t030_013/c1_r1_rbl
+ u_t030_013/c2_w0_bl u_t030_013/c2_w0_br u_t030_013/c2_w1_bl u_t030_013/c2_w1_br
+ u_t030_013/c2_r0_rbl u_t030_013/c2_r1_rbl u_t030_013/c3_w0_bl u_t030_013/c3_w0_br
+ u_t030_013/c3_w1_bl u_t030_013/c3_w1_br u_t030_013/c3_r0_rbl u_t030_013/c3_r1_rbl
+ u_t030_013/r0_w0_wl u_t030_013/r0_w1_wl u_t030_013/r0_r0_rwl u_t030_013/r0_r1_rwl
+ u_t030_013/r1_w0_wl u_t030_013/r1_w1_wl u_t030_013/r1_r0_rwl u_t030_013/r1_r1_rwl
+ u_t030_013/r2_w0_wl u_t030_013/r2_w1_wl u_t030_013/r2_r0_rwl u_t030_013/r2_r1_rwl
+ u_t030_013/r3_w0_wl u_t030_013/r3_w1_wl u_t030_013/r3_r0_rwl u_t030_013/r3_r1_rwl
+ u_t030_013/VDD VSS u_t030_013/m2_717_1265# u_t030_013/m2_603_2031# u_t030_013/m2_1290_336#
+ u_t030_013/m2_2000_2037# u_t030_013/m2_791_2909# u_t030_013/m2_7_2126# u_t030_013/m2_2154_2081#
+ u_t030_013/m2_1795_2037# u_t030_013/m2_871_303# u_t030_013/m2_431_438# u_t030_013/m2_1290_2898#
+ u_t030_013/m2_1714_1210# u_t030_013/m2_431_1982# u_t030_013/m2_512_1265# u_t030_013/m2_2573_2126#
+ u_t030_013/m2_603_1259# u_t030_013/m2_2074_2909# u_t030_013/m2_7_336# u_t030_013/m2_717_2037#
+ u_t030_013/m2_1886_2031# u_t030_013/m2_2573_336# u_t030_013/m2_7_2898# u_t030_013/m2_2000_1265#
+ u_t030_013/m2_512_2037# u_t030_013/m2_1795_1265# u_t030_013/m2_1714_1982# u_t030_013/m2_1886_1259#
+ u_t030_013/m2_1290_2126# u_t030_013/m2_1714_438# u_t030_013/m2_431_1210# u_t030_013/m2_2573_2898#
+ u_t030_013/m2_2154_303# u_t030_013/m2_871_2081# VSUBS detronyx_12t_2w2r_rc4_4x4_routed_5layer_direct
Xu_t015_010 u_t015_010/c0_w0_bl u_t015_010/c0_w0_br u_t015_010/c0_w1_bl u_t015_010/c0_w1_br
+ u_t015_010/c0_r0_rbl u_t015_010/c0_r1_rbl u_t015_010/c1_w0_bl u_t015_010/c1_w0_br
+ u_t015_010/c1_w1_bl u_t015_010/c1_w1_br u_t015_010/c1_r0_rbl u_t015_010/c1_r1_rbl
+ u_t015_010/c2_w0_bl u_t015_010/c2_w0_br u_t015_010/c2_w1_bl u_t015_010/c2_w1_br
+ u_t015_010/c2_r0_rbl u_t015_010/c2_r1_rbl u_t015_010/c3_w0_bl u_t015_010/c3_w0_br
+ u_t015_010/c3_w1_bl u_t015_010/c3_w1_br u_t015_010/c3_r0_rbl u_t015_010/c3_r1_rbl
+ u_t015_010/r0_w0_wl u_t015_010/r0_w1_wl u_t015_010/r0_r0_rwl u_t015_010/r0_r1_rwl
+ u_t015_010/r1_w0_wl u_t015_010/r1_w1_wl u_t015_010/r1_r0_rwl u_t015_010/r1_r1_rwl
+ u_t015_010/r2_w0_wl u_t015_010/r2_w1_wl u_t015_010/r2_r0_rwl u_t015_010/r2_r1_rwl
+ u_t015_010/r3_w0_wl u_t015_010/r3_w1_wl u_t015_010/r3_r0_rwl u_t015_010/r3_r1_rwl
+ VSS u_t015_010/VSS u_t015_010/m2_717_1265# u_t015_010/m2_603_2031# u_t015_010/m2_1290_336#
+ u_t015_010/m2_2000_2037# u_t015_010/m2_791_2909# u_t015_010/m2_7_2126# u_t015_010/m2_2154_2081#
+ u_t015_010/m2_1795_2037# u_t015_010/m2_871_303# u_t015_010/m2_431_438# u_t015_010/m2_1290_2898#
+ u_t015_010/m2_1714_1210# u_t015_010/m2_431_1982# u_t015_010/m2_512_1265# u_t015_010/m2_2573_2126#
+ u_t015_010/m2_603_1259# u_t015_010/m2_2074_2909# u_t015_010/m2_7_336# u_t015_010/m2_717_2037#
+ u_t015_010/m2_1886_2031# u_t015_010/m2_2573_336# u_t015_010/m2_7_2898# u_t015_010/m2_2000_1265#
+ u_t015_010/m2_512_2037# u_t015_010/m2_1795_1265# u_t015_010/m2_1714_1982# u_t015_010/m2_1886_1259#
+ u_t015_010/m2_1290_2126# u_t015_010/m2_1714_438# u_t015_010/m2_431_1210# u_t015_010/m2_2573_2898#
+ u_t015_010/m2_2154_303# u_t015_010/m2_871_2081# VSUBS detronyx_12t_2w2r_rc4_4x4_routed_5layer_direct
Xu_t030_002 u_t030_002/c0_w0_bl u_t030_002/c0_w0_br u_t030_002/c0_w1_bl u_t030_002/c0_w1_br
+ u_t030_002/c0_r0_rbl u_t030_002/c0_r1_rbl u_t030_002/c1_w0_bl u_t030_002/c1_w0_br
+ u_t030_002/c1_w1_bl u_t030_002/c1_w1_br u_t030_002/c1_r0_rbl u_t030_002/c1_r1_rbl
+ u_t030_002/c2_w0_bl u_t030_002/c2_w0_br u_t030_002/c2_w1_bl u_t030_002/c2_w1_br
+ u_t030_002/c2_r0_rbl u_t030_002/c2_r1_rbl u_t030_002/c3_w0_bl u_t030_002/c3_w0_br
+ u_t030_002/c3_w1_bl u_t030_002/c3_w1_br u_t030_002/c3_r0_rbl u_t030_002/c3_r1_rbl
+ u_t030_002/r0_w0_wl u_t030_002/r0_w1_wl u_t030_002/r0_r0_rwl u_t030_002/r0_r1_rwl
+ u_t030_002/r1_w0_wl u_t030_002/r1_w1_wl u_t030_002/r1_r0_rwl u_t030_002/r1_r1_rwl
+ u_t030_002/r2_w0_wl u_t030_002/r2_w1_wl u_t030_002/r2_r0_rwl u_t030_002/r2_r1_rwl
+ u_t030_002/r3_w0_wl u_t030_002/r3_w1_wl u_t030_002/r3_r0_rwl u_t030_002/r3_r1_rwl
+ VSS VSS u_t030_002/m2_717_1265# u_t030_002/m2_603_2031# u_t030_002/m2_1290_336#
+ u_t030_002/m2_2000_2037# u_t030_002/m2_791_2909# u_t030_002/m2_7_2126# u_t030_002/m2_2154_2081#
+ u_t030_002/m2_1795_2037# u_t030_002/m2_871_303# u_t030_002/m2_431_438# u_t030_002/m2_1290_2898#
+ u_t030_002/m2_1714_1210# u_t030_002/m2_431_1982# u_t030_002/m2_512_1265# u_t030_002/m2_2573_2126#
+ u_t030_002/m2_603_1259# u_t030_002/m2_2074_2909# u_t030_002/m2_7_336# u_t030_002/m2_717_2037#
+ u_t030_002/m2_1886_2031# u_t030_002/m2_2573_336# u_t030_002/m2_7_2898# u_t030_002/m2_2000_1265#
+ u_t030_002/m2_512_2037# u_t030_002/m2_1795_1265# u_t030_002/m2_1714_1982# u_t030_002/m2_1886_1259#
+ u_t030_002/m2_1290_2126# u_t030_002/m2_1714_438# u_t030_002/m2_431_1210# u_t030_002/m2_2573_2898#
+ u_t030_002/m2_2154_303# u_t030_002/m2_871_2081# VSUBS detronyx_12t_2w2r_rc4_4x4_routed_5layer_direct
Xgf180mcu_as_sc_mcu7t3v3__nand4_2_436 VSS gf180mcu_as_sc_mcu7t3v3__inv_2_1582/VDD
+ VSS VSS VSS VSS gf180mcu_as_sc_mcu7t3v3__nand4_2_436/Y gf180mcu_as_sc_mcu7t3v3__inv_2_1579/VNW
+ VSUBS gf180mcu_as_sc_mcu7t3v3__nand4_2
Xgf180mcu_as_sc_mcu7t3v3__nand4_2_425 gf180mcu_as_sc_mcu7t3v3__inv_2_1547/VDD VSS
+ VSS VSS VSS VSS VSS gf180mcu_as_sc_mcu7t3v3__inv_2_1547/VNW VSUBS gf180mcu_as_sc_mcu7t3v3__nand4_2
Xgf180mcu_as_sc_mcu7t3v3__nand4_2_414 VSS VSS VSS VSS VSS VSS VSS gf180mcu_as_sc_mcu7t3v3__inv_2_1514/VNW
+ VSUBS gf180mcu_as_sc_mcu7t3v3__nand4_2
Xgf180mcu_as_sc_mcu7t3v3__nand4_2_469 gf180mcu_as_sc_mcu7t3v3__inv_2_1382/VDD VSS
+ VSS VSS VSS VSS VSS gf180mcu_as_sc_mcu7t3v3__inv_2_1382/VNW VSUBS gf180mcu_as_sc_mcu7t3v3__nand4_2
Xgf180mcu_as_sc_mcu7t3v3__nand4_2_403 gf180mcu_as_sc_mcu7t3v3__inv_2_1508/VDD gf180mcu_as_sc_mcu7t3v3__inv_2_1508/VSS
+ VSS VSS VSS VSS gf180mcu_as_sc_mcu7t3v3__nand4_2_403/Y gf180mcu_as_sc_mcu7t3v3__inv_2_1508/VNW
+ VSUBS gf180mcu_as_sc_mcu7t3v3__nand4_2
Xgf180mcu_as_sc_mcu7t3v3__nand4_2_447 VSS gf180mcu_as_sc_mcu7t3v3__inv_2_1717/VDD
+ VSS VSS VSS VSS VSS gf180mcu_as_sc_mcu7t3v3__inv_2_1324/VNW VSUBS gf180mcu_as_sc_mcu7t3v3__nand4_2
Xgf180mcu_as_sc_mcu7t3v3__nand4_2_458 gf180mcu_as_sc_mcu7t3v3__inv_2_1320/VDD VSS
+ VSS VSS VSS VSS VSS gf180mcu_as_sc_mcu7t3v3__inv_2_1320/VNW VSUBS gf180mcu_as_sc_mcu7t3v3__nand4_2
Xu_t006_010 u_t006_010/c0_w0_bl u_t006_010/c0_w0_br u_t006_010/c0_w1_bl u_t006_010/c0_w1_br
+ u_t006_010/c0_r0_rbl u_t006_010/c0_r1_rbl u_t006_010/c1_w0_bl u_t006_010/c1_w0_br
+ u_t006_010/c1_w1_bl u_t006_010/c1_w1_br u_t006_010/c1_r0_rbl u_t006_010/c1_r1_rbl
+ u_t006_010/c2_w0_bl u_t006_010/c2_w0_br u_t006_010/c2_w1_bl u_t006_010/c2_w1_br
+ u_t006_010/c2_r0_rbl u_t006_010/c2_r1_rbl u_t006_010/c3_w0_bl u_t006_010/c3_w0_br
+ u_t006_010/c3_w1_bl u_t006_010/c3_w1_br u_t006_010/c3_r0_rbl u_t006_010/c3_r1_rbl
+ u_t006_010/r0_w0_wl u_t006_010/r0_w1_wl u_t006_010/r0_r0_rwl u_t006_010/r0_r1_rwl
+ u_t006_010/r1_w0_wl u_t006_010/r1_w1_wl u_t006_010/r1_r0_rwl u_t006_010/r1_r1_rwl
+ u_t006_010/r2_w0_wl u_t006_010/r2_w1_wl u_t006_010/r2_r0_rwl u_t006_010/r2_r1_rwl
+ u_t006_010/r3_w0_wl u_t006_010/r3_w1_wl u_t006_010/r3_r0_rwl u_t006_010/r3_r1_rwl
+ VSS u_t006_010/VSS u_t006_010/m2_717_1265# u_t006_010/m2_603_2031# u_t006_010/m2_1290_336#
+ u_t006_010/m2_2000_2037# u_t006_010/m2_791_2909# u_t006_010/m2_7_2126# u_t006_010/m2_2154_2081#
+ u_t006_010/m2_1795_2037# u_t006_010/m2_871_303# u_t006_010/m2_431_438# u_t006_010/m2_1290_2898#
+ u_t006_010/m2_1714_1210# u_t006_010/m2_431_1982# u_t006_010/m2_512_1265# u_t006_010/m2_2573_2126#
+ u_t006_010/m2_603_1259# u_t006_010/m2_2074_2909# u_t006_010/m2_7_336# u_t006_010/m2_717_2037#
+ u_t006_010/m2_1886_2031# u_t006_010/m2_2573_336# u_t006_010/m2_7_2898# u_t006_010/m2_2000_1265#
+ u_t006_010/m2_512_2037# u_t006_010/m2_1795_1265# u_t006_010/m2_1714_1982# u_t006_010/m2_1886_1259#
+ u_t006_010/m2_1290_2126# u_t006_010/m2_1714_438# u_t006_010/m2_431_1210# u_t006_010/m2_2573_2898#
+ u_t006_010/m2_2154_303# u_t006_010/m2_871_2081# VSUBS detronyx_12t_2w2r_rc4_4x4_routed_5layer_direct
Xgf180mcu_as_sc_mcu7t3v3__inv_2_4 gf180mcu_as_sc_mcu7t3v3__inv_2_4/VDD gf180mcu_as_sc_mcu7t3v3__inv_2_8/VDD
+ gf180mcu_as_sc_mcu7t3v3__inv_2_8/Y VSS gf180mcu_as_sc_mcu7t3v3__inv_2_4/VNW VSUBS
+ gf180mcu_as_sc_mcu7t3v3__inv_2
Xu_t021_013 u_t021_013/c0_w0_bl u_t021_013/c0_w0_br u_t021_013/c0_w1_bl u_t021_013/c0_w1_br
+ u_t021_013/c0_r0_rbl u_t021_013/c0_r1_rbl u_t021_013/c1_w0_bl u_t021_013/c1_w0_br
+ u_t021_013/c1_w1_bl u_t021_013/c1_w1_br u_t021_013/c1_r0_rbl u_t021_013/c1_r1_rbl
+ u_t021_013/c2_w0_bl u_t021_013/c2_w0_br u_t021_013/c2_w1_bl u_t021_013/c2_w1_br
+ u_t021_013/c2_r0_rbl u_t021_013/c2_r1_rbl u_t021_013/c3_w0_bl u_t021_013/c3_w0_br
+ u_t021_013/c3_w1_bl u_t021_013/c3_w1_br u_t021_013/c3_r0_rbl u_t021_013/c3_r1_rbl
+ u_t021_013/r0_w0_wl u_t021_013/r0_w1_wl u_t021_013/r0_r0_rwl u_t021_013/r0_r1_rwl
+ u_t021_013/r1_w0_wl u_t021_013/r1_w1_wl u_t021_013/r1_r0_rwl u_t021_013/r1_r1_rwl
+ u_t021_013/r2_w0_wl u_t021_013/r2_w1_wl u_t021_013/r2_r0_rwl u_t021_013/r2_r1_rwl
+ u_t021_013/r3_w0_wl u_t021_013/r3_w1_wl u_t021_013/r3_r0_rwl u_t021_013/r3_r1_rwl
+ u_t021_013/VDD VSS u_t021_013/m2_717_1265# u_t021_013/m2_603_2031# u_t021_013/m2_1290_336#
+ u_t021_013/m2_2000_2037# u_t021_013/m2_791_2909# u_t021_013/m2_7_2126# u_t021_013/m2_2154_2081#
+ u_t021_013/m2_1795_2037# u_t021_013/m2_871_303# u_t021_013/m2_431_438# u_t021_013/m2_1290_2898#
+ u_t021_013/m2_1714_1210# u_t021_013/m2_431_1982# u_t021_013/m2_512_1265# u_t021_013/m2_2573_2126#
+ u_t021_013/m2_603_1259# u_t021_013/m2_2074_2909# u_t021_013/m2_7_336# u_t021_013/m2_717_2037#
+ u_t021_013/m2_1886_2031# u_t021_013/m2_2573_336# u_t021_013/m2_7_2898# u_t021_013/m2_2000_1265#
+ u_t021_013/m2_512_2037# u_t021_013/m2_1795_1265# u_t021_013/m2_1714_1982# u_t021_013/m2_1886_1259#
+ u_t021_013/m2_1290_2126# u_t021_013/m2_1714_438# u_t021_013/m2_431_1210# u_t021_013/m2_2573_2898#
+ u_t021_013/m2_2154_303# u_t021_013/m2_871_2081# VSUBS detronyx_12t_2w2r_rc4_4x4_routed_5layer_direct
Xu_t021_002 u_t021_002/c0_w0_bl u_t021_002/c0_w0_br u_t021_002/c0_w1_bl u_t021_002/c0_w1_br
+ u_t021_002/c0_r0_rbl u_t021_002/c0_r1_rbl u_t021_002/c1_w0_bl u_t021_002/c1_w0_br
+ u_t021_002/c1_w1_bl u_t021_002/c1_w1_br u_t021_002/c1_r0_rbl u_t021_002/c1_r1_rbl
+ u_t021_002/c2_w0_bl u_t021_002/c2_w0_br u_t021_002/c2_w1_bl u_t021_002/c2_w1_br
+ u_t021_002/c2_r0_rbl u_t021_002/c2_r1_rbl u_t021_002/c3_w0_bl u_t021_002/c3_w0_br
+ u_t021_002/c3_w1_bl u_t021_002/c3_w1_br u_t021_002/c3_r0_rbl u_t021_002/c3_r1_rbl
+ u_t021_002/r0_w0_wl u_t021_002/r0_w1_wl u_t021_002/r0_r0_rwl u_t021_002/r0_r1_rwl
+ u_t021_002/r1_w0_wl u_t021_002/r1_w1_wl u_t021_002/r1_r0_rwl u_t021_002/r1_r1_rwl
+ u_t021_002/r2_w0_wl u_t021_002/r2_w1_wl u_t021_002/r2_r0_rwl u_t021_002/r2_r1_rwl
+ u_t021_002/r3_w0_wl u_t021_002/r3_w1_wl u_t021_002/r3_r0_rwl u_t021_002/r3_r1_rwl
+ VSS VSS u_t021_002/m2_717_1265# u_t021_002/m2_603_2031# u_t021_002/m2_1290_336#
+ u_t021_002/m2_2000_2037# u_t021_002/m2_791_2909# u_t021_002/m2_7_2126# u_t021_002/m2_2154_2081#
+ u_t021_002/m2_1795_2037# u_t021_002/m2_871_303# u_t021_002/m2_431_438# u_t021_002/m2_1290_2898#
+ u_t021_002/m2_1714_1210# u_t021_002/m2_431_1982# u_t021_002/m2_512_1265# u_t021_002/m2_2573_2126#
+ u_t021_002/m2_603_1259# u_t021_002/m2_2074_2909# u_t021_002/m2_7_336# u_t021_002/m2_717_2037#
+ u_t021_002/m2_1886_2031# u_t021_002/m2_2573_336# u_t021_002/m2_7_2898# u_t021_002/m2_2000_1265#
+ u_t021_002/m2_512_2037# u_t021_002/m2_1795_1265# u_t021_002/m2_1714_1982# u_t021_002/m2_1886_1259#
+ u_t021_002/m2_1290_2126# u_t021_002/m2_1714_438# u_t021_002/m2_431_1210# u_t021_002/m2_2573_2898#
+ u_t021_002/m2_2154_303# u_t021_002/m2_871_2081# VSUBS detronyx_12t_2w2r_rc4_4x4_routed_5layer_direct
Xu_t012_013 u_t012_013/c0_w0_bl u_t012_013/c0_w0_br u_t012_013/c0_w1_bl u_t012_013/c0_w1_br
+ u_t012_013/c0_r0_rbl u_t012_013/c0_r1_rbl u_t012_013/c1_w0_bl u_t012_013/c1_w0_br
+ u_t012_013/c1_w1_bl u_t012_013/c1_w1_br u_t012_013/c1_r0_rbl u_t012_013/c1_r1_rbl
+ u_t012_013/c2_w0_bl u_t012_013/c2_w0_br u_t012_013/c2_w1_bl u_t012_013/c2_w1_br
+ u_t012_013/c2_r0_rbl u_t012_013/c2_r1_rbl u_t012_013/c3_w0_bl u_t012_013/c3_w0_br
+ u_t012_013/c3_w1_bl u_t012_013/c3_w1_br u_t012_013/c3_r0_rbl u_t012_013/c3_r1_rbl
+ u_t012_013/r0_w0_wl u_t012_013/r0_w1_wl u_t012_013/r0_r0_rwl u_t012_013/r0_r1_rwl
+ u_t012_013/r1_w0_wl u_t012_013/r1_w1_wl u_t012_013/r1_r0_rwl u_t012_013/r1_r1_rwl
+ u_t012_013/r2_w0_wl u_t012_013/r2_w1_wl u_t012_013/r2_r0_rwl u_t012_013/r2_r1_rwl
+ u_t012_013/r3_w0_wl u_t012_013/r3_w1_wl u_t012_013/r3_r0_rwl u_t012_013/r3_r1_rwl
+ u_t012_013/VDD VSS u_t012_013/m2_717_1265# u_t012_013/m2_603_2031# u_t012_013/m2_1290_336#
+ u_t012_013/m2_2000_2037# u_t012_013/m2_791_2909# u_t012_013/m2_7_2126# u_t012_013/m2_2154_2081#
+ u_t012_013/m2_1795_2037# u_t012_013/m2_871_303# u_t012_013/m2_431_438# u_t012_013/m2_1290_2898#
+ u_t012_013/m2_1714_1210# u_t012_013/m2_431_1982# u_t012_013/m2_512_1265# u_t012_013/m2_2573_2126#
+ u_t012_013/m2_603_1259# u_t012_013/m2_2074_2909# u_t012_013/m2_7_336# u_t012_013/m2_717_2037#
+ u_t012_013/m2_1886_2031# u_t012_013/m2_2573_336# u_t012_013/m2_7_2898# u_t012_013/m2_2000_1265#
+ u_t012_013/m2_512_2037# u_t012_013/m2_1795_1265# u_t012_013/m2_1714_1982# u_t012_013/m2_1886_1259#
+ u_t012_013/m2_1290_2126# u_t012_013/m2_1714_438# u_t012_013/m2_431_1210# u_t012_013/m2_2573_2898#
+ u_t012_013/m2_2154_303# u_t012_013/m2_871_2081# VSUBS detronyx_12t_2w2r_rc4_4x4_routed_5layer_direct
Xu_t012_002 u_t012_002/c0_w0_bl u_t012_002/c0_w0_br u_t012_002/c0_w1_bl u_t012_002/c0_w1_br
+ u_t012_002/c0_r0_rbl u_t012_002/c0_r1_rbl u_t012_002/c1_w0_bl u_t012_002/c1_w0_br
+ u_t012_002/c1_w1_bl u_t012_002/c1_w1_br u_t012_002/c1_r0_rbl u_t012_002/c1_r1_rbl
+ u_t012_002/c2_w0_bl u_t012_002/c2_w0_br u_t012_002/c2_w1_bl u_t012_002/c2_w1_br
+ u_t012_002/c2_r0_rbl u_t012_002/c2_r1_rbl u_t012_002/c3_w0_bl u_t012_002/c3_w0_br
+ u_t012_002/c3_w1_bl u_t012_002/c3_w1_br u_t012_002/c3_r0_rbl u_t012_002/c3_r1_rbl
+ u_t012_002/r0_w0_wl u_t012_002/r0_w1_wl u_t012_002/r0_r0_rwl u_t012_002/r0_r1_rwl
+ u_t012_002/r1_w0_wl u_t012_002/r1_w1_wl u_t012_002/r1_r0_rwl u_t012_002/r1_r1_rwl
+ u_t012_002/r2_w0_wl u_t012_002/r2_w1_wl u_t012_002/r2_r0_rwl u_t012_002/r2_r1_rwl
+ u_t012_002/r3_w0_wl u_t012_002/r3_w1_wl u_t012_002/r3_r0_rwl u_t012_002/r3_r1_rwl
+ VSS VSS u_t012_002/m2_717_1265# u_t012_002/m2_603_2031# u_t012_002/m2_1290_336#
+ u_t012_002/m2_2000_2037# u_t012_002/m2_791_2909# u_t012_002/m2_7_2126# u_t012_002/m2_2154_2081#
+ u_t012_002/m2_1795_2037# u_t012_002/m2_871_303# u_t012_002/m2_431_438# u_t012_002/m2_1290_2898#
+ u_t012_002/m2_1714_1210# u_t012_002/m2_431_1982# u_t012_002/m2_512_1265# u_t012_002/m2_2573_2126#
+ u_t012_002/m2_603_1259# u_t012_002/m2_2074_2909# u_t012_002/m2_7_336# u_t012_002/m2_717_2037#
+ u_t012_002/m2_1886_2031# u_t012_002/m2_2573_336# u_t012_002/m2_7_2898# u_t012_002/m2_2000_1265#
+ u_t012_002/m2_512_2037# u_t012_002/m2_1795_1265# u_t012_002/m2_1714_1982# u_t012_002/m2_1886_1259#
+ u_t012_002/m2_1290_2126# u_t012_002/m2_1714_438# u_t012_002/m2_431_1210# u_t012_002/m2_2573_2898#
+ u_t012_002/m2_2154_303# u_t012_002/m2_871_2081# VSUBS detronyx_12t_2w2r_rc4_4x4_routed_5layer_direct
Xgf180mcu_as_sc_mcu7t3v3__inv_2_1472 gf180mcu_as_sc_mcu7t3v3__inv_2_1473/VDD VSS VSS
+ VSS gf180mcu_as_sc_mcu7t3v3__inv_2_1473/VNW VSUBS gf180mcu_as_sc_mcu7t3v3__inv_2
Xgf180mcu_as_sc_mcu7t3v3__inv_2_1483 VSS VSS VSS VSS gf180mcu_as_sc_mcu7t3v3__inv_2_1485/VNW
+ VSUBS gf180mcu_as_sc_mcu7t3v3__inv_2
Xgf180mcu_as_sc_mcu7t3v3__inv_2_1494 VSS VSS VSS VSS gf180mcu_as_sc_mcu7t3v3__inv_2_1494/VNW
+ VSUBS gf180mcu_as_sc_mcu7t3v3__inv_2
Xgf180mcu_as_sc_mcu7t3v3__inv_2_1450 gf180mcu_as_sc_mcu7t3v3__inv_2_1452/VDD gf180mcu_as_sc_mcu7t3v3__inv_2_1455/VDD
+ VSS VSS gf180mcu_as_sc_mcu7t3v3__inv_2_1452/VNW VSUBS gf180mcu_as_sc_mcu7t3v3__inv_2
Xgf180mcu_as_sc_mcu7t3v3__inv_2_1461 VSS gf180mcu_as_sc_mcu7t3v3__inv_2_1511/VDD VSS
+ VSS gf180mcu_as_sc_mcu7t3v3__inv_2_1461/VNW VSUBS gf180mcu_as_sc_mcu7t3v3__inv_2
Xgf180mcu_as_sc_mcu7t3v3__inv_2_912 VSS VSS VSS VSS gf180mcu_as_sc_mcu7t3v3__inv_2_944/VNW
+ VSUBS gf180mcu_as_sc_mcu7t3v3__inv_2
Xgf180mcu_as_sc_mcu7t3v3__inv_2_945 VSS VSS VSS VSS gf180mcu_as_sc_mcu7t3v3__inv_2_945/VNW
+ VSUBS gf180mcu_as_sc_mcu7t3v3__inv_2
Xgf180mcu_as_sc_mcu7t3v3__inv_2_923 VSS VSS VSS VSS gf180mcu_as_sc_mcu7t3v3__inv_2_948/VNW
+ VSUBS gf180mcu_as_sc_mcu7t3v3__inv_2
Xgf180mcu_as_sc_mcu7t3v3__inv_2_901 VSS VSS VSS VSS gf180mcu_as_sc_mcu7t3v3__inv_2_956/VNW
+ VSUBS gf180mcu_as_sc_mcu7t3v3__inv_2
Xgf180mcu_as_sc_mcu7t3v3__inv_2_934 VSS VSS VSS VSS gf180mcu_as_sc_mcu7t3v3__inv_2_934/VNW
+ VSUBS gf180mcu_as_sc_mcu7t3v3__inv_2
Xu_t003_013 u_t003_013/c0_w0_bl u_t003_013/c0_w0_br u_t003_013/c0_w1_bl u_t003_013/c0_w1_br
+ u_t003_013/c0_r0_rbl u_t003_013/c0_r1_rbl u_t003_013/c1_w0_bl u_t003_013/c1_w0_br
+ u_t003_013/c1_w1_bl u_t003_013/c1_w1_br u_t003_013/c1_r0_rbl u_t003_013/c1_r1_rbl
+ u_t003_013/c2_w0_bl u_t003_013/c2_w0_br u_t003_013/c2_w1_bl u_t003_013/c2_w1_br
+ u_t003_013/c2_r0_rbl u_t003_013/c2_r1_rbl u_t003_013/c3_w0_bl u_t003_013/c3_w0_br
+ u_t003_013/c3_w1_bl u_t003_013/c3_w1_br u_t003_013/c3_r0_rbl u_t003_013/c3_r1_rbl
+ u_t003_013/r0_w0_wl u_t003_013/r0_w1_wl u_t003_013/r0_r0_rwl u_t003_013/r0_r1_rwl
+ u_t003_013/r1_w0_wl u_t003_013/r1_w1_wl u_t003_013/r1_r0_rwl u_t003_013/r1_r1_rwl
+ u_t003_013/r2_w0_wl u_t003_013/r2_w1_wl u_t003_013/r2_r0_rwl u_t003_013/r2_r1_rwl
+ u_t003_013/r3_w0_wl u_t003_013/r3_w1_wl u_t003_013/r3_r0_rwl u_t003_013/r3_r1_rwl
+ u_t004_013/VDD u_t003_013/VSS u_t003_013/m2_717_1265# u_t003_013/m2_603_2031# u_t003_013/m2_1290_336#
+ u_t003_013/m2_2000_2037# u_t003_013/m2_791_2909# u_t003_013/m2_7_2126# u_t003_013/m2_2154_2081#
+ u_t003_013/m2_1795_2037# u_t003_013/m2_871_303# u_t003_013/m2_431_438# u_t003_013/m2_1290_2898#
+ u_t003_013/m2_1714_1210# u_t003_013/m2_431_1982# u_t003_013/m2_512_1265# u_t003_013/m2_2573_2126#
+ u_t003_013/m2_603_1259# u_t003_013/m2_2074_2909# u_t003_013/m2_7_336# u_t003_013/m2_717_2037#
+ u_t003_013/m2_1886_2031# u_t003_013/m2_2573_336# u_t003_013/m2_7_2898# u_t003_013/m2_2000_1265#
+ u_t003_013/m2_512_2037# u_t003_013/m2_1795_1265# u_t003_013/m2_1714_1982# u_t003_013/m2_1886_1259#
+ u_t003_013/m2_1290_2126# u_t003_013/m2_1714_438# u_t003_013/m2_431_1210# u_t003_013/m2_2573_2898#
+ u_t003_013/m2_2154_303# u_t003_013/m2_871_2081# VSUBS detronyx_12t_2w2r_rc4_4x4_routed_5layer_direct
Xu_t003_002 u_t003_002/c0_w0_bl u_t003_002/c0_w0_br u_t003_002/c0_w1_bl u_t003_002/c0_w1_br
+ u_t003_002/c0_r0_rbl u_t003_002/c0_r1_rbl u_t003_002/c1_w0_bl u_t003_002/c1_w0_br
+ u_t003_002/c1_w1_bl u_t003_002/c1_w1_br u_t003_002/c1_r0_rbl u_t003_002/c1_r1_rbl
+ u_t003_002/c2_w0_bl u_t003_002/c2_w0_br u_t003_002/c2_w1_bl u_t003_002/c2_w1_br
+ u_t003_002/c2_r0_rbl u_t003_002/c2_r1_rbl u_t003_002/c3_w0_bl u_t003_002/c3_w0_br
+ u_t003_002/c3_w1_bl u_t003_002/c3_w1_br u_t003_002/c3_r0_rbl u_t003_002/c3_r1_rbl
+ u_t003_002/r0_w0_wl u_t003_002/r0_w1_wl u_t003_002/r0_r0_rwl u_t003_002/r0_r1_rwl
+ u_t003_002/r1_w0_wl u_t003_002/r1_w1_wl u_t003_002/r1_r0_rwl u_t003_002/r1_r1_rwl
+ u_t003_002/r2_w0_wl u_t003_002/r2_w1_wl u_t003_002/r2_r0_rwl u_t003_002/r2_r1_rwl
+ u_t003_002/r3_w0_wl u_t003_002/r3_w1_wl u_t003_002/r3_r0_rwl u_t003_002/r3_r1_rwl
+ VSS VSS u_t003_002/m2_717_1265# u_t003_002/m2_603_2031# u_t003_002/m2_1290_336#
+ u_t003_002/m2_2000_2037# u_t003_002/m2_791_2909# u_t003_002/m2_7_2126# u_t003_002/m2_2154_2081#
+ u_t003_002/m2_1795_2037# u_t003_002/m2_871_303# u_t003_002/m2_431_438# u_t003_002/m2_1290_2898#
+ u_t003_002/m2_1714_1210# u_t003_002/m2_431_1982# u_t003_002/m2_512_1265# u_t003_002/m2_2573_2126#
+ u_t003_002/m2_603_1259# u_t003_002/m2_2074_2909# u_t003_002/m2_7_336# u_t003_002/m2_717_2037#
+ u_t003_002/m2_1886_2031# u_t003_002/m2_2573_336# u_t003_002/m2_7_2898# u_t003_002/m2_2000_1265#
+ u_t003_002/m2_512_2037# u_t003_002/m2_1795_1265# u_t003_002/m2_1714_1982# u_t003_002/m2_1886_1259#
+ u_t003_002/m2_1290_2126# u_t003_002/m2_1714_438# u_t003_002/m2_431_1210# u_t003_002/m2_2573_2898#
+ u_t003_002/m2_2154_303# u_t003_002/m2_871_2081# VSUBS detronyx_12t_2w2r_rc4_4x4_routed_5layer_direct
Xgf180mcu_as_sc_mcu7t3v3__inv_2_956 VSS VSS VSS VSS gf180mcu_as_sc_mcu7t3v3__inv_2_956/VNW
+ VSUBS gf180mcu_as_sc_mcu7t3v3__inv_2
Xgf180mcu_as_sc_mcu7t3v3__inv_2_978 VSS gf180mcu_as_sc_mcu7t3v3__inv_2_984/VDD VSS
+ gf180mcu_as_sc_mcu7t3v3__inv_2_998/A gf180mcu_as_sc_mcu7t3v3__inv_2_980/VNW VSUBS
+ gf180mcu_as_sc_mcu7t3v3__inv_2
Xgf180mcu_as_sc_mcu7t3v3__inv_2_989 gf180mcu_as_sc_mcu7t3v3__inv_2_989/VDD gf180mcu_as_sc_mcu7t3v3__inv_2_989/VSS
+ VSS gf180mcu_as_sc_mcu7t3v3__inv_2_998/A gf180mcu_as_sc_mcu7t3v3__inv_2_989/VNW
+ VSUBS gf180mcu_as_sc_mcu7t3v3__inv_2
Xgf180mcu_as_sc_mcu7t3v3__inv_2_967 VSS VSS gf180mcu_as_sc_mcu7t3v3__inv_2_977/A gf180mcu_as_sc_mcu7t3v3__inv_2_968/Y
+ gf180mcu_as_sc_mcu7t3v3__inv_2_968/VNW VSUBS gf180mcu_as_sc_mcu7t3v3__inv_2
Xgf180mcu_as_sc_mcu7t3v3__nand4_2_266 VSS VSS VSS VSS VSS VSS gf180mcu_as_sc_mcu7t3v3__nand4_2_266/Y
+ gf180mcu_as_sc_mcu7t3v3__inv_2_949/VNW VSUBS gf180mcu_as_sc_mcu7t3v3__nand4_2
Xgf180mcu_as_sc_mcu7t3v3__nand4_2_277 VSS VSS VSS VSS VSS VSS VSS gf180mcu_as_sc_mcu7t3v3__inv_2_954/VNW
+ VSUBS gf180mcu_as_sc_mcu7t3v3__nand4_2
Xgf180mcu_as_sc_mcu7t3v3__nand4_2_200 VSS gf180mcu_as_sc_mcu7t3v3__inv_2_688/VDD VSS
+ VSS VSS VSS VSS gf180mcu_as_sc_mcu7t3v3__inv_2_684/VNW VSUBS gf180mcu_as_sc_mcu7t3v3__nand4_2
Xgf180mcu_as_sc_mcu7t3v3__nand4_2_222 VSS VSS VSS VSS VSS VSS gf180mcu_as_sc_mcu7t3v3__nand4_2_222/Y
+ gf180mcu_as_sc_mcu7t3v3__inv_2_822/VNW VSUBS gf180mcu_as_sc_mcu7t3v3__nand4_2
Xgf180mcu_as_sc_mcu7t3v3__nand4_2_211 gf180mcu_as_sc_mcu7t3v3__inv_2_689/VSS VSS VSS
+ VSS VSS VSS VSS gf180mcu_as_sc_mcu7t3v3__inv_2_661/VNW VSUBS gf180mcu_as_sc_mcu7t3v3__nand4_2
Xgf180mcu_as_sc_mcu7t3v3__nand4_2_233 VSS VSS VSS VSS VSS VSS VSS gf180mcu_as_sc_mcu7t3v3__inv_2_816/VNW
+ VSUBS gf180mcu_as_sc_mcu7t3v3__nand4_2
Xgf180mcu_as_sc_mcu7t3v3__nand4_2_244 VSS VSS VSS VSS VSS VSS VSS gf180mcu_as_sc_mcu7t3v3__inv_2_840/VNW
+ VSUBS gf180mcu_as_sc_mcu7t3v3__nand4_2
Xgf180mcu_as_sc_mcu7t3v3__nand4_2_288 gf180mcu_as_sc_mcu7t3v3__inv_2_989/VSS VSS VSS
+ VSS VSS VSS VSS gf180mcu_as_sc_mcu7t3v3__inv_2_976/VNW VSUBS gf180mcu_as_sc_mcu7t3v3__nand4_2
Xgf180mcu_as_sc_mcu7t3v3__nand4_2_299 VSS gf180mcu_as_sc_mcu7t3v3__inv_2_985/VDD VSS
+ VSS VSS VSS VSS gf180mcu_as_sc_mcu7t3v3__inv_2_972/VNW VSUBS gf180mcu_as_sc_mcu7t3v3__nand4_2
Xgf180mcu_as_sc_mcu7t3v3__nand4_2_255 VSS VSS VSS VSS VSS VSS gf180mcu_as_sc_mcu7t3v3__nand4_2_255/Y
+ gf180mcu_as_sc_mcu7t3v3__inv_2_943/VNW VSUBS gf180mcu_as_sc_mcu7t3v3__nand4_2
Xgf180mcu_as_sc_mcu7t3v3__inv_2_219 VSS VSS gf180mcu_as_sc_mcu7t3v3__inv_2_219/Y VSS
+ gf180mcu_as_sc_mcu7t3v3__inv_2_221/VNW VSUBS gf180mcu_as_sc_mcu7t3v3__inv_2
Xgf180mcu_as_sc_mcu7t3v3__inv_2_208 gf180mcu_as_sc_mcu7t3v3__inv_2_257/VSS VSS gf180mcu_as_sc_mcu7t3v3__inv_2_208/Y
+ VSS gf180mcu_as_sc_mcu7t3v3__inv_2_209/VNW VSUBS gf180mcu_as_sc_mcu7t3v3__inv_2
Xu_t000_005 u_t000_005/c0_w0_bl u_t000_005/c0_w0_br u_t000_005/c0_w1_bl u_t000_005/c0_w1_br
+ u_t000_005/c0_r0_rbl u_t000_005/c0_r1_rbl u_t000_005/c1_w0_bl u_t000_005/c1_w0_br
+ u_t000_005/c1_w1_bl u_t000_005/c1_w1_br u_t000_005/c1_r0_rbl u_t000_005/c1_r1_rbl
+ u_t000_005/c2_w0_bl u_t000_005/c2_w0_br u_t000_005/c2_w1_bl u_t000_005/c2_w1_br
+ u_t000_005/c2_r0_rbl u_t000_005/c2_r1_rbl u_t000_005/c3_w0_bl u_t000_005/c3_w0_br
+ u_t000_005/c3_w1_bl u_t000_005/c3_w1_br u_t000_005/c3_r0_rbl u_t000_005/c3_r1_rbl
+ u_t000_005/r0_w0_wl u_t000_005/r0_w1_wl u_t000_005/r0_r0_rwl u_t000_005/r0_r1_rwl
+ u_t000_005/r1_w0_wl u_t000_005/r1_w1_wl u_t000_005/r1_r0_rwl u_t000_005/r1_r1_rwl
+ u_t000_005/r2_w0_wl u_t000_005/r2_w1_wl u_t000_005/r2_r0_rwl u_t000_005/r2_r1_rwl
+ u_t000_005/r3_w0_wl u_t000_005/r3_w1_wl u_t000_005/r3_r0_rwl u_t000_005/r3_r1_rwl
+ u_t000_005/VDD VSS u_t000_005/m2_717_1265# u_t000_005/m2_603_2031# u_t000_005/m2_1290_336#
+ u_t000_005/m2_2000_2037# u_t000_005/m2_791_2909# u_t000_005/m2_7_2126# u_t000_005/m2_2154_2081#
+ u_t000_005/m2_1795_2037# u_t000_005/m2_871_303# u_t000_005/m2_431_438# u_t000_005/m2_1290_2898#
+ u_t000_005/m2_1714_1210# u_t000_005/m2_431_1982# u_t000_005/m2_512_1265# u_t000_005/m2_2573_2126#
+ u_t000_005/m2_603_1259# u_t000_005/m2_2074_2909# u_t000_005/m2_7_336# u_t000_005/m2_717_2037#
+ u_t000_005/m2_1886_2031# u_t000_005/m2_2573_336# u_t000_005/m2_7_2898# u_t000_005/m2_2000_1265#
+ u_t000_005/m2_512_2037# u_t000_005/m2_1795_1265# u_t000_005/m2_1714_1982# u_t000_005/m2_1886_1259#
+ u_t000_005/m2_1290_2126# u_t000_005/m2_1714_438# u_t000_005/m2_431_1210# u_t000_005/m2_2573_2898#
+ u_t000_005/m2_2154_303# u_t000_005/m2_871_2081# VSUBS detronyx_12t_2w2r_rc4_4x4_routed_5layer_direct
Xgf180mcu_as_sc_mcu7t3v3__inv_2_1280 VSS VSS VSS VSS gf180mcu_as_sc_mcu7t3v3__inv_2_1280/VNW
+ VSUBS gf180mcu_as_sc_mcu7t3v3__inv_2
Xgf180mcu_as_sc_mcu7t3v3__inv_2_1291 VSS VSS VSS VSS gf180mcu_as_sc_mcu7t3v3__inv_2_1291/VNW
+ VSUBS gf180mcu_as_sc_mcu7t3v3__inv_2
Xgf180mcu_as_sc_mcu7t3v3__inv_2_775 VSS VSS gf180mcu_as_sc_mcu7t3v3__inv_2_775/Y VSS
+ gf180mcu_as_sc_mcu7t3v3__inv_2_826/VNW VSUBS gf180mcu_as_sc_mcu7t3v3__inv_2
Xgf180mcu_as_sc_mcu7t3v3__inv_2_764 VSS VSS gf180mcu_as_sc_mcu7t3v3__inv_2_764/Y VSS
+ gf180mcu_as_sc_mcu7t3v3__inv_2_822/VNW VSUBS gf180mcu_as_sc_mcu7t3v3__inv_2
Xgf180mcu_as_sc_mcu7t3v3__inv_2_753 VSS VSS VSS VSS gf180mcu_as_sc_mcu7t3v3__inv_2_831/VNW
+ VSUBS gf180mcu_as_sc_mcu7t3v3__inv_2
Xgf180mcu_as_sc_mcu7t3v3__inv_2_720 VSS VSS gf180mcu_as_sc_mcu7t3v3__inv_2_720/Y VSS
+ gf180mcu_as_sc_mcu7t3v3__inv_2_720/VNW VSUBS gf180mcu_as_sc_mcu7t3v3__inv_2
Xgf180mcu_as_sc_mcu7t3v3__inv_2_786 VSS VSS VSS VSS gf180mcu_as_sc_mcu7t3v3__inv_2_816/VNW
+ VSUBS gf180mcu_as_sc_mcu7t3v3__inv_2
Xgf180mcu_as_sc_mcu7t3v3__inv_2_797 VSS VSS VSS VSS gf180mcu_as_sc_mcu7t3v3__inv_2_846/VNW
+ VSUBS gf180mcu_as_sc_mcu7t3v3__inv_2
Xgf180mcu_as_sc_mcu7t3v3__inv_2_731 gf180mcu_as_sc_mcu7t3v3__inv_2_731/VDD gf180mcu_as_sc_mcu7t3v3__inv_2_741/VDD
+ gf180mcu_as_sc_mcu7t3v3__inv_2_731/Y VSS gf180mcu_as_sc_mcu7t3v3__inv_2_731/VNW
+ VSUBS gf180mcu_as_sc_mcu7t3v3__inv_2
Xgf180mcu_as_sc_mcu7t3v3__inv_2_742 gf180mcu_as_sc_mcu7t3v3__inv_2_743/VDD gf180mcu_as_sc_mcu7t3v3__inv_2_743/VSS
+ gf180mcu_as_sc_mcu7t3v3__inv_2_742/Y gf180mcu_as_sc_mcu7t3v3__inv_2_742/A gf180mcu_as_sc_mcu7t3v3__inv_2_743/VNW
+ VSUBS gf180mcu_as_sc_mcu7t3v3__inv_2
Xgf180mcu_as_sc_mcu7t3v3__nand4_2_0 VSS gf180mcu_as_sc_mcu7t3v3__inv_2_99/VSS VSS
+ VSS VSS VSS gf180mcu_as_sc_mcu7t3v3__nand4_2_0/Y gf180mcu_as_sc_mcu7t3v3__inv_2_99/VNW
+ VSUBS gf180mcu_as_sc_mcu7t3v3__nand4_2
Xgf180mcu_as_sc_mcu7t3v3__inv_2_550 VSS VSS VSS VSS gf180mcu_as_sc_mcu7t3v3__inv_2_550/VNW
+ VSUBS gf180mcu_as_sc_mcu7t3v3__inv_2
Xgf180mcu_as_sc_mcu7t3v3__inv_2_572 gf180mcu_as_sc_mcu7t3v3__inv_2_576/VDD gf180mcu_as_sc_mcu7t3v3__inv_2_576/VDD
+ VSS gf180mcu_as_sc_mcu7t3v3__inv_2_573/Y gf180mcu_as_sc_mcu7t3v3__inv_2_573/VNW
+ VSUBS gf180mcu_as_sc_mcu7t3v3__inv_2
Xgf180mcu_as_sc_mcu7t3v3__inv_2_583 gf180mcu_as_sc_mcu7t3v3__inv_2_584/VDD VSS VSS
+ gf180mcu_as_sc_mcu7t3v3__inv_2_584/Y gf180mcu_as_sc_mcu7t3v3__inv_2_584/VNW VSUBS
+ gf180mcu_as_sc_mcu7t3v3__inv_2
Xgf180mcu_as_sc_mcu7t3v3__inv_2_594 gf180mcu_as_sc_mcu7t3v3__inv_2_638/VSS gf180mcu_as_sc_mcu7t3v3__inv_2_638/VSS
+ gf180mcu_as_sc_mcu7t3v3__inv_2_594/Y VSS gf180mcu_as_sc_mcu7t3v3__inv_2_638/VNW
+ VSUBS gf180mcu_as_sc_mcu7t3v3__inv_2
Xgf180mcu_as_sc_mcu7t3v3__inv_2_561 VSS VSS VSS VSS gf180mcu_as_sc_mcu7t3v3__inv_2_561/VNW
+ VSUBS gf180mcu_as_sc_mcu7t3v3__inv_2
Xgf180mcu_as_sc_mcu7t3v3__nor2_2_9 gf180mcu_as_sc_mcu7t3v3__nor2_2_9/VDD gf180mcu_as_sc_mcu7t3v3__nor2_2_9/VSS
+ VSS VSS VSS gf180mcu_as_sc_mcu7t3v3__nor2_2_9/VNW VSUBS gf180mcu_as_sc_mcu7t3v3__nor2_2
Xu_t028_008 u_t028_008/c0_w0_bl u_t028_008/c0_w0_br u_t028_008/c0_w1_bl u_t028_008/c0_w1_br
+ u_t028_008/c0_r0_rbl u_t028_008/c0_r1_rbl u_t028_008/c1_w0_bl u_t028_008/c1_w0_br
+ u_t028_008/c1_w1_bl u_t028_008/c1_w1_br u_t028_008/c1_r0_rbl u_t028_008/c1_r1_rbl
+ u_t028_008/c2_w0_bl u_t028_008/c2_w0_br u_t028_008/c2_w1_bl u_t028_008/c2_w1_br
+ u_t028_008/c2_r0_rbl u_t028_008/c2_r1_rbl u_t028_008/c3_w0_bl u_t028_008/c3_w0_br
+ u_t028_008/c3_w1_bl u_t028_008/c3_w1_br u_t028_008/c3_r0_rbl u_t028_008/c3_r1_rbl
+ u_t028_008/r0_w0_wl u_t028_008/r0_w1_wl u_t028_008/r0_r0_rwl u_t028_008/r0_r1_rwl
+ u_t028_008/r1_w0_wl u_t028_008/r1_w1_wl u_t028_008/r1_r0_rwl u_t028_008/r1_r1_rwl
+ u_t028_008/r2_w0_wl u_t028_008/r2_w1_wl u_t028_008/r2_r0_rwl u_t028_008/r2_r1_rwl
+ u_t028_008/r3_w0_wl u_t028_008/r3_w1_wl u_t028_008/r3_r0_rwl u_t028_008/r3_r1_rwl
+ VSS u_t028_009/VSS u_t028_008/m2_717_1265# u_t028_008/m2_603_2031# u_t028_008/m2_1290_336#
+ u_t028_008/m2_2000_2037# u_t028_008/m2_791_2909# u_t028_008/m2_7_2126# u_t028_008/m2_2154_2081#
+ u_t028_008/m2_1795_2037# u_t028_008/m2_871_303# u_t028_008/m2_431_438# u_t028_008/m2_1290_2898#
+ u_t028_008/m2_1714_1210# u_t028_008/m2_431_1982# u_t028_008/m2_512_1265# u_t028_008/m2_2573_2126#
+ u_t028_008/m2_603_1259# u_t028_008/m2_2074_2909# u_t028_008/m2_7_336# u_t028_008/m2_717_2037#
+ u_t028_008/m2_1886_2031# u_t028_008/m2_2573_336# u_t028_008/m2_7_2898# u_t028_008/m2_2000_1265#
+ u_t028_008/m2_512_2037# u_t028_008/m2_1795_1265# u_t028_008/m2_1714_1982# u_t028_008/m2_1886_1259#
+ u_t028_008/m2_1290_2126# u_t028_008/m2_1714_438# u_t028_008/m2_431_1210# u_t028_008/m2_2573_2898#
+ u_t028_008/m2_2154_303# u_t028_008/m2_871_2081# VSUBS detronyx_12t_2w2r_rc4_4x4_routed_5layer_direct
Xgf180mcu_as_sc_mcu7t3v3__inv_2_391 gf180mcu_as_sc_mcu7t3v3__nor2_2_6/VDD gf180mcu_as_sc_mcu7t3v3__nor2_2_6/VSS
+ VSS VSS gf180mcu_as_sc_mcu7t3v3__nor2_2_6/VNW VSUBS gf180mcu_as_sc_mcu7t3v3__inv_2
Xgf180mcu_as_sc_mcu7t3v3__inv_2_380 gf180mcu_as_sc_mcu7t3v3__nor2_2_6/VDD gf180mcu_as_sc_mcu7t3v3__nand3_2_4/VSS
+ VSS VSS gf180mcu_as_sc_mcu7t3v3__nor2_2_6/VNW VSUBS gf180mcu_as_sc_mcu7t3v3__inv_2
Xu_t019_008 u_t019_008/c0_w0_bl u_t019_008/c0_w0_br u_t019_008/c0_w1_bl u_t019_008/c0_w1_br
+ u_t019_008/c0_r0_rbl u_t019_008/c0_r1_rbl u_t019_008/c1_w0_bl u_t019_008/c1_w0_br
+ u_t019_008/c1_w1_bl u_t019_008/c1_w1_br u_t019_008/c1_r0_rbl u_t019_008/c1_r1_rbl
+ u_t019_008/c2_w0_bl u_t019_008/c2_w0_br u_t019_008/c2_w1_bl u_t019_008/c2_w1_br
+ u_t019_008/c2_r0_rbl u_t019_008/c2_r1_rbl u_t019_008/c3_w0_bl u_t019_008/c3_w0_br
+ u_t019_008/c3_w1_bl u_t019_008/c3_w1_br u_t019_008/c3_r0_rbl u_t019_008/c3_r1_rbl
+ u_t019_008/r0_w0_wl u_t019_008/r0_w1_wl u_t019_008/r0_r0_rwl u_t019_008/r0_r1_rwl
+ u_t019_008/r1_w0_wl u_t019_008/r1_w1_wl u_t019_008/r1_r0_rwl u_t019_008/r1_r1_rwl
+ u_t019_008/r2_w0_wl u_t019_008/r2_w1_wl u_t019_008/r2_r0_rwl u_t019_008/r2_r1_rwl
+ u_t019_008/r3_w0_wl u_t019_008/r3_w1_wl u_t019_008/r3_r0_rwl u_t019_008/r3_r1_rwl
+ VSS u_t019_009/VSS u_t019_008/m2_717_1265# u_t019_008/m2_603_2031# u_t019_008/m2_1290_336#
+ u_t019_008/m2_2000_2037# u_t019_008/m2_791_2909# u_t019_008/m2_7_2126# u_t019_008/m2_2154_2081#
+ u_t019_008/m2_1795_2037# u_t019_008/m2_871_303# u_t019_008/m2_431_438# u_t019_008/m2_1290_2898#
+ u_t019_008/m2_1714_1210# u_t019_008/m2_431_1982# u_t019_008/m2_512_1265# u_t019_008/m2_2573_2126#
+ u_t019_008/m2_603_1259# u_t019_008/m2_2074_2909# u_t019_008/m2_7_336# u_t019_008/m2_717_2037#
+ u_t019_008/m2_1886_2031# u_t019_008/m2_2573_336# u_t019_008/m2_7_2898# u_t019_008/m2_2000_1265#
+ u_t019_008/m2_512_2037# u_t019_008/m2_1795_1265# u_t019_008/m2_1714_1982# u_t019_008/m2_1886_1259#
+ u_t019_008/m2_1290_2126# u_t019_008/m2_1714_438# u_t019_008/m2_431_1210# u_t019_008/m2_2573_2898#
+ u_t019_008/m2_2154_303# u_t019_008/m2_871_2081# VSUBS detronyx_12t_2w2r_rc4_4x4_routed_5layer_direct
Xgf180mcu_as_sc_mcu7t3v3__inv_2_1109 VSS gf180mcu_as_sc_mcu7t3v3__inv_2_1111/VSS VSS
+ gf180mcu_as_sc_mcu7t3v3__inv_2_1109/A gf180mcu_as_sc_mcu7t3v3__inv_2_1111/VNW VSUBS
+ gf180mcu_as_sc_mcu7t3v3__inv_2
Xgf180mcu_as_sc_mcu7t3v3__nand3_2_12 gf180mcu_as_sc_mcu7t3v3__nor2_2_4/VDD gf180mcu_as_sc_mcu7t3v3__nand2_2_3/VSS
+ VSS VSS VSS VSS gf180mcu_as_sc_mcu7t3v3__nor2_2_4/VNW VSUBS gf180mcu_as_sc_mcu7t3v3__nand3_2
Xu_t024_011 u_t024_011/c0_w0_bl u_t024_011/c0_w0_br u_t024_011/c0_w1_bl u_t024_011/c0_w1_br
+ u_t024_011/c0_r0_rbl u_t024_011/c0_r1_rbl u_t024_011/c1_w0_bl u_t024_011/c1_w0_br
+ u_t024_011/c1_w1_bl u_t024_011/c1_w1_br u_t024_011/c1_r0_rbl u_t024_011/c1_r1_rbl
+ u_t024_011/c2_w0_bl u_t024_011/c2_w0_br u_t024_011/c2_w1_bl u_t024_011/c2_w1_br
+ u_t024_011/c2_r0_rbl u_t024_011/c2_r1_rbl u_t024_011/c3_w0_bl u_t024_011/c3_w0_br
+ u_t024_011/c3_w1_bl u_t024_011/c3_w1_br u_t024_011/c3_r0_rbl u_t024_011/c3_r1_rbl
+ u_t024_011/r0_w0_wl u_t024_011/r0_w1_wl u_t024_011/r0_r0_rwl u_t024_011/r0_r1_rwl
+ u_t024_011/r1_w0_wl u_t024_011/r1_w1_wl u_t024_011/r1_r0_rwl u_t024_011/r1_r1_rwl
+ u_t024_011/r2_w0_wl u_t024_011/r2_w1_wl u_t024_011/r2_r0_rwl u_t024_011/r2_r1_rwl
+ u_t024_011/r3_w0_wl u_t024_011/r3_w1_wl u_t024_011/r3_r0_rwl u_t024_011/r3_r1_rwl
+ u_t025_011/VDD u_t024_011/VSS u_t024_011/m2_717_1265# u_t024_011/m2_603_2031# u_t024_011/m2_1290_336#
+ u_t024_011/m2_2000_2037# u_t024_011/m2_791_2909# u_t024_011/m2_7_2126# u_t024_011/m2_2154_2081#
+ u_t024_011/m2_1795_2037# u_t024_011/m2_871_303# u_t024_011/m2_431_438# u_t024_011/m2_1290_2898#
+ u_t024_011/m2_1714_1210# u_t024_011/m2_431_1982# u_t024_011/m2_512_1265# u_t024_011/m2_2573_2126#
+ u_t024_011/m2_603_1259# u_t024_011/m2_2074_2909# u_t024_011/m2_7_336# u_t024_011/m2_717_2037#
+ u_t024_011/m2_1886_2031# u_t024_011/m2_2573_336# u_t024_011/m2_7_2898# u_t024_011/m2_2000_1265#
+ u_t024_011/m2_512_2037# u_t024_011/m2_1795_1265# u_t024_011/m2_1714_1982# u_t024_011/m2_1886_1259#
+ u_t024_011/m2_1290_2126# u_t024_011/m2_1714_438# u_t024_011/m2_431_1210# u_t024_011/m2_2573_2898#
+ u_t024_011/m2_2154_303# u_t024_011/m2_871_2081# VSUBS detronyx_12t_2w2r_rc4_4x4_routed_5layer_direct
Xgf180mcu_as_sc_mcu7t3v3__nand3_2_56 gf180mcu_as_sc_mcu7t3v3__nand3_2_65/VDD gf180mcu_as_sc_mcu7t3v3__nor2_2_9/VSS
+ VSS VSS VSS VSS gf180mcu_as_sc_mcu7t3v3__nand3_2_65/VNW VSUBS gf180mcu_as_sc_mcu7t3v3__nand3_2
Xgf180mcu_as_sc_mcu7t3v3__nand3_2_45 gf180mcu_as_sc_mcu7t3v3__nor2_2_9/VDD gf180mcu_as_sc_mcu7t3v3__nand3_2_63/VSS
+ VSS VSS VSS VSS gf180mcu_as_sc_mcu7t3v3__nor2_2_9/VNW VSUBS gf180mcu_as_sc_mcu7t3v3__nand3_2
Xu_t024_000 VSS u_t024_000/c0_w0_br VSS u_t024_000/c0_w1_br u_t024_000/c0_r0_rbl u_t024_000/c0_r1_rbl
+ VSS VSS VSS VSS VSS VSS u_t024_000/c2_w0_bl u_t024_000/c2_w0_br u_t024_000/c2_w1_bl
+ u_t024_000/c2_w1_br u_t024_000/c2_r0_rbl u_t024_000/c2_r1_rbl u_t024_000/c3_w0_bl
+ u_t024_000/c3_w0_br u_t024_000/c3_w1_bl u_t024_000/c3_w1_br u_t024_000/c3_r0_rbl
+ u_t024_000/c3_r1_rbl VSS VSS VSS VSS VSS VSS VSS VSS VSS VSS VSS VSS VSS VSS VSS
+ VSS VSS VSS u_t024_000/m2_717_1265# VSS VSS VSS VSS VSS VSS VSS VSS VSS VSS VSS
+ VSS u_t024_000/m2_512_1265# u_t024_000/m2_2573_2126# VSS VSS VSS VSS VSS u_t024_000/m2_2573_336#
+ VSS u_t024_000/m2_2000_1265# VSS u_t024_000/m2_1795_1265# VSS VSS VSS VSS VSS u_t024_000/m2_2573_2898#
+ VSS VSS VSUBS detronyx_12t_2w2r_rc4_4x4_routed_5layer_direct
Xgf180mcu_as_sc_mcu7t3v3__nand3_2_23 gf180mcu_as_sc_mcu7t3v3__nand3_2_9/VDD gf180mcu_as_sc_mcu7t3v3__nor2_2_4/VSS
+ VSS VSS VSS VSS gf180mcu_as_sc_mcu7t3v3__nand3_2_9/VNW VSUBS gf180mcu_as_sc_mcu7t3v3__nand3_2
Xgf180mcu_as_sc_mcu7t3v3__nand3_2_34 gf180mcu_as_sc_mcu7t3v3__nor2_2_7/VDD gf180mcu_as_sc_mcu7t3v3__nor2_2_7/VSS
+ VSS VSS VSS VSS gf180mcu_as_sc_mcu7t3v3__nor2_2_7/VNW VSUBS gf180mcu_as_sc_mcu7t3v3__nand3_2
Xgf180mcu_as_sc_mcu7t3v3__inv_2_1632 gf180mcu_as_sc_mcu7t3v3__inv_2_1634/VDD gf180mcu_as_sc_mcu7t3v3__inv_2_1638/VDD
+ VSS gf180mcu_as_sc_mcu7t3v3__inv_2_1689/A gf180mcu_as_sc_mcu7t3v3__inv_2_1634/VNW
+ VSUBS gf180mcu_as_sc_mcu7t3v3__inv_2
Xgf180mcu_as_sc_mcu7t3v3__inv_2_1665 gf180mcu_as_sc_mcu7t3v3__inv_2_1665/VDD VSS gf180mcu_as_sc_mcu7t3v3__inv_2_1689/A
+ VSS gf180mcu_as_sc_mcu7t3v3__inv_2_1665/VNW VSUBS gf180mcu_as_sc_mcu7t3v3__inv_2
Xgf180mcu_as_sc_mcu7t3v3__inv_2_1643 VSS gf180mcu_as_sc_mcu7t3v3__inv_2_1685/VDD gf180mcu_as_sc_mcu7t3v3__inv_2_1643/Y
+ gf180mcu_as_sc_mcu7t3v3__inv_2_1685/A gf180mcu_as_sc_mcu7t3v3__inv_2_1653/VNW VSUBS
+ gf180mcu_as_sc_mcu7t3v3__inv_2
Xgf180mcu_as_sc_mcu7t3v3__inv_2_1621 VSS gf180mcu_as_sc_mcu7t3v3__inv_2_1626/VDD gf180mcu_as_sc_mcu7t3v3__inv_2_1621/Y
+ gf180mcu_as_sc_mcu7t3v3__inv_2_1669/A gf180mcu_as_sc_mcu7t3v3__inv_2_1622/VNW VSUBS
+ gf180mcu_as_sc_mcu7t3v3__inv_2
Xgf180mcu_as_sc_mcu7t3v3__inv_2_1654 gf180mcu_as_sc_mcu7t3v3__inv_2_1656/VDD gf180mcu_as_sc_mcu7t3v3__inv_2_1660/VDD
+ VSS gf180mcu_as_sc_mcu7t3v3__inv_2_1669/A gf180mcu_as_sc_mcu7t3v3__inv_2_1656/VNW
+ VSUBS gf180mcu_as_sc_mcu7t3v3__inv_2
Xgf180mcu_as_sc_mcu7t3v3__inv_2_1676 VSS VSS gf180mcu_as_sc_mcu7t3v3__inv_2_1684/Y
+ VSS gf180mcu_as_sc_mcu7t3v3__inv_2_1676/VNW VSUBS gf180mcu_as_sc_mcu7t3v3__inv_2
Xgf180mcu_as_sc_mcu7t3v3__inv_2_1687 VSS VSS gf180mcu_as_sc_mcu7t3v3__inv_2_1694/Y
+ gf180mcu_as_sc_mcu7t3v3__inv_2_1694/Y gf180mcu_as_sc_mcu7t3v3__inv_2_1688/VNW VSUBS
+ gf180mcu_as_sc_mcu7t3v3__inv_2
Xgf180mcu_as_sc_mcu7t3v3__inv_2_1610 gf180mcu_as_sc_mcu7t3v3__inv_2_1691/VSS gf180mcu_as_sc_mcu7t3v3__inv_2_1694/VDD
+ gf180mcu_as_sc_mcu7t3v3__inv_2_1694/Y VSS gf180mcu_as_sc_mcu7t3v3__inv_2_1610/VNW
+ VSUBS gf180mcu_as_sc_mcu7t3v3__inv_2
Xgf180mcu_as_sc_mcu7t3v3__inv_2_1698 gf180mcu_as_sc_mcu7t3v3__nand3_2_9/VDD gf180mcu_as_sc_mcu7t3v3__nor2_2_7/VSS
+ VSS VSS gf180mcu_as_sc_mcu7t3v3__nand3_2_9/VNW VSUBS gf180mcu_as_sc_mcu7t3v3__inv_2
Xu_t015_011 u_t015_011/c0_w0_bl u_t015_011/c0_w0_br u_t015_011/c0_w1_bl u_t015_011/c0_w1_br
+ u_t015_011/c0_r0_rbl u_t015_011/c0_r1_rbl u_t015_011/c1_w0_bl u_t015_011/c1_w0_br
+ u_t015_011/c1_w1_bl u_t015_011/c1_w1_br u_t015_011/c1_r0_rbl u_t015_011/c1_r1_rbl
+ u_t015_011/c2_w0_bl u_t015_011/c2_w0_br u_t015_011/c2_w1_bl u_t015_011/c2_w1_br
+ u_t015_011/c2_r0_rbl u_t015_011/c2_r1_rbl u_t015_011/c3_w0_bl u_t015_011/c3_w0_br
+ u_t015_011/c3_w1_bl u_t015_011/c3_w1_br u_t015_011/c3_r0_rbl u_t015_011/c3_r1_rbl
+ u_t015_011/r0_w0_wl u_t015_011/r0_w1_wl u_t015_011/r0_r0_rwl u_t015_011/r0_r1_rwl
+ u_t015_011/r1_w0_wl u_t015_011/r1_w1_wl u_t015_011/r1_r0_rwl u_t015_011/r1_r1_rwl
+ u_t015_011/r2_w0_wl u_t015_011/r2_w1_wl u_t015_011/r2_r0_rwl u_t015_011/r2_r1_rwl
+ u_t015_011/r3_w0_wl u_t015_011/r3_w1_wl u_t015_011/r3_r0_rwl u_t015_011/r3_r1_rwl
+ u_t015_011/VDD u_t015_011/VSS u_t015_011/m2_717_1265# u_t015_011/m2_603_2031# u_t015_011/m2_1290_336#
+ u_t015_011/m2_2000_2037# u_t015_011/m2_791_2909# u_t015_011/m2_7_2126# u_t015_011/m2_2154_2081#
+ u_t015_011/m2_1795_2037# u_t015_011/m2_871_303# u_t015_011/m2_431_438# u_t015_011/m2_1290_2898#
+ u_t015_011/m2_1714_1210# u_t015_011/m2_431_1982# u_t015_011/m2_512_1265# u_t015_011/m2_2573_2126#
+ u_t015_011/m2_603_1259# u_t015_011/m2_2074_2909# u_t015_011/m2_7_336# u_t015_011/m2_717_2037#
+ u_t015_011/m2_1886_2031# u_t015_011/m2_2573_336# u_t015_011/m2_7_2898# u_t015_011/m2_2000_1265#
+ u_t015_011/m2_512_2037# u_t015_011/m2_1795_1265# u_t015_011/m2_1714_1982# u_t015_011/m2_1886_1259#
+ u_t015_011/m2_1290_2126# u_t015_011/m2_1714_438# u_t015_011/m2_431_1210# u_t015_011/m2_2573_2898#
+ u_t015_011/m2_2154_303# u_t015_011/m2_871_2081# VSUBS detronyx_12t_2w2r_rc4_4x4_routed_5layer_direct
Xu_t015_000 VSS u_t015_000/c0_w0_br VSS u_t015_000/c0_w1_br u_t015_000/c0_r0_rbl u_t015_000/c0_r1_rbl
+ VSS VSS VSS VSS VSS VSS u_t015_000/c2_w0_bl u_t015_000/c2_w0_br u_t015_000/c2_w1_bl
+ u_t015_000/c2_w1_br u_t015_000/c2_r0_rbl u_t015_000/c2_r1_rbl u_t015_000/c3_w0_bl
+ u_t015_000/c3_w0_br u_t015_000/c3_w1_bl u_t015_000/c3_w1_br u_t015_000/c3_r0_rbl
+ u_t015_000/c3_r1_rbl VSS VSS VSS VSS VSS VSS VSS VSS VSS VSS VSS VSS VSS VSS VSS
+ VSS VSS VSS u_t015_000/m2_717_1265# u_t015_000/m2_603_2031# u_t015_000/m2_1290_336#
+ u_t015_000/m2_2000_2037# u_t015_000/m2_791_2909# u_t015_000/m2_7_2126# u_t015_000/m2_2154_2081#
+ u_t015_000/m2_1795_2037# u_t015_000/m2_871_303# u_t015_000/m2_431_438# u_t015_000/m2_1290_2898#
+ u_t015_000/m2_1714_1210# u_t015_000/m2_431_1982# u_t015_000/m2_512_1265# u_t015_000/m2_2573_2126#
+ u_t015_000/m2_603_1259# u_t015_000/m2_2074_2909# u_t015_000/m2_7_336# u_t015_000/m2_717_2037#
+ u_t015_000/m2_1886_2031# u_t015_000/m2_2573_336# u_t015_000/m2_7_2898# u_t015_000/m2_2000_1265#
+ u_t015_000/m2_512_2037# u_t015_000/m2_1795_1265# u_t015_000/m2_1714_1982# u_t015_000/m2_1886_1259#
+ u_t015_000/m2_1290_2126# u_t015_000/m2_1714_438# u_t015_000/m2_431_1210# u_t015_000/m2_2573_2898#
+ u_t015_000/m2_2154_303# u_t015_000/m2_871_2081# VSUBS detronyx_12t_2w2r_rc4_4x4_routed_5layer_direct
Xu_t030_014 u_t030_014/c0_w0_bl u_t030_014/c0_w0_br u_t030_014/c0_w1_bl u_t030_014/c0_w1_br
+ u_t030_014/c0_r0_rbl u_t030_014/c0_r1_rbl u_t030_014/c1_w0_bl u_t030_014/c1_w0_br
+ u_t030_014/c1_w1_bl u_t030_014/c1_w1_br u_t030_014/c1_r0_rbl u_t030_014/c1_r1_rbl
+ u_t030_014/c2_w0_bl u_t030_014/c2_w0_br u_t030_014/c2_w1_bl u_t030_014/c2_w1_br
+ u_t030_014/c2_r0_rbl u_t030_014/c2_r1_rbl u_t030_014/c3_w0_bl u_t030_014/c3_w0_br
+ u_t030_014/c3_w1_bl u_t030_014/c3_w1_br u_t030_014/c3_r0_rbl u_t030_014/c3_r1_rbl
+ u_t030_014/r0_w0_wl u_t030_014/r0_w1_wl u_t030_014/r0_r0_rwl u_t030_014/r0_r1_rwl
+ u_t030_014/r1_w0_wl u_t030_014/r1_w1_wl u_t030_014/r1_r0_rwl u_t030_014/r1_r1_rwl
+ u_t030_014/r2_w0_wl u_t030_014/r2_w1_wl u_t030_014/r2_r0_rwl u_t030_014/r2_r1_rwl
+ u_t030_014/r3_w0_wl u_t030_014/r3_w1_wl u_t030_014/r3_r0_rwl u_t030_014/r3_r1_rwl
+ u_t030_014/VDD VSS u_t030_014/m2_717_1265# u_t030_014/m2_603_2031# u_t030_014/m2_1290_336#
+ u_t030_014/m2_2000_2037# u_t030_014/m2_791_2909# u_t030_014/m2_7_2126# u_t030_014/m2_2154_2081#
+ u_t030_014/m2_1795_2037# u_t030_014/m2_871_303# u_t030_014/m2_431_438# u_t030_014/m2_1290_2898#
+ u_t030_014/m2_1714_1210# u_t030_014/m2_431_1982# u_t030_014/m2_512_1265# u_t030_014/m2_2573_2126#
+ u_t030_014/m2_603_1259# u_t030_014/m2_2074_2909# u_t030_014/m2_7_336# u_t030_014/m2_717_2037#
+ u_t030_014/m2_1886_2031# u_t030_014/m2_2573_336# u_t030_014/m2_7_2898# u_t030_014/m2_2000_1265#
+ u_t030_014/m2_512_2037# u_t030_014/m2_1795_1265# u_t030_014/m2_1714_1982# u_t030_014/m2_1886_1259#
+ u_t030_014/m2_1290_2126# u_t030_014/m2_1714_438# u_t030_014/m2_431_1210# u_t030_014/m2_2573_2898#
+ u_t030_014/m2_2154_303# u_t030_014/m2_871_2081# VSUBS detronyx_12t_2w2r_rc4_4x4_routed_5layer_direct
Xu_t030_003 u_t030_003/c0_w0_bl u_t030_003/c0_w0_br u_t030_003/c0_w1_bl u_t030_003/c0_w1_br
+ u_t030_003/c0_r0_rbl u_t030_003/c0_r1_rbl u_t030_003/c1_w0_bl u_t030_003/c1_w0_br
+ u_t030_003/c1_w1_bl u_t030_003/c1_w1_br u_t030_003/c1_r0_rbl u_t030_003/c1_r1_rbl
+ u_t030_003/c2_w0_bl u_t030_003/c2_w0_br u_t030_003/c2_w1_bl u_t030_003/c2_w1_br
+ u_t030_003/c2_r0_rbl u_t030_003/c2_r1_rbl u_t030_003/c3_w0_bl u_t030_003/c3_w0_br
+ u_t030_003/c3_w1_bl u_t030_003/c3_w1_br u_t030_003/c3_r0_rbl u_t030_003/c3_r1_rbl
+ u_t030_003/r0_w0_wl u_t030_003/r0_w1_wl u_t030_003/r0_r0_rwl u_t030_003/r0_r1_rwl
+ u_t030_003/r1_w0_wl u_t030_003/r1_w1_wl u_t030_003/r1_r0_rwl u_t030_003/r1_r1_rwl
+ u_t030_003/r2_w0_wl u_t030_003/r2_w1_wl u_t030_003/r2_r0_rwl u_t030_003/r2_r1_rwl
+ u_t030_003/r3_w0_wl u_t030_003/r3_w1_wl u_t030_003/r3_r0_rwl u_t030_003/r3_r1_rwl
+ u_t030_003/VDD VSS u_t030_003/m2_717_1265# u_t030_003/m2_603_2031# u_t030_003/m2_1290_336#
+ u_t030_003/m2_2000_2037# u_t030_003/m2_791_2909# u_t030_003/m2_7_2126# u_t030_003/m2_2154_2081#
+ u_t030_003/m2_1795_2037# u_t030_003/m2_871_303# u_t030_003/m2_431_438# u_t030_003/m2_1290_2898#
+ u_t030_003/m2_1714_1210# u_t030_003/m2_431_1982# u_t030_003/m2_512_1265# u_t030_003/m2_2573_2126#
+ u_t030_003/m2_603_1259# u_t030_003/m2_2074_2909# u_t030_003/m2_7_336# u_t030_003/m2_717_2037#
+ u_t030_003/m2_1886_2031# u_t030_003/m2_2573_336# u_t030_003/m2_7_2898# u_t030_003/m2_2000_1265#
+ u_t030_003/m2_512_2037# u_t030_003/m2_1795_1265# u_t030_003/m2_1714_1982# u_t030_003/m2_1886_1259#
+ u_t030_003/m2_1290_2126# u_t030_003/m2_1714_438# u_t030_003/m2_431_1210# u_t030_003/m2_2573_2898#
+ u_t030_003/m2_2154_303# u_t030_003/m2_871_2081# VSUBS detronyx_12t_2w2r_rc4_4x4_routed_5layer_direct
Xgf180mcu_as_sc_mcu7t3v3__nand4_2_437 gf180mcu_as_sc_mcu7t3v3__inv_2_1582/VDD VSS
+ VSS VSS VSS VSS gf180mcu_as_sc_mcu7t3v3__nand4_2_437/Y gf180mcu_as_sc_mcu7t3v3__inv_2_1582/VNW
+ VSUBS gf180mcu_as_sc_mcu7t3v3__nand4_2
Xgf180mcu_as_sc_mcu7t3v3__nand4_2_426 VSS gf180mcu_as_sc_mcu7t3v3__inv_2_1553/VDD
+ VSS VSS VSS VSS gf180mcu_as_sc_mcu7t3v3__nand4_2_426/Y gf180mcu_as_sc_mcu7t3v3__inv_2_1550/VNW
+ VSUBS gf180mcu_as_sc_mcu7t3v3__nand4_2
Xgf180mcu_as_sc_mcu7t3v3__nand4_2_415 gf180mcu_as_sc_mcu7t3v3__inv_2_1562/VSS VSS
+ VSS VSS VSS VSS gf180mcu_as_sc_mcu7t3v3__nand4_2_415/Y gf180mcu_as_sc_mcu7t3v3__inv_2_1519/VNW
+ VSUBS gf180mcu_as_sc_mcu7t3v3__nand4_2
Xgf180mcu_as_sc_mcu7t3v3__nand4_2_404 gf180mcu_as_sc_mcu7t3v3__inv_2_1482/VDD VSS
+ VSS VSS VSS VSS gf180mcu_as_sc_mcu7t3v3__nand4_2_404/Y gf180mcu_as_sc_mcu7t3v3__inv_2_1482/VNW
+ VSUBS gf180mcu_as_sc_mcu7t3v3__nand4_2
Xgf180mcu_as_sc_mcu7t3v3__nand4_2_459 VSS gf180mcu_as_sc_mcu7t3v3__inv_2_1349/VDD
+ VSS VSS VSS VSS VSS gf180mcu_as_sc_mcu7t3v3__inv_2_1333/VNW VSUBS gf180mcu_as_sc_mcu7t3v3__nand4_2
Xgf180mcu_as_sc_mcu7t3v3__nand4_2_448 gf180mcu_as_sc_mcu7t3v3__inv_2_1409/VSS VSS
+ VSS VSS VSS VSS VSS gf180mcu_as_sc_mcu7t3v3__inv_2_1328/VNW VSUBS gf180mcu_as_sc_mcu7t3v3__nand4_2
Xu_t006_011 u_t006_011/c0_w0_bl u_t006_011/c0_w0_br u_t006_011/c0_w1_bl u_t006_011/c0_w1_br
+ u_t006_011/c0_r0_rbl u_t006_011/c0_r1_rbl u_t006_011/c1_w0_bl u_t006_011/c1_w0_br
+ u_t006_011/c1_w1_bl u_t006_011/c1_w1_br u_t006_011/c1_r0_rbl u_t006_011/c1_r1_rbl
+ u_t006_011/c2_w0_bl u_t006_011/c2_w0_br u_t006_011/c2_w1_bl u_t006_011/c2_w1_br
+ u_t006_011/c2_r0_rbl u_t006_011/c2_r1_rbl u_t006_011/c3_w0_bl u_t006_011/c3_w0_br
+ u_t006_011/c3_w1_bl u_t006_011/c3_w1_br u_t006_011/c3_r0_rbl u_t006_011/c3_r1_rbl
+ u_t006_011/r0_w0_wl u_t006_011/r0_w1_wl u_t006_011/r0_r0_rwl u_t006_011/r0_r1_rwl
+ u_t006_011/r1_w0_wl u_t006_011/r1_w1_wl u_t006_011/r1_r0_rwl u_t006_011/r1_r1_rwl
+ u_t006_011/r2_w0_wl u_t006_011/r2_w1_wl u_t006_011/r2_r0_rwl u_t006_011/r2_r1_rwl
+ u_t006_011/r3_w0_wl u_t006_011/r3_w1_wl u_t006_011/r3_r0_rwl u_t006_011/r3_r1_rwl
+ u_t006_011/VDD u_t006_011/VSS u_t006_011/m2_717_1265# u_t006_011/m2_603_2031# u_t006_011/m2_1290_336#
+ u_t006_011/m2_2000_2037# u_t006_011/m2_791_2909# u_t006_011/m2_7_2126# u_t006_011/m2_2154_2081#
+ u_t006_011/m2_1795_2037# u_t006_011/m2_871_303# u_t006_011/m2_431_438# u_t006_011/m2_1290_2898#
+ u_t006_011/m2_1714_1210# u_t006_011/m2_431_1982# u_t006_011/m2_512_1265# u_t006_011/m2_2573_2126#
+ u_t006_011/m2_603_1259# u_t006_011/m2_2074_2909# u_t006_011/m2_7_336# u_t006_011/m2_717_2037#
+ u_t006_011/m2_1886_2031# u_t006_011/m2_2573_336# u_t006_011/m2_7_2898# u_t006_011/m2_2000_1265#
+ u_t006_011/m2_512_2037# u_t006_011/m2_1795_1265# u_t006_011/m2_1714_1982# u_t006_011/m2_1886_1259#
+ u_t006_011/m2_1290_2126# u_t006_011/m2_1714_438# u_t006_011/m2_431_1210# u_t006_011/m2_2573_2898#
+ u_t006_011/m2_2154_303# u_t006_011/m2_871_2081# VSUBS detronyx_12t_2w2r_rc4_4x4_routed_5layer_direct
Xu_t021_003 u_t021_003/c0_w0_bl u_t021_003/c0_w0_br u_t021_003/c0_w1_bl u_t021_003/c0_w1_br
+ u_t021_003/c0_r0_rbl u_t021_003/c0_r1_rbl u_t021_003/c1_w0_bl u_t021_003/c1_w0_br
+ u_t021_003/c1_w1_bl u_t021_003/c1_w1_br u_t021_003/c1_r0_rbl u_t021_003/c1_r1_rbl
+ u_t021_003/c2_w0_bl u_t021_003/c2_w0_br u_t021_003/c2_w1_bl u_t021_003/c2_w1_br
+ u_t021_003/c2_r0_rbl u_t021_003/c2_r1_rbl u_t021_003/c3_w0_bl u_t021_003/c3_w0_br
+ u_t021_003/c3_w1_bl u_t021_003/c3_w1_br u_t021_003/c3_r0_rbl u_t021_003/c3_r1_rbl
+ u_t021_003/r0_w0_wl u_t021_003/r0_w1_wl u_t021_003/r0_r0_rwl u_t021_003/r0_r1_rwl
+ u_t021_003/r1_w0_wl u_t021_003/r1_w1_wl u_t021_003/r1_r0_rwl u_t021_003/r1_r1_rwl
+ u_t021_003/r2_w0_wl u_t021_003/r2_w1_wl u_t021_003/r2_r0_rwl u_t021_003/r2_r1_rwl
+ u_t021_003/r3_w0_wl u_t021_003/r3_w1_wl u_t021_003/r3_r0_rwl u_t021_003/r3_r1_rwl
+ u_t021_003/VDD VSS u_t021_003/m2_717_1265# u_t021_003/m2_603_2031# u_t021_003/m2_1290_336#
+ u_t021_003/m2_2000_2037# u_t021_003/m2_791_2909# u_t021_003/m2_7_2126# u_t021_003/m2_2154_2081#
+ u_t021_003/m2_1795_2037# u_t021_003/m2_871_303# u_t021_003/m2_431_438# u_t021_003/m2_1290_2898#
+ u_t021_003/m2_1714_1210# u_t021_003/m2_431_1982# u_t021_003/m2_512_1265# u_t021_003/m2_2573_2126#
+ u_t021_003/m2_603_1259# u_t021_003/m2_2074_2909# u_t021_003/m2_7_336# u_t021_003/m2_717_2037#
+ u_t021_003/m2_1886_2031# u_t021_003/m2_2573_336# u_t021_003/m2_7_2898# u_t021_003/m2_2000_1265#
+ u_t021_003/m2_512_2037# u_t021_003/m2_1795_1265# u_t021_003/m2_1714_1982# u_t021_003/m2_1886_1259#
+ u_t021_003/m2_1290_2126# u_t021_003/m2_1714_438# u_t021_003/m2_431_1210# u_t021_003/m2_2573_2898#
+ u_t021_003/m2_2154_303# u_t021_003/m2_871_2081# VSUBS detronyx_12t_2w2r_rc4_4x4_routed_5layer_direct
Xgf180mcu_as_sc_mcu7t3v3__inv_2_5 gf180mcu_as_sc_mcu7t3v3__inv_2_9/VDD gf180mcu_as_sc_mcu7t3v3__inv_2_9/VSS
+ gf180mcu_as_sc_mcu7t3v3__inv_2_5/Y gf180mcu_as_sc_mcu7t3v3__inv_2_9/Y gf180mcu_as_sc_mcu7t3v3__inv_2_9/VNW
+ VSUBS gf180mcu_as_sc_mcu7t3v3__inv_2
Xu_t006_000 VSS u_t006_000/c0_w0_br VSS u_t006_000/c0_w1_br u_t006_000/c0_r0_rbl u_t006_000/c0_r1_rbl
+ VSS VSS VSS VSS VSS VSS u_t006_000/c2_w0_bl u_t006_000/c2_w0_br u_t006_000/c2_w1_bl
+ u_t006_000/c2_w1_br u_t006_000/c2_r0_rbl u_t006_000/c2_r1_rbl u_t006_000/c3_w0_bl
+ u_t006_000/c3_w0_br u_t006_000/c3_w1_bl u_t006_000/c3_w1_br u_t006_000/c3_r0_rbl
+ u_t006_000/c3_r1_rbl VSS VSS VSS VSS VSS VSS VSS VSS VSS VSS VSS VSS VSS VSS VSS
+ VSS VSS VSS u_t006_000/m2_717_1265# u_t006_000/m2_603_2031# u_t006_000/m2_1290_336#
+ u_t006_000/m2_2000_2037# u_t006_000/m2_791_2909# u_t006_000/m2_7_2126# u_t006_000/m2_2154_2081#
+ u_t006_000/m2_1795_2037# u_t006_000/m2_871_303# u_t006_000/m2_431_438# u_t006_000/m2_1290_2898#
+ u_t006_000/m2_1714_1210# u_t006_000/m2_431_1982# u_t006_000/m2_512_1265# u_t006_000/m2_2573_2126#
+ u_t006_000/m2_603_1259# u_t006_000/m2_2074_2909# u_t006_000/m2_7_336# u_t006_000/m2_717_2037#
+ u_t006_000/m2_1886_2031# u_t006_000/m2_2573_336# u_t006_000/m2_7_2898# u_t006_000/m2_2000_1265#
+ u_t006_000/m2_512_2037# u_t006_000/m2_1795_1265# u_t006_000/m2_1714_1982# u_t006_000/m2_1886_1259#
+ u_t006_000/m2_1290_2126# u_t006_000/m2_1714_438# u_t006_000/m2_431_1210# u_t006_000/m2_2573_2898#
+ u_t006_000/m2_2154_303# u_t006_000/m2_871_2081# VSUBS detronyx_12t_2w2r_rc4_4x4_routed_5layer_direct
Xu_t021_014 u_t021_014/c0_w0_bl u_t021_014/c0_w0_br u_t021_014/c0_w1_bl u_t021_014/c0_w1_br
+ u_t021_014/c0_r0_rbl u_t021_014/c0_r1_rbl u_t021_014/c1_w0_bl u_t021_014/c1_w0_br
+ u_t021_014/c1_w1_bl u_t021_014/c1_w1_br u_t021_014/c1_r0_rbl u_t021_014/c1_r1_rbl
+ u_t021_014/c2_w0_bl u_t021_014/c2_w0_br u_t021_014/c2_w1_bl u_t021_014/c2_w1_br
+ u_t021_014/c2_r0_rbl u_t021_014/c2_r1_rbl u_t021_014/c3_w0_bl u_t021_014/c3_w0_br
+ u_t021_014/c3_w1_bl u_t021_014/c3_w1_br u_t021_014/c3_r0_rbl u_t021_014/c3_r1_rbl
+ u_t021_014/r0_w0_wl u_t021_014/r0_w1_wl u_t021_014/r0_r0_rwl u_t021_014/r0_r1_rwl
+ u_t021_014/r1_w0_wl u_t021_014/r1_w1_wl u_t021_014/r1_r0_rwl u_t021_014/r1_r1_rwl
+ u_t021_014/r2_w0_wl u_t021_014/r2_w1_wl u_t021_014/r2_r0_rwl u_t021_014/r2_r1_rwl
+ u_t021_014/r3_w0_wl u_t021_014/r3_w1_wl u_t021_014/r3_r0_rwl u_t021_014/r3_r1_rwl
+ u_t021_014/VDD VSS u_t021_014/m2_717_1265# u_t021_014/m2_603_2031# u_t021_014/m2_1290_336#
+ u_t021_014/m2_2000_2037# u_t021_014/m2_791_2909# u_t021_014/m2_7_2126# u_t021_014/m2_2154_2081#
+ u_t021_014/m2_1795_2037# u_t021_014/m2_871_303# u_t021_014/m2_431_438# u_t021_014/m2_1290_2898#
+ u_t021_014/m2_1714_1210# u_t021_014/m2_431_1982# u_t021_014/m2_512_1265# u_t021_014/m2_2573_2126#
+ u_t021_014/m2_603_1259# u_t021_014/m2_2074_2909# u_t021_014/m2_7_336# u_t021_014/m2_717_2037#
+ u_t021_014/m2_1886_2031# u_t021_014/m2_2573_336# u_t021_014/m2_7_2898# u_t021_014/m2_2000_1265#
+ u_t021_014/m2_512_2037# u_t021_014/m2_1795_1265# u_t021_014/m2_1714_1982# u_t021_014/m2_1886_1259#
+ u_t021_014/m2_1290_2126# u_t021_014/m2_1714_438# u_t021_014/m2_431_1210# u_t021_014/m2_2573_2898#
+ u_t021_014/m2_2154_303# u_t021_014/m2_871_2081# VSUBS detronyx_12t_2w2r_rc4_4x4_routed_5layer_direct
Xu_t012_014 u_t012_014/c0_w0_bl u_t012_014/c0_w0_br u_t012_014/c0_w1_bl u_t012_014/c0_w1_br
+ u_t012_014/c0_r0_rbl u_t012_014/c0_r1_rbl u_t012_014/c1_w0_bl u_t012_014/c1_w0_br
+ u_t012_014/c1_w1_bl u_t012_014/c1_w1_br u_t012_014/c1_r0_rbl u_t012_014/c1_r1_rbl
+ u_t012_014/c2_w0_bl u_t012_014/c2_w0_br u_t012_014/c2_w1_bl u_t012_014/c2_w1_br
+ u_t012_014/c2_r0_rbl u_t012_014/c2_r1_rbl u_t012_014/c3_w0_bl u_t012_014/c3_w0_br
+ u_t012_014/c3_w1_bl u_t012_014/c3_w1_br u_t012_014/c3_r0_rbl u_t012_014/c3_r1_rbl
+ u_t012_014/r0_w0_wl u_t012_014/r0_w1_wl u_t012_014/r0_r0_rwl u_t012_014/r0_r1_rwl
+ u_t012_014/r1_w0_wl u_t012_014/r1_w1_wl u_t012_014/r1_r0_rwl u_t012_014/r1_r1_rwl
+ u_t012_014/r2_w0_wl u_t012_014/r2_w1_wl u_t012_014/r2_r0_rwl u_t012_014/r2_r1_rwl
+ u_t012_014/r3_w0_wl u_t012_014/r3_w1_wl u_t012_014/r3_r0_rwl u_t012_014/r3_r1_rwl
+ u_t012_014/VDD VSS u_t012_014/m2_717_1265# u_t012_014/m2_603_2031# u_t012_014/m2_1290_336#
+ u_t012_014/m2_2000_2037# u_t012_014/m2_791_2909# u_t012_014/m2_7_2126# u_t012_014/m2_2154_2081#
+ u_t012_014/m2_1795_2037# u_t012_014/m2_871_303# u_t012_014/m2_431_438# u_t012_014/m2_1290_2898#
+ u_t012_014/m2_1714_1210# u_t012_014/m2_431_1982# u_t012_014/m2_512_1265# u_t012_014/m2_2573_2126#
+ u_t012_014/m2_603_1259# u_t012_014/m2_2074_2909# u_t012_014/m2_7_336# u_t012_014/m2_717_2037#
+ u_t012_014/m2_1886_2031# u_t012_014/m2_2573_336# u_t012_014/m2_7_2898# u_t012_014/m2_2000_1265#
+ u_t012_014/m2_512_2037# u_t012_014/m2_1795_1265# u_t012_014/m2_1714_1982# u_t012_014/m2_1886_1259#
+ u_t012_014/m2_1290_2126# u_t012_014/m2_1714_438# u_t012_014/m2_431_1210# u_t012_014/m2_2573_2898#
+ u_t012_014/m2_2154_303# u_t012_014/m2_871_2081# VSUBS detronyx_12t_2w2r_rc4_4x4_routed_5layer_direct
Xu_t012_003 u_t012_003/c0_w0_bl u_t012_003/c0_w0_br u_t012_003/c0_w1_bl u_t012_003/c0_w1_br
+ u_t012_003/c0_r0_rbl u_t012_003/c0_r1_rbl u_t012_003/c1_w0_bl u_t012_003/c1_w0_br
+ u_t012_003/c1_w1_bl u_t012_003/c1_w1_br u_t012_003/c1_r0_rbl u_t012_003/c1_r1_rbl
+ u_t012_003/c2_w0_bl u_t012_003/c2_w0_br u_t012_003/c2_w1_bl u_t012_003/c2_w1_br
+ u_t012_003/c2_r0_rbl u_t012_003/c2_r1_rbl u_t012_003/c3_w0_bl u_t012_003/c3_w0_br
+ u_t012_003/c3_w1_bl u_t012_003/c3_w1_br u_t012_003/c3_r0_rbl u_t012_003/c3_r1_rbl
+ u_t012_003/r0_w0_wl u_t012_003/r0_w1_wl u_t012_003/r0_r0_rwl u_t012_003/r0_r1_rwl
+ u_t012_003/r1_w0_wl u_t012_003/r1_w1_wl u_t012_003/r1_r0_rwl u_t012_003/r1_r1_rwl
+ u_t012_003/r2_w0_wl u_t012_003/r2_w1_wl u_t012_003/r2_r0_rwl u_t012_003/r2_r1_rwl
+ u_t012_003/r3_w0_wl u_t012_003/r3_w1_wl u_t012_003/r3_r0_rwl u_t012_003/r3_r1_rwl
+ u_t012_003/VDD VSS u_t012_003/m2_717_1265# u_t012_003/m2_603_2031# u_t012_003/m2_1290_336#
+ u_t012_003/m2_2000_2037# u_t012_003/m2_791_2909# u_t012_003/m2_7_2126# u_t012_003/m2_2154_2081#
+ u_t012_003/m2_1795_2037# u_t012_003/m2_871_303# u_t012_003/m2_431_438# u_t012_003/m2_1290_2898#
+ u_t012_003/m2_1714_1210# u_t012_003/m2_431_1982# u_t012_003/m2_512_1265# u_t012_003/m2_2573_2126#
+ u_t012_003/m2_603_1259# u_t012_003/m2_2074_2909# u_t012_003/m2_7_336# u_t012_003/m2_717_2037#
+ u_t012_003/m2_1886_2031# u_t012_003/m2_2573_336# u_t012_003/m2_7_2898# u_t012_003/m2_2000_1265#
+ u_t012_003/m2_512_2037# u_t012_003/m2_1795_1265# u_t012_003/m2_1714_1982# u_t012_003/m2_1886_1259#
+ u_t012_003/m2_1290_2126# u_t012_003/m2_1714_438# u_t012_003/m2_431_1210# u_t012_003/m2_2573_2898#
+ u_t012_003/m2_2154_303# u_t012_003/m2_871_2081# VSUBS detronyx_12t_2w2r_rc4_4x4_routed_5layer_direct
Xgf180mcu_as_sc_mcu7t3v3__inv_2_1473 gf180mcu_as_sc_mcu7t3v3__inv_2_1473/VDD VSS VSS
+ VSS gf180mcu_as_sc_mcu7t3v3__inv_2_1473/VNW VSUBS gf180mcu_as_sc_mcu7t3v3__inv_2
Xgf180mcu_as_sc_mcu7t3v3__inv_2_1462 gf180mcu_as_sc_mcu7t3v3__inv_2_1476/VSS gf180mcu_as_sc_mcu7t3v3__inv_2_1482/VDD
+ VSS VSS gf180mcu_as_sc_mcu7t3v3__inv_2_1464/VNW VSUBS gf180mcu_as_sc_mcu7t3v3__inv_2
Xgf180mcu_as_sc_mcu7t3v3__inv_2_1484 VSS VSS VSS VSS gf180mcu_as_sc_mcu7t3v3__inv_2_1485/VNW
+ VSUBS gf180mcu_as_sc_mcu7t3v3__inv_2
Xgf180mcu_as_sc_mcu7t3v3__inv_2_1495 VSS gf180mcu_as_sc_mcu7t3v3__inv_2_1500/VDD VSS
+ VSS gf180mcu_as_sc_mcu7t3v3__inv_2_1497/VNW VSUBS gf180mcu_as_sc_mcu7t3v3__inv_2
Xgf180mcu_as_sc_mcu7t3v3__inv_2_1451 gf180mcu_as_sc_mcu7t3v3__inv_2_1452/VDD gf180mcu_as_sc_mcu7t3v3__inv_2_1455/VDD
+ gf180mcu_as_sc_mcu7t3v3__inv_2_1451/Y VSS gf180mcu_as_sc_mcu7t3v3__inv_2_1452/VNW
+ VSUBS gf180mcu_as_sc_mcu7t3v3__inv_2
Xgf180mcu_as_sc_mcu7t3v3__inv_2_1440 VSS gf180mcu_as_sc_mcu7t3v3__inv_2_1443/VDD gf180mcu_as_sc_mcu7t3v3__inv_2_1440/Y
+ VSS gf180mcu_as_sc_mcu7t3v3__inv_2_1440/VNW VSUBS gf180mcu_as_sc_mcu7t3v3__inv_2
Xu_t003_003 u_t003_003/c0_w0_bl u_t003_003/c0_w0_br u_t003_003/c0_w1_bl u_t003_003/c0_w1_br
+ u_t003_003/c0_r0_rbl u_t003_003/c0_r1_rbl u_t003_003/c1_w0_bl u_t003_003/c1_w0_br
+ u_t003_003/c1_w1_bl u_t003_003/c1_w1_br u_t003_003/c1_r0_rbl u_t003_003/c1_r1_rbl
+ u_t003_003/c2_w0_bl u_t003_003/c2_w0_br u_t003_003/c2_w1_bl u_t003_003/c2_w1_br
+ u_t003_003/c2_r0_rbl u_t003_003/c2_r1_rbl u_t003_003/c3_w0_bl u_t003_003/c3_w0_br
+ u_t003_003/c3_w1_bl u_t003_003/c3_w1_br u_t003_003/c3_r0_rbl u_t003_003/c3_r1_rbl
+ u_t003_003/r0_w0_wl u_t003_003/r0_w1_wl u_t003_003/r0_r0_rwl u_t003_003/r0_r1_rwl
+ u_t003_003/r1_w0_wl u_t003_003/r1_w1_wl u_t003_003/r1_r0_rwl u_t003_003/r1_r1_rwl
+ u_t003_003/r2_w0_wl u_t003_003/r2_w1_wl u_t003_003/r2_r0_rwl u_t003_003/r2_r1_rwl
+ u_t003_003/r3_w0_wl u_t003_003/r3_w1_wl u_t003_003/r3_r0_rwl u_t003_003/r3_r1_rwl
+ u_t004_003/VDD u_t003_003/VSS u_t003_003/m2_717_1265# u_t003_003/m2_603_2031# u_t003_003/m2_1290_336#
+ u_t003_003/m2_2000_2037# u_t003_003/m2_791_2909# u_t003_003/m2_7_2126# u_t003_003/m2_2154_2081#
+ u_t003_003/m2_1795_2037# u_t003_003/m2_871_303# u_t003_003/m2_431_438# u_t003_003/m2_1290_2898#
+ u_t003_003/m2_1714_1210# u_t003_003/m2_431_1982# u_t003_003/m2_512_1265# u_t003_003/m2_2573_2126#
+ u_t003_003/m2_603_1259# u_t003_003/m2_2074_2909# u_t003_003/m2_7_336# u_t003_003/m2_717_2037#
+ u_t003_003/m2_1886_2031# u_t003_003/m2_2573_336# u_t003_003/m2_7_2898# u_t003_003/m2_2000_1265#
+ u_t003_003/m2_512_2037# u_t003_003/m2_1795_1265# u_t003_003/m2_1714_1982# u_t003_003/m2_1886_1259#
+ u_t003_003/m2_1290_2126# u_t003_003/m2_1714_438# u_t003_003/m2_431_1210# u_t003_003/m2_2573_2898#
+ u_t003_003/m2_2154_303# u_t003_003/m2_871_2081# VSUBS detronyx_12t_2w2r_rc4_4x4_routed_5layer_direct
Xgf180mcu_as_sc_mcu7t3v3__inv_2_913 VSS VSS VSS VSS gf180mcu_as_sc_mcu7t3v3__inv_2_945/VNW
+ VSUBS gf180mcu_as_sc_mcu7t3v3__inv_2
Xgf180mcu_as_sc_mcu7t3v3__inv_2_946 VSS VSS VSS VSS gf180mcu_as_sc_mcu7t3v3__inv_2_946/VNW
+ VSUBS gf180mcu_as_sc_mcu7t3v3__inv_2
Xgf180mcu_as_sc_mcu7t3v3__inv_2_902 VSS VSS VSS VSS gf180mcu_as_sc_mcu7t3v3__inv_2_951/VNW
+ VSUBS gf180mcu_as_sc_mcu7t3v3__inv_2
Xgf180mcu_as_sc_mcu7t3v3__inv_2_979 VSS gf180mcu_as_sc_mcu7t3v3__inv_2_984/VDD gf180mcu_as_sc_mcu7t3v3__inv_2_998/A
+ gf180mcu_as_sc_mcu7t3v3__inv_2_980/Y gf180mcu_as_sc_mcu7t3v3__inv_2_980/VNW VSUBS
+ gf180mcu_as_sc_mcu7t3v3__inv_2
Xgf180mcu_as_sc_mcu7t3v3__inv_2_935 VSS VSS VSS VSS gf180mcu_as_sc_mcu7t3v3__inv_2_935/VNW
+ VSUBS gf180mcu_as_sc_mcu7t3v3__inv_2
Xgf180mcu_as_sc_mcu7t3v3__inv_2_968 VSS VSS gf180mcu_as_sc_mcu7t3v3__inv_2_968/Y VSS
+ gf180mcu_as_sc_mcu7t3v3__inv_2_968/VNW VSUBS gf180mcu_as_sc_mcu7t3v3__inv_2
Xgf180mcu_as_sc_mcu7t3v3__inv_2_924 VSS VSS gf180mcu_as_sc_mcu7t3v3__inv_2_924/Y VSS
+ gf180mcu_as_sc_mcu7t3v3__inv_2_959/VNW VSUBS gf180mcu_as_sc_mcu7t3v3__inv_2
Xgf180mcu_as_sc_mcu7t3v3__inv_2_957 VSS VSS VSS VSS gf180mcu_as_sc_mcu7t3v3__inv_2_957/VNW
+ VSUBS gf180mcu_as_sc_mcu7t3v3__inv_2
Xu_t003_014 u_t003_014/c0_w0_bl u_t003_014/c0_w0_br u_t003_014/c0_w1_bl u_t003_014/c0_w1_br
+ u_t003_014/c0_r0_rbl u_t003_014/c0_r1_rbl u_t003_014/c1_w0_bl u_t003_014/c1_w0_br
+ u_t003_014/c1_w1_bl u_t003_014/c1_w1_br u_t003_014/c1_r0_rbl u_t003_014/c1_r1_rbl
+ u_t003_014/c2_w0_bl u_t003_014/c2_w0_br u_t003_014/c2_w1_bl u_t003_014/c2_w1_br
+ u_t003_014/c2_r0_rbl u_t003_014/c2_r1_rbl u_t003_014/c3_w0_bl u_t003_014/c3_w0_br
+ u_t003_014/c3_w1_bl u_t003_014/c3_w1_br u_t003_014/c3_r0_rbl u_t003_014/c3_r1_rbl
+ u_t003_014/r0_w0_wl u_t003_014/r0_w1_wl u_t003_014/r0_r0_rwl u_t003_014/r0_r1_rwl
+ u_t003_014/r1_w0_wl u_t003_014/r1_w1_wl u_t003_014/r1_r0_rwl u_t003_014/r1_r1_rwl
+ u_t003_014/r2_w0_wl u_t003_014/r2_w1_wl u_t003_014/r2_r0_rwl u_t003_014/r2_r1_rwl
+ u_t003_014/r3_w0_wl u_t003_014/r3_w1_wl u_t003_014/r3_r0_rwl u_t003_014/r3_r1_rwl
+ u_t004_014/VDD u_t003_015/VSS u_t003_014/m2_717_1265# u_t003_014/m2_603_2031# u_t003_014/m2_1290_336#
+ u_t003_014/m2_2000_2037# u_t003_014/m2_791_2909# u_t003_014/m2_7_2126# u_t003_014/m2_2154_2081#
+ u_t003_014/m2_1795_2037# u_t003_014/m2_871_303# u_t003_014/m2_431_438# u_t003_014/m2_1290_2898#
+ u_t003_014/m2_1714_1210# u_t003_014/m2_431_1982# u_t003_014/m2_512_1265# u_t003_014/m2_2573_2126#
+ u_t003_014/m2_603_1259# u_t003_014/m2_2074_2909# u_t003_014/m2_7_336# u_t003_014/m2_717_2037#
+ u_t003_014/m2_1886_2031# u_t003_014/m2_2573_336# u_t003_014/m2_7_2898# u_t003_014/m2_2000_1265#
+ u_t003_014/m2_512_2037# u_t003_014/m2_1795_1265# u_t003_014/m2_1714_1982# u_t003_014/m2_1886_1259#
+ u_t003_014/m2_1290_2126# u_t003_014/m2_1714_438# u_t003_014/m2_431_1210# u_t003_014/m2_2573_2898#
+ u_t003_014/m2_2154_303# u_t003_014/m2_871_2081# VSUBS detronyx_12t_2w2r_rc4_4x4_routed_5layer_direct
Xgf180mcu_as_sc_mcu7t3v3__nand4_2_201 gf180mcu_as_sc_mcu7t3v3__inv_2_688/VDD VSS VSS
+ VSS VSS VSS VSS gf180mcu_as_sc_mcu7t3v3__inv_2_688/VNW VSUBS gf180mcu_as_sc_mcu7t3v3__nand4_2
Xgf180mcu_as_sc_mcu7t3v3__nand4_2_278 VSS VSS VSS VSS VSS VSS VSS gf180mcu_as_sc_mcu7t3v3__inv_2_945/VNW
+ VSUBS gf180mcu_as_sc_mcu7t3v3__nand4_2
Xgf180mcu_as_sc_mcu7t3v3__nand4_2_223 VSS VSS VSS VSS VSS VSS gf180mcu_as_sc_mcu7t3v3__nand4_2_223/Y
+ gf180mcu_as_sc_mcu7t3v3__inv_2_823/VNW VSUBS gf180mcu_as_sc_mcu7t3v3__nand4_2
Xgf180mcu_as_sc_mcu7t3v3__nand4_2_212 VSS gf180mcu_as_sc_mcu7t3v3__inv_2_679/VSS VSS
+ VSS VSS VSS VSS gf180mcu_as_sc_mcu7t3v3__inv_2_679/VNW VSUBS gf180mcu_as_sc_mcu7t3v3__nand4_2
Xgf180mcu_as_sc_mcu7t3v3__nand4_2_245 VSS VSS VSS VSS VSS VSS gf180mcu_as_sc_mcu7t3v3__nand4_2_245/Y
+ gf180mcu_as_sc_mcu7t3v3__inv_2_848/VNW VSUBS gf180mcu_as_sc_mcu7t3v3__nand4_2
Xgf180mcu_as_sc_mcu7t3v3__nand4_2_234 VSS VSS VSS VSS VSS VSS gf180mcu_as_sc_mcu7t3v3__nand4_2_234/Y
+ gf180mcu_as_sc_mcu7t3v3__inv_2_842/VNW VSUBS gf180mcu_as_sc_mcu7t3v3__nand4_2
Xgf180mcu_as_sc_mcu7t3v3__nand4_2_289 VSS gf180mcu_as_sc_mcu7t3v3__inv_2_984/VDD VSS
+ VSS VSS VSS VSS gf180mcu_as_sc_mcu7t3v3__inv_2_980/VNW VSUBS gf180mcu_as_sc_mcu7t3v3__nand4_2
Xgf180mcu_as_sc_mcu7t3v3__nand4_2_256 VSS VSS VSS VSS VSS VSS gf180mcu_as_sc_mcu7t3v3__nand4_2_256/Y
+ gf180mcu_as_sc_mcu7t3v3__inv_2_928/VNW VSUBS gf180mcu_as_sc_mcu7t3v3__nand4_2
Xgf180mcu_as_sc_mcu7t3v3__nand4_2_267 VSS VSS VSS VSS VSS VSS VSS gf180mcu_as_sc_mcu7t3v3__inv_2_925/VNW
+ VSUBS gf180mcu_as_sc_mcu7t3v3__nand4_2
Xgf180mcu_as_sc_mcu7t3v3__inv_2_209 gf180mcu_as_sc_mcu7t3v3__inv_2_257/VSS VSS gf180mcu_as_sc_mcu7t3v3__inv_2_209/Y
+ VSS gf180mcu_as_sc_mcu7t3v3__inv_2_209/VNW VSUBS gf180mcu_as_sc_mcu7t3v3__inv_2
Xu_t000_006 u_t000_006/c0_w0_bl u_t000_006/c0_w0_br u_t000_006/c0_w1_bl u_t000_006/c0_w1_br
+ u_t000_006/c0_r0_rbl u_t000_006/c0_r1_rbl u_t000_006/c1_w0_bl u_t000_006/c1_w0_br
+ u_t000_006/c1_w1_bl u_t000_006/c1_w1_br u_t000_006/c1_r0_rbl u_t000_006/c1_r1_rbl
+ u_t000_006/c2_w0_bl u_t000_006/c2_w0_br u_t000_006/c2_w1_bl u_t000_006/c2_w1_br
+ u_t000_006/c2_r0_rbl u_t000_006/c2_r1_rbl u_t000_006/c3_w0_bl u_t000_006/c3_w0_br
+ u_t000_006/c3_w1_bl u_t000_006/c3_w1_br u_t000_006/c3_r0_rbl u_t000_006/c3_r1_rbl
+ u_t000_006/r0_w0_wl u_t000_006/r0_w1_wl u_t000_006/r0_r0_rwl u_t000_006/r0_r1_rwl
+ u_t000_006/r1_w0_wl u_t000_006/r1_w1_wl u_t000_006/r1_r0_rwl u_t000_006/r1_r1_rwl
+ u_t000_006/r2_w0_wl u_t000_006/r2_w1_wl u_t000_006/r2_r0_rwl u_t000_006/r2_r1_rwl
+ u_t000_006/r3_w0_wl u_t000_006/r3_w1_wl u_t000_006/r3_r0_rwl u_t000_006/r3_r1_rwl
+ u_t000_006/VDD VSS u_t000_006/m2_717_1265# u_t000_006/m2_603_2031# u_t000_006/m2_1290_336#
+ u_t000_006/m2_2000_2037# u_t000_006/m2_791_2909# u_t000_006/m2_7_2126# u_t000_006/m2_2154_2081#
+ u_t000_006/m2_1795_2037# u_t000_006/m2_871_303# u_t000_006/m2_431_438# u_t000_006/m2_1290_2898#
+ u_t000_006/m2_1714_1210# u_t000_006/m2_431_1982# u_t000_006/m2_512_1265# u_t000_006/m2_2573_2126#
+ u_t000_006/m2_603_1259# u_t000_006/m2_2074_2909# u_t000_006/m2_7_336# u_t000_006/m2_717_2037#
+ u_t000_006/m2_1886_2031# u_t000_006/m2_2573_336# u_t000_006/m2_7_2898# u_t000_006/m2_2000_1265#
+ u_t000_006/m2_512_2037# u_t000_006/m2_1795_1265# u_t000_006/m2_1714_1982# u_t000_006/m2_1886_1259#
+ u_t000_006/m2_1290_2126# u_t000_006/m2_1714_438# u_t000_006/m2_431_1210# u_t000_006/m2_2573_2898#
+ u_t000_006/m2_2154_303# u_t000_006/m2_871_2081# VSUBS detronyx_12t_2w2r_rc4_4x4_routed_5layer_direct
Xgf180mcu_as_sc_mcu7t3v3__inv_2_1270 gf180mcu_as_sc_mcu7t3v3__nand3_2_65/VDD gf180mcu_as_sc_mcu7t3v3__nand3_2_62/VSS
+ VSS VSS gf180mcu_as_sc_mcu7t3v3__nand3_2_65/VNW VSUBS gf180mcu_as_sc_mcu7t3v3__inv_2
Xgf180mcu_as_sc_mcu7t3v3__inv_2_1281 VSS VSS VSS VSS gf180mcu_as_sc_mcu7t3v3__inv_2_1281/VNW
+ VSUBS gf180mcu_as_sc_mcu7t3v3__inv_2
Xgf180mcu_as_sc_mcu7t3v3__inv_2_1292 VSS VSS VSS VSS gf180mcu_as_sc_mcu7t3v3__inv_2_1292/VNW
+ VSUBS gf180mcu_as_sc_mcu7t3v3__inv_2
Xgf180mcu_as_sc_mcu7t3v3__inv_2_765 VSS VSS VSS VSS gf180mcu_as_sc_mcu7t3v3__inv_2_835/VNW
+ VSUBS gf180mcu_as_sc_mcu7t3v3__inv_2
Xgf180mcu_as_sc_mcu7t3v3__inv_2_754 VSS VSS VSS VSS gf180mcu_as_sc_mcu7t3v3__inv_2_831/VNW
+ VSUBS gf180mcu_as_sc_mcu7t3v3__inv_2
Xgf180mcu_as_sc_mcu7t3v3__inv_2_776 VSS VSS VSS VSS gf180mcu_as_sc_mcu7t3v3__inv_2_827/VNW
+ VSUBS gf180mcu_as_sc_mcu7t3v3__inv_2
Xgf180mcu_as_sc_mcu7t3v3__inv_2_710 gf180mcu_as_sc_mcu7t3v3__inv_2_712/VDD VSS gf180mcu_as_sc_mcu7t3v3__inv_2_710/Y
+ gf180mcu_as_sc_mcu7t3v3__inv_2_733/Y gf180mcu_as_sc_mcu7t3v3__inv_2_712/VNW VSUBS
+ gf180mcu_as_sc_mcu7t3v3__inv_2
Xgf180mcu_as_sc_mcu7t3v3__inv_2_732 VSS VSS gf180mcu_as_sc_mcu7t3v3__inv_2_732/Y gf180mcu_as_sc_mcu7t3v3__inv_2_733/Y
+ gf180mcu_as_sc_mcu7t3v3__inv_2_733/VNW VSUBS gf180mcu_as_sc_mcu7t3v3__inv_2
Xgf180mcu_as_sc_mcu7t3v3__inv_2_721 VSS gf180mcu_as_sc_mcu7t3v3__inv_2_737/VSS gf180mcu_as_sc_mcu7t3v3__inv_2_742/A
+ gf180mcu_as_sc_mcu7t3v3__inv_2_721/A gf180mcu_as_sc_mcu7t3v3__inv_2_737/VNW VSUBS
+ gf180mcu_as_sc_mcu7t3v3__inv_2
Xgf180mcu_as_sc_mcu7t3v3__inv_2_798 VSS VSS gf180mcu_as_sc_mcu7t3v3__inv_2_798/Y VSS
+ gf180mcu_as_sc_mcu7t3v3__inv_2_846/VNW VSUBS gf180mcu_as_sc_mcu7t3v3__inv_2
Xgf180mcu_as_sc_mcu7t3v3__inv_2_787 VSS VSS gf180mcu_as_sc_mcu7t3v3__inv_2_787/Y VSS
+ gf180mcu_as_sc_mcu7t3v3__inv_2_842/VNW VSUBS gf180mcu_as_sc_mcu7t3v3__inv_2
Xgf180mcu_as_sc_mcu7t3v3__inv_2_743 gf180mcu_as_sc_mcu7t3v3__inv_2_743/VDD gf180mcu_as_sc_mcu7t3v3__inv_2_743/VSS
+ gf180mcu_as_sc_mcu7t3v3__inv_2_743/Y gf180mcu_as_sc_mcu7t3v3__inv_2_743/A gf180mcu_as_sc_mcu7t3v3__inv_2_743/VNW
+ VSUBS gf180mcu_as_sc_mcu7t3v3__inv_2
Xgf180mcu_as_sc_mcu7t3v3__nand4_2_1 gf180mcu_as_sc_mcu7t3v3__inv_2_99/VSS gf180mcu_as_sc_mcu7t3v3__inv_2_94/VDD
+ VSS VSS VSS VSS gf180mcu_as_sc_mcu7t3v3__nand4_2_1/Y gf180mcu_as_sc_mcu7t3v3__inv_2_81/VNW
+ VSUBS gf180mcu_as_sc_mcu7t3v3__nand4_2
Xgf180mcu_as_sc_mcu7t3v3__inv_2_540 VSS VSS VSS VSS gf180mcu_as_sc_mcu7t3v3__inv_2_542/VNW
+ VSUBS gf180mcu_as_sc_mcu7t3v3__inv_2
Xgf180mcu_as_sc_mcu7t3v3__inv_2_551 VSS VSS VSS VSS gf180mcu_as_sc_mcu7t3v3__inv_2_551/VNW
+ VSUBS gf180mcu_as_sc_mcu7t3v3__inv_2
Xgf180mcu_as_sc_mcu7t3v3__inv_2_573 gf180mcu_as_sc_mcu7t3v3__inv_2_576/VDD gf180mcu_as_sc_mcu7t3v3__inv_2_576/VDD
+ gf180mcu_as_sc_mcu7t3v3__inv_2_573/Y VSS gf180mcu_as_sc_mcu7t3v3__inv_2_573/VNW
+ VSUBS gf180mcu_as_sc_mcu7t3v3__inv_2
Xgf180mcu_as_sc_mcu7t3v3__inv_2_584 gf180mcu_as_sc_mcu7t3v3__inv_2_584/VDD VSS gf180mcu_as_sc_mcu7t3v3__inv_2_584/Y
+ VSS gf180mcu_as_sc_mcu7t3v3__inv_2_584/VNW VSUBS gf180mcu_as_sc_mcu7t3v3__inv_2
Xgf180mcu_as_sc_mcu7t3v3__inv_2_595 VSS gf180mcu_as_sc_mcu7t3v3__inv_2_607/VDD gf180mcu_as_sc_mcu7t3v3__inv_2_595/Y
+ gf180mcu_as_sc_mcu7t3v3__inv_2_638/A gf180mcu_as_sc_mcu7t3v3__inv_2_603/VNW VSUBS
+ gf180mcu_as_sc_mcu7t3v3__inv_2
Xgf180mcu_as_sc_mcu7t3v3__inv_2_562 VSS VSS VSS VSS gf180mcu_as_sc_mcu7t3v3__inv_2_562/VNW
+ VSUBS gf180mcu_as_sc_mcu7t3v3__inv_2
Xu_t028_009 u_t028_009/c0_w0_bl u_t028_009/c0_w0_br u_t028_009/c0_w1_bl u_t028_009/c0_w1_br
+ u_t028_009/c0_r0_rbl u_t028_009/c0_r1_rbl u_t028_009/c1_w0_bl u_t028_009/c1_w0_br
+ u_t028_009/c1_w1_bl u_t028_009/c1_w1_br u_t028_009/c1_r0_rbl u_t028_009/c1_r1_rbl
+ u_t028_009/c2_w0_bl u_t028_009/c2_w0_br u_t028_009/c2_w1_bl u_t028_009/c2_w1_br
+ u_t028_009/c2_r0_rbl u_t028_009/c2_r1_rbl u_t028_009/c3_w0_bl u_t028_009/c3_w0_br
+ u_t028_009/c3_w1_bl u_t028_009/c3_w1_br u_t028_009/c3_r0_rbl u_t028_009/c3_r1_rbl
+ u_t028_009/r0_w0_wl u_t028_009/r0_w1_wl u_t028_009/r0_r0_rwl u_t028_009/r0_r1_rwl
+ u_t028_009/r1_w0_wl u_t028_009/r1_w1_wl u_t028_009/r1_r0_rwl u_t028_009/r1_r1_rwl
+ u_t028_009/r2_w0_wl u_t028_009/r2_w1_wl u_t028_009/r2_r0_rwl u_t028_009/r2_r1_rwl
+ u_t028_009/r3_w0_wl u_t028_009/r3_w1_wl u_t028_009/r3_r0_rwl u_t028_009/r3_r1_rwl
+ VSS u_t028_009/VSS u_t028_009/m2_717_1265# u_t028_009/m2_603_2031# u_t028_009/m2_1290_336#
+ u_t028_009/m2_2000_2037# u_t028_009/m2_791_2909# u_t028_009/m2_7_2126# u_t028_009/m2_2154_2081#
+ u_t028_009/m2_1795_2037# u_t028_009/m2_871_303# u_t028_009/m2_431_438# u_t028_009/m2_1290_2898#
+ u_t028_009/m2_1714_1210# u_t028_009/m2_431_1982# u_t028_009/m2_512_1265# u_t028_009/m2_2573_2126#
+ u_t028_009/m2_603_1259# u_t028_009/m2_2074_2909# u_t028_009/m2_7_336# u_t028_009/m2_717_2037#
+ u_t028_009/m2_1886_2031# u_t028_009/m2_2573_336# u_t028_009/m2_7_2898# u_t028_009/m2_2000_1265#
+ u_t028_009/m2_512_2037# u_t028_009/m2_1795_1265# u_t028_009/m2_1714_1982# u_t028_009/m2_1886_1259#
+ u_t028_009/m2_1290_2126# u_t028_009/m2_1714_438# u_t028_009/m2_431_1210# u_t028_009/m2_2573_2898#
+ u_t028_009/m2_2154_303# u_t028_009/m2_871_2081# VSUBS detronyx_12t_2w2r_rc4_4x4_routed_5layer_direct
Xgf180mcu_as_sc_mcu7t3v3__inv_2_370 gf180mcu_as_sc_mcu7t3v3__inv_2_371/VDD gf180mcu_as_sc_mcu7t3v3__inv_2_371/VSS
+ VSS VSS gf180mcu_as_sc_mcu7t3v3__inv_2_371/VNW VSUBS gf180mcu_as_sc_mcu7t3v3__inv_2
Xgf180mcu_as_sc_mcu7t3v3__inv_2_392 gf180mcu_as_sc_mcu7t3v3__nor2_2_6/VDD gf180mcu_as_sc_mcu7t3v3__nand3_2_4/VSS
+ VSS VSS gf180mcu_as_sc_mcu7t3v3__nor2_2_6/VNW VSUBS gf180mcu_as_sc_mcu7t3v3__inv_2
Xgf180mcu_as_sc_mcu7t3v3__inv_2_381 gf180mcu_as_sc_mcu7t3v3__nor2_2_7/VDD gf180mcu_as_sc_mcu7t3v3__nand3_2_4/VSS
+ VSS VSS gf180mcu_as_sc_mcu7t3v3__nor2_2_7/VNW VSUBS gf180mcu_as_sc_mcu7t3v3__inv_2
Xu_t019_009 u_t019_009/c0_w0_bl u_t019_009/c0_w0_br u_t019_009/c0_w1_bl u_t019_009/c0_w1_br
+ u_t019_009/c0_r0_rbl u_t019_009/c0_r1_rbl u_t019_009/c1_w0_bl u_t019_009/c1_w0_br
+ u_t019_009/c1_w1_bl u_t019_009/c1_w1_br u_t019_009/c1_r0_rbl u_t019_009/c1_r1_rbl
+ u_t019_009/c2_w0_bl u_t019_009/c2_w0_br u_t019_009/c2_w1_bl u_t019_009/c2_w1_br
+ u_t019_009/c2_r0_rbl u_t019_009/c2_r1_rbl u_t019_009/c3_w0_bl u_t019_009/c3_w0_br
+ u_t019_009/c3_w1_bl u_t019_009/c3_w1_br u_t019_009/c3_r0_rbl u_t019_009/c3_r1_rbl
+ u_t019_009/r0_w0_wl u_t019_009/r0_w1_wl u_t019_009/r0_r0_rwl u_t019_009/r0_r1_rwl
+ u_t019_009/r1_w0_wl u_t019_009/r1_w1_wl u_t019_009/r1_r0_rwl u_t019_009/r1_r1_rwl
+ u_t019_009/r2_w0_wl u_t019_009/r2_w1_wl u_t019_009/r2_r0_rwl u_t019_009/r2_r1_rwl
+ u_t019_009/r3_w0_wl u_t019_009/r3_w1_wl u_t019_009/r3_r0_rwl u_t019_009/r3_r1_rwl
+ VSS u_t019_009/VSS u_t019_009/m2_717_1265# u_t019_009/m2_603_2031# u_t019_009/m2_1290_336#
+ u_t019_009/m2_2000_2037# u_t019_009/m2_791_2909# u_t019_009/m2_7_2126# u_t019_009/m2_2154_2081#
+ u_t019_009/m2_1795_2037# u_t019_009/m2_871_303# u_t019_009/m2_431_438# u_t019_009/m2_1290_2898#
+ u_t019_009/m2_1714_1210# u_t019_009/m2_431_1982# u_t019_009/m2_512_1265# u_t019_009/m2_2573_2126#
+ u_t019_009/m2_603_1259# u_t019_009/m2_2074_2909# u_t019_009/m2_7_336# u_t019_009/m2_717_2037#
+ u_t019_009/m2_1886_2031# u_t019_009/m2_2573_336# u_t019_009/m2_7_2898# u_t019_009/m2_2000_1265#
+ u_t019_009/m2_512_2037# u_t019_009/m2_1795_1265# u_t019_009/m2_1714_1982# u_t019_009/m2_1886_1259#
+ u_t019_009/m2_1290_2126# u_t019_009/m2_1714_438# u_t019_009/m2_431_1210# u_t019_009/m2_2573_2898#
+ u_t019_009/m2_2154_303# u_t019_009/m2_871_2081# VSUBS detronyx_12t_2w2r_rc4_4x4_routed_5layer_direct
Xgf180mcu_as_sc_mcu7t3v3__nand3_2_46 gf180mcu_as_sc_mcu7t3v3__nor2_2_9/VDD gf180mcu_as_sc_mcu7t3v3__nor2_2_9/VSS
+ VSS VSS VSS VSS gf180mcu_as_sc_mcu7t3v3__nor2_2_9/VNW VSUBS gf180mcu_as_sc_mcu7t3v3__nand3_2
Xgf180mcu_as_sc_mcu7t3v3__nand3_2_13 gf180mcu_as_sc_mcu7t3v3__nor2_2_6/VDD gf180mcu_as_sc_mcu7t3v3__nor2_2_6/VSS
+ VSS VSS VSS VSS gf180mcu_as_sc_mcu7t3v3__nor2_2_6/VNW VSUBS gf180mcu_as_sc_mcu7t3v3__nand3_2
Xgf180mcu_as_sc_mcu7t3v3__nand3_2_24 gf180mcu_as_sc_mcu7t3v3__nor2_2_6/VDD gf180mcu_as_sc_mcu7t3v3__nand3_2_4/VSS
+ VSS VSS VSS VSS gf180mcu_as_sc_mcu7t3v3__nor2_2_6/VNW VSUBS gf180mcu_as_sc_mcu7t3v3__nand3_2
Xgf180mcu_as_sc_mcu7t3v3__nand3_2_35 gf180mcu_as_sc_mcu7t3v3__nor2_2_4/VDD gf180mcu_as_sc_mcu7t3v3__nor2_2_4/VSS
+ VSS VSS VSS VSS gf180mcu_as_sc_mcu7t3v3__nor2_2_4/VNW VSUBS gf180mcu_as_sc_mcu7t3v3__nand3_2
Xu_t024_012 u_t024_012/c0_w0_bl u_t024_012/c0_w0_br u_t024_012/c0_w1_bl u_t024_012/c0_w1_br
+ u_t024_012/c0_r0_rbl u_t024_012/c0_r1_rbl u_t024_012/c1_w0_bl u_t024_012/c1_w0_br
+ u_t024_012/c1_w1_bl u_t024_012/c1_w1_br u_t024_012/c1_r0_rbl u_t024_012/c1_r1_rbl
+ u_t024_012/c2_w0_bl u_t024_012/c2_w0_br u_t024_012/c2_w1_bl u_t024_012/c2_w1_br
+ u_t024_012/c2_r0_rbl u_t024_012/c2_r1_rbl u_t024_012/c3_w0_bl u_t024_012/c3_w0_br
+ u_t024_012/c3_w1_bl u_t024_012/c3_w1_br u_t024_012/c3_r0_rbl u_t024_012/c3_r1_rbl
+ u_t024_012/r0_w0_wl u_t024_012/r0_w1_wl u_t024_012/r0_r0_rwl u_t024_012/r0_r1_rwl
+ u_t024_012/r1_w0_wl u_t024_012/r1_w1_wl u_t024_012/r1_r0_rwl u_t024_012/r1_r1_rwl
+ u_t024_012/r2_w0_wl u_t024_012/r2_w1_wl u_t024_012/r2_r0_rwl u_t024_012/r2_r1_rwl
+ u_t024_012/r3_w0_wl u_t024_012/r3_w1_wl u_t024_012/r3_r0_rwl u_t024_012/r3_r1_rwl
+ u_t025_012/VDD u_t024_012/VSS u_t024_012/m2_717_1265# u_t024_012/m2_603_2031# u_t024_012/m2_1290_336#
+ u_t024_012/m2_2000_2037# u_t024_012/m2_791_2909# u_t024_012/m2_7_2126# u_t024_012/m2_2154_2081#
+ u_t024_012/m2_1795_2037# u_t024_012/m2_871_303# u_t024_012/m2_431_438# u_t024_012/m2_1290_2898#
+ u_t024_012/m2_1714_1210# u_t024_012/m2_431_1982# u_t024_012/m2_512_1265# u_t024_012/m2_2573_2126#
+ u_t024_012/m2_603_1259# u_t024_012/m2_2074_2909# u_t024_012/m2_7_336# u_t024_012/m2_717_2037#
+ u_t024_012/m2_1886_2031# u_t024_012/m2_2573_336# u_t024_012/m2_7_2898# u_t024_012/m2_2000_1265#
+ u_t024_012/m2_512_2037# u_t024_012/m2_1795_1265# u_t024_012/m2_1714_1982# u_t024_012/m2_1886_1259#
+ u_t024_012/m2_1290_2126# u_t024_012/m2_1714_438# u_t024_012/m2_431_1210# u_t024_012/m2_2573_2898#
+ u_t024_012/m2_2154_303# u_t024_012/m2_871_2081# VSUBS detronyx_12t_2w2r_rc4_4x4_routed_5layer_direct
Xu_t024_001 u_t024_001/c0_w0_bl u_t024_001/c0_w0_br u_t024_001/c0_w1_bl u_t024_001/c0_w1_br
+ u_t024_001/c0_r0_rbl u_t024_001/c0_r1_rbl u_t024_001/c1_w0_bl u_t024_001/c1_w0_br
+ u_t024_001/c1_w1_bl u_t024_001/c1_w1_br u_t024_001/c1_r0_rbl u_t024_001/c1_r1_rbl
+ u_t024_001/c2_w0_bl u_t024_001/c2_w0_br u_t024_001/c2_w1_bl u_t024_001/c2_w1_br
+ u_t024_001/c2_r0_rbl u_t024_001/c2_r1_rbl u_t024_001/c3_w0_bl u_t024_001/c3_w0_br
+ u_t024_001/c3_w1_bl u_t024_001/c3_w1_br u_t024_001/c3_r0_rbl u_t024_001/c3_r1_rbl
+ u_t024_001/r0_w0_wl u_t024_001/r0_w1_wl u_t024_001/r0_r0_rwl u_t024_001/r0_r1_rwl
+ u_t024_001/r1_w0_wl u_t024_001/r1_w1_wl u_t024_001/r1_r0_rwl u_t024_001/r1_r1_rwl
+ u_t024_001/r2_w0_wl u_t024_001/r2_w1_wl u_t024_001/r2_r0_rwl u_t024_001/r2_r1_rwl
+ u_t024_001/r3_w0_wl u_t024_001/r3_w1_wl u_t024_001/r3_r0_rwl u_t024_001/r3_r1_rwl
+ VSS VSS u_t024_001/m2_717_1265# u_t024_001/m2_603_2031# u_t024_001/m2_1290_336#
+ u_t024_001/m2_2000_2037# u_t024_001/m2_791_2909# u_t024_001/m2_7_2126# u_t024_001/m2_2154_2081#
+ u_t024_001/m2_1795_2037# u_t024_001/m2_871_303# u_t024_001/m2_431_438# u_t024_001/m2_1290_2898#
+ u_t024_001/m2_1714_1210# u_t024_001/m2_431_1982# u_t024_001/m2_512_1265# u_t024_001/m2_2573_2126#
+ u_t024_001/m2_603_1259# u_t024_001/m2_2074_2909# u_t024_001/m2_7_336# u_t024_001/m2_717_2037#
+ u_t024_001/m2_1886_2031# u_t024_001/m2_2573_336# u_t024_001/m2_7_2898# u_t024_001/m2_2000_1265#
+ u_t024_001/m2_512_2037# u_t024_001/m2_1795_1265# u_t024_001/m2_1714_1982# u_t024_001/m2_1886_1259#
+ u_t024_001/m2_1290_2126# u_t024_001/m2_1714_438# u_t024_001/m2_431_1210# u_t024_001/m2_2573_2898#
+ u_t024_001/m2_2154_303# u_t024_001/m2_871_2081# VSUBS detronyx_12t_2w2r_rc4_4x4_routed_5layer_direct
Xgf180mcu_as_sc_mcu7t3v3__nand3_2_57 gf180mcu_as_sc_mcu7t3v3__nand3_2_65/VDD gf180mcu_as_sc_mcu7t3v3__nand3_2_62/VSS
+ VSS VSS VSS VSS gf180mcu_as_sc_mcu7t3v3__nand3_2_65/VNW VSUBS gf180mcu_as_sc_mcu7t3v3__nand3_2
Xgf180mcu_as_sc_mcu7t3v3__inv_2_1633 gf180mcu_as_sc_mcu7t3v3__inv_2_1634/VDD gf180mcu_as_sc_mcu7t3v3__inv_2_1638/VDD
+ gf180mcu_as_sc_mcu7t3v3__inv_2_1633/Y gf180mcu_as_sc_mcu7t3v3__inv_2_1689/A gf180mcu_as_sc_mcu7t3v3__inv_2_1634/VNW
+ VSUBS gf180mcu_as_sc_mcu7t3v3__inv_2
Xgf180mcu_as_sc_mcu7t3v3__inv_2_1644 gf180mcu_as_sc_mcu7t3v3__inv_2_1649/VDD gf180mcu_as_sc_mcu7t3v3__inv_2_1665/VDD
+ VSS gf180mcu_as_sc_mcu7t3v3__inv_2_1689/A gf180mcu_as_sc_mcu7t3v3__inv_2_1649/VNW
+ VSUBS gf180mcu_as_sc_mcu7t3v3__inv_2
Xgf180mcu_as_sc_mcu7t3v3__inv_2_1677 VSS gf180mcu_as_sc_mcu7t3v3__inv_2_1689/VDD gf180mcu_as_sc_mcu7t3v3__inv_2_1689/A
+ gf180mcu_as_sc_mcu7t3v3__inv_2_1689/A gf180mcu_as_sc_mcu7t3v3__inv_2_1681/VNW VSUBS
+ gf180mcu_as_sc_mcu7t3v3__inv_2
Xgf180mcu_as_sc_mcu7t3v3__inv_2_1611 gf180mcu_as_sc_mcu7t3v3__inv_2_1689/VDD gf180mcu_as_sc_mcu7t3v3__inv_2_1689/VSS
+ gf180mcu_as_sc_mcu7t3v3__inv_2_1689/A VSS gf180mcu_as_sc_mcu7t3v3__inv_2_1689/VNW
+ VSUBS gf180mcu_as_sc_mcu7t3v3__inv_2
Xgf180mcu_as_sc_mcu7t3v3__inv_2_1600 VSS VSS gf180mcu_as_sc_mcu7t3v3__inv_2_1600/Y
+ VSS gf180mcu_as_sc_mcu7t3v3__inv_2_1601/VNW VSUBS gf180mcu_as_sc_mcu7t3v3__inv_2
Xgf180mcu_as_sc_mcu7t3v3__inv_2_1622 VSS gf180mcu_as_sc_mcu7t3v3__inv_2_1626/VDD gf180mcu_as_sc_mcu7t3v3__inv_2_1669/A
+ VSS gf180mcu_as_sc_mcu7t3v3__inv_2_1622/VNW VSUBS gf180mcu_as_sc_mcu7t3v3__inv_2
Xgf180mcu_as_sc_mcu7t3v3__inv_2_1655 gf180mcu_as_sc_mcu7t3v3__inv_2_1656/VDD gf180mcu_as_sc_mcu7t3v3__inv_2_1660/VDD
+ gf180mcu_as_sc_mcu7t3v3__inv_2_1655/Y gf180mcu_as_sc_mcu7t3v3__inv_2_1669/A gf180mcu_as_sc_mcu7t3v3__inv_2_1656/VNW
+ VSUBS gf180mcu_as_sc_mcu7t3v3__inv_2
Xgf180mcu_as_sc_mcu7t3v3__inv_2_1666 VSS gf180mcu_as_sc_mcu7t3v3__inv_2_1672/VDD VSS
+ gf180mcu_as_sc_mcu7t3v3__inv_2_1672/Y gf180mcu_as_sc_mcu7t3v3__inv_2_1668/VNW VSUBS
+ gf180mcu_as_sc_mcu7t3v3__inv_2
Xgf180mcu_as_sc_mcu7t3v3__inv_2_1688 VSS VSS gf180mcu_as_sc_mcu7t3v3__inv_2_1694/Y
+ VSS gf180mcu_as_sc_mcu7t3v3__inv_2_1688/VNW VSUBS gf180mcu_as_sc_mcu7t3v3__inv_2
Xgf180mcu_as_sc_mcu7t3v3__inv_2_1699 gf180mcu_as_sc_mcu7t3v3__nand3_2_9/VDD gf180mcu_as_sc_mcu7t3v3__nor2_2_4/VSS
+ VSS VSS gf180mcu_as_sc_mcu7t3v3__nand3_2_9/VNW VSUBS gf180mcu_as_sc_mcu7t3v3__inv_2
Xu_t015_012 u_t015_012/c0_w0_bl u_t015_012/c0_w0_br u_t015_012/c0_w1_bl u_t015_012/c0_w1_br
+ u_t015_012/c0_r0_rbl u_t015_012/c0_r1_rbl u_t015_012/c1_w0_bl u_t015_012/c1_w0_br
+ u_t015_012/c1_w1_bl u_t015_012/c1_w1_br u_t015_012/c1_r0_rbl u_t015_012/c1_r1_rbl
+ u_t015_012/c2_w0_bl u_t015_012/c2_w0_br u_t015_012/c2_w1_bl u_t015_012/c2_w1_br
+ u_t015_012/c2_r0_rbl u_t015_012/c2_r1_rbl u_t015_012/c3_w0_bl u_t015_012/c3_w0_br
+ u_t015_012/c3_w1_bl u_t015_012/c3_w1_br u_t015_012/c3_r0_rbl u_t015_012/c3_r1_rbl
+ u_t015_012/r0_w0_wl u_t015_012/r0_w1_wl u_t015_012/r0_r0_rwl u_t015_012/r0_r1_rwl
+ u_t015_012/r1_w0_wl u_t015_012/r1_w1_wl u_t015_012/r1_r0_rwl u_t015_012/r1_r1_rwl
+ u_t015_012/r2_w0_wl u_t015_012/r2_w1_wl u_t015_012/r2_r0_rwl u_t015_012/r2_r1_rwl
+ u_t015_012/r3_w0_wl u_t015_012/r3_w1_wl u_t015_012/r3_r0_rwl u_t015_012/r3_r1_rwl
+ u_t015_012/VDD u_t015_012/VSS u_t015_012/m2_717_1265# u_t015_012/m2_603_2031# u_t015_012/m2_1290_336#
+ u_t015_012/m2_2000_2037# u_t015_012/m2_791_2909# u_t015_012/m2_7_2126# u_t015_012/m2_2154_2081#
+ u_t015_012/m2_1795_2037# u_t015_012/m2_871_303# u_t015_012/m2_431_438# u_t015_012/m2_1290_2898#
+ u_t015_012/m2_1714_1210# u_t015_012/m2_431_1982# u_t015_012/m2_512_1265# u_t015_012/m2_2573_2126#
+ u_t015_012/m2_603_1259# u_t015_012/m2_2074_2909# u_t015_012/m2_7_336# u_t015_012/m2_717_2037#
+ u_t015_012/m2_1886_2031# u_t015_012/m2_2573_336# u_t015_012/m2_7_2898# u_t015_012/m2_2000_1265#
+ u_t015_012/m2_512_2037# u_t015_012/m2_1795_1265# u_t015_012/m2_1714_1982# u_t015_012/m2_1886_1259#
+ u_t015_012/m2_1290_2126# u_t015_012/m2_1714_438# u_t015_012/m2_431_1210# u_t015_012/m2_2573_2898#
+ u_t015_012/m2_2154_303# u_t015_012/m2_871_2081# VSUBS detronyx_12t_2w2r_rc4_4x4_routed_5layer_direct
Xu_t015_001 u_t015_001/c0_w0_bl u_t015_001/c0_w0_br u_t015_001/c0_w1_bl u_t015_001/c0_w1_br
+ u_t015_001/c0_r0_rbl u_t015_001/c0_r1_rbl u_t015_001/c1_w0_bl u_t015_001/c1_w0_br
+ u_t015_001/c1_w1_bl u_t015_001/c1_w1_br u_t015_001/c1_r0_rbl u_t015_001/c1_r1_rbl
+ u_t015_001/c2_w0_bl u_t015_001/c2_w0_br u_t015_001/c2_w1_bl u_t015_001/c2_w1_br
+ u_t015_001/c2_r0_rbl u_t015_001/c2_r1_rbl u_t015_001/c3_w0_bl u_t015_001/c3_w0_br
+ u_t015_001/c3_w1_bl u_t015_001/c3_w1_br u_t015_001/c3_r0_rbl u_t015_001/c3_r1_rbl
+ u_t015_001/r0_w0_wl u_t015_001/r0_w1_wl u_t015_001/r0_r0_rwl u_t015_001/r0_r1_rwl
+ u_t015_001/r1_w0_wl u_t015_001/r1_w1_wl u_t015_001/r1_r0_rwl u_t015_001/r1_r1_rwl
+ u_t015_001/r2_w0_wl u_t015_001/r2_w1_wl u_t015_001/r2_r0_rwl u_t015_001/r2_r1_rwl
+ u_t015_001/r3_w0_wl u_t015_001/r3_w1_wl u_t015_001/r3_r0_rwl u_t015_001/r3_r1_rwl
+ VSS VSS u_t015_001/m2_717_1265# u_t015_001/m2_603_2031# u_t015_001/m2_1290_336#
+ u_t015_001/m2_2000_2037# u_t015_001/m2_791_2909# u_t015_001/m2_7_2126# u_t015_001/m2_2154_2081#
+ u_t015_001/m2_1795_2037# u_t015_001/m2_871_303# u_t015_001/m2_431_438# u_t015_001/m2_1290_2898#
+ u_t015_001/m2_1714_1210# u_t015_001/m2_431_1982# u_t015_001/m2_512_1265# u_t015_001/m2_2573_2126#
+ u_t015_001/m2_603_1259# u_t015_001/m2_2074_2909# u_t015_001/m2_7_336# u_t015_001/m2_717_2037#
+ u_t015_001/m2_1886_2031# u_t015_001/m2_2573_336# u_t015_001/m2_7_2898# u_t015_001/m2_2000_1265#
+ u_t015_001/m2_512_2037# u_t015_001/m2_1795_1265# u_t015_001/m2_1714_1982# u_t015_001/m2_1886_1259#
+ u_t015_001/m2_1290_2126# u_t015_001/m2_1714_438# u_t015_001/m2_431_1210# u_t015_001/m2_2573_2898#
+ u_t015_001/m2_2154_303# u_t015_001/m2_871_2081# VSUBS detronyx_12t_2w2r_rc4_4x4_routed_5layer_direct
Xu_t030_015 u_t030_015/c0_w0_bl u_t030_015/c0_w0_br u_t030_015/c0_w1_bl u_t030_015/c0_w1_br
+ u_t030_015/c0_r0_rbl u_t030_015/c0_r1_rbl u_t030_015/c1_w0_bl u_t030_015/c1_w0_br
+ u_t030_015/c1_w1_bl u_t030_015/c1_w1_br u_t030_015/c1_r0_rbl u_t030_015/c1_r1_rbl
+ u_t030_015/c2_w0_bl u_t030_015/c2_w0_br u_t030_015/c2_w1_bl u_t030_015/c2_w1_br
+ u_t030_015/c2_r0_rbl u_t030_015/c2_r1_rbl u_t030_015/c3_w0_bl u_t030_015/c3_w0_br
+ u_t030_015/c3_w1_bl u_t030_015/c3_w1_br u_t030_015/c3_r0_rbl u_t030_015/c3_r1_rbl
+ u_t030_015/r0_w0_wl u_t030_015/r0_w1_wl u_t030_015/r0_r0_rwl u_t030_015/r0_r1_rwl
+ u_t030_015/r1_w0_wl u_t030_015/r1_w1_wl u_t030_015/r1_r0_rwl u_t030_015/r1_r1_rwl
+ u_t030_015/r2_w0_wl u_t030_015/r2_w1_wl u_t030_015/r2_r0_rwl u_t030_015/r2_r1_rwl
+ u_t030_015/r3_w0_wl u_t030_015/r3_w1_wl u_t030_015/r3_r0_rwl u_t030_015/r3_r1_rwl
+ VSS VSS u_t030_015/m2_717_1265# u_t030_015/m2_603_2031# u_t030_015/m2_1290_336#
+ u_t030_015/m2_2000_2037# u_t030_015/m2_791_2909# u_t030_015/m2_7_2126# u_t030_015/m2_2154_2081#
+ u_t030_015/m2_1795_2037# u_t030_015/m2_871_303# u_t030_015/m2_431_438# u_t030_015/m2_1290_2898#
+ u_t030_015/m2_1714_1210# u_t030_015/m2_431_1982# u_t030_015/m2_512_1265# u_t030_015/m2_2573_2126#
+ u_t030_015/m2_603_1259# u_t030_015/m2_2074_2909# u_t030_015/m2_7_336# u_t030_015/m2_717_2037#
+ u_t030_015/m2_1886_2031# u_t030_015/m2_2573_336# u_t030_015/m2_7_2898# u_t030_015/m2_2000_1265#
+ u_t030_015/m2_512_2037# u_t030_015/m2_1795_1265# u_t030_015/m2_1714_1982# u_t030_015/m2_1886_1259#
+ u_t030_015/m2_1290_2126# u_t030_015/m2_1714_438# u_t030_015/m2_431_1210# u_t030_015/m2_2573_2898#
+ u_t030_015/m2_2154_303# u_t030_015/m2_871_2081# VSUBS detronyx_12t_2w2r_rc4_4x4_routed_5layer_direct
Xu_t030_004 u_t030_004/c0_w0_bl u_t030_004/c0_w0_br u_t030_004/c0_w1_bl u_t030_004/c0_w1_br
+ u_t030_004/c0_r0_rbl u_t030_004/c0_r1_rbl u_t030_004/c1_w0_bl u_t030_004/c1_w0_br
+ u_t030_004/c1_w1_bl u_t030_004/c1_w1_br u_t030_004/c1_r0_rbl u_t030_004/c1_r1_rbl
+ u_t030_004/c2_w0_bl u_t030_004/c2_w0_br u_t030_004/c2_w1_bl u_t030_004/c2_w1_br
+ u_t030_004/c2_r0_rbl u_t030_004/c2_r1_rbl u_t030_004/c3_w0_bl u_t030_004/c3_w0_br
+ u_t030_004/c3_w1_bl u_t030_004/c3_w1_br u_t030_004/c3_r0_rbl u_t030_004/c3_r1_rbl
+ u_t030_004/r0_w0_wl u_t030_004/r0_w1_wl u_t030_004/r0_r0_rwl u_t030_004/r0_r1_rwl
+ u_t030_004/r1_w0_wl u_t030_004/r1_w1_wl u_t030_004/r1_r0_rwl u_t030_004/r1_r1_rwl
+ u_t030_004/r2_w0_wl u_t030_004/r2_w1_wl u_t030_004/r2_r0_rwl u_t030_004/r2_r1_rwl
+ u_t030_004/r3_w0_wl u_t030_004/r3_w1_wl u_t030_004/r3_r0_rwl u_t030_004/r3_r1_rwl
+ u_t030_004/VDD VSS u_t030_004/m2_717_1265# u_t030_004/m2_603_2031# u_t030_004/m2_1290_336#
+ u_t030_004/m2_2000_2037# u_t030_004/m2_791_2909# u_t030_004/m2_7_2126# u_t030_004/m2_2154_2081#
+ u_t030_004/m2_1795_2037# u_t030_004/m2_871_303# u_t030_004/m2_431_438# u_t030_004/m2_1290_2898#
+ u_t030_004/m2_1714_1210# u_t030_004/m2_431_1982# u_t030_004/m2_512_1265# u_t030_004/m2_2573_2126#
+ u_t030_004/m2_603_1259# u_t030_004/m2_2074_2909# u_t030_004/m2_7_336# u_t030_004/m2_717_2037#
+ u_t030_004/m2_1886_2031# u_t030_004/m2_2573_336# u_t030_004/m2_7_2898# u_t030_004/m2_2000_1265#
+ u_t030_004/m2_512_2037# u_t030_004/m2_1795_1265# u_t030_004/m2_1714_1982# u_t030_004/m2_1886_1259#
+ u_t030_004/m2_1290_2126# u_t030_004/m2_1714_438# u_t030_004/m2_431_1210# u_t030_004/m2_2573_2898#
+ u_t030_004/m2_2154_303# u_t030_004/m2_871_2081# VSUBS detronyx_12t_2w2r_rc4_4x4_routed_5layer_direct
Xgf180mcu_as_sc_mcu7t3v3__nand4_2_438 VSS VSS VSS VSS VSS VSS VSS gf180mcu_as_sc_mcu7t3v3__inv_2_1585/VNW
+ VSUBS gf180mcu_as_sc_mcu7t3v3__nand4_2
Xgf180mcu_as_sc_mcu7t3v3__nand4_2_427 gf180mcu_as_sc_mcu7t3v3__inv_2_1553/VDD gf180mcu_as_sc_mcu7t3v3__inv_2_1556/VDD
+ VSS VSS VSS VSS gf180mcu_as_sc_mcu7t3v3__nand4_2_427/Y gf180mcu_as_sc_mcu7t3v3__inv_2_1553/VNW
+ VSUBS gf180mcu_as_sc_mcu7t3v3__nand4_2
Xgf180mcu_as_sc_mcu7t3v3__nand4_2_416 VSS gf180mcu_as_sc_mcu7t3v3__inv_2_1523/VDD
+ VSS VSS VSS VSS gf180mcu_as_sc_mcu7t3v3__nand4_2_416/Y gf180mcu_as_sc_mcu7t3v3__inv_2_1520/VNW
+ VSUBS gf180mcu_as_sc_mcu7t3v3__nand4_2
Xgf180mcu_as_sc_mcu7t3v3__nand4_2_405 VSS VSS VSS VSS VSS VSS VSS gf180mcu_as_sc_mcu7t3v3__inv_2_1485/VNW
+ VSUBS gf180mcu_as_sc_mcu7t3v3__nand4_2
Xgf180mcu_as_sc_mcu7t3v3__inv_2_6 gf180mcu_as_sc_mcu7t3v3__inv_2_8/VDD gf180mcu_as_sc_mcu7t3v3__inv_2_8/VSS
+ VSS gf180mcu_as_sc_mcu7t3v3__inv_2_8/Y gf180mcu_as_sc_mcu7t3v3__inv_2_8/VNW VSUBS
+ gf180mcu_as_sc_mcu7t3v3__inv_2
Xgf180mcu_as_sc_mcu7t3v3__nand4_2_449 VSS VSS VSS VSS VSS VSS VSS gf180mcu_as_sc_mcu7t3v3__inv_2_1332/VNW
+ VSUBS gf180mcu_as_sc_mcu7t3v3__nand4_2
Xu_t021_015 u_t021_015/c0_w0_bl u_t021_015/c0_w0_br u_t021_015/c0_w1_bl u_t021_015/c0_w1_br
+ u_t021_015/c0_r0_rbl u_t021_015/c0_r1_rbl u_t021_015/c1_w0_bl u_t021_015/c1_w0_br
+ u_t021_015/c1_w1_bl u_t021_015/c1_w1_br u_t021_015/c1_r0_rbl u_t021_015/c1_r1_rbl
+ u_t021_015/c2_w0_bl u_t021_015/c2_w0_br u_t021_015/c2_w1_bl u_t021_015/c2_w1_br
+ u_t021_015/c2_r0_rbl u_t021_015/c2_r1_rbl u_t021_015/c3_w0_bl u_t021_015/c3_w0_br
+ u_t021_015/c3_w1_bl u_t021_015/c3_w1_br u_t021_015/c3_r0_rbl u_t021_015/c3_r1_rbl
+ u_t021_015/r0_w0_wl u_t021_015/r0_w1_wl u_t021_015/r0_r0_rwl u_t021_015/r0_r1_rwl
+ u_t021_015/r1_w0_wl u_t021_015/r1_w1_wl u_t021_015/r1_r0_rwl u_t021_015/r1_r1_rwl
+ u_t021_015/r2_w0_wl u_t021_015/r2_w1_wl u_t021_015/r2_r0_rwl u_t021_015/r2_r1_rwl
+ u_t021_015/r3_w0_wl u_t021_015/r3_w1_wl u_t021_015/r3_r0_rwl u_t021_015/r3_r1_rwl
+ VSS VSS u_t021_015/m2_717_1265# u_t021_015/m2_603_2031# u_t021_015/m2_1290_336#
+ u_t021_015/m2_2000_2037# u_t021_015/m2_791_2909# u_t021_015/m2_7_2126# u_t021_015/m2_2154_2081#
+ u_t021_015/m2_1795_2037# u_t021_015/m2_871_303# u_t021_015/m2_431_438# u_t021_015/m2_1290_2898#
+ u_t021_015/m2_1714_1210# u_t021_015/m2_431_1982# u_t021_015/m2_512_1265# u_t021_015/m2_2573_2126#
+ u_t021_015/m2_603_1259# u_t021_015/m2_2074_2909# u_t021_015/m2_7_336# u_t021_015/m2_717_2037#
+ u_t021_015/m2_1886_2031# u_t021_015/m2_2573_336# u_t021_015/m2_7_2898# u_t021_015/m2_2000_1265#
+ u_t021_015/m2_512_2037# u_t021_015/m2_1795_1265# u_t021_015/m2_1714_1982# u_t021_015/m2_1886_1259#
+ u_t021_015/m2_1290_2126# u_t021_015/m2_1714_438# u_t021_015/m2_431_1210# u_t021_015/m2_2573_2898#
+ u_t021_015/m2_2154_303# u_t021_015/m2_871_2081# VSUBS detronyx_12t_2w2r_rc4_4x4_routed_5layer_direct
Xu_t006_012 u_t006_012/c0_w0_bl u_t006_012/c0_w0_br u_t006_012/c0_w1_bl u_t006_012/c0_w1_br
+ u_t006_012/c0_r0_rbl u_t006_012/c0_r1_rbl u_t006_012/c1_w0_bl u_t006_012/c1_w0_br
+ u_t006_012/c1_w1_bl u_t006_012/c1_w1_br u_t006_012/c1_r0_rbl u_t006_012/c1_r1_rbl
+ u_t006_012/c2_w0_bl u_t006_012/c2_w0_br u_t006_012/c2_w1_bl u_t006_012/c2_w1_br
+ u_t006_012/c2_r0_rbl u_t006_012/c2_r1_rbl u_t006_012/c3_w0_bl u_t006_012/c3_w0_br
+ u_t006_012/c3_w1_bl u_t006_012/c3_w1_br u_t006_012/c3_r0_rbl u_t006_012/c3_r1_rbl
+ u_t006_012/r0_w0_wl u_t006_012/r0_w1_wl u_t006_012/r0_r0_rwl u_t006_012/r0_r1_rwl
+ u_t006_012/r1_w0_wl u_t006_012/r1_w1_wl u_t006_012/r1_r0_rwl u_t006_012/r1_r1_rwl
+ u_t006_012/r2_w0_wl u_t006_012/r2_w1_wl u_t006_012/r2_r0_rwl u_t006_012/r2_r1_rwl
+ u_t006_012/r3_w0_wl u_t006_012/r3_w1_wl u_t006_012/r3_r0_rwl u_t006_012/r3_r1_rwl
+ u_t006_012/VDD u_t006_012/VSS u_t006_012/m2_717_1265# u_t006_012/m2_603_2031# u_t006_012/m2_1290_336#
+ u_t006_012/m2_2000_2037# u_t006_012/m2_791_2909# u_t006_012/m2_7_2126# u_t006_012/m2_2154_2081#
+ u_t006_012/m2_1795_2037# u_t006_012/m2_871_303# u_t006_012/m2_431_438# u_t006_012/m2_1290_2898#
+ u_t006_012/m2_1714_1210# u_t006_012/m2_431_1982# u_t006_012/m2_512_1265# u_t006_012/m2_2573_2126#
+ u_t006_012/m2_603_1259# u_t006_012/m2_2074_2909# u_t006_012/m2_7_336# u_t006_012/m2_717_2037#
+ u_t006_012/m2_1886_2031# u_t006_012/m2_2573_336# u_t006_012/m2_7_2898# u_t006_012/m2_2000_1265#
+ u_t006_012/m2_512_2037# u_t006_012/m2_1795_1265# u_t006_012/m2_1714_1982# u_t006_012/m2_1886_1259#
+ u_t006_012/m2_1290_2126# u_t006_012/m2_1714_438# u_t006_012/m2_431_1210# u_t006_012/m2_2573_2898#
+ u_t006_012/m2_2154_303# u_t006_012/m2_871_2081# VSUBS detronyx_12t_2w2r_rc4_4x4_routed_5layer_direct
Xu_t021_004 u_t021_004/c0_w0_bl u_t021_004/c0_w0_br u_t021_004/c0_w1_bl u_t021_004/c0_w1_br
+ u_t021_004/c0_r0_rbl u_t021_004/c0_r1_rbl u_t021_004/c1_w0_bl u_t021_004/c1_w0_br
+ u_t021_004/c1_w1_bl u_t021_004/c1_w1_br u_t021_004/c1_r0_rbl u_t021_004/c1_r1_rbl
+ u_t021_004/c2_w0_bl u_t021_004/c2_w0_br u_t021_004/c2_w1_bl u_t021_004/c2_w1_br
+ u_t021_004/c2_r0_rbl u_t021_004/c2_r1_rbl u_t021_004/c3_w0_bl u_t021_004/c3_w0_br
+ u_t021_004/c3_w1_bl u_t021_004/c3_w1_br u_t021_004/c3_r0_rbl u_t021_004/c3_r1_rbl
+ u_t021_004/r0_w0_wl u_t021_004/r0_w1_wl u_t021_004/r0_r0_rwl u_t021_004/r0_r1_rwl
+ u_t021_004/r1_w0_wl u_t021_004/r1_w1_wl u_t021_004/r1_r0_rwl u_t021_004/r1_r1_rwl
+ u_t021_004/r2_w0_wl u_t021_004/r2_w1_wl u_t021_004/r2_r0_rwl u_t021_004/r2_r1_rwl
+ u_t021_004/r3_w0_wl u_t021_004/r3_w1_wl u_t021_004/r3_r0_rwl u_t021_004/r3_r1_rwl
+ u_t021_004/VDD VSS u_t021_004/m2_717_1265# u_t021_004/m2_603_2031# u_t021_004/m2_1290_336#
+ u_t021_004/m2_2000_2037# u_t021_004/m2_791_2909# u_t021_004/m2_7_2126# u_t021_004/m2_2154_2081#
+ u_t021_004/m2_1795_2037# u_t021_004/m2_871_303# u_t021_004/m2_431_438# u_t021_004/m2_1290_2898#
+ u_t021_004/m2_1714_1210# u_t021_004/m2_431_1982# u_t021_004/m2_512_1265# u_t021_004/m2_2573_2126#
+ u_t021_004/m2_603_1259# u_t021_004/m2_2074_2909# u_t021_004/m2_7_336# u_t021_004/m2_717_2037#
+ u_t021_004/m2_1886_2031# u_t021_004/m2_2573_336# u_t021_004/m2_7_2898# u_t021_004/m2_2000_1265#
+ u_t021_004/m2_512_2037# u_t021_004/m2_1795_1265# u_t021_004/m2_1714_1982# u_t021_004/m2_1886_1259#
+ u_t021_004/m2_1290_2126# u_t021_004/m2_1714_438# u_t021_004/m2_431_1210# u_t021_004/m2_2573_2898#
+ u_t021_004/m2_2154_303# u_t021_004/m2_871_2081# VSUBS detronyx_12t_2w2r_rc4_4x4_routed_5layer_direct
Xu_t006_001 u_t006_001/c0_w0_bl u_t006_001/c0_w0_br u_t006_001/c0_w1_bl u_t006_001/c0_w1_br
+ u_t006_001/c0_r0_rbl u_t006_001/c0_r1_rbl u_t006_001/c1_w0_bl u_t006_001/c1_w0_br
+ u_t006_001/c1_w1_bl u_t006_001/c1_w1_br u_t006_001/c1_r0_rbl u_t006_001/c1_r1_rbl
+ u_t006_001/c2_w0_bl u_t006_001/c2_w0_br u_t006_001/c2_w1_bl u_t006_001/c2_w1_br
+ u_t006_001/c2_r0_rbl u_t006_001/c2_r1_rbl u_t006_001/c3_w0_bl u_t006_001/c3_w0_br
+ u_t006_001/c3_w1_bl u_t006_001/c3_w1_br u_t006_001/c3_r0_rbl u_t006_001/c3_r1_rbl
+ u_t006_001/r0_w0_wl u_t006_001/r0_w1_wl u_t006_001/r0_r0_rwl u_t006_001/r0_r1_rwl
+ u_t006_001/r1_w0_wl u_t006_001/r1_w1_wl u_t006_001/r1_r0_rwl u_t006_001/r1_r1_rwl
+ u_t006_001/r2_w0_wl u_t006_001/r2_w1_wl u_t006_001/r2_r0_rwl u_t006_001/r2_r1_rwl
+ u_t006_001/r3_w0_wl u_t006_001/r3_w1_wl u_t006_001/r3_r0_rwl u_t006_001/r3_r1_rwl
+ VSS VSS u_t006_001/m2_717_1265# u_t006_001/m2_603_2031# u_t006_001/m2_1290_336#
+ u_t006_001/m2_2000_2037# u_t006_001/m2_791_2909# u_t006_001/m2_7_2126# u_t006_001/m2_2154_2081#
+ u_t006_001/m2_1795_2037# u_t006_001/m2_871_303# u_t006_001/m2_431_438# u_t006_001/m2_1290_2898#
+ u_t006_001/m2_1714_1210# u_t006_001/m2_431_1982# u_t006_001/m2_512_1265# u_t006_001/m2_2573_2126#
+ u_t006_001/m2_603_1259# u_t006_001/m2_2074_2909# u_t006_001/m2_7_336# u_t006_001/m2_717_2037#
+ u_t006_001/m2_1886_2031# u_t006_001/m2_2573_336# u_t006_001/m2_7_2898# u_t006_001/m2_2000_1265#
+ u_t006_001/m2_512_2037# u_t006_001/m2_1795_1265# u_t006_001/m2_1714_1982# u_t006_001/m2_1886_1259#
+ u_t006_001/m2_1290_2126# u_t006_001/m2_1714_438# u_t006_001/m2_431_1210# u_t006_001/m2_2573_2898#
+ u_t006_001/m2_2154_303# u_t006_001/m2_871_2081# VSUBS detronyx_12t_2w2r_rc4_4x4_routed_5layer_direct
Xu_t012_015 u_t012_015/c0_w0_bl u_t012_015/c0_w0_br u_t012_015/c0_w1_bl u_t012_015/c0_w1_br
+ u_t012_015/c0_r0_rbl u_t012_015/c0_r1_rbl u_t012_015/c1_w0_bl u_t012_015/c1_w0_br
+ u_t012_015/c1_w1_bl u_t012_015/c1_w1_br u_t012_015/c1_r0_rbl u_t012_015/c1_r1_rbl
+ u_t012_015/c2_w0_bl u_t012_015/c2_w0_br u_t012_015/c2_w1_bl u_t012_015/c2_w1_br
+ u_t012_015/c2_r0_rbl u_t012_015/c2_r1_rbl u_t012_015/c3_w0_bl u_t012_015/c3_w0_br
+ u_t012_015/c3_w1_bl u_t012_015/c3_w1_br u_t012_015/c3_r0_rbl u_t012_015/c3_r1_rbl
+ u_t012_015/r0_w0_wl u_t012_015/r0_w1_wl u_t012_015/r0_r0_rwl u_t012_015/r0_r1_rwl
+ u_t012_015/r1_w0_wl u_t012_015/r1_w1_wl u_t012_015/r1_r0_rwl u_t012_015/r1_r1_rwl
+ u_t012_015/r2_w0_wl u_t012_015/r2_w1_wl u_t012_015/r2_r0_rwl u_t012_015/r2_r1_rwl
+ u_t012_015/r3_w0_wl u_t012_015/r3_w1_wl u_t012_015/r3_r0_rwl u_t012_015/r3_r1_rwl
+ VSS VSS u_t012_015/m2_717_1265# u_t012_015/m2_603_2031# u_t012_015/m2_1290_336#
+ u_t012_015/m2_2000_2037# u_t012_015/m2_791_2909# u_t012_015/m2_7_2126# u_t012_015/m2_2154_2081#
+ u_t012_015/m2_1795_2037# u_t012_015/m2_871_303# u_t012_015/m2_431_438# u_t012_015/m2_1290_2898#
+ u_t012_015/m2_1714_1210# u_t012_015/m2_431_1982# u_t012_015/m2_512_1265# u_t012_015/m2_2573_2126#
+ u_t012_015/m2_603_1259# u_t012_015/m2_2074_2909# u_t012_015/m2_7_336# u_t012_015/m2_717_2037#
+ u_t012_015/m2_1886_2031# u_t012_015/m2_2573_336# u_t012_015/m2_7_2898# u_t012_015/m2_2000_1265#
+ u_t012_015/m2_512_2037# u_t012_015/m2_1795_1265# u_t012_015/m2_1714_1982# u_t012_015/m2_1886_1259#
+ u_t012_015/m2_1290_2126# u_t012_015/m2_1714_438# u_t012_015/m2_431_1210# u_t012_015/m2_2573_2898#
+ u_t012_015/m2_2154_303# u_t012_015/m2_871_2081# VSUBS detronyx_12t_2w2r_rc4_4x4_routed_5layer_direct
Xu_t012_004 u_t012_004/c0_w0_bl u_t012_004/c0_w0_br u_t012_004/c0_w1_bl u_t012_004/c0_w1_br
+ u_t012_004/c0_r0_rbl u_t012_004/c0_r1_rbl u_t012_004/c1_w0_bl u_t012_004/c1_w0_br
+ u_t012_004/c1_w1_bl u_t012_004/c1_w1_br u_t012_004/c1_r0_rbl u_t012_004/c1_r1_rbl
+ u_t012_004/c2_w0_bl u_t012_004/c2_w0_br u_t012_004/c2_w1_bl u_t012_004/c2_w1_br
+ u_t012_004/c2_r0_rbl u_t012_004/c2_r1_rbl u_t012_004/c3_w0_bl u_t012_004/c3_w0_br
+ u_t012_004/c3_w1_bl u_t012_004/c3_w1_br u_t012_004/c3_r0_rbl u_t012_004/c3_r1_rbl
+ u_t012_004/r0_w0_wl u_t012_004/r0_w1_wl u_t012_004/r0_r0_rwl u_t012_004/r0_r1_rwl
+ u_t012_004/r1_w0_wl u_t012_004/r1_w1_wl u_t012_004/r1_r0_rwl u_t012_004/r1_r1_rwl
+ u_t012_004/r2_w0_wl u_t012_004/r2_w1_wl u_t012_004/r2_r0_rwl u_t012_004/r2_r1_rwl
+ u_t012_004/r3_w0_wl u_t012_004/r3_w1_wl u_t012_004/r3_r0_rwl u_t012_004/r3_r1_rwl
+ u_t012_004/VDD VSS u_t012_004/m2_717_1265# u_t012_004/m2_603_2031# u_t012_004/m2_1290_336#
+ u_t012_004/m2_2000_2037# u_t012_004/m2_791_2909# u_t012_004/m2_7_2126# u_t012_004/m2_2154_2081#
+ u_t012_004/m2_1795_2037# u_t012_004/m2_871_303# u_t012_004/m2_431_438# u_t012_004/m2_1290_2898#
+ u_t012_004/m2_1714_1210# u_t012_004/m2_431_1982# u_t012_004/m2_512_1265# u_t012_004/m2_2573_2126#
+ u_t012_004/m2_603_1259# u_t012_004/m2_2074_2909# u_t012_004/m2_7_336# u_t012_004/m2_717_2037#
+ u_t012_004/m2_1886_2031# u_t012_004/m2_2573_336# u_t012_004/m2_7_2898# u_t012_004/m2_2000_1265#
+ u_t012_004/m2_512_2037# u_t012_004/m2_1795_1265# u_t012_004/m2_1714_1982# u_t012_004/m2_1886_1259#
+ u_t012_004/m2_1290_2126# u_t012_004/m2_1714_438# u_t012_004/m2_431_1210# u_t012_004/m2_2573_2898#
+ u_t012_004/m2_2154_303# u_t012_004/m2_871_2081# VSUBS detronyx_12t_2w2r_rc4_4x4_routed_5layer_direct
Xgf180mcu_as_sc_mcu7t3v3__inv_2_1474 VSS gf180mcu_as_sc_mcu7t3v3__inv_2_1476/VSS VSS
+ VSS gf180mcu_as_sc_mcu7t3v3__inv_2_1476/VNW VSUBS gf180mcu_as_sc_mcu7t3v3__inv_2
Xgf180mcu_as_sc_mcu7t3v3__inv_2_1463 gf180mcu_as_sc_mcu7t3v3__inv_2_1476/VSS gf180mcu_as_sc_mcu7t3v3__inv_2_1482/VDD
+ gf180mcu_as_sc_mcu7t3v3__inv_2_1463/Y VSS gf180mcu_as_sc_mcu7t3v3__inv_2_1464/VNW
+ VSUBS gf180mcu_as_sc_mcu7t3v3__inv_2
Xgf180mcu_as_sc_mcu7t3v3__inv_2_1485 VSS VSS VSS VSS gf180mcu_as_sc_mcu7t3v3__inv_2_1485/VNW
+ VSUBS gf180mcu_as_sc_mcu7t3v3__inv_2
Xgf180mcu_as_sc_mcu7t3v3__inv_2_1496 VSS gf180mcu_as_sc_mcu7t3v3__inv_2_1500/VDD gf180mcu_as_sc_mcu7t3v3__inv_2_1496/Y
+ VSS gf180mcu_as_sc_mcu7t3v3__inv_2_1497/VNW VSUBS gf180mcu_as_sc_mcu7t3v3__inv_2
Xgf180mcu_as_sc_mcu7t3v3__inv_2_1452 gf180mcu_as_sc_mcu7t3v3__inv_2_1452/VDD gf180mcu_as_sc_mcu7t3v3__inv_2_1455/VDD
+ gf180mcu_as_sc_mcu7t3v3__inv_2_1452/Y VSS gf180mcu_as_sc_mcu7t3v3__inv_2_1452/VNW
+ VSUBS gf180mcu_as_sc_mcu7t3v3__inv_2
Xgf180mcu_as_sc_mcu7t3v3__inv_2_1441 gf180mcu_as_sc_mcu7t3v3__inv_2_1443/VDD gf180mcu_as_sc_mcu7t3v3__inv_2_1446/VDD
+ VSS VSS gf180mcu_as_sc_mcu7t3v3__inv_2_1443/VNW VSUBS gf180mcu_as_sc_mcu7t3v3__inv_2
Xgf180mcu_as_sc_mcu7t3v3__inv_2_1430 VSS gf180mcu_as_sc_mcu7t3v3__inv_2_1434/VDD gf180mcu_as_sc_mcu7t3v3__inv_2_1430/Y
+ VSS gf180mcu_as_sc_mcu7t3v3__inv_2_1431/VNW VSUBS gf180mcu_as_sc_mcu7t3v3__inv_2
Xu_t003_015 u_t003_015/c0_w0_bl u_t003_015/c0_w0_br u_t003_015/c0_w1_bl u_t003_015/c0_w1_br
+ u_t003_015/c0_r0_rbl u_t003_015/c0_r1_rbl u_t003_015/c1_w0_bl u_t003_015/c1_w0_br
+ u_t003_015/c1_w1_bl u_t003_015/c1_w1_br u_t003_015/c1_r0_rbl u_t003_015/c1_r1_rbl
+ u_t003_015/c2_w0_bl u_t003_015/c2_w0_br u_t003_015/c2_w1_bl u_t003_015/c2_w1_br
+ u_t003_015/c2_r0_rbl u_t003_015/c2_r1_rbl u_t003_015/c3_w0_bl u_t003_015/c3_w0_br
+ u_t003_015/c3_w1_bl u_t003_015/c3_w1_br u_t003_015/c3_r0_rbl u_t003_015/c3_r1_rbl
+ u_t003_015/r0_w0_wl u_t003_015/r0_w1_wl u_t003_015/r0_r0_rwl u_t003_015/r0_r1_rwl
+ u_t003_015/r1_w0_wl u_t003_015/r1_w1_wl u_t003_015/r1_r0_rwl u_t003_015/r1_r1_rwl
+ u_t003_015/r2_w0_wl u_t003_015/r2_w1_wl u_t003_015/r2_r0_rwl u_t003_015/r2_r1_rwl
+ u_t003_015/r3_w0_wl u_t003_015/r3_w1_wl u_t003_015/r3_r0_rwl u_t003_015/r3_r1_rwl
+ VSS u_t003_015/VSS u_t003_015/m2_717_1265# u_t003_015/m2_603_2031# u_t003_015/m2_1290_336#
+ u_t003_015/m2_2000_2037# u_t003_015/m2_791_2909# u_t003_015/m2_7_2126# u_t003_015/m2_2154_2081#
+ u_t003_015/m2_1795_2037# u_t003_015/m2_871_303# u_t003_015/m2_431_438# u_t003_015/m2_1290_2898#
+ u_t003_015/m2_1714_1210# u_t003_015/m2_431_1982# u_t003_015/m2_512_1265# u_t003_015/m2_2573_2126#
+ u_t003_015/m2_603_1259# u_t003_015/m2_2074_2909# u_t003_015/m2_7_336# u_t003_015/m2_717_2037#
+ u_t003_015/m2_1886_2031# u_t003_015/m2_2573_336# u_t003_015/m2_7_2898# u_t003_015/m2_2000_1265#
+ u_t003_015/m2_512_2037# u_t003_015/m2_1795_1265# u_t003_015/m2_1714_1982# u_t003_015/m2_1886_1259#
+ u_t003_015/m2_1290_2126# u_t003_015/m2_1714_438# u_t003_015/m2_431_1210# u_t003_015/m2_2573_2898#
+ u_t003_015/m2_2154_303# u_t003_015/m2_871_2081# VSUBS detronyx_12t_2w2r_rc4_4x4_routed_5layer_direct
Xu_t003_004 u_t003_004/c0_w0_bl u_t003_004/c0_w0_br u_t003_004/c0_w1_bl u_t003_004/c0_w1_br
+ u_t003_004/c0_r0_rbl u_t003_004/c0_r1_rbl u_t003_004/c1_w0_bl u_t003_004/c1_w0_br
+ u_t003_004/c1_w1_bl u_t003_004/c1_w1_br u_t003_004/c1_r0_rbl u_t003_004/c1_r1_rbl
+ u_t003_004/c2_w0_bl u_t003_004/c2_w0_br u_t003_004/c2_w1_bl u_t003_004/c2_w1_br
+ u_t003_004/c2_r0_rbl u_t003_004/c2_r1_rbl u_t003_004/c3_w0_bl u_t003_004/c3_w0_br
+ u_t003_004/c3_w1_bl u_t003_004/c3_w1_br u_t003_004/c3_r0_rbl u_t003_004/c3_r1_rbl
+ u_t003_004/r0_w0_wl u_t003_004/r0_w1_wl u_t003_004/r0_r0_rwl u_t003_004/r0_r1_rwl
+ u_t003_004/r1_w0_wl u_t003_004/r1_w1_wl u_t003_004/r1_r0_rwl u_t003_004/r1_r1_rwl
+ u_t003_004/r2_w0_wl u_t003_004/r2_w1_wl u_t003_004/r2_r0_rwl u_t003_004/r2_r1_rwl
+ u_t003_004/r3_w0_wl u_t003_004/r3_w1_wl u_t003_004/r3_r0_rwl u_t003_004/r3_r1_rwl
+ u_t004_004/VDD u_t003_004/VSS u_t003_004/m2_717_1265# u_t003_004/m2_603_2031# u_t003_004/m2_1290_336#
+ u_t003_004/m2_2000_2037# u_t003_004/m2_791_2909# u_t003_004/m2_7_2126# u_t003_004/m2_2154_2081#
+ u_t003_004/m2_1795_2037# u_t003_004/m2_871_303# u_t003_004/m2_431_438# u_t003_004/m2_1290_2898#
+ u_t003_004/m2_1714_1210# u_t003_004/m2_431_1982# u_t003_004/m2_512_1265# u_t003_004/m2_2573_2126#
+ u_t003_004/m2_603_1259# u_t003_004/m2_2074_2909# u_t003_004/m2_7_336# u_t003_004/m2_717_2037#
+ u_t003_004/m2_1886_2031# u_t003_004/m2_2573_336# u_t003_004/m2_7_2898# u_t003_004/m2_2000_1265#
+ u_t003_004/m2_512_2037# u_t003_004/m2_1795_1265# u_t003_004/m2_1714_1982# u_t003_004/m2_1886_1259#
+ u_t003_004/m2_1290_2126# u_t003_004/m2_1714_438# u_t003_004/m2_431_1210# u_t003_004/m2_2573_2898#
+ u_t003_004/m2_2154_303# u_t003_004/m2_871_2081# VSUBS detronyx_12t_2w2r_rc4_4x4_routed_5layer_direct
Xgf180mcu_as_sc_mcu7t3v3__inv_2_914 VSS VSS VSS VSS gf180mcu_as_sc_mcu7t3v3__inv_2_945/VNW
+ VSUBS gf180mcu_as_sc_mcu7t3v3__inv_2
Xgf180mcu_as_sc_mcu7t3v3__inv_2_947 VSS VSS VSS VSS gf180mcu_as_sc_mcu7t3v3__inv_2_947/VNW
+ VSUBS gf180mcu_as_sc_mcu7t3v3__inv_2
Xgf180mcu_as_sc_mcu7t3v3__inv_2_903 VSS VSS VSS VSS gf180mcu_as_sc_mcu7t3v3__inv_2_951/VNW
+ VSUBS gf180mcu_as_sc_mcu7t3v3__inv_2
Xgf180mcu_as_sc_mcu7t3v3__inv_2_936 VSS VSS VSS VSS gf180mcu_as_sc_mcu7t3v3__inv_2_936/VNW
+ VSUBS gf180mcu_as_sc_mcu7t3v3__inv_2
Xgf180mcu_as_sc_mcu7t3v3__inv_2_969 VSS gf180mcu_as_sc_mcu7t3v3__inv_2_989/VDD gf180mcu_as_sc_mcu7t3v3__inv_2_969/Y
+ VSS gf180mcu_as_sc_mcu7t3v3__inv_2_969/VNW VSUBS gf180mcu_as_sc_mcu7t3v3__inv_2
Xgf180mcu_as_sc_mcu7t3v3__inv_2_958 VSS VSS VSS VSS gf180mcu_as_sc_mcu7t3v3__inv_2_959/VNW
+ VSUBS gf180mcu_as_sc_mcu7t3v3__inv_2
Xgf180mcu_as_sc_mcu7t3v3__inv_2_925 VSS VSS VSS VSS gf180mcu_as_sc_mcu7t3v3__inv_2_925/VNW
+ VSUBS gf180mcu_as_sc_mcu7t3v3__inv_2
Xgf180mcu_as_sc_mcu7t3v3__nand4_2_202 VSS VSS VSS VSS VSS VSS VSS gf180mcu_as_sc_mcu7t3v3__inv_2_692/VNW
+ VSUBS gf180mcu_as_sc_mcu7t3v3__nand4_2
Xgf180mcu_as_sc_mcu7t3v3__nand4_2_224 VSS VSS VSS VSS VSS VSS VSS gf180mcu_as_sc_mcu7t3v3__inv_2_824/VNW
+ VSUBS gf180mcu_as_sc_mcu7t3v3__nand4_2
Xgf180mcu_as_sc_mcu7t3v3__nand4_2_213 VSS VSS VSS VSS VSS VSS VSS gf180mcu_as_sc_mcu7t3v3__inv_2_828/VNW
+ VSUBS gf180mcu_as_sc_mcu7t3v3__nand4_2
Xgf180mcu_as_sc_mcu7t3v3__nand4_2_235 VSS VSS VSS VSS VSS VSS VSS gf180mcu_as_sc_mcu7t3v3__inv_2_843/VNW
+ VSUBS gf180mcu_as_sc_mcu7t3v3__nand4_2
Xgf180mcu_as_sc_mcu7t3v3__nand4_2_268 VSS VSS VSS VSS VSS VSS VSS gf180mcu_as_sc_mcu7t3v3__inv_2_926/VNW
+ VSUBS gf180mcu_as_sc_mcu7t3v3__nand4_2
Xgf180mcu_as_sc_mcu7t3v3__nand4_2_279 VSS VSS VSS VSS VSS VSS gf180mcu_as_sc_mcu7t3v3__nand4_2_279/Y
+ gf180mcu_as_sc_mcu7t3v3__inv_2_946/VNW VSUBS gf180mcu_as_sc_mcu7t3v3__nand4_2
Xgf180mcu_as_sc_mcu7t3v3__nand4_2_246 VSS VSS VSS VSS VSS VSS gf180mcu_as_sc_mcu7t3v3__nand4_2_246/Y
+ gf180mcu_as_sc_mcu7t3v3__inv_2_841/VNW VSUBS gf180mcu_as_sc_mcu7t3v3__nand4_2
Xgf180mcu_as_sc_mcu7t3v3__nand4_2_257 VSS VSS VSS VSS VSS VSS VSS gf180mcu_as_sc_mcu7t3v3__inv_2_929/VNW
+ VSUBS gf180mcu_as_sc_mcu7t3v3__nand4_2
Xu_t000_007 u_t000_007/c0_w0_bl u_t000_007/c0_w0_br u_t000_007/c0_w1_bl u_t000_007/c0_w1_br
+ u_t000_007/c0_r0_rbl u_t000_007/c0_r1_rbl u_t000_007/c1_w0_bl u_t000_007/c1_w0_br
+ u_t000_007/c1_w1_bl u_t000_007/c1_w1_br u_t000_007/c1_r0_rbl u_t000_007/c1_r1_rbl
+ u_t000_007/c2_w0_bl u_t000_007/c2_w0_br u_t000_007/c2_w1_bl u_t000_007/c2_w1_br
+ u_t000_007/c2_r0_rbl u_t000_007/c2_r1_rbl u_t000_007/c3_w0_bl u_t000_007/c3_w0_br
+ u_t000_007/c3_w1_bl u_t000_007/c3_w1_br u_t000_007/c3_r0_rbl u_t000_007/c3_r1_rbl
+ u_t000_007/r0_w0_wl u_t000_007/r0_w1_wl u_t000_007/r0_r0_rwl u_t000_007/r0_r1_rwl
+ u_t000_007/r1_w0_wl u_t000_007/r1_w1_wl u_t000_007/r1_r0_rwl u_t000_007/r1_r1_rwl
+ u_t000_007/r2_w0_wl u_t000_007/r2_w1_wl u_t000_007/r2_r0_rwl u_t000_007/r2_r1_rwl
+ u_t000_007/r3_w0_wl u_t000_007/r3_w1_wl u_t000_007/r3_r0_rwl u_t000_007/r3_r1_rwl
+ VSS VSS u_t000_007/m2_717_1265# u_t000_007/m2_603_2031# u_t000_007/m2_1290_336#
+ u_t000_007/m2_2000_2037# u_t000_007/m2_791_2909# u_t000_007/m2_7_2126# u_t000_007/m2_2154_2081#
+ u_t000_007/m2_1795_2037# u_t000_007/m2_871_303# u_t000_007/m2_431_438# u_t000_007/m2_1290_2898#
+ u_t000_007/m2_1714_1210# u_t000_007/m2_431_1982# u_t000_007/m2_512_1265# u_t000_007/m2_2573_2126#
+ u_t000_007/m2_603_1259# u_t000_007/m2_2074_2909# u_t000_007/m2_7_336# u_t000_007/m2_717_2037#
+ u_t000_007/m2_1886_2031# u_t000_007/m2_2573_336# u_t000_007/m2_7_2898# u_t000_007/m2_2000_1265#
+ u_t000_007/m2_512_2037# u_t000_007/m2_1795_1265# u_t000_007/m2_1714_1982# u_t000_007/m2_1886_1259#
+ u_t000_007/m2_1290_2126# u_t000_007/m2_1714_438# u_t000_007/m2_431_1210# u_t000_007/m2_2573_2898#
+ u_t000_007/m2_2154_303# u_t000_007/m2_871_2081# VSUBS detronyx_12t_2w2r_rc4_4x4_routed_5layer_direct
Xgf180mcu_as_sc_mcu7t3v3__inv_2_1260 gf180mcu_as_sc_mcu7t3v3__nor2_2_9/VDD gf180mcu_as_sc_mcu7t3v3__nor2_2_9/VSS
+ VSS VSS gf180mcu_as_sc_mcu7t3v3__nor2_2_9/VNW VSUBS gf180mcu_as_sc_mcu7t3v3__inv_2
Xgf180mcu_as_sc_mcu7t3v3__inv_2_1271 VSS VSS VSS VSS gf180mcu_as_sc_mcu7t3v3__inv_2_1271/VNW
+ VSUBS gf180mcu_as_sc_mcu7t3v3__inv_2
Xgf180mcu_as_sc_mcu7t3v3__inv_2_1282 VSS VSS VSS VSS gf180mcu_as_sc_mcu7t3v3__inv_2_1282/VNW
+ VSUBS gf180mcu_as_sc_mcu7t3v3__inv_2
Xgf180mcu_as_sc_mcu7t3v3__inv_2_1293 VSS VSS VSS VSS gf180mcu_as_sc_mcu7t3v3__inv_2_1293/VNW
+ VSUBS gf180mcu_as_sc_mcu7t3v3__inv_2
Xgf180mcu_as_sc_mcu7t3v3__inv_2_711 gf180mcu_as_sc_mcu7t3v3__inv_2_712/VDD VSS gf180mcu_as_sc_mcu7t3v3__inv_2_711/Y
+ gf180mcu_as_sc_mcu7t3v3__inv_2_712/Y gf180mcu_as_sc_mcu7t3v3__inv_2_712/VNW VSUBS
+ gf180mcu_as_sc_mcu7t3v3__inv_2
Xgf180mcu_as_sc_mcu7t3v3__inv_2_700 VSS gf180mcu_as_sc_mcu7t3v3__inv_2_737/VSS gf180mcu_as_sc_mcu7t3v3__inv_2_721/A
+ VSS gf180mcu_as_sc_mcu7t3v3__inv_2_737/VNW VSUBS gf180mcu_as_sc_mcu7t3v3__inv_2
Xgf180mcu_as_sc_mcu7t3v3__inv_2_766 VSS VSS VSS VSS gf180mcu_as_sc_mcu7t3v3__inv_2_823/VNW
+ VSUBS gf180mcu_as_sc_mcu7t3v3__inv_2
Xgf180mcu_as_sc_mcu7t3v3__inv_2_755 VSS VSS VSS VSS gf180mcu_as_sc_mcu7t3v3__inv_2_835/VNW
+ VSUBS gf180mcu_as_sc_mcu7t3v3__inv_2
Xgf180mcu_as_sc_mcu7t3v3__inv_2_777 VSS VSS gf180mcu_as_sc_mcu7t3v3__inv_2_777/Y VSS
+ gf180mcu_as_sc_mcu7t3v3__inv_2_827/VNW VSUBS gf180mcu_as_sc_mcu7t3v3__inv_2
Xgf180mcu_as_sc_mcu7t3v3__inv_2_744 gf180mcu_as_sc_mcu7t3v3__inv_2_746/VDD gf180mcu_as_sc_mcu7t3v3__inv_2_746/VSS
+ gf180mcu_as_sc_mcu7t3v3__inv_2_744/Y gf180mcu_as_sc_mcu7t3v3__inv_2_744/A gf180mcu_as_sc_mcu7t3v3__inv_2_746/VNW
+ VSUBS gf180mcu_as_sc_mcu7t3v3__inv_2
Xgf180mcu_as_sc_mcu7t3v3__inv_2_722 VSS gf180mcu_as_sc_mcu7t3v3__inv_2_746/VDD gf180mcu_as_sc_mcu7t3v3__inv_2_722/Y
+ gf180mcu_as_sc_mcu7t3v3__inv_2_722/A gf180mcu_as_sc_mcu7t3v3__inv_2_724/VNW VSUBS
+ gf180mcu_as_sc_mcu7t3v3__inv_2
Xgf180mcu_as_sc_mcu7t3v3__inv_2_799 VSS VSS VSS VSS gf180mcu_as_sc_mcu7t3v3__inv_2_850/VNW
+ VSUBS gf180mcu_as_sc_mcu7t3v3__inv_2
Xgf180mcu_as_sc_mcu7t3v3__inv_2_788 VSS VSS VSS VSS gf180mcu_as_sc_mcu7t3v3__inv_2_849/VNW
+ VSUBS gf180mcu_as_sc_mcu7t3v3__inv_2
Xgf180mcu_as_sc_mcu7t3v3__inv_2_733 VSS VSS gf180mcu_as_sc_mcu7t3v3__inv_2_733/Y gf180mcu_as_sc_mcu7t3v3__inv_2_733/A
+ gf180mcu_as_sc_mcu7t3v3__inv_2_733/VNW VSUBS gf180mcu_as_sc_mcu7t3v3__inv_2
Xgf180mcu_as_sc_mcu7t3v3__inv_2_1090 gf180mcu_as_sc_mcu7t3v3__inv_2_1091/VDD VSS gf180mcu_as_sc_mcu7t3v3__inv_2_1090/Y
+ gf180mcu_as_sc_mcu7t3v3__inv_2_1091/Y gf180mcu_as_sc_mcu7t3v3__inv_2_1091/VNW VSUBS
+ gf180mcu_as_sc_mcu7t3v3__inv_2
Xgf180mcu_as_sc_mcu7t3v3__nand4_2_2 gf180mcu_as_sc_mcu7t3v3__inv_2_98/VDD VSS VSS
+ VSS VSS VSS VSS gf180mcu_as_sc_mcu7t3v3__inv_2_98/VNW VSUBS gf180mcu_as_sc_mcu7t3v3__nand4_2
Xgf180mcu_as_sc_mcu7t3v3__inv_2_541 VSS VSS VSS VSS gf180mcu_as_sc_mcu7t3v3__inv_2_542/VNW
+ VSUBS gf180mcu_as_sc_mcu7t3v3__inv_2
Xgf180mcu_as_sc_mcu7t3v3__inv_2_530 gf180mcu_as_sc_mcu7t3v3__nor2_2_4/VDD gf180mcu_as_sc_mcu7t3v3__nor2_2_4/VSS
+ VSS VSS gf180mcu_as_sc_mcu7t3v3__nor2_2_4/VNW VSUBS gf180mcu_as_sc_mcu7t3v3__inv_2
Xgf180mcu_as_sc_mcu7t3v3__inv_2_552 VSS VSS VSS VSS gf180mcu_as_sc_mcu7t3v3__inv_2_552/VNW
+ VSUBS gf180mcu_as_sc_mcu7t3v3__inv_2
Xgf180mcu_as_sc_mcu7t3v3__inv_2_563 VSS VSS VSS VSS gf180mcu_as_sc_mcu7t3v3__inv_2_563/VNW
+ VSUBS gf180mcu_as_sc_mcu7t3v3__inv_2
Xgf180mcu_as_sc_mcu7t3v3__inv_2_585 VSS gf180mcu_as_sc_mcu7t3v3__inv_2_588/VDD gf180mcu_as_sc_mcu7t3v3__inv_2_585/Y
+ gf180mcu_as_sc_mcu7t3v3__inv_2_640/Y gf180mcu_as_sc_mcu7t3v3__inv_2_585/VNW VSUBS
+ gf180mcu_as_sc_mcu7t3v3__inv_2
Xgf180mcu_as_sc_mcu7t3v3__inv_2_574 gf180mcu_as_sc_mcu7t3v3__inv_2_576/VDD gf180mcu_as_sc_mcu7t3v3__inv_2_579/VDD
+ gf180mcu_as_sc_mcu7t3v3__inv_2_574/Y VSS gf180mcu_as_sc_mcu7t3v3__inv_2_576/VNW
+ VSUBS gf180mcu_as_sc_mcu7t3v3__inv_2
Xgf180mcu_as_sc_mcu7t3v3__inv_2_596 gf180mcu_as_sc_mcu7t3v3__inv_2_638/VSS gf180mcu_as_sc_mcu7t3v3__inv_2_602/VDD
+ gf180mcu_as_sc_mcu7t3v3__inv_2_596/Y gf180mcu_as_sc_mcu7t3v3__inv_2_638/A gf180mcu_as_sc_mcu7t3v3__inv_2_598/VNW
+ VSUBS gf180mcu_as_sc_mcu7t3v3__inv_2
Xgf180mcu_as_sc_mcu7t3v3__inv_2_393 gf180mcu_as_sc_mcu7t3v3__nor2_2_7/VDD gf180mcu_as_sc_mcu7t3v3__nand3_2_4/VSS
+ VSS VSS gf180mcu_as_sc_mcu7t3v3__nor2_2_7/VNW VSUBS gf180mcu_as_sc_mcu7t3v3__inv_2
Xgf180mcu_as_sc_mcu7t3v3__inv_2_382 gf180mcu_as_sc_mcu7t3v3__nor2_2_7/VDD gf180mcu_as_sc_mcu7t3v3__nor2_2_7/VSS
+ VSS VSS gf180mcu_as_sc_mcu7t3v3__nor2_2_7/VNW VSUBS gf180mcu_as_sc_mcu7t3v3__inv_2
Xgf180mcu_as_sc_mcu7t3v3__inv_2_371 gf180mcu_as_sc_mcu7t3v3__inv_2_371/VDD gf180mcu_as_sc_mcu7t3v3__inv_2_371/VSS
+ VSS VSS gf180mcu_as_sc_mcu7t3v3__inv_2_371/VNW VSUBS gf180mcu_as_sc_mcu7t3v3__inv_2
Xgf180mcu_as_sc_mcu7t3v3__inv_2_360 gf180mcu_as_sc_mcu7t3v3__inv_2_365/VDD gf180mcu_as_sc_mcu7t3v3__inv_2_365/VDD
+ VSS gf180mcu_as_sc_mcu7t3v3__inv_2_365/Y gf180mcu_as_sc_mcu7t3v3__inv_2_362/VNW
+ VSUBS gf180mcu_as_sc_mcu7t3v3__inv_2
Xu_t027_010 u_t027_010/c0_w0_bl u_t027_010/c0_w0_br u_t027_010/c0_w1_bl u_t027_010/c0_w1_br
+ u_t027_010/c0_r0_rbl u_t027_010/c0_r1_rbl u_t027_010/c1_w0_bl u_t027_010/c1_w0_br
+ u_t027_010/c1_w1_bl u_t027_010/c1_w1_br u_t027_010/c1_r0_rbl u_t027_010/c1_r1_rbl
+ u_t027_010/c2_w0_bl u_t027_010/c2_w0_br u_t027_010/c2_w1_bl u_t027_010/c2_w1_br
+ u_t027_010/c2_r0_rbl u_t027_010/c2_r1_rbl u_t027_010/c3_w0_bl u_t027_010/c3_w0_br
+ u_t027_010/c3_w1_bl u_t027_010/c3_w1_br u_t027_010/c3_r0_rbl u_t027_010/c3_r1_rbl
+ u_t027_010/r0_w0_wl u_t027_010/r0_w1_wl u_t027_010/r0_r0_rwl u_t027_010/r0_r1_rwl
+ u_t027_010/r1_w0_wl u_t027_010/r1_w1_wl u_t027_010/r1_r0_rwl u_t027_010/r1_r1_rwl
+ u_t027_010/r2_w0_wl u_t027_010/r2_w1_wl u_t027_010/r2_r0_rwl u_t027_010/r2_r1_rwl
+ u_t027_010/r3_w0_wl u_t027_010/r3_w1_wl u_t027_010/r3_r0_rwl u_t027_010/r3_r1_rwl
+ VSS u_t027_010/VSS u_t027_010/m2_717_1265# u_t027_010/m2_603_2031# u_t027_010/m2_1290_336#
+ u_t027_010/m2_2000_2037# u_t027_010/m2_791_2909# u_t027_010/m2_7_2126# u_t027_010/m2_2154_2081#
+ u_t027_010/m2_1795_2037# u_t027_010/m2_871_303# u_t027_010/m2_431_438# u_t027_010/m2_1290_2898#
+ u_t027_010/m2_1714_1210# u_t027_010/m2_431_1982# u_t027_010/m2_512_1265# u_t027_010/m2_2573_2126#
+ u_t027_010/m2_603_1259# u_t027_010/m2_2074_2909# u_t027_010/m2_7_336# u_t027_010/m2_717_2037#
+ u_t027_010/m2_1886_2031# u_t027_010/m2_2573_336# u_t027_010/m2_7_2898# u_t027_010/m2_2000_1265#
+ u_t027_010/m2_512_2037# u_t027_010/m2_1795_1265# u_t027_010/m2_1714_1982# u_t027_010/m2_1886_1259#
+ u_t027_010/m2_1290_2126# u_t027_010/m2_1714_438# u_t027_010/m2_431_1210# u_t027_010/m2_2573_2898#
+ u_t027_010/m2_2154_303# u_t027_010/m2_871_2081# VSUBS detronyx_12t_2w2r_rc4_4x4_routed_5layer_direct
Xu_t018_010 u_t018_010/c0_w0_bl u_t018_010/c0_w0_br u_t018_010/c0_w1_bl u_t018_010/c0_w1_br
+ u_t018_010/c0_r0_rbl u_t018_010/c0_r1_rbl u_t018_010/c1_w0_bl u_t018_010/c1_w0_br
+ u_t018_010/c1_w1_bl u_t018_010/c1_w1_br u_t018_010/c1_r0_rbl u_t018_010/c1_r1_rbl
+ u_t018_010/c2_w0_bl u_t018_010/c2_w0_br u_t018_010/c2_w1_bl u_t018_010/c2_w1_br
+ u_t018_010/c2_r0_rbl u_t018_010/c2_r1_rbl u_t018_010/c3_w0_bl u_t018_010/c3_w0_br
+ u_t018_010/c3_w1_bl u_t018_010/c3_w1_br u_t018_010/c3_r0_rbl u_t018_010/c3_r1_rbl
+ u_t018_010/r0_w0_wl u_t018_010/r0_w1_wl u_t018_010/r0_r0_rwl u_t018_010/r0_r1_rwl
+ u_t018_010/r1_w0_wl u_t018_010/r1_w1_wl u_t018_010/r1_r0_rwl u_t018_010/r1_r1_rwl
+ u_t018_010/r2_w0_wl u_t018_010/r2_w1_wl u_t018_010/r2_r0_rwl u_t018_010/r2_r1_rwl
+ u_t018_010/r3_w0_wl u_t018_010/r3_w1_wl u_t018_010/r3_r0_rwl u_t018_010/r3_r1_rwl
+ VSS u_t018_010/VSS u_t018_010/m2_717_1265# u_t018_010/m2_603_2031# u_t018_010/m2_1290_336#
+ u_t018_010/m2_2000_2037# u_t018_010/m2_791_2909# u_t018_010/m2_7_2126# u_t018_010/m2_2154_2081#
+ u_t018_010/m2_1795_2037# u_t018_010/m2_871_303# u_t018_010/m2_431_438# u_t018_010/m2_1290_2898#
+ u_t018_010/m2_1714_1210# u_t018_010/m2_431_1982# u_t018_010/m2_512_1265# u_t018_010/m2_2573_2126#
+ u_t018_010/m2_603_1259# u_t018_010/m2_2074_2909# u_t018_010/m2_7_336# u_t018_010/m2_717_2037#
+ u_t018_010/m2_1886_2031# u_t018_010/m2_2573_336# u_t018_010/m2_7_2898# u_t018_010/m2_2000_1265#
+ u_t018_010/m2_512_2037# u_t018_010/m2_1795_1265# u_t018_010/m2_1714_1982# u_t018_010/m2_1886_1259#
+ u_t018_010/m2_1290_2126# u_t018_010/m2_1714_438# u_t018_010/m2_431_1210# u_t018_010/m2_2573_2898#
+ u_t018_010/m2_2154_303# u_t018_010/m2_871_2081# VSUBS detronyx_12t_2w2r_rc4_4x4_routed_5layer_direct
Xu_t009_010 u_t009_010/c0_w0_bl u_t009_010/c0_w0_br u_t009_010/c0_w1_bl u_t009_010/c0_w1_br
+ u_t009_010/c0_r0_rbl u_t009_010/c0_r1_rbl u_t009_010/c1_w0_bl u_t009_010/c1_w0_br
+ u_t009_010/c1_w1_bl u_t009_010/c1_w1_br u_t009_010/c1_r0_rbl u_t009_010/c1_r1_rbl
+ u_t009_010/c2_w0_bl u_t009_010/c2_w0_br u_t009_010/c2_w1_bl u_t009_010/c2_w1_br
+ u_t009_010/c2_r0_rbl u_t009_010/c2_r1_rbl u_t009_010/c3_w0_bl u_t009_010/c3_w0_br
+ u_t009_010/c3_w1_bl u_t009_010/c3_w1_br u_t009_010/c3_r0_rbl u_t009_010/c3_r1_rbl
+ u_t009_010/r0_w0_wl u_t009_010/r0_w1_wl u_t009_010/r0_r0_rwl u_t009_010/r0_r1_rwl
+ u_t009_010/r1_w0_wl u_t009_010/r1_w1_wl u_t009_010/r1_r0_rwl u_t009_010/r1_r1_rwl
+ u_t009_010/r2_w0_wl u_t009_010/r2_w1_wl u_t009_010/r2_r0_rwl u_t009_010/r2_r1_rwl
+ u_t009_010/r3_w0_wl u_t009_010/r3_w1_wl u_t009_010/r3_r0_rwl u_t009_010/r3_r1_rwl
+ VSS VSS u_t009_010/m2_717_1265# u_t009_010/m2_603_2031# u_t009_010/m2_1290_336#
+ u_t009_010/m2_2000_2037# u_t009_010/m2_791_2909# u_t009_010/m2_7_2126# u_t009_010/m2_2154_2081#
+ u_t009_010/m2_1795_2037# u_t009_010/m2_871_303# u_t009_010/m2_431_438# u_t009_010/m2_1290_2898#
+ u_t009_010/m2_1714_1210# u_t009_010/m2_431_1982# u_t009_010/m2_512_1265# u_t009_010/m2_2573_2126#
+ u_t009_010/m2_603_1259# u_t009_010/m2_2074_2909# u_t009_010/m2_7_336# u_t009_010/m2_717_2037#
+ u_t009_010/m2_1886_2031# u_t009_010/m2_2573_336# u_t009_010/m2_7_2898# u_t009_010/m2_2000_1265#
+ u_t009_010/m2_512_2037# u_t009_010/m2_1795_1265# u_t009_010/m2_1714_1982# u_t009_010/m2_1886_1259#
+ u_t009_010/m2_1290_2126# u_t009_010/m2_1714_438# u_t009_010/m2_431_1210# u_t009_010/m2_2573_2898#
+ u_t009_010/m2_2154_303# u_t009_010/m2_871_2081# VSUBS detronyx_12t_2w2r_rc4_4x4_routed_5layer_direct
Xu_t024_002 u_t024_002/c0_w0_bl u_t024_002/c0_w0_br u_t024_002/c0_w1_bl u_t024_002/c0_w1_br
+ u_t024_002/c0_r0_rbl u_t024_002/c0_r1_rbl u_t024_002/c1_w0_bl u_t024_002/c1_w0_br
+ u_t024_002/c1_w1_bl u_t024_002/c1_w1_br u_t024_002/c1_r0_rbl u_t024_002/c1_r1_rbl
+ u_t024_002/c2_w0_bl u_t024_002/c2_w0_br u_t024_002/c2_w1_bl u_t024_002/c2_w1_br
+ u_t024_002/c2_r0_rbl u_t024_002/c2_r1_rbl u_t024_002/c3_w0_bl u_t024_002/c3_w0_br
+ u_t024_002/c3_w1_bl u_t024_002/c3_w1_br u_t024_002/c3_r0_rbl u_t024_002/c3_r1_rbl
+ u_t024_002/r0_w0_wl u_t024_002/r0_w1_wl u_t024_002/r0_r0_rwl u_t024_002/r0_r1_rwl
+ u_t024_002/r1_w0_wl u_t024_002/r1_w1_wl u_t024_002/r1_r0_rwl u_t024_002/r1_r1_rwl
+ u_t024_002/r2_w0_wl u_t024_002/r2_w1_wl u_t024_002/r2_r0_rwl u_t024_002/r2_r1_rwl
+ u_t024_002/r3_w0_wl u_t024_002/r3_w1_wl u_t024_002/r3_r0_rwl u_t024_002/r3_r1_rwl
+ VSS VSS u_t024_002/m2_717_1265# u_t024_002/m2_603_2031# u_t024_002/m2_1290_336#
+ u_t024_002/m2_2000_2037# u_t024_002/m2_791_2909# u_t024_002/m2_7_2126# u_t024_002/m2_2154_2081#
+ u_t024_002/m2_1795_2037# u_t024_002/m2_871_303# u_t024_002/m2_431_438# u_t024_002/m2_1290_2898#
+ u_t024_002/m2_1714_1210# u_t024_002/m2_431_1982# u_t024_002/m2_512_1265# u_t024_002/m2_2573_2126#
+ u_t024_002/m2_603_1259# u_t024_002/m2_2074_2909# u_t024_002/m2_7_336# u_t024_002/m2_717_2037#
+ u_t024_002/m2_1886_2031# u_t024_002/m2_2573_336# u_t024_002/m2_7_2898# u_t024_002/m2_2000_1265#
+ u_t024_002/m2_512_2037# u_t024_002/m2_1795_1265# u_t024_002/m2_1714_1982# u_t024_002/m2_1886_1259#
+ u_t024_002/m2_1290_2126# u_t024_002/m2_1714_438# u_t024_002/m2_431_1210# u_t024_002/m2_2573_2898#
+ u_t024_002/m2_2154_303# u_t024_002/m2_871_2081# VSUBS detronyx_12t_2w2r_rc4_4x4_routed_5layer_direct
Xgf180mcu_as_sc_mcu7t3v3__nand3_2_58 gf180mcu_as_sc_mcu7t3v3__nor2_2_9/VDD gf180mcu_as_sc_mcu7t3v3__nand3_2_63/VSS
+ VSS VSS VSS VSS gf180mcu_as_sc_mcu7t3v3__nor2_2_9/VNW VSUBS gf180mcu_as_sc_mcu7t3v3__nand3_2
Xgf180mcu_as_sc_mcu7t3v3__nand3_2_47 gf180mcu_as_sc_mcu7t3v3__nand3_2_65/VDD gf180mcu_as_sc_mcu7t3v3__nor2_2_9/VSS
+ VSS VSS VSS VSS gf180mcu_as_sc_mcu7t3v3__nand3_2_65/VNW VSUBS gf180mcu_as_sc_mcu7t3v3__nand3_2
Xgf180mcu_as_sc_mcu7t3v3__nand3_2_36 gf180mcu_as_sc_mcu7t3v3__nor2_2_6/VDD gf180mcu_as_sc_mcu7t3v3__nor2_2_6/VSS
+ VSS VSS VSS VSS gf180mcu_as_sc_mcu7t3v3__nor2_2_6/VNW VSUBS gf180mcu_as_sc_mcu7t3v3__nand3_2
Xgf180mcu_as_sc_mcu7t3v3__nand3_2_25 gf180mcu_as_sc_mcu7t3v3__nor2_2_6/VDD gf180mcu_as_sc_mcu7t3v3__nor2_2_6/VSS
+ VSS VSS VSS VSS gf180mcu_as_sc_mcu7t3v3__nor2_2_6/VNW VSUBS gf180mcu_as_sc_mcu7t3v3__nand3_2
Xgf180mcu_as_sc_mcu7t3v3__nand3_2_14 gf180mcu_as_sc_mcu7t3v3__nor2_2_4/VDD gf180mcu_as_sc_mcu7t3v3__nand2_2_3/VSS
+ VSS VSS VSS VSS gf180mcu_as_sc_mcu7t3v3__nor2_2_4/VNW VSUBS gf180mcu_as_sc_mcu7t3v3__nand3_2
Xu_t024_013 u_t024_013/c0_w0_bl u_t024_013/c0_w0_br u_t024_013/c0_w1_bl u_t024_013/c0_w1_br
+ u_t024_013/c0_r0_rbl u_t024_013/c0_r1_rbl u_t024_013/c1_w0_bl u_t024_013/c1_w0_br
+ u_t024_013/c1_w1_bl u_t024_013/c1_w1_br u_t024_013/c1_r0_rbl u_t024_013/c1_r1_rbl
+ u_t024_013/c2_w0_bl u_t024_013/c2_w0_br u_t024_013/c2_w1_bl u_t024_013/c2_w1_br
+ u_t024_013/c2_r0_rbl u_t024_013/c2_r1_rbl u_t024_013/c3_w0_bl u_t024_013/c3_w0_br
+ u_t024_013/c3_w1_bl u_t024_013/c3_w1_br u_t024_013/c3_r0_rbl u_t024_013/c3_r1_rbl
+ u_t024_013/r0_w0_wl u_t024_013/r0_w1_wl u_t024_013/r0_r0_rwl u_t024_013/r0_r1_rwl
+ u_t024_013/r1_w0_wl u_t024_013/r1_w1_wl u_t024_013/r1_r0_rwl u_t024_013/r1_r1_rwl
+ u_t024_013/r2_w0_wl u_t024_013/r2_w1_wl u_t024_013/r2_r0_rwl u_t024_013/r2_r1_rwl
+ u_t024_013/r3_w0_wl u_t024_013/r3_w1_wl u_t024_013/r3_r0_rwl u_t024_013/r3_r1_rwl
+ u_t025_013/VDD u_t024_013/VSS u_t024_013/m2_717_1265# u_t024_013/m2_603_2031# u_t024_013/m2_1290_336#
+ u_t024_013/m2_2000_2037# u_t024_013/m2_791_2909# u_t024_013/m2_7_2126# u_t024_013/m2_2154_2081#
+ u_t024_013/m2_1795_2037# u_t024_013/m2_871_303# u_t024_013/m2_431_438# u_t024_013/m2_1290_2898#
+ u_t024_013/m2_1714_1210# u_t024_013/m2_431_1982# u_t024_013/m2_512_1265# u_t024_013/m2_2573_2126#
+ u_t024_013/m2_603_1259# u_t024_013/m2_2074_2909# u_t024_013/m2_7_336# u_t024_013/m2_717_2037#
+ u_t024_013/m2_1886_2031# u_t024_013/m2_2573_336# u_t024_013/m2_7_2898# u_t024_013/m2_2000_1265#
+ u_t024_013/m2_512_2037# u_t024_013/m2_1795_1265# u_t024_013/m2_1714_1982# u_t024_013/m2_1886_1259#
+ u_t024_013/m2_1290_2126# u_t024_013/m2_1714_438# u_t024_013/m2_431_1210# u_t024_013/m2_2573_2898#
+ u_t024_013/m2_2154_303# u_t024_013/m2_871_2081# VSUBS detronyx_12t_2w2r_rc4_4x4_routed_5layer_direct
Xgf180mcu_as_sc_mcu7t3v3__inv_2_1612 gf180mcu_as_sc_mcu7t3v3__inv_2_1614/VDD gf180mcu_as_sc_mcu7t3v3__inv_2_1618/VDD
+ VSS gf180mcu_as_sc_mcu7t3v3__inv_2_1669/A gf180mcu_as_sc_mcu7t3v3__inv_2_1614/VNW
+ VSUBS gf180mcu_as_sc_mcu7t3v3__inv_2
Xgf180mcu_as_sc_mcu7t3v3__inv_2_1601 VSS VSS gf180mcu_as_sc_mcu7t3v3__inv_2_1601/Y
+ VSS gf180mcu_as_sc_mcu7t3v3__inv_2_1601/VNW VSUBS gf180mcu_as_sc_mcu7t3v3__inv_2
Xgf180mcu_as_sc_mcu7t3v3__inv_2_190 gf180mcu_as_sc_mcu7t3v3__inv_2_190/VDD gf180mcu_as_sc_mcu7t3v3__inv_2_193/VDD
+ gf180mcu_as_sc_mcu7t3v3__inv_2_190/Y VSS gf180mcu_as_sc_mcu7t3v3__inv_2_190/VNW
+ VSUBS gf180mcu_as_sc_mcu7t3v3__inv_2
Xgf180mcu_as_sc_mcu7t3v3__inv_2_1634 gf180mcu_as_sc_mcu7t3v3__inv_2_1634/VDD gf180mcu_as_sc_mcu7t3v3__inv_2_1638/VDD
+ gf180mcu_as_sc_mcu7t3v3__inv_2_1689/A VSS gf180mcu_as_sc_mcu7t3v3__inv_2_1634/VNW
+ VSUBS gf180mcu_as_sc_mcu7t3v3__inv_2
Xgf180mcu_as_sc_mcu7t3v3__inv_2_1645 gf180mcu_as_sc_mcu7t3v3__inv_2_1649/VDD gf180mcu_as_sc_mcu7t3v3__inv_2_1665/VDD
+ gf180mcu_as_sc_mcu7t3v3__inv_2_1645/Y gf180mcu_as_sc_mcu7t3v3__inv_2_1689/A gf180mcu_as_sc_mcu7t3v3__inv_2_1649/VNW
+ VSUBS gf180mcu_as_sc_mcu7t3v3__inv_2
Xgf180mcu_as_sc_mcu7t3v3__inv_2_1689 gf180mcu_as_sc_mcu7t3v3__inv_2_1689/VDD gf180mcu_as_sc_mcu7t3v3__inv_2_1689/VSS
+ VSS gf180mcu_as_sc_mcu7t3v3__inv_2_1689/A gf180mcu_as_sc_mcu7t3v3__inv_2_1689/VNW
+ VSUBS gf180mcu_as_sc_mcu7t3v3__inv_2
Xgf180mcu_as_sc_mcu7t3v3__inv_2_1623 gf180mcu_as_sc_mcu7t3v3__inv_2_1689/VSS VSS gf180mcu_as_sc_mcu7t3v3__inv_2_1623/Y
+ gf180mcu_as_sc_mcu7t3v3__inv_2_1689/A gf180mcu_as_sc_mcu7t3v3__inv_2_1627/VNW VSUBS
+ gf180mcu_as_sc_mcu7t3v3__inv_2
Xgf180mcu_as_sc_mcu7t3v3__inv_2_1656 gf180mcu_as_sc_mcu7t3v3__inv_2_1656/VDD gf180mcu_as_sc_mcu7t3v3__inv_2_1660/VDD
+ gf180mcu_as_sc_mcu7t3v3__inv_2_1669/A VSS gf180mcu_as_sc_mcu7t3v3__inv_2_1656/VNW
+ VSUBS gf180mcu_as_sc_mcu7t3v3__inv_2
Xgf180mcu_as_sc_mcu7t3v3__inv_2_1667 VSS gf180mcu_as_sc_mcu7t3v3__inv_2_1672/VDD gf180mcu_as_sc_mcu7t3v3__inv_2_1667/Y
+ gf180mcu_as_sc_mcu7t3v3__inv_2_1672/Y gf180mcu_as_sc_mcu7t3v3__inv_2_1668/VNW VSUBS
+ gf180mcu_as_sc_mcu7t3v3__inv_2
Xgf180mcu_as_sc_mcu7t3v3__inv_2_1678 VSS gf180mcu_as_sc_mcu7t3v3__inv_2_1684/VDD VSS
+ gf180mcu_as_sc_mcu7t3v3__inv_2_1684/Y gf180mcu_as_sc_mcu7t3v3__inv_2_1680/VNW VSUBS
+ gf180mcu_as_sc_mcu7t3v3__inv_2
Xu_t015_013 u_t015_013/c0_w0_bl u_t015_013/c0_w0_br u_t015_013/c0_w1_bl u_t015_013/c0_w1_br
+ u_t015_013/c0_r0_rbl u_t015_013/c0_r1_rbl u_t015_013/c1_w0_bl u_t015_013/c1_w0_br
+ u_t015_013/c1_w1_bl u_t015_013/c1_w1_br u_t015_013/c1_r0_rbl u_t015_013/c1_r1_rbl
+ u_t015_013/c2_w0_bl u_t015_013/c2_w0_br u_t015_013/c2_w1_bl u_t015_013/c2_w1_br
+ u_t015_013/c2_r0_rbl u_t015_013/c2_r1_rbl u_t015_013/c3_w0_bl u_t015_013/c3_w0_br
+ u_t015_013/c3_w1_bl u_t015_013/c3_w1_br u_t015_013/c3_r0_rbl u_t015_013/c3_r1_rbl
+ u_t015_013/r0_w0_wl u_t015_013/r0_w1_wl u_t015_013/r0_r0_rwl u_t015_013/r0_r1_rwl
+ u_t015_013/r1_w0_wl u_t015_013/r1_w1_wl u_t015_013/r1_r0_rwl u_t015_013/r1_r1_rwl
+ u_t015_013/r2_w0_wl u_t015_013/r2_w1_wl u_t015_013/r2_r0_rwl u_t015_013/r2_r1_rwl
+ u_t015_013/r3_w0_wl u_t015_013/r3_w1_wl u_t015_013/r3_r0_rwl u_t015_013/r3_r1_rwl
+ u_t015_013/VDD u_t015_013/VSS u_t015_013/m2_717_1265# u_t015_013/m2_603_2031# u_t015_013/m2_1290_336#
+ u_t015_013/m2_2000_2037# u_t015_013/m2_791_2909# u_t015_013/m2_7_2126# u_t015_013/m2_2154_2081#
+ u_t015_013/m2_1795_2037# u_t015_013/m2_871_303# u_t015_013/m2_431_438# u_t015_013/m2_1290_2898#
+ u_t015_013/m2_1714_1210# u_t015_013/m2_431_1982# u_t015_013/m2_512_1265# u_t015_013/m2_2573_2126#
+ u_t015_013/m2_603_1259# u_t015_013/m2_2074_2909# u_t015_013/m2_7_336# u_t015_013/m2_717_2037#
+ u_t015_013/m2_1886_2031# u_t015_013/m2_2573_336# u_t015_013/m2_7_2898# u_t015_013/m2_2000_1265#
+ u_t015_013/m2_512_2037# u_t015_013/m2_1795_1265# u_t015_013/m2_1714_1982# u_t015_013/m2_1886_1259#
+ u_t015_013/m2_1290_2126# u_t015_013/m2_1714_438# u_t015_013/m2_431_1210# u_t015_013/m2_2573_2898#
+ u_t015_013/m2_2154_303# u_t015_013/m2_871_2081# VSUBS detronyx_12t_2w2r_rc4_4x4_routed_5layer_direct
Xu_t015_002 u_t015_002/c0_w0_bl u_t015_002/c0_w0_br u_t015_002/c0_w1_bl u_t015_002/c0_w1_br
+ u_t015_002/c0_r0_rbl u_t015_002/c0_r1_rbl u_t015_002/c1_w0_bl u_t015_002/c1_w0_br
+ u_t015_002/c1_w1_bl u_t015_002/c1_w1_br u_t015_002/c1_r0_rbl u_t015_002/c1_r1_rbl
+ u_t015_002/c2_w0_bl u_t015_002/c2_w0_br u_t015_002/c2_w1_bl u_t015_002/c2_w1_br
+ u_t015_002/c2_r0_rbl u_t015_002/c2_r1_rbl u_t015_002/c3_w0_bl u_t015_002/c3_w0_br
+ u_t015_002/c3_w1_bl u_t015_002/c3_w1_br u_t015_002/c3_r0_rbl u_t015_002/c3_r1_rbl
+ u_t015_002/r0_w0_wl u_t015_002/r0_w1_wl u_t015_002/r0_r0_rwl u_t015_002/r0_r1_rwl
+ u_t015_002/r1_w0_wl u_t015_002/r1_w1_wl u_t015_002/r1_r0_rwl u_t015_002/r1_r1_rwl
+ u_t015_002/r2_w0_wl u_t015_002/r2_w1_wl u_t015_002/r2_r0_rwl u_t015_002/r2_r1_rwl
+ u_t015_002/r3_w0_wl u_t015_002/r3_w1_wl u_t015_002/r3_r0_rwl u_t015_002/r3_r1_rwl
+ VSS VSS u_t015_002/m2_717_1265# u_t015_002/m2_603_2031# u_t015_002/m2_1290_336#
+ u_t015_002/m2_2000_2037# u_t015_002/m2_791_2909# u_t015_002/m2_7_2126# u_t015_002/m2_2154_2081#
+ u_t015_002/m2_1795_2037# u_t015_002/m2_871_303# u_t015_002/m2_431_438# u_t015_002/m2_1290_2898#
+ u_t015_002/m2_1714_1210# u_t015_002/m2_431_1982# u_t015_002/m2_512_1265# u_t015_002/m2_2573_2126#
+ u_t015_002/m2_603_1259# u_t015_002/m2_2074_2909# u_t015_002/m2_7_336# u_t015_002/m2_717_2037#
+ u_t015_002/m2_1886_2031# u_t015_002/m2_2573_336# u_t015_002/m2_7_2898# u_t015_002/m2_2000_1265#
+ u_t015_002/m2_512_2037# u_t015_002/m2_1795_1265# u_t015_002/m2_1714_1982# u_t015_002/m2_1886_1259#
+ u_t015_002/m2_1290_2126# u_t015_002/m2_1714_438# u_t015_002/m2_431_1210# u_t015_002/m2_2573_2898#
+ u_t015_002/m2_2154_303# u_t015_002/m2_871_2081# VSUBS detronyx_12t_2w2r_rc4_4x4_routed_5layer_direct
Xu_t030_005 u_t030_005/c0_w0_bl u_t030_005/c0_w0_br u_t030_005/c0_w1_bl u_t030_005/c0_w1_br
+ u_t030_005/c0_r0_rbl u_t030_005/c0_r1_rbl u_t030_005/c1_w0_bl u_t030_005/c1_w0_br
+ u_t030_005/c1_w1_bl u_t030_005/c1_w1_br u_t030_005/c1_r0_rbl u_t030_005/c1_r1_rbl
+ u_t030_005/c2_w0_bl u_t030_005/c2_w0_br u_t030_005/c2_w1_bl u_t030_005/c2_w1_br
+ u_t030_005/c2_r0_rbl u_t030_005/c2_r1_rbl u_t030_005/c3_w0_bl u_t030_005/c3_w0_br
+ u_t030_005/c3_w1_bl u_t030_005/c3_w1_br u_t030_005/c3_r0_rbl u_t030_005/c3_r1_rbl
+ u_t030_005/r0_w0_wl u_t030_005/r0_w1_wl u_t030_005/r0_r0_rwl u_t030_005/r0_r1_rwl
+ u_t030_005/r1_w0_wl u_t030_005/r1_w1_wl u_t030_005/r1_r0_rwl u_t030_005/r1_r1_rwl
+ u_t030_005/r2_w0_wl u_t030_005/r2_w1_wl u_t030_005/r2_r0_rwl u_t030_005/r2_r1_rwl
+ u_t030_005/r3_w0_wl u_t030_005/r3_w1_wl u_t030_005/r3_r0_rwl u_t030_005/r3_r1_rwl
+ u_t030_005/VDD VSS u_t030_005/m2_717_1265# u_t030_005/m2_603_2031# u_t030_005/m2_1290_336#
+ u_t030_005/m2_2000_2037# u_t030_005/m2_791_2909# u_t030_005/m2_7_2126# u_t030_005/m2_2154_2081#
+ u_t030_005/m2_1795_2037# u_t030_005/m2_871_303# u_t030_005/m2_431_438# u_t030_005/m2_1290_2898#
+ u_t030_005/m2_1714_1210# u_t030_005/m2_431_1982# u_t030_005/m2_512_1265# u_t030_005/m2_2573_2126#
+ u_t030_005/m2_603_1259# u_t030_005/m2_2074_2909# u_t030_005/m2_7_336# u_t030_005/m2_717_2037#
+ u_t030_005/m2_1886_2031# u_t030_005/m2_2573_336# u_t030_005/m2_7_2898# u_t030_005/m2_2000_1265#
+ u_t030_005/m2_512_2037# u_t030_005/m2_1795_1265# u_t030_005/m2_1714_1982# u_t030_005/m2_1886_1259#
+ u_t030_005/m2_1290_2126# u_t030_005/m2_1714_438# u_t030_005/m2_431_1210# u_t030_005/m2_2573_2898#
+ u_t030_005/m2_2154_303# u_t030_005/m2_871_2081# VSUBS detronyx_12t_2w2r_rc4_4x4_routed_5layer_direct
Xgf180mcu_as_sc_mcu7t3v3__nand4_2_417 gf180mcu_as_sc_mcu7t3v3__inv_2_1523/VDD VSS
+ VSS VSS VSS VSS gf180mcu_as_sc_mcu7t3v3__nand4_2_417/Y gf180mcu_as_sc_mcu7t3v3__inv_2_1523/VNW
+ VSUBS gf180mcu_as_sc_mcu7t3v3__nand4_2
Xgf180mcu_as_sc_mcu7t3v3__nand4_2_406 VSS gf180mcu_as_sc_mcu7t3v3__inv_2_1491/VDD
+ VSS VSS VSS VSS gf180mcu_as_sc_mcu7t3v3__nand4_2_406/Y gf180mcu_as_sc_mcu7t3v3__inv_2_1488/VNW
+ VSUBS gf180mcu_as_sc_mcu7t3v3__nand4_2
Xu_t006_002 u_t006_002/c0_w0_bl u_t006_002/c0_w0_br u_t006_002/c0_w1_bl u_t006_002/c0_w1_br
+ u_t006_002/c0_r0_rbl u_t006_002/c0_r1_rbl u_t006_002/c1_w0_bl u_t006_002/c1_w0_br
+ u_t006_002/c1_w1_bl u_t006_002/c1_w1_br u_t006_002/c1_r0_rbl u_t006_002/c1_r1_rbl
+ u_t006_002/c2_w0_bl u_t006_002/c2_w0_br u_t006_002/c2_w1_bl u_t006_002/c2_w1_br
+ u_t006_002/c2_r0_rbl u_t006_002/c2_r1_rbl u_t006_002/c3_w0_bl u_t006_002/c3_w0_br
+ u_t006_002/c3_w1_bl u_t006_002/c3_w1_br u_t006_002/c3_r0_rbl u_t006_002/c3_r1_rbl
+ u_t006_002/r0_w0_wl u_t006_002/r0_w1_wl u_t006_002/r0_r0_rwl u_t006_002/r0_r1_rwl
+ u_t006_002/r1_w0_wl u_t006_002/r1_w1_wl u_t006_002/r1_r0_rwl u_t006_002/r1_r1_rwl
+ u_t006_002/r2_w0_wl u_t006_002/r2_w1_wl u_t006_002/r2_r0_rwl u_t006_002/r2_r1_rwl
+ u_t006_002/r3_w0_wl u_t006_002/r3_w1_wl u_t006_002/r3_r0_rwl u_t006_002/r3_r1_rwl
+ VSS VSS u_t006_002/m2_717_1265# u_t006_002/m2_603_2031# u_t006_002/m2_1290_336#
+ u_t006_002/m2_2000_2037# u_t006_002/m2_791_2909# u_t006_002/m2_7_2126# u_t006_002/m2_2154_2081#
+ u_t006_002/m2_1795_2037# u_t006_002/m2_871_303# u_t006_002/m2_431_438# u_t006_002/m2_1290_2898#
+ u_t006_002/m2_1714_1210# u_t006_002/m2_431_1982# u_t006_002/m2_512_1265# u_t006_002/m2_2573_2126#
+ u_t006_002/m2_603_1259# u_t006_002/m2_2074_2909# u_t006_002/m2_7_336# u_t006_002/m2_717_2037#
+ u_t006_002/m2_1886_2031# u_t006_002/m2_2573_336# u_t006_002/m2_7_2898# u_t006_002/m2_2000_1265#
+ u_t006_002/m2_512_2037# u_t006_002/m2_1795_1265# u_t006_002/m2_1714_1982# u_t006_002/m2_1886_1259#
+ u_t006_002/m2_1290_2126# u_t006_002/m2_1714_438# u_t006_002/m2_431_1210# u_t006_002/m2_2573_2898#
+ u_t006_002/m2_2154_303# u_t006_002/m2_871_2081# VSUBS detronyx_12t_2w2r_rc4_4x4_routed_5layer_direct
Xgf180mcu_as_sc_mcu7t3v3__nand4_2_439 gf180mcu_as_sc_mcu7t3v3__inv_2_1598/VSS VSS
+ VSS VSS VSS VSS VSS gf180mcu_as_sc_mcu7t3v3__inv_2_1587/VNW VSUBS gf180mcu_as_sc_mcu7t3v3__nand4_2
Xgf180mcu_as_sc_mcu7t3v3__nand4_2_428 gf180mcu_as_sc_mcu7t3v3__inv_2_1556/VDD VSS
+ VSS VSS VSS VSS VSS gf180mcu_as_sc_mcu7t3v3__inv_2_1556/VNW VSUBS gf180mcu_as_sc_mcu7t3v3__nand4_2
Xgf180mcu_as_sc_mcu7t3v3__inv_2_7 gf180mcu_as_sc_mcu7t3v3__inv_2_8/VDD gf180mcu_as_sc_mcu7t3v3__inv_2_8/VSS
+ gf180mcu_as_sc_mcu7t3v3__inv_2_7/Y gf180mcu_as_sc_mcu7t3v3__inv_2_8/Y gf180mcu_as_sc_mcu7t3v3__inv_2_8/VNW
+ VSUBS gf180mcu_as_sc_mcu7t3v3__inv_2
Xu_t006_013 u_t006_013/c0_w0_bl u_t006_013/c0_w0_br u_t006_013/c0_w1_bl u_t006_013/c0_w1_br
+ u_t006_013/c0_r0_rbl u_t006_013/c0_r1_rbl u_t006_013/c1_w0_bl u_t006_013/c1_w0_br
+ u_t006_013/c1_w1_bl u_t006_013/c1_w1_br u_t006_013/c1_r0_rbl u_t006_013/c1_r1_rbl
+ u_t006_013/c2_w0_bl u_t006_013/c2_w0_br u_t006_013/c2_w1_bl u_t006_013/c2_w1_br
+ u_t006_013/c2_r0_rbl u_t006_013/c2_r1_rbl u_t006_013/c3_w0_bl u_t006_013/c3_w0_br
+ u_t006_013/c3_w1_bl u_t006_013/c3_w1_br u_t006_013/c3_r0_rbl u_t006_013/c3_r1_rbl
+ u_t006_013/r0_w0_wl u_t006_013/r0_w1_wl u_t006_013/r0_r0_rwl u_t006_013/r0_r1_rwl
+ u_t006_013/r1_w0_wl u_t006_013/r1_w1_wl u_t006_013/r1_r0_rwl u_t006_013/r1_r1_rwl
+ u_t006_013/r2_w0_wl u_t006_013/r2_w1_wl u_t006_013/r2_r0_rwl u_t006_013/r2_r1_rwl
+ u_t006_013/r3_w0_wl u_t006_013/r3_w1_wl u_t006_013/r3_r0_rwl u_t006_013/r3_r1_rwl
+ u_t006_013/VDD u_t006_013/VSS u_t006_013/m2_717_1265# u_t006_013/m2_603_2031# u_t006_013/m2_1290_336#
+ u_t006_013/m2_2000_2037# u_t006_013/m2_791_2909# u_t006_013/m2_7_2126# u_t006_013/m2_2154_2081#
+ u_t006_013/m2_1795_2037# u_t006_013/m2_871_303# u_t006_013/m2_431_438# u_t006_013/m2_1290_2898#
+ u_t006_013/m2_1714_1210# u_t006_013/m2_431_1982# u_t006_013/m2_512_1265# u_t006_013/m2_2573_2126#
+ u_t006_013/m2_603_1259# u_t006_013/m2_2074_2909# u_t006_013/m2_7_336# u_t006_013/m2_717_2037#
+ u_t006_013/m2_1886_2031# u_t006_013/m2_2573_336# u_t006_013/m2_7_2898# u_t006_013/m2_2000_1265#
+ u_t006_013/m2_512_2037# u_t006_013/m2_1795_1265# u_t006_013/m2_1714_1982# u_t006_013/m2_1886_1259#
+ u_t006_013/m2_1290_2126# u_t006_013/m2_1714_438# u_t006_013/m2_431_1210# u_t006_013/m2_2573_2898#
+ u_t006_013/m2_2154_303# u_t006_013/m2_871_2081# VSUBS detronyx_12t_2w2r_rc4_4x4_routed_5layer_direct
Xu_t021_005 u_t021_005/c0_w0_bl u_t021_005/c0_w0_br u_t021_005/c0_w1_bl u_t021_005/c0_w1_br
+ u_t021_005/c0_r0_rbl u_t021_005/c0_r1_rbl u_t021_005/c1_w0_bl u_t021_005/c1_w0_br
+ u_t021_005/c1_w1_bl u_t021_005/c1_w1_br u_t021_005/c1_r0_rbl u_t021_005/c1_r1_rbl
+ u_t021_005/c2_w0_bl u_t021_005/c2_w0_br u_t021_005/c2_w1_bl u_t021_005/c2_w1_br
+ u_t021_005/c2_r0_rbl u_t021_005/c2_r1_rbl u_t021_005/c3_w0_bl u_t021_005/c3_w0_br
+ u_t021_005/c3_w1_bl u_t021_005/c3_w1_br u_t021_005/c3_r0_rbl u_t021_005/c3_r1_rbl
+ u_t021_005/r0_w0_wl u_t021_005/r0_w1_wl u_t021_005/r0_r0_rwl u_t021_005/r0_r1_rwl
+ u_t021_005/r1_w0_wl u_t021_005/r1_w1_wl u_t021_005/r1_r0_rwl u_t021_005/r1_r1_rwl
+ u_t021_005/r2_w0_wl u_t021_005/r2_w1_wl u_t021_005/r2_r0_rwl u_t021_005/r2_r1_rwl
+ u_t021_005/r3_w0_wl u_t021_005/r3_w1_wl u_t021_005/r3_r0_rwl u_t021_005/r3_r1_rwl
+ u_t021_005/VDD VSS u_t021_005/m2_717_1265# u_t021_005/m2_603_2031# u_t021_005/m2_1290_336#
+ u_t021_005/m2_2000_2037# u_t021_005/m2_791_2909# u_t021_005/m2_7_2126# u_t021_005/m2_2154_2081#
+ u_t021_005/m2_1795_2037# u_t021_005/m2_871_303# u_t021_005/m2_431_438# u_t021_005/m2_1290_2898#
+ u_t021_005/m2_1714_1210# u_t021_005/m2_431_1982# u_t021_005/m2_512_1265# u_t021_005/m2_2573_2126#
+ u_t021_005/m2_603_1259# u_t021_005/m2_2074_2909# u_t021_005/m2_7_336# u_t021_005/m2_717_2037#
+ u_t021_005/m2_1886_2031# u_t021_005/m2_2573_336# u_t021_005/m2_7_2898# u_t021_005/m2_2000_1265#
+ u_t021_005/m2_512_2037# u_t021_005/m2_1795_1265# u_t021_005/m2_1714_1982# u_t021_005/m2_1886_1259#
+ u_t021_005/m2_1290_2126# u_t021_005/m2_1714_438# u_t021_005/m2_431_1210# u_t021_005/m2_2573_2898#
+ u_t021_005/m2_2154_303# u_t021_005/m2_871_2081# VSUBS detronyx_12t_2w2r_rc4_4x4_routed_5layer_direct
Xu_t012_005 u_t012_005/c0_w0_bl u_t012_005/c0_w0_br u_t012_005/c0_w1_bl u_t012_005/c0_w1_br
+ u_t012_005/c0_r0_rbl u_t012_005/c0_r1_rbl u_t012_005/c1_w0_bl u_t012_005/c1_w0_br
+ u_t012_005/c1_w1_bl u_t012_005/c1_w1_br u_t012_005/c1_r0_rbl u_t012_005/c1_r1_rbl
+ u_t012_005/c2_w0_bl u_t012_005/c2_w0_br u_t012_005/c2_w1_bl u_t012_005/c2_w1_br
+ u_t012_005/c2_r0_rbl u_t012_005/c2_r1_rbl u_t012_005/c3_w0_bl u_t012_005/c3_w0_br
+ u_t012_005/c3_w1_bl u_t012_005/c3_w1_br u_t012_005/c3_r0_rbl u_t012_005/c3_r1_rbl
+ u_t012_005/r0_w0_wl u_t012_005/r0_w1_wl u_t012_005/r0_r0_rwl u_t012_005/r0_r1_rwl
+ u_t012_005/r1_w0_wl u_t012_005/r1_w1_wl u_t012_005/r1_r0_rwl u_t012_005/r1_r1_rwl
+ u_t012_005/r2_w0_wl u_t012_005/r2_w1_wl u_t012_005/r2_r0_rwl u_t012_005/r2_r1_rwl
+ u_t012_005/r3_w0_wl u_t012_005/r3_w1_wl u_t012_005/r3_r0_rwl u_t012_005/r3_r1_rwl
+ u_t012_005/VDD VSS u_t012_005/m2_717_1265# u_t012_005/m2_603_2031# u_t012_005/m2_1290_336#
+ u_t012_005/m2_2000_2037# u_t012_005/m2_791_2909# u_t012_005/m2_7_2126# u_t012_005/m2_2154_2081#
+ u_t012_005/m2_1795_2037# u_t012_005/m2_871_303# u_t012_005/m2_431_438# u_t012_005/m2_1290_2898#
+ u_t012_005/m2_1714_1210# u_t012_005/m2_431_1982# u_t012_005/m2_512_1265# u_t012_005/m2_2573_2126#
+ u_t012_005/m2_603_1259# u_t012_005/m2_2074_2909# u_t012_005/m2_7_336# u_t012_005/m2_717_2037#
+ u_t012_005/m2_1886_2031# u_t012_005/m2_2573_336# u_t012_005/m2_7_2898# u_t012_005/m2_2000_1265#
+ u_t012_005/m2_512_2037# u_t012_005/m2_1795_1265# u_t012_005/m2_1714_1982# u_t012_005/m2_1886_1259#
+ u_t012_005/m2_1290_2126# u_t012_005/m2_1714_438# u_t012_005/m2_431_1210# u_t012_005/m2_2573_2898#
+ u_t012_005/m2_2154_303# u_t012_005/m2_871_2081# VSUBS detronyx_12t_2w2r_rc4_4x4_routed_5layer_direct
Xgf180mcu_as_sc_mcu7t3v3__inv_2_1420 VSS gf180mcu_as_sc_mcu7t3v3__inv_2_1720/VDD gf180mcu_as_sc_mcu7t3v3__inv_2_1420/Y
+ VSS gf180mcu_as_sc_mcu7t3v3__inv_2_1422/VNW VSUBS gf180mcu_as_sc_mcu7t3v3__inv_2
Xgf180mcu_as_sc_mcu7t3v3__inv_2_1453 gf180mcu_as_sc_mcu7t3v3__inv_2_1455/VDD VSS VSS
+ VSS gf180mcu_as_sc_mcu7t3v3__inv_2_1455/VNW VSUBS gf180mcu_as_sc_mcu7t3v3__inv_2
Xgf180mcu_as_sc_mcu7t3v3__inv_2_1442 gf180mcu_as_sc_mcu7t3v3__inv_2_1443/VDD gf180mcu_as_sc_mcu7t3v3__inv_2_1446/VDD
+ gf180mcu_as_sc_mcu7t3v3__inv_2_1442/Y VSS gf180mcu_as_sc_mcu7t3v3__inv_2_1443/VNW
+ VSUBS gf180mcu_as_sc_mcu7t3v3__inv_2
Xgf180mcu_as_sc_mcu7t3v3__inv_2_1431 VSS gf180mcu_as_sc_mcu7t3v3__inv_2_1434/VDD gf180mcu_as_sc_mcu7t3v3__inv_2_1431/Y
+ VSS gf180mcu_as_sc_mcu7t3v3__inv_2_1431/VNW VSUBS gf180mcu_as_sc_mcu7t3v3__inv_2
Xgf180mcu_as_sc_mcu7t3v3__inv_2_1475 VSS gf180mcu_as_sc_mcu7t3v3__inv_2_1476/VSS VSS
+ VSS gf180mcu_as_sc_mcu7t3v3__inv_2_1476/VNW VSUBS gf180mcu_as_sc_mcu7t3v3__inv_2
Xgf180mcu_as_sc_mcu7t3v3__inv_2_1464 gf180mcu_as_sc_mcu7t3v3__inv_2_1476/VSS gf180mcu_as_sc_mcu7t3v3__inv_2_1482/VDD
+ gf180mcu_as_sc_mcu7t3v3__inv_2_1464/Y VSS gf180mcu_as_sc_mcu7t3v3__inv_2_1464/VNW
+ VSUBS gf180mcu_as_sc_mcu7t3v3__inv_2
Xgf180mcu_as_sc_mcu7t3v3__inv_2_1486 VSS gf180mcu_as_sc_mcu7t3v3__inv_2_1491/VDD VSS
+ VSS gf180mcu_as_sc_mcu7t3v3__inv_2_1488/VNW VSUBS gf180mcu_as_sc_mcu7t3v3__inv_2
Xgf180mcu_as_sc_mcu7t3v3__inv_2_1497 VSS gf180mcu_as_sc_mcu7t3v3__inv_2_1500/VDD gf180mcu_as_sc_mcu7t3v3__inv_2_1497/Y
+ VSS gf180mcu_as_sc_mcu7t3v3__inv_2_1497/VNW VSUBS gf180mcu_as_sc_mcu7t3v3__inv_2
Xgf180mcu_as_sc_mcu7t3v3__inv_2_904 VSS VSS gf180mcu_as_sc_mcu7t3v3__inv_2_904/Y VSS
+ gf180mcu_as_sc_mcu7t3v3__inv_2_956/VNW VSUBS gf180mcu_as_sc_mcu7t3v3__inv_2
Xu_t003_005 u_t003_005/c0_w0_bl u_t003_005/c0_w0_br u_t003_005/c0_w1_bl u_t003_005/c0_w1_br
+ u_t003_005/c0_r0_rbl u_t003_005/c0_r1_rbl u_t003_005/c1_w0_bl u_t003_005/c1_w0_br
+ u_t003_005/c1_w1_bl u_t003_005/c1_w1_br u_t003_005/c1_r0_rbl u_t003_005/c1_r1_rbl
+ u_t003_005/c2_w0_bl u_t003_005/c2_w0_br u_t003_005/c2_w1_bl u_t003_005/c2_w1_br
+ u_t003_005/c2_r0_rbl u_t003_005/c2_r1_rbl u_t003_005/c3_w0_bl u_t003_005/c3_w0_br
+ u_t003_005/c3_w1_bl u_t003_005/c3_w1_br u_t003_005/c3_r0_rbl u_t003_005/c3_r1_rbl
+ u_t003_005/r0_w0_wl u_t003_005/r0_w1_wl u_t003_005/r0_r0_rwl u_t003_005/r0_r1_rwl
+ u_t003_005/r1_w0_wl u_t003_005/r1_w1_wl u_t003_005/r1_r0_rwl u_t003_005/r1_r1_rwl
+ u_t003_005/r2_w0_wl u_t003_005/r2_w1_wl u_t003_005/r2_r0_rwl u_t003_005/r2_r1_rwl
+ u_t003_005/r3_w0_wl u_t003_005/r3_w1_wl u_t003_005/r3_r0_rwl u_t003_005/r3_r1_rwl
+ u_t004_005/VDD u_t003_005/VSS u_t003_005/m2_717_1265# u_t003_005/m2_603_2031# u_t003_005/m2_1290_336#
+ u_t003_005/m2_2000_2037# u_t003_005/m2_791_2909# u_t003_005/m2_7_2126# u_t003_005/m2_2154_2081#
+ u_t003_005/m2_1795_2037# u_t003_005/m2_871_303# u_t003_005/m2_431_438# u_t003_005/m2_1290_2898#
+ u_t003_005/m2_1714_1210# u_t003_005/m2_431_1982# u_t003_005/m2_512_1265# u_t003_005/m2_2573_2126#
+ u_t003_005/m2_603_1259# u_t003_005/m2_2074_2909# u_t003_005/m2_7_336# u_t003_005/m2_717_2037#
+ u_t003_005/m2_1886_2031# u_t003_005/m2_2573_336# u_t003_005/m2_7_2898# u_t003_005/m2_2000_1265#
+ u_t003_005/m2_512_2037# u_t003_005/m2_1795_1265# u_t003_005/m2_1714_1982# u_t003_005/m2_1886_1259#
+ u_t003_005/m2_1290_2126# u_t003_005/m2_1714_438# u_t003_005/m2_431_1210# u_t003_005/m2_2573_2898#
+ u_t003_005/m2_2154_303# u_t003_005/m2_871_2081# VSUBS detronyx_12t_2w2r_rc4_4x4_routed_5layer_direct
Xgf180mcu_as_sc_mcu7t3v3__inv_2_926 VSS VSS VSS VSS gf180mcu_as_sc_mcu7t3v3__inv_2_926/VNW
+ VSUBS gf180mcu_as_sc_mcu7t3v3__inv_2
Xgf180mcu_as_sc_mcu7t3v3__inv_2_948 VSS VSS VSS VSS gf180mcu_as_sc_mcu7t3v3__inv_2_948/VNW
+ VSUBS gf180mcu_as_sc_mcu7t3v3__inv_2
Xgf180mcu_as_sc_mcu7t3v3__inv_2_937 VSS VSS VSS VSS gf180mcu_as_sc_mcu7t3v3__inv_2_937/VNW
+ VSUBS gf180mcu_as_sc_mcu7t3v3__inv_2
Xgf180mcu_as_sc_mcu7t3v3__inv_2_959 VSS VSS VSS VSS gf180mcu_as_sc_mcu7t3v3__inv_2_959/VNW
+ VSUBS gf180mcu_as_sc_mcu7t3v3__inv_2
Xgf180mcu_as_sc_mcu7t3v3__inv_2_915 VSS VSS VSS VSS gf180mcu_as_sc_mcu7t3v3__inv_2_957/VNW
+ VSUBS gf180mcu_as_sc_mcu7t3v3__inv_2
Xgf180mcu_as_sc_mcu7t3v3__nand4_2_269 VSS VSS VSS VSS VSS VSS gf180mcu_as_sc_mcu7t3v3__nand4_2_269/Y
+ gf180mcu_as_sc_mcu7t3v3__inv_2_927/VNW VSUBS gf180mcu_as_sc_mcu7t3v3__nand4_2
Xgf180mcu_as_sc_mcu7t3v3__nand4_2_203 VSS gf180mcu_as_sc_mcu7t3v3__inv_2_656/VDD VSS
+ VSS VSS VSS VSS gf180mcu_as_sc_mcu7t3v3__inv_2_652/VNW VSUBS gf180mcu_as_sc_mcu7t3v3__nand4_2
Xgf180mcu_as_sc_mcu7t3v3__nand4_2_225 VSS VSS VSS VSS VSS VSS VSS gf180mcu_as_sc_mcu7t3v3__inv_2_825/VNW
+ VSUBS gf180mcu_as_sc_mcu7t3v3__nand4_2
Xgf180mcu_as_sc_mcu7t3v3__nand4_2_214 VSS VSS VSS VSS VSS VSS VSS gf180mcu_as_sc_mcu7t3v3__inv_2_829/VNW
+ VSUBS gf180mcu_as_sc_mcu7t3v3__nand4_2
Xgf180mcu_as_sc_mcu7t3v3__nand4_2_247 VSS VSS VSS VSS VSS VSS gf180mcu_as_sc_mcu7t3v3__nand4_2_247/Y
+ gf180mcu_as_sc_mcu7t3v3__inv_2_819/VNW VSUBS gf180mcu_as_sc_mcu7t3v3__nand4_2
Xgf180mcu_as_sc_mcu7t3v3__nand4_2_236 VSS VSS VSS VSS VSS VSS VSS gf180mcu_as_sc_mcu7t3v3__inv_2_844/VNW
+ VSUBS gf180mcu_as_sc_mcu7t3v3__nand4_2
Xgf180mcu_as_sc_mcu7t3v3__nand4_2_258 VSS VSS VSS VSS VSS VSS gf180mcu_as_sc_mcu7t3v3__nand4_2_258/Y
+ gf180mcu_as_sc_mcu7t3v3__inv_2_930/VNW VSUBS gf180mcu_as_sc_mcu7t3v3__nand4_2
Xu_t000_008 u_t000_008/c0_w0_bl u_t000_008/c0_w0_br u_t000_008/c0_w1_bl u_t000_008/c0_w1_br
+ u_t000_008/c0_r0_rbl u_t000_008/c0_r1_rbl u_t000_008/c1_w0_bl u_t000_008/c1_w0_br
+ u_t000_008/c1_w1_bl u_t000_008/c1_w1_br u_t000_008/c1_r0_rbl u_t000_008/c1_r1_rbl
+ u_t000_008/c2_w0_bl u_t000_008/c2_w0_br u_t000_008/c2_w1_bl u_t000_008/c2_w1_br
+ u_t000_008/c2_r0_rbl u_t000_008/c2_r1_rbl u_t000_008/c3_w0_bl u_t000_008/c3_w0_br
+ u_t000_008/c3_w1_bl u_t000_008/c3_w1_br u_t000_008/c3_r0_rbl u_t000_008/c3_r1_rbl
+ u_t000_008/r0_w0_wl u_t000_008/r0_w1_wl u_t000_008/r0_r0_rwl u_t000_008/r0_r1_rwl
+ u_t000_008/r1_w0_wl u_t000_008/r1_w1_wl u_t000_008/r1_r0_rwl u_t000_008/r1_r1_rwl
+ u_t000_008/r2_w0_wl u_t000_008/r2_w1_wl u_t000_008/r2_r0_rwl u_t000_008/r2_r1_rwl
+ u_t000_008/r3_w0_wl u_t000_008/r3_w1_wl u_t000_008/r3_r0_rwl u_t000_008/r3_r1_rwl
+ VSS VSS u_t000_008/m2_717_1265# u_t000_008/m2_603_2031# u_t000_008/m2_1290_336#
+ u_t000_008/m2_2000_2037# u_t000_008/m2_791_2909# u_t000_008/m2_7_2126# u_t000_008/m2_2154_2081#
+ u_t000_008/m2_1795_2037# u_t000_008/m2_871_303# u_t000_008/m2_431_438# u_t000_008/m2_1290_2898#
+ u_t000_008/m2_1714_1210# u_t000_008/m2_431_1982# u_t000_008/m2_512_1265# u_t000_008/m2_2573_2126#
+ u_t000_008/m2_603_1259# u_t000_008/m2_2074_2909# u_t000_008/m2_7_336# u_t000_008/m2_717_2037#
+ u_t000_008/m2_1886_2031# u_t000_008/m2_2573_336# u_t000_008/m2_7_2898# u_t000_008/m2_2000_1265#
+ u_t000_008/m2_512_2037# u_t000_008/m2_1795_1265# u_t000_008/m2_1714_1982# u_t000_008/m2_1886_1259#
+ u_t000_008/m2_1290_2126# u_t000_008/m2_1714_438# u_t000_008/m2_431_1210# u_t000_008/m2_2573_2898#
+ u_t000_008/m2_2154_303# u_t000_008/m2_871_2081# VSUBS detronyx_12t_2w2r_rc4_4x4_routed_5layer_direct
Xgf180mcu_as_sc_mcu7t3v3__inv_2_1250 gf180mcu_as_sc_mcu7t3v3__nor2_2_9/VDD gf180mcu_as_sc_mcu7t3v3__nor2_2_9/VSS
+ VSS VSS gf180mcu_as_sc_mcu7t3v3__nor2_2_9/VNW VSUBS gf180mcu_as_sc_mcu7t3v3__inv_2
Xgf180mcu_as_sc_mcu7t3v3__inv_2_1261 gf180mcu_as_sc_mcu7t3v3__nand3_2_65/VDD gf180mcu_as_sc_mcu7t3v3__nand3_2_62/VSS
+ VSS VSS gf180mcu_as_sc_mcu7t3v3__nand3_2_65/VNW VSUBS gf180mcu_as_sc_mcu7t3v3__inv_2
Xgf180mcu_as_sc_mcu7t3v3__inv_2_1283 VSS VSS VSS VSS gf180mcu_as_sc_mcu7t3v3__inv_2_1283/VNW
+ VSUBS gf180mcu_as_sc_mcu7t3v3__inv_2
Xgf180mcu_as_sc_mcu7t3v3__inv_2_1272 VSS VSS VSS VSS gf180mcu_as_sc_mcu7t3v3__inv_2_1272/VNW
+ VSUBS gf180mcu_as_sc_mcu7t3v3__inv_2
Xgf180mcu_as_sc_mcu7t3v3__inv_2_1294 VSS VSS VSS VSS gf180mcu_as_sc_mcu7t3v3__inv_2_1294/VNW
+ VSUBS gf180mcu_as_sc_mcu7t3v3__inv_2
Xgf180mcu_as_sc_mcu7t3v3__inv_2_745 gf180mcu_as_sc_mcu7t3v3__inv_2_746/VDD gf180mcu_as_sc_mcu7t3v3__inv_2_746/VSS
+ gf180mcu_as_sc_mcu7t3v3__inv_2_745/Y gf180mcu_as_sc_mcu7t3v3__inv_2_746/Y gf180mcu_as_sc_mcu7t3v3__inv_2_746/VNW
+ VSUBS gf180mcu_as_sc_mcu7t3v3__inv_2
Xgf180mcu_as_sc_mcu7t3v3__inv_2_723 VSS gf180mcu_as_sc_mcu7t3v3__inv_2_746/VDD gf180mcu_as_sc_mcu7t3v3__inv_2_723/Y
+ gf180mcu_as_sc_mcu7t3v3__inv_2_724/Y gf180mcu_as_sc_mcu7t3v3__inv_2_724/VNW VSUBS
+ gf180mcu_as_sc_mcu7t3v3__inv_2
Xgf180mcu_as_sc_mcu7t3v3__inv_2_712 gf180mcu_as_sc_mcu7t3v3__inv_2_712/VDD VSS gf180mcu_as_sc_mcu7t3v3__inv_2_712/Y
+ VSS gf180mcu_as_sc_mcu7t3v3__inv_2_712/VNW VSUBS gf180mcu_as_sc_mcu7t3v3__inv_2
Xgf180mcu_as_sc_mcu7t3v3__inv_2_701 gf180mcu_as_sc_mcu7t3v3__inv_2_743/VSS VSS gf180mcu_as_sc_mcu7t3v3__inv_2_701/Y
+ VSS gf180mcu_as_sc_mcu7t3v3__inv_2_701/VNW VSUBS gf180mcu_as_sc_mcu7t3v3__inv_2
Xgf180mcu_as_sc_mcu7t3v3__inv_2_734 VSS VSS gf180mcu_as_sc_mcu7t3v3__inv_2_734/Y gf180mcu_as_sc_mcu7t3v3__inv_2_742/A
+ gf180mcu_as_sc_mcu7t3v3__inv_2_736/VNW VSUBS gf180mcu_as_sc_mcu7t3v3__inv_2
Xgf180mcu_as_sc_mcu7t3v3__inv_2_767 VSS VSS gf180mcu_as_sc_mcu7t3v3__inv_2_767/Y VSS
+ gf180mcu_as_sc_mcu7t3v3__inv_2_823/VNW VSUBS gf180mcu_as_sc_mcu7t3v3__inv_2
Xgf180mcu_as_sc_mcu7t3v3__inv_2_756 VSS VSS gf180mcu_as_sc_mcu7t3v3__inv_2_756/Y VSS
+ gf180mcu_as_sc_mcu7t3v3__inv_2_836/VNW VSUBS gf180mcu_as_sc_mcu7t3v3__inv_2
Xgf180mcu_as_sc_mcu7t3v3__inv_2_778 VSS VSS VSS VSS gf180mcu_as_sc_mcu7t3v3__inv_2_834/VNW
+ VSUBS gf180mcu_as_sc_mcu7t3v3__inv_2
Xgf180mcu_as_sc_mcu7t3v3__inv_2_789 VSS VSS VSS VSS gf180mcu_as_sc_mcu7t3v3__inv_2_843/VNW
+ VSUBS gf180mcu_as_sc_mcu7t3v3__inv_2
Xgf180mcu_as_sc_mcu7t3v3__inv_2_1091 gf180mcu_as_sc_mcu7t3v3__inv_2_1091/VDD VSS gf180mcu_as_sc_mcu7t3v3__inv_2_1091/Y
+ VSS gf180mcu_as_sc_mcu7t3v3__inv_2_1091/VNW VSUBS gf180mcu_as_sc_mcu7t3v3__inv_2
Xgf180mcu_as_sc_mcu7t3v3__inv_2_1080 VSS VSS gf180mcu_as_sc_mcu7t3v3__inv_2_1080/Y
+ VSS gf180mcu_as_sc_mcu7t3v3__inv_2_1080/VNW VSUBS gf180mcu_as_sc_mcu7t3v3__inv_2
Xgf180mcu_as_sc_mcu7t3v3__nand4_2_3 gf180mcu_as_sc_mcu7t3v3__inv_2_91/VSS gf180mcu_as_sc_mcu7t3v3__inv_2_91/VSS
+ VSS VSS VSS VSS VSS gf180mcu_as_sc_mcu7t3v3__nand4_2_3/VNW VSUBS gf180mcu_as_sc_mcu7t3v3__nand4_2
Xgf180mcu_as_sc_mcu7t3v3__inv_2_542 VSS VSS VSS VSS gf180mcu_as_sc_mcu7t3v3__inv_2_542/VNW
+ VSUBS gf180mcu_as_sc_mcu7t3v3__inv_2
Xgf180mcu_as_sc_mcu7t3v3__inv_2_586 gf180mcu_as_sc_mcu7t3v3__inv_2_588/VDD gf180mcu_as_sc_mcu7t3v3__inv_2_590/VSS
+ gf180mcu_as_sc_mcu7t3v3__inv_2_586/Y gf180mcu_as_sc_mcu7t3v3__inv_2_640/Y gf180mcu_as_sc_mcu7t3v3__inv_2_588/VNW
+ VSUBS gf180mcu_as_sc_mcu7t3v3__inv_2
Xgf180mcu_as_sc_mcu7t3v3__inv_2_564 gf180mcu_as_sc_mcu7t3v3__inv_2_590/VSS gf180mcu_as_sc_mcu7t3v3__inv_2_590/VSS
+ gf180mcu_as_sc_mcu7t3v3__inv_2_590/A VSS gf180mcu_as_sc_mcu7t3v3__inv_2_590/VNW
+ VSUBS gf180mcu_as_sc_mcu7t3v3__inv_2
Xgf180mcu_as_sc_mcu7t3v3__inv_2_575 gf180mcu_as_sc_mcu7t3v3__inv_2_576/VDD gf180mcu_as_sc_mcu7t3v3__inv_2_579/VDD
+ gf180mcu_as_sc_mcu7t3v3__inv_2_575/Y gf180mcu_as_sc_mcu7t3v3__inv_2_576/Y gf180mcu_as_sc_mcu7t3v3__inv_2_576/VNW
+ VSUBS gf180mcu_as_sc_mcu7t3v3__inv_2
Xgf180mcu_as_sc_mcu7t3v3__inv_2_520 gf180mcu_as_sc_mcu7t3v3__nor2_2_6/VDD gf180mcu_as_sc_mcu7t3v3__nor2_2_6/VSS
+ VSS VSS gf180mcu_as_sc_mcu7t3v3__nor2_2_6/VNW VSUBS gf180mcu_as_sc_mcu7t3v3__inv_2
Xgf180mcu_as_sc_mcu7t3v3__inv_2_531 gf180mcu_as_sc_mcu7t3v3__nor2_2_4/VDD gf180mcu_as_sc_mcu7t3v3__nand2_2_3/VSS
+ VSS VSS gf180mcu_as_sc_mcu7t3v3__nor2_2_4/VNW VSUBS gf180mcu_as_sc_mcu7t3v3__inv_2
Xgf180mcu_as_sc_mcu7t3v3__inv_2_553 VSS VSS VSS VSS gf180mcu_as_sc_mcu7t3v3__inv_2_553/VNW
+ VSUBS gf180mcu_as_sc_mcu7t3v3__inv_2
Xgf180mcu_as_sc_mcu7t3v3__inv_2_597 gf180mcu_as_sc_mcu7t3v3__inv_2_638/VSS gf180mcu_as_sc_mcu7t3v3__inv_2_602/VDD
+ gf180mcu_as_sc_mcu7t3v3__inv_2_597/Y gf180mcu_as_sc_mcu7t3v3__inv_2_598/Y gf180mcu_as_sc_mcu7t3v3__inv_2_598/VNW
+ VSUBS gf180mcu_as_sc_mcu7t3v3__inv_2
Xgf180mcu_as_sc_mcu7t3v3__inv_2_372 gf180mcu_as_sc_mcu7t3v3__nor2_2_7/VDD gf180mcu_as_sc_mcu7t3v3__nand3_2_4/VSS
+ gf180mcu_as_sc_mcu7t3v3__inv_2_372/Y VSS gf180mcu_as_sc_mcu7t3v3__nor2_2_7/VNW VSUBS
+ gf180mcu_as_sc_mcu7t3v3__inv_2
Xgf180mcu_as_sc_mcu7t3v3__inv_2_394 gf180mcu_as_sc_mcu7t3v3__nor2_2_7/VDD gf180mcu_as_sc_mcu7t3v3__nor2_2_7/VSS
+ VSS VSS gf180mcu_as_sc_mcu7t3v3__nor2_2_7/VNW VSUBS gf180mcu_as_sc_mcu7t3v3__inv_2
Xgf180mcu_as_sc_mcu7t3v3__inv_2_383 gf180mcu_as_sc_mcu7t3v3__nand3_2_9/VDD gf180mcu_as_sc_mcu7t3v3__nor2_2_7/VSS
+ VSS VSS gf180mcu_as_sc_mcu7t3v3__nand3_2_9/VNW VSUBS gf180mcu_as_sc_mcu7t3v3__inv_2
Xgf180mcu_as_sc_mcu7t3v3__inv_2_361 gf180mcu_as_sc_mcu7t3v3__inv_2_365/VDD gf180mcu_as_sc_mcu7t3v3__inv_2_365/VDD
+ gf180mcu_as_sc_mcu7t3v3__inv_2_365/Y gf180mcu_as_sc_mcu7t3v3__inv_2_365/Y gf180mcu_as_sc_mcu7t3v3__inv_2_362/VNW
+ VSUBS gf180mcu_as_sc_mcu7t3v3__inv_2
Xgf180mcu_as_sc_mcu7t3v3__inv_2_350 gf180mcu_as_sc_mcu7t3v3__inv_2_350/VDD VSS gf180mcu_as_sc_mcu7t3v3__inv_2_350/Y
+ VSS gf180mcu_as_sc_mcu7t3v3__inv_2_350/VNW VSUBS gf180mcu_as_sc_mcu7t3v3__inv_2
Xu_t027_011 u_t027_011/c0_w0_bl u_t027_011/c0_w0_br u_t027_011/c0_w1_bl u_t027_011/c0_w1_br
+ u_t027_011/c0_r0_rbl u_t027_011/c0_r1_rbl u_t027_011/c1_w0_bl u_t027_011/c1_w0_br
+ u_t027_011/c1_w1_bl u_t027_011/c1_w1_br u_t027_011/c1_r0_rbl u_t027_011/c1_r1_rbl
+ u_t027_011/c2_w0_bl u_t027_011/c2_w0_br u_t027_011/c2_w1_bl u_t027_011/c2_w1_br
+ u_t027_011/c2_r0_rbl u_t027_011/c2_r1_rbl u_t027_011/c3_w0_bl u_t027_011/c3_w0_br
+ u_t027_011/c3_w1_bl u_t027_011/c3_w1_br u_t027_011/c3_r0_rbl u_t027_011/c3_r1_rbl
+ u_t027_011/r0_w0_wl u_t027_011/r0_w1_wl u_t027_011/r0_r0_rwl u_t027_011/r0_r1_rwl
+ u_t027_011/r1_w0_wl u_t027_011/r1_w1_wl u_t027_011/r1_r0_rwl u_t027_011/r1_r1_rwl
+ u_t027_011/r2_w0_wl u_t027_011/r2_w1_wl u_t027_011/r2_r0_rwl u_t027_011/r2_r1_rwl
+ u_t027_011/r3_w0_wl u_t027_011/r3_w1_wl u_t027_011/r3_r0_rwl u_t027_011/r3_r1_rwl
+ u_t027_011/VDD u_t027_011/VSS u_t027_011/m2_717_1265# u_t027_011/m2_603_2031# u_t027_011/m2_1290_336#
+ u_t027_011/m2_2000_2037# u_t027_011/m2_791_2909# u_t027_011/m2_7_2126# u_t027_011/m2_2154_2081#
+ u_t027_011/m2_1795_2037# u_t027_011/m2_871_303# u_t027_011/m2_431_438# u_t027_011/m2_1290_2898#
+ u_t027_011/m2_1714_1210# u_t027_011/m2_431_1982# u_t027_011/m2_512_1265# u_t027_011/m2_2573_2126#
+ u_t027_011/m2_603_1259# u_t027_011/m2_2074_2909# u_t027_011/m2_7_336# u_t027_011/m2_717_2037#
+ u_t027_011/m2_1886_2031# u_t027_011/m2_2573_336# u_t027_011/m2_7_2898# u_t027_011/m2_2000_1265#
+ u_t027_011/m2_512_2037# u_t027_011/m2_1795_1265# u_t027_011/m2_1714_1982# u_t027_011/m2_1886_1259#
+ u_t027_011/m2_1290_2126# u_t027_011/m2_1714_438# u_t027_011/m2_431_1210# u_t027_011/m2_2573_2898#
+ u_t027_011/m2_2154_303# u_t027_011/m2_871_2081# VSUBS detronyx_12t_2w2r_rc4_4x4_routed_5layer_direct
Xu_t027_000 VSS u_t027_000/c0_w0_br VSS u_t027_000/c0_w1_br u_t027_000/c0_r0_rbl u_t027_000/c0_r1_rbl
+ VSS VSS VSS VSS VSS VSS u_t027_000/c2_w0_bl u_t027_000/c2_w0_br u_t027_000/c2_w1_bl
+ u_t027_000/c2_w1_br u_t027_000/c2_r0_rbl u_t027_000/c2_r1_rbl u_t027_000/c3_w0_bl
+ u_t027_000/c3_w0_br u_t027_000/c3_w1_bl u_t027_000/c3_w1_br u_t027_000/c3_r0_rbl
+ u_t027_000/c3_r1_rbl VSS VSS VSS VSS VSS VSS VSS VSS VSS VSS VSS VSS VSS VSS VSS
+ VSS VSS VSS u_t027_000/m2_717_1265# VSS VSS VSS VSS u_t027_000/m2_7_2126# VSS VSS
+ VSS VSS VSS VSS VSS u_t027_000/m2_512_1265# u_t027_000/m2_2573_2126# u_t027_000/m2_603_1259#
+ VSS VSS VSS VSS u_t027_000/m2_2573_336# VSS u_t027_000/m2_2000_1265# VSS u_t027_000/m2_1795_1265#
+ VSS u_t027_000/m2_1886_1259# u_t027_000/m2_1290_2126# VSS VSS u_t027_000/m2_2573_2898#
+ VSS VSS VSUBS detronyx_12t_2w2r_rc4_4x4_routed_5layer_direct
Xu_t018_011 u_t018_011/c0_w0_bl u_t018_011/c0_w0_br u_t018_011/c0_w1_bl u_t018_011/c0_w1_br
+ u_t018_011/c0_r0_rbl u_t018_011/c0_r1_rbl u_t018_011/c1_w0_bl u_t018_011/c1_w0_br
+ u_t018_011/c1_w1_bl u_t018_011/c1_w1_br u_t018_011/c1_r0_rbl u_t018_011/c1_r1_rbl
+ u_t018_011/c2_w0_bl u_t018_011/c2_w0_br u_t018_011/c2_w1_bl u_t018_011/c2_w1_br
+ u_t018_011/c2_r0_rbl u_t018_011/c2_r1_rbl u_t018_011/c3_w0_bl u_t018_011/c3_w0_br
+ u_t018_011/c3_w1_bl u_t018_011/c3_w1_br u_t018_011/c3_r0_rbl u_t018_011/c3_r1_rbl
+ u_t018_011/r0_w0_wl u_t018_011/r0_w1_wl u_t018_011/r0_r0_rwl u_t018_011/r0_r1_rwl
+ u_t018_011/r1_w0_wl u_t018_011/r1_w1_wl u_t018_011/r1_r0_rwl u_t018_011/r1_r1_rwl
+ u_t018_011/r2_w0_wl u_t018_011/r2_w1_wl u_t018_011/r2_r0_rwl u_t018_011/r2_r1_rwl
+ u_t018_011/r3_w0_wl u_t018_011/r3_w1_wl u_t018_011/r3_r0_rwl u_t018_011/r3_r1_rwl
+ u_t018_011/VDD u_t018_011/VSS u_t018_011/m2_717_1265# u_t018_011/m2_603_2031# u_t018_011/m2_1290_336#
+ u_t018_011/m2_2000_2037# u_t018_011/m2_791_2909# u_t018_011/m2_7_2126# u_t018_011/m2_2154_2081#
+ u_t018_011/m2_1795_2037# u_t018_011/m2_871_303# u_t018_011/m2_431_438# u_t018_011/m2_1290_2898#
+ u_t018_011/m2_1714_1210# u_t018_011/m2_431_1982# u_t018_011/m2_512_1265# u_t018_011/m2_2573_2126#
+ u_t018_011/m2_603_1259# u_t018_011/m2_2074_2909# u_t018_011/m2_7_336# u_t018_011/m2_717_2037#
+ u_t018_011/m2_1886_2031# u_t018_011/m2_2573_336# u_t018_011/m2_7_2898# u_t018_011/m2_2000_1265#
+ u_t018_011/m2_512_2037# u_t018_011/m2_1795_1265# u_t018_011/m2_1714_1982# u_t018_011/m2_1886_1259#
+ u_t018_011/m2_1290_2126# u_t018_011/m2_1714_438# u_t018_011/m2_431_1210# u_t018_011/m2_2573_2898#
+ u_t018_011/m2_2154_303# u_t018_011/m2_871_2081# VSUBS detronyx_12t_2w2r_rc4_4x4_routed_5layer_direct
Xu_t018_000 VSS u_t018_000/c0_w0_br VSS u_t018_000/c0_w1_br u_t018_000/c0_r0_rbl u_t018_000/c0_r1_rbl
+ VSS VSS VSS VSS VSS VSS u_t018_000/c2_w0_bl u_t018_000/c2_w0_br u_t018_000/c2_w1_bl
+ u_t018_000/c2_w1_br u_t018_000/c2_r0_rbl u_t018_000/c2_r1_rbl u_t018_000/c3_w0_bl
+ u_t018_000/c3_w0_br u_t018_000/c3_w1_bl u_t018_000/c3_w1_br u_t018_000/c3_r0_rbl
+ u_t018_000/c3_r1_rbl VSS VSS VSS VSS VSS VSS VSS VSS VSS VSS VSS VSS VSS VSS VSS
+ VSS VSS VSS VSS VSS VSS VSS VSS VSS VSS VSS VSS VSS VSS VSS VSS VSS u_t018_000/m2_2573_2126#
+ VSS VSS VSS VSS VSS u_t018_000/m2_2573_336# VSS VSS VSS VSS u_t018_000/m2_1714_1982#
+ VSS VSS u_t018_000/m2_1714_438# VSS u_t018_000/m2_2573_2898# VSS VSS VSUBS detronyx_12t_2w2r_rc4_4x4_routed_5layer_direct
Xu_t024_014 u_t024_014/c0_w0_bl u_t024_014/c0_w0_br u_t024_014/c0_w1_bl u_t024_014/c0_w1_br
+ u_t024_014/c0_r0_rbl u_t024_014/c0_r1_rbl u_t024_014/c1_w0_bl u_t024_014/c1_w0_br
+ u_t024_014/c1_w1_bl u_t024_014/c1_w1_br u_t024_014/c1_r0_rbl u_t024_014/c1_r1_rbl
+ u_t024_014/c2_w0_bl u_t024_014/c2_w0_br u_t024_014/c2_w1_bl u_t024_014/c2_w1_br
+ u_t024_014/c2_r0_rbl u_t024_014/c2_r1_rbl u_t024_014/c3_w0_bl u_t024_014/c3_w0_br
+ u_t024_014/c3_w1_bl u_t024_014/c3_w1_br u_t024_014/c3_r0_rbl u_t024_014/c3_r1_rbl
+ u_t024_014/r0_w0_wl u_t024_014/r0_w1_wl u_t024_014/r0_r0_rwl u_t024_014/r0_r1_rwl
+ u_t024_014/r1_w0_wl u_t024_014/r1_w1_wl u_t024_014/r1_r0_rwl u_t024_014/r1_r1_rwl
+ u_t024_014/r2_w0_wl u_t024_014/r2_w1_wl u_t024_014/r2_r0_rwl u_t024_014/r2_r1_rwl
+ u_t024_014/r3_w0_wl u_t024_014/r3_w1_wl u_t024_014/r3_r0_rwl u_t024_014/r3_r1_rwl
+ u_t025_014/VDD u_t024_015/VSS u_t024_014/m2_717_1265# u_t024_014/m2_603_2031# u_t024_014/m2_1290_336#
+ u_t024_014/m2_2000_2037# u_t024_014/m2_791_2909# u_t024_014/m2_7_2126# u_t024_014/m2_2154_2081#
+ u_t024_014/m2_1795_2037# u_t024_014/m2_871_303# u_t024_014/m2_431_438# u_t024_014/m2_1290_2898#
+ u_t024_014/m2_1714_1210# u_t024_014/m2_431_1982# u_t024_014/m2_512_1265# u_t024_014/m2_2573_2126#
+ u_t024_014/m2_603_1259# u_t024_014/m2_2074_2909# u_t024_014/m2_7_336# u_t024_014/m2_717_2037#
+ u_t024_014/m2_1886_2031# u_t024_014/m2_2573_336# u_t024_014/m2_7_2898# u_t024_014/m2_2000_1265#
+ u_t024_014/m2_512_2037# u_t024_014/m2_1795_1265# u_t024_014/m2_1714_1982# u_t024_014/m2_1886_1259#
+ u_t024_014/m2_1290_2126# u_t024_014/m2_1714_438# u_t024_014/m2_431_1210# u_t024_014/m2_2573_2898#
+ u_t024_014/m2_2154_303# u_t024_014/m2_871_2081# VSUBS detronyx_12t_2w2r_rc4_4x4_routed_5layer_direct
Xu_t009_011 u_t009_011/c0_w0_bl u_t009_011/c0_w0_br u_t009_011/c0_w1_bl u_t009_011/c0_w1_br
+ u_t009_011/c0_r0_rbl u_t009_011/c0_r1_rbl u_t009_011/c1_w0_bl u_t009_011/c1_w0_br
+ u_t009_011/c1_w1_bl u_t009_011/c1_w1_br u_t009_011/c1_r0_rbl u_t009_011/c1_r1_rbl
+ u_t009_011/c2_w0_bl u_t009_011/c2_w0_br u_t009_011/c2_w1_bl u_t009_011/c2_w1_br
+ u_t009_011/c2_r0_rbl u_t009_011/c2_r1_rbl u_t009_011/c3_w0_bl u_t009_011/c3_w0_br
+ u_t009_011/c3_w1_bl u_t009_011/c3_w1_br u_t009_011/c3_r0_rbl u_t009_011/c3_r1_rbl
+ u_t009_011/r0_w0_wl u_t009_011/r0_w1_wl u_t009_011/r0_r0_rwl u_t009_011/r0_r1_rwl
+ u_t009_011/r1_w0_wl u_t009_011/r1_w1_wl u_t009_011/r1_r0_rwl u_t009_011/r1_r1_rwl
+ u_t009_011/r2_w0_wl u_t009_011/r2_w1_wl u_t009_011/r2_r0_rwl u_t009_011/r2_r1_rwl
+ u_t009_011/r3_w0_wl u_t009_011/r3_w1_wl u_t009_011/r3_r0_rwl u_t009_011/r3_r1_rwl
+ u_t009_011/VDD VSS u_t009_011/m2_717_1265# u_t009_011/m2_603_2031# u_t009_011/m2_1290_336#
+ u_t009_011/m2_2000_2037# u_t009_011/m2_791_2909# u_t009_011/m2_7_2126# u_t009_011/m2_2154_2081#
+ u_t009_011/m2_1795_2037# u_t009_011/m2_871_303# u_t009_011/m2_431_438# u_t009_011/m2_1290_2898#
+ u_t009_011/m2_1714_1210# u_t009_011/m2_431_1982# u_t009_011/m2_512_1265# u_t009_011/m2_2573_2126#
+ u_t009_011/m2_603_1259# u_t009_011/m2_2074_2909# u_t009_011/m2_7_336# u_t009_011/m2_717_2037#
+ u_t009_011/m2_1886_2031# u_t009_011/m2_2573_336# u_t009_011/m2_7_2898# u_t009_011/m2_2000_1265#
+ u_t009_011/m2_512_2037# u_t009_011/m2_1795_1265# u_t009_011/m2_1714_1982# u_t009_011/m2_1886_1259#
+ u_t009_011/m2_1290_2126# u_t009_011/m2_1714_438# u_t009_011/m2_431_1210# u_t009_011/m2_2573_2898#
+ u_t009_011/m2_2154_303# u_t009_011/m2_871_2081# VSUBS detronyx_12t_2w2r_rc4_4x4_routed_5layer_direct
Xu_t024_003 u_t024_003/c0_w0_bl u_t024_003/c0_w0_br u_t024_003/c0_w1_bl u_t024_003/c0_w1_br
+ u_t024_003/c0_r0_rbl u_t024_003/c0_r1_rbl u_t024_003/c1_w0_bl u_t024_003/c1_w0_br
+ u_t024_003/c1_w1_bl u_t024_003/c1_w1_br u_t024_003/c1_r0_rbl u_t024_003/c1_r1_rbl
+ u_t024_003/c2_w0_bl u_t024_003/c2_w0_br u_t024_003/c2_w1_bl u_t024_003/c2_w1_br
+ u_t024_003/c2_r0_rbl u_t024_003/c2_r1_rbl u_t024_003/c3_w0_bl u_t024_003/c3_w0_br
+ u_t024_003/c3_w1_bl u_t024_003/c3_w1_br u_t024_003/c3_r0_rbl u_t024_003/c3_r1_rbl
+ u_t024_003/r0_w0_wl u_t024_003/r0_w1_wl u_t024_003/r0_r0_rwl u_t024_003/r0_r1_rwl
+ u_t024_003/r1_w0_wl u_t024_003/r1_w1_wl u_t024_003/r1_r0_rwl u_t024_003/r1_r1_rwl
+ u_t024_003/r2_w0_wl u_t024_003/r2_w1_wl u_t024_003/r2_r0_rwl u_t024_003/r2_r1_rwl
+ u_t024_003/r3_w0_wl u_t024_003/r3_w1_wl u_t024_003/r3_r0_rwl u_t024_003/r3_r1_rwl
+ u_t025_003/VDD u_t024_003/VSS u_t024_003/m2_717_1265# u_t024_003/m2_603_2031# u_t024_003/m2_1290_336#
+ u_t024_003/m2_2000_2037# u_t024_003/m2_791_2909# u_t024_003/m2_7_2126# u_t024_003/m2_2154_2081#
+ u_t024_003/m2_1795_2037# u_t024_003/m2_871_303# u_t024_003/m2_431_438# u_t024_003/m2_1290_2898#
+ u_t024_003/m2_1714_1210# u_t024_003/m2_431_1982# u_t024_003/m2_512_1265# u_t024_003/m2_2573_2126#
+ u_t024_003/m2_603_1259# u_t024_003/m2_2074_2909# u_t024_003/m2_7_336# u_t024_003/m2_717_2037#
+ u_t024_003/m2_1886_2031# u_t024_003/m2_2573_336# u_t024_003/m2_7_2898# u_t024_003/m2_2000_1265#
+ u_t024_003/m2_512_2037# u_t024_003/m2_1795_1265# u_t024_003/m2_1714_1982# u_t024_003/m2_1886_1259#
+ u_t024_003/m2_1290_2126# u_t024_003/m2_1714_438# u_t024_003/m2_431_1210# u_t024_003/m2_2573_2898#
+ u_t024_003/m2_2154_303# u_t024_003/m2_871_2081# VSUBS detronyx_12t_2w2r_rc4_4x4_routed_5layer_direct
Xgf180mcu_as_sc_mcu7t3v3__nand3_2_59 gf180mcu_as_sc_mcu7t3v3__nor2_2_9/VDD gf180mcu_as_sc_mcu7t3v3__nor2_2_9/VSS
+ VSS VSS VSS VSS gf180mcu_as_sc_mcu7t3v3__nor2_2_9/VNW VSUBS gf180mcu_as_sc_mcu7t3v3__nand3_2
Xgf180mcu_as_sc_mcu7t3v3__nand3_2_48 gf180mcu_as_sc_mcu7t3v3__nand3_2_65/VDD gf180mcu_as_sc_mcu7t3v3__nand3_2_62/VSS
+ VSS VSS VSS VSS gf180mcu_as_sc_mcu7t3v3__nand3_2_65/VNW VSUBS gf180mcu_as_sc_mcu7t3v3__nand3_2
Xgf180mcu_as_sc_mcu7t3v3__nand3_2_37 gf180mcu_as_sc_mcu7t3v3__nor2_2_6/VDD gf180mcu_as_sc_mcu7t3v3__nand3_2_4/VSS
+ VSS VSS VSS VSS gf180mcu_as_sc_mcu7t3v3__nor2_2_6/VNW VSUBS gf180mcu_as_sc_mcu7t3v3__nand3_2
Xgf180mcu_as_sc_mcu7t3v3__nand3_2_15 gf180mcu_as_sc_mcu7t3v3__nor2_2_6/VDD gf180mcu_as_sc_mcu7t3v3__nor2_2_6/VSS
+ VSS VSS VSS VSS gf180mcu_as_sc_mcu7t3v3__nor2_2_6/VNW VSUBS gf180mcu_as_sc_mcu7t3v3__nand3_2
Xgf180mcu_as_sc_mcu7t3v3__nand3_2_26 gf180mcu_as_sc_mcu7t3v3__nor2_2_7/VDD gf180mcu_as_sc_mcu7t3v3__nand3_2_4/VSS
+ VSS VSS VSS VSS gf180mcu_as_sc_mcu7t3v3__nor2_2_7/VNW VSUBS gf180mcu_as_sc_mcu7t3v3__nand3_2
Xu_t009_000 VSS u_t009_000/c0_w0_br VSS u_t009_000/c0_w1_br u_t009_000/c0_r0_rbl u_t009_000/c0_r1_rbl
+ VSS VSS VSS VSS VSS VSS u_t009_000/c2_w0_bl u_t009_000/c2_w0_br u_t009_000/c2_w1_bl
+ u_t009_000/c2_w1_br u_t009_000/c2_r0_rbl u_t009_000/c2_r1_rbl u_t009_000/c3_w0_bl
+ u_t009_000/c3_w0_br u_t009_000/c3_w1_bl u_t009_000/c3_w1_br u_t009_000/c3_r0_rbl
+ u_t009_000/c3_r1_rbl VSS VSS VSS VSS VSS VSS VSS VSS VSS VSS VSS VSS VSS VSS VSS
+ VSS VSS VSS u_t009_000/m2_717_1265# u_t009_000/m2_603_2031# u_t009_000/m2_1290_336#
+ u_t009_000/m2_2000_2037# u_t009_000/m2_791_2909# u_t009_000/m2_7_2126# u_t009_000/m2_2154_2081#
+ u_t009_000/m2_1795_2037# u_t009_000/m2_871_303# u_t009_000/m2_431_438# u_t009_000/m2_1290_2898#
+ u_t009_000/m2_1714_1210# u_t009_000/m2_431_1982# u_t009_000/m2_512_1265# u_t009_000/m2_2573_2126#
+ u_t009_000/m2_603_1259# u_t009_000/m2_2074_2909# u_t009_000/m2_7_336# u_t009_000/m2_717_2037#
+ u_t009_000/m2_1886_2031# u_t009_000/m2_2573_336# u_t009_000/m2_7_2898# u_t009_000/m2_2000_1265#
+ u_t009_000/m2_512_2037# u_t009_000/m2_1795_1265# u_t009_000/m2_1714_1982# u_t009_000/m2_1886_1259#
+ u_t009_000/m2_1290_2126# u_t009_000/m2_1714_438# u_t009_000/m2_431_1210# u_t009_000/m2_2573_2898#
+ u_t009_000/m2_2154_303# u_t009_000/m2_871_2081# VSUBS detronyx_12t_2w2r_rc4_4x4_routed_5layer_direct
Xgf180mcu_as_sc_mcu7t3v3__inv_2_1635 VSS VSS gf180mcu_as_sc_mcu7t3v3__inv_2_1669/A
+ gf180mcu_as_sc_mcu7t3v3__inv_2_1669/A gf180mcu_as_sc_mcu7t3v3__inv_2_1669/VNW VSUBS
+ gf180mcu_as_sc_mcu7t3v3__inv_2
Xgf180mcu_as_sc_mcu7t3v3__inv_2_1602 VSS VSS gf180mcu_as_sc_mcu7t3v3__inv_2_1669/A
+ VSS gf180mcu_as_sc_mcu7t3v3__inv_2_1669/VNW VSUBS gf180mcu_as_sc_mcu7t3v3__inv_2
Xgf180mcu_as_sc_mcu7t3v3__inv_2_1613 gf180mcu_as_sc_mcu7t3v3__inv_2_1614/VDD gf180mcu_as_sc_mcu7t3v3__inv_2_1618/VDD
+ gf180mcu_as_sc_mcu7t3v3__inv_2_1613/Y gf180mcu_as_sc_mcu7t3v3__inv_2_1669/A gf180mcu_as_sc_mcu7t3v3__inv_2_1614/VNW
+ VSUBS gf180mcu_as_sc_mcu7t3v3__inv_2
Xgf180mcu_as_sc_mcu7t3v3__inv_2_1624 gf180mcu_as_sc_mcu7t3v3__inv_2_1626/VDD gf180mcu_as_sc_mcu7t3v3__inv_2_1648/VDD
+ VSS gf180mcu_as_sc_mcu7t3v3__inv_2_1669/A gf180mcu_as_sc_mcu7t3v3__inv_2_1626/VNW
+ VSUBS gf180mcu_as_sc_mcu7t3v3__inv_2
Xgf180mcu_as_sc_mcu7t3v3__inv_2_180 VSS gf180mcu_as_sc_mcu7t3v3__inv_2_182/VDD VSS
+ VSS gf180mcu_as_sc_mcu7t3v3__inv_2_180/VNW VSUBS gf180mcu_as_sc_mcu7t3v3__inv_2
Xgf180mcu_as_sc_mcu7t3v3__inv_2_191 gf180mcu_as_sc_mcu7t3v3__inv_2_193/VDD VSS gf180mcu_as_sc_mcu7t3v3__inv_2_191/Y
+ VSS gf180mcu_as_sc_mcu7t3v3__inv_2_193/VNW VSUBS gf180mcu_as_sc_mcu7t3v3__inv_2
Xgf180mcu_as_sc_mcu7t3v3__inv_2_1657 gf180mcu_as_sc_mcu7t3v3__inv_2_1665/VDD VSS VSS
+ gf180mcu_as_sc_mcu7t3v3__inv_2_1689/A gf180mcu_as_sc_mcu7t3v3__inv_2_1665/VNW VSUBS
+ gf180mcu_as_sc_mcu7t3v3__inv_2
Xgf180mcu_as_sc_mcu7t3v3__inv_2_1646 gf180mcu_as_sc_mcu7t3v3__inv_2_1648/VDD VSS VSS
+ gf180mcu_as_sc_mcu7t3v3__inv_2_1669/A gf180mcu_as_sc_mcu7t3v3__inv_2_1648/VNW VSUBS
+ gf180mcu_as_sc_mcu7t3v3__inv_2
Xgf180mcu_as_sc_mcu7t3v3__inv_2_1668 VSS gf180mcu_as_sc_mcu7t3v3__inv_2_1672/VDD gf180mcu_as_sc_mcu7t3v3__inv_2_1672/Y
+ VSS gf180mcu_as_sc_mcu7t3v3__inv_2_1668/VNW VSUBS gf180mcu_as_sc_mcu7t3v3__inv_2
Xgf180mcu_as_sc_mcu7t3v3__inv_2_1679 VSS gf180mcu_as_sc_mcu7t3v3__inv_2_1684/VDD gf180mcu_as_sc_mcu7t3v3__inv_2_1679/Y
+ gf180mcu_as_sc_mcu7t3v3__inv_2_1684/Y gf180mcu_as_sc_mcu7t3v3__inv_2_1680/VNW VSUBS
+ gf180mcu_as_sc_mcu7t3v3__inv_2
Xu_t015_014 u_t015_014/c0_w0_bl u_t015_014/c0_w0_br u_t015_014/c0_w1_bl u_t015_014/c0_w1_br
+ u_t015_014/c0_r0_rbl u_t015_014/c0_r1_rbl u_t015_014/c1_w0_bl u_t015_014/c1_w0_br
+ u_t015_014/c1_w1_bl u_t015_014/c1_w1_br u_t015_014/c1_r0_rbl u_t015_014/c1_r1_rbl
+ u_t015_014/c2_w0_bl u_t015_014/c2_w0_br u_t015_014/c2_w1_bl u_t015_014/c2_w1_br
+ u_t015_014/c2_r0_rbl u_t015_014/c2_r1_rbl u_t015_014/c3_w0_bl u_t015_014/c3_w0_br
+ u_t015_014/c3_w1_bl u_t015_014/c3_w1_br u_t015_014/c3_r0_rbl u_t015_014/c3_r1_rbl
+ u_t015_014/r0_w0_wl u_t015_014/r0_w1_wl u_t015_014/r0_r0_rwl u_t015_014/r0_r1_rwl
+ u_t015_014/r1_w0_wl u_t015_014/r1_w1_wl u_t015_014/r1_r0_rwl u_t015_014/r1_r1_rwl
+ u_t015_014/r2_w0_wl u_t015_014/r2_w1_wl u_t015_014/r2_r0_rwl u_t015_014/r2_r1_rwl
+ u_t015_014/r3_w0_wl u_t015_014/r3_w1_wl u_t015_014/r3_r0_rwl u_t015_014/r3_r1_rwl
+ u_t015_014/VDD u_t015_015/VSS u_t015_014/m2_717_1265# u_t015_014/m2_603_2031# u_t015_014/m2_1290_336#
+ u_t015_014/m2_2000_2037# u_t015_014/m2_791_2909# u_t015_014/m2_7_2126# u_t015_014/m2_2154_2081#
+ u_t015_014/m2_1795_2037# u_t015_014/m2_871_303# u_t015_014/m2_431_438# u_t015_014/m2_1290_2898#
+ u_t015_014/m2_1714_1210# u_t015_014/m2_431_1982# u_t015_014/m2_512_1265# u_t015_014/m2_2573_2126#
+ u_t015_014/m2_603_1259# u_t015_014/m2_2074_2909# u_t015_014/m2_7_336# u_t015_014/m2_717_2037#
+ u_t015_014/m2_1886_2031# u_t015_014/m2_2573_336# u_t015_014/m2_7_2898# u_t015_014/m2_2000_1265#
+ u_t015_014/m2_512_2037# u_t015_014/m2_1795_1265# u_t015_014/m2_1714_1982# u_t015_014/m2_1886_1259#
+ u_t015_014/m2_1290_2126# u_t015_014/m2_1714_438# u_t015_014/m2_431_1210# u_t015_014/m2_2573_2898#
+ u_t015_014/m2_2154_303# u_t015_014/m2_871_2081# VSUBS detronyx_12t_2w2r_rc4_4x4_routed_5layer_direct
Xu_t030_006 u_t030_006/c0_w0_bl u_t030_006/c0_w0_br u_t030_006/c0_w1_bl u_t030_006/c0_w1_br
+ u_t030_006/c0_r0_rbl u_t030_006/c0_r1_rbl u_t030_006/c1_w0_bl u_t030_006/c1_w0_br
+ u_t030_006/c1_w1_bl u_t030_006/c1_w1_br u_t030_006/c1_r0_rbl u_t030_006/c1_r1_rbl
+ u_t030_006/c2_w0_bl u_t030_006/c2_w0_br u_t030_006/c2_w1_bl u_t030_006/c2_w1_br
+ u_t030_006/c2_r0_rbl u_t030_006/c2_r1_rbl u_t030_006/c3_w0_bl u_t030_006/c3_w0_br
+ u_t030_006/c3_w1_bl u_t030_006/c3_w1_br u_t030_006/c3_r0_rbl u_t030_006/c3_r1_rbl
+ u_t030_006/r0_w0_wl u_t030_006/r0_w1_wl u_t030_006/r0_r0_rwl u_t030_006/r0_r1_rwl
+ u_t030_006/r1_w0_wl u_t030_006/r1_w1_wl u_t030_006/r1_r0_rwl u_t030_006/r1_r1_rwl
+ u_t030_006/r2_w0_wl u_t030_006/r2_w1_wl u_t030_006/r2_r0_rwl u_t030_006/r2_r1_rwl
+ u_t030_006/r3_w0_wl u_t030_006/r3_w1_wl u_t030_006/r3_r0_rwl u_t030_006/r3_r1_rwl
+ u_t030_006/VDD VSS u_t030_006/m2_717_1265# u_t030_006/m2_603_2031# u_t030_006/m2_1290_336#
+ u_t030_006/m2_2000_2037# u_t030_006/m2_791_2909# u_t030_006/m2_7_2126# u_t030_006/m2_2154_2081#
+ u_t030_006/m2_1795_2037# u_t030_006/m2_871_303# u_t030_006/m2_431_438# u_t030_006/m2_1290_2898#
+ u_t030_006/m2_1714_1210# u_t030_006/m2_431_1982# u_t030_006/m2_512_1265# u_t030_006/m2_2573_2126#
+ u_t030_006/m2_603_1259# u_t030_006/m2_2074_2909# u_t030_006/m2_7_336# u_t030_006/m2_717_2037#
+ u_t030_006/m2_1886_2031# u_t030_006/m2_2573_336# u_t030_006/m2_7_2898# u_t030_006/m2_2000_1265#
+ u_t030_006/m2_512_2037# u_t030_006/m2_1795_1265# u_t030_006/m2_1714_1982# u_t030_006/m2_1886_1259#
+ u_t030_006/m2_1290_2126# u_t030_006/m2_1714_438# u_t030_006/m2_431_1210# u_t030_006/m2_2573_2898#
+ u_t030_006/m2_2154_303# u_t030_006/m2_871_2081# VSUBS detronyx_12t_2w2r_rc4_4x4_routed_5layer_direct
Xu_t015_003 u_t015_003/c0_w0_bl u_t015_003/c0_w0_br u_t015_003/c0_w1_bl u_t015_003/c0_w1_br
+ u_t015_003/c0_r0_rbl u_t015_003/c0_r1_rbl u_t015_003/c1_w0_bl u_t015_003/c1_w0_br
+ u_t015_003/c1_w1_bl u_t015_003/c1_w1_br u_t015_003/c1_r0_rbl u_t015_003/c1_r1_rbl
+ u_t015_003/c2_w0_bl u_t015_003/c2_w0_br u_t015_003/c2_w1_bl u_t015_003/c2_w1_br
+ u_t015_003/c2_r0_rbl u_t015_003/c2_r1_rbl u_t015_003/c3_w0_bl u_t015_003/c3_w0_br
+ u_t015_003/c3_w1_bl u_t015_003/c3_w1_br u_t015_003/c3_r0_rbl u_t015_003/c3_r1_rbl
+ u_t015_003/r0_w0_wl u_t015_003/r0_w1_wl u_t015_003/r0_r0_rwl u_t015_003/r0_r1_rwl
+ u_t015_003/r1_w0_wl u_t015_003/r1_w1_wl u_t015_003/r1_r0_rwl u_t015_003/r1_r1_rwl
+ u_t015_003/r2_w0_wl u_t015_003/r2_w1_wl u_t015_003/r2_r0_rwl u_t015_003/r2_r1_rwl
+ u_t015_003/r3_w0_wl u_t015_003/r3_w1_wl u_t015_003/r3_r0_rwl u_t015_003/r3_r1_rwl
+ u_t015_003/VDD u_t015_003/VSS u_t015_003/m2_717_1265# u_t015_003/m2_603_2031# u_t015_003/m2_1290_336#
+ u_t015_003/m2_2000_2037# u_t015_003/m2_791_2909# u_t015_003/m2_7_2126# u_t015_003/m2_2154_2081#
+ u_t015_003/m2_1795_2037# u_t015_003/m2_871_303# u_t015_003/m2_431_438# u_t015_003/m2_1290_2898#
+ u_t015_003/m2_1714_1210# u_t015_003/m2_431_1982# u_t015_003/m2_512_1265# u_t015_003/m2_2573_2126#
+ u_t015_003/m2_603_1259# u_t015_003/m2_2074_2909# u_t015_003/m2_7_336# u_t015_003/m2_717_2037#
+ u_t015_003/m2_1886_2031# u_t015_003/m2_2573_336# u_t015_003/m2_7_2898# u_t015_003/m2_2000_1265#
+ u_t015_003/m2_512_2037# u_t015_003/m2_1795_1265# u_t015_003/m2_1714_1982# u_t015_003/m2_1886_1259#
+ u_t015_003/m2_1290_2126# u_t015_003/m2_1714_438# u_t015_003/m2_431_1210# u_t015_003/m2_2573_2898#
+ u_t015_003/m2_2154_303# u_t015_003/m2_871_2081# VSUBS detronyx_12t_2w2r_rc4_4x4_routed_5layer_direct
Xgf180mcu_as_sc_mcu7t3v3__nand4_2_429 VSS gf180mcu_as_sc_mcu7t3v3__inv_2_1562/VDD
+ VSS VSS VSS VSS VSS gf180mcu_as_sc_mcu7t3v3__inv_2_1559/VNW VSUBS gf180mcu_as_sc_mcu7t3v3__nand4_2
Xgf180mcu_as_sc_mcu7t3v3__nand4_2_418 VSS VSS VSS VSS VSS VSS VSS gf180mcu_as_sc_mcu7t3v3__inv_2_1526/VNW
+ VSUBS gf180mcu_as_sc_mcu7t3v3__nand4_2
Xgf180mcu_as_sc_mcu7t3v3__nand4_2_407 gf180mcu_as_sc_mcu7t3v3__inv_2_1491/VDD VSS
+ VSS VSS VSS VSS gf180mcu_as_sc_mcu7t3v3__nand4_2_407/Y gf180mcu_as_sc_mcu7t3v3__inv_2_1491/VNW
+ VSUBS gf180mcu_as_sc_mcu7t3v3__nand4_2
Xu_t006_014 u_t006_014/c0_w0_bl u_t006_014/c0_w0_br u_t006_014/c0_w1_bl u_t006_014/c0_w1_br
+ u_t006_014/c0_r0_rbl u_t006_014/c0_r1_rbl u_t006_014/c1_w0_bl u_t006_014/c1_w0_br
+ u_t006_014/c1_w1_bl u_t006_014/c1_w1_br u_t006_014/c1_r0_rbl u_t006_014/c1_r1_rbl
+ u_t006_014/c2_w0_bl u_t006_014/c2_w0_br u_t006_014/c2_w1_bl u_t006_014/c2_w1_br
+ u_t006_014/c2_r0_rbl u_t006_014/c2_r1_rbl u_t006_014/c3_w0_bl u_t006_014/c3_w0_br
+ u_t006_014/c3_w1_bl u_t006_014/c3_w1_br u_t006_014/c3_r0_rbl u_t006_014/c3_r1_rbl
+ u_t006_014/r0_w0_wl u_t006_014/r0_w1_wl u_t006_014/r0_r0_rwl u_t006_014/r0_r1_rwl
+ u_t006_014/r1_w0_wl u_t006_014/r1_w1_wl u_t006_014/r1_r0_rwl u_t006_014/r1_r1_rwl
+ u_t006_014/r2_w0_wl u_t006_014/r2_w1_wl u_t006_014/r2_r0_rwl u_t006_014/r2_r1_rwl
+ u_t006_014/r3_w0_wl u_t006_014/r3_w1_wl u_t006_014/r3_r0_rwl u_t006_014/r3_r1_rwl
+ u_t006_014/VDD u_t006_015/VSS u_t006_014/m2_717_1265# u_t006_014/m2_603_2031# u_t006_014/m2_1290_336#
+ u_t006_014/m2_2000_2037# u_t006_014/m2_791_2909# u_t006_014/m2_7_2126# u_t006_014/m2_2154_2081#
+ u_t006_014/m2_1795_2037# u_t006_014/m2_871_303# u_t006_014/m2_431_438# u_t006_014/m2_1290_2898#
+ u_t006_014/m2_1714_1210# u_t006_014/m2_431_1982# u_t006_014/m2_512_1265# u_t006_014/m2_2573_2126#
+ u_t006_014/m2_603_1259# u_t006_014/m2_2074_2909# u_t006_014/m2_7_336# u_t006_014/m2_717_2037#
+ u_t006_014/m2_1886_2031# u_t006_014/m2_2573_336# u_t006_014/m2_7_2898# u_t006_014/m2_2000_1265#
+ u_t006_014/m2_512_2037# u_t006_014/m2_1795_1265# u_t006_014/m2_1714_1982# u_t006_014/m2_1886_1259#
+ u_t006_014/m2_1290_2126# u_t006_014/m2_1714_438# u_t006_014/m2_431_1210# u_t006_014/m2_2573_2898#
+ u_t006_014/m2_2154_303# u_t006_014/m2_871_2081# VSUBS detronyx_12t_2w2r_rc4_4x4_routed_5layer_direct
Xu_t006_003 u_t006_003/c0_w0_bl u_t006_003/c0_w0_br u_t006_003/c0_w1_bl u_t006_003/c0_w1_br
+ u_t006_003/c0_r0_rbl u_t006_003/c0_r1_rbl u_t006_003/c1_w0_bl u_t006_003/c1_w0_br
+ u_t006_003/c1_w1_bl u_t006_003/c1_w1_br u_t006_003/c1_r0_rbl u_t006_003/c1_r1_rbl
+ u_t006_003/c2_w0_bl u_t006_003/c2_w0_br u_t006_003/c2_w1_bl u_t006_003/c2_w1_br
+ u_t006_003/c2_r0_rbl u_t006_003/c2_r1_rbl u_t006_003/c3_w0_bl u_t006_003/c3_w0_br
+ u_t006_003/c3_w1_bl u_t006_003/c3_w1_br u_t006_003/c3_r0_rbl u_t006_003/c3_r1_rbl
+ u_t006_003/r0_w0_wl u_t006_003/r0_w1_wl u_t006_003/r0_r0_rwl u_t006_003/r0_r1_rwl
+ u_t006_003/r1_w0_wl u_t006_003/r1_w1_wl u_t006_003/r1_r0_rwl u_t006_003/r1_r1_rwl
+ u_t006_003/r2_w0_wl u_t006_003/r2_w1_wl u_t006_003/r2_r0_rwl u_t006_003/r2_r1_rwl
+ u_t006_003/r3_w0_wl u_t006_003/r3_w1_wl u_t006_003/r3_r0_rwl u_t006_003/r3_r1_rwl
+ u_t006_003/VDD u_t006_003/VSS u_t006_003/m2_717_1265# u_t006_003/m2_603_2031# u_t006_003/m2_1290_336#
+ u_t006_003/m2_2000_2037# u_t006_003/m2_791_2909# u_t006_003/m2_7_2126# u_t006_003/m2_2154_2081#
+ u_t006_003/m2_1795_2037# u_t006_003/m2_871_303# u_t006_003/m2_431_438# u_t006_003/m2_1290_2898#
+ u_t006_003/m2_1714_1210# u_t006_003/m2_431_1982# u_t006_003/m2_512_1265# u_t006_003/m2_2573_2126#
+ u_t006_003/m2_603_1259# u_t006_003/m2_2074_2909# u_t006_003/m2_7_336# u_t006_003/m2_717_2037#
+ u_t006_003/m2_1886_2031# u_t006_003/m2_2573_336# u_t006_003/m2_7_2898# u_t006_003/m2_2000_1265#
+ u_t006_003/m2_512_2037# u_t006_003/m2_1795_1265# u_t006_003/m2_1714_1982# u_t006_003/m2_1886_1259#
+ u_t006_003/m2_1290_2126# u_t006_003/m2_1714_438# u_t006_003/m2_431_1210# u_t006_003/m2_2573_2898#
+ u_t006_003/m2_2154_303# u_t006_003/m2_871_2081# VSUBS detronyx_12t_2w2r_rc4_4x4_routed_5layer_direct
Xgf180mcu_as_sc_mcu7t3v3__inv_2_8 gf180mcu_as_sc_mcu7t3v3__inv_2_8/VDD gf180mcu_as_sc_mcu7t3v3__inv_2_8/VSS
+ gf180mcu_as_sc_mcu7t3v3__inv_2_8/Y VSS gf180mcu_as_sc_mcu7t3v3__inv_2_8/VNW VSUBS
+ gf180mcu_as_sc_mcu7t3v3__inv_2
Xu_t021_006 u_t021_006/c0_w0_bl u_t021_006/c0_w0_br u_t021_006/c0_w1_bl u_t021_006/c0_w1_br
+ u_t021_006/c0_r0_rbl u_t021_006/c0_r1_rbl u_t021_006/c1_w0_bl u_t021_006/c1_w0_br
+ u_t021_006/c1_w1_bl u_t021_006/c1_w1_br u_t021_006/c1_r0_rbl u_t021_006/c1_r1_rbl
+ u_t021_006/c2_w0_bl u_t021_006/c2_w0_br u_t021_006/c2_w1_bl u_t021_006/c2_w1_br
+ u_t021_006/c2_r0_rbl u_t021_006/c2_r1_rbl u_t021_006/c3_w0_bl u_t021_006/c3_w0_br
+ u_t021_006/c3_w1_bl u_t021_006/c3_w1_br u_t021_006/c3_r0_rbl u_t021_006/c3_r1_rbl
+ u_t021_006/r0_w0_wl u_t021_006/r0_w1_wl u_t021_006/r0_r0_rwl u_t021_006/r0_r1_rwl
+ u_t021_006/r1_w0_wl u_t021_006/r1_w1_wl u_t021_006/r1_r0_rwl u_t021_006/r1_r1_rwl
+ u_t021_006/r2_w0_wl u_t021_006/r2_w1_wl u_t021_006/r2_r0_rwl u_t021_006/r2_r1_rwl
+ u_t021_006/r3_w0_wl u_t021_006/r3_w1_wl u_t021_006/r3_r0_rwl u_t021_006/r3_r1_rwl
+ u_t021_006/VDD VSS u_t021_006/m2_717_1265# u_t021_006/m2_603_2031# u_t021_006/m2_1290_336#
+ u_t021_006/m2_2000_2037# u_t021_006/m2_791_2909# u_t021_006/m2_7_2126# u_t021_006/m2_2154_2081#
+ u_t021_006/m2_1795_2037# u_t021_006/m2_871_303# u_t021_006/m2_431_438# u_t021_006/m2_1290_2898#
+ u_t021_006/m2_1714_1210# u_t021_006/m2_431_1982# u_t021_006/m2_512_1265# u_t021_006/m2_2573_2126#
+ u_t021_006/m2_603_1259# u_t021_006/m2_2074_2909# u_t021_006/m2_7_336# u_t021_006/m2_717_2037#
+ u_t021_006/m2_1886_2031# u_t021_006/m2_2573_336# u_t021_006/m2_7_2898# u_t021_006/m2_2000_1265#
+ u_t021_006/m2_512_2037# u_t021_006/m2_1795_1265# u_t021_006/m2_1714_1982# u_t021_006/m2_1886_1259#
+ u_t021_006/m2_1290_2126# u_t021_006/m2_1714_438# u_t021_006/m2_431_1210# u_t021_006/m2_2573_2898#
+ u_t021_006/m2_2154_303# u_t021_006/m2_871_2081# VSUBS detronyx_12t_2w2r_rc4_4x4_routed_5layer_direct
Xu_t012_006 u_t012_006/c0_w0_bl u_t012_006/c0_w0_br u_t012_006/c0_w1_bl u_t012_006/c0_w1_br
+ u_t012_006/c0_r0_rbl u_t012_006/c0_r1_rbl u_t012_006/c1_w0_bl u_t012_006/c1_w0_br
+ u_t012_006/c1_w1_bl u_t012_006/c1_w1_br u_t012_006/c1_r0_rbl u_t012_006/c1_r1_rbl
+ u_t012_006/c2_w0_bl u_t012_006/c2_w0_br u_t012_006/c2_w1_bl u_t012_006/c2_w1_br
+ u_t012_006/c2_r0_rbl u_t012_006/c2_r1_rbl u_t012_006/c3_w0_bl u_t012_006/c3_w0_br
+ u_t012_006/c3_w1_bl u_t012_006/c3_w1_br u_t012_006/c3_r0_rbl u_t012_006/c3_r1_rbl
+ u_t012_006/r0_w0_wl u_t012_006/r0_w1_wl u_t012_006/r0_r0_rwl u_t012_006/r0_r1_rwl
+ u_t012_006/r1_w0_wl u_t012_006/r1_w1_wl u_t012_006/r1_r0_rwl u_t012_006/r1_r1_rwl
+ u_t012_006/r2_w0_wl u_t012_006/r2_w1_wl u_t012_006/r2_r0_rwl u_t012_006/r2_r1_rwl
+ u_t012_006/r3_w0_wl u_t012_006/r3_w1_wl u_t012_006/r3_r0_rwl u_t012_006/r3_r1_rwl
+ u_t012_006/VDD VSS u_t012_006/m2_717_1265# u_t012_006/m2_603_2031# u_t012_006/m2_1290_336#
+ u_t012_006/m2_2000_2037# u_t012_006/m2_791_2909# u_t012_006/m2_7_2126# u_t012_006/m2_2154_2081#
+ u_t012_006/m2_1795_2037# u_t012_006/m2_871_303# u_t012_006/m2_431_438# u_t012_006/m2_1290_2898#
+ u_t012_006/m2_1714_1210# u_t012_006/m2_431_1982# u_t012_006/m2_512_1265# u_t012_006/m2_2573_2126#
+ u_t012_006/m2_603_1259# u_t012_006/m2_2074_2909# u_t012_006/m2_7_336# u_t012_006/m2_717_2037#
+ u_t012_006/m2_1886_2031# u_t012_006/m2_2573_336# u_t012_006/m2_7_2898# u_t012_006/m2_2000_1265#
+ u_t012_006/m2_512_2037# u_t012_006/m2_1795_1265# u_t012_006/m2_1714_1982# u_t012_006/m2_1886_1259#
+ u_t012_006/m2_1290_2126# u_t012_006/m2_1714_438# u_t012_006/m2_431_1210# u_t012_006/m2_2573_2898#
+ u_t012_006/m2_2154_303# u_t012_006/m2_871_2081# VSUBS detronyx_12t_2w2r_rc4_4x4_routed_5layer_direct
Xgf180mcu_as_sc_mcu7t3v3__inv_2_1465 VSS gf180mcu_as_sc_mcu7t3v3__inv_2_1470/VDD VSS
+ VSS gf180mcu_as_sc_mcu7t3v3__inv_2_1467/VNW VSUBS gf180mcu_as_sc_mcu7t3v3__inv_2
Xgf180mcu_as_sc_mcu7t3v3__inv_2_1476 VSS gf180mcu_as_sc_mcu7t3v3__inv_2_1476/VSS VSS
+ VSS gf180mcu_as_sc_mcu7t3v3__inv_2_1476/VNW VSUBS gf180mcu_as_sc_mcu7t3v3__inv_2
Xgf180mcu_as_sc_mcu7t3v3__inv_2_1487 VSS gf180mcu_as_sc_mcu7t3v3__inv_2_1491/VDD gf180mcu_as_sc_mcu7t3v3__inv_2_1487/Y
+ VSS gf180mcu_as_sc_mcu7t3v3__inv_2_1488/VNW VSUBS gf180mcu_as_sc_mcu7t3v3__inv_2
Xgf180mcu_as_sc_mcu7t3v3__inv_2_1421 VSS gf180mcu_as_sc_mcu7t3v3__inv_2_1720/VDD gf180mcu_as_sc_mcu7t3v3__inv_2_1421/Y
+ VSS gf180mcu_as_sc_mcu7t3v3__inv_2_1422/VNW VSUBS gf180mcu_as_sc_mcu7t3v3__inv_2
Xgf180mcu_as_sc_mcu7t3v3__inv_2_1410 VSS gf180mcu_as_sc_mcu7t3v3__inv_2_1457/VSS VSS
+ VSS gf180mcu_as_sc_mcu7t3v3__inv_2_1457/VNW VSUBS gf180mcu_as_sc_mcu7t3v3__inv_2
Xgf180mcu_as_sc_mcu7t3v3__inv_2_1454 gf180mcu_as_sc_mcu7t3v3__inv_2_1455/VDD VSS VSS
+ VSS gf180mcu_as_sc_mcu7t3v3__inv_2_1455/VNW VSUBS gf180mcu_as_sc_mcu7t3v3__inv_2
Xgf180mcu_as_sc_mcu7t3v3__inv_2_1443 gf180mcu_as_sc_mcu7t3v3__inv_2_1443/VDD gf180mcu_as_sc_mcu7t3v3__inv_2_1446/VDD
+ gf180mcu_as_sc_mcu7t3v3__inv_2_1443/Y VSS gf180mcu_as_sc_mcu7t3v3__inv_2_1443/VNW
+ VSUBS gf180mcu_as_sc_mcu7t3v3__inv_2
Xgf180mcu_as_sc_mcu7t3v3__inv_2_1432 gf180mcu_as_sc_mcu7t3v3__inv_2_1434/VDD VSS VSS
+ VSS gf180mcu_as_sc_mcu7t3v3__inv_2_1434/VNW VSUBS gf180mcu_as_sc_mcu7t3v3__inv_2
Xgf180mcu_as_sc_mcu7t3v3__inv_2_1498 gf180mcu_as_sc_mcu7t3v3__inv_2_1500/VDD gf180mcu_as_sc_mcu7t3v3__inv_2_1503/VDD
+ VSS VSS gf180mcu_as_sc_mcu7t3v3__inv_2_1500/VNW VSUBS gf180mcu_as_sc_mcu7t3v3__inv_2
Xgf180mcu_as_sc_mcu7t3v3__inv_2_927 VSS VSS VSS VSS gf180mcu_as_sc_mcu7t3v3__inv_2_927/VNW
+ VSUBS gf180mcu_as_sc_mcu7t3v3__inv_2
Xgf180mcu_as_sc_mcu7t3v3__inv_2_916 VSS VSS VSS VSS gf180mcu_as_sc_mcu7t3v3__inv_2_946/VNW
+ VSUBS gf180mcu_as_sc_mcu7t3v3__inv_2
Xgf180mcu_as_sc_mcu7t3v3__inv_2_905 VSS VSS VSS VSS gf180mcu_as_sc_mcu7t3v3__inv_2_952/VNW
+ VSUBS gf180mcu_as_sc_mcu7t3v3__inv_2
Xu_t003_006 u_t003_006/c0_w0_bl u_t003_006/c0_w0_br u_t003_006/c0_w1_bl u_t003_006/c0_w1_br
+ u_t003_006/c0_r0_rbl u_t003_006/c0_r1_rbl u_t003_006/c1_w0_bl u_t003_006/c1_w0_br
+ u_t003_006/c1_w1_bl u_t003_006/c1_w1_br u_t003_006/c1_r0_rbl u_t003_006/c1_r1_rbl
+ u_t003_006/c2_w0_bl u_t003_006/c2_w0_br u_t003_006/c2_w1_bl u_t003_006/c2_w1_br
+ u_t003_006/c2_r0_rbl u_t003_006/c2_r1_rbl u_t003_006/c3_w0_bl u_t003_006/c3_w0_br
+ u_t003_006/c3_w1_bl u_t003_006/c3_w1_br u_t003_006/c3_r0_rbl u_t003_006/c3_r1_rbl
+ u_t003_006/r0_w0_wl u_t003_006/r0_w1_wl u_t003_006/r0_r0_rwl u_t003_006/r0_r1_rwl
+ u_t003_006/r1_w0_wl u_t003_006/r1_w1_wl u_t003_006/r1_r0_rwl u_t003_006/r1_r1_rwl
+ u_t003_006/r2_w0_wl u_t003_006/r2_w1_wl u_t003_006/r2_r0_rwl u_t003_006/r2_r1_rwl
+ u_t003_006/r3_w0_wl u_t003_006/r3_w1_wl u_t003_006/r3_r0_rwl u_t003_006/r3_r1_rwl
+ u_t004_006/VDD u_t003_009/VSS u_t003_006/m2_717_1265# u_t003_006/m2_603_2031# u_t003_006/m2_1290_336#
+ u_t003_006/m2_2000_2037# u_t003_006/m2_791_2909# u_t003_006/m2_7_2126# u_t003_006/m2_2154_2081#
+ u_t003_006/m2_1795_2037# u_t003_006/m2_871_303# u_t003_006/m2_431_438# u_t003_006/m2_1290_2898#
+ u_t003_006/m2_1714_1210# u_t003_006/m2_431_1982# u_t003_006/m2_512_1265# u_t003_006/m2_2573_2126#
+ u_t003_006/m2_603_1259# u_t003_006/m2_2074_2909# u_t003_006/m2_7_336# u_t003_006/m2_717_2037#
+ u_t003_006/m2_1886_2031# u_t003_006/m2_2573_336# u_t003_006/m2_7_2898# u_t003_006/m2_2000_1265#
+ u_t003_006/m2_512_2037# u_t003_006/m2_1795_1265# u_t003_006/m2_1714_1982# u_t003_006/m2_1886_1259#
+ u_t003_006/m2_1290_2126# u_t003_006/m2_1714_438# u_t003_006/m2_431_1210# u_t003_006/m2_2573_2898#
+ u_t003_006/m2_2154_303# u_t003_006/m2_871_2081# VSUBS detronyx_12t_2w2r_rc4_4x4_routed_5layer_direct
Xgf180mcu_as_sc_mcu7t3v3__inv_2_949 VSS VSS VSS VSS gf180mcu_as_sc_mcu7t3v3__inv_2_949/VNW
+ VSUBS gf180mcu_as_sc_mcu7t3v3__inv_2
Xgf180mcu_as_sc_mcu7t3v3__inv_2_938 VSS VSS VSS VSS gf180mcu_as_sc_mcu7t3v3__inv_2_938/VNW
+ VSUBS gf180mcu_as_sc_mcu7t3v3__inv_2
Xgf180mcu_as_sc_mcu7t3v3__nand4_2_248 gf180mcu_as_sc_mcu7t3v3__inv_2_854/VDD gf180mcu_as_sc_mcu7t3v3__inv_2_854/VSS
+ VSS VSS VSS VSS VSS gf180mcu_as_sc_mcu7t3v3__inv_2_854/VNW VSUBS gf180mcu_as_sc_mcu7t3v3__nand4_2
Xgf180mcu_as_sc_mcu7t3v3__nand4_2_204 gf180mcu_as_sc_mcu7t3v3__inv_2_656/VDD gf180mcu_as_sc_mcu7t3v3__inv_2_854/VDD
+ VSS VSS VSS VSS VSS gf180mcu_as_sc_mcu7t3v3__inv_2_656/VNW VSUBS gf180mcu_as_sc_mcu7t3v3__nand4_2
Xgf180mcu_as_sc_mcu7t3v3__nand4_2_215 VSS VSS VSS VSS VSS VSS gf180mcu_as_sc_mcu7t3v3__nand4_2_215/Y
+ gf180mcu_as_sc_mcu7t3v3__inv_2_834/VNW VSUBS gf180mcu_as_sc_mcu7t3v3__nand4_2
Xgf180mcu_as_sc_mcu7t3v3__nand4_2_226 VSS VSS VSS VSS VSS VSS gf180mcu_as_sc_mcu7t3v3__nand4_2_226/Y
+ gf180mcu_as_sc_mcu7t3v3__inv_2_833/VNW VSUBS gf180mcu_as_sc_mcu7t3v3__nand4_2
Xgf180mcu_as_sc_mcu7t3v3__nand4_2_237 VSS VSS VSS VSS VSS VSS gf180mcu_as_sc_mcu7t3v3__nand4_2_237/Y
+ gf180mcu_as_sc_mcu7t3v3__inv_2_849/VNW VSUBS gf180mcu_as_sc_mcu7t3v3__nand4_2
Xgf180mcu_as_sc_mcu7t3v3__nand4_2_259 VSS VSS VSS VSS VSS VSS gf180mcu_as_sc_mcu7t3v3__nand4_2_259/Y
+ gf180mcu_as_sc_mcu7t3v3__inv_2_940/VNW VSUBS gf180mcu_as_sc_mcu7t3v3__nand4_2
Xu_t000_009 u_t000_009/c0_w0_bl u_t000_009/c0_w0_br u_t000_009/c0_w1_bl u_t000_009/c0_w1_br
+ u_t000_009/c0_r0_rbl u_t000_009/c0_r1_rbl u_t000_009/c1_w0_bl u_t000_009/c1_w0_br
+ u_t000_009/c1_w1_bl u_t000_009/c1_w1_br u_t000_009/c1_r0_rbl u_t000_009/c1_r1_rbl
+ u_t000_009/c2_w0_bl u_t000_009/c2_w0_br u_t000_009/c2_w1_bl u_t000_009/c2_w1_br
+ u_t000_009/c2_r0_rbl u_t000_009/c2_r1_rbl u_t000_009/c3_w0_bl u_t000_009/c3_w0_br
+ u_t000_009/c3_w1_bl u_t000_009/c3_w1_br u_t000_009/c3_r0_rbl u_t000_009/c3_r1_rbl
+ u_t000_009/r0_w0_wl u_t000_009/r0_w1_wl u_t000_009/r0_r0_rwl u_t000_009/r0_r1_rwl
+ u_t000_009/r1_w0_wl u_t000_009/r1_w1_wl u_t000_009/r1_r0_rwl u_t000_009/r1_r1_rwl
+ u_t000_009/r2_w0_wl u_t000_009/r2_w1_wl u_t000_009/r2_r0_rwl u_t000_009/r2_r1_rwl
+ u_t000_009/r3_w0_wl u_t000_009/r3_w1_wl u_t000_009/r3_r0_rwl u_t000_009/r3_r1_rwl
+ VSS VSS u_t000_009/m2_717_1265# u_t000_009/m2_603_2031# u_t000_009/m2_1290_336#
+ u_t000_009/m2_2000_2037# u_t000_009/m2_791_2909# u_t000_009/m2_7_2126# u_t000_009/m2_2154_2081#
+ u_t000_009/m2_1795_2037# u_t000_009/m2_871_303# u_t000_009/m2_431_438# u_t000_009/m2_1290_2898#
+ u_t000_009/m2_1714_1210# u_t000_009/m2_431_1982# u_t000_009/m2_512_1265# u_t000_009/m2_2573_2126#
+ u_t000_009/m2_603_1259# u_t000_009/m2_2074_2909# u_t000_009/m2_7_336# u_t000_009/m2_717_2037#
+ u_t000_009/m2_1886_2031# u_t000_009/m2_2573_336# u_t000_009/m2_7_2898# u_t000_009/m2_2000_1265#
+ u_t000_009/m2_512_2037# u_t000_009/m2_1795_1265# u_t000_009/m2_1714_1982# u_t000_009/m2_1886_1259#
+ u_t000_009/m2_1290_2126# u_t000_009/m2_1714_438# u_t000_009/m2_431_1210# u_t000_009/m2_2573_2898#
+ u_t000_009/m2_2154_303# u_t000_009/m2_871_2081# VSUBS detronyx_12t_2w2r_rc4_4x4_routed_5layer_direct
Xgf180mcu_as_sc_mcu7t3v3__inv_2_1262 gf180mcu_as_sc_mcu7t3v3__nand3_2_65/VDD gf180mcu_as_sc_mcu7t3v3__nor2_2_9/VSS
+ VSS VSS gf180mcu_as_sc_mcu7t3v3__nand3_2_65/VNW VSUBS gf180mcu_as_sc_mcu7t3v3__inv_2
Xgf180mcu_as_sc_mcu7t3v3__inv_2_1273 gf180mcu_as_sc_mcu7t3v3__nor2_2_9/VDD gf180mcu_as_sc_mcu7t3v3__nand3_2_63/VSS
+ VSS VSS gf180mcu_as_sc_mcu7t3v3__nor2_2_9/VNW VSUBS gf180mcu_as_sc_mcu7t3v3__inv_2
Xgf180mcu_as_sc_mcu7t3v3__inv_2_1240 gf180mcu_as_sc_mcu7t3v3__nand3_2_65/VDD gf180mcu_as_sc_mcu7t3v3__nor2_2_9/VSS
+ VSS VSS gf180mcu_as_sc_mcu7t3v3__nand3_2_65/VNW VSUBS gf180mcu_as_sc_mcu7t3v3__inv_2
Xgf180mcu_as_sc_mcu7t3v3__inv_2_1251 gf180mcu_as_sc_mcu7t3v3__nand3_2_65/VDD gf180mcu_as_sc_mcu7t3v3__nand3_2_62/VSS
+ VSS VSS gf180mcu_as_sc_mcu7t3v3__nand3_2_65/VNW VSUBS gf180mcu_as_sc_mcu7t3v3__inv_2
Xgf180mcu_as_sc_mcu7t3v3__inv_2_1284 VSS VSS VSS VSS gf180mcu_as_sc_mcu7t3v3__inv_2_1286/VNW
+ VSUBS gf180mcu_as_sc_mcu7t3v3__inv_2
Xgf180mcu_as_sc_mcu7t3v3__inv_2_1295 VSS VSS VSS VSS gf180mcu_as_sc_mcu7t3v3__inv_2_1295/VNW
+ VSUBS gf180mcu_as_sc_mcu7t3v3__inv_2
Xgf180mcu_as_sc_mcu7t3v3__inv_2_768 VSS VSS VSS VSS gf180mcu_as_sc_mcu7t3v3__inv_2_833/VNW
+ VSUBS gf180mcu_as_sc_mcu7t3v3__inv_2
Xgf180mcu_as_sc_mcu7t3v3__inv_2_757 VSS VSS VSS VSS gf180mcu_as_sc_mcu7t3v3__inv_2_832/VNW
+ VSUBS gf180mcu_as_sc_mcu7t3v3__inv_2
Xgf180mcu_as_sc_mcu7t3v3__inv_2_779 VSS VSS VSS VSS gf180mcu_as_sc_mcu7t3v3__inv_2_828/VNW
+ VSUBS gf180mcu_as_sc_mcu7t3v3__inv_2
Xgf180mcu_as_sc_mcu7t3v3__inv_2_746 gf180mcu_as_sc_mcu7t3v3__inv_2_746/VDD gf180mcu_as_sc_mcu7t3v3__inv_2_746/VSS
+ gf180mcu_as_sc_mcu7t3v3__inv_2_746/Y VSS gf180mcu_as_sc_mcu7t3v3__inv_2_746/VNW
+ VSUBS gf180mcu_as_sc_mcu7t3v3__inv_2
Xgf180mcu_as_sc_mcu7t3v3__inv_2_724 VSS gf180mcu_as_sc_mcu7t3v3__inv_2_746/VDD gf180mcu_as_sc_mcu7t3v3__inv_2_724/Y
+ VSS gf180mcu_as_sc_mcu7t3v3__inv_2_724/VNW VSUBS gf180mcu_as_sc_mcu7t3v3__inv_2
Xgf180mcu_as_sc_mcu7t3v3__inv_2_702 gf180mcu_as_sc_mcu7t3v3__inv_2_737/VSS gf180mcu_as_sc_mcu7t3v3__inv_2_730/VDD
+ gf180mcu_as_sc_mcu7t3v3__inv_2_702/Y gf180mcu_as_sc_mcu7t3v3__inv_2_742/A gf180mcu_as_sc_mcu7t3v3__inv_2_704/VNW
+ VSUBS gf180mcu_as_sc_mcu7t3v3__inv_2
Xgf180mcu_as_sc_mcu7t3v3__inv_2_713 VSS gf180mcu_as_sc_mcu7t3v3__inv_2_731/VDD gf180mcu_as_sc_mcu7t3v3__inv_2_713/Y
+ gf180mcu_as_sc_mcu7t3v3__inv_2_717/Y gf180mcu_as_sc_mcu7t3v3__inv_2_717/VNW VSUBS
+ gf180mcu_as_sc_mcu7t3v3__inv_2
Xgf180mcu_as_sc_mcu7t3v3__inv_2_735 VSS VSS gf180mcu_as_sc_mcu7t3v3__inv_2_742/A gf180mcu_as_sc_mcu7t3v3__inv_2_736/Y
+ gf180mcu_as_sc_mcu7t3v3__inv_2_736/VNW VSUBS gf180mcu_as_sc_mcu7t3v3__inv_2
Xgf180mcu_as_sc_mcu7t3v3__inv_2_1070 VSS gf180mcu_as_sc_mcu7t3v3__inv_2_1075/VDD gf180mcu_as_sc_mcu7t3v3__inv_2_1070/Y
+ gf180mcu_as_sc_mcu7t3v3__inv_2_1071/Y gf180mcu_as_sc_mcu7t3v3__inv_2_1071/VNW VSUBS
+ gf180mcu_as_sc_mcu7t3v3__inv_2
Xgf180mcu_as_sc_mcu7t3v3__inv_2_1081 VSS gf180mcu_as_sc_mcu7t3v3__inv_2_1087/VDD VSS
+ gf180mcu_as_sc_mcu7t3v3__inv_2_1149/A gf180mcu_as_sc_mcu7t3v3__inv_2_1083/VNW VSUBS
+ gf180mcu_as_sc_mcu7t3v3__inv_2
Xgf180mcu_as_sc_mcu7t3v3__inv_2_1092 VSS gf180mcu_as_sc_mcu7t3v3__inv_2_1112/VDD gf180mcu_as_sc_mcu7t3v3__inv_2_1092/Y
+ gf180mcu_as_sc_mcu7t3v3__inv_2_1096/Y gf180mcu_as_sc_mcu7t3v3__inv_2_1096/VNW VSUBS
+ gf180mcu_as_sc_mcu7t3v3__inv_2
Xgf180mcu_as_sc_mcu7t3v3__nand4_2_4 gf180mcu_as_sc_mcu7t3v3__inv_2_94/VDD gf180mcu_as_sc_mcu7t3v3__inv_2_94/VSS
+ VSS VSS VSS VSS gf180mcu_as_sc_mcu7t3v3__nand4_2_4/Y gf180mcu_as_sc_mcu7t3v3__inv_2_94/VNW
+ VSUBS gf180mcu_as_sc_mcu7t3v3__nand4_2
Xgf180mcu_as_sc_mcu7t3v3__inv_2_510 VSS VSS VSS VSS gf180mcu_as_sc_mcu7t3v3__inv_2_557/VNW
+ VSUBS gf180mcu_as_sc_mcu7t3v3__inv_2
Xgf180mcu_as_sc_mcu7t3v3__inv_2_543 VSS VSS VSS VSS gf180mcu_as_sc_mcu7t3v3__inv_2_543/VNW
+ VSUBS gf180mcu_as_sc_mcu7t3v3__inv_2
Xgf180mcu_as_sc_mcu7t3v3__inv_2_565 gf180mcu_as_sc_mcu7t3v3__inv_2_590/VSS gf180mcu_as_sc_mcu7t3v3__inv_2_570/VDD
+ gf180mcu_as_sc_mcu7t3v3__inv_2_565/Y gf180mcu_as_sc_mcu7t3v3__inv_2_590/Y gf180mcu_as_sc_mcu7t3v3__inv_2_567/VNW
+ VSUBS gf180mcu_as_sc_mcu7t3v3__inv_2
Xgf180mcu_as_sc_mcu7t3v3__inv_2_587 gf180mcu_as_sc_mcu7t3v3__inv_2_588/VDD gf180mcu_as_sc_mcu7t3v3__inv_2_590/VSS
+ gf180mcu_as_sc_mcu7t3v3__inv_2_587/Y gf180mcu_as_sc_mcu7t3v3__inv_2_588/Y gf180mcu_as_sc_mcu7t3v3__inv_2_588/VNW
+ VSUBS gf180mcu_as_sc_mcu7t3v3__inv_2
Xgf180mcu_as_sc_mcu7t3v3__inv_2_576 gf180mcu_as_sc_mcu7t3v3__inv_2_576/VDD gf180mcu_as_sc_mcu7t3v3__inv_2_579/VDD
+ gf180mcu_as_sc_mcu7t3v3__inv_2_576/Y VSS gf180mcu_as_sc_mcu7t3v3__inv_2_576/VNW
+ VSUBS gf180mcu_as_sc_mcu7t3v3__inv_2
Xgf180mcu_as_sc_mcu7t3v3__inv_2_521 gf180mcu_as_sc_mcu7t3v3__nor2_2_6/VDD gf180mcu_as_sc_mcu7t3v3__nand3_2_4/VSS
+ VSS VSS gf180mcu_as_sc_mcu7t3v3__nor2_2_6/VNW VSUBS gf180mcu_as_sc_mcu7t3v3__inv_2
Xgf180mcu_as_sc_mcu7t3v3__inv_2_532 gf180mcu_as_sc_mcu7t3v3__nor2_2_7/VDD gf180mcu_as_sc_mcu7t3v3__nand3_2_4/VSS
+ VSS VSS gf180mcu_as_sc_mcu7t3v3__nor2_2_7/VNW VSUBS gf180mcu_as_sc_mcu7t3v3__inv_2
Xgf180mcu_as_sc_mcu7t3v3__inv_2_554 VSS VSS VSS VSS gf180mcu_as_sc_mcu7t3v3__inv_2_554/VNW
+ VSUBS gf180mcu_as_sc_mcu7t3v3__inv_2
Xgf180mcu_as_sc_mcu7t3v3__inv_2_598 gf180mcu_as_sc_mcu7t3v3__inv_2_638/VSS gf180mcu_as_sc_mcu7t3v3__inv_2_602/VDD
+ gf180mcu_as_sc_mcu7t3v3__inv_2_598/Y VSS gf180mcu_as_sc_mcu7t3v3__inv_2_598/VNW
+ VSUBS gf180mcu_as_sc_mcu7t3v3__inv_2
Xgf180mcu_as_sc_mcu7t3v3__inv_2_395 gf180mcu_as_sc_mcu7t3v3__nand3_2_9/VDD gf180mcu_as_sc_mcu7t3v3__nor2_2_7/VSS
+ VSS VSS gf180mcu_as_sc_mcu7t3v3__nand3_2_9/VNW VSUBS gf180mcu_as_sc_mcu7t3v3__inv_2
Xgf180mcu_as_sc_mcu7t3v3__inv_2_384 gf180mcu_as_sc_mcu7t3v3__nand3_2_9/VDD gf180mcu_as_sc_mcu7t3v3__nor2_2_4/VSS
+ VSS VSS gf180mcu_as_sc_mcu7t3v3__nand3_2_9/VNW VSUBS gf180mcu_as_sc_mcu7t3v3__inv_2
Xgf180mcu_as_sc_mcu7t3v3__inv_2_373 gf180mcu_as_sc_mcu7t3v3__nor2_2_7/VDD gf180mcu_as_sc_mcu7t3v3__nor2_2_7/VSS
+ gf180mcu_as_sc_mcu7t3v3__inv_2_373/Y VSS gf180mcu_as_sc_mcu7t3v3__nor2_2_7/VNW VSUBS
+ gf180mcu_as_sc_mcu7t3v3__inv_2
Xgf180mcu_as_sc_mcu7t3v3__inv_2_362 gf180mcu_as_sc_mcu7t3v3__inv_2_365/VDD gf180mcu_as_sc_mcu7t3v3__inv_2_365/VDD
+ gf180mcu_as_sc_mcu7t3v3__inv_2_365/Y VSS gf180mcu_as_sc_mcu7t3v3__inv_2_362/VNW
+ VSUBS gf180mcu_as_sc_mcu7t3v3__inv_2
Xgf180mcu_as_sc_mcu7t3v3__inv_2_351 VSS VSS VSS gf180mcu_as_sc_mcu7t3v3__inv_2_359/Y
+ gf180mcu_as_sc_mcu7t3v3__inv_2_353/VNW VSUBS gf180mcu_as_sc_mcu7t3v3__inv_2
Xgf180mcu_as_sc_mcu7t3v3__inv_2_340 gf180mcu_as_sc_mcu7t3v3__inv_2_341/VDD VSS gf180mcu_as_sc_mcu7t3v3__inv_2_340/Y
+ gf180mcu_as_sc_mcu7t3v3__inv_2_341/Y gf180mcu_as_sc_mcu7t3v3__inv_2_341/VNW VSUBS
+ gf180mcu_as_sc_mcu7t3v3__inv_2
Xu_t027_001 u_t027_001/c0_w0_bl u_t027_001/c0_w0_br u_t027_001/c0_w1_bl u_t027_001/c0_w1_br
+ u_t027_001/c0_r0_rbl u_t027_001/c0_r1_rbl u_t027_001/c1_w0_bl u_t027_001/c1_w0_br
+ u_t027_001/c1_w1_bl u_t027_001/c1_w1_br u_t027_001/c1_r0_rbl u_t027_001/c1_r1_rbl
+ u_t027_001/c2_w0_bl u_t027_001/c2_w0_br u_t027_001/c2_w1_bl u_t027_001/c2_w1_br
+ u_t027_001/c2_r0_rbl u_t027_001/c2_r1_rbl u_t027_001/c3_w0_bl u_t027_001/c3_w0_br
+ u_t027_001/c3_w1_bl u_t027_001/c3_w1_br u_t027_001/c3_r0_rbl u_t027_001/c3_r1_rbl
+ u_t027_001/r0_w0_wl u_t027_001/r0_w1_wl u_t027_001/r0_r0_rwl u_t027_001/r0_r1_rwl
+ u_t027_001/r1_w0_wl u_t027_001/r1_w1_wl u_t027_001/r1_r0_rwl u_t027_001/r1_r1_rwl
+ u_t027_001/r2_w0_wl u_t027_001/r2_w1_wl u_t027_001/r2_r0_rwl u_t027_001/r2_r1_rwl
+ u_t027_001/r3_w0_wl u_t027_001/r3_w1_wl u_t027_001/r3_r0_rwl u_t027_001/r3_r1_rwl
+ VSS VSS u_t027_001/m2_717_1265# u_t027_001/m2_603_2031# u_t027_001/m2_1290_336#
+ u_t027_001/m2_2000_2037# u_t027_001/m2_791_2909# u_t027_001/m2_7_2126# u_t027_001/m2_2154_2081#
+ u_t027_001/m2_1795_2037# u_t027_001/m2_871_303# u_t027_001/m2_431_438# u_t027_001/m2_1290_2898#
+ u_t027_001/m2_1714_1210# u_t027_001/m2_431_1982# u_t027_001/m2_512_1265# u_t027_001/m2_2573_2126#
+ u_t027_001/m2_603_1259# u_t027_001/m2_2074_2909# u_t027_001/m2_7_336# u_t027_001/m2_717_2037#
+ u_t027_001/m2_1886_2031# u_t027_001/m2_2573_336# u_t027_001/m2_7_2898# u_t027_001/m2_2000_1265#
+ u_t027_001/m2_512_2037# u_t027_001/m2_1795_1265# u_t027_001/m2_1714_1982# u_t027_001/m2_1886_1259#
+ u_t027_001/m2_1290_2126# u_t027_001/m2_1714_438# u_t027_001/m2_431_1210# u_t027_001/m2_2573_2898#
+ u_t027_001/m2_2154_303# u_t027_001/m2_871_2081# VSUBS detronyx_12t_2w2r_rc4_4x4_routed_5layer_direct
Xu_t027_012 u_t027_012/c0_w0_bl u_t027_012/c0_w0_br u_t027_012/c0_w1_bl u_t027_012/c0_w1_br
+ u_t027_012/c0_r0_rbl u_t027_012/c0_r1_rbl u_t027_012/c1_w0_bl u_t027_012/c1_w0_br
+ u_t027_012/c1_w1_bl u_t027_012/c1_w1_br u_t027_012/c1_r0_rbl u_t027_012/c1_r1_rbl
+ u_t027_012/c2_w0_bl u_t027_012/c2_w0_br u_t027_012/c2_w1_bl u_t027_012/c2_w1_br
+ u_t027_012/c2_r0_rbl u_t027_012/c2_r1_rbl u_t027_012/c3_w0_bl u_t027_012/c3_w0_br
+ u_t027_012/c3_w1_bl u_t027_012/c3_w1_br u_t027_012/c3_r0_rbl u_t027_012/c3_r1_rbl
+ u_t027_012/r0_w0_wl u_t027_012/r0_w1_wl u_t027_012/r0_r0_rwl u_t027_012/r0_r1_rwl
+ u_t027_012/r1_w0_wl u_t027_012/r1_w1_wl u_t027_012/r1_r0_rwl u_t027_012/r1_r1_rwl
+ u_t027_012/r2_w0_wl u_t027_012/r2_w1_wl u_t027_012/r2_r0_rwl u_t027_012/r2_r1_rwl
+ u_t027_012/r3_w0_wl u_t027_012/r3_w1_wl u_t027_012/r3_r0_rwl u_t027_012/r3_r1_rwl
+ u_t027_012/VDD u_t027_012/VSS u_t027_012/m2_717_1265# u_t027_012/m2_603_2031# u_t027_012/m2_1290_336#
+ u_t027_012/m2_2000_2037# u_t027_012/m2_791_2909# u_t027_012/m2_7_2126# u_t027_012/m2_2154_2081#
+ u_t027_012/m2_1795_2037# u_t027_012/m2_871_303# u_t027_012/m2_431_438# u_t027_012/m2_1290_2898#
+ u_t027_012/m2_1714_1210# u_t027_012/m2_431_1982# u_t027_012/m2_512_1265# u_t027_012/m2_2573_2126#
+ u_t027_012/m2_603_1259# u_t027_012/m2_2074_2909# u_t027_012/m2_7_336# u_t027_012/m2_717_2037#
+ u_t027_012/m2_1886_2031# u_t027_012/m2_2573_336# u_t027_012/m2_7_2898# u_t027_012/m2_2000_1265#
+ u_t027_012/m2_512_2037# u_t027_012/m2_1795_1265# u_t027_012/m2_1714_1982# u_t027_012/m2_1886_1259#
+ u_t027_012/m2_1290_2126# u_t027_012/m2_1714_438# u_t027_012/m2_431_1210# u_t027_012/m2_2573_2898#
+ u_t027_012/m2_2154_303# u_t027_012/m2_871_2081# VSUBS detronyx_12t_2w2r_rc4_4x4_routed_5layer_direct
Xu_t018_012 u_t018_012/c0_w0_bl u_t018_012/c0_w0_br u_t018_012/c0_w1_bl u_t018_012/c0_w1_br
+ u_t018_012/c0_r0_rbl u_t018_012/c0_r1_rbl u_t018_012/c1_w0_bl u_t018_012/c1_w0_br
+ u_t018_012/c1_w1_bl u_t018_012/c1_w1_br u_t018_012/c1_r0_rbl u_t018_012/c1_r1_rbl
+ u_t018_012/c2_w0_bl u_t018_012/c2_w0_br u_t018_012/c2_w1_bl u_t018_012/c2_w1_br
+ u_t018_012/c2_r0_rbl u_t018_012/c2_r1_rbl u_t018_012/c3_w0_bl u_t018_012/c3_w0_br
+ u_t018_012/c3_w1_bl u_t018_012/c3_w1_br u_t018_012/c3_r0_rbl u_t018_012/c3_r1_rbl
+ u_t018_012/r0_w0_wl u_t018_012/r0_w1_wl u_t018_012/r0_r0_rwl u_t018_012/r0_r1_rwl
+ u_t018_012/r1_w0_wl u_t018_012/r1_w1_wl u_t018_012/r1_r0_rwl u_t018_012/r1_r1_rwl
+ u_t018_012/r2_w0_wl u_t018_012/r2_w1_wl u_t018_012/r2_r0_rwl u_t018_012/r2_r1_rwl
+ u_t018_012/r3_w0_wl u_t018_012/r3_w1_wl u_t018_012/r3_r0_rwl u_t018_012/r3_r1_rwl
+ u_t018_012/VDD u_t018_012/VSS u_t018_012/m2_717_1265# u_t018_012/m2_603_2031# u_t018_012/m2_1290_336#
+ u_t018_012/m2_2000_2037# u_t018_012/m2_791_2909# u_t018_012/m2_7_2126# u_t018_012/m2_2154_2081#
+ u_t018_012/m2_1795_2037# u_t018_012/m2_871_303# u_t018_012/m2_431_438# u_t018_012/m2_1290_2898#
+ u_t018_012/m2_1714_1210# u_t018_012/m2_431_1982# u_t018_012/m2_512_1265# u_t018_012/m2_2573_2126#
+ u_t018_012/m2_603_1259# u_t018_012/m2_2074_2909# u_t018_012/m2_7_336# u_t018_012/m2_717_2037#
+ u_t018_012/m2_1886_2031# u_t018_012/m2_2573_336# u_t018_012/m2_7_2898# u_t018_012/m2_2000_1265#
+ u_t018_012/m2_512_2037# u_t018_012/m2_1795_1265# u_t018_012/m2_1714_1982# u_t018_012/m2_1886_1259#
+ u_t018_012/m2_1290_2126# u_t018_012/m2_1714_438# u_t018_012/m2_431_1210# u_t018_012/m2_2573_2898#
+ u_t018_012/m2_2154_303# u_t018_012/m2_871_2081# VSUBS detronyx_12t_2w2r_rc4_4x4_routed_5layer_direct
Xu_t018_001 u_t018_001/c0_w0_bl u_t018_001/c0_w0_br u_t018_001/c0_w1_bl u_t018_001/c0_w1_br
+ u_t018_001/c0_r0_rbl u_t018_001/c0_r1_rbl u_t018_001/c1_w0_bl u_t018_001/c1_w0_br
+ u_t018_001/c1_w1_bl u_t018_001/c1_w1_br u_t018_001/c1_r0_rbl u_t018_001/c1_r1_rbl
+ u_t018_001/c2_w0_bl u_t018_001/c2_w0_br u_t018_001/c2_w1_bl u_t018_001/c2_w1_br
+ u_t018_001/c2_r0_rbl u_t018_001/c2_r1_rbl u_t018_001/c3_w0_bl u_t018_001/c3_w0_br
+ u_t018_001/c3_w1_bl u_t018_001/c3_w1_br u_t018_001/c3_r0_rbl u_t018_001/c3_r1_rbl
+ u_t018_001/r0_w0_wl u_t018_001/r0_w1_wl u_t018_001/r0_r0_rwl u_t018_001/r0_r1_rwl
+ u_t018_001/r1_w0_wl u_t018_001/r1_w1_wl u_t018_001/r1_r0_rwl u_t018_001/r1_r1_rwl
+ u_t018_001/r2_w0_wl u_t018_001/r2_w1_wl u_t018_001/r2_r0_rwl u_t018_001/r2_r1_rwl
+ u_t018_001/r3_w0_wl u_t018_001/r3_w1_wl u_t018_001/r3_r0_rwl u_t018_001/r3_r1_rwl
+ VSS VSS u_t018_001/m2_717_1265# u_t018_001/m2_603_2031# u_t018_001/m2_1290_336#
+ u_t018_001/m2_2000_2037# u_t018_001/m2_791_2909# u_t018_001/m2_7_2126# u_t018_001/m2_2154_2081#
+ u_t018_001/m2_1795_2037# u_t018_001/m2_871_303# u_t018_001/m2_431_438# u_t018_001/m2_1290_2898#
+ u_t018_001/m2_1714_1210# u_t018_001/m2_431_1982# u_t018_001/m2_512_1265# u_t018_001/m2_2573_2126#
+ u_t018_001/m2_603_1259# u_t018_001/m2_2074_2909# u_t018_001/m2_7_336# u_t018_001/m2_717_2037#
+ u_t018_001/m2_1886_2031# u_t018_001/m2_2573_336# u_t018_001/m2_7_2898# u_t018_001/m2_2000_1265#
+ u_t018_001/m2_512_2037# u_t018_001/m2_1795_1265# u_t018_001/m2_1714_1982# u_t018_001/m2_1886_1259#
+ u_t018_001/m2_1290_2126# u_t018_001/m2_1714_438# u_t018_001/m2_431_1210# u_t018_001/m2_2573_2898#
+ u_t018_001/m2_2154_303# u_t018_001/m2_871_2081# VSUBS detronyx_12t_2w2r_rc4_4x4_routed_5layer_direct
Xu_t009_001 u_t009_001/c0_w0_bl u_t009_001/c0_w0_br u_t009_001/c0_w1_bl u_t009_001/c0_w1_br
+ u_t009_001/c0_r0_rbl u_t009_001/c0_r1_rbl u_t009_001/c1_w0_bl u_t009_001/c1_w0_br
+ u_t009_001/c1_w1_bl u_t009_001/c1_w1_br u_t009_001/c1_r0_rbl u_t009_001/c1_r1_rbl
+ u_t009_001/c2_w0_bl u_t009_001/c2_w0_br u_t009_001/c2_w1_bl u_t009_001/c2_w1_br
+ u_t009_001/c2_r0_rbl u_t009_001/c2_r1_rbl u_t009_001/c3_w0_bl u_t009_001/c3_w0_br
+ u_t009_001/c3_w1_bl u_t009_001/c3_w1_br u_t009_001/c3_r0_rbl u_t009_001/c3_r1_rbl
+ u_t009_001/r0_w0_wl u_t009_001/r0_w1_wl u_t009_001/r0_r0_rwl u_t009_001/r0_r1_rwl
+ u_t009_001/r1_w0_wl u_t009_001/r1_w1_wl u_t009_001/r1_r0_rwl u_t009_001/r1_r1_rwl
+ u_t009_001/r2_w0_wl u_t009_001/r2_w1_wl u_t009_001/r2_r0_rwl u_t009_001/r2_r1_rwl
+ u_t009_001/r3_w0_wl u_t009_001/r3_w1_wl u_t009_001/r3_r0_rwl u_t009_001/r3_r1_rwl
+ VSS VSS u_t009_001/m2_717_1265# u_t009_001/m2_603_2031# u_t009_001/m2_1290_336#
+ u_t009_001/m2_2000_2037# u_t009_001/m2_791_2909# u_t009_001/m2_7_2126# u_t009_001/m2_2154_2081#
+ u_t009_001/m2_1795_2037# u_t009_001/m2_871_303# u_t009_001/m2_431_438# u_t009_001/m2_1290_2898#
+ u_t009_001/m2_1714_1210# u_t009_001/m2_431_1982# u_t009_001/m2_512_1265# u_t009_001/m2_2573_2126#
+ u_t009_001/m2_603_1259# u_t009_001/m2_2074_2909# u_t009_001/m2_7_336# u_t009_001/m2_717_2037#
+ u_t009_001/m2_1886_2031# u_t009_001/m2_2573_336# u_t009_001/m2_7_2898# u_t009_001/m2_2000_1265#
+ u_t009_001/m2_512_2037# u_t009_001/m2_1795_1265# u_t009_001/m2_1714_1982# u_t009_001/m2_1886_1259#
+ u_t009_001/m2_1290_2126# u_t009_001/m2_1714_438# u_t009_001/m2_431_1210# u_t009_001/m2_2573_2898#
+ u_t009_001/m2_2154_303# u_t009_001/m2_871_2081# VSUBS detronyx_12t_2w2r_rc4_4x4_routed_5layer_direct
Xu_t024_015 u_t024_015/c0_w0_bl u_t024_015/c0_w0_br u_t024_015/c0_w1_bl u_t024_015/c0_w1_br
+ u_t024_015/c0_r0_rbl u_t024_015/c0_r1_rbl u_t024_015/c1_w0_bl u_t024_015/c1_w0_br
+ u_t024_015/c1_w1_bl u_t024_015/c1_w1_br u_t024_015/c1_r0_rbl u_t024_015/c1_r1_rbl
+ u_t024_015/c2_w0_bl u_t024_015/c2_w0_br u_t024_015/c2_w1_bl u_t024_015/c2_w1_br
+ u_t024_015/c2_r0_rbl u_t024_015/c2_r1_rbl u_t024_015/c3_w0_bl u_t024_015/c3_w0_br
+ u_t024_015/c3_w1_bl u_t024_015/c3_w1_br u_t024_015/c3_r0_rbl u_t024_015/c3_r1_rbl
+ u_t024_015/r0_w0_wl u_t024_015/r0_w1_wl u_t024_015/r0_r0_rwl u_t024_015/r0_r1_rwl
+ u_t024_015/r1_w0_wl u_t024_015/r1_w1_wl u_t024_015/r1_r0_rwl u_t024_015/r1_r1_rwl
+ u_t024_015/r2_w0_wl u_t024_015/r2_w1_wl u_t024_015/r2_r0_rwl u_t024_015/r2_r1_rwl
+ u_t024_015/r3_w0_wl u_t024_015/r3_w1_wl u_t024_015/r3_r0_rwl u_t024_015/r3_r1_rwl
+ VSS u_t024_015/VSS u_t024_015/m2_717_1265# u_t024_015/m2_603_2031# u_t024_015/m2_1290_336#
+ u_t024_015/m2_2000_2037# u_t024_015/m2_791_2909# u_t024_015/m2_7_2126# u_t024_015/m2_2154_2081#
+ u_t024_015/m2_1795_2037# u_t024_015/m2_871_303# u_t024_015/m2_431_438# u_t024_015/m2_1290_2898#
+ u_t024_015/m2_1714_1210# u_t024_015/m2_431_1982# u_t024_015/m2_512_1265# u_t024_015/m2_2573_2126#
+ u_t024_015/m2_603_1259# u_t024_015/m2_2074_2909# u_t024_015/m2_7_336# u_t024_015/m2_717_2037#
+ u_t024_015/m2_1886_2031# u_t024_015/m2_2573_336# u_t024_015/m2_7_2898# u_t024_015/m2_2000_1265#
+ u_t024_015/m2_512_2037# u_t024_015/m2_1795_1265# u_t024_015/m2_1714_1982# u_t024_015/m2_1886_1259#
+ u_t024_015/m2_1290_2126# u_t024_015/m2_1714_438# u_t024_015/m2_431_1210# u_t024_015/m2_2573_2898#
+ u_t024_015/m2_2154_303# u_t024_015/m2_871_2081# VSUBS detronyx_12t_2w2r_rc4_4x4_routed_5layer_direct
Xu_t009_012 u_t009_012/c0_w0_bl u_t009_012/c0_w0_br u_t009_012/c0_w1_bl u_t009_012/c0_w1_br
+ u_t009_012/c0_r0_rbl u_t009_012/c0_r1_rbl u_t009_012/c1_w0_bl u_t009_012/c1_w0_br
+ u_t009_012/c1_w1_bl u_t009_012/c1_w1_br u_t009_012/c1_r0_rbl u_t009_012/c1_r1_rbl
+ u_t009_012/c2_w0_bl u_t009_012/c2_w0_br u_t009_012/c2_w1_bl u_t009_012/c2_w1_br
+ u_t009_012/c2_r0_rbl u_t009_012/c2_r1_rbl u_t009_012/c3_w0_bl u_t009_012/c3_w0_br
+ u_t009_012/c3_w1_bl u_t009_012/c3_w1_br u_t009_012/c3_r0_rbl u_t009_012/c3_r1_rbl
+ u_t009_012/r0_w0_wl u_t009_012/r0_w1_wl u_t009_012/r0_r0_rwl u_t009_012/r0_r1_rwl
+ u_t009_012/r1_w0_wl u_t009_012/r1_w1_wl u_t009_012/r1_r0_rwl u_t009_012/r1_r1_rwl
+ u_t009_012/r2_w0_wl u_t009_012/r2_w1_wl u_t009_012/r2_r0_rwl u_t009_012/r2_r1_rwl
+ u_t009_012/r3_w0_wl u_t009_012/r3_w1_wl u_t009_012/r3_r0_rwl u_t009_012/r3_r1_rwl
+ u_t009_012/VDD VSS u_t009_012/m2_717_1265# u_t009_012/m2_603_2031# u_t009_012/m2_1290_336#
+ u_t009_012/m2_2000_2037# u_t009_012/m2_791_2909# u_t009_012/m2_7_2126# u_t009_012/m2_2154_2081#
+ u_t009_012/m2_1795_2037# u_t009_012/m2_871_303# u_t009_012/m2_431_438# u_t009_012/m2_1290_2898#
+ u_t009_012/m2_1714_1210# u_t009_012/m2_431_1982# u_t009_012/m2_512_1265# u_t009_012/m2_2573_2126#
+ u_t009_012/m2_603_1259# u_t009_012/m2_2074_2909# u_t009_012/m2_7_336# u_t009_012/m2_717_2037#
+ u_t009_012/m2_1886_2031# u_t009_012/m2_2573_336# u_t009_012/m2_7_2898# u_t009_012/m2_2000_1265#
+ u_t009_012/m2_512_2037# u_t009_012/m2_1795_1265# u_t009_012/m2_1714_1982# u_t009_012/m2_1886_1259#
+ u_t009_012/m2_1290_2126# u_t009_012/m2_1714_438# u_t009_012/m2_431_1210# u_t009_012/m2_2573_2898#
+ u_t009_012/m2_2154_303# u_t009_012/m2_871_2081# VSUBS detronyx_12t_2w2r_rc4_4x4_routed_5layer_direct
Xu_t024_004 u_t024_004/c0_w0_bl u_t024_004/c0_w0_br u_t024_004/c0_w1_bl u_t024_004/c0_w1_br
+ u_t024_004/c0_r0_rbl u_t024_004/c0_r1_rbl u_t024_004/c1_w0_bl u_t024_004/c1_w0_br
+ u_t024_004/c1_w1_bl u_t024_004/c1_w1_br u_t024_004/c1_r0_rbl u_t024_004/c1_r1_rbl
+ u_t024_004/c2_w0_bl u_t024_004/c2_w0_br u_t024_004/c2_w1_bl u_t024_004/c2_w1_br
+ u_t024_004/c2_r0_rbl u_t024_004/c2_r1_rbl u_t024_004/c3_w0_bl u_t024_004/c3_w0_br
+ u_t024_004/c3_w1_bl u_t024_004/c3_w1_br u_t024_004/c3_r0_rbl u_t024_004/c3_r1_rbl
+ u_t024_004/r0_w0_wl u_t024_004/r0_w1_wl u_t024_004/r0_r0_rwl u_t024_004/r0_r1_rwl
+ u_t024_004/r1_w0_wl u_t024_004/r1_w1_wl u_t024_004/r1_r0_rwl u_t024_004/r1_r1_rwl
+ u_t024_004/r2_w0_wl u_t024_004/r2_w1_wl u_t024_004/r2_r0_rwl u_t024_004/r2_r1_rwl
+ u_t024_004/r3_w0_wl u_t024_004/r3_w1_wl u_t024_004/r3_r0_rwl u_t024_004/r3_r1_rwl
+ u_t025_004/VDD u_t024_004/VSS u_t024_004/m2_717_1265# u_t024_004/m2_603_2031# u_t024_004/m2_1290_336#
+ u_t024_004/m2_2000_2037# u_t024_004/m2_791_2909# u_t024_004/m2_7_2126# u_t024_004/m2_2154_2081#
+ u_t024_004/m2_1795_2037# u_t024_004/m2_871_303# u_t024_004/m2_431_438# u_t024_004/m2_1290_2898#
+ u_t024_004/m2_1714_1210# u_t024_004/m2_431_1982# u_t024_004/m2_512_1265# u_t024_004/m2_2573_2126#
+ u_t024_004/m2_603_1259# u_t024_004/m2_2074_2909# u_t024_004/m2_7_336# u_t024_004/m2_717_2037#
+ u_t024_004/m2_1886_2031# u_t024_004/m2_2573_336# u_t024_004/m2_7_2898# u_t024_004/m2_2000_1265#
+ u_t024_004/m2_512_2037# u_t024_004/m2_1795_1265# u_t024_004/m2_1714_1982# u_t024_004/m2_1886_1259#
+ u_t024_004/m2_1290_2126# u_t024_004/m2_1714_438# u_t024_004/m2_431_1210# u_t024_004/m2_2573_2898#
+ u_t024_004/m2_2154_303# u_t024_004/m2_871_2081# VSUBS detronyx_12t_2w2r_rc4_4x4_routed_5layer_direct
Xgf180mcu_as_sc_mcu7t3v3__nand3_2_49 gf180mcu_as_sc_mcu7t3v3__nor2_2_9/VDD gf180mcu_as_sc_mcu7t3v3__nand3_2_63/VSS
+ VSS VSS VSS VSS gf180mcu_as_sc_mcu7t3v3__nor2_2_9/VNW VSUBS gf180mcu_as_sc_mcu7t3v3__nand3_2
Xgf180mcu_as_sc_mcu7t3v3__nand3_2_16 gf180mcu_as_sc_mcu7t3v3__nor2_2_6/VDD gf180mcu_as_sc_mcu7t3v3__nand3_2_4/VSS
+ VSS VSS VSS VSS gf180mcu_as_sc_mcu7t3v3__nor2_2_6/VNW VSUBS gf180mcu_as_sc_mcu7t3v3__nand3_2
Xgf180mcu_as_sc_mcu7t3v3__nand3_2_38 gf180mcu_as_sc_mcu7t3v3__nor2_2_7/VDD gf180mcu_as_sc_mcu7t3v3__nand3_2_4/VSS
+ VSS VSS VSS VSS gf180mcu_as_sc_mcu7t3v3__nor2_2_7/VNW VSUBS gf180mcu_as_sc_mcu7t3v3__nand3_2
Xgf180mcu_as_sc_mcu7t3v3__nand3_2_27 gf180mcu_as_sc_mcu7t3v3__nor2_2_7/VDD gf180mcu_as_sc_mcu7t3v3__nand3_2_4/VSS
+ VSS VSS VSS VSS gf180mcu_as_sc_mcu7t3v3__nor2_2_7/VNW VSUBS gf180mcu_as_sc_mcu7t3v3__nand3_2
Xgf180mcu_as_sc_mcu7t3v3__inv_2_170 gf180mcu_as_sc_mcu7t3v3__inv_2_171/VDD VSS gf180mcu_as_sc_mcu7t3v3__inv_2_170/Y
+ VSS gf180mcu_as_sc_mcu7t3v3__inv_2_171/VNW VSUBS gf180mcu_as_sc_mcu7t3v3__inv_2
Xgf180mcu_as_sc_mcu7t3v3__inv_2_1636 gf180mcu_as_sc_mcu7t3v3__inv_2_1638/VDD VSS VSS
+ gf180mcu_as_sc_mcu7t3v3__inv_2_1689/A gf180mcu_as_sc_mcu7t3v3__inv_2_1638/VNW VSUBS
+ gf180mcu_as_sc_mcu7t3v3__inv_2
Xgf180mcu_as_sc_mcu7t3v3__inv_2_1669 VSS VSS VSS gf180mcu_as_sc_mcu7t3v3__inv_2_1669/A
+ gf180mcu_as_sc_mcu7t3v3__inv_2_1669/VNW VSUBS gf180mcu_as_sc_mcu7t3v3__inv_2
Xgf180mcu_as_sc_mcu7t3v3__inv_2_1614 gf180mcu_as_sc_mcu7t3v3__inv_2_1614/VDD gf180mcu_as_sc_mcu7t3v3__inv_2_1618/VDD
+ gf180mcu_as_sc_mcu7t3v3__inv_2_1669/A VSS gf180mcu_as_sc_mcu7t3v3__inv_2_1614/VNW
+ VSUBS gf180mcu_as_sc_mcu7t3v3__inv_2
Xgf180mcu_as_sc_mcu7t3v3__inv_2_1647 gf180mcu_as_sc_mcu7t3v3__inv_2_1648/VDD VSS gf180mcu_as_sc_mcu7t3v3__inv_2_1669/A
+ gf180mcu_as_sc_mcu7t3v3__inv_2_1669/A gf180mcu_as_sc_mcu7t3v3__inv_2_1648/VNW VSUBS
+ gf180mcu_as_sc_mcu7t3v3__inv_2
Xgf180mcu_as_sc_mcu7t3v3__inv_2_1625 gf180mcu_as_sc_mcu7t3v3__inv_2_1626/VDD gf180mcu_as_sc_mcu7t3v3__inv_2_1648/VDD
+ gf180mcu_as_sc_mcu7t3v3__inv_2_1625/Y gf180mcu_as_sc_mcu7t3v3__inv_2_1669/A gf180mcu_as_sc_mcu7t3v3__inv_2_1626/VNW
+ VSUBS gf180mcu_as_sc_mcu7t3v3__inv_2
Xgf180mcu_as_sc_mcu7t3v3__inv_2_1658 gf180mcu_as_sc_mcu7t3v3__inv_2_1660/VDD VSS VSS
+ gf180mcu_as_sc_mcu7t3v3__inv_2_1669/A gf180mcu_as_sc_mcu7t3v3__inv_2_1660/VNW VSUBS
+ gf180mcu_as_sc_mcu7t3v3__inv_2
Xgf180mcu_as_sc_mcu7t3v3__inv_2_1603 VSS gf180mcu_as_sc_mcu7t3v3__inv_2_1691/VSS gf180mcu_as_sc_mcu7t3v3__inv_2_1694/Y
+ VSS gf180mcu_as_sc_mcu7t3v3__inv_2_1691/VNW VSUBS gf180mcu_as_sc_mcu7t3v3__inv_2
Xgf180mcu_as_sc_mcu7t3v3__inv_2_181 gf180mcu_as_sc_mcu7t3v3__inv_2_182/VDD gf180mcu_as_sc_mcu7t3v3__inv_2_371/VDD
+ gf180mcu_as_sc_mcu7t3v3__inv_2_181/Y VSS gf180mcu_as_sc_mcu7t3v3__inv_2_182/VNW
+ VSUBS gf180mcu_as_sc_mcu7t3v3__inv_2
Xgf180mcu_as_sc_mcu7t3v3__inv_2_192 gf180mcu_as_sc_mcu7t3v3__inv_2_193/VDD VSS gf180mcu_as_sc_mcu7t3v3__inv_2_192/Y
+ VSS gf180mcu_as_sc_mcu7t3v3__inv_2_193/VNW VSUBS gf180mcu_as_sc_mcu7t3v3__inv_2
Xu_t015_015 u_t015_015/c0_w0_bl u_t015_015/c0_w0_br u_t015_015/c0_w1_bl u_t015_015/c0_w1_br
+ u_t015_015/c0_r0_rbl u_t015_015/c0_r1_rbl u_t015_015/c1_w0_bl u_t015_015/c1_w0_br
+ u_t015_015/c1_w1_bl u_t015_015/c1_w1_br u_t015_015/c1_r0_rbl u_t015_015/c1_r1_rbl
+ u_t015_015/c2_w0_bl u_t015_015/c2_w0_br u_t015_015/c2_w1_bl u_t015_015/c2_w1_br
+ u_t015_015/c2_r0_rbl u_t015_015/c2_r1_rbl u_t015_015/c3_w0_bl u_t015_015/c3_w0_br
+ u_t015_015/c3_w1_bl u_t015_015/c3_w1_br u_t015_015/c3_r0_rbl u_t015_015/c3_r1_rbl
+ u_t015_015/r0_w0_wl u_t015_015/r0_w1_wl u_t015_015/r0_r0_rwl u_t015_015/r0_r1_rwl
+ u_t015_015/r1_w0_wl u_t015_015/r1_w1_wl u_t015_015/r1_r0_rwl u_t015_015/r1_r1_rwl
+ u_t015_015/r2_w0_wl u_t015_015/r2_w1_wl u_t015_015/r2_r0_rwl u_t015_015/r2_r1_rwl
+ u_t015_015/r3_w0_wl u_t015_015/r3_w1_wl u_t015_015/r3_r0_rwl u_t015_015/r3_r1_rwl
+ VSS u_t015_015/VSS u_t015_015/m2_717_1265# u_t015_015/m2_603_2031# u_t015_015/m2_1290_336#
+ u_t015_015/m2_2000_2037# u_t015_015/m2_791_2909# u_t015_015/m2_7_2126# u_t015_015/m2_2154_2081#
+ u_t015_015/m2_1795_2037# u_t015_015/m2_871_303# u_t015_015/m2_431_438# u_t015_015/m2_1290_2898#
+ u_t015_015/m2_1714_1210# u_t015_015/m2_431_1982# u_t015_015/m2_512_1265# u_t015_015/m2_2573_2126#
+ u_t015_015/m2_603_1259# u_t015_015/m2_2074_2909# u_t015_015/m2_7_336# u_t015_015/m2_717_2037#
+ u_t015_015/m2_1886_2031# u_t015_015/m2_2573_336# u_t015_015/m2_7_2898# u_t015_015/m2_2000_1265#
+ u_t015_015/m2_512_2037# u_t015_015/m2_1795_1265# u_t015_015/m2_1714_1982# u_t015_015/m2_1886_1259#
+ u_t015_015/m2_1290_2126# u_t015_015/m2_1714_438# u_t015_015/m2_431_1210# u_t015_015/m2_2573_2898#
+ u_t015_015/m2_2154_303# u_t015_015/m2_871_2081# VSUBS detronyx_12t_2w2r_rc4_4x4_routed_5layer_direct
Xu_t030_007 u_t030_007/c0_w0_bl u_t030_007/c0_w0_br u_t030_007/c0_w1_bl u_t030_007/c0_w1_br
+ u_t030_007/c0_r0_rbl u_t030_007/c0_r1_rbl u_t030_007/c1_w0_bl u_t030_007/c1_w0_br
+ u_t030_007/c1_w1_bl u_t030_007/c1_w1_br u_t030_007/c1_r0_rbl u_t030_007/c1_r1_rbl
+ u_t030_007/c2_w0_bl u_t030_007/c2_w0_br u_t030_007/c2_w1_bl u_t030_007/c2_w1_br
+ u_t030_007/c2_r0_rbl u_t030_007/c2_r1_rbl u_t030_007/c3_w0_bl u_t030_007/c3_w0_br
+ u_t030_007/c3_w1_bl u_t030_007/c3_w1_br u_t030_007/c3_r0_rbl u_t030_007/c3_r1_rbl
+ u_t030_007/r0_w0_wl u_t030_007/r0_w1_wl u_t030_007/r0_r0_rwl u_t030_007/r0_r1_rwl
+ u_t030_007/r1_w0_wl u_t030_007/r1_w1_wl u_t030_007/r1_r0_rwl u_t030_007/r1_r1_rwl
+ u_t030_007/r2_w0_wl u_t030_007/r2_w1_wl u_t030_007/r2_r0_rwl u_t030_007/r2_r1_rwl
+ u_t030_007/r3_w0_wl u_t030_007/r3_w1_wl u_t030_007/r3_r0_rwl u_t030_007/r3_r1_rwl
+ VSS VSS u_t030_007/m2_717_1265# u_t030_007/m2_603_2031# u_t030_007/m2_1290_336#
+ u_t030_007/m2_2000_2037# u_t030_007/m2_791_2909# u_t030_007/m2_7_2126# u_t030_007/m2_2154_2081#
+ u_t030_007/m2_1795_2037# u_t030_007/m2_871_303# u_t030_007/m2_431_438# u_t030_007/m2_1290_2898#
+ u_t030_007/m2_1714_1210# u_t030_007/m2_431_1982# u_t030_007/m2_512_1265# u_t030_007/m2_2573_2126#
+ u_t030_007/m2_603_1259# u_t030_007/m2_2074_2909# u_t030_007/m2_7_336# u_t030_007/m2_717_2037#
+ u_t030_007/m2_1886_2031# u_t030_007/m2_2573_336# u_t030_007/m2_7_2898# u_t030_007/m2_2000_1265#
+ u_t030_007/m2_512_2037# u_t030_007/m2_1795_1265# u_t030_007/m2_1714_1982# u_t030_007/m2_1886_1259#
+ u_t030_007/m2_1290_2126# u_t030_007/m2_1714_438# u_t030_007/m2_431_1210# u_t030_007/m2_2573_2898#
+ u_t030_007/m2_2154_303# u_t030_007/m2_871_2081# VSUBS detronyx_12t_2w2r_rc4_4x4_routed_5layer_direct
Xu_t015_004 u_t015_004/c0_w0_bl u_t015_004/c0_w0_br u_t015_004/c0_w1_bl u_t015_004/c0_w1_br
+ u_t015_004/c0_r0_rbl u_t015_004/c0_r1_rbl u_t015_004/c1_w0_bl u_t015_004/c1_w0_br
+ u_t015_004/c1_w1_bl u_t015_004/c1_w1_br u_t015_004/c1_r0_rbl u_t015_004/c1_r1_rbl
+ u_t015_004/c2_w0_bl u_t015_004/c2_w0_br u_t015_004/c2_w1_bl u_t015_004/c2_w1_br
+ u_t015_004/c2_r0_rbl u_t015_004/c2_r1_rbl u_t015_004/c3_w0_bl u_t015_004/c3_w0_br
+ u_t015_004/c3_w1_bl u_t015_004/c3_w1_br u_t015_004/c3_r0_rbl u_t015_004/c3_r1_rbl
+ u_t015_004/r0_w0_wl u_t015_004/r0_w1_wl u_t015_004/r0_r0_rwl u_t015_004/r0_r1_rwl
+ u_t015_004/r1_w0_wl u_t015_004/r1_w1_wl u_t015_004/r1_r0_rwl u_t015_004/r1_r1_rwl
+ u_t015_004/r2_w0_wl u_t015_004/r2_w1_wl u_t015_004/r2_r0_rwl u_t015_004/r2_r1_rwl
+ u_t015_004/r3_w0_wl u_t015_004/r3_w1_wl u_t015_004/r3_r0_rwl u_t015_004/r3_r1_rwl
+ u_t015_004/VDD u_t015_004/VSS u_t015_004/m2_717_1265# u_t015_004/m2_603_2031# u_t015_004/m2_1290_336#
+ u_t015_004/m2_2000_2037# u_t015_004/m2_791_2909# u_t015_004/m2_7_2126# u_t015_004/m2_2154_2081#
+ u_t015_004/m2_1795_2037# u_t015_004/m2_871_303# u_t015_004/m2_431_438# u_t015_004/m2_1290_2898#
+ u_t015_004/m2_1714_1210# u_t015_004/m2_431_1982# u_t015_004/m2_512_1265# u_t015_004/m2_2573_2126#
+ u_t015_004/m2_603_1259# u_t015_004/m2_2074_2909# u_t015_004/m2_7_336# u_t015_004/m2_717_2037#
+ u_t015_004/m2_1886_2031# u_t015_004/m2_2573_336# u_t015_004/m2_7_2898# u_t015_004/m2_2000_1265#
+ u_t015_004/m2_512_2037# u_t015_004/m2_1795_1265# u_t015_004/m2_1714_1982# u_t015_004/m2_1886_1259#
+ u_t015_004/m2_1290_2126# u_t015_004/m2_1714_438# u_t015_004/m2_431_1210# u_t015_004/m2_2573_2898#
+ u_t015_004/m2_2154_303# u_t015_004/m2_871_2081# VSUBS detronyx_12t_2w2r_rc4_4x4_routed_5layer_direct
Xgf180mcu_as_sc_mcu7t3v3__nand4_2_419 VSS gf180mcu_as_sc_mcu7t3v3__inv_2_1532/VDD
+ VSS VSS VSS VSS gf180mcu_as_sc_mcu7t3v3__nand4_2_419/Y gf180mcu_as_sc_mcu7t3v3__inv_2_1529/VNW
+ VSUBS gf180mcu_as_sc_mcu7t3v3__nand4_2
Xgf180mcu_as_sc_mcu7t3v3__nand4_2_408 VSS VSS VSS VSS VSS VSS VSS gf180mcu_as_sc_mcu7t3v3__inv_2_1494/VNW
+ VSUBS gf180mcu_as_sc_mcu7t3v3__nand4_2
Xu_t006_015 u_t006_015/c0_w0_bl u_t006_015/c0_w0_br u_t006_015/c0_w1_bl u_t006_015/c0_w1_br
+ u_t006_015/c0_r0_rbl u_t006_015/c0_r1_rbl u_t006_015/c1_w0_bl u_t006_015/c1_w0_br
+ u_t006_015/c1_w1_bl u_t006_015/c1_w1_br u_t006_015/c1_r0_rbl u_t006_015/c1_r1_rbl
+ u_t006_015/c2_w0_bl u_t006_015/c2_w0_br u_t006_015/c2_w1_bl u_t006_015/c2_w1_br
+ u_t006_015/c2_r0_rbl u_t006_015/c2_r1_rbl u_t006_015/c3_w0_bl u_t006_015/c3_w0_br
+ u_t006_015/c3_w1_bl u_t006_015/c3_w1_br u_t006_015/c3_r0_rbl u_t006_015/c3_r1_rbl
+ u_t006_015/r0_w0_wl u_t006_015/r0_w1_wl u_t006_015/r0_r0_rwl u_t006_015/r0_r1_rwl
+ u_t006_015/r1_w0_wl u_t006_015/r1_w1_wl u_t006_015/r1_r0_rwl u_t006_015/r1_r1_rwl
+ u_t006_015/r2_w0_wl u_t006_015/r2_w1_wl u_t006_015/r2_r0_rwl u_t006_015/r2_r1_rwl
+ u_t006_015/r3_w0_wl u_t006_015/r3_w1_wl u_t006_015/r3_r0_rwl u_t006_015/r3_r1_rwl
+ VSS u_t006_015/VSS u_t006_015/m2_717_1265# u_t006_015/m2_603_2031# u_t006_015/m2_1290_336#
+ u_t006_015/m2_2000_2037# u_t006_015/m2_791_2909# u_t006_015/m2_7_2126# u_t006_015/m2_2154_2081#
+ u_t006_015/m2_1795_2037# u_t006_015/m2_871_303# u_t006_015/m2_431_438# u_t006_015/m2_1290_2898#
+ u_t006_015/m2_1714_1210# u_t006_015/m2_431_1982# u_t006_015/m2_512_1265# u_t006_015/m2_2573_2126#
+ u_t006_015/m2_603_1259# u_t006_015/m2_2074_2909# u_t006_015/m2_7_336# u_t006_015/m2_717_2037#
+ u_t006_015/m2_1886_2031# u_t006_015/m2_2573_336# u_t006_015/m2_7_2898# u_t006_015/m2_2000_1265#
+ u_t006_015/m2_512_2037# u_t006_015/m2_1795_1265# u_t006_015/m2_1714_1982# u_t006_015/m2_1886_1259#
+ u_t006_015/m2_1290_2126# u_t006_015/m2_1714_438# u_t006_015/m2_431_1210# u_t006_015/m2_2573_2898#
+ u_t006_015/m2_2154_303# u_t006_015/m2_871_2081# VSUBS detronyx_12t_2w2r_rc4_4x4_routed_5layer_direct
Xu_t006_004 u_t006_004/c0_w0_bl u_t006_004/c0_w0_br u_t006_004/c0_w1_bl u_t006_004/c0_w1_br
+ u_t006_004/c0_r0_rbl u_t006_004/c0_r1_rbl u_t006_004/c1_w0_bl u_t006_004/c1_w0_br
+ u_t006_004/c1_w1_bl u_t006_004/c1_w1_br u_t006_004/c1_r0_rbl u_t006_004/c1_r1_rbl
+ u_t006_004/c2_w0_bl u_t006_004/c2_w0_br u_t006_004/c2_w1_bl u_t006_004/c2_w1_br
+ u_t006_004/c2_r0_rbl u_t006_004/c2_r1_rbl u_t006_004/c3_w0_bl u_t006_004/c3_w0_br
+ u_t006_004/c3_w1_bl u_t006_004/c3_w1_br u_t006_004/c3_r0_rbl u_t006_004/c3_r1_rbl
+ u_t006_004/r0_w0_wl u_t006_004/r0_w1_wl u_t006_004/r0_r0_rwl u_t006_004/r0_r1_rwl
+ u_t006_004/r1_w0_wl u_t006_004/r1_w1_wl u_t006_004/r1_r0_rwl u_t006_004/r1_r1_rwl
+ u_t006_004/r2_w0_wl u_t006_004/r2_w1_wl u_t006_004/r2_r0_rwl u_t006_004/r2_r1_rwl
+ u_t006_004/r3_w0_wl u_t006_004/r3_w1_wl u_t006_004/r3_r0_rwl u_t006_004/r3_r1_rwl
+ u_t006_004/VDD u_t006_004/VSS u_t006_004/m2_717_1265# u_t006_004/m2_603_2031# u_t006_004/m2_1290_336#
+ u_t006_004/m2_2000_2037# u_t006_004/m2_791_2909# u_t006_004/m2_7_2126# u_t006_004/m2_2154_2081#
+ u_t006_004/m2_1795_2037# u_t006_004/m2_871_303# u_t006_004/m2_431_438# u_t006_004/m2_1290_2898#
+ u_t006_004/m2_1714_1210# u_t006_004/m2_431_1982# u_t006_004/m2_512_1265# u_t006_004/m2_2573_2126#
+ u_t006_004/m2_603_1259# u_t006_004/m2_2074_2909# u_t006_004/m2_7_336# u_t006_004/m2_717_2037#
+ u_t006_004/m2_1886_2031# u_t006_004/m2_2573_336# u_t006_004/m2_7_2898# u_t006_004/m2_2000_1265#
+ u_t006_004/m2_512_2037# u_t006_004/m2_1795_1265# u_t006_004/m2_1714_1982# u_t006_004/m2_1886_1259#
+ u_t006_004/m2_1290_2126# u_t006_004/m2_1714_438# u_t006_004/m2_431_1210# u_t006_004/m2_2573_2898#
+ u_t006_004/m2_2154_303# u_t006_004/m2_871_2081# VSUBS detronyx_12t_2w2r_rc4_4x4_routed_5layer_direct
Xgf180mcu_as_sc_mcu7t3v3__inv_2_9 gf180mcu_as_sc_mcu7t3v3__inv_2_9/VDD gf180mcu_as_sc_mcu7t3v3__inv_2_9/VSS
+ gf180mcu_as_sc_mcu7t3v3__inv_2_9/Y VSS gf180mcu_as_sc_mcu7t3v3__inv_2_9/VNW VSUBS
+ gf180mcu_as_sc_mcu7t3v3__inv_2
Xu_t021_007 u_t021_007/c0_w0_bl u_t021_007/c0_w0_br u_t021_007/c0_w1_bl u_t021_007/c0_w1_br
+ u_t021_007/c0_r0_rbl u_t021_007/c0_r1_rbl u_t021_007/c1_w0_bl u_t021_007/c1_w0_br
+ u_t021_007/c1_w1_bl u_t021_007/c1_w1_br u_t021_007/c1_r0_rbl u_t021_007/c1_r1_rbl
+ u_t021_007/c2_w0_bl u_t021_007/c2_w0_br u_t021_007/c2_w1_bl u_t021_007/c2_w1_br
+ u_t021_007/c2_r0_rbl u_t021_007/c2_r1_rbl u_t021_007/c3_w0_bl u_t021_007/c3_w0_br
+ u_t021_007/c3_w1_bl u_t021_007/c3_w1_br u_t021_007/c3_r0_rbl u_t021_007/c3_r1_rbl
+ u_t021_007/r0_w0_wl u_t021_007/r0_w1_wl u_t021_007/r0_r0_rwl u_t021_007/r0_r1_rwl
+ u_t021_007/r1_w0_wl u_t021_007/r1_w1_wl u_t021_007/r1_r0_rwl u_t021_007/r1_r1_rwl
+ u_t021_007/r2_w0_wl u_t021_007/r2_w1_wl u_t021_007/r2_r0_rwl u_t021_007/r2_r1_rwl
+ u_t021_007/r3_w0_wl u_t021_007/r3_w1_wl u_t021_007/r3_r0_rwl u_t021_007/r3_r1_rwl
+ VSS VSS u_t021_007/m2_717_1265# u_t021_007/m2_603_2031# u_t021_007/m2_1290_336#
+ u_t021_007/m2_2000_2037# u_t021_007/m2_791_2909# u_t021_007/m2_7_2126# u_t021_007/m2_2154_2081#
+ u_t021_007/m2_1795_2037# u_t021_007/m2_871_303# u_t021_007/m2_431_438# u_t021_007/m2_1290_2898#
+ u_t021_007/m2_1714_1210# u_t021_007/m2_431_1982# u_t021_007/m2_512_1265# u_t021_007/m2_2573_2126#
+ u_t021_007/m2_603_1259# u_t021_007/m2_2074_2909# u_t021_007/m2_7_336# u_t021_007/m2_717_2037#
+ u_t021_007/m2_1886_2031# u_t021_007/m2_2573_336# u_t021_007/m2_7_2898# u_t021_007/m2_2000_1265#
+ u_t021_007/m2_512_2037# u_t021_007/m2_1795_1265# u_t021_007/m2_1714_1982# u_t021_007/m2_1886_1259#
+ u_t021_007/m2_1290_2126# u_t021_007/m2_1714_438# u_t021_007/m2_431_1210# u_t021_007/m2_2573_2898#
+ u_t021_007/m2_2154_303# u_t021_007/m2_871_2081# VSUBS detronyx_12t_2w2r_rc4_4x4_routed_5layer_direct
Xu_t012_007 u_t012_007/c0_w0_bl u_t012_007/c0_w0_br u_t012_007/c0_w1_bl u_t012_007/c0_w1_br
+ u_t012_007/c0_r0_rbl u_t012_007/c0_r1_rbl u_t012_007/c1_w0_bl u_t012_007/c1_w0_br
+ u_t012_007/c1_w1_bl u_t012_007/c1_w1_br u_t012_007/c1_r0_rbl u_t012_007/c1_r1_rbl
+ u_t012_007/c2_w0_bl u_t012_007/c2_w0_br u_t012_007/c2_w1_bl u_t012_007/c2_w1_br
+ u_t012_007/c2_r0_rbl u_t012_007/c2_r1_rbl u_t012_007/c3_w0_bl u_t012_007/c3_w0_br
+ u_t012_007/c3_w1_bl u_t012_007/c3_w1_br u_t012_007/c3_r0_rbl u_t012_007/c3_r1_rbl
+ u_t012_007/r0_w0_wl u_t012_007/r0_w1_wl u_t012_007/r0_r0_rwl u_t012_007/r0_r1_rwl
+ u_t012_007/r1_w0_wl u_t012_007/r1_w1_wl u_t012_007/r1_r0_rwl u_t012_007/r1_r1_rwl
+ u_t012_007/r2_w0_wl u_t012_007/r2_w1_wl u_t012_007/r2_r0_rwl u_t012_007/r2_r1_rwl
+ u_t012_007/r3_w0_wl u_t012_007/r3_w1_wl u_t012_007/r3_r0_rwl u_t012_007/r3_r1_rwl
+ VSS VSS u_t012_007/m2_717_1265# u_t012_007/m2_603_2031# u_t012_007/m2_1290_336#
+ u_t012_007/m2_2000_2037# u_t012_007/m2_791_2909# u_t012_007/m2_7_2126# u_t012_007/m2_2154_2081#
+ u_t012_007/m2_1795_2037# u_t012_007/m2_871_303# u_t012_007/m2_431_438# u_t012_007/m2_1290_2898#
+ u_t012_007/m2_1714_1210# u_t012_007/m2_431_1982# u_t012_007/m2_512_1265# u_t012_007/m2_2573_2126#
+ u_t012_007/m2_603_1259# u_t012_007/m2_2074_2909# u_t012_007/m2_7_336# u_t012_007/m2_717_2037#
+ u_t012_007/m2_1886_2031# u_t012_007/m2_2573_336# u_t012_007/m2_7_2898# u_t012_007/m2_2000_1265#
+ u_t012_007/m2_512_2037# u_t012_007/m2_1795_1265# u_t012_007/m2_1714_1982# u_t012_007/m2_1886_1259#
+ u_t012_007/m2_1290_2126# u_t012_007/m2_1714_438# u_t012_007/m2_431_1210# u_t012_007/m2_2573_2898#
+ u_t012_007/m2_2154_303# u_t012_007/m2_871_2081# VSUBS detronyx_12t_2w2r_rc4_4x4_routed_5layer_direct
Xgf180mcu_as_sc_mcu7t3v3__inv_2_1466 VSS gf180mcu_as_sc_mcu7t3v3__inv_2_1470/VDD VSS
+ VSS gf180mcu_as_sc_mcu7t3v3__inv_2_1467/VNW VSUBS gf180mcu_as_sc_mcu7t3v3__inv_2
Xgf180mcu_as_sc_mcu7t3v3__inv_2_1400 VSS gf180mcu_as_sc_mcu7t3v3__inv_2_1406/VDD VSS
+ gf180mcu_as_sc_mcu7t3v3__inv_2_1409/A gf180mcu_as_sc_mcu7t3v3__inv_2_1402/VNW VSUBS
+ gf180mcu_as_sc_mcu7t3v3__inv_2
Xgf180mcu_as_sc_mcu7t3v3__inv_2_1488 VSS gf180mcu_as_sc_mcu7t3v3__inv_2_1491/VDD gf180mcu_as_sc_mcu7t3v3__inv_2_1488/Y
+ VSS gf180mcu_as_sc_mcu7t3v3__inv_2_1488/VNW VSUBS gf180mcu_as_sc_mcu7t3v3__inv_2
Xgf180mcu_as_sc_mcu7t3v3__inv_2_1499 gf180mcu_as_sc_mcu7t3v3__inv_2_1500/VDD gf180mcu_as_sc_mcu7t3v3__inv_2_1503/VDD
+ gf180mcu_as_sc_mcu7t3v3__inv_2_1499/Y VSS gf180mcu_as_sc_mcu7t3v3__inv_2_1500/VNW
+ VSUBS gf180mcu_as_sc_mcu7t3v3__inv_2
Xgf180mcu_as_sc_mcu7t3v3__inv_2_1477 gf180mcu_as_sc_mcu7t3v3__inv_2_1508/VDD gf180mcu_as_sc_mcu7t3v3__inv_2_1508/VSS
+ gf180mcu_as_sc_mcu7t3v3__inv_2_1477/Y VSS gf180mcu_as_sc_mcu7t3v3__inv_2_1508/VNW
+ VSUBS gf180mcu_as_sc_mcu7t3v3__inv_2
Xgf180mcu_as_sc_mcu7t3v3__inv_2_1422 VSS gf180mcu_as_sc_mcu7t3v3__inv_2_1720/VDD gf180mcu_as_sc_mcu7t3v3__inv_2_1422/Y
+ VSS gf180mcu_as_sc_mcu7t3v3__inv_2_1422/VNW VSUBS gf180mcu_as_sc_mcu7t3v3__inv_2
Xgf180mcu_as_sc_mcu7t3v3__inv_2_1411 gf180mcu_as_sc_mcu7t3v3__inv_2_1457/VSS gf180mcu_as_sc_mcu7t3v3__inv_2_1416/VDD
+ VSS VSS gf180mcu_as_sc_mcu7t3v3__inv_2_1413/VNW VSUBS gf180mcu_as_sc_mcu7t3v3__inv_2
Xgf180mcu_as_sc_mcu7t3v3__inv_2_1455 gf180mcu_as_sc_mcu7t3v3__inv_2_1455/VDD VSS VSS
+ VSS gf180mcu_as_sc_mcu7t3v3__inv_2_1455/VNW VSUBS gf180mcu_as_sc_mcu7t3v3__inv_2
Xgf180mcu_as_sc_mcu7t3v3__inv_2_1444 gf180mcu_as_sc_mcu7t3v3__inv_2_1446/VDD VSS VSS
+ VSS gf180mcu_as_sc_mcu7t3v3__inv_2_1446/VNW VSUBS gf180mcu_as_sc_mcu7t3v3__inv_2
Xgf180mcu_as_sc_mcu7t3v3__inv_2_1433 gf180mcu_as_sc_mcu7t3v3__inv_2_1434/VDD VSS gf180mcu_as_sc_mcu7t3v3__inv_2_1433/Y
+ VSS gf180mcu_as_sc_mcu7t3v3__inv_2_1434/VNW VSUBS gf180mcu_as_sc_mcu7t3v3__inv_2
Xgf180mcu_as_sc_mcu7t3v3__inv_2_917 VSS VSS gf180mcu_as_sc_mcu7t3v3__inv_2_917/Y VSS
+ gf180mcu_as_sc_mcu7t3v3__inv_2_946/VNW VSUBS gf180mcu_as_sc_mcu7t3v3__inv_2
Xgf180mcu_as_sc_mcu7t3v3__inv_2_906 VSS VSS gf180mcu_as_sc_mcu7t3v3__inv_2_906/Y VSS
+ gf180mcu_as_sc_mcu7t3v3__inv_2_952/VNW VSUBS gf180mcu_as_sc_mcu7t3v3__inv_2
Xgf180mcu_as_sc_mcu7t3v3__inv_2_939 VSS VSS VSS VSS gf180mcu_as_sc_mcu7t3v3__inv_2_939/VNW
+ VSUBS gf180mcu_as_sc_mcu7t3v3__inv_2
Xgf180mcu_as_sc_mcu7t3v3__inv_2_928 VSS VSS VSS VSS gf180mcu_as_sc_mcu7t3v3__inv_2_928/VNW
+ VSUBS gf180mcu_as_sc_mcu7t3v3__inv_2
Xu_t003_007 u_t003_007/c0_w0_bl u_t003_007/c0_w0_br u_t003_007/c0_w1_bl u_t003_007/c0_w1_br
+ u_t003_007/c0_r0_rbl u_t003_007/c0_r1_rbl u_t003_007/c1_w0_bl u_t003_007/c1_w0_br
+ u_t003_007/c1_w1_bl u_t003_007/c1_w1_br u_t003_007/c1_r0_rbl u_t003_007/c1_r1_rbl
+ u_t003_007/c2_w0_bl u_t003_007/c2_w0_br u_t003_007/c2_w1_bl u_t003_007/c2_w1_br
+ u_t003_007/c2_r0_rbl u_t003_007/c2_r1_rbl u_t003_007/c3_w0_bl u_t003_007/c3_w0_br
+ u_t003_007/c3_w1_bl u_t003_007/c3_w1_br u_t003_007/c3_r0_rbl u_t003_007/c3_r1_rbl
+ u_t003_007/r0_w0_wl u_t003_007/r0_w1_wl u_t003_007/r0_r0_rwl u_t003_007/r0_r1_rwl
+ u_t003_007/r1_w0_wl u_t003_007/r1_w1_wl u_t003_007/r1_r0_rwl u_t003_007/r1_r1_rwl
+ u_t003_007/r2_w0_wl u_t003_007/r2_w1_wl u_t003_007/r2_r0_rwl u_t003_007/r2_r1_rwl
+ u_t003_007/r3_w0_wl u_t003_007/r3_w1_wl u_t003_007/r3_r0_rwl u_t003_007/r3_r1_rwl
+ VSS u_t003_009/VSS u_t003_007/m2_717_1265# u_t003_007/m2_603_2031# u_t003_007/m2_1290_336#
+ u_t003_007/m2_2000_2037# u_t003_007/m2_791_2909# u_t003_007/m2_7_2126# u_t003_007/m2_2154_2081#
+ u_t003_007/m2_1795_2037# u_t003_007/m2_871_303# u_t003_007/m2_431_438# u_t003_007/m2_1290_2898#
+ u_t003_007/m2_1714_1210# u_t003_007/m2_431_1982# u_t003_007/m2_512_1265# u_t003_007/m2_2573_2126#
+ u_t003_007/m2_603_1259# u_t003_007/m2_2074_2909# u_t003_007/m2_7_336# u_t003_007/m2_717_2037#
+ u_t003_007/m2_1886_2031# u_t003_007/m2_2573_336# u_t003_007/m2_7_2898# u_t003_007/m2_2000_1265#
+ u_t003_007/m2_512_2037# u_t003_007/m2_1795_1265# u_t003_007/m2_1714_1982# u_t003_007/m2_1886_1259#
+ u_t003_007/m2_1290_2126# u_t003_007/m2_1714_438# u_t003_007/m2_431_1210# u_t003_007/m2_2573_2898#
+ u_t003_007/m2_2154_303# u_t003_007/m2_871_2081# VSUBS detronyx_12t_2w2r_rc4_4x4_routed_5layer_direct
Xgf180mcu_as_sc_mcu7t3v3__nand4_2_249 VSS VSS VSS VSS VSS VSS VSS gf180mcu_as_sc_mcu7t3v3__inv_2_857/VNW
+ VSUBS gf180mcu_as_sc_mcu7t3v3__nand4_2
Xgf180mcu_as_sc_mcu7t3v3__nand4_2_227 VSS VSS VSS VSS VSS VSS gf180mcu_as_sc_mcu7t3v3__nand4_2_227/Y
+ gf180mcu_as_sc_mcu7t3v3__inv_2_826/VNW VSUBS gf180mcu_as_sc_mcu7t3v3__nand4_2
Xgf180mcu_as_sc_mcu7t3v3__nand4_2_205 VSS gf180mcu_as_sc_mcu7t3v3__inv_2_664/VDD VSS
+ VSS VSS VSS VSS gf180mcu_as_sc_mcu7t3v3__inv_2_660/VNW VSUBS gf180mcu_as_sc_mcu7t3v3__nand4_2
Xgf180mcu_as_sc_mcu7t3v3__nand4_2_216 VSS VSS VSS VSS VSS VSS gf180mcu_as_sc_mcu7t3v3__nand4_2_216/Y
+ gf180mcu_as_sc_mcu7t3v3__inv_2_830/VNW VSUBS gf180mcu_as_sc_mcu7t3v3__nand4_2
Xgf180mcu_as_sc_mcu7t3v3__nand4_2_238 VSS VSS VSS VSS VSS VSS gf180mcu_as_sc_mcu7t3v3__nand4_2_238/Y
+ gf180mcu_as_sc_mcu7t3v3__inv_2_845/VNW VSUBS gf180mcu_as_sc_mcu7t3v3__nand4_2
Xgf180mcu_as_sc_mcu7t3v3__inv_2_1230 gf180mcu_as_sc_mcu7t3v3__nor2_2_9/VDD gf180mcu_as_sc_mcu7t3v3__nand3_2_63/VSS
+ VSS VSS gf180mcu_as_sc_mcu7t3v3__nor2_2_9/VNW VSUBS gf180mcu_as_sc_mcu7t3v3__inv_2
Xgf180mcu_as_sc_mcu7t3v3__inv_2_1252 gf180mcu_as_sc_mcu7t3v3__nand3_2_65/VDD gf180mcu_as_sc_mcu7t3v3__nor2_2_9/VSS
+ VSS VSS gf180mcu_as_sc_mcu7t3v3__nand3_2_65/VNW VSUBS gf180mcu_as_sc_mcu7t3v3__inv_2
Xgf180mcu_as_sc_mcu7t3v3__inv_2_1241 gf180mcu_as_sc_mcu7t3v3__nand3_2_65/VDD gf180mcu_as_sc_mcu7t3v3__nand3_2_62/VSS
+ VSS VSS gf180mcu_as_sc_mcu7t3v3__nand3_2_65/VNW VSUBS gf180mcu_as_sc_mcu7t3v3__inv_2
Xgf180mcu_as_sc_mcu7t3v3__inv_2_1274 VSS VSS VSS VSS gf180mcu_as_sc_mcu7t3v3__inv_2_1274/VNW
+ VSUBS gf180mcu_as_sc_mcu7t3v3__inv_2
Xgf180mcu_as_sc_mcu7t3v3__inv_2_1285 VSS VSS VSS VSS gf180mcu_as_sc_mcu7t3v3__inv_2_1286/VNW
+ VSUBS gf180mcu_as_sc_mcu7t3v3__inv_2
Xgf180mcu_as_sc_mcu7t3v3__inv_2_1263 VSS VSS VSS VSS gf180mcu_as_sc_mcu7t3v3__inv_2_1263/VNW
+ VSUBS gf180mcu_as_sc_mcu7t3v3__inv_2
Xgf180mcu_as_sc_mcu7t3v3__inv_2_1296 VSS VSS VSS VSS gf180mcu_as_sc_mcu7t3v3__inv_2_1296/VNW
+ VSUBS gf180mcu_as_sc_mcu7t3v3__inv_2
Xgf180mcu_as_sc_mcu7t3v3__inv_2_769 VSS VSS VSS VSS gf180mcu_as_sc_mcu7t3v3__inv_2_824/VNW
+ VSUBS gf180mcu_as_sc_mcu7t3v3__inv_2
Xgf180mcu_as_sc_mcu7t3v3__inv_2_758 VSS VSS VSS VSS gf180mcu_as_sc_mcu7t3v3__inv_2_820/VNW
+ VSUBS gf180mcu_as_sc_mcu7t3v3__inv_2
Xgf180mcu_as_sc_mcu7t3v3__inv_2_747 VSS VSS gf180mcu_as_sc_mcu7t3v3__inv_2_747/Y VSS
+ gf180mcu_as_sc_mcu7t3v3__inv_2_834/VNW VSUBS gf180mcu_as_sc_mcu7t3v3__inv_2
Xgf180mcu_as_sc_mcu7t3v3__inv_2_714 VSS VSS gf180mcu_as_sc_mcu7t3v3__inv_2_714/Y gf180mcu_as_sc_mcu7t3v3__inv_2_722/A
+ gf180mcu_as_sc_mcu7t3v3__inv_2_716/VNW VSUBS gf180mcu_as_sc_mcu7t3v3__inv_2
Xgf180mcu_as_sc_mcu7t3v3__inv_2_703 gf180mcu_as_sc_mcu7t3v3__inv_2_737/VSS gf180mcu_as_sc_mcu7t3v3__inv_2_730/VDD
+ gf180mcu_as_sc_mcu7t3v3__inv_2_703/Y gf180mcu_as_sc_mcu7t3v3__inv_2_704/Y gf180mcu_as_sc_mcu7t3v3__inv_2_704/VNW
+ VSUBS gf180mcu_as_sc_mcu7t3v3__inv_2
Xgf180mcu_as_sc_mcu7t3v3__inv_2_725 gf180mcu_as_sc_mcu7t3v3__inv_2_731/VDD gf180mcu_as_sc_mcu7t3v3__inv_2_741/VDD
+ gf180mcu_as_sc_mcu7t3v3__inv_2_725/Y gf180mcu_as_sc_mcu7t3v3__inv_2_742/A gf180mcu_as_sc_mcu7t3v3__inv_2_731/VNW
+ VSUBS gf180mcu_as_sc_mcu7t3v3__inv_2
Xgf180mcu_as_sc_mcu7t3v3__inv_2_736 VSS VSS gf180mcu_as_sc_mcu7t3v3__inv_2_736/Y VSS
+ gf180mcu_as_sc_mcu7t3v3__inv_2_736/VNW VSUBS gf180mcu_as_sc_mcu7t3v3__inv_2
Xgf180mcu_as_sc_mcu7t3v3__inv_2_1071 VSS gf180mcu_as_sc_mcu7t3v3__inv_2_1075/VDD gf180mcu_as_sc_mcu7t3v3__inv_2_1071/Y
+ VSS gf180mcu_as_sc_mcu7t3v3__inv_2_1071/VNW VSUBS gf180mcu_as_sc_mcu7t3v3__inv_2
Xgf180mcu_as_sc_mcu7t3v3__inv_2_90 gf180mcu_as_sc_mcu7t3v3__inv_2_91/VSS gf180mcu_as_sc_mcu7t3v3__inv_2_97/VDD
+ gf180mcu_as_sc_mcu7t3v3__inv_2_90/Y VSS gf180mcu_as_sc_mcu7t3v3__inv_2_90/VNW VSUBS
+ gf180mcu_as_sc_mcu7t3v3__inv_2
Xgf180mcu_as_sc_mcu7t3v3__inv_2_1060 gf180mcu_as_sc_mcu7t3v3__inv_2_1061/VDD gf180mcu_as_sc_mcu7t3v3__inv_2_964/VDD
+ gf180mcu_as_sc_mcu7t3v3__inv_2_1060/Y gf180mcu_as_sc_mcu7t3v3__inv_2_1061/Y gf180mcu_as_sc_mcu7t3v3__inv_2_1061/VNW
+ VSUBS gf180mcu_as_sc_mcu7t3v3__inv_2
Xgf180mcu_as_sc_mcu7t3v3__inv_2_1082 VSS gf180mcu_as_sc_mcu7t3v3__inv_2_1087/VDD gf180mcu_as_sc_mcu7t3v3__inv_2_1149/A
+ gf180mcu_as_sc_mcu7t3v3__inv_2_1083/Y gf180mcu_as_sc_mcu7t3v3__inv_2_1083/VNW VSUBS
+ gf180mcu_as_sc_mcu7t3v3__inv_2
Xgf180mcu_as_sc_mcu7t3v3__inv_2_1093 VSS VSS VSS gf180mcu_as_sc_mcu7t3v3__inv_2_1101/A
+ gf180mcu_as_sc_mcu7t3v3__inv_2_1095/VNW VSUBS gf180mcu_as_sc_mcu7t3v3__inv_2
Xgf180mcu_as_sc_mcu7t3v3__inv_2_511 VSS VSS gf180mcu_as_sc_mcu7t3v3__inv_2_511/Y VSS
+ gf180mcu_as_sc_mcu7t3v3__inv_2_557/VNW VSUBS gf180mcu_as_sc_mcu7t3v3__inv_2
Xgf180mcu_as_sc_mcu7t3v3__nand4_2_5 gf180mcu_as_sc_mcu7t3v3__inv_2_94/VDD gf180mcu_as_sc_mcu7t3v3__inv_2_94/VDD
+ VSS VSS VSS VSS VSS gf180mcu_as_sc_mcu7t3v3__inv_2_92/VNW VSUBS gf180mcu_as_sc_mcu7t3v3__nand4_2
Xgf180mcu_as_sc_mcu7t3v3__inv_2_500 VSS VSS VSS VSS gf180mcu_as_sc_mcu7t3v3__inv_2_556/VNW
+ VSUBS gf180mcu_as_sc_mcu7t3v3__inv_2
Xgf180mcu_as_sc_mcu7t3v3__inv_2_566 gf180mcu_as_sc_mcu7t3v3__inv_2_590/VSS gf180mcu_as_sc_mcu7t3v3__inv_2_570/VDD
+ gf180mcu_as_sc_mcu7t3v3__inv_2_566/Y gf180mcu_as_sc_mcu7t3v3__inv_2_567/Y gf180mcu_as_sc_mcu7t3v3__inv_2_567/VNW
+ VSUBS gf180mcu_as_sc_mcu7t3v3__inv_2
Xgf180mcu_as_sc_mcu7t3v3__inv_2_588 gf180mcu_as_sc_mcu7t3v3__inv_2_588/VDD gf180mcu_as_sc_mcu7t3v3__inv_2_590/VSS
+ gf180mcu_as_sc_mcu7t3v3__inv_2_588/Y VSS gf180mcu_as_sc_mcu7t3v3__inv_2_588/VNW
+ VSUBS gf180mcu_as_sc_mcu7t3v3__inv_2
Xgf180mcu_as_sc_mcu7t3v3__inv_2_544 VSS VSS VSS VSS gf180mcu_as_sc_mcu7t3v3__inv_2_544/VNW
+ VSUBS gf180mcu_as_sc_mcu7t3v3__inv_2
Xgf180mcu_as_sc_mcu7t3v3__inv_2_577 gf180mcu_as_sc_mcu7t3v3__inv_2_579/VDD gf180mcu_as_sc_mcu7t3v3__inv_2_584/VDD
+ gf180mcu_as_sc_mcu7t3v3__inv_2_577/Y VSS gf180mcu_as_sc_mcu7t3v3__inv_2_579/VNW
+ VSUBS gf180mcu_as_sc_mcu7t3v3__inv_2
Xgf180mcu_as_sc_mcu7t3v3__inv_2_522 gf180mcu_as_sc_mcu7t3v3__nor2_2_7/VDD gf180mcu_as_sc_mcu7t3v3__nand3_2_4/VSS
+ VSS VSS gf180mcu_as_sc_mcu7t3v3__nor2_2_7/VNW VSUBS gf180mcu_as_sc_mcu7t3v3__inv_2
Xgf180mcu_as_sc_mcu7t3v3__inv_2_533 gf180mcu_as_sc_mcu7t3v3__nor2_2_7/VDD gf180mcu_as_sc_mcu7t3v3__nor2_2_7/VSS
+ VSS VSS gf180mcu_as_sc_mcu7t3v3__nor2_2_7/VNW VSUBS gf180mcu_as_sc_mcu7t3v3__inv_2
Xgf180mcu_as_sc_mcu7t3v3__inv_2_599 VSS gf180mcu_as_sc_mcu7t3v3__inv_2_607/VDD gf180mcu_as_sc_mcu7t3v3__inv_2_638/A
+ gf180mcu_as_sc_mcu7t3v3__inv_2_603/Y gf180mcu_as_sc_mcu7t3v3__inv_2_603/VNW VSUBS
+ gf180mcu_as_sc_mcu7t3v3__inv_2
Xgf180mcu_as_sc_mcu7t3v3__inv_2_555 VSS VSS VSS VSS gf180mcu_as_sc_mcu7t3v3__inv_2_555/VNW
+ VSUBS gf180mcu_as_sc_mcu7t3v3__inv_2
Xgf180mcu_as_sc_mcu7t3v3__inv_2_352 VSS VSS gf180mcu_as_sc_mcu7t3v3__inv_2_359/Y gf180mcu_as_sc_mcu7t3v3__inv_2_359/Y
+ gf180mcu_as_sc_mcu7t3v3__inv_2_353/VNW VSUBS gf180mcu_as_sc_mcu7t3v3__inv_2
Xgf180mcu_as_sc_mcu7t3v3__inv_2_341 gf180mcu_as_sc_mcu7t3v3__inv_2_341/VDD VSS gf180mcu_as_sc_mcu7t3v3__inv_2_341/Y
+ VSS gf180mcu_as_sc_mcu7t3v3__inv_2_341/VNW VSUBS gf180mcu_as_sc_mcu7t3v3__inv_2
Xgf180mcu_as_sc_mcu7t3v3__inv_2_330 gf180mcu_as_sc_mcu7t3v3__inv_2_332/VDD VSS VSS
+ gf180mcu_as_sc_mcu7t3v3__inv_2_341/Y gf180mcu_as_sc_mcu7t3v3__inv_2_332/VNW VSUBS
+ gf180mcu_as_sc_mcu7t3v3__inv_2
Xgf180mcu_as_sc_mcu7t3v3__inv_2_396 gf180mcu_as_sc_mcu7t3v3__nand3_2_9/VDD gf180mcu_as_sc_mcu7t3v3__nor2_2_4/VSS
+ VSS VSS gf180mcu_as_sc_mcu7t3v3__nand3_2_9/VNW VSUBS gf180mcu_as_sc_mcu7t3v3__inv_2
Xgf180mcu_as_sc_mcu7t3v3__inv_2_385 gf180mcu_as_sc_mcu7t3v3__nor2_2_4/VDD gf180mcu_as_sc_mcu7t3v3__nor2_2_4/VSS
+ VSS VSS gf180mcu_as_sc_mcu7t3v3__nor2_2_4/VNW VSUBS gf180mcu_as_sc_mcu7t3v3__inv_2
Xgf180mcu_as_sc_mcu7t3v3__inv_2_374 gf180mcu_as_sc_mcu7t3v3__nand3_2_9/VDD gf180mcu_as_sc_mcu7t3v3__nor2_2_7/VSS
+ gf180mcu_as_sc_mcu7t3v3__inv_2_374/Y VSS gf180mcu_as_sc_mcu7t3v3__nand3_2_9/VNW
+ VSUBS gf180mcu_as_sc_mcu7t3v3__inv_2
Xgf180mcu_as_sc_mcu7t3v3__inv_2_363 gf180mcu_as_sc_mcu7t3v3__inv_2_365/VDD gf180mcu_as_sc_mcu7t3v3__inv_2_365/VSS
+ VSS gf180mcu_as_sc_mcu7t3v3__inv_2_365/Y gf180mcu_as_sc_mcu7t3v3__inv_2_365/VNW
+ VSUBS gf180mcu_as_sc_mcu7t3v3__inv_2
Xu_t027_013 u_t027_013/c0_w0_bl u_t027_013/c0_w0_br u_t027_013/c0_w1_bl u_t027_013/c0_w1_br
+ u_t027_013/c0_r0_rbl u_t027_013/c0_r1_rbl u_t027_013/c1_w0_bl u_t027_013/c1_w0_br
+ u_t027_013/c1_w1_bl u_t027_013/c1_w1_br u_t027_013/c1_r0_rbl u_t027_013/c1_r1_rbl
+ u_t027_013/c2_w0_bl u_t027_013/c2_w0_br u_t027_013/c2_w1_bl u_t027_013/c2_w1_br
+ u_t027_013/c2_r0_rbl u_t027_013/c2_r1_rbl u_t027_013/c3_w0_bl u_t027_013/c3_w0_br
+ u_t027_013/c3_w1_bl u_t027_013/c3_w1_br u_t027_013/c3_r0_rbl u_t027_013/c3_r1_rbl
+ u_t027_013/r0_w0_wl u_t027_013/r0_w1_wl u_t027_013/r0_r0_rwl u_t027_013/r0_r1_rwl
+ u_t027_013/r1_w0_wl u_t027_013/r1_w1_wl u_t027_013/r1_r0_rwl u_t027_013/r1_r1_rwl
+ u_t027_013/r2_w0_wl u_t027_013/r2_w1_wl u_t027_013/r2_r0_rwl u_t027_013/r2_r1_rwl
+ u_t027_013/r3_w0_wl u_t027_013/r3_w1_wl u_t027_013/r3_r0_rwl u_t027_013/r3_r1_rwl
+ u_t027_013/VDD u_t027_013/VSS u_t027_013/m2_717_1265# u_t027_013/m2_603_2031# u_t027_013/m2_1290_336#
+ u_t027_013/m2_2000_2037# u_t027_013/m2_791_2909# u_t027_013/m2_7_2126# u_t027_013/m2_2154_2081#
+ u_t027_013/m2_1795_2037# u_t027_013/m2_871_303# u_t027_013/m2_431_438# u_t027_013/m2_1290_2898#
+ u_t027_013/m2_1714_1210# u_t027_013/m2_431_1982# u_t027_013/m2_512_1265# u_t027_013/m2_2573_2126#
+ u_t027_013/m2_603_1259# u_t027_013/m2_2074_2909# u_t027_013/m2_7_336# u_t027_013/m2_717_2037#
+ u_t027_013/m2_1886_2031# u_t027_013/m2_2573_336# u_t027_013/m2_7_2898# u_t027_013/m2_2000_1265#
+ u_t027_013/m2_512_2037# u_t027_013/m2_1795_1265# u_t027_013/m2_1714_1982# u_t027_013/m2_1886_1259#
+ u_t027_013/m2_1290_2126# u_t027_013/m2_1714_438# u_t027_013/m2_431_1210# u_t027_013/m2_2573_2898#
+ u_t027_013/m2_2154_303# u_t027_013/m2_871_2081# VSUBS detronyx_12t_2w2r_rc4_4x4_routed_5layer_direct
Xu_t027_002 u_t027_002/c0_w0_bl u_t027_002/c0_w0_br u_t027_002/c0_w1_bl u_t027_002/c0_w1_br
+ u_t027_002/c0_r0_rbl u_t027_002/c0_r1_rbl u_t027_002/c1_w0_bl u_t027_002/c1_w0_br
+ u_t027_002/c1_w1_bl u_t027_002/c1_w1_br u_t027_002/c1_r0_rbl u_t027_002/c1_r1_rbl
+ u_t027_002/c2_w0_bl u_t027_002/c2_w0_br u_t027_002/c2_w1_bl u_t027_002/c2_w1_br
+ u_t027_002/c2_r0_rbl u_t027_002/c2_r1_rbl u_t027_002/c3_w0_bl u_t027_002/c3_w0_br
+ u_t027_002/c3_w1_bl u_t027_002/c3_w1_br u_t027_002/c3_r0_rbl u_t027_002/c3_r1_rbl
+ u_t027_002/r0_w0_wl u_t027_002/r0_w1_wl u_t027_002/r0_r0_rwl u_t027_002/r0_r1_rwl
+ u_t027_002/r1_w0_wl u_t027_002/r1_w1_wl u_t027_002/r1_r0_rwl u_t027_002/r1_r1_rwl
+ u_t027_002/r2_w0_wl u_t027_002/r2_w1_wl u_t027_002/r2_r0_rwl u_t027_002/r2_r1_rwl
+ u_t027_002/r3_w0_wl u_t027_002/r3_w1_wl u_t027_002/r3_r0_rwl u_t027_002/r3_r1_rwl
+ VSS VSS u_t027_002/m2_717_1265# u_t027_002/m2_603_2031# u_t027_002/m2_1290_336#
+ u_t027_002/m2_2000_2037# u_t027_002/m2_791_2909# u_t027_002/m2_7_2126# u_t027_002/m2_2154_2081#
+ u_t027_002/m2_1795_2037# u_t027_002/m2_871_303# u_t027_002/m2_431_438# u_t027_002/m2_1290_2898#
+ u_t027_002/m2_1714_1210# u_t027_002/m2_431_1982# u_t027_002/m2_512_1265# u_t027_002/m2_2573_2126#
+ u_t027_002/m2_603_1259# u_t027_002/m2_2074_2909# u_t027_002/m2_7_336# u_t027_002/m2_717_2037#
+ u_t027_002/m2_1886_2031# u_t027_002/m2_2573_336# u_t027_002/m2_7_2898# u_t027_002/m2_2000_1265#
+ u_t027_002/m2_512_2037# u_t027_002/m2_1795_1265# u_t027_002/m2_1714_1982# u_t027_002/m2_1886_1259#
+ u_t027_002/m2_1290_2126# u_t027_002/m2_1714_438# u_t027_002/m2_431_1210# u_t027_002/m2_2573_2898#
+ u_t027_002/m2_2154_303# u_t027_002/m2_871_2081# VSUBS detronyx_12t_2w2r_rc4_4x4_routed_5layer_direct
Xu_t018_013 u_t018_013/c0_w0_bl u_t018_013/c0_w0_br u_t018_013/c0_w1_bl u_t018_013/c0_w1_br
+ u_t018_013/c0_r0_rbl u_t018_013/c0_r1_rbl u_t018_013/c1_w0_bl u_t018_013/c1_w0_br
+ u_t018_013/c1_w1_bl u_t018_013/c1_w1_br u_t018_013/c1_r0_rbl u_t018_013/c1_r1_rbl
+ u_t018_013/c2_w0_bl u_t018_013/c2_w0_br u_t018_013/c2_w1_bl u_t018_013/c2_w1_br
+ u_t018_013/c2_r0_rbl u_t018_013/c2_r1_rbl u_t018_013/c3_w0_bl u_t018_013/c3_w0_br
+ u_t018_013/c3_w1_bl u_t018_013/c3_w1_br u_t018_013/c3_r0_rbl u_t018_013/c3_r1_rbl
+ u_t018_013/r0_w0_wl u_t018_013/r0_w1_wl u_t018_013/r0_r0_rwl u_t018_013/r0_r1_rwl
+ u_t018_013/r1_w0_wl u_t018_013/r1_w1_wl u_t018_013/r1_r0_rwl u_t018_013/r1_r1_rwl
+ u_t018_013/r2_w0_wl u_t018_013/r2_w1_wl u_t018_013/r2_r0_rwl u_t018_013/r2_r1_rwl
+ u_t018_013/r3_w0_wl u_t018_013/r3_w1_wl u_t018_013/r3_r0_rwl u_t018_013/r3_r1_rwl
+ u_t018_013/VDD u_t018_013/VSS u_t018_013/m2_717_1265# u_t018_013/m2_603_2031# u_t018_013/m2_1290_336#
+ u_t018_013/m2_2000_2037# u_t018_013/m2_791_2909# u_t018_013/m2_7_2126# u_t018_013/m2_2154_2081#
+ u_t018_013/m2_1795_2037# u_t018_013/m2_871_303# u_t018_013/m2_431_438# u_t018_013/m2_1290_2898#
+ u_t018_013/m2_1714_1210# u_t018_013/m2_431_1982# u_t018_013/m2_512_1265# u_t018_013/m2_2573_2126#
+ u_t018_013/m2_603_1259# u_t018_013/m2_2074_2909# u_t018_013/m2_7_336# u_t018_013/m2_717_2037#
+ u_t018_013/m2_1886_2031# u_t018_013/m2_2573_336# u_t018_013/m2_7_2898# u_t018_013/m2_2000_1265#
+ u_t018_013/m2_512_2037# u_t018_013/m2_1795_1265# u_t018_013/m2_1714_1982# u_t018_013/m2_1886_1259#
+ u_t018_013/m2_1290_2126# u_t018_013/m2_1714_438# u_t018_013/m2_431_1210# u_t018_013/m2_2573_2898#
+ u_t018_013/m2_2154_303# u_t018_013/m2_871_2081# VSUBS detronyx_12t_2w2r_rc4_4x4_routed_5layer_direct
Xu_t018_002 u_t018_002/c0_w0_bl u_t018_002/c0_w0_br u_t018_002/c0_w1_bl u_t018_002/c0_w1_br
+ u_t018_002/c0_r0_rbl u_t018_002/c0_r1_rbl u_t018_002/c1_w0_bl u_t018_002/c1_w0_br
+ u_t018_002/c1_w1_bl u_t018_002/c1_w1_br u_t018_002/c1_r0_rbl u_t018_002/c1_r1_rbl
+ u_t018_002/c2_w0_bl u_t018_002/c2_w0_br u_t018_002/c2_w1_bl u_t018_002/c2_w1_br
+ u_t018_002/c2_r0_rbl u_t018_002/c2_r1_rbl u_t018_002/c3_w0_bl u_t018_002/c3_w0_br
+ u_t018_002/c3_w1_bl u_t018_002/c3_w1_br u_t018_002/c3_r0_rbl u_t018_002/c3_r1_rbl
+ u_t018_002/r0_w0_wl u_t018_002/r0_w1_wl u_t018_002/r0_r0_rwl u_t018_002/r0_r1_rwl
+ u_t018_002/r1_w0_wl u_t018_002/r1_w1_wl u_t018_002/r1_r0_rwl u_t018_002/r1_r1_rwl
+ u_t018_002/r2_w0_wl u_t018_002/r2_w1_wl u_t018_002/r2_r0_rwl u_t018_002/r2_r1_rwl
+ u_t018_002/r3_w0_wl u_t018_002/r3_w1_wl u_t018_002/r3_r0_rwl u_t018_002/r3_r1_rwl
+ VSS VSS u_t018_002/m2_717_1265# u_t018_002/m2_603_2031# u_t018_002/m2_1290_336#
+ u_t018_002/m2_2000_2037# u_t018_002/m2_791_2909# u_t018_002/m2_7_2126# u_t018_002/m2_2154_2081#
+ u_t018_002/m2_1795_2037# u_t018_002/m2_871_303# u_t018_002/m2_431_438# u_t018_002/m2_1290_2898#
+ u_t018_002/m2_1714_1210# u_t018_002/m2_431_1982# u_t018_002/m2_512_1265# u_t018_002/m2_2573_2126#
+ u_t018_002/m2_603_1259# u_t018_002/m2_2074_2909# u_t018_002/m2_7_336# u_t018_002/m2_717_2037#
+ u_t018_002/m2_1886_2031# u_t018_002/m2_2573_336# u_t018_002/m2_7_2898# u_t018_002/m2_2000_1265#
+ u_t018_002/m2_512_2037# u_t018_002/m2_1795_1265# u_t018_002/m2_1714_1982# u_t018_002/m2_1886_1259#
+ u_t018_002/m2_1290_2126# u_t018_002/m2_1714_438# u_t018_002/m2_431_1210# u_t018_002/m2_2573_2898#
+ u_t018_002/m2_2154_303# u_t018_002/m2_871_2081# VSUBS detronyx_12t_2w2r_rc4_4x4_routed_5layer_direct
Xu_t009_013 u_t009_013/c0_w0_bl u_t009_013/c0_w0_br u_t009_013/c0_w1_bl u_t009_013/c0_w1_br
+ u_t009_013/c0_r0_rbl u_t009_013/c0_r1_rbl u_t009_013/c1_w0_bl u_t009_013/c1_w0_br
+ u_t009_013/c1_w1_bl u_t009_013/c1_w1_br u_t009_013/c1_r0_rbl u_t009_013/c1_r1_rbl
+ u_t009_013/c2_w0_bl u_t009_013/c2_w0_br u_t009_013/c2_w1_bl u_t009_013/c2_w1_br
+ u_t009_013/c2_r0_rbl u_t009_013/c2_r1_rbl u_t009_013/c3_w0_bl u_t009_013/c3_w0_br
+ u_t009_013/c3_w1_bl u_t009_013/c3_w1_br u_t009_013/c3_r0_rbl u_t009_013/c3_r1_rbl
+ u_t009_013/r0_w0_wl u_t009_013/r0_w1_wl u_t009_013/r0_r0_rwl u_t009_013/r0_r1_rwl
+ u_t009_013/r1_w0_wl u_t009_013/r1_w1_wl u_t009_013/r1_r0_rwl u_t009_013/r1_r1_rwl
+ u_t009_013/r2_w0_wl u_t009_013/r2_w1_wl u_t009_013/r2_r0_rwl u_t009_013/r2_r1_rwl
+ u_t009_013/r3_w0_wl u_t009_013/r3_w1_wl u_t009_013/r3_r0_rwl u_t009_013/r3_r1_rwl
+ u_t009_013/VDD VSS u_t009_013/m2_717_1265# u_t009_013/m2_603_2031# u_t009_013/m2_1290_336#
+ u_t009_013/m2_2000_2037# u_t009_013/m2_791_2909# u_t009_013/m2_7_2126# u_t009_013/m2_2154_2081#
+ u_t009_013/m2_1795_2037# u_t009_013/m2_871_303# u_t009_013/m2_431_438# u_t009_013/m2_1290_2898#
+ u_t009_013/m2_1714_1210# u_t009_013/m2_431_1982# u_t009_013/m2_512_1265# u_t009_013/m2_2573_2126#
+ u_t009_013/m2_603_1259# u_t009_013/m2_2074_2909# u_t009_013/m2_7_336# u_t009_013/m2_717_2037#
+ u_t009_013/m2_1886_2031# u_t009_013/m2_2573_336# u_t009_013/m2_7_2898# u_t009_013/m2_2000_1265#
+ u_t009_013/m2_512_2037# u_t009_013/m2_1795_1265# u_t009_013/m2_1714_1982# u_t009_013/m2_1886_1259#
+ u_t009_013/m2_1290_2126# u_t009_013/m2_1714_438# u_t009_013/m2_431_1210# u_t009_013/m2_2573_2898#
+ u_t009_013/m2_2154_303# u_t009_013/m2_871_2081# VSUBS detronyx_12t_2w2r_rc4_4x4_routed_5layer_direct
Xu_t009_002 u_t009_002/c0_w0_bl u_t009_002/c0_w0_br u_t009_002/c0_w1_bl u_t009_002/c0_w1_br
+ u_t009_002/c0_r0_rbl u_t009_002/c0_r1_rbl u_t009_002/c1_w0_bl u_t009_002/c1_w0_br
+ u_t009_002/c1_w1_bl u_t009_002/c1_w1_br u_t009_002/c1_r0_rbl u_t009_002/c1_r1_rbl
+ u_t009_002/c2_w0_bl u_t009_002/c2_w0_br u_t009_002/c2_w1_bl u_t009_002/c2_w1_br
+ u_t009_002/c2_r0_rbl u_t009_002/c2_r1_rbl u_t009_002/c3_w0_bl u_t009_002/c3_w0_br
+ u_t009_002/c3_w1_bl u_t009_002/c3_w1_br u_t009_002/c3_r0_rbl u_t009_002/c3_r1_rbl
+ u_t009_002/r0_w0_wl u_t009_002/r0_w1_wl u_t009_002/r0_r0_rwl u_t009_002/r0_r1_rwl
+ u_t009_002/r1_w0_wl u_t009_002/r1_w1_wl u_t009_002/r1_r0_rwl u_t009_002/r1_r1_rwl
+ u_t009_002/r2_w0_wl u_t009_002/r2_w1_wl u_t009_002/r2_r0_rwl u_t009_002/r2_r1_rwl
+ u_t009_002/r3_w0_wl u_t009_002/r3_w1_wl u_t009_002/r3_r0_rwl u_t009_002/r3_r1_rwl
+ VSS VSS u_t009_002/m2_717_1265# u_t009_002/m2_603_2031# u_t009_002/m2_1290_336#
+ u_t009_002/m2_2000_2037# u_t009_002/m2_791_2909# u_t009_002/m2_7_2126# u_t009_002/m2_2154_2081#
+ u_t009_002/m2_1795_2037# u_t009_002/m2_871_303# u_t009_002/m2_431_438# u_t009_002/m2_1290_2898#
+ u_t009_002/m2_1714_1210# u_t009_002/m2_431_1982# u_t009_002/m2_512_1265# u_t009_002/m2_2573_2126#
+ u_t009_002/m2_603_1259# u_t009_002/m2_2074_2909# u_t009_002/m2_7_336# u_t009_002/m2_717_2037#
+ u_t009_002/m2_1886_2031# u_t009_002/m2_2573_336# u_t009_002/m2_7_2898# u_t009_002/m2_2000_1265#
+ u_t009_002/m2_512_2037# u_t009_002/m2_1795_1265# u_t009_002/m2_1714_1982# u_t009_002/m2_1886_1259#
+ u_t009_002/m2_1290_2126# u_t009_002/m2_1714_438# u_t009_002/m2_431_1210# u_t009_002/m2_2573_2898#
+ u_t009_002/m2_2154_303# u_t009_002/m2_871_2081# VSUBS detronyx_12t_2w2r_rc4_4x4_routed_5layer_direct
Xgf180mcu_as_sc_mcu7t3v3__nand3_2_17 gf180mcu_as_sc_mcu7t3v3__nor2_2_6/VDD gf180mcu_as_sc_mcu7t3v3__nor2_2_6/VSS
+ VSS VSS VSS VSS gf180mcu_as_sc_mcu7t3v3__nor2_2_6/VNW VSUBS gf180mcu_as_sc_mcu7t3v3__nand3_2
Xgf180mcu_as_sc_mcu7t3v3__nand3_2_28 gf180mcu_as_sc_mcu7t3v3__nor2_2_7/VDD gf180mcu_as_sc_mcu7t3v3__nor2_2_7/VSS
+ VSS VSS VSS VSS gf180mcu_as_sc_mcu7t3v3__nor2_2_7/VNW VSUBS gf180mcu_as_sc_mcu7t3v3__nand3_2
Xu_t024_005 u_t024_005/c0_w0_bl u_t024_005/c0_w0_br u_t024_005/c0_w1_bl u_t024_005/c0_w1_br
+ u_t024_005/c0_r0_rbl u_t024_005/c0_r1_rbl u_t024_005/c1_w0_bl u_t024_005/c1_w0_br
+ u_t024_005/c1_w1_bl u_t024_005/c1_w1_br u_t024_005/c1_r0_rbl u_t024_005/c1_r1_rbl
+ u_t024_005/c2_w0_bl u_t024_005/c2_w0_br u_t024_005/c2_w1_bl u_t024_005/c2_w1_br
+ u_t024_005/c2_r0_rbl u_t024_005/c2_r1_rbl u_t024_005/c3_w0_bl u_t024_005/c3_w0_br
+ u_t024_005/c3_w1_bl u_t024_005/c3_w1_br u_t024_005/c3_r0_rbl u_t024_005/c3_r1_rbl
+ u_t024_005/r0_w0_wl u_t024_005/r0_w1_wl u_t024_005/r0_r0_rwl u_t024_005/r0_r1_rwl
+ u_t024_005/r1_w0_wl u_t024_005/r1_w1_wl u_t024_005/r1_r0_rwl u_t024_005/r1_r1_rwl
+ u_t024_005/r2_w0_wl u_t024_005/r2_w1_wl u_t024_005/r2_r0_rwl u_t024_005/r2_r1_rwl
+ u_t024_005/r3_w0_wl u_t024_005/r3_w1_wl u_t024_005/r3_r0_rwl u_t024_005/r3_r1_rwl
+ u_t025_005/VDD u_t024_005/VSS u_t024_005/m2_717_1265# u_t024_005/m2_603_2031# u_t024_005/m2_1290_336#
+ u_t024_005/m2_2000_2037# u_t024_005/m2_791_2909# u_t024_005/m2_7_2126# u_t024_005/m2_2154_2081#
+ u_t024_005/m2_1795_2037# u_t024_005/m2_871_303# u_t024_005/m2_431_438# u_t024_005/m2_1290_2898#
+ u_t024_005/m2_1714_1210# u_t024_005/m2_431_1982# u_t024_005/m2_512_1265# u_t024_005/m2_2573_2126#
+ u_t024_005/m2_603_1259# u_t024_005/m2_2074_2909# u_t024_005/m2_7_336# u_t024_005/m2_717_2037#
+ u_t024_005/m2_1886_2031# u_t024_005/m2_2573_336# u_t024_005/m2_7_2898# u_t024_005/m2_2000_1265#
+ u_t024_005/m2_512_2037# u_t024_005/m2_1795_1265# u_t024_005/m2_1714_1982# u_t024_005/m2_1886_1259#
+ u_t024_005/m2_1290_2126# u_t024_005/m2_1714_438# u_t024_005/m2_431_1210# u_t024_005/m2_2573_2898#
+ u_t024_005/m2_2154_303# u_t024_005/m2_871_2081# VSUBS detronyx_12t_2w2r_rc4_4x4_routed_5layer_direct
Xgf180mcu_as_sc_mcu7t3v3__nand3_2_39 gf180mcu_as_sc_mcu7t3v3__nor2_2_7/VDD gf180mcu_as_sc_mcu7t3v3__nor2_2_7/VSS
+ VSS VSS VSS VSS gf180mcu_as_sc_mcu7t3v3__nor2_2_7/VNW VSUBS gf180mcu_as_sc_mcu7t3v3__nand3_2
Xgf180mcu_as_sc_mcu7t3v3__inv_2_182 gf180mcu_as_sc_mcu7t3v3__inv_2_182/VDD gf180mcu_as_sc_mcu7t3v3__inv_2_371/VDD
+ gf180mcu_as_sc_mcu7t3v3__inv_2_182/Y VSS gf180mcu_as_sc_mcu7t3v3__inv_2_182/VNW
+ VSUBS gf180mcu_as_sc_mcu7t3v3__inv_2
Xgf180mcu_as_sc_mcu7t3v3__inv_2_171 gf180mcu_as_sc_mcu7t3v3__inv_2_171/VDD VSS gf180mcu_as_sc_mcu7t3v3__inv_2_171/Y
+ VSS gf180mcu_as_sc_mcu7t3v3__inv_2_171/VNW VSUBS gf180mcu_as_sc_mcu7t3v3__inv_2
Xgf180mcu_as_sc_mcu7t3v3__inv_2_193 gf180mcu_as_sc_mcu7t3v3__inv_2_193/VDD VSS gf180mcu_as_sc_mcu7t3v3__inv_2_193/Y
+ VSS gf180mcu_as_sc_mcu7t3v3__inv_2_193/VNW VSUBS gf180mcu_as_sc_mcu7t3v3__inv_2
Xgf180mcu_as_sc_mcu7t3v3__inv_2_160 gf180mcu_as_sc_mcu7t3v3__inv_2_177/VSS gf180mcu_as_sc_mcu7t3v3__inv_2_163/VDD
+ gf180mcu_as_sc_mcu7t3v3__inv_2_160/Y VSS gf180mcu_as_sc_mcu7t3v3__inv_2_160/VNW
+ VSUBS gf180mcu_as_sc_mcu7t3v3__inv_2
Xgf180mcu_as_sc_mcu7t3v3__inv_2_1637 gf180mcu_as_sc_mcu7t3v3__inv_2_1638/VDD VSS gf180mcu_as_sc_mcu7t3v3__inv_2_1689/A
+ gf180mcu_as_sc_mcu7t3v3__inv_2_1689/A gf180mcu_as_sc_mcu7t3v3__inv_2_1638/VNW VSUBS
+ gf180mcu_as_sc_mcu7t3v3__inv_2
Xgf180mcu_as_sc_mcu7t3v3__inv_2_1615 gf180mcu_as_sc_mcu7t3v3__inv_2_1685/VDD VSS gf180mcu_as_sc_mcu7t3v3__inv_2_1615/Y
+ gf180mcu_as_sc_mcu7t3v3__inv_2_1685/A gf180mcu_as_sc_mcu7t3v3__inv_2_1685/VNW VSUBS
+ gf180mcu_as_sc_mcu7t3v3__inv_2
Xgf180mcu_as_sc_mcu7t3v3__inv_2_1604 VSS gf180mcu_as_sc_mcu7t3v3__inv_2_1614/VDD VSS
+ gf180mcu_as_sc_mcu7t3v3__inv_2_1669/A gf180mcu_as_sc_mcu7t3v3__inv_2_1606/VNW VSUBS
+ gf180mcu_as_sc_mcu7t3v3__inv_2
Xgf180mcu_as_sc_mcu7t3v3__inv_2_1648 gf180mcu_as_sc_mcu7t3v3__inv_2_1648/VDD VSS gf180mcu_as_sc_mcu7t3v3__inv_2_1669/A
+ VSS gf180mcu_as_sc_mcu7t3v3__inv_2_1648/VNW VSUBS gf180mcu_as_sc_mcu7t3v3__inv_2
Xgf180mcu_as_sc_mcu7t3v3__inv_2_1626 gf180mcu_as_sc_mcu7t3v3__inv_2_1626/VDD gf180mcu_as_sc_mcu7t3v3__inv_2_1648/VDD
+ gf180mcu_as_sc_mcu7t3v3__inv_2_1669/A VSS gf180mcu_as_sc_mcu7t3v3__inv_2_1626/VNW
+ VSUBS gf180mcu_as_sc_mcu7t3v3__inv_2
Xgf180mcu_as_sc_mcu7t3v3__inv_2_1659 gf180mcu_as_sc_mcu7t3v3__inv_2_1660/VDD VSS gf180mcu_as_sc_mcu7t3v3__inv_2_1659/Y
+ gf180mcu_as_sc_mcu7t3v3__inv_2_1669/A gf180mcu_as_sc_mcu7t3v3__inv_2_1660/VNW VSUBS
+ gf180mcu_as_sc_mcu7t3v3__inv_2
Xu_t015_005 u_t015_005/c0_w0_bl u_t015_005/c0_w0_br u_t015_005/c0_w1_bl u_t015_005/c0_w1_br
+ u_t015_005/c0_r0_rbl u_t015_005/c0_r1_rbl u_t015_005/c1_w0_bl u_t015_005/c1_w0_br
+ u_t015_005/c1_w1_bl u_t015_005/c1_w1_br u_t015_005/c1_r0_rbl u_t015_005/c1_r1_rbl
+ u_t015_005/c2_w0_bl u_t015_005/c2_w0_br u_t015_005/c2_w1_bl u_t015_005/c2_w1_br
+ u_t015_005/c2_r0_rbl u_t015_005/c2_r1_rbl u_t015_005/c3_w0_bl u_t015_005/c3_w0_br
+ u_t015_005/c3_w1_bl u_t015_005/c3_w1_br u_t015_005/c3_r0_rbl u_t015_005/c3_r1_rbl
+ u_t015_005/r0_w0_wl u_t015_005/r0_w1_wl u_t015_005/r0_r0_rwl u_t015_005/r0_r1_rwl
+ u_t015_005/r1_w0_wl u_t015_005/r1_w1_wl u_t015_005/r1_r0_rwl u_t015_005/r1_r1_rwl
+ u_t015_005/r2_w0_wl u_t015_005/r2_w1_wl u_t015_005/r2_r0_rwl u_t015_005/r2_r1_rwl
+ u_t015_005/r3_w0_wl u_t015_005/r3_w1_wl u_t015_005/r3_r0_rwl u_t015_005/r3_r1_rwl
+ u_t015_005/VDD u_t015_005/VSS u_t015_005/m2_717_1265# u_t015_005/m2_603_2031# u_t015_005/m2_1290_336#
+ u_t015_005/m2_2000_2037# u_t015_005/m2_791_2909# u_t015_005/m2_7_2126# u_t015_005/m2_2154_2081#
+ u_t015_005/m2_1795_2037# u_t015_005/m2_871_303# u_t015_005/m2_431_438# u_t015_005/m2_1290_2898#
+ u_t015_005/m2_1714_1210# u_t015_005/m2_431_1982# u_t015_005/m2_512_1265# u_t015_005/m2_2573_2126#
+ u_t015_005/m2_603_1259# u_t015_005/m2_2074_2909# u_t015_005/m2_7_336# u_t015_005/m2_717_2037#
+ u_t015_005/m2_1886_2031# u_t015_005/m2_2573_336# u_t015_005/m2_7_2898# u_t015_005/m2_2000_1265#
+ u_t015_005/m2_512_2037# u_t015_005/m2_1795_1265# u_t015_005/m2_1714_1982# u_t015_005/m2_1886_1259#
+ u_t015_005/m2_1290_2126# u_t015_005/m2_1714_438# u_t015_005/m2_431_1210# u_t015_005/m2_2573_2898#
+ u_t015_005/m2_2154_303# u_t015_005/m2_871_2081# VSUBS detronyx_12t_2w2r_rc4_4x4_routed_5layer_direct
Xu_t030_008 u_t030_008/c0_w0_bl u_t030_008/c0_w0_br u_t030_008/c0_w1_bl u_t030_008/c0_w1_br
+ u_t030_008/c0_r0_rbl u_t030_008/c0_r1_rbl u_t030_008/c1_w0_bl u_t030_008/c1_w0_br
+ u_t030_008/c1_w1_bl u_t030_008/c1_w1_br u_t030_008/c1_r0_rbl u_t030_008/c1_r1_rbl
+ u_t030_008/c2_w0_bl u_t030_008/c2_w0_br u_t030_008/c2_w1_bl u_t030_008/c2_w1_br
+ u_t030_008/c2_r0_rbl u_t030_008/c2_r1_rbl u_t030_008/c3_w0_bl u_t030_008/c3_w0_br
+ u_t030_008/c3_w1_bl u_t030_008/c3_w1_br u_t030_008/c3_r0_rbl u_t030_008/c3_r1_rbl
+ u_t030_008/r0_w0_wl u_t030_008/r0_w1_wl u_t030_008/r0_r0_rwl u_t030_008/r0_r1_rwl
+ u_t030_008/r1_w0_wl u_t030_008/r1_w1_wl u_t030_008/r1_r0_rwl u_t030_008/r1_r1_rwl
+ u_t030_008/r2_w0_wl u_t030_008/r2_w1_wl u_t030_008/r2_r0_rwl u_t030_008/r2_r1_rwl
+ u_t030_008/r3_w0_wl u_t030_008/r3_w1_wl u_t030_008/r3_r0_rwl u_t030_008/r3_r1_rwl
+ VSS VSS u_t030_008/m2_717_1265# u_t030_008/m2_603_2031# u_t030_008/m2_1290_336#
+ u_t030_008/m2_2000_2037# u_t030_008/m2_791_2909# u_t030_008/m2_7_2126# u_t030_008/m2_2154_2081#
+ u_t030_008/m2_1795_2037# u_t030_008/m2_871_303# u_t030_008/m2_431_438# u_t030_008/m2_1290_2898#
+ u_t030_008/m2_1714_1210# u_t030_008/m2_431_1982# u_t030_008/m2_512_1265# u_t030_008/m2_2573_2126#
+ u_t030_008/m2_603_1259# u_t030_008/m2_2074_2909# u_t030_008/m2_7_336# u_t030_008/m2_717_2037#
+ u_t030_008/m2_1886_2031# u_t030_008/m2_2573_336# u_t030_008/m2_7_2898# u_t030_008/m2_2000_1265#
+ u_t030_008/m2_512_2037# u_t030_008/m2_1795_1265# u_t030_008/m2_1714_1982# u_t030_008/m2_1886_1259#
+ u_t030_008/m2_1290_2126# u_t030_008/m2_1714_438# u_t030_008/m2_431_1210# u_t030_008/m2_2573_2898#
+ u_t030_008/m2_2154_303# u_t030_008/m2_871_2081# VSUBS detronyx_12t_2w2r_rc4_4x4_routed_5layer_direct
Xgf180mcu_as_sc_mcu7t3v3__nand4_2_409 VSS gf180mcu_as_sc_mcu7t3v3__inv_2_1500/VDD
+ VSS VSS VSS VSS gf180mcu_as_sc_mcu7t3v3__nand4_2_409/Y gf180mcu_as_sc_mcu7t3v3__inv_2_1497/VNW
+ VSUBS gf180mcu_as_sc_mcu7t3v3__nand4_2
Xu_t021_008 u_t021_008/c0_w0_bl u_t021_008/c0_w0_br u_t021_008/c0_w1_bl u_t021_008/c0_w1_br
+ u_t021_008/c0_r0_rbl u_t021_008/c0_r1_rbl u_t021_008/c1_w0_bl u_t021_008/c1_w0_br
+ u_t021_008/c1_w1_bl u_t021_008/c1_w1_br u_t021_008/c1_r0_rbl u_t021_008/c1_r1_rbl
+ u_t021_008/c2_w0_bl u_t021_008/c2_w0_br u_t021_008/c2_w1_bl u_t021_008/c2_w1_br
+ u_t021_008/c2_r0_rbl u_t021_008/c2_r1_rbl u_t021_008/c3_w0_bl u_t021_008/c3_w0_br
+ u_t021_008/c3_w1_bl u_t021_008/c3_w1_br u_t021_008/c3_r0_rbl u_t021_008/c3_r1_rbl
+ u_t021_008/r0_w0_wl u_t021_008/r0_w1_wl u_t021_008/r0_r0_rwl u_t021_008/r0_r1_rwl
+ u_t021_008/r1_w0_wl u_t021_008/r1_w1_wl u_t021_008/r1_r0_rwl u_t021_008/r1_r1_rwl
+ u_t021_008/r2_w0_wl u_t021_008/r2_w1_wl u_t021_008/r2_r0_rwl u_t021_008/r2_r1_rwl
+ u_t021_008/r3_w0_wl u_t021_008/r3_w1_wl u_t021_008/r3_r0_rwl u_t021_008/r3_r1_rwl
+ VSS VSS u_t021_008/m2_717_1265# u_t021_008/m2_603_2031# u_t021_008/m2_1290_336#
+ u_t021_008/m2_2000_2037# u_t021_008/m2_791_2909# u_t021_008/m2_7_2126# u_t021_008/m2_2154_2081#
+ u_t021_008/m2_1795_2037# u_t021_008/m2_871_303# u_t021_008/m2_431_438# u_t021_008/m2_1290_2898#
+ u_t021_008/m2_1714_1210# u_t021_008/m2_431_1982# u_t021_008/m2_512_1265# u_t021_008/m2_2573_2126#
+ u_t021_008/m2_603_1259# u_t021_008/m2_2074_2909# u_t021_008/m2_7_336# u_t021_008/m2_717_2037#
+ u_t021_008/m2_1886_2031# u_t021_008/m2_2573_336# u_t021_008/m2_7_2898# u_t021_008/m2_2000_1265#
+ u_t021_008/m2_512_2037# u_t021_008/m2_1795_1265# u_t021_008/m2_1714_1982# u_t021_008/m2_1886_1259#
+ u_t021_008/m2_1290_2126# u_t021_008/m2_1714_438# u_t021_008/m2_431_1210# u_t021_008/m2_2573_2898#
+ u_t021_008/m2_2154_303# u_t021_008/m2_871_2081# VSUBS detronyx_12t_2w2r_rc4_4x4_routed_5layer_direct
Xu_t006_005 u_t006_005/c0_w0_bl u_t006_005/c0_w0_br u_t006_005/c0_w1_bl u_t006_005/c0_w1_br
+ u_t006_005/c0_r0_rbl u_t006_005/c0_r1_rbl u_t006_005/c1_w0_bl u_t006_005/c1_w0_br
+ u_t006_005/c1_w1_bl u_t006_005/c1_w1_br u_t006_005/c1_r0_rbl u_t006_005/c1_r1_rbl
+ u_t006_005/c2_w0_bl u_t006_005/c2_w0_br u_t006_005/c2_w1_bl u_t006_005/c2_w1_br
+ u_t006_005/c2_r0_rbl u_t006_005/c2_r1_rbl u_t006_005/c3_w0_bl u_t006_005/c3_w0_br
+ u_t006_005/c3_w1_bl u_t006_005/c3_w1_br u_t006_005/c3_r0_rbl u_t006_005/c3_r1_rbl
+ u_t006_005/r0_w0_wl u_t006_005/r0_w1_wl u_t006_005/r0_r0_rwl u_t006_005/r0_r1_rwl
+ u_t006_005/r1_w0_wl u_t006_005/r1_w1_wl u_t006_005/r1_r0_rwl u_t006_005/r1_r1_rwl
+ u_t006_005/r2_w0_wl u_t006_005/r2_w1_wl u_t006_005/r2_r0_rwl u_t006_005/r2_r1_rwl
+ u_t006_005/r3_w0_wl u_t006_005/r3_w1_wl u_t006_005/r3_r0_rwl u_t006_005/r3_r1_rwl
+ u_t006_005/VDD u_t006_005/VSS u_t006_005/m2_717_1265# u_t006_005/m2_603_2031# u_t006_005/m2_1290_336#
+ u_t006_005/m2_2000_2037# u_t006_005/m2_791_2909# u_t006_005/m2_7_2126# u_t006_005/m2_2154_2081#
+ u_t006_005/m2_1795_2037# u_t006_005/m2_871_303# u_t006_005/m2_431_438# u_t006_005/m2_1290_2898#
+ u_t006_005/m2_1714_1210# u_t006_005/m2_431_1982# u_t006_005/m2_512_1265# u_t006_005/m2_2573_2126#
+ u_t006_005/m2_603_1259# u_t006_005/m2_2074_2909# u_t006_005/m2_7_336# u_t006_005/m2_717_2037#
+ u_t006_005/m2_1886_2031# u_t006_005/m2_2573_336# u_t006_005/m2_7_2898# u_t006_005/m2_2000_1265#
+ u_t006_005/m2_512_2037# u_t006_005/m2_1795_1265# u_t006_005/m2_1714_1982# u_t006_005/m2_1886_1259#
+ u_t006_005/m2_1290_2126# u_t006_005/m2_1714_438# u_t006_005/m2_431_1210# u_t006_005/m2_2573_2898#
+ u_t006_005/m2_2154_303# u_t006_005/m2_871_2081# VSUBS detronyx_12t_2w2r_rc4_4x4_routed_5layer_direct
Xgf180mcu_as_sc_mcu7t3v3__nand2_2_50 gf180mcu_as_sc_mcu7t3v3__nor2_2_9/VDD gf180mcu_as_sc_mcu7t3v3__nor2_2_9/VSS
+ VSS VSS VSS gf180mcu_as_sc_mcu7t3v3__nor2_2_9/VNW VSUBS gf180mcu_as_sc_mcu7t3v3__nand2_2
Xu_t012_008 u_t012_008/c0_w0_bl u_t012_008/c0_w0_br u_t012_008/c0_w1_bl u_t012_008/c0_w1_br
+ u_t012_008/c0_r0_rbl u_t012_008/c0_r1_rbl u_t012_008/c1_w0_bl u_t012_008/c1_w0_br
+ u_t012_008/c1_w1_bl u_t012_008/c1_w1_br u_t012_008/c1_r0_rbl u_t012_008/c1_r1_rbl
+ u_t012_008/c2_w0_bl u_t012_008/c2_w0_br u_t012_008/c2_w1_bl u_t012_008/c2_w1_br
+ u_t012_008/c2_r0_rbl u_t012_008/c2_r1_rbl u_t012_008/c3_w0_bl u_t012_008/c3_w0_br
+ u_t012_008/c3_w1_bl u_t012_008/c3_w1_br u_t012_008/c3_r0_rbl u_t012_008/c3_r1_rbl
+ u_t012_008/r0_w0_wl u_t012_008/r0_w1_wl u_t012_008/r0_r0_rwl u_t012_008/r0_r1_rwl
+ u_t012_008/r1_w0_wl u_t012_008/r1_w1_wl u_t012_008/r1_r0_rwl u_t012_008/r1_r1_rwl
+ u_t012_008/r2_w0_wl u_t012_008/r2_w1_wl u_t012_008/r2_r0_rwl u_t012_008/r2_r1_rwl
+ u_t012_008/r3_w0_wl u_t012_008/r3_w1_wl u_t012_008/r3_r0_rwl u_t012_008/r3_r1_rwl
+ VSS VSS u_t012_008/m2_717_1265# u_t012_008/m2_603_2031# u_t012_008/m2_1290_336#
+ u_t012_008/m2_2000_2037# u_t012_008/m2_791_2909# u_t012_008/m2_7_2126# u_t012_008/m2_2154_2081#
+ u_t012_008/m2_1795_2037# u_t012_008/m2_871_303# u_t012_008/m2_431_438# u_t012_008/m2_1290_2898#
+ u_t012_008/m2_1714_1210# u_t012_008/m2_431_1982# u_t012_008/m2_512_1265# u_t012_008/m2_2573_2126#
+ u_t012_008/m2_603_1259# u_t012_008/m2_2074_2909# u_t012_008/m2_7_336# u_t012_008/m2_717_2037#
+ u_t012_008/m2_1886_2031# u_t012_008/m2_2573_336# u_t012_008/m2_7_2898# u_t012_008/m2_2000_1265#
+ u_t012_008/m2_512_2037# u_t012_008/m2_1795_1265# u_t012_008/m2_1714_1982# u_t012_008/m2_1886_1259#
+ u_t012_008/m2_1290_2126# u_t012_008/m2_1714_438# u_t012_008/m2_431_1210# u_t012_008/m2_2573_2898#
+ u_t012_008/m2_2154_303# u_t012_008/m2_871_2081# VSUBS detronyx_12t_2w2r_rc4_4x4_routed_5layer_direct
Xgf180mcu_as_sc_mcu7t3v3__inv_2_1401 VSS gf180mcu_as_sc_mcu7t3v3__inv_2_1406/VDD gf180mcu_as_sc_mcu7t3v3__inv_2_1401/Y
+ gf180mcu_as_sc_mcu7t3v3__inv_2_1409/A gf180mcu_as_sc_mcu7t3v3__inv_2_1402/VNW VSUBS
+ gf180mcu_as_sc_mcu7t3v3__inv_2
Xgf180mcu_as_sc_mcu7t3v3__inv_2_1467 VSS gf180mcu_as_sc_mcu7t3v3__inv_2_1470/VDD VSS
+ VSS gf180mcu_as_sc_mcu7t3v3__inv_2_1467/VNW VSUBS gf180mcu_as_sc_mcu7t3v3__inv_2
Xgf180mcu_as_sc_mcu7t3v3__inv_2_1489 gf180mcu_as_sc_mcu7t3v3__inv_2_1491/VDD VSS VSS
+ VSS gf180mcu_as_sc_mcu7t3v3__inv_2_1491/VNW VSUBS gf180mcu_as_sc_mcu7t3v3__inv_2
Xgf180mcu_as_sc_mcu7t3v3__inv_2_1478 gf180mcu_as_sc_mcu7t3v3__inv_2_1508/VSS VSS VSS
+ VSS gf180mcu_as_sc_mcu7t3v3__inv_2_1479/VNW VSUBS gf180mcu_as_sc_mcu7t3v3__inv_2
Xgf180mcu_as_sc_mcu7t3v3__inv_2_1412 gf180mcu_as_sc_mcu7t3v3__inv_2_1457/VSS gf180mcu_as_sc_mcu7t3v3__inv_2_1416/VDD
+ gf180mcu_as_sc_mcu7t3v3__inv_2_1412/Y VSS gf180mcu_as_sc_mcu7t3v3__inv_2_1413/VNW
+ VSUBS gf180mcu_as_sc_mcu7t3v3__inv_2
Xgf180mcu_as_sc_mcu7t3v3__inv_2_1456 VSS gf180mcu_as_sc_mcu7t3v3__inv_2_1457/VSS VSS
+ VSS gf180mcu_as_sc_mcu7t3v3__inv_2_1457/VNW VSUBS gf180mcu_as_sc_mcu7t3v3__inv_2
Xgf180mcu_as_sc_mcu7t3v3__inv_2_1445 gf180mcu_as_sc_mcu7t3v3__inv_2_1446/VDD VSS VSS
+ VSS gf180mcu_as_sc_mcu7t3v3__inv_2_1446/VNW VSUBS gf180mcu_as_sc_mcu7t3v3__inv_2
Xgf180mcu_as_sc_mcu7t3v3__inv_2_1434 gf180mcu_as_sc_mcu7t3v3__inv_2_1434/VDD VSS gf180mcu_as_sc_mcu7t3v3__inv_2_1434/Y
+ VSS gf180mcu_as_sc_mcu7t3v3__inv_2_1434/VNW VSUBS gf180mcu_as_sc_mcu7t3v3__inv_2
Xgf180mcu_as_sc_mcu7t3v3__inv_2_1423 gf180mcu_as_sc_mcu7t3v3__inv_2_1511/VSS VSS VSS
+ VSS gf180mcu_as_sc_mcu7t3v3__inv_2_1425/VNW VSUBS gf180mcu_as_sc_mcu7t3v3__inv_2
Xu_t003_008 u_t003_008/c0_w0_bl u_t003_008/c0_w0_br u_t003_008/c0_w1_bl u_t003_008/c0_w1_br
+ u_t003_008/c0_r0_rbl u_t003_008/c0_r1_rbl u_t003_008/c1_w0_bl u_t003_008/c1_w0_br
+ u_t003_008/c1_w1_bl u_t003_008/c1_w1_br u_t003_008/c1_r0_rbl u_t003_008/c1_r1_rbl
+ u_t003_008/c2_w0_bl u_t003_008/c2_w0_br u_t003_008/c2_w1_bl u_t003_008/c2_w1_br
+ u_t003_008/c2_r0_rbl u_t003_008/c2_r1_rbl u_t003_008/c3_w0_bl u_t003_008/c3_w0_br
+ u_t003_008/c3_w1_bl u_t003_008/c3_w1_br u_t003_008/c3_r0_rbl u_t003_008/c3_r1_rbl
+ u_t003_008/r0_w0_wl u_t003_008/r0_w1_wl u_t003_008/r0_r0_rwl u_t003_008/r0_r1_rwl
+ u_t003_008/r1_w0_wl u_t003_008/r1_w1_wl u_t003_008/r1_r0_rwl u_t003_008/r1_r1_rwl
+ u_t003_008/r2_w0_wl u_t003_008/r2_w1_wl u_t003_008/r2_r0_rwl u_t003_008/r2_r1_rwl
+ u_t003_008/r3_w0_wl u_t003_008/r3_w1_wl u_t003_008/r3_r0_rwl u_t003_008/r3_r1_rwl
+ VSS u_t003_009/VSS u_t003_008/m2_717_1265# u_t003_008/m2_603_2031# u_t003_008/m2_1290_336#
+ u_t003_008/m2_2000_2037# u_t003_008/m2_791_2909# u_t003_008/m2_7_2126# u_t003_008/m2_2154_2081#
+ u_t003_008/m2_1795_2037# u_t003_008/m2_871_303# u_t003_008/m2_431_438# u_t003_008/m2_1290_2898#
+ u_t003_008/m2_1714_1210# u_t003_008/m2_431_1982# u_t003_008/m2_512_1265# u_t003_008/m2_2573_2126#
+ u_t003_008/m2_603_1259# u_t003_008/m2_2074_2909# u_t003_008/m2_7_336# u_t003_008/m2_717_2037#
+ u_t003_008/m2_1886_2031# u_t003_008/m2_2573_336# u_t003_008/m2_7_2898# u_t003_008/m2_2000_1265#
+ u_t003_008/m2_512_2037# u_t003_008/m2_1795_1265# u_t003_008/m2_1714_1982# u_t003_008/m2_1886_1259#
+ u_t003_008/m2_1290_2126# u_t003_008/m2_1714_438# u_t003_008/m2_431_1210# u_t003_008/m2_2573_2898#
+ u_t003_008/m2_2154_303# u_t003_008/m2_871_2081# VSUBS detronyx_12t_2w2r_rc4_4x4_routed_5layer_direct
Xgf180mcu_as_sc_mcu7t3v3__inv_2_907 VSS VSS VSS VSS gf180mcu_as_sc_mcu7t3v3__inv_2_953/VNW
+ VSUBS gf180mcu_as_sc_mcu7t3v3__inv_2
Xgf180mcu_as_sc_mcu7t3v3__inv_2_918 VSS VSS VSS VSS gf180mcu_as_sc_mcu7t3v3__inv_2_955/VNW
+ VSUBS gf180mcu_as_sc_mcu7t3v3__inv_2
Xgf180mcu_as_sc_mcu7t3v3__inv_2_929 VSS VSS VSS VSS gf180mcu_as_sc_mcu7t3v3__inv_2_929/VNW
+ VSUBS gf180mcu_as_sc_mcu7t3v3__inv_2
Xgf180mcu_as_sc_mcu7t3v3__nand4_2_206 gf180mcu_as_sc_mcu7t3v3__inv_2_664/VDD VSS VSS
+ VSS VSS VSS VSS gf180mcu_as_sc_mcu7t3v3__inv_2_664/VNW VSUBS gf180mcu_as_sc_mcu7t3v3__nand4_2
Xgf180mcu_as_sc_mcu7t3v3__nand4_2_217 VSS VSS VSS VSS VSS VSS VSS gf180mcu_as_sc_mcu7t3v3__inv_2_831/VNW
+ VSUBS gf180mcu_as_sc_mcu7t3v3__nand4_2
Xgf180mcu_as_sc_mcu7t3v3__nand4_2_228 VSS VSS VSS VSS VSS VSS VSS gf180mcu_as_sc_mcu7t3v3__inv_2_835/VNW
+ VSUBS gf180mcu_as_sc_mcu7t3v3__nand4_2
Xgf180mcu_as_sc_mcu7t3v3__nand4_2_239 VSS VSS VSS VSS VSS VSS gf180mcu_as_sc_mcu7t3v3__nand4_2_239/Y
+ gf180mcu_as_sc_mcu7t3v3__inv_2_846/VNW VSUBS gf180mcu_as_sc_mcu7t3v3__nand4_2
Xgf180mcu_as_sc_mcu7t3v3__inv_2_1231 gf180mcu_as_sc_mcu7t3v3__nor2_2_9/VDD gf180mcu_as_sc_mcu7t3v3__nor2_2_9/VSS
+ VSS VSS gf180mcu_as_sc_mcu7t3v3__nor2_2_9/VNW VSUBS gf180mcu_as_sc_mcu7t3v3__inv_2
Xgf180mcu_as_sc_mcu7t3v3__inv_2_1253 gf180mcu_as_sc_mcu7t3v3__nor2_2_9/VDD gf180mcu_as_sc_mcu7t3v3__nand3_2_63/VSS
+ VSS VSS gf180mcu_as_sc_mcu7t3v3__nor2_2_9/VNW VSUBS gf180mcu_as_sc_mcu7t3v3__inv_2
Xgf180mcu_as_sc_mcu7t3v3__inv_2_1242 gf180mcu_as_sc_mcu7t3v3__nand3_2_65/VDD gf180mcu_as_sc_mcu7t3v3__nor2_2_9/VSS
+ VSS VSS gf180mcu_as_sc_mcu7t3v3__nand3_2_65/VNW VSUBS gf180mcu_as_sc_mcu7t3v3__inv_2
Xgf180mcu_as_sc_mcu7t3v3__inv_2_1220 VSS VSS VSS VSS gf180mcu_as_sc_mcu7t3v3__inv_2_1275/VNW
+ VSUBS gf180mcu_as_sc_mcu7t3v3__inv_2
Xgf180mcu_as_sc_mcu7t3v3__inv_2_1264 gf180mcu_as_sc_mcu7t3v3__nor2_2_9/VDD gf180mcu_as_sc_mcu7t3v3__nor2_2_9/VSS
+ VSS VSS gf180mcu_as_sc_mcu7t3v3__nor2_2_9/VNW VSUBS gf180mcu_as_sc_mcu7t3v3__inv_2
Xgf180mcu_as_sc_mcu7t3v3__inv_2_1275 VSS VSS VSS VSS gf180mcu_as_sc_mcu7t3v3__inv_2_1275/VNW
+ VSUBS gf180mcu_as_sc_mcu7t3v3__inv_2
Xgf180mcu_as_sc_mcu7t3v3__inv_2_1286 VSS VSS gf180mcu_as_sc_mcu7t3v3__inv_2_1286/Y
+ VSS gf180mcu_as_sc_mcu7t3v3__inv_2_1286/VNW VSUBS gf180mcu_as_sc_mcu7t3v3__inv_2
Xgf180mcu_as_sc_mcu7t3v3__inv_2_1297 VSS VSS VSS VSS gf180mcu_as_sc_mcu7t3v3__inv_2_1297/VNW
+ VSUBS gf180mcu_as_sc_mcu7t3v3__inv_2
Xgf180mcu_as_sc_mcu7t3v3__inv_2_759 VSS VSS gf180mcu_as_sc_mcu7t3v3__inv_2_759/Y VSS
+ gf180mcu_as_sc_mcu7t3v3__inv_2_820/VNW VSUBS gf180mcu_as_sc_mcu7t3v3__inv_2
Xgf180mcu_as_sc_mcu7t3v3__inv_2_748 VSS VSS VSS VSS gf180mcu_as_sc_mcu7t3v3__inv_2_829/VNW
+ VSUBS gf180mcu_as_sc_mcu7t3v3__inv_2
Xgf180mcu_as_sc_mcu7t3v3__inv_2_726 gf180mcu_as_sc_mcu7t3v3__inv_2_746/VDD gf180mcu_as_sc_mcu7t3v3__inv_2_746/VDD
+ gf180mcu_as_sc_mcu7t3v3__inv_2_726/Y gf180mcu_as_sc_mcu7t3v3__inv_2_744/A gf180mcu_as_sc_mcu7t3v3__inv_2_728/VNW
+ VSUBS gf180mcu_as_sc_mcu7t3v3__inv_2
Xgf180mcu_as_sc_mcu7t3v3__inv_2_715 VSS VSS gf180mcu_as_sc_mcu7t3v3__inv_2_722/A gf180mcu_as_sc_mcu7t3v3__inv_2_716/Y
+ gf180mcu_as_sc_mcu7t3v3__inv_2_716/VNW VSUBS gf180mcu_as_sc_mcu7t3v3__inv_2
Xgf180mcu_as_sc_mcu7t3v3__inv_2_704 gf180mcu_as_sc_mcu7t3v3__inv_2_737/VSS gf180mcu_as_sc_mcu7t3v3__inv_2_730/VDD
+ gf180mcu_as_sc_mcu7t3v3__inv_2_704/Y VSS gf180mcu_as_sc_mcu7t3v3__inv_2_704/VNW
+ VSUBS gf180mcu_as_sc_mcu7t3v3__inv_2
Xgf180mcu_as_sc_mcu7t3v3__inv_2_737 VSS gf180mcu_as_sc_mcu7t3v3__inv_2_737/VSS gf180mcu_as_sc_mcu7t3v3__inv_2_737/Y
+ gf180mcu_as_sc_mcu7t3v3__inv_2_742/A gf180mcu_as_sc_mcu7t3v3__inv_2_737/VNW VSUBS
+ gf180mcu_as_sc_mcu7t3v3__inv_2
Xgf180mcu_as_sc_mcu7t3v3__inv_2_1094 VSS VSS gf180mcu_as_sc_mcu7t3v3__inv_2_1101/A
+ gf180mcu_as_sc_mcu7t3v3__inv_2_1095/Y gf180mcu_as_sc_mcu7t3v3__inv_2_1095/VNW VSUBS
+ gf180mcu_as_sc_mcu7t3v3__inv_2
Xgf180mcu_as_sc_mcu7t3v3__inv_2_1083 VSS gf180mcu_as_sc_mcu7t3v3__inv_2_1087/VDD gf180mcu_as_sc_mcu7t3v3__inv_2_1083/Y
+ VSS gf180mcu_as_sc_mcu7t3v3__inv_2_1083/VNW VSUBS gf180mcu_as_sc_mcu7t3v3__inv_2
Xgf180mcu_as_sc_mcu7t3v3__inv_2_1072 VSS VSS VSS gf180mcu_as_sc_mcu7t3v3__inv_2_1306/Y
+ gf180mcu_as_sc_mcu7t3v3__inv_2_1080/VNW VSUBS gf180mcu_as_sc_mcu7t3v3__inv_2
Xgf180mcu_as_sc_mcu7t3v3__inv_2_1050 gf180mcu_as_sc_mcu7t3v3__inv_2_1052/VDD VSS VSS
+ gf180mcu_as_sc_mcu7t3v3__inv_2_962/A gf180mcu_as_sc_mcu7t3v3__inv_2_1052/VNW VSUBS
+ gf180mcu_as_sc_mcu7t3v3__inv_2
Xgf180mcu_as_sc_mcu7t3v3__inv_2_91 gf180mcu_as_sc_mcu7t3v3__inv_2_94/VSS gf180mcu_as_sc_mcu7t3v3__inv_2_91/VSS
+ gf180mcu_as_sc_mcu7t3v3__inv_2_91/Y VSS gf180mcu_as_sc_mcu7t3v3__inv_2_91/VNW VSUBS
+ gf180mcu_as_sc_mcu7t3v3__inv_2
Xgf180mcu_as_sc_mcu7t3v3__inv_2_80 gf180mcu_as_sc_mcu7t3v3__inv_2_99/VSS gf180mcu_as_sc_mcu7t3v3__inv_2_94/VDD
+ gf180mcu_as_sc_mcu7t3v3__inv_2_80/Y VSS gf180mcu_as_sc_mcu7t3v3__inv_2_81/VNW VSUBS
+ gf180mcu_as_sc_mcu7t3v3__inv_2
Xgf180mcu_as_sc_mcu7t3v3__inv_2_1061 gf180mcu_as_sc_mcu7t3v3__inv_2_1061/VDD gf180mcu_as_sc_mcu7t3v3__inv_2_964/VDD
+ gf180mcu_as_sc_mcu7t3v3__inv_2_1061/Y VSS gf180mcu_as_sc_mcu7t3v3__inv_2_1061/VNW
+ VSUBS gf180mcu_as_sc_mcu7t3v3__inv_2
Xgf180mcu_as_sc_mcu7t3v3__nand4_2_6 gf180mcu_as_sc_mcu7t3v3__inv_2_91/VSS gf180mcu_as_sc_mcu7t3v3__inv_2_97/VDD
+ VSS VSS VSS VSS gf180mcu_as_sc_mcu7t3v3__nand4_2_6/Y gf180mcu_as_sc_mcu7t3v3__inv_2_90/VNW
+ VSUBS gf180mcu_as_sc_mcu7t3v3__nand4_2
Xgf180mcu_as_sc_mcu7t3v3__inv_2_545 VSS VSS VSS VSS gf180mcu_as_sc_mcu7t3v3__inv_2_545/VNW
+ VSUBS gf180mcu_as_sc_mcu7t3v3__inv_2
Xgf180mcu_as_sc_mcu7t3v3__inv_2_534 gf180mcu_as_sc_mcu7t3v3__nor2_2_6/VDD gf180mcu_as_sc_mcu7t3v3__nor2_2_6/VSS
+ VSS VSS gf180mcu_as_sc_mcu7t3v3__nor2_2_6/VNW VSUBS gf180mcu_as_sc_mcu7t3v3__inv_2
Xgf180mcu_as_sc_mcu7t3v3__inv_2_523 gf180mcu_as_sc_mcu7t3v3__nor2_2_7/VDD gf180mcu_as_sc_mcu7t3v3__nor2_2_7/VSS
+ VSS VSS gf180mcu_as_sc_mcu7t3v3__nor2_2_7/VNW VSUBS gf180mcu_as_sc_mcu7t3v3__inv_2
Xgf180mcu_as_sc_mcu7t3v3__inv_2_501 VSS VSS VSS VSS gf180mcu_as_sc_mcu7t3v3__inv_2_536/VNW
+ VSUBS gf180mcu_as_sc_mcu7t3v3__inv_2
Xgf180mcu_as_sc_mcu7t3v3__inv_2_512 VSS VSS VSS VSS gf180mcu_as_sc_mcu7t3v3__inv_2_563/VNW
+ VSUBS gf180mcu_as_sc_mcu7t3v3__inv_2
Xgf180mcu_as_sc_mcu7t3v3__inv_2_589 gf180mcu_as_sc_mcu7t3v3__inv_2_590/VSS gf180mcu_as_sc_mcu7t3v3__inv_2_590/VSS
+ gf180mcu_as_sc_mcu7t3v3__inv_2_589/Y gf180mcu_as_sc_mcu7t3v3__inv_2_590/Y gf180mcu_as_sc_mcu7t3v3__inv_2_590/VNW
+ VSUBS gf180mcu_as_sc_mcu7t3v3__inv_2
Xgf180mcu_as_sc_mcu7t3v3__inv_2_567 gf180mcu_as_sc_mcu7t3v3__inv_2_590/VSS gf180mcu_as_sc_mcu7t3v3__inv_2_570/VDD
+ gf180mcu_as_sc_mcu7t3v3__inv_2_567/Y VSS gf180mcu_as_sc_mcu7t3v3__inv_2_567/VNW
+ VSUBS gf180mcu_as_sc_mcu7t3v3__inv_2
Xgf180mcu_as_sc_mcu7t3v3__inv_2_578 gf180mcu_as_sc_mcu7t3v3__inv_2_579/VDD gf180mcu_as_sc_mcu7t3v3__inv_2_584/VDD
+ gf180mcu_as_sc_mcu7t3v3__inv_2_578/Y gf180mcu_as_sc_mcu7t3v3__inv_2_579/Y gf180mcu_as_sc_mcu7t3v3__inv_2_579/VNW
+ VSUBS gf180mcu_as_sc_mcu7t3v3__inv_2
Xgf180mcu_as_sc_mcu7t3v3__inv_2_556 VSS VSS VSS VSS gf180mcu_as_sc_mcu7t3v3__inv_2_556/VNW
+ VSUBS gf180mcu_as_sc_mcu7t3v3__inv_2
Xgf180mcu_as_sc_mcu7t3v3__inv_2_375 gf180mcu_as_sc_mcu7t3v3__nor2_2_4/VDD gf180mcu_as_sc_mcu7t3v3__nor2_2_4/VSS
+ VSS VSS gf180mcu_as_sc_mcu7t3v3__nor2_2_4/VNW VSUBS gf180mcu_as_sc_mcu7t3v3__inv_2
Xgf180mcu_as_sc_mcu7t3v3__inv_2_386 gf180mcu_as_sc_mcu7t3v3__nor2_2_4/VDD gf180mcu_as_sc_mcu7t3v3__nand2_2_3/VSS
+ VSS VSS gf180mcu_as_sc_mcu7t3v3__nor2_2_4/VNW VSUBS gf180mcu_as_sc_mcu7t3v3__inv_2
Xgf180mcu_as_sc_mcu7t3v3__inv_2_364 gf180mcu_as_sc_mcu7t3v3__inv_2_365/VDD gf180mcu_as_sc_mcu7t3v3__inv_2_365/VSS
+ gf180mcu_as_sc_mcu7t3v3__inv_2_364/Y gf180mcu_as_sc_mcu7t3v3__inv_2_365/Y gf180mcu_as_sc_mcu7t3v3__inv_2_365/VNW
+ VSUBS gf180mcu_as_sc_mcu7t3v3__inv_2
Xgf180mcu_as_sc_mcu7t3v3__inv_2_353 VSS VSS gf180mcu_as_sc_mcu7t3v3__inv_2_359/Y VSS
+ gf180mcu_as_sc_mcu7t3v3__inv_2_353/VNW VSUBS gf180mcu_as_sc_mcu7t3v3__inv_2
Xgf180mcu_as_sc_mcu7t3v3__inv_2_342 VSS VSS VSS gf180mcu_as_sc_mcu7t3v3__inv_2_350/Y
+ gf180mcu_as_sc_mcu7t3v3__inv_2_344/VNW VSUBS gf180mcu_as_sc_mcu7t3v3__inv_2
Xgf180mcu_as_sc_mcu7t3v3__inv_2_331 gf180mcu_as_sc_mcu7t3v3__inv_2_332/VDD VSS gf180mcu_as_sc_mcu7t3v3__inv_2_341/Y
+ gf180mcu_as_sc_mcu7t3v3__inv_2_341/Y gf180mcu_as_sc_mcu7t3v3__inv_2_332/VNW VSUBS
+ gf180mcu_as_sc_mcu7t3v3__inv_2
Xgf180mcu_as_sc_mcu7t3v3__inv_2_320 gf180mcu_as_sc_mcu7t3v3__inv_2_320/VDD gf180mcu_as_sc_mcu7t3v3__inv_2_323/VDD
+ gf180mcu_as_sc_mcu7t3v3__inv_2_341/Y VSS gf180mcu_as_sc_mcu7t3v3__inv_2_320/VNW
+ VSUBS gf180mcu_as_sc_mcu7t3v3__inv_2
Xgf180mcu_as_sc_mcu7t3v3__inv_2_397 gf180mcu_as_sc_mcu7t3v3__nor2_2_4/VDD gf180mcu_as_sc_mcu7t3v3__nor2_2_4/VSS
+ VSS VSS gf180mcu_as_sc_mcu7t3v3__nor2_2_4/VNW VSUBS gf180mcu_as_sc_mcu7t3v3__inv_2
Xu_t027_014 u_t027_014/c0_w0_bl u_t027_014/c0_w0_br u_t027_014/c0_w1_bl u_t027_014/c0_w1_br
+ u_t027_014/c0_r0_rbl u_t027_014/c0_r1_rbl u_t027_014/c1_w0_bl u_t027_014/c1_w0_br
+ u_t027_014/c1_w1_bl u_t027_014/c1_w1_br u_t027_014/c1_r0_rbl u_t027_014/c1_r1_rbl
+ u_t027_014/c2_w0_bl u_t027_014/c2_w0_br u_t027_014/c2_w1_bl u_t027_014/c2_w1_br
+ u_t027_014/c2_r0_rbl u_t027_014/c2_r1_rbl u_t027_014/c3_w0_bl u_t027_014/c3_w0_br
+ u_t027_014/c3_w1_bl u_t027_014/c3_w1_br u_t027_014/c3_r0_rbl u_t027_014/c3_r1_rbl
+ u_t027_014/r0_w0_wl u_t027_014/r0_w1_wl u_t027_014/r0_r0_rwl u_t027_014/r0_r1_rwl
+ u_t027_014/r1_w0_wl u_t027_014/r1_w1_wl u_t027_014/r1_r0_rwl u_t027_014/r1_r1_rwl
+ u_t027_014/r2_w0_wl u_t027_014/r2_w1_wl u_t027_014/r2_r0_rwl u_t027_014/r2_r1_rwl
+ u_t027_014/r3_w0_wl u_t027_014/r3_w1_wl u_t027_014/r3_r0_rwl u_t027_014/r3_r1_rwl
+ u_t027_014/VDD u_t027_015/VSS u_t027_014/m2_717_1265# u_t027_014/m2_603_2031# u_t027_014/m2_1290_336#
+ u_t027_014/m2_2000_2037# u_t027_014/m2_791_2909# u_t027_014/m2_7_2126# u_t027_014/m2_2154_2081#
+ u_t027_014/m2_1795_2037# u_t027_014/m2_871_303# u_t027_014/m2_431_438# u_t027_014/m2_1290_2898#
+ u_t027_014/m2_1714_1210# u_t027_014/m2_431_1982# u_t027_014/m2_512_1265# u_t027_014/m2_2573_2126#
+ u_t027_014/m2_603_1259# u_t027_014/m2_2074_2909# u_t027_014/m2_7_336# u_t027_014/m2_717_2037#
+ u_t027_014/m2_1886_2031# u_t027_014/m2_2573_336# u_t027_014/m2_7_2898# u_t027_014/m2_2000_1265#
+ u_t027_014/m2_512_2037# u_t027_014/m2_1795_1265# u_t027_014/m2_1714_1982# u_t027_014/m2_1886_1259#
+ u_t027_014/m2_1290_2126# u_t027_014/m2_1714_438# u_t027_014/m2_431_1210# u_t027_014/m2_2573_2898#
+ u_t027_014/m2_2154_303# u_t027_014/m2_871_2081# VSUBS detronyx_12t_2w2r_rc4_4x4_routed_5layer_direct
Xu_t027_003 u_t027_003/c0_w0_bl u_t027_003/c0_w0_br u_t027_003/c0_w1_bl u_t027_003/c0_w1_br
+ u_t027_003/c0_r0_rbl u_t027_003/c0_r1_rbl u_t027_003/c1_w0_bl u_t027_003/c1_w0_br
+ u_t027_003/c1_w1_bl u_t027_003/c1_w1_br u_t027_003/c1_r0_rbl u_t027_003/c1_r1_rbl
+ u_t027_003/c2_w0_bl u_t027_003/c2_w0_br u_t027_003/c2_w1_bl u_t027_003/c2_w1_br
+ u_t027_003/c2_r0_rbl u_t027_003/c2_r1_rbl u_t027_003/c3_w0_bl u_t027_003/c3_w0_br
+ u_t027_003/c3_w1_bl u_t027_003/c3_w1_br u_t027_003/c3_r0_rbl u_t027_003/c3_r1_rbl
+ u_t027_003/r0_w0_wl u_t027_003/r0_w1_wl u_t027_003/r0_r0_rwl u_t027_003/r0_r1_rwl
+ u_t027_003/r1_w0_wl u_t027_003/r1_w1_wl u_t027_003/r1_r0_rwl u_t027_003/r1_r1_rwl
+ u_t027_003/r2_w0_wl u_t027_003/r2_w1_wl u_t027_003/r2_r0_rwl u_t027_003/r2_r1_rwl
+ u_t027_003/r3_w0_wl u_t027_003/r3_w1_wl u_t027_003/r3_r0_rwl u_t027_003/r3_r1_rwl
+ u_t027_003/VDD u_t027_003/VSS u_t027_003/m2_717_1265# u_t027_003/m2_603_2031# u_t027_003/m2_1290_336#
+ u_t027_003/m2_2000_2037# u_t027_003/m2_791_2909# u_t027_003/m2_7_2126# u_t027_003/m2_2154_2081#
+ u_t027_003/m2_1795_2037# u_t027_003/m2_871_303# u_t027_003/m2_431_438# u_t027_003/m2_1290_2898#
+ u_t027_003/m2_1714_1210# u_t027_003/m2_431_1982# u_t027_003/m2_512_1265# u_t027_003/m2_2573_2126#
+ u_t027_003/m2_603_1259# u_t027_003/m2_2074_2909# u_t027_003/m2_7_336# u_t027_003/m2_717_2037#
+ u_t027_003/m2_1886_2031# u_t027_003/m2_2573_336# u_t027_003/m2_7_2898# u_t027_003/m2_2000_1265#
+ u_t027_003/m2_512_2037# u_t027_003/m2_1795_1265# u_t027_003/m2_1714_1982# u_t027_003/m2_1886_1259#
+ u_t027_003/m2_1290_2126# u_t027_003/m2_1714_438# u_t027_003/m2_431_1210# u_t027_003/m2_2573_2898#
+ u_t027_003/m2_2154_303# u_t027_003/m2_871_2081# VSUBS detronyx_12t_2w2r_rc4_4x4_routed_5layer_direct
Xu_t018_014 u_t018_014/c0_w0_bl u_t018_014/c0_w0_br u_t018_014/c0_w1_bl u_t018_014/c0_w1_br
+ u_t018_014/c0_r0_rbl u_t018_014/c0_r1_rbl u_t018_014/c1_w0_bl u_t018_014/c1_w0_br
+ u_t018_014/c1_w1_bl u_t018_014/c1_w1_br u_t018_014/c1_r0_rbl u_t018_014/c1_r1_rbl
+ u_t018_014/c2_w0_bl u_t018_014/c2_w0_br u_t018_014/c2_w1_bl u_t018_014/c2_w1_br
+ u_t018_014/c2_r0_rbl u_t018_014/c2_r1_rbl u_t018_014/c3_w0_bl u_t018_014/c3_w0_br
+ u_t018_014/c3_w1_bl u_t018_014/c3_w1_br u_t018_014/c3_r0_rbl u_t018_014/c3_r1_rbl
+ u_t018_014/r0_w0_wl u_t018_014/r0_w1_wl u_t018_014/r0_r0_rwl u_t018_014/r0_r1_rwl
+ u_t018_014/r1_w0_wl u_t018_014/r1_w1_wl u_t018_014/r1_r0_rwl u_t018_014/r1_r1_rwl
+ u_t018_014/r2_w0_wl u_t018_014/r2_w1_wl u_t018_014/r2_r0_rwl u_t018_014/r2_r1_rwl
+ u_t018_014/r3_w0_wl u_t018_014/r3_w1_wl u_t018_014/r3_r0_rwl u_t018_014/r3_r1_rwl
+ u_t018_014/VDD u_t018_015/VSS u_t018_014/m2_717_1265# u_t018_014/m2_603_2031# u_t018_014/m2_1290_336#
+ u_t018_014/m2_2000_2037# u_t018_014/m2_791_2909# u_t018_014/m2_7_2126# u_t018_014/m2_2154_2081#
+ u_t018_014/m2_1795_2037# u_t018_014/m2_871_303# u_t018_014/m2_431_438# u_t018_014/m2_1290_2898#
+ u_t018_014/m2_1714_1210# u_t018_014/m2_431_1982# u_t018_014/m2_512_1265# u_t018_014/m2_2573_2126#
+ u_t018_014/m2_603_1259# u_t018_014/m2_2074_2909# u_t018_014/m2_7_336# u_t018_014/m2_717_2037#
+ u_t018_014/m2_1886_2031# u_t018_014/m2_2573_336# u_t018_014/m2_7_2898# u_t018_014/m2_2000_1265#
+ u_t018_014/m2_512_2037# u_t018_014/m2_1795_1265# u_t018_014/m2_1714_1982# u_t018_014/m2_1886_1259#
+ u_t018_014/m2_1290_2126# u_t018_014/m2_1714_438# u_t018_014/m2_431_1210# u_t018_014/m2_2573_2898#
+ u_t018_014/m2_2154_303# u_t018_014/m2_871_2081# VSUBS detronyx_12t_2w2r_rc4_4x4_routed_5layer_direct
Xu_t018_003 u_t018_003/c0_w0_bl u_t018_003/c0_w0_br u_t018_003/c0_w1_bl u_t018_003/c0_w1_br
+ u_t018_003/c0_r0_rbl u_t018_003/c0_r1_rbl u_t018_003/c1_w0_bl u_t018_003/c1_w0_br
+ u_t018_003/c1_w1_bl u_t018_003/c1_w1_br u_t018_003/c1_r0_rbl u_t018_003/c1_r1_rbl
+ u_t018_003/c2_w0_bl u_t018_003/c2_w0_br u_t018_003/c2_w1_bl u_t018_003/c2_w1_br
+ u_t018_003/c2_r0_rbl u_t018_003/c2_r1_rbl u_t018_003/c3_w0_bl u_t018_003/c3_w0_br
+ u_t018_003/c3_w1_bl u_t018_003/c3_w1_br u_t018_003/c3_r0_rbl u_t018_003/c3_r1_rbl
+ u_t018_003/r0_w0_wl u_t018_003/r0_w1_wl u_t018_003/r0_r0_rwl u_t018_003/r0_r1_rwl
+ u_t018_003/r1_w0_wl u_t018_003/r1_w1_wl u_t018_003/r1_r0_rwl u_t018_003/r1_r1_rwl
+ u_t018_003/r2_w0_wl u_t018_003/r2_w1_wl u_t018_003/r2_r0_rwl u_t018_003/r2_r1_rwl
+ u_t018_003/r3_w0_wl u_t018_003/r3_w1_wl u_t018_003/r3_r0_rwl u_t018_003/r3_r1_rwl
+ u_t018_003/VDD u_t018_003/VSS u_t018_003/m2_717_1265# u_t018_003/m2_603_2031# u_t018_003/m2_1290_336#
+ u_t018_003/m2_2000_2037# u_t018_003/m2_791_2909# u_t018_003/m2_7_2126# u_t018_003/m2_2154_2081#
+ u_t018_003/m2_1795_2037# u_t018_003/m2_871_303# u_t018_003/m2_431_438# u_t018_003/m2_1290_2898#
+ u_t018_003/m2_1714_1210# u_t018_003/m2_431_1982# u_t018_003/m2_512_1265# u_t018_003/m2_2573_2126#
+ u_t018_003/m2_603_1259# u_t018_003/m2_2074_2909# u_t018_003/m2_7_336# u_t018_003/m2_717_2037#
+ u_t018_003/m2_1886_2031# u_t018_003/m2_2573_336# u_t018_003/m2_7_2898# u_t018_003/m2_2000_1265#
+ u_t018_003/m2_512_2037# u_t018_003/m2_1795_1265# u_t018_003/m2_1714_1982# u_t018_003/m2_1886_1259#
+ u_t018_003/m2_1290_2126# u_t018_003/m2_1714_438# u_t018_003/m2_431_1210# u_t018_003/m2_2573_2898#
+ u_t018_003/m2_2154_303# u_t018_003/m2_871_2081# VSUBS detronyx_12t_2w2r_rc4_4x4_routed_5layer_direct
Xu_t009_014 u_t009_014/c0_w0_bl u_t009_014/c0_w0_br u_t009_014/c0_w1_bl u_t009_014/c0_w1_br
+ u_t009_014/c0_r0_rbl u_t009_014/c0_r1_rbl u_t009_014/c1_w0_bl u_t009_014/c1_w0_br
+ u_t009_014/c1_w1_bl u_t009_014/c1_w1_br u_t009_014/c1_r0_rbl u_t009_014/c1_r1_rbl
+ u_t009_014/c2_w0_bl u_t009_014/c2_w0_br u_t009_014/c2_w1_bl u_t009_014/c2_w1_br
+ u_t009_014/c2_r0_rbl u_t009_014/c2_r1_rbl u_t009_014/c3_w0_bl u_t009_014/c3_w0_br
+ u_t009_014/c3_w1_bl u_t009_014/c3_w1_br u_t009_014/c3_r0_rbl u_t009_014/c3_r1_rbl
+ u_t009_014/r0_w0_wl u_t009_014/r0_w1_wl u_t009_014/r0_r0_rwl u_t009_014/r0_r1_rwl
+ u_t009_014/r1_w0_wl u_t009_014/r1_w1_wl u_t009_014/r1_r0_rwl u_t009_014/r1_r1_rwl
+ u_t009_014/r2_w0_wl u_t009_014/r2_w1_wl u_t009_014/r2_r0_rwl u_t009_014/r2_r1_rwl
+ u_t009_014/r3_w0_wl u_t009_014/r3_w1_wl u_t009_014/r3_r0_rwl u_t009_014/r3_r1_rwl
+ u_t009_014/VDD VSS u_t009_014/m2_717_1265# u_t009_014/m2_603_2031# u_t009_014/m2_1290_336#
+ u_t009_014/m2_2000_2037# u_t009_014/m2_791_2909# u_t009_014/m2_7_2126# u_t009_014/m2_2154_2081#
+ u_t009_014/m2_1795_2037# u_t009_014/m2_871_303# u_t009_014/m2_431_438# u_t009_014/m2_1290_2898#
+ u_t009_014/m2_1714_1210# u_t009_014/m2_431_1982# u_t009_014/m2_512_1265# u_t009_014/m2_2573_2126#
+ u_t009_014/m2_603_1259# u_t009_014/m2_2074_2909# u_t009_014/m2_7_336# u_t009_014/m2_717_2037#
+ u_t009_014/m2_1886_2031# u_t009_014/m2_2573_336# u_t009_014/m2_7_2898# u_t009_014/m2_2000_1265#
+ u_t009_014/m2_512_2037# u_t009_014/m2_1795_1265# u_t009_014/m2_1714_1982# u_t009_014/m2_1886_1259#
+ u_t009_014/m2_1290_2126# u_t009_014/m2_1714_438# u_t009_014/m2_431_1210# u_t009_014/m2_2573_2898#
+ u_t009_014/m2_2154_303# u_t009_014/m2_871_2081# VSUBS detronyx_12t_2w2r_rc4_4x4_routed_5layer_direct
Xu_t009_003 u_t009_003/c0_w0_bl u_t009_003/c0_w0_br u_t009_003/c0_w1_bl u_t009_003/c0_w1_br
+ u_t009_003/c0_r0_rbl u_t009_003/c0_r1_rbl u_t009_003/c1_w0_bl u_t009_003/c1_w0_br
+ u_t009_003/c1_w1_bl u_t009_003/c1_w1_br u_t009_003/c1_r0_rbl u_t009_003/c1_r1_rbl
+ u_t009_003/c2_w0_bl u_t009_003/c2_w0_br u_t009_003/c2_w1_bl u_t009_003/c2_w1_br
+ u_t009_003/c2_r0_rbl u_t009_003/c2_r1_rbl u_t009_003/c3_w0_bl u_t009_003/c3_w0_br
+ u_t009_003/c3_w1_bl u_t009_003/c3_w1_br u_t009_003/c3_r0_rbl u_t009_003/c3_r1_rbl
+ u_t009_003/r0_w0_wl u_t009_003/r0_w1_wl u_t009_003/r0_r0_rwl u_t009_003/r0_r1_rwl
+ u_t009_003/r1_w0_wl u_t009_003/r1_w1_wl u_t009_003/r1_r0_rwl u_t009_003/r1_r1_rwl
+ u_t009_003/r2_w0_wl u_t009_003/r2_w1_wl u_t009_003/r2_r0_rwl u_t009_003/r2_r1_rwl
+ u_t009_003/r3_w0_wl u_t009_003/r3_w1_wl u_t009_003/r3_r0_rwl u_t009_003/r3_r1_rwl
+ u_t009_003/VDD VSS u_t009_003/m2_717_1265# u_t009_003/m2_603_2031# u_t009_003/m2_1290_336#
+ u_t009_003/m2_2000_2037# u_t009_003/m2_791_2909# u_t009_003/m2_7_2126# u_t009_003/m2_2154_2081#
+ u_t009_003/m2_1795_2037# u_t009_003/m2_871_303# u_t009_003/m2_431_438# u_t009_003/m2_1290_2898#
+ u_t009_003/m2_1714_1210# u_t009_003/m2_431_1982# u_t009_003/m2_512_1265# u_t009_003/m2_2573_2126#
+ u_t009_003/m2_603_1259# u_t009_003/m2_2074_2909# u_t009_003/m2_7_336# u_t009_003/m2_717_2037#
+ u_t009_003/m2_1886_2031# u_t009_003/m2_2573_336# u_t009_003/m2_7_2898# u_t009_003/m2_2000_1265#
+ u_t009_003/m2_512_2037# u_t009_003/m2_1795_1265# u_t009_003/m2_1714_1982# u_t009_003/m2_1886_1259#
+ u_t009_003/m2_1290_2126# u_t009_003/m2_1714_438# u_t009_003/m2_431_1210# u_t009_003/m2_2573_2898#
+ u_t009_003/m2_2154_303# u_t009_003/m2_871_2081# VSUBS detronyx_12t_2w2r_rc4_4x4_routed_5layer_direct
Xgf180mcu_as_sc_mcu7t3v3__nand3_2_18 gf180mcu_as_sc_mcu7t3v3__nor2_2_6/VDD gf180mcu_as_sc_mcu7t3v3__nand3_2_4/VSS
+ VSS VSS VSS VSS gf180mcu_as_sc_mcu7t3v3__nor2_2_6/VNW VSUBS gf180mcu_as_sc_mcu7t3v3__nand3_2
Xgf180mcu_as_sc_mcu7t3v3__nand3_2_29 gf180mcu_as_sc_mcu7t3v3__nand3_2_9/VDD gf180mcu_as_sc_mcu7t3v3__nor2_2_7/VSS
+ VSS VSS VSS VSS gf180mcu_as_sc_mcu7t3v3__nand3_2_9/VNW VSUBS gf180mcu_as_sc_mcu7t3v3__nand3_2
Xu_t024_006 u_t024_006/c0_w0_bl u_t024_006/c0_w0_br u_t024_006/c0_w1_bl u_t024_006/c0_w1_br
+ u_t024_006/c0_r0_rbl u_t024_006/c0_r1_rbl u_t024_006/c1_w0_bl u_t024_006/c1_w0_br
+ u_t024_006/c1_w1_bl u_t024_006/c1_w1_br u_t024_006/c1_r0_rbl u_t024_006/c1_r1_rbl
+ u_t024_006/c2_w0_bl u_t024_006/c2_w0_br u_t024_006/c2_w1_bl u_t024_006/c2_w1_br
+ u_t024_006/c2_r0_rbl u_t024_006/c2_r1_rbl u_t024_006/c3_w0_bl u_t024_006/c3_w0_br
+ u_t024_006/c3_w1_bl u_t024_006/c3_w1_br u_t024_006/c3_r0_rbl u_t024_006/c3_r1_rbl
+ u_t024_006/r0_w0_wl u_t024_006/r0_w1_wl u_t024_006/r0_r0_rwl u_t024_006/r0_r1_rwl
+ u_t024_006/r1_w0_wl u_t024_006/r1_w1_wl u_t024_006/r1_r0_rwl u_t024_006/r1_r1_rwl
+ u_t024_006/r2_w0_wl u_t024_006/r2_w1_wl u_t024_006/r2_r0_rwl u_t024_006/r2_r1_rwl
+ u_t024_006/r3_w0_wl u_t024_006/r3_w1_wl u_t024_006/r3_r0_rwl u_t024_006/r3_r1_rwl
+ u_t025_006/VDD u_t024_009/VSS u_t024_006/m2_717_1265# u_t024_006/m2_603_2031# u_t024_006/m2_1290_336#
+ u_t024_006/m2_2000_2037# u_t024_006/m2_791_2909# u_t024_006/m2_7_2126# u_t024_006/m2_2154_2081#
+ u_t024_006/m2_1795_2037# u_t024_006/m2_871_303# u_t024_006/m2_431_438# u_t024_006/m2_1290_2898#
+ u_t024_006/m2_1714_1210# u_t024_006/m2_431_1982# u_t024_006/m2_512_1265# u_t024_006/m2_2573_2126#
+ u_t024_006/m2_603_1259# u_t024_006/m2_2074_2909# u_t024_006/m2_7_336# u_t024_006/m2_717_2037#
+ u_t024_006/m2_1886_2031# u_t024_006/m2_2573_336# u_t024_006/m2_7_2898# u_t024_006/m2_2000_1265#
+ u_t024_006/m2_512_2037# u_t024_006/m2_1795_1265# u_t024_006/m2_1714_1982# u_t024_006/m2_1886_1259#
+ u_t024_006/m2_1290_2126# u_t024_006/m2_1714_438# u_t024_006/m2_431_1210# u_t024_006/m2_2573_2898#
+ u_t024_006/m2_2154_303# u_t024_006/m2_871_2081# VSUBS detronyx_12t_2w2r_rc4_4x4_routed_5layer_direct
Xgf180mcu_as_sc_mcu7t3v3__inv_2_150 gf180mcu_as_sc_mcu7t3v3__inv_2_152/VDD gf180mcu_as_sc_mcu7t3v3__nand4_2_9/VDD
+ gf180mcu_as_sc_mcu7t3v3__inv_2_150/Y VSS gf180mcu_as_sc_mcu7t3v3__inv_2_152/VNW
+ VSUBS gf180mcu_as_sc_mcu7t3v3__inv_2
Xgf180mcu_as_sc_mcu7t3v3__inv_2_172 VSS VSS gf180mcu_as_sc_mcu7t3v3__inv_2_172/Y VSS
+ gf180mcu_as_sc_mcu7t3v3__inv_2_174/VNW VSUBS gf180mcu_as_sc_mcu7t3v3__inv_2
Xgf180mcu_as_sc_mcu7t3v3__inv_2_194 VSS VSS gf180mcu_as_sc_mcu7t3v3__inv_2_194/Y VSS
+ gf180mcu_as_sc_mcu7t3v3__inv_2_196/VNW VSUBS gf180mcu_as_sc_mcu7t3v3__inv_2
Xgf180mcu_as_sc_mcu7t3v3__inv_2_183 gf180mcu_as_sc_mcu7t3v3__inv_2_203/VSS VSS gf180mcu_as_sc_mcu7t3v3__inv_2_183/Y
+ VSS gf180mcu_as_sc_mcu7t3v3__inv_2_197/VNW VSUBS gf180mcu_as_sc_mcu7t3v3__inv_2
Xgf180mcu_as_sc_mcu7t3v3__inv_2_161 gf180mcu_as_sc_mcu7t3v3__inv_2_163/VDD VSS gf180mcu_as_sc_mcu7t3v3__inv_2_161/Y
+ VSS gf180mcu_as_sc_mcu7t3v3__inv_2_163/VNW VSUBS gf180mcu_as_sc_mcu7t3v3__inv_2
Xgf180mcu_as_sc_mcu7t3v3__inv_2_1638 gf180mcu_as_sc_mcu7t3v3__inv_2_1638/VDD VSS gf180mcu_as_sc_mcu7t3v3__inv_2_1689/A
+ VSS gf180mcu_as_sc_mcu7t3v3__inv_2_1638/VNW VSUBS gf180mcu_as_sc_mcu7t3v3__inv_2
Xgf180mcu_as_sc_mcu7t3v3__inv_2_1649 gf180mcu_as_sc_mcu7t3v3__inv_2_1649/VDD gf180mcu_as_sc_mcu7t3v3__inv_2_1665/VDD
+ gf180mcu_as_sc_mcu7t3v3__inv_2_1689/A VSS gf180mcu_as_sc_mcu7t3v3__inv_2_1649/VNW
+ VSUBS gf180mcu_as_sc_mcu7t3v3__inv_2
Xgf180mcu_as_sc_mcu7t3v3__inv_2_1627 gf180mcu_as_sc_mcu7t3v3__inv_2_1689/VSS VSS gf180mcu_as_sc_mcu7t3v3__inv_2_1689/A
+ VSS gf180mcu_as_sc_mcu7t3v3__inv_2_1627/VNW VSUBS gf180mcu_as_sc_mcu7t3v3__inv_2
Xgf180mcu_as_sc_mcu7t3v3__inv_2_1605 VSS gf180mcu_as_sc_mcu7t3v3__inv_2_1614/VDD gf180mcu_as_sc_mcu7t3v3__inv_2_1605/Y
+ gf180mcu_as_sc_mcu7t3v3__inv_2_1669/A gf180mcu_as_sc_mcu7t3v3__inv_2_1606/VNW VSUBS
+ gf180mcu_as_sc_mcu7t3v3__inv_2
Xgf180mcu_as_sc_mcu7t3v3__inv_2_1616 gf180mcu_as_sc_mcu7t3v3__inv_2_1618/VDD VSS VSS
+ gf180mcu_as_sc_mcu7t3v3__inv_2_1669/A gf180mcu_as_sc_mcu7t3v3__inv_2_1618/VNW VSUBS
+ gf180mcu_as_sc_mcu7t3v3__inv_2
Xu_t015_006 u_t015_006/c0_w0_bl u_t015_006/c0_w0_br u_t015_006/c0_w1_bl u_t015_006/c0_w1_br
+ u_t015_006/c0_r0_rbl u_t015_006/c0_r1_rbl u_t015_006/c1_w0_bl u_t015_006/c1_w0_br
+ u_t015_006/c1_w1_bl u_t015_006/c1_w1_br u_t015_006/c1_r0_rbl u_t015_006/c1_r1_rbl
+ u_t015_006/c2_w0_bl u_t015_006/c2_w0_br u_t015_006/c2_w1_bl u_t015_006/c2_w1_br
+ u_t015_006/c2_r0_rbl u_t015_006/c2_r1_rbl u_t015_006/c3_w0_bl u_t015_006/c3_w0_br
+ u_t015_006/c3_w1_bl u_t015_006/c3_w1_br u_t015_006/c3_r0_rbl u_t015_006/c3_r1_rbl
+ u_t015_006/r0_w0_wl u_t015_006/r0_w1_wl u_t015_006/r0_r0_rwl u_t015_006/r0_r1_rwl
+ u_t015_006/r1_w0_wl u_t015_006/r1_w1_wl u_t015_006/r1_r0_rwl u_t015_006/r1_r1_rwl
+ u_t015_006/r2_w0_wl u_t015_006/r2_w1_wl u_t015_006/r2_r0_rwl u_t015_006/r2_r1_rwl
+ u_t015_006/r3_w0_wl u_t015_006/r3_w1_wl u_t015_006/r3_r0_rwl u_t015_006/r3_r1_rwl
+ u_t015_006/VDD u_t015_009/VSS u_t015_006/m2_717_1265# u_t015_006/m2_603_2031# u_t015_006/m2_1290_336#
+ u_t015_006/m2_2000_2037# u_t015_006/m2_791_2909# u_t015_006/m2_7_2126# u_t015_006/m2_2154_2081#
+ u_t015_006/m2_1795_2037# u_t015_006/m2_871_303# u_t015_006/m2_431_438# u_t015_006/m2_1290_2898#
+ u_t015_006/m2_1714_1210# u_t015_006/m2_431_1982# u_t015_006/m2_512_1265# u_t015_006/m2_2573_2126#
+ u_t015_006/m2_603_1259# u_t015_006/m2_2074_2909# u_t015_006/m2_7_336# u_t015_006/m2_717_2037#
+ u_t015_006/m2_1886_2031# u_t015_006/m2_2573_336# u_t015_006/m2_7_2898# u_t015_006/m2_2000_1265#
+ u_t015_006/m2_512_2037# u_t015_006/m2_1795_1265# u_t015_006/m2_1714_1982# u_t015_006/m2_1886_1259#
+ u_t015_006/m2_1290_2126# u_t015_006/m2_1714_438# u_t015_006/m2_431_1210# u_t015_006/m2_2573_2898#
+ u_t015_006/m2_2154_303# u_t015_006/m2_871_2081# VSUBS detronyx_12t_2w2r_rc4_4x4_routed_5layer_direct
Xu_t030_009 u_t030_009/c0_w0_bl u_t030_009/c0_w0_br u_t030_009/c0_w1_bl u_t030_009/c0_w1_br
+ u_t030_009/c0_r0_rbl u_t030_009/c0_r1_rbl u_t030_009/c1_w0_bl u_t030_009/c1_w0_br
+ u_t030_009/c1_w1_bl u_t030_009/c1_w1_br u_t030_009/c1_r0_rbl u_t030_009/c1_r1_rbl
+ u_t030_009/c2_w0_bl u_t030_009/c2_w0_br u_t030_009/c2_w1_bl u_t030_009/c2_w1_br
+ u_t030_009/c2_r0_rbl u_t030_009/c2_r1_rbl u_t030_009/c3_w0_bl u_t030_009/c3_w0_br
+ u_t030_009/c3_w1_bl u_t030_009/c3_w1_br u_t030_009/c3_r0_rbl u_t030_009/c3_r1_rbl
+ u_t030_009/r0_w0_wl u_t030_009/r0_w1_wl u_t030_009/r0_r0_rwl u_t030_009/r0_r1_rwl
+ u_t030_009/r1_w0_wl u_t030_009/r1_w1_wl u_t030_009/r1_r0_rwl u_t030_009/r1_r1_rwl
+ u_t030_009/r2_w0_wl u_t030_009/r2_w1_wl u_t030_009/r2_r0_rwl u_t030_009/r2_r1_rwl
+ u_t030_009/r3_w0_wl u_t030_009/r3_w1_wl u_t030_009/r3_r0_rwl u_t030_009/r3_r1_rwl
+ VSS VSS u_t030_009/m2_717_1265# u_t030_009/m2_603_2031# u_t030_009/m2_1290_336#
+ u_t030_009/m2_2000_2037# u_t030_009/m2_791_2909# u_t030_009/m2_7_2126# u_t030_009/m2_2154_2081#
+ u_t030_009/m2_1795_2037# u_t030_009/m2_871_303# u_t030_009/m2_431_438# u_t030_009/m2_1290_2898#
+ u_t030_009/m2_1714_1210# u_t030_009/m2_431_1982# u_t030_009/m2_512_1265# u_t030_009/m2_2573_2126#
+ u_t030_009/m2_603_1259# u_t030_009/m2_2074_2909# u_t030_009/m2_7_336# u_t030_009/m2_717_2037#
+ u_t030_009/m2_1886_2031# u_t030_009/m2_2573_336# u_t030_009/m2_7_2898# u_t030_009/m2_2000_1265#
+ u_t030_009/m2_512_2037# u_t030_009/m2_1795_1265# u_t030_009/m2_1714_1982# u_t030_009/m2_1886_1259#
+ u_t030_009/m2_1290_2126# u_t030_009/m2_1714_438# u_t030_009/m2_431_1210# u_t030_009/m2_2573_2898#
+ u_t030_009/m2_2154_303# u_t030_009/m2_871_2081# VSUBS detronyx_12t_2w2r_rc4_4x4_routed_5layer_direct
Xu_t021_009 u_t021_009/c0_w0_bl u_t021_009/c0_w0_br u_t021_009/c0_w1_bl u_t021_009/c0_w1_br
+ u_t021_009/c0_r0_rbl u_t021_009/c0_r1_rbl u_t021_009/c1_w0_bl u_t021_009/c1_w0_br
+ u_t021_009/c1_w1_bl u_t021_009/c1_w1_br u_t021_009/c1_r0_rbl u_t021_009/c1_r1_rbl
+ u_t021_009/c2_w0_bl u_t021_009/c2_w0_br u_t021_009/c2_w1_bl u_t021_009/c2_w1_br
+ u_t021_009/c2_r0_rbl u_t021_009/c2_r1_rbl u_t021_009/c3_w0_bl u_t021_009/c3_w0_br
+ u_t021_009/c3_w1_bl u_t021_009/c3_w1_br u_t021_009/c3_r0_rbl u_t021_009/c3_r1_rbl
+ u_t021_009/r0_w0_wl u_t021_009/r0_w1_wl u_t021_009/r0_r0_rwl u_t021_009/r0_r1_rwl
+ u_t021_009/r1_w0_wl u_t021_009/r1_w1_wl u_t021_009/r1_r0_rwl u_t021_009/r1_r1_rwl
+ u_t021_009/r2_w0_wl u_t021_009/r2_w1_wl u_t021_009/r2_r0_rwl u_t021_009/r2_r1_rwl
+ u_t021_009/r3_w0_wl u_t021_009/r3_w1_wl u_t021_009/r3_r0_rwl u_t021_009/r3_r1_rwl
+ VSS VSS u_t021_009/m2_717_1265# u_t021_009/m2_603_2031# u_t021_009/m2_1290_336#
+ u_t021_009/m2_2000_2037# u_t021_009/m2_791_2909# u_t021_009/m2_7_2126# u_t021_009/m2_2154_2081#
+ u_t021_009/m2_1795_2037# u_t021_009/m2_871_303# u_t021_009/m2_431_438# u_t021_009/m2_1290_2898#
+ u_t021_009/m2_1714_1210# u_t021_009/m2_431_1982# u_t021_009/m2_512_1265# u_t021_009/m2_2573_2126#
+ u_t021_009/m2_603_1259# u_t021_009/m2_2074_2909# u_t021_009/m2_7_336# u_t021_009/m2_717_2037#
+ u_t021_009/m2_1886_2031# u_t021_009/m2_2573_336# u_t021_009/m2_7_2898# u_t021_009/m2_2000_1265#
+ u_t021_009/m2_512_2037# u_t021_009/m2_1795_1265# u_t021_009/m2_1714_1982# u_t021_009/m2_1886_1259#
+ u_t021_009/m2_1290_2126# u_t021_009/m2_1714_438# u_t021_009/m2_431_1210# u_t021_009/m2_2573_2898#
+ u_t021_009/m2_2154_303# u_t021_009/m2_871_2081# VSUBS detronyx_12t_2w2r_rc4_4x4_routed_5layer_direct
Xu_t006_006 u_t006_006/c0_w0_bl u_t006_006/c0_w0_br u_t006_006/c0_w1_bl u_t006_006/c0_w1_br
+ u_t006_006/c0_r0_rbl u_t006_006/c0_r1_rbl u_t006_006/c1_w0_bl u_t006_006/c1_w0_br
+ u_t006_006/c1_w1_bl u_t006_006/c1_w1_br u_t006_006/c1_r0_rbl u_t006_006/c1_r1_rbl
+ u_t006_006/c2_w0_bl u_t006_006/c2_w0_br u_t006_006/c2_w1_bl u_t006_006/c2_w1_br
+ u_t006_006/c2_r0_rbl u_t006_006/c2_r1_rbl u_t006_006/c3_w0_bl u_t006_006/c3_w0_br
+ u_t006_006/c3_w1_bl u_t006_006/c3_w1_br u_t006_006/c3_r0_rbl u_t006_006/c3_r1_rbl
+ u_t006_006/r0_w0_wl u_t006_006/r0_w1_wl u_t006_006/r0_r0_rwl u_t006_006/r0_r1_rwl
+ u_t006_006/r1_w0_wl u_t006_006/r1_w1_wl u_t006_006/r1_r0_rwl u_t006_006/r1_r1_rwl
+ u_t006_006/r2_w0_wl u_t006_006/r2_w1_wl u_t006_006/r2_r0_rwl u_t006_006/r2_r1_rwl
+ u_t006_006/r3_w0_wl u_t006_006/r3_w1_wl u_t006_006/r3_r0_rwl u_t006_006/r3_r1_rwl
+ u_t006_006/VDD u_t006_009/VSS u_t006_006/m2_717_1265# u_t006_006/m2_603_2031# u_t006_006/m2_1290_336#
+ u_t006_006/m2_2000_2037# u_t006_006/m2_791_2909# u_t006_006/m2_7_2126# u_t006_006/m2_2154_2081#
+ u_t006_006/m2_1795_2037# u_t006_006/m2_871_303# u_t006_006/m2_431_438# u_t006_006/m2_1290_2898#
+ u_t006_006/m2_1714_1210# u_t006_006/m2_431_1982# u_t006_006/m2_512_1265# u_t006_006/m2_2573_2126#
+ u_t006_006/m2_603_1259# u_t006_006/m2_2074_2909# u_t006_006/m2_7_336# u_t006_006/m2_717_2037#
+ u_t006_006/m2_1886_2031# u_t006_006/m2_2573_336# u_t006_006/m2_7_2898# u_t006_006/m2_2000_1265#
+ u_t006_006/m2_512_2037# u_t006_006/m2_1795_1265# u_t006_006/m2_1714_1982# u_t006_006/m2_1886_1259#
+ u_t006_006/m2_1290_2126# u_t006_006/m2_1714_438# u_t006_006/m2_431_1210# u_t006_006/m2_2573_2898#
+ u_t006_006/m2_2154_303# u_t006_006/m2_871_2081# VSUBS detronyx_12t_2w2r_rc4_4x4_routed_5layer_direct
Xgf180mcu_as_sc_mcu7t3v3__nand2_2_51 gf180mcu_as_sc_mcu7t3v3__nand3_2_65/VDD gf180mcu_as_sc_mcu7t3v3__nor2_2_9/VSS
+ VSS VSS VSS gf180mcu_as_sc_mcu7t3v3__nand3_2_65/VNW VSUBS gf180mcu_as_sc_mcu7t3v3__nand2_2
Xgf180mcu_as_sc_mcu7t3v3__nand2_2_40 gf180mcu_as_sc_mcu7t3v3__nand3_2_65/VDD gf180mcu_as_sc_mcu7t3v3__nand3_2_62/VSS
+ VSS VSS VSS gf180mcu_as_sc_mcu7t3v3__nand3_2_65/VNW VSUBS gf180mcu_as_sc_mcu7t3v3__nand2_2
Xu_t012_009 u_t012_009/c0_w0_bl u_t012_009/c0_w0_br u_t012_009/c0_w1_bl u_t012_009/c0_w1_br
+ u_t012_009/c0_r0_rbl u_t012_009/c0_r1_rbl u_t012_009/c1_w0_bl u_t012_009/c1_w0_br
+ u_t012_009/c1_w1_bl u_t012_009/c1_w1_br u_t012_009/c1_r0_rbl u_t012_009/c1_r1_rbl
+ u_t012_009/c2_w0_bl u_t012_009/c2_w0_br u_t012_009/c2_w1_bl u_t012_009/c2_w1_br
+ u_t012_009/c2_r0_rbl u_t012_009/c2_r1_rbl u_t012_009/c3_w0_bl u_t012_009/c3_w0_br
+ u_t012_009/c3_w1_bl u_t012_009/c3_w1_br u_t012_009/c3_r0_rbl u_t012_009/c3_r1_rbl
+ u_t012_009/r0_w0_wl u_t012_009/r0_w1_wl u_t012_009/r0_r0_rwl u_t012_009/r0_r1_rwl
+ u_t012_009/r1_w0_wl u_t012_009/r1_w1_wl u_t012_009/r1_r0_rwl u_t012_009/r1_r1_rwl
+ u_t012_009/r2_w0_wl u_t012_009/r2_w1_wl u_t012_009/r2_r0_rwl u_t012_009/r2_r1_rwl
+ u_t012_009/r3_w0_wl u_t012_009/r3_w1_wl u_t012_009/r3_r0_rwl u_t012_009/r3_r1_rwl
+ VSS VSS u_t012_009/m2_717_1265# u_t012_009/m2_603_2031# u_t012_009/m2_1290_336#
+ u_t012_009/m2_2000_2037# u_t012_009/m2_791_2909# u_t012_009/m2_7_2126# u_t012_009/m2_2154_2081#
+ u_t012_009/m2_1795_2037# u_t012_009/m2_871_303# u_t012_009/m2_431_438# u_t012_009/m2_1290_2898#
+ u_t012_009/m2_1714_1210# u_t012_009/m2_431_1982# u_t012_009/m2_512_1265# u_t012_009/m2_2573_2126#
+ u_t012_009/m2_603_1259# u_t012_009/m2_2074_2909# u_t012_009/m2_7_336# u_t012_009/m2_717_2037#
+ u_t012_009/m2_1886_2031# u_t012_009/m2_2573_336# u_t012_009/m2_7_2898# u_t012_009/m2_2000_1265#
+ u_t012_009/m2_512_2037# u_t012_009/m2_1795_1265# u_t012_009/m2_1714_1982# u_t012_009/m2_1886_1259#
+ u_t012_009/m2_1290_2126# u_t012_009/m2_1714_438# u_t012_009/m2_431_1210# u_t012_009/m2_2573_2898#
+ u_t012_009/m2_2154_303# u_t012_009/m2_871_2081# VSUBS detronyx_12t_2w2r_rc4_4x4_routed_5layer_direct
Xgf180mcu_as_sc_mcu7t3v3__inv_2_1402 VSS gf180mcu_as_sc_mcu7t3v3__inv_2_1406/VDD gf180mcu_as_sc_mcu7t3v3__inv_2_1409/A
+ VSS gf180mcu_as_sc_mcu7t3v3__inv_2_1402/VNW VSUBS gf180mcu_as_sc_mcu7t3v3__inv_2
Xgf180mcu_as_sc_mcu7t3v3__inv_2_1413 gf180mcu_as_sc_mcu7t3v3__inv_2_1457/VSS gf180mcu_as_sc_mcu7t3v3__inv_2_1416/VDD
+ gf180mcu_as_sc_mcu7t3v3__inv_2_1413/Y VSS gf180mcu_as_sc_mcu7t3v3__inv_2_1413/VNW
+ VSUBS gf180mcu_as_sc_mcu7t3v3__inv_2
Xgf180mcu_as_sc_mcu7t3v3__inv_2_1435 VSS VSS VSS VSS gf180mcu_as_sc_mcu7t3v3__inv_2_1437/VNW
+ VSUBS gf180mcu_as_sc_mcu7t3v3__inv_2
Xgf180mcu_as_sc_mcu7t3v3__inv_2_1424 gf180mcu_as_sc_mcu7t3v3__inv_2_1511/VSS VSS gf180mcu_as_sc_mcu7t3v3__inv_2_1424/Y
+ VSS gf180mcu_as_sc_mcu7t3v3__inv_2_1425/VNW VSUBS gf180mcu_as_sc_mcu7t3v3__inv_2
Xgf180mcu_as_sc_mcu7t3v3__inv_2_1468 gf180mcu_as_sc_mcu7t3v3__inv_2_1470/VDD gf180mcu_as_sc_mcu7t3v3__inv_2_1473/VDD
+ VSS VSS gf180mcu_as_sc_mcu7t3v3__inv_2_1470/VNW VSUBS gf180mcu_as_sc_mcu7t3v3__inv_2
Xgf180mcu_as_sc_mcu7t3v3__inv_2_1457 VSS gf180mcu_as_sc_mcu7t3v3__inv_2_1457/VSS VSS
+ VSS gf180mcu_as_sc_mcu7t3v3__inv_2_1457/VNW VSUBS gf180mcu_as_sc_mcu7t3v3__inv_2
Xgf180mcu_as_sc_mcu7t3v3__inv_2_1446 gf180mcu_as_sc_mcu7t3v3__inv_2_1446/VDD VSS VSS
+ VSS gf180mcu_as_sc_mcu7t3v3__inv_2_1446/VNW VSUBS gf180mcu_as_sc_mcu7t3v3__inv_2
Xgf180mcu_as_sc_mcu7t3v3__inv_2_1479 gf180mcu_as_sc_mcu7t3v3__inv_2_1508/VSS VSS VSS
+ VSS gf180mcu_as_sc_mcu7t3v3__inv_2_1479/VNW VSUBS gf180mcu_as_sc_mcu7t3v3__inv_2
Xu_t003_009 u_t003_009/c0_w0_bl u_t003_009/c0_w0_br u_t003_009/c0_w1_bl u_t003_009/c0_w1_br
+ u_t003_009/c0_r0_rbl u_t003_009/c0_r1_rbl u_t003_009/c1_w0_bl u_t003_009/c1_w0_br
+ u_t003_009/c1_w1_bl u_t003_009/c1_w1_br u_t003_009/c1_r0_rbl u_t003_009/c1_r1_rbl
+ u_t003_009/c2_w0_bl u_t003_009/c2_w0_br u_t003_009/c2_w1_bl u_t003_009/c2_w1_br
+ u_t003_009/c2_r0_rbl u_t003_009/c2_r1_rbl u_t003_009/c3_w0_bl u_t003_009/c3_w0_br
+ u_t003_009/c3_w1_bl u_t003_009/c3_w1_br u_t003_009/c3_r0_rbl u_t003_009/c3_r1_rbl
+ u_t003_009/r0_w0_wl u_t003_009/r0_w1_wl u_t003_009/r0_r0_rwl u_t003_009/r0_r1_rwl
+ u_t003_009/r1_w0_wl u_t003_009/r1_w1_wl u_t003_009/r1_r0_rwl u_t003_009/r1_r1_rwl
+ u_t003_009/r2_w0_wl u_t003_009/r2_w1_wl u_t003_009/r2_r0_rwl u_t003_009/r2_r1_rwl
+ u_t003_009/r3_w0_wl u_t003_009/r3_w1_wl u_t003_009/r3_r0_rwl u_t003_009/r3_r1_rwl
+ VSS u_t003_009/VSS u_t003_009/m2_717_1265# u_t003_009/m2_603_2031# u_t003_009/m2_1290_336#
+ u_t003_009/m2_2000_2037# u_t003_009/m2_791_2909# u_t003_009/m2_7_2126# u_t003_009/m2_2154_2081#
+ u_t003_009/m2_1795_2037# u_t003_009/m2_871_303# u_t003_009/m2_431_438# u_t003_009/m2_1290_2898#
+ u_t003_009/m2_1714_1210# u_t003_009/m2_431_1982# u_t003_009/m2_512_1265# u_t003_009/m2_2573_2126#
+ u_t003_009/m2_603_1259# u_t003_009/m2_2074_2909# u_t003_009/m2_7_336# u_t003_009/m2_717_2037#
+ u_t003_009/m2_1886_2031# u_t003_009/m2_2573_336# u_t003_009/m2_7_2898# u_t003_009/m2_2000_1265#
+ u_t003_009/m2_512_2037# u_t003_009/m2_1795_1265# u_t003_009/m2_1714_1982# u_t003_009/m2_1886_1259#
+ u_t003_009/m2_1290_2126# u_t003_009/m2_1714_438# u_t003_009/m2_431_1210# u_t003_009/m2_2573_2898#
+ u_t003_009/m2_2154_303# u_t003_009/m2_871_2081# VSUBS detronyx_12t_2w2r_rc4_4x4_routed_5layer_direct
Xgf180mcu_as_sc_mcu7t3v3__inv_2_919 VSS VSS VSS VSS gf180mcu_as_sc_mcu7t3v3__inv_2_947/VNW
+ VSUBS gf180mcu_as_sc_mcu7t3v3__inv_2
Xgf180mcu_as_sc_mcu7t3v3__inv_2_908 VSS VSS gf180mcu_as_sc_mcu7t3v3__inv_2_908/Y VSS
+ gf180mcu_as_sc_mcu7t3v3__inv_2_953/VNW VSUBS gf180mcu_as_sc_mcu7t3v3__inv_2
Xgf180mcu_as_sc_mcu7t3v3__nand4_2_218 VSS VSS VSS VSS VSS VSS gf180mcu_as_sc_mcu7t3v3__nand4_2_218/Y
+ gf180mcu_as_sc_mcu7t3v3__inv_2_836/VNW VSUBS gf180mcu_as_sc_mcu7t3v3__nand4_2
Xgf180mcu_as_sc_mcu7t3v3__nand4_2_207 gf180mcu_as_sc_mcu7t3v3__inv_2_746/VSS gf180mcu_as_sc_mcu7t3v3__inv_2_674/VDD
+ VSS VSS VSS VSS VSS gf180mcu_as_sc_mcu7t3v3__inv_2_670/VNW VSUBS gf180mcu_as_sc_mcu7t3v3__nand4_2
Xgf180mcu_as_sc_mcu7t3v3__nand4_2_229 VSS VSS VSS VSS VSS VSS gf180mcu_as_sc_mcu7t3v3__nand4_2_229/Y
+ gf180mcu_as_sc_mcu7t3v3__inv_2_827/VNW VSUBS gf180mcu_as_sc_mcu7t3v3__nand4_2
Xgf180mcu_as_sc_mcu7t3v3__inv_2_1243 gf180mcu_as_sc_mcu7t3v3__nor2_2_9/VDD gf180mcu_as_sc_mcu7t3v3__nand3_2_63/VSS
+ VSS VSS gf180mcu_as_sc_mcu7t3v3__nor2_2_9/VNW VSUBS gf180mcu_as_sc_mcu7t3v3__inv_2
Xgf180mcu_as_sc_mcu7t3v3__inv_2_1254 gf180mcu_as_sc_mcu7t3v3__nor2_2_9/VDD gf180mcu_as_sc_mcu7t3v3__nor2_2_9/VSS
+ VSS VSS gf180mcu_as_sc_mcu7t3v3__nor2_2_9/VNW VSUBS gf180mcu_as_sc_mcu7t3v3__inv_2
Xgf180mcu_as_sc_mcu7t3v3__inv_2_1232 gf180mcu_as_sc_mcu7t3v3__nand3_2_65/VDD gf180mcu_as_sc_mcu7t3v3__nand3_2_62/VSS
+ VSS VSS gf180mcu_as_sc_mcu7t3v3__nand3_2_65/VNW VSUBS gf180mcu_as_sc_mcu7t3v3__inv_2
Xgf180mcu_as_sc_mcu7t3v3__inv_2_1265 gf180mcu_as_sc_mcu7t3v3__nand3_2_65/VDD gf180mcu_as_sc_mcu7t3v3__nand3_2_62/VSS
+ VSS VSS gf180mcu_as_sc_mcu7t3v3__nand3_2_65/VNW VSUBS gf180mcu_as_sc_mcu7t3v3__inv_2
Xgf180mcu_as_sc_mcu7t3v3__inv_2_1210 gf180mcu_as_sc_mcu7t3v3__nand3_2_65/VDD gf180mcu_as_sc_mcu7t3v3__nand3_2_62/VSS
+ VSS VSS gf180mcu_as_sc_mcu7t3v3__nand3_2_65/VNW VSUBS gf180mcu_as_sc_mcu7t3v3__inv_2
Xgf180mcu_as_sc_mcu7t3v3__inv_2_1221 VSS VSS VSS VSS gf180mcu_as_sc_mcu7t3v3__inv_2_1275/VNW
+ VSUBS gf180mcu_as_sc_mcu7t3v3__inv_2
Xgf180mcu_as_sc_mcu7t3v3__inv_2_1276 VSS VSS VSS VSS gf180mcu_as_sc_mcu7t3v3__inv_2_1276/VNW
+ VSUBS gf180mcu_as_sc_mcu7t3v3__inv_2
Xgf180mcu_as_sc_mcu7t3v3__inv_2_1287 VSS VSS VSS VSS gf180mcu_as_sc_mcu7t3v3__inv_2_1287/VNW
+ VSUBS gf180mcu_as_sc_mcu7t3v3__inv_2
Xgf180mcu_as_sc_mcu7t3v3__inv_2_1298 VSS VSS VSS VSS gf180mcu_as_sc_mcu7t3v3__inv_2_1298/VNW
+ VSUBS gf180mcu_as_sc_mcu7t3v3__inv_2
Xgf180mcu_as_sc_mcu7t3v3__inv_2_727 gf180mcu_as_sc_mcu7t3v3__inv_2_746/VDD gf180mcu_as_sc_mcu7t3v3__inv_2_746/VDD
+ gf180mcu_as_sc_mcu7t3v3__inv_2_744/A gf180mcu_as_sc_mcu7t3v3__inv_2_728/Y gf180mcu_as_sc_mcu7t3v3__inv_2_728/VNW
+ VSUBS gf180mcu_as_sc_mcu7t3v3__inv_2
Xgf180mcu_as_sc_mcu7t3v3__inv_2_716 VSS VSS gf180mcu_as_sc_mcu7t3v3__inv_2_716/Y VSS
+ gf180mcu_as_sc_mcu7t3v3__inv_2_716/VNW VSUBS gf180mcu_as_sc_mcu7t3v3__inv_2
Xgf180mcu_as_sc_mcu7t3v3__inv_2_705 gf180mcu_as_sc_mcu7t3v3__inv_2_741/VDD VSS gf180mcu_as_sc_mcu7t3v3__inv_2_705/Y
+ VSS gf180mcu_as_sc_mcu7t3v3__inv_2_741/VNW VSUBS gf180mcu_as_sc_mcu7t3v3__inv_2
Xgf180mcu_as_sc_mcu7t3v3__inv_2_749 VSS VSS VSS VSS gf180mcu_as_sc_mcu7t3v3__inv_2_829/VNW
+ VSUBS gf180mcu_as_sc_mcu7t3v3__inv_2
Xgf180mcu_as_sc_mcu7t3v3__inv_2_738 VSS gf180mcu_as_sc_mcu7t3v3__inv_2_743/VDD gf180mcu_as_sc_mcu7t3v3__inv_2_738/Y
+ gf180mcu_as_sc_mcu7t3v3__inv_2_742/A gf180mcu_as_sc_mcu7t3v3__inv_2_740/VNW VSUBS
+ gf180mcu_as_sc_mcu7t3v3__inv_2
Xgf180mcu_as_sc_mcu7t3v3__inv_2_70 VSS gf180mcu_as_sc_mcu7t3v3__inv_2_0/VSS VSS gf180mcu_as_sc_mcu7t3v3__inv_2_9/Y
+ gf180mcu_as_sc_mcu7t3v3__inv_2_0/VNW VSUBS gf180mcu_as_sc_mcu7t3v3__inv_2
Xgf180mcu_as_sc_mcu7t3v3__inv_2_1084 VSS gf180mcu_as_sc_mcu7t3v3__inv_2_1100/VSS VSS
+ gf180mcu_as_sc_mcu7t3v3__inv_2_1149/A gf180mcu_as_sc_mcu7t3v3__inv_2_1100/VNW VSUBS
+ gf180mcu_as_sc_mcu7t3v3__inv_2
Xgf180mcu_as_sc_mcu7t3v3__inv_2_1073 gf180mcu_as_sc_mcu7t3v3__inv_2_1075/VDD gf180mcu_as_sc_mcu7t3v3__inv_2_1079/VDD
+ VSS gf180mcu_as_sc_mcu7t3v3__inv_2_1149/A gf180mcu_as_sc_mcu7t3v3__inv_2_1075/VNW
+ VSUBS gf180mcu_as_sc_mcu7t3v3__inv_2
Xgf180mcu_as_sc_mcu7t3v3__inv_2_1095 VSS VSS gf180mcu_as_sc_mcu7t3v3__inv_2_1095/Y
+ VSS gf180mcu_as_sc_mcu7t3v3__inv_2_1095/VNW VSUBS gf180mcu_as_sc_mcu7t3v3__inv_2
Xgf180mcu_as_sc_mcu7t3v3__inv_2_1062 gf180mcu_as_sc_mcu7t3v3__inv_2_1111/VSS VSS VSS
+ gf180mcu_as_sc_mcu7t3v3__inv_2_1109/A gf180mcu_as_sc_mcu7t3v3__inv_2_1064/VNW VSUBS
+ gf180mcu_as_sc_mcu7t3v3__inv_2
Xgf180mcu_as_sc_mcu7t3v3__inv_2_1040 VSS VSS gf180mcu_as_sc_mcu7t3v3__inv_2_1040/Y
+ VSS gf180mcu_as_sc_mcu7t3v3__inv_2_1040/VNW VSUBS gf180mcu_as_sc_mcu7t3v3__inv_2
Xgf180mcu_as_sc_mcu7t3v3__inv_2_1051 gf180mcu_as_sc_mcu7t3v3__inv_2_1052/VDD VSS gf180mcu_as_sc_mcu7t3v3__inv_2_962/A
+ gf180mcu_as_sc_mcu7t3v3__inv_2_1052/Y gf180mcu_as_sc_mcu7t3v3__inv_2_1052/VNW VSUBS
+ gf180mcu_as_sc_mcu7t3v3__inv_2
Xgf180mcu_as_sc_mcu7t3v3__inv_2_81 gf180mcu_as_sc_mcu7t3v3__inv_2_99/VSS gf180mcu_as_sc_mcu7t3v3__inv_2_94/VDD
+ gf180mcu_as_sc_mcu7t3v3__inv_2_81/Y VSS gf180mcu_as_sc_mcu7t3v3__inv_2_81/VNW VSUBS
+ gf180mcu_as_sc_mcu7t3v3__inv_2
Xgf180mcu_as_sc_mcu7t3v3__inv_2_92 gf180mcu_as_sc_mcu7t3v3__inv_2_94/VDD gf180mcu_as_sc_mcu7t3v3__inv_2_94/VDD
+ VSS VSS gf180mcu_as_sc_mcu7t3v3__inv_2_92/VNW VSUBS gf180mcu_as_sc_mcu7t3v3__inv_2
Xgf180mcu_as_sc_mcu7t3v3__nand4_2_7 gf180mcu_as_sc_mcu7t3v3__inv_2_97/VDD gf180mcu_as_sc_mcu7t3v3__inv_2_98/VDD
+ VSS VSS VSS VSS gf180mcu_as_sc_mcu7t3v3__nand4_2_7/Y gf180mcu_as_sc_mcu7t3v3__inv_2_97/VNW
+ VSUBS gf180mcu_as_sc_mcu7t3v3__nand4_2
Xgf180mcu_as_sc_mcu7t3v3__inv_2_557 VSS VSS VSS VSS gf180mcu_as_sc_mcu7t3v3__inv_2_557/VNW
+ VSUBS gf180mcu_as_sc_mcu7t3v3__inv_2
Xgf180mcu_as_sc_mcu7t3v3__inv_2_513 VSS VSS VSS VSS gf180mcu_as_sc_mcu7t3v3__inv_2_558/VNW
+ VSUBS gf180mcu_as_sc_mcu7t3v3__inv_2
Xgf180mcu_as_sc_mcu7t3v3__inv_2_546 VSS VSS VSS VSS gf180mcu_as_sc_mcu7t3v3__inv_2_546/VNW
+ VSUBS gf180mcu_as_sc_mcu7t3v3__inv_2
Xgf180mcu_as_sc_mcu7t3v3__inv_2_568 gf180mcu_as_sc_mcu7t3v3__inv_2_570/VDD gf180mcu_as_sc_mcu7t3v3__inv_2_576/VDD
+ gf180mcu_as_sc_mcu7t3v3__inv_2_568/Y gf180mcu_as_sc_mcu7t3v3__inv_2_590/Y gf180mcu_as_sc_mcu7t3v3__inv_2_570/VNW
+ VSUBS gf180mcu_as_sc_mcu7t3v3__inv_2
Xgf180mcu_as_sc_mcu7t3v3__inv_2_579 gf180mcu_as_sc_mcu7t3v3__inv_2_579/VDD gf180mcu_as_sc_mcu7t3v3__inv_2_584/VDD
+ gf180mcu_as_sc_mcu7t3v3__inv_2_579/Y VSS gf180mcu_as_sc_mcu7t3v3__inv_2_579/VNW
+ VSUBS gf180mcu_as_sc_mcu7t3v3__inv_2
Xgf180mcu_as_sc_mcu7t3v3__inv_2_535 gf180mcu_as_sc_mcu7t3v3__nor2_2_6/VDD gf180mcu_as_sc_mcu7t3v3__nand3_2_4/VSS
+ VSS VSS gf180mcu_as_sc_mcu7t3v3__nor2_2_6/VNW VSUBS gf180mcu_as_sc_mcu7t3v3__inv_2
Xgf180mcu_as_sc_mcu7t3v3__inv_2_524 gf180mcu_as_sc_mcu7t3v3__nand3_2_9/VDD gf180mcu_as_sc_mcu7t3v3__nor2_2_7/VSS
+ VSS VSS gf180mcu_as_sc_mcu7t3v3__nand3_2_9/VNW VSUBS gf180mcu_as_sc_mcu7t3v3__inv_2
Xgf180mcu_as_sc_mcu7t3v3__inv_2_502 VSS VSS VSS VSS gf180mcu_as_sc_mcu7t3v3__inv_2_536/VNW
+ VSUBS gf180mcu_as_sc_mcu7t3v3__inv_2
Xgf180mcu_as_sc_mcu7t3v3__nand4_2_390 VSS gf180mcu_as_sc_mcu7t3v3__inv_2_1443/VDD
+ VSS VSS VSS VSS gf180mcu_as_sc_mcu7t3v3__nand4_2_390/Y gf180mcu_as_sc_mcu7t3v3__inv_2_1440/VNW
+ VSUBS gf180mcu_as_sc_mcu7t3v3__nand4_2
Xgf180mcu_as_sc_mcu7t3v3__inv_2_387 gf180mcu_as_sc_mcu7t3v3__nor2_2_7/VDD gf180mcu_as_sc_mcu7t3v3__nand3_2_4/VSS
+ VSS VSS gf180mcu_as_sc_mcu7t3v3__nor2_2_7/VNW VSUBS gf180mcu_as_sc_mcu7t3v3__inv_2
Xgf180mcu_as_sc_mcu7t3v3__inv_2_376 gf180mcu_as_sc_mcu7t3v3__nor2_2_4/VDD gf180mcu_as_sc_mcu7t3v3__nand2_2_3/VSS
+ VSS VSS gf180mcu_as_sc_mcu7t3v3__nor2_2_4/VNW VSUBS gf180mcu_as_sc_mcu7t3v3__inv_2
Xgf180mcu_as_sc_mcu7t3v3__inv_2_398 gf180mcu_as_sc_mcu7t3v3__nor2_2_4/VDD gf180mcu_as_sc_mcu7t3v3__nand2_2_3/VSS
+ VSS VSS gf180mcu_as_sc_mcu7t3v3__nor2_2_4/VNW VSUBS gf180mcu_as_sc_mcu7t3v3__inv_2
Xgf180mcu_as_sc_mcu7t3v3__inv_2_310 gf180mcu_as_sc_mcu7t3v3__inv_2_311/VDD gf180mcu_as_sc_mcu7t3v3__inv_2_311/VSS
+ gf180mcu_as_sc_mcu7t3v3__inv_2_365/Y gf180mcu_as_sc_mcu7t3v3__inv_2_365/Y gf180mcu_as_sc_mcu7t3v3__inv_2_311/VNW
+ VSUBS gf180mcu_as_sc_mcu7t3v3__inv_2
Xgf180mcu_as_sc_mcu7t3v3__inv_2_365 gf180mcu_as_sc_mcu7t3v3__inv_2_365/VDD gf180mcu_as_sc_mcu7t3v3__inv_2_365/VSS
+ gf180mcu_as_sc_mcu7t3v3__inv_2_365/Y VSS gf180mcu_as_sc_mcu7t3v3__inv_2_365/VNW
+ VSUBS gf180mcu_as_sc_mcu7t3v3__inv_2
Xgf180mcu_as_sc_mcu7t3v3__inv_2_354 VSS VSS VSS gf180mcu_as_sc_mcu7t3v3__inv_2_359/Y
+ gf180mcu_as_sc_mcu7t3v3__inv_2_356/VNW VSUBS gf180mcu_as_sc_mcu7t3v3__inv_2
Xgf180mcu_as_sc_mcu7t3v3__inv_2_343 VSS VSS gf180mcu_as_sc_mcu7t3v3__inv_2_350/Y gf180mcu_as_sc_mcu7t3v3__inv_2_350/Y
+ gf180mcu_as_sc_mcu7t3v3__inv_2_344/VNW VSUBS gf180mcu_as_sc_mcu7t3v3__inv_2
Xgf180mcu_as_sc_mcu7t3v3__inv_2_332 gf180mcu_as_sc_mcu7t3v3__inv_2_332/VDD VSS gf180mcu_as_sc_mcu7t3v3__inv_2_341/Y
+ VSS gf180mcu_as_sc_mcu7t3v3__inv_2_332/VNW VSUBS gf180mcu_as_sc_mcu7t3v3__inv_2
Xgf180mcu_as_sc_mcu7t3v3__inv_2_321 gf180mcu_as_sc_mcu7t3v3__inv_2_323/VDD VSS VSS
+ gf180mcu_as_sc_mcu7t3v3__inv_2_341/Y gf180mcu_as_sc_mcu7t3v3__inv_2_323/VNW VSUBS
+ gf180mcu_as_sc_mcu7t3v3__inv_2
Xu_t027_015 u_t027_015/c0_w0_bl u_t027_015/c0_w0_br u_t027_015/c0_w1_bl u_t027_015/c0_w1_br
+ u_t027_015/c0_r0_rbl u_t027_015/c0_r1_rbl u_t027_015/c1_w0_bl u_t027_015/c1_w0_br
+ u_t027_015/c1_w1_bl u_t027_015/c1_w1_br u_t027_015/c1_r0_rbl u_t027_015/c1_r1_rbl
+ u_t027_015/c2_w0_bl u_t027_015/c2_w0_br u_t027_015/c2_w1_bl u_t027_015/c2_w1_br
+ u_t027_015/c2_r0_rbl u_t027_015/c2_r1_rbl u_t027_015/c3_w0_bl u_t027_015/c3_w0_br
+ u_t027_015/c3_w1_bl u_t027_015/c3_w1_br u_t027_015/c3_r0_rbl u_t027_015/c3_r1_rbl
+ u_t027_015/r0_w0_wl u_t027_015/r0_w1_wl u_t027_015/r0_r0_rwl u_t027_015/r0_r1_rwl
+ u_t027_015/r1_w0_wl u_t027_015/r1_w1_wl u_t027_015/r1_r0_rwl u_t027_015/r1_r1_rwl
+ u_t027_015/r2_w0_wl u_t027_015/r2_w1_wl u_t027_015/r2_r0_rwl u_t027_015/r2_r1_rwl
+ u_t027_015/r3_w0_wl u_t027_015/r3_w1_wl u_t027_015/r3_r0_rwl u_t027_015/r3_r1_rwl
+ VSS u_t027_015/VSS u_t027_015/m2_717_1265# u_t027_015/m2_603_2031# u_t027_015/m2_1290_336#
+ u_t027_015/m2_2000_2037# u_t027_015/m2_791_2909# u_t027_015/m2_7_2126# u_t027_015/m2_2154_2081#
+ u_t027_015/m2_1795_2037# u_t027_015/m2_871_303# u_t027_015/m2_431_438# u_t027_015/m2_1290_2898#
+ u_t027_015/m2_1714_1210# u_t027_015/m2_431_1982# u_t027_015/m2_512_1265# u_t027_015/m2_2573_2126#
+ u_t027_015/m2_603_1259# u_t027_015/m2_2074_2909# u_t027_015/m2_7_336# u_t027_015/m2_717_2037#
+ u_t027_015/m2_1886_2031# u_t027_015/m2_2573_336# u_t027_015/m2_7_2898# u_t027_015/m2_2000_1265#
+ u_t027_015/m2_512_2037# u_t027_015/m2_1795_1265# u_t027_015/m2_1714_1982# u_t027_015/m2_1886_1259#
+ u_t027_015/m2_1290_2126# u_t027_015/m2_1714_438# u_t027_015/m2_431_1210# u_t027_015/m2_2573_2898#
+ u_t027_015/m2_2154_303# u_t027_015/m2_871_2081# VSUBS detronyx_12t_2w2r_rc4_4x4_routed_5layer_direct
Xu_t027_004 u_t027_004/c0_w0_bl u_t027_004/c0_w0_br u_t027_004/c0_w1_bl u_t027_004/c0_w1_br
+ u_t027_004/c0_r0_rbl u_t027_004/c0_r1_rbl u_t027_004/c1_w0_bl u_t027_004/c1_w0_br
+ u_t027_004/c1_w1_bl u_t027_004/c1_w1_br u_t027_004/c1_r0_rbl u_t027_004/c1_r1_rbl
+ u_t027_004/c2_w0_bl u_t027_004/c2_w0_br u_t027_004/c2_w1_bl u_t027_004/c2_w1_br
+ u_t027_004/c2_r0_rbl u_t027_004/c2_r1_rbl u_t027_004/c3_w0_bl u_t027_004/c3_w0_br
+ u_t027_004/c3_w1_bl u_t027_004/c3_w1_br u_t027_004/c3_r0_rbl u_t027_004/c3_r1_rbl
+ u_t027_004/r0_w0_wl u_t027_004/r0_w1_wl u_t027_004/r0_r0_rwl u_t027_004/r0_r1_rwl
+ u_t027_004/r1_w0_wl u_t027_004/r1_w1_wl u_t027_004/r1_r0_rwl u_t027_004/r1_r1_rwl
+ u_t027_004/r2_w0_wl u_t027_004/r2_w1_wl u_t027_004/r2_r0_rwl u_t027_004/r2_r1_rwl
+ u_t027_004/r3_w0_wl u_t027_004/r3_w1_wl u_t027_004/r3_r0_rwl u_t027_004/r3_r1_rwl
+ u_t027_004/VDD u_t027_004/VSS u_t027_004/m2_717_1265# u_t027_004/m2_603_2031# u_t027_004/m2_1290_336#
+ u_t027_004/m2_2000_2037# u_t027_004/m2_791_2909# u_t027_004/m2_7_2126# u_t027_004/m2_2154_2081#
+ u_t027_004/m2_1795_2037# u_t027_004/m2_871_303# u_t027_004/m2_431_438# u_t027_004/m2_1290_2898#
+ u_t027_004/m2_1714_1210# u_t027_004/m2_431_1982# u_t027_004/m2_512_1265# u_t027_004/m2_2573_2126#
+ u_t027_004/m2_603_1259# u_t027_004/m2_2074_2909# u_t027_004/m2_7_336# u_t027_004/m2_717_2037#
+ u_t027_004/m2_1886_2031# u_t027_004/m2_2573_336# u_t027_004/m2_7_2898# u_t027_004/m2_2000_1265#
+ u_t027_004/m2_512_2037# u_t027_004/m2_1795_1265# u_t027_004/m2_1714_1982# u_t027_004/m2_1886_1259#
+ u_t027_004/m2_1290_2126# u_t027_004/m2_1714_438# u_t027_004/m2_431_1210# u_t027_004/m2_2573_2898#
+ u_t027_004/m2_2154_303# u_t027_004/m2_871_2081# VSUBS detronyx_12t_2w2r_rc4_4x4_routed_5layer_direct
Xu_t018_015 u_t018_015/c0_w0_bl u_t018_015/c0_w0_br u_t018_015/c0_w1_bl u_t018_015/c0_w1_br
+ u_t018_015/c0_r0_rbl u_t018_015/c0_r1_rbl u_t018_015/c1_w0_bl u_t018_015/c1_w0_br
+ u_t018_015/c1_w1_bl u_t018_015/c1_w1_br u_t018_015/c1_r0_rbl u_t018_015/c1_r1_rbl
+ u_t018_015/c2_w0_bl u_t018_015/c2_w0_br u_t018_015/c2_w1_bl u_t018_015/c2_w1_br
+ u_t018_015/c2_r0_rbl u_t018_015/c2_r1_rbl u_t018_015/c3_w0_bl u_t018_015/c3_w0_br
+ u_t018_015/c3_w1_bl u_t018_015/c3_w1_br u_t018_015/c3_r0_rbl u_t018_015/c3_r1_rbl
+ u_t018_015/r0_w0_wl u_t018_015/r0_w1_wl u_t018_015/r0_r0_rwl u_t018_015/r0_r1_rwl
+ u_t018_015/r1_w0_wl u_t018_015/r1_w1_wl u_t018_015/r1_r0_rwl u_t018_015/r1_r1_rwl
+ u_t018_015/r2_w0_wl u_t018_015/r2_w1_wl u_t018_015/r2_r0_rwl u_t018_015/r2_r1_rwl
+ u_t018_015/r3_w0_wl u_t018_015/r3_w1_wl u_t018_015/r3_r0_rwl u_t018_015/r3_r1_rwl
+ VSS u_t018_015/VSS u_t018_015/m2_717_1265# u_t018_015/m2_603_2031# u_t018_015/m2_1290_336#
+ u_t018_015/m2_2000_2037# u_t018_015/m2_791_2909# u_t018_015/m2_7_2126# u_t018_015/m2_2154_2081#
+ u_t018_015/m2_1795_2037# u_t018_015/m2_871_303# u_t018_015/m2_431_438# u_t018_015/m2_1290_2898#
+ u_t018_015/m2_1714_1210# u_t018_015/m2_431_1982# u_t018_015/m2_512_1265# u_t018_015/m2_2573_2126#
+ u_t018_015/m2_603_1259# u_t018_015/m2_2074_2909# u_t018_015/m2_7_336# u_t018_015/m2_717_2037#
+ u_t018_015/m2_1886_2031# u_t018_015/m2_2573_336# u_t018_015/m2_7_2898# u_t018_015/m2_2000_1265#
+ u_t018_015/m2_512_2037# u_t018_015/m2_1795_1265# u_t018_015/m2_1714_1982# u_t018_015/m2_1886_1259#
+ u_t018_015/m2_1290_2126# u_t018_015/m2_1714_438# u_t018_015/m2_431_1210# u_t018_015/m2_2573_2898#
+ u_t018_015/m2_2154_303# u_t018_015/m2_871_2081# VSUBS detronyx_12t_2w2r_rc4_4x4_routed_5layer_direct
Xu_t018_004 u_t018_004/c0_w0_bl u_t018_004/c0_w0_br u_t018_004/c0_w1_bl u_t018_004/c0_w1_br
+ u_t018_004/c0_r0_rbl u_t018_004/c0_r1_rbl u_t018_004/c1_w0_bl u_t018_004/c1_w0_br
+ u_t018_004/c1_w1_bl u_t018_004/c1_w1_br u_t018_004/c1_r0_rbl u_t018_004/c1_r1_rbl
+ u_t018_004/c2_w0_bl u_t018_004/c2_w0_br u_t018_004/c2_w1_bl u_t018_004/c2_w1_br
+ u_t018_004/c2_r0_rbl u_t018_004/c2_r1_rbl u_t018_004/c3_w0_bl u_t018_004/c3_w0_br
+ u_t018_004/c3_w1_bl u_t018_004/c3_w1_br u_t018_004/c3_r0_rbl u_t018_004/c3_r1_rbl
+ u_t018_004/r0_w0_wl u_t018_004/r0_w1_wl u_t018_004/r0_r0_rwl u_t018_004/r0_r1_rwl
+ u_t018_004/r1_w0_wl u_t018_004/r1_w1_wl u_t018_004/r1_r0_rwl u_t018_004/r1_r1_rwl
+ u_t018_004/r2_w0_wl u_t018_004/r2_w1_wl u_t018_004/r2_r0_rwl u_t018_004/r2_r1_rwl
+ u_t018_004/r3_w0_wl u_t018_004/r3_w1_wl u_t018_004/r3_r0_rwl u_t018_004/r3_r1_rwl
+ u_t018_004/VDD u_t018_004/VSS u_t018_004/m2_717_1265# u_t018_004/m2_603_2031# u_t018_004/m2_1290_336#
+ u_t018_004/m2_2000_2037# u_t018_004/m2_791_2909# u_t018_004/m2_7_2126# u_t018_004/m2_2154_2081#
+ u_t018_004/m2_1795_2037# u_t018_004/m2_871_303# u_t018_004/m2_431_438# u_t018_004/m2_1290_2898#
+ u_t018_004/m2_1714_1210# u_t018_004/m2_431_1982# u_t018_004/m2_512_1265# u_t018_004/m2_2573_2126#
+ u_t018_004/m2_603_1259# u_t018_004/m2_2074_2909# u_t018_004/m2_7_336# u_t018_004/m2_717_2037#
+ u_t018_004/m2_1886_2031# u_t018_004/m2_2573_336# u_t018_004/m2_7_2898# u_t018_004/m2_2000_1265#
+ u_t018_004/m2_512_2037# u_t018_004/m2_1795_1265# u_t018_004/m2_1714_1982# u_t018_004/m2_1886_1259#
+ u_t018_004/m2_1290_2126# u_t018_004/m2_1714_438# u_t018_004/m2_431_1210# u_t018_004/m2_2573_2898#
+ u_t018_004/m2_2154_303# u_t018_004/m2_871_2081# VSUBS detronyx_12t_2w2r_rc4_4x4_routed_5layer_direct
Xu_t009_015 u_t009_015/c0_w0_bl u_t009_015/c0_w0_br u_t009_015/c0_w1_bl u_t009_015/c0_w1_br
+ u_t009_015/c0_r0_rbl u_t009_015/c0_r1_rbl u_t009_015/c1_w0_bl u_t009_015/c1_w0_br
+ u_t009_015/c1_w1_bl u_t009_015/c1_w1_br u_t009_015/c1_r0_rbl u_t009_015/c1_r1_rbl
+ u_t009_015/c2_w0_bl u_t009_015/c2_w0_br u_t009_015/c2_w1_bl u_t009_015/c2_w1_br
+ u_t009_015/c2_r0_rbl u_t009_015/c2_r1_rbl u_t009_015/c3_w0_bl u_t009_015/c3_w0_br
+ u_t009_015/c3_w1_bl u_t009_015/c3_w1_br u_t009_015/c3_r0_rbl u_t009_015/c3_r1_rbl
+ u_t009_015/r0_w0_wl u_t009_015/r0_w1_wl u_t009_015/r0_r0_rwl u_t009_015/r0_r1_rwl
+ u_t009_015/r1_w0_wl u_t009_015/r1_w1_wl u_t009_015/r1_r0_rwl u_t009_015/r1_r1_rwl
+ u_t009_015/r2_w0_wl u_t009_015/r2_w1_wl u_t009_015/r2_r0_rwl u_t009_015/r2_r1_rwl
+ u_t009_015/r3_w0_wl u_t009_015/r3_w1_wl u_t009_015/r3_r0_rwl u_t009_015/r3_r1_rwl
+ VSS VSS u_t009_015/m2_717_1265# u_t009_015/m2_603_2031# u_t009_015/m2_1290_336#
+ u_t009_015/m2_2000_2037# u_t009_015/m2_791_2909# u_t009_015/m2_7_2126# u_t009_015/m2_2154_2081#
+ u_t009_015/m2_1795_2037# u_t009_015/m2_871_303# u_t009_015/m2_431_438# u_t009_015/m2_1290_2898#
+ u_t009_015/m2_1714_1210# u_t009_015/m2_431_1982# u_t009_015/m2_512_1265# u_t009_015/m2_2573_2126#
+ u_t009_015/m2_603_1259# u_t009_015/m2_2074_2909# u_t009_015/m2_7_336# u_t009_015/m2_717_2037#
+ u_t009_015/m2_1886_2031# u_t009_015/m2_2573_336# u_t009_015/m2_7_2898# u_t009_015/m2_2000_1265#
+ u_t009_015/m2_512_2037# u_t009_015/m2_1795_1265# u_t009_015/m2_1714_1982# u_t009_015/m2_1886_1259#
+ u_t009_015/m2_1290_2126# u_t009_015/m2_1714_438# u_t009_015/m2_431_1210# u_t009_015/m2_2573_2898#
+ u_t009_015/m2_2154_303# u_t009_015/m2_871_2081# VSUBS detronyx_12t_2w2r_rc4_4x4_routed_5layer_direct
Xu_t024_007 u_t024_007/c0_w0_bl u_t024_007/c0_w0_br u_t024_007/c0_w1_bl u_t024_007/c0_w1_br
+ u_t024_007/c0_r0_rbl u_t024_007/c0_r1_rbl u_t024_007/c1_w0_bl u_t024_007/c1_w0_br
+ u_t024_007/c1_w1_bl u_t024_007/c1_w1_br u_t024_007/c1_r0_rbl u_t024_007/c1_r1_rbl
+ u_t024_007/c2_w0_bl u_t024_007/c2_w0_br u_t024_007/c2_w1_bl u_t024_007/c2_w1_br
+ u_t024_007/c2_r0_rbl u_t024_007/c2_r1_rbl u_t024_007/c3_w0_bl u_t024_007/c3_w0_br
+ u_t024_007/c3_w1_bl u_t024_007/c3_w1_br u_t024_007/c3_r0_rbl u_t024_007/c3_r1_rbl
+ u_t024_007/r0_w0_wl u_t024_007/r0_w1_wl u_t024_007/r0_r0_rwl u_t024_007/r0_r1_rwl
+ u_t024_007/r1_w0_wl u_t024_007/r1_w1_wl u_t024_007/r1_r0_rwl u_t024_007/r1_r1_rwl
+ u_t024_007/r2_w0_wl u_t024_007/r2_w1_wl u_t024_007/r2_r0_rwl u_t024_007/r2_r1_rwl
+ u_t024_007/r3_w0_wl u_t024_007/r3_w1_wl u_t024_007/r3_r0_rwl u_t024_007/r3_r1_rwl
+ VSS u_t024_009/VSS u_t024_007/m2_717_1265# u_t024_007/m2_603_2031# u_t024_007/m2_1290_336#
+ u_t024_007/m2_2000_2037# u_t024_007/m2_791_2909# u_t024_007/m2_7_2126# u_t024_007/m2_2154_2081#
+ u_t024_007/m2_1795_2037# u_t024_007/m2_871_303# u_t024_007/m2_431_438# u_t024_007/m2_1290_2898#
+ u_t024_007/m2_1714_1210# u_t024_007/m2_431_1982# u_t024_007/m2_512_1265# u_t024_007/m2_2573_2126#
+ u_t024_007/m2_603_1259# u_t024_007/m2_2074_2909# u_t024_007/m2_7_336# u_t024_007/m2_717_2037#
+ u_t024_007/m2_1886_2031# u_t024_007/m2_2573_336# u_t024_007/m2_7_2898# u_t024_007/m2_2000_1265#
+ u_t024_007/m2_512_2037# u_t024_007/m2_1795_1265# u_t024_007/m2_1714_1982# u_t024_007/m2_1886_1259#
+ u_t024_007/m2_1290_2126# u_t024_007/m2_1714_438# u_t024_007/m2_431_1210# u_t024_007/m2_2573_2898#
+ u_t024_007/m2_2154_303# u_t024_007/m2_871_2081# VSUBS detronyx_12t_2w2r_rc4_4x4_routed_5layer_direct
Xu_t009_004 u_t009_004/c0_w0_bl u_t009_004/c0_w0_br u_t009_004/c0_w1_bl u_t009_004/c0_w1_br
+ u_t009_004/c0_r0_rbl u_t009_004/c0_r1_rbl u_t009_004/c1_w0_bl u_t009_004/c1_w0_br
+ u_t009_004/c1_w1_bl u_t009_004/c1_w1_br u_t009_004/c1_r0_rbl u_t009_004/c1_r1_rbl
+ u_t009_004/c2_w0_bl u_t009_004/c2_w0_br u_t009_004/c2_w1_bl u_t009_004/c2_w1_br
+ u_t009_004/c2_r0_rbl u_t009_004/c2_r1_rbl u_t009_004/c3_w0_bl u_t009_004/c3_w0_br
+ u_t009_004/c3_w1_bl u_t009_004/c3_w1_br u_t009_004/c3_r0_rbl u_t009_004/c3_r1_rbl
+ u_t009_004/r0_w0_wl u_t009_004/r0_w1_wl u_t009_004/r0_r0_rwl u_t009_004/r0_r1_rwl
+ u_t009_004/r1_w0_wl u_t009_004/r1_w1_wl u_t009_004/r1_r0_rwl u_t009_004/r1_r1_rwl
+ u_t009_004/r2_w0_wl u_t009_004/r2_w1_wl u_t009_004/r2_r0_rwl u_t009_004/r2_r1_rwl
+ u_t009_004/r3_w0_wl u_t009_004/r3_w1_wl u_t009_004/r3_r0_rwl u_t009_004/r3_r1_rwl
+ u_t009_004/VDD VSS u_t009_004/m2_717_1265# u_t009_004/m2_603_2031# u_t009_004/m2_1290_336#
+ u_t009_004/m2_2000_2037# u_t009_004/m2_791_2909# u_t009_004/m2_7_2126# u_t009_004/m2_2154_2081#
+ u_t009_004/m2_1795_2037# u_t009_004/m2_871_303# u_t009_004/m2_431_438# u_t009_004/m2_1290_2898#
+ u_t009_004/m2_1714_1210# u_t009_004/m2_431_1982# u_t009_004/m2_512_1265# u_t009_004/m2_2573_2126#
+ u_t009_004/m2_603_1259# u_t009_004/m2_2074_2909# u_t009_004/m2_7_336# u_t009_004/m2_717_2037#
+ u_t009_004/m2_1886_2031# u_t009_004/m2_2573_336# u_t009_004/m2_7_2898# u_t009_004/m2_2000_1265#
+ u_t009_004/m2_512_2037# u_t009_004/m2_1795_1265# u_t009_004/m2_1714_1982# u_t009_004/m2_1886_1259#
+ u_t009_004/m2_1290_2126# u_t009_004/m2_1714_438# u_t009_004/m2_431_1210# u_t009_004/m2_2573_2898#
+ u_t009_004/m2_2154_303# u_t009_004/m2_871_2081# VSUBS detronyx_12t_2w2r_rc4_4x4_routed_5layer_direct
Xgf180mcu_as_sc_mcu7t3v3__nand3_2_19 gf180mcu_as_sc_mcu7t3v3__nor2_2_4/VDD gf180mcu_as_sc_mcu7t3v3__nor2_2_4/VSS
+ VSS VSS VSS VSS gf180mcu_as_sc_mcu7t3v3__nor2_2_4/VNW VSUBS gf180mcu_as_sc_mcu7t3v3__nand3_2
Xgf180mcu_as_sc_mcu7t3v3__inv_2_1606 VSS gf180mcu_as_sc_mcu7t3v3__inv_2_1614/VDD gf180mcu_as_sc_mcu7t3v3__inv_2_1669/A
+ VSS gf180mcu_as_sc_mcu7t3v3__inv_2_1606/VNW VSUBS gf180mcu_as_sc_mcu7t3v3__inv_2
Xgf180mcu_as_sc_mcu7t3v3__inv_2_1617 gf180mcu_as_sc_mcu7t3v3__inv_2_1618/VDD VSS gf180mcu_as_sc_mcu7t3v3__inv_2_1669/A
+ gf180mcu_as_sc_mcu7t3v3__inv_2_1669/A gf180mcu_as_sc_mcu7t3v3__inv_2_1618/VNW VSUBS
+ gf180mcu_as_sc_mcu7t3v3__inv_2
Xgf180mcu_as_sc_mcu7t3v3__inv_2_151 gf180mcu_as_sc_mcu7t3v3__inv_2_152/VDD gf180mcu_as_sc_mcu7t3v3__nand4_2_9/VDD
+ gf180mcu_as_sc_mcu7t3v3__inv_2_151/Y VSS gf180mcu_as_sc_mcu7t3v3__inv_2_152/VNW
+ VSUBS gf180mcu_as_sc_mcu7t3v3__inv_2
Xgf180mcu_as_sc_mcu7t3v3__inv_2_140 VSS gf180mcu_as_sc_mcu7t3v3__inv_2_143/VDD VSS
+ VSS gf180mcu_as_sc_mcu7t3v3__inv_2_140/VNW VSUBS gf180mcu_as_sc_mcu7t3v3__inv_2
Xgf180mcu_as_sc_mcu7t3v3__inv_2_173 VSS VSS VSS VSS gf180mcu_as_sc_mcu7t3v3__inv_2_174/VNW
+ VSUBS gf180mcu_as_sc_mcu7t3v3__inv_2
Xgf180mcu_as_sc_mcu7t3v3__inv_2_184 gf180mcu_as_sc_mcu7t3v3__inv_2_203/VSS VSS gf180mcu_as_sc_mcu7t3v3__inv_2_184/Y
+ VSS gf180mcu_as_sc_mcu7t3v3__inv_2_197/VNW VSUBS gf180mcu_as_sc_mcu7t3v3__inv_2
Xgf180mcu_as_sc_mcu7t3v3__inv_2_195 VSS VSS VSS VSS gf180mcu_as_sc_mcu7t3v3__inv_2_196/VNW
+ VSUBS gf180mcu_as_sc_mcu7t3v3__inv_2
Xgf180mcu_as_sc_mcu7t3v3__inv_2_162 gf180mcu_as_sc_mcu7t3v3__inv_2_163/VDD VSS VSS
+ VSS gf180mcu_as_sc_mcu7t3v3__inv_2_163/VNW VSUBS gf180mcu_as_sc_mcu7t3v3__inv_2
Xgf180mcu_as_sc_mcu7t3v3__inv_2_1639 VSS gf180mcu_as_sc_mcu7t3v3__inv_2_1685/VDD VSS
+ gf180mcu_as_sc_mcu7t3v3__inv_2_1685/A gf180mcu_as_sc_mcu7t3v3__inv_2_1653/VNW VSUBS
+ gf180mcu_as_sc_mcu7t3v3__inv_2
Xgf180mcu_as_sc_mcu7t3v3__inv_2_1628 gf180mcu_as_sc_mcu7t3v3__inv_2_1685/VDD VSS gf180mcu_as_sc_mcu7t3v3__inv_2_1685/A
+ VSS gf180mcu_as_sc_mcu7t3v3__inv_2_1685/VNW VSUBS gf180mcu_as_sc_mcu7t3v3__inv_2
Xu_t015_007 u_t015_007/c0_w0_bl u_t015_007/c0_w0_br u_t015_007/c0_w1_bl u_t015_007/c0_w1_br
+ u_t015_007/c0_r0_rbl u_t015_007/c0_r1_rbl u_t015_007/c1_w0_bl u_t015_007/c1_w0_br
+ u_t015_007/c1_w1_bl u_t015_007/c1_w1_br u_t015_007/c1_r0_rbl u_t015_007/c1_r1_rbl
+ u_t015_007/c2_w0_bl u_t015_007/c2_w0_br u_t015_007/c2_w1_bl u_t015_007/c2_w1_br
+ u_t015_007/c2_r0_rbl u_t015_007/c2_r1_rbl u_t015_007/c3_w0_bl u_t015_007/c3_w0_br
+ u_t015_007/c3_w1_bl u_t015_007/c3_w1_br u_t015_007/c3_r0_rbl u_t015_007/c3_r1_rbl
+ u_t015_007/r0_w0_wl u_t015_007/r0_w1_wl u_t015_007/r0_r0_rwl u_t015_007/r0_r1_rwl
+ u_t015_007/r1_w0_wl u_t015_007/r1_w1_wl u_t015_007/r1_r0_rwl u_t015_007/r1_r1_rwl
+ u_t015_007/r2_w0_wl u_t015_007/r2_w1_wl u_t015_007/r2_r0_rwl u_t015_007/r2_r1_rwl
+ u_t015_007/r3_w0_wl u_t015_007/r3_w1_wl u_t015_007/r3_r0_rwl u_t015_007/r3_r1_rwl
+ VSS u_t015_009/VSS u_t015_007/m2_717_1265# u_t015_007/m2_603_2031# u_t015_007/m2_1290_336#
+ u_t015_007/m2_2000_2037# u_t015_007/m2_791_2909# u_t015_007/m2_7_2126# u_t015_007/m2_2154_2081#
+ u_t015_007/m2_1795_2037# u_t015_007/m2_871_303# u_t015_007/m2_431_438# u_t015_007/m2_1290_2898#
+ u_t015_007/m2_1714_1210# u_t015_007/m2_431_1982# u_t015_007/m2_512_1265# u_t015_007/m2_2573_2126#
+ u_t015_007/m2_603_1259# u_t015_007/m2_2074_2909# u_t015_007/m2_7_336# u_t015_007/m2_717_2037#
+ u_t015_007/m2_1886_2031# u_t015_007/m2_2573_336# u_t015_007/m2_7_2898# u_t015_007/m2_2000_1265#
+ u_t015_007/m2_512_2037# u_t015_007/m2_1795_1265# u_t015_007/m2_1714_1982# u_t015_007/m2_1886_1259#
+ u_t015_007/m2_1290_2126# u_t015_007/m2_1714_438# u_t015_007/m2_431_1210# u_t015_007/m2_2573_2898#
+ u_t015_007/m2_2154_303# u_t015_007/m2_871_2081# VSUBS detronyx_12t_2w2r_rc4_4x4_routed_5layer_direct
Xu_t006_007 u_t006_007/c0_w0_bl u_t006_007/c0_w0_br u_t006_007/c0_w1_bl u_t006_007/c0_w1_br
+ u_t006_007/c0_r0_rbl u_t006_007/c0_r1_rbl u_t006_007/c1_w0_bl u_t006_007/c1_w0_br
+ u_t006_007/c1_w1_bl u_t006_007/c1_w1_br u_t006_007/c1_r0_rbl u_t006_007/c1_r1_rbl
+ u_t006_007/c2_w0_bl u_t006_007/c2_w0_br u_t006_007/c2_w1_bl u_t006_007/c2_w1_br
+ u_t006_007/c2_r0_rbl u_t006_007/c2_r1_rbl u_t006_007/c3_w0_bl u_t006_007/c3_w0_br
+ u_t006_007/c3_w1_bl u_t006_007/c3_w1_br u_t006_007/c3_r0_rbl u_t006_007/c3_r1_rbl
+ u_t006_007/r0_w0_wl u_t006_007/r0_w1_wl u_t006_007/r0_r0_rwl u_t006_007/r0_r1_rwl
+ u_t006_007/r1_w0_wl u_t006_007/r1_w1_wl u_t006_007/r1_r0_rwl u_t006_007/r1_r1_rwl
+ u_t006_007/r2_w0_wl u_t006_007/r2_w1_wl u_t006_007/r2_r0_rwl u_t006_007/r2_r1_rwl
+ u_t006_007/r3_w0_wl u_t006_007/r3_w1_wl u_t006_007/r3_r0_rwl u_t006_007/r3_r1_rwl
+ VSS u_t006_009/VSS u_t006_007/m2_717_1265# u_t006_007/m2_603_2031# u_t006_007/m2_1290_336#
+ u_t006_007/m2_2000_2037# u_t006_007/m2_791_2909# u_t006_007/m2_7_2126# u_t006_007/m2_2154_2081#
+ u_t006_007/m2_1795_2037# u_t006_007/m2_871_303# u_t006_007/m2_431_438# u_t006_007/m2_1290_2898#
+ u_t006_007/m2_1714_1210# u_t006_007/m2_431_1982# u_t006_007/m2_512_1265# u_t006_007/m2_2573_2126#
+ u_t006_007/m2_603_1259# u_t006_007/m2_2074_2909# u_t006_007/m2_7_336# u_t006_007/m2_717_2037#
+ u_t006_007/m2_1886_2031# u_t006_007/m2_2573_336# u_t006_007/m2_7_2898# u_t006_007/m2_2000_1265#
+ u_t006_007/m2_512_2037# u_t006_007/m2_1795_1265# u_t006_007/m2_1714_1982# u_t006_007/m2_1886_1259#
+ u_t006_007/m2_1290_2126# u_t006_007/m2_1714_438# u_t006_007/m2_431_1210# u_t006_007/m2_2573_2898#
+ u_t006_007/m2_2154_303# u_t006_007/m2_871_2081# VSUBS detronyx_12t_2w2r_rc4_4x4_routed_5layer_direct
Xgf180mcu_as_sc_mcu7t3v3__nand2_2_41 gf180mcu_as_sc_mcu7t3v3__nor2_2_9/VDD gf180mcu_as_sc_mcu7t3v3__nand3_2_63/VSS
+ VSS VSS VSS gf180mcu_as_sc_mcu7t3v3__nor2_2_9/VNW VSUBS gf180mcu_as_sc_mcu7t3v3__nand2_2
Xgf180mcu_as_sc_mcu7t3v3__nand2_2_30 gf180mcu_as_sc_mcu7t3v3__nand3_2_9/VDD gf180mcu_as_sc_mcu7t3v3__nor2_2_4/VSS
+ VSS VSS VSS gf180mcu_as_sc_mcu7t3v3__nand3_2_9/VNW VSUBS gf180mcu_as_sc_mcu7t3v3__nand2_2
Xgf180mcu_as_sc_mcu7t3v3__nand2_2_52 gf180mcu_as_sc_mcu7t3v3__nand3_2_65/VDD gf180mcu_as_sc_mcu7t3v3__nand3_2_62/VSS
+ VSS VSS VSS gf180mcu_as_sc_mcu7t3v3__nand3_2_65/VNW VSUBS gf180mcu_as_sc_mcu7t3v3__nand2_2
Xu_t020_010 u_t020_010/c0_w0_bl u_t020_010/c0_w0_br u_t020_010/c0_w1_bl u_t020_010/c0_w1_br
+ u_t020_010/c0_r0_rbl u_t020_010/c0_r1_rbl u_t020_010/c1_w0_bl u_t020_010/c1_w0_br
+ u_t020_010/c1_w1_bl u_t020_010/c1_w1_br u_t020_010/c1_r0_rbl u_t020_010/c1_r1_rbl
+ u_t020_010/c2_w0_bl u_t020_010/c2_w0_br u_t020_010/c2_w1_bl u_t020_010/c2_w1_br
+ u_t020_010/c2_r0_rbl u_t020_010/c2_r1_rbl u_t020_010/c3_w0_bl u_t020_010/c3_w0_br
+ u_t020_010/c3_w1_bl u_t020_010/c3_w1_br u_t020_010/c3_r0_rbl u_t020_010/c3_r1_rbl
+ u_t020_010/r0_w0_wl u_t020_010/r0_w1_wl u_t020_010/r0_r0_rwl u_t020_010/r0_r1_rwl
+ u_t020_010/r1_w0_wl u_t020_010/r1_w1_wl u_t020_010/r1_r0_rwl u_t020_010/r1_r1_rwl
+ u_t020_010/r2_w0_wl u_t020_010/r2_w1_wl u_t020_010/r2_r0_rwl u_t020_010/r2_r1_rwl
+ u_t020_010/r3_w0_wl u_t020_010/r3_w1_wl u_t020_010/r3_r0_rwl u_t020_010/r3_r1_rwl
+ VSS u_t020_010/VSS u_t020_010/m2_717_1265# u_t020_010/m2_603_2031# u_t020_010/m2_1290_336#
+ u_t020_010/m2_2000_2037# u_t020_010/m2_791_2909# u_t020_010/m2_7_2126# u_t020_010/m2_2154_2081#
+ u_t020_010/m2_1795_2037# u_t020_010/m2_871_303# u_t020_010/m2_431_438# u_t020_010/m2_1290_2898#
+ u_t020_010/m2_1714_1210# u_t020_010/m2_431_1982# u_t020_010/m2_512_1265# u_t020_010/m2_2573_2126#
+ u_t020_010/m2_603_1259# u_t020_010/m2_2074_2909# u_t020_010/m2_7_336# u_t020_010/m2_717_2037#
+ u_t020_010/m2_1886_2031# u_t020_010/m2_2573_336# u_t020_010/m2_7_2898# u_t020_010/m2_2000_1265#
+ u_t020_010/m2_512_2037# u_t020_010/m2_1795_1265# u_t020_010/m2_1714_1982# u_t020_010/m2_1886_1259#
+ u_t020_010/m2_1290_2126# u_t020_010/m2_1714_438# u_t020_010/m2_431_1210# u_t020_010/m2_2573_2898#
+ u_t020_010/m2_2154_303# u_t020_010/m2_871_2081# VSUBS detronyx_12t_2w2r_rc4_4x4_routed_5layer_direct
Xgf180mcu_as_sc_mcu7t3v3__inv_2_1469 gf180mcu_as_sc_mcu7t3v3__inv_2_1470/VDD gf180mcu_as_sc_mcu7t3v3__inv_2_1473/VDD
+ gf180mcu_as_sc_mcu7t3v3__inv_2_1469/Y VSS gf180mcu_as_sc_mcu7t3v3__inv_2_1470/VNW
+ VSUBS gf180mcu_as_sc_mcu7t3v3__inv_2
Xgf180mcu_as_sc_mcu7t3v3__inv_2_1403 gf180mcu_as_sc_mcu7t3v3__inv_2_1403/VDD VSS gf180mcu_as_sc_mcu7t3v3__inv_2_1409/A
+ gf180mcu_as_sc_mcu7t3v3__inv_2_1409/A gf180mcu_as_sc_mcu7t3v3__inv_2_1403/VNW VSUBS
+ gf180mcu_as_sc_mcu7t3v3__inv_2
Xgf180mcu_as_sc_mcu7t3v3__inv_2_1414 gf180mcu_as_sc_mcu7t3v3__inv_2_1416/VDD VSS VSS
+ VSS gf180mcu_as_sc_mcu7t3v3__inv_2_1416/VNW VSUBS gf180mcu_as_sc_mcu7t3v3__inv_2
Xgf180mcu_as_sc_mcu7t3v3__inv_2_1447 VSS gf180mcu_as_sc_mcu7t3v3__inv_2_1452/VDD VSS
+ VSS gf180mcu_as_sc_mcu7t3v3__inv_2_1449/VNW VSUBS gf180mcu_as_sc_mcu7t3v3__inv_2
Xgf180mcu_as_sc_mcu7t3v3__inv_2_1436 VSS VSS VSS VSS gf180mcu_as_sc_mcu7t3v3__inv_2_1437/VNW
+ VSUBS gf180mcu_as_sc_mcu7t3v3__inv_2
Xgf180mcu_as_sc_mcu7t3v3__inv_2_1425 gf180mcu_as_sc_mcu7t3v3__inv_2_1511/VSS VSS gf180mcu_as_sc_mcu7t3v3__inv_2_1425/Y
+ VSS gf180mcu_as_sc_mcu7t3v3__inv_2_1425/VNW VSUBS gf180mcu_as_sc_mcu7t3v3__inv_2
Xgf180mcu_as_sc_mcu7t3v3__inv_2_1458 gf180mcu_as_sc_mcu7t3v3__inv_2_1508/VSS VSS VSS
+ VSS gf180mcu_as_sc_mcu7t3v3__inv_2_1479/VNW VSUBS gf180mcu_as_sc_mcu7t3v3__inv_2
Xgf180mcu_as_sc_mcu7t3v3__inv_2_909 VSS VSS VSS VSS gf180mcu_as_sc_mcu7t3v3__inv_2_954/VNW
+ VSUBS gf180mcu_as_sc_mcu7t3v3__inv_2
Xu_t011_010 u_t011_010/c0_w0_bl u_t011_010/c0_w0_br u_t011_010/c0_w1_bl u_t011_010/c0_w1_br
+ u_t011_010/c0_r0_rbl u_t011_010/c0_r1_rbl u_t011_010/c1_w0_bl u_t011_010/c1_w0_br
+ u_t011_010/c1_w1_bl u_t011_010/c1_w1_br u_t011_010/c1_r0_rbl u_t011_010/c1_r1_rbl
+ u_t011_010/c2_w0_bl u_t011_010/c2_w0_br u_t011_010/c2_w1_bl u_t011_010/c2_w1_br
+ u_t011_010/c2_r0_rbl u_t011_010/c2_r1_rbl u_t011_010/c3_w0_bl u_t011_010/c3_w0_br
+ u_t011_010/c3_w1_bl u_t011_010/c3_w1_br u_t011_010/c3_r0_rbl u_t011_010/c3_r1_rbl
+ u_t011_010/r0_w0_wl u_t011_010/r0_w1_wl u_t011_010/r0_r0_rwl u_t011_010/r0_r1_rwl
+ u_t011_010/r1_w0_wl u_t011_010/r1_w1_wl u_t011_010/r1_r0_rwl u_t011_010/r1_r1_rwl
+ u_t011_010/r2_w0_wl u_t011_010/r2_w1_wl u_t011_010/r2_r0_rwl u_t011_010/r2_r1_rwl
+ u_t011_010/r3_w0_wl u_t011_010/r3_w1_wl u_t011_010/r3_r0_rwl u_t011_010/r3_r1_rwl
+ VSS u_t011_010/VSS u_t011_010/m2_717_1265# u_t011_010/m2_603_2031# u_t011_010/m2_1290_336#
+ u_t011_010/m2_2000_2037# u_t011_010/m2_791_2909# u_t011_010/m2_7_2126# u_t011_010/m2_2154_2081#
+ u_t011_010/m2_1795_2037# u_t011_010/m2_871_303# u_t011_010/m2_431_438# u_t011_010/m2_1290_2898#
+ u_t011_010/m2_1714_1210# u_t011_010/m2_431_1982# u_t011_010/m2_512_1265# u_t011_010/m2_2573_2126#
+ u_t011_010/m2_603_1259# u_t011_010/m2_2074_2909# u_t011_010/m2_7_336# u_t011_010/m2_717_2037#
+ u_t011_010/m2_1886_2031# u_t011_010/m2_2573_336# u_t011_010/m2_7_2898# u_t011_010/m2_2000_1265#
+ u_t011_010/m2_512_2037# u_t011_010/m2_1795_1265# u_t011_010/m2_1714_1982# u_t011_010/m2_1886_1259#
+ u_t011_010/m2_1290_2126# u_t011_010/m2_1714_438# u_t011_010/m2_431_1210# u_t011_010/m2_2573_2898#
+ u_t011_010/m2_2154_303# u_t011_010/m2_871_2081# VSUBS detronyx_12t_2w2r_rc4_4x4_routed_5layer_direct
Xgf180mcu_as_sc_mcu7t3v3__nand4_2_219 VSS VSS VSS VSS VSS VSS gf180mcu_as_sc_mcu7t3v3__nand4_2_219/Y
+ gf180mcu_as_sc_mcu7t3v3__inv_2_820/VNW VSUBS gf180mcu_as_sc_mcu7t3v3__nand4_2
Xgf180mcu_as_sc_mcu7t3v3__nand4_2_208 gf180mcu_as_sc_mcu7t3v3__inv_2_674/VDD gf180mcu_as_sc_mcu7t3v3__inv_2_678/VDD
+ VSS VSS VSS VSS VSS gf180mcu_as_sc_mcu7t3v3__inv_2_674/VNW VSUBS gf180mcu_as_sc_mcu7t3v3__nand4_2
Xu_t002_010 u_t002_010/c0_w0_bl u_t002_010/c0_w0_br u_t002_010/c0_w1_bl u_t002_010/c0_w1_br
+ u_t002_010/c0_r0_rbl u_t002_010/c0_r1_rbl u_t002_010/c1_w0_bl u_t002_010/c1_w0_br
+ u_t002_010/c1_w1_bl u_t002_010/c1_w1_br u_t002_010/c1_r0_rbl u_t002_010/c1_r1_rbl
+ u_t002_010/c2_w0_bl u_t002_010/c2_w0_br u_t002_010/c2_w1_bl u_t002_010/c2_w1_br
+ u_t002_010/c2_r0_rbl u_t002_010/c2_r1_rbl u_t002_010/c3_w0_bl u_t002_010/c3_w0_br
+ u_t002_010/c3_w1_bl u_t002_010/c3_w1_br u_t002_010/c3_r0_rbl u_t002_010/c3_r1_rbl
+ u_t002_010/r0_w0_wl u_t002_010/r0_w1_wl u_t002_010/r0_r0_rwl u_t002_010/r0_r1_rwl
+ u_t002_010/r1_w0_wl u_t002_010/r1_w1_wl u_t002_010/r1_r0_rwl u_t002_010/r1_r1_rwl
+ u_t002_010/r2_w0_wl u_t002_010/r2_w1_wl u_t002_010/r2_r0_rwl u_t002_010/r2_r1_rwl
+ u_t002_010/r3_w0_wl u_t002_010/r3_w1_wl u_t002_010/r3_r0_rwl u_t002_010/r3_r1_rwl
+ VSS u_t002_010/VSS u_t002_010/m2_717_1265# u_t002_010/m2_603_2031# u_t002_010/m2_1290_336#
+ u_t002_010/m2_2000_2037# u_t002_010/m2_791_2909# u_t002_010/m2_7_2126# u_t002_010/m2_2154_2081#
+ u_t002_010/m2_1795_2037# u_t002_010/m2_871_303# u_t002_010/m2_431_438# u_t002_010/m2_1290_2898#
+ u_t002_010/m2_1714_1210# u_t002_010/m2_431_1982# u_t002_010/m2_512_1265# u_t002_010/m2_2573_2126#
+ u_t002_010/m2_603_1259# u_t002_010/m2_2074_2909# u_t002_010/m2_7_336# u_t002_010/m2_717_2037#
+ u_t002_010/m2_1886_2031# u_t002_010/m2_2573_336# u_t002_010/m2_7_2898# u_t002_010/m2_2000_1265#
+ u_t002_010/m2_512_2037# u_t002_010/m2_1795_1265# u_t002_010/m2_1714_1982# u_t002_010/m2_1886_1259#
+ u_t002_010/m2_1290_2126# u_t002_010/m2_1714_438# u_t002_010/m2_431_1210# u_t002_010/m2_2573_2898#
+ u_t002_010/m2_2154_303# u_t002_010/m2_871_2081# VSUBS detronyx_12t_2w2r_rc4_4x4_routed_5layer_direct
Xgf180mcu_as_sc_mcu7t3v3__inv_2_1244 gf180mcu_as_sc_mcu7t3v3__nand3_2_65/VDD gf180mcu_as_sc_mcu7t3v3__nor2_2_9/VSS
+ VSS VSS gf180mcu_as_sc_mcu7t3v3__nand3_2_65/VNW VSUBS gf180mcu_as_sc_mcu7t3v3__inv_2
Xgf180mcu_as_sc_mcu7t3v3__inv_2_1233 gf180mcu_as_sc_mcu7t3v3__nand3_2_65/VDD gf180mcu_as_sc_mcu7t3v3__nor2_2_9/VSS
+ VSS VSS gf180mcu_as_sc_mcu7t3v3__nand3_2_65/VNW VSUBS gf180mcu_as_sc_mcu7t3v3__inv_2
Xgf180mcu_as_sc_mcu7t3v3__inv_2_1266 gf180mcu_as_sc_mcu7t3v3__nand3_2_65/VDD gf180mcu_as_sc_mcu7t3v3__nor2_2_9/VSS
+ VSS VSS gf180mcu_as_sc_mcu7t3v3__nand3_2_65/VNW VSUBS gf180mcu_as_sc_mcu7t3v3__inv_2
Xgf180mcu_as_sc_mcu7t3v3__inv_2_1211 gf180mcu_as_sc_mcu7t3v3__nand3_2_65/VDD gf180mcu_as_sc_mcu7t3v3__nor2_2_9/VSS
+ gf180mcu_as_sc_mcu7t3v3__inv_2_1211/Y VSS gf180mcu_as_sc_mcu7t3v3__nand3_2_65/VNW
+ VSUBS gf180mcu_as_sc_mcu7t3v3__inv_2
Xgf180mcu_as_sc_mcu7t3v3__inv_2_1255 gf180mcu_as_sc_mcu7t3v3__nand3_2_65/VDD gf180mcu_as_sc_mcu7t3v3__nand3_2_62/VSS
+ VSS VSS gf180mcu_as_sc_mcu7t3v3__nand3_2_65/VNW VSUBS gf180mcu_as_sc_mcu7t3v3__inv_2
Xgf180mcu_as_sc_mcu7t3v3__inv_2_1277 VSS VSS VSS VSS gf180mcu_as_sc_mcu7t3v3__inv_2_1277/VNW
+ VSUBS gf180mcu_as_sc_mcu7t3v3__inv_2
Xgf180mcu_as_sc_mcu7t3v3__inv_2_1222 VSS VSS gf180mcu_as_sc_mcu7t3v3__inv_2_1222/Y
+ VSS gf180mcu_as_sc_mcu7t3v3__inv_2_1283/VNW VSUBS gf180mcu_as_sc_mcu7t3v3__inv_2
Xgf180mcu_as_sc_mcu7t3v3__inv_2_1200 VSS VSS VSS VSS gf180mcu_as_sc_mcu7t3v3__inv_2_1272/VNW
+ VSUBS gf180mcu_as_sc_mcu7t3v3__inv_2
Xgf180mcu_as_sc_mcu7t3v3__inv_2_1299 VSS VSS VSS VSS gf180mcu_as_sc_mcu7t3v3__inv_2_1299/VNW
+ VSUBS gf180mcu_as_sc_mcu7t3v3__inv_2
Xgf180mcu_as_sc_mcu7t3v3__inv_2_1288 VSS VSS VSS VSS gf180mcu_as_sc_mcu7t3v3__inv_2_1288/VNW
+ VSUBS gf180mcu_as_sc_mcu7t3v3__inv_2
Xgf180mcu_as_sc_mcu7t3v3__inv_2_728 gf180mcu_as_sc_mcu7t3v3__inv_2_746/VDD gf180mcu_as_sc_mcu7t3v3__inv_2_746/VDD
+ gf180mcu_as_sc_mcu7t3v3__inv_2_728/Y VSS gf180mcu_as_sc_mcu7t3v3__inv_2_728/VNW
+ VSUBS gf180mcu_as_sc_mcu7t3v3__inv_2
Xgf180mcu_as_sc_mcu7t3v3__inv_2_706 gf180mcu_as_sc_mcu7t3v3__inv_2_730/VDD VSS gf180mcu_as_sc_mcu7t3v3__inv_2_706/Y
+ gf180mcu_as_sc_mcu7t3v3__inv_2_742/A gf180mcu_as_sc_mcu7t3v3__inv_2_730/VNW VSUBS
+ gf180mcu_as_sc_mcu7t3v3__inv_2
Xgf180mcu_as_sc_mcu7t3v3__inv_2_717 VSS gf180mcu_as_sc_mcu7t3v3__inv_2_731/VDD gf180mcu_as_sc_mcu7t3v3__inv_2_717/Y
+ VSS gf180mcu_as_sc_mcu7t3v3__inv_2_717/VNW VSUBS gf180mcu_as_sc_mcu7t3v3__inv_2
Xgf180mcu_as_sc_mcu7t3v3__inv_2_739 VSS gf180mcu_as_sc_mcu7t3v3__inv_2_743/VDD gf180mcu_as_sc_mcu7t3v3__inv_2_739/Y
+ gf180mcu_as_sc_mcu7t3v3__inv_2_740/Y gf180mcu_as_sc_mcu7t3v3__inv_2_740/VNW VSUBS
+ gf180mcu_as_sc_mcu7t3v3__inv_2
Xgf180mcu_as_sc_mcu7t3v3__inv_2_82 gf180mcu_as_sc_mcu7t3v3__inv_2_94/VDD gf180mcu_as_sc_mcu7t3v3__inv_2_94/VDD
+ gf180mcu_as_sc_mcu7t3v3__inv_2_82/Y VSS gf180mcu_as_sc_mcu7t3v3__inv_2_92/VNW VSUBS
+ gf180mcu_as_sc_mcu7t3v3__inv_2
Xgf180mcu_as_sc_mcu7t3v3__inv_2_93 gf180mcu_as_sc_mcu7t3v3__inv_2_94/VDD gf180mcu_as_sc_mcu7t3v3__inv_2_94/VSS
+ gf180mcu_as_sc_mcu7t3v3__inv_2_93/Y VSS gf180mcu_as_sc_mcu7t3v3__inv_2_94/VNW VSUBS
+ gf180mcu_as_sc_mcu7t3v3__inv_2
Xgf180mcu_as_sc_mcu7t3v3__inv_2_71 gf180mcu_as_sc_mcu7t3v3__inv_2_73/VDD gf180mcu_as_sc_mcu7t3v3__inv_2_9/VDD
+ VSS gf180mcu_as_sc_mcu7t3v3__inv_2_73/Y gf180mcu_as_sc_mcu7t3v3__inv_2_73/VNW VSUBS
+ gf180mcu_as_sc_mcu7t3v3__inv_2
Xgf180mcu_as_sc_mcu7t3v3__inv_2_60 gf180mcu_as_sc_mcu7t3v3__inv_2_61/VDD gf180mcu_as_sc_mcu7t3v3__inv_2_69/VDD
+ gf180mcu_as_sc_mcu7t3v3__inv_2_60/Y gf180mcu_as_sc_mcu7t3v3__inv_2_61/Y gf180mcu_as_sc_mcu7t3v3__inv_2_61/VNW
+ VSUBS gf180mcu_as_sc_mcu7t3v3__inv_2
Xgf180mcu_as_sc_mcu7t3v3__inv_2_1074 gf180mcu_as_sc_mcu7t3v3__inv_2_1075/VDD gf180mcu_as_sc_mcu7t3v3__inv_2_1079/VDD
+ gf180mcu_as_sc_mcu7t3v3__inv_2_1074/Y gf180mcu_as_sc_mcu7t3v3__inv_2_1075/Y gf180mcu_as_sc_mcu7t3v3__inv_2_1075/VNW
+ VSUBS gf180mcu_as_sc_mcu7t3v3__inv_2
Xgf180mcu_as_sc_mcu7t3v3__inv_2_1085 gf180mcu_as_sc_mcu7t3v3__inv_2_1087/VDD gf180mcu_as_sc_mcu7t3v3__inv_2_1091/VDD
+ VSS gf180mcu_as_sc_mcu7t3v3__inv_2_1149/A gf180mcu_as_sc_mcu7t3v3__inv_2_1087/VNW
+ VSUBS gf180mcu_as_sc_mcu7t3v3__inv_2
Xgf180mcu_as_sc_mcu7t3v3__inv_2_1063 gf180mcu_as_sc_mcu7t3v3__inv_2_1111/VSS VSS gf180mcu_as_sc_mcu7t3v3__inv_2_1063/Y
+ gf180mcu_as_sc_mcu7t3v3__inv_2_1064/Y gf180mcu_as_sc_mcu7t3v3__inv_2_1064/VNW VSUBS
+ gf180mcu_as_sc_mcu7t3v3__inv_2
Xgf180mcu_as_sc_mcu7t3v3__inv_2_1096 VSS gf180mcu_as_sc_mcu7t3v3__inv_2_1112/VDD gf180mcu_as_sc_mcu7t3v3__inv_2_1096/Y
+ VSS gf180mcu_as_sc_mcu7t3v3__inv_2_1096/VNW VSUBS gf180mcu_as_sc_mcu7t3v3__inv_2
Xgf180mcu_as_sc_mcu7t3v3__inv_2_1030 VSS gf180mcu_as_sc_mcu7t3v3__inv_2_1036/VDD VSS
+ gf180mcu_as_sc_mcu7t3v3__inv_2_1306/Y gf180mcu_as_sc_mcu7t3v3__inv_2_1032/VNW VSUBS
+ gf180mcu_as_sc_mcu7t3v3__inv_2
Xgf180mcu_as_sc_mcu7t3v3__inv_2_1041 gf180mcu_as_sc_mcu7t3v3__inv_2_1049/VDD VSS VSS
+ gf180mcu_as_sc_mcu7t3v3__inv_2_1041/A gf180mcu_as_sc_mcu7t3v3__inv_2_1049/VNW VSUBS
+ gf180mcu_as_sc_mcu7t3v3__inv_2
Xgf180mcu_as_sc_mcu7t3v3__inv_2_1052 gf180mcu_as_sc_mcu7t3v3__inv_2_1052/VDD VSS gf180mcu_as_sc_mcu7t3v3__inv_2_1052/Y
+ VSS gf180mcu_as_sc_mcu7t3v3__inv_2_1052/VNW VSUBS gf180mcu_as_sc_mcu7t3v3__inv_2
Xgf180mcu_as_sc_mcu7t3v3__nand4_2_8 gf180mcu_as_sc_mcu7t3v3__inv_2_94/VSS gf180mcu_as_sc_mcu7t3v3__inv_2_91/VSS
+ VSS VSS VSS VSS gf180mcu_as_sc_mcu7t3v3__nand4_2_8/Y gf180mcu_as_sc_mcu7t3v3__inv_2_91/VNW
+ VSUBS gf180mcu_as_sc_mcu7t3v3__nand4_2
Xgf180mcu_as_sc_mcu7t3v3__inv_2_558 VSS VSS VSS VSS gf180mcu_as_sc_mcu7t3v3__inv_2_558/VNW
+ VSUBS gf180mcu_as_sc_mcu7t3v3__inv_2
Xgf180mcu_as_sc_mcu7t3v3__inv_2_514 VSS VSS gf180mcu_as_sc_mcu7t3v3__inv_2_514/Y VSS
+ gf180mcu_as_sc_mcu7t3v3__inv_2_558/VNW VSUBS gf180mcu_as_sc_mcu7t3v3__inv_2
Xgf180mcu_as_sc_mcu7t3v3__inv_2_547 VSS VSS VSS VSS gf180mcu_as_sc_mcu7t3v3__inv_2_547/VNW
+ VSUBS gf180mcu_as_sc_mcu7t3v3__inv_2
Xgf180mcu_as_sc_mcu7t3v3__inv_2_569 gf180mcu_as_sc_mcu7t3v3__inv_2_570/VDD gf180mcu_as_sc_mcu7t3v3__inv_2_576/VDD
+ gf180mcu_as_sc_mcu7t3v3__inv_2_569/Y gf180mcu_as_sc_mcu7t3v3__inv_2_570/Y gf180mcu_as_sc_mcu7t3v3__inv_2_570/VNW
+ VSUBS gf180mcu_as_sc_mcu7t3v3__inv_2
Xgf180mcu_as_sc_mcu7t3v3__inv_2_525 gf180mcu_as_sc_mcu7t3v3__nand3_2_9/VDD gf180mcu_as_sc_mcu7t3v3__nor2_2_4/VSS
+ VSS VSS gf180mcu_as_sc_mcu7t3v3__nand3_2_9/VNW VSUBS gf180mcu_as_sc_mcu7t3v3__inv_2
Xgf180mcu_as_sc_mcu7t3v3__inv_2_503 VSS VSS VSS VSS gf180mcu_as_sc_mcu7t3v3__inv_2_556/VNW
+ VSUBS gf180mcu_as_sc_mcu7t3v3__inv_2
Xgf180mcu_as_sc_mcu7t3v3__inv_2_536 VSS VSS VSS VSS gf180mcu_as_sc_mcu7t3v3__inv_2_536/VNW
+ VSUBS gf180mcu_as_sc_mcu7t3v3__inv_2
Xgf180mcu_as_sc_mcu7t3v3__nand4_2_380 VSS gf180mcu_as_sc_mcu7t3v3__inv_2_1457/VSS
+ VSS VSS VSS VSS VSS gf180mcu_as_sc_mcu7t3v3__inv_2_1457/VNW VSUBS gf180mcu_as_sc_mcu7t3v3__nand4_2
Xgf180mcu_as_sc_mcu7t3v3__nand4_2_391 gf180mcu_as_sc_mcu7t3v3__inv_2_1443/VDD gf180mcu_as_sc_mcu7t3v3__inv_2_1446/VDD
+ VSS VSS VSS VSS gf180mcu_as_sc_mcu7t3v3__nand4_2_391/Y gf180mcu_as_sc_mcu7t3v3__inv_2_1443/VNW
+ VSUBS gf180mcu_as_sc_mcu7t3v3__nand4_2
Xgf180mcu_as_sc_mcu7t3v3__inv_2_300 gf180mcu_as_sc_mcu7t3v3__inv_2_304/VSS VSS gf180mcu_as_sc_mcu7t3v3__inv_2_304/A
+ VSS gf180mcu_as_sc_mcu7t3v3__inv_2_303/VNW VSUBS gf180mcu_as_sc_mcu7t3v3__inv_2
Xgf180mcu_as_sc_mcu7t3v3__inv_2_311 gf180mcu_as_sc_mcu7t3v3__inv_2_311/VDD gf180mcu_as_sc_mcu7t3v3__inv_2_311/VSS
+ gf180mcu_as_sc_mcu7t3v3__inv_2_365/Y VSS gf180mcu_as_sc_mcu7t3v3__inv_2_311/VNW
+ VSUBS gf180mcu_as_sc_mcu7t3v3__inv_2
Xgf180mcu_as_sc_mcu7t3v3__inv_2_377 gf180mcu_as_sc_mcu7t3v3__nor2_2_6/VDD gf180mcu_as_sc_mcu7t3v3__nor2_2_6/VSS
+ VSS VSS gf180mcu_as_sc_mcu7t3v3__nor2_2_6/VNW VSUBS gf180mcu_as_sc_mcu7t3v3__inv_2
Xgf180mcu_as_sc_mcu7t3v3__inv_2_388 gf180mcu_as_sc_mcu7t3v3__nor2_2_7/VDD gf180mcu_as_sc_mcu7t3v3__nor2_2_7/VSS
+ VSS VSS gf180mcu_as_sc_mcu7t3v3__nor2_2_7/VNW VSUBS gf180mcu_as_sc_mcu7t3v3__inv_2
Xgf180mcu_as_sc_mcu7t3v3__inv_2_399 gf180mcu_as_sc_mcu7t3v3__nor2_2_4/VDD gf180mcu_as_sc_mcu7t3v3__nor2_2_4/VSS
+ VSS VSS gf180mcu_as_sc_mcu7t3v3__nor2_2_4/VNW VSUBS gf180mcu_as_sc_mcu7t3v3__inv_2
Xgf180mcu_as_sc_mcu7t3v3__inv_2_366 VSS gf180mcu_as_sc_mcu7t3v3__inv_2_53/VDD VSS
+ gf180mcu_as_sc_mcu7t3v3__inv_2_61/Y gf180mcu_as_sc_mcu7t3v3__inv_2_368/VNW VSUBS
+ gf180mcu_as_sc_mcu7t3v3__inv_2
Xgf180mcu_as_sc_mcu7t3v3__inv_2_355 VSS VSS gf180mcu_as_sc_mcu7t3v3__inv_2_355/Y gf180mcu_as_sc_mcu7t3v3__inv_2_359/Y
+ gf180mcu_as_sc_mcu7t3v3__inv_2_356/VNW VSUBS gf180mcu_as_sc_mcu7t3v3__inv_2
Xgf180mcu_as_sc_mcu7t3v3__inv_2_344 VSS VSS gf180mcu_as_sc_mcu7t3v3__inv_2_350/Y VSS
+ gf180mcu_as_sc_mcu7t3v3__inv_2_344/VNW VSUBS gf180mcu_as_sc_mcu7t3v3__inv_2
Xgf180mcu_as_sc_mcu7t3v3__inv_2_333 VSS gf180mcu_as_sc_mcu7t3v3__inv_2_338/VDD VSS
+ gf180mcu_as_sc_mcu7t3v3__inv_2_341/Y gf180mcu_as_sc_mcu7t3v3__inv_2_335/VNW VSUBS
+ gf180mcu_as_sc_mcu7t3v3__inv_2
Xgf180mcu_as_sc_mcu7t3v3__inv_2_322 gf180mcu_as_sc_mcu7t3v3__inv_2_323/VDD VSS gf180mcu_as_sc_mcu7t3v3__inv_2_341/Y
+ gf180mcu_as_sc_mcu7t3v3__inv_2_341/Y gf180mcu_as_sc_mcu7t3v3__inv_2_323/VNW VSUBS
+ gf180mcu_as_sc_mcu7t3v3__inv_2
Xu_t027_005 u_t027_005/c0_w0_bl u_t027_005/c0_w0_br u_t027_005/c0_w1_bl u_t027_005/c0_w1_br
+ u_t027_005/c0_r0_rbl u_t027_005/c0_r1_rbl u_t027_005/c1_w0_bl u_t027_005/c1_w0_br
+ u_t027_005/c1_w1_bl u_t027_005/c1_w1_br u_t027_005/c1_r0_rbl u_t027_005/c1_r1_rbl
+ u_t027_005/c2_w0_bl u_t027_005/c2_w0_br u_t027_005/c2_w1_bl u_t027_005/c2_w1_br
+ u_t027_005/c2_r0_rbl u_t027_005/c2_r1_rbl u_t027_005/c3_w0_bl u_t027_005/c3_w0_br
+ u_t027_005/c3_w1_bl u_t027_005/c3_w1_br u_t027_005/c3_r0_rbl u_t027_005/c3_r1_rbl
+ u_t027_005/r0_w0_wl u_t027_005/r0_w1_wl u_t027_005/r0_r0_rwl u_t027_005/r0_r1_rwl
+ u_t027_005/r1_w0_wl u_t027_005/r1_w1_wl u_t027_005/r1_r0_rwl u_t027_005/r1_r1_rwl
+ u_t027_005/r2_w0_wl u_t027_005/r2_w1_wl u_t027_005/r2_r0_rwl u_t027_005/r2_r1_rwl
+ u_t027_005/r3_w0_wl u_t027_005/r3_w1_wl u_t027_005/r3_r0_rwl u_t027_005/r3_r1_rwl
+ u_t027_005/VDD u_t027_005/VSS u_t027_005/m2_717_1265# u_t027_005/m2_603_2031# u_t027_005/m2_1290_336#
+ u_t027_005/m2_2000_2037# u_t027_005/m2_791_2909# u_t027_005/m2_7_2126# u_t027_005/m2_2154_2081#
+ u_t027_005/m2_1795_2037# u_t027_005/m2_871_303# u_t027_005/m2_431_438# u_t027_005/m2_1290_2898#
+ u_t027_005/m2_1714_1210# u_t027_005/m2_431_1982# u_t027_005/m2_512_1265# u_t027_005/m2_2573_2126#
+ u_t027_005/m2_603_1259# u_t027_005/m2_2074_2909# u_t027_005/m2_7_336# u_t027_005/m2_717_2037#
+ u_t027_005/m2_1886_2031# u_t027_005/m2_2573_336# u_t027_005/m2_7_2898# u_t027_005/m2_2000_1265#
+ u_t027_005/m2_512_2037# u_t027_005/m2_1795_1265# u_t027_005/m2_1714_1982# u_t027_005/m2_1886_1259#
+ u_t027_005/m2_1290_2126# u_t027_005/m2_1714_438# u_t027_005/m2_431_1210# u_t027_005/m2_2573_2898#
+ u_t027_005/m2_2154_303# u_t027_005/m2_871_2081# VSUBS detronyx_12t_2w2r_rc4_4x4_routed_5layer_direct
Xu_t018_005 u_t018_005/c0_w0_bl u_t018_005/c0_w0_br u_t018_005/c0_w1_bl u_t018_005/c0_w1_br
+ u_t018_005/c0_r0_rbl u_t018_005/c0_r1_rbl u_t018_005/c1_w0_bl u_t018_005/c1_w0_br
+ u_t018_005/c1_w1_bl u_t018_005/c1_w1_br u_t018_005/c1_r0_rbl u_t018_005/c1_r1_rbl
+ u_t018_005/c2_w0_bl u_t018_005/c2_w0_br u_t018_005/c2_w1_bl u_t018_005/c2_w1_br
+ u_t018_005/c2_r0_rbl u_t018_005/c2_r1_rbl u_t018_005/c3_w0_bl u_t018_005/c3_w0_br
+ u_t018_005/c3_w1_bl u_t018_005/c3_w1_br u_t018_005/c3_r0_rbl u_t018_005/c3_r1_rbl
+ u_t018_005/r0_w0_wl u_t018_005/r0_w1_wl u_t018_005/r0_r0_rwl u_t018_005/r0_r1_rwl
+ u_t018_005/r1_w0_wl u_t018_005/r1_w1_wl u_t018_005/r1_r0_rwl u_t018_005/r1_r1_rwl
+ u_t018_005/r2_w0_wl u_t018_005/r2_w1_wl u_t018_005/r2_r0_rwl u_t018_005/r2_r1_rwl
+ u_t018_005/r3_w0_wl u_t018_005/r3_w1_wl u_t018_005/r3_r0_rwl u_t018_005/r3_r1_rwl
+ u_t018_005/VDD u_t018_005/VSS u_t018_005/m2_717_1265# u_t018_005/m2_603_2031# u_t018_005/m2_1290_336#
+ u_t018_005/m2_2000_2037# u_t018_005/m2_791_2909# u_t018_005/m2_7_2126# u_t018_005/m2_2154_2081#
+ u_t018_005/m2_1795_2037# u_t018_005/m2_871_303# u_t018_005/m2_431_438# u_t018_005/m2_1290_2898#
+ u_t018_005/m2_1714_1210# u_t018_005/m2_431_1982# u_t018_005/m2_512_1265# u_t018_005/m2_2573_2126#
+ u_t018_005/m2_603_1259# u_t018_005/m2_2074_2909# u_t018_005/m2_7_336# u_t018_005/m2_717_2037#
+ u_t018_005/m2_1886_2031# u_t018_005/m2_2573_336# u_t018_005/m2_7_2898# u_t018_005/m2_2000_1265#
+ u_t018_005/m2_512_2037# u_t018_005/m2_1795_1265# u_t018_005/m2_1714_1982# u_t018_005/m2_1886_1259#
+ u_t018_005/m2_1290_2126# u_t018_005/m2_1714_438# u_t018_005/m2_431_1210# u_t018_005/m2_2573_2898#
+ u_t018_005/m2_2154_303# u_t018_005/m2_871_2081# VSUBS detronyx_12t_2w2r_rc4_4x4_routed_5layer_direct
Xu_t024_008 u_t024_008/c0_w0_bl u_t024_008/c0_w0_br u_t024_008/c0_w1_bl u_t024_008/c0_w1_br
+ u_t024_008/c0_r0_rbl u_t024_008/c0_r1_rbl u_t024_008/c1_w0_bl u_t024_008/c1_w0_br
+ u_t024_008/c1_w1_bl u_t024_008/c1_w1_br u_t024_008/c1_r0_rbl u_t024_008/c1_r1_rbl
+ u_t024_008/c2_w0_bl u_t024_008/c2_w0_br u_t024_008/c2_w1_bl u_t024_008/c2_w1_br
+ u_t024_008/c2_r0_rbl u_t024_008/c2_r1_rbl u_t024_008/c3_w0_bl u_t024_008/c3_w0_br
+ u_t024_008/c3_w1_bl u_t024_008/c3_w1_br u_t024_008/c3_r0_rbl u_t024_008/c3_r1_rbl
+ u_t024_008/r0_w0_wl u_t024_008/r0_w1_wl u_t024_008/r0_r0_rwl u_t024_008/r0_r1_rwl
+ u_t024_008/r1_w0_wl u_t024_008/r1_w1_wl u_t024_008/r1_r0_rwl u_t024_008/r1_r1_rwl
+ u_t024_008/r2_w0_wl u_t024_008/r2_w1_wl u_t024_008/r2_r0_rwl u_t024_008/r2_r1_rwl
+ u_t024_008/r3_w0_wl u_t024_008/r3_w1_wl u_t024_008/r3_r0_rwl u_t024_008/r3_r1_rwl
+ VSS u_t024_009/VSS u_t024_008/m2_717_1265# u_t024_008/m2_603_2031# u_t024_008/m2_1290_336#
+ u_t024_008/m2_2000_2037# u_t024_008/m2_791_2909# u_t024_008/m2_7_2126# u_t024_008/m2_2154_2081#
+ u_t024_008/m2_1795_2037# u_t024_008/m2_871_303# u_t024_008/m2_431_438# u_t024_008/m2_1290_2898#
+ u_t024_008/m2_1714_1210# u_t024_008/m2_431_1982# u_t024_008/m2_512_1265# u_t024_008/m2_2573_2126#
+ u_t024_008/m2_603_1259# u_t024_008/m2_2074_2909# u_t024_008/m2_7_336# u_t024_008/m2_717_2037#
+ u_t024_008/m2_1886_2031# u_t024_008/m2_2573_336# u_t024_008/m2_7_2898# u_t024_008/m2_2000_1265#
+ u_t024_008/m2_512_2037# u_t024_008/m2_1795_1265# u_t024_008/m2_1714_1982# u_t024_008/m2_1886_1259#
+ u_t024_008/m2_1290_2126# u_t024_008/m2_1714_438# u_t024_008/m2_431_1210# u_t024_008/m2_2573_2898#
+ u_t024_008/m2_2154_303# u_t024_008/m2_871_2081# VSUBS detronyx_12t_2w2r_rc4_4x4_routed_5layer_direct
Xu_t009_005 u_t009_005/c0_w0_bl u_t009_005/c0_w0_br u_t009_005/c0_w1_bl u_t009_005/c0_w1_br
+ u_t009_005/c0_r0_rbl u_t009_005/c0_r1_rbl u_t009_005/c1_w0_bl u_t009_005/c1_w0_br
+ u_t009_005/c1_w1_bl u_t009_005/c1_w1_br u_t009_005/c1_r0_rbl u_t009_005/c1_r1_rbl
+ u_t009_005/c2_w0_bl u_t009_005/c2_w0_br u_t009_005/c2_w1_bl u_t009_005/c2_w1_br
+ u_t009_005/c2_r0_rbl u_t009_005/c2_r1_rbl u_t009_005/c3_w0_bl u_t009_005/c3_w0_br
+ u_t009_005/c3_w1_bl u_t009_005/c3_w1_br u_t009_005/c3_r0_rbl u_t009_005/c3_r1_rbl
+ u_t009_005/r0_w0_wl u_t009_005/r0_w1_wl u_t009_005/r0_r0_rwl u_t009_005/r0_r1_rwl
+ u_t009_005/r1_w0_wl u_t009_005/r1_w1_wl u_t009_005/r1_r0_rwl u_t009_005/r1_r1_rwl
+ u_t009_005/r2_w0_wl u_t009_005/r2_w1_wl u_t009_005/r2_r0_rwl u_t009_005/r2_r1_rwl
+ u_t009_005/r3_w0_wl u_t009_005/r3_w1_wl u_t009_005/r3_r0_rwl u_t009_005/r3_r1_rwl
+ u_t009_005/VDD VSS u_t009_005/m2_717_1265# u_t009_005/m2_603_2031# u_t009_005/m2_1290_336#
+ u_t009_005/m2_2000_2037# u_t009_005/m2_791_2909# u_t009_005/m2_7_2126# u_t009_005/m2_2154_2081#
+ u_t009_005/m2_1795_2037# u_t009_005/m2_871_303# u_t009_005/m2_431_438# u_t009_005/m2_1290_2898#
+ u_t009_005/m2_1714_1210# u_t009_005/m2_431_1982# u_t009_005/m2_512_1265# u_t009_005/m2_2573_2126#
+ u_t009_005/m2_603_1259# u_t009_005/m2_2074_2909# u_t009_005/m2_7_336# u_t009_005/m2_717_2037#
+ u_t009_005/m2_1886_2031# u_t009_005/m2_2573_336# u_t009_005/m2_7_2898# u_t009_005/m2_2000_1265#
+ u_t009_005/m2_512_2037# u_t009_005/m2_1795_1265# u_t009_005/m2_1714_1982# u_t009_005/m2_1886_1259#
+ u_t009_005/m2_1290_2126# u_t009_005/m2_1714_438# u_t009_005/m2_431_1210# u_t009_005/m2_2573_2898#
+ u_t009_005/m2_2154_303# u_t009_005/m2_871_2081# VSUBS detronyx_12t_2w2r_rc4_4x4_routed_5layer_direct
Xgf180mcu_as_sc_mcu7t3v3__inv_2_152 gf180mcu_as_sc_mcu7t3v3__inv_2_152/VDD gf180mcu_as_sc_mcu7t3v3__nand4_2_9/VDD
+ gf180mcu_as_sc_mcu7t3v3__inv_2_152/Y VSS gf180mcu_as_sc_mcu7t3v3__inv_2_152/VNW
+ VSUBS gf180mcu_as_sc_mcu7t3v3__inv_2
Xgf180mcu_as_sc_mcu7t3v3__inv_2_141 gf180mcu_as_sc_mcu7t3v3__inv_2_143/VDD gf180mcu_as_sc_mcu7t3v3__inv_2_146/VDD
+ gf180mcu_as_sc_mcu7t3v3__inv_2_141/Y VSS gf180mcu_as_sc_mcu7t3v3__inv_2_143/VNW
+ VSUBS gf180mcu_as_sc_mcu7t3v3__inv_2
Xgf180mcu_as_sc_mcu7t3v3__inv_2_130 gf180mcu_as_sc_mcu7t3v3__inv_2_131/VDD gf180mcu_as_sc_mcu7t3v3__inv_2_134/VDD
+ gf180mcu_as_sc_mcu7t3v3__inv_2_130/Y VSS gf180mcu_as_sc_mcu7t3v3__inv_2_131/VNW
+ VSUBS gf180mcu_as_sc_mcu7t3v3__inv_2
Xgf180mcu_as_sc_mcu7t3v3__inv_2_1607 gf180mcu_as_sc_mcu7t3v3__inv_2_1689/VDD gf180mcu_as_sc_mcu7t3v3__inv_2_1689/VSS
+ gf180mcu_as_sc_mcu7t3v3__inv_2_1607/Y gf180mcu_as_sc_mcu7t3v3__inv_2_1689/A gf180mcu_as_sc_mcu7t3v3__inv_2_1689/VNW
+ VSUBS gf180mcu_as_sc_mcu7t3v3__inv_2
Xgf180mcu_as_sc_mcu7t3v3__inv_2_1629 VSS VSS VSS gf180mcu_as_sc_mcu7t3v3__inv_2_1685/A
+ gf180mcu_as_sc_mcu7t3v3__inv_2_1631/VNW VSUBS gf180mcu_as_sc_mcu7t3v3__inv_2
Xgf180mcu_as_sc_mcu7t3v3__inv_2_1618 gf180mcu_as_sc_mcu7t3v3__inv_2_1618/VDD VSS gf180mcu_as_sc_mcu7t3v3__inv_2_1669/A
+ VSS gf180mcu_as_sc_mcu7t3v3__inv_2_1618/VNW VSUBS gf180mcu_as_sc_mcu7t3v3__inv_2
Xgf180mcu_as_sc_mcu7t3v3__inv_2_174 VSS VSS VSS VSS gf180mcu_as_sc_mcu7t3v3__inv_2_174/VNW
+ VSUBS gf180mcu_as_sc_mcu7t3v3__inv_2
Xgf180mcu_as_sc_mcu7t3v3__inv_2_196 VSS VSS VSS VSS gf180mcu_as_sc_mcu7t3v3__inv_2_196/VNW
+ VSUBS gf180mcu_as_sc_mcu7t3v3__inv_2
Xgf180mcu_as_sc_mcu7t3v3__inv_2_163 gf180mcu_as_sc_mcu7t3v3__inv_2_163/VDD VSS VSS
+ VSS gf180mcu_as_sc_mcu7t3v3__inv_2_163/VNW VSUBS gf180mcu_as_sc_mcu7t3v3__inv_2
Xgf180mcu_as_sc_mcu7t3v3__inv_2_185 VSS gf180mcu_as_sc_mcu7t3v3__inv_2_190/VDD VSS
+ VSS gf180mcu_as_sc_mcu7t3v3__inv_2_187/VNW VSUBS gf180mcu_as_sc_mcu7t3v3__inv_2
Xu_t015_008 u_t015_008/c0_w0_bl u_t015_008/c0_w0_br u_t015_008/c0_w1_bl u_t015_008/c0_w1_br
+ u_t015_008/c0_r0_rbl u_t015_008/c0_r1_rbl u_t015_008/c1_w0_bl u_t015_008/c1_w0_br
+ u_t015_008/c1_w1_bl u_t015_008/c1_w1_br u_t015_008/c1_r0_rbl u_t015_008/c1_r1_rbl
+ u_t015_008/c2_w0_bl u_t015_008/c2_w0_br u_t015_008/c2_w1_bl u_t015_008/c2_w1_br
+ u_t015_008/c2_r0_rbl u_t015_008/c2_r1_rbl u_t015_008/c3_w0_bl u_t015_008/c3_w0_br
+ u_t015_008/c3_w1_bl u_t015_008/c3_w1_br u_t015_008/c3_r0_rbl u_t015_008/c3_r1_rbl
+ u_t015_008/r0_w0_wl u_t015_008/r0_w1_wl u_t015_008/r0_r0_rwl u_t015_008/r0_r1_rwl
+ u_t015_008/r1_w0_wl u_t015_008/r1_w1_wl u_t015_008/r1_r0_rwl u_t015_008/r1_r1_rwl
+ u_t015_008/r2_w0_wl u_t015_008/r2_w1_wl u_t015_008/r2_r0_rwl u_t015_008/r2_r1_rwl
+ u_t015_008/r3_w0_wl u_t015_008/r3_w1_wl u_t015_008/r3_r0_rwl u_t015_008/r3_r1_rwl
+ VSS u_t015_009/VSS u_t015_008/m2_717_1265# u_t015_008/m2_603_2031# u_t015_008/m2_1290_336#
+ u_t015_008/m2_2000_2037# u_t015_008/m2_791_2909# u_t015_008/m2_7_2126# u_t015_008/m2_2154_2081#
+ u_t015_008/m2_1795_2037# u_t015_008/m2_871_303# u_t015_008/m2_431_438# u_t015_008/m2_1290_2898#
+ u_t015_008/m2_1714_1210# u_t015_008/m2_431_1982# u_t015_008/m2_512_1265# u_t015_008/m2_2573_2126#
+ u_t015_008/m2_603_1259# u_t015_008/m2_2074_2909# u_t015_008/m2_7_336# u_t015_008/m2_717_2037#
+ u_t015_008/m2_1886_2031# u_t015_008/m2_2573_336# u_t015_008/m2_7_2898# u_t015_008/m2_2000_1265#
+ u_t015_008/m2_512_2037# u_t015_008/m2_1795_1265# u_t015_008/m2_1714_1982# u_t015_008/m2_1886_1259#
+ u_t015_008/m2_1290_2126# u_t015_008/m2_1714_438# u_t015_008/m2_431_1210# u_t015_008/m2_2573_2898#
+ u_t015_008/m2_2154_303# u_t015_008/m2_871_2081# VSUBS detronyx_12t_2w2r_rc4_4x4_routed_5layer_direct
Xu_t006_008 u_t006_008/c0_w0_bl u_t006_008/c0_w0_br u_t006_008/c0_w1_bl u_t006_008/c0_w1_br
+ u_t006_008/c0_r0_rbl u_t006_008/c0_r1_rbl u_t006_008/c1_w0_bl u_t006_008/c1_w0_br
+ u_t006_008/c1_w1_bl u_t006_008/c1_w1_br u_t006_008/c1_r0_rbl u_t006_008/c1_r1_rbl
+ u_t006_008/c2_w0_bl u_t006_008/c2_w0_br u_t006_008/c2_w1_bl u_t006_008/c2_w1_br
+ u_t006_008/c2_r0_rbl u_t006_008/c2_r1_rbl u_t006_008/c3_w0_bl u_t006_008/c3_w0_br
+ u_t006_008/c3_w1_bl u_t006_008/c3_w1_br u_t006_008/c3_r0_rbl u_t006_008/c3_r1_rbl
+ u_t006_008/r0_w0_wl u_t006_008/r0_w1_wl u_t006_008/r0_r0_rwl u_t006_008/r0_r1_rwl
+ u_t006_008/r1_w0_wl u_t006_008/r1_w1_wl u_t006_008/r1_r0_rwl u_t006_008/r1_r1_rwl
+ u_t006_008/r2_w0_wl u_t006_008/r2_w1_wl u_t006_008/r2_r0_rwl u_t006_008/r2_r1_rwl
+ u_t006_008/r3_w0_wl u_t006_008/r3_w1_wl u_t006_008/r3_r0_rwl u_t006_008/r3_r1_rwl
+ VSS u_t006_009/VSS u_t006_008/m2_717_1265# u_t006_008/m2_603_2031# u_t006_008/m2_1290_336#
+ u_t006_008/m2_2000_2037# u_t006_008/m2_791_2909# u_t006_008/m2_7_2126# u_t006_008/m2_2154_2081#
+ u_t006_008/m2_1795_2037# u_t006_008/m2_871_303# u_t006_008/m2_431_438# u_t006_008/m2_1290_2898#
+ u_t006_008/m2_1714_1210# u_t006_008/m2_431_1982# u_t006_008/m2_512_1265# u_t006_008/m2_2573_2126#
+ u_t006_008/m2_603_1259# u_t006_008/m2_2074_2909# u_t006_008/m2_7_336# u_t006_008/m2_717_2037#
+ u_t006_008/m2_1886_2031# u_t006_008/m2_2573_336# u_t006_008/m2_7_2898# u_t006_008/m2_2000_1265#
+ u_t006_008/m2_512_2037# u_t006_008/m2_1795_1265# u_t006_008/m2_1714_1982# u_t006_008/m2_1886_1259#
+ u_t006_008/m2_1290_2126# u_t006_008/m2_1714_438# u_t006_008/m2_431_1210# u_t006_008/m2_2573_2898#
+ u_t006_008/m2_2154_303# u_t006_008/m2_871_2081# VSUBS detronyx_12t_2w2r_rc4_4x4_routed_5layer_direct
Xgf180mcu_as_sc_mcu7t3v3__nand2_2_42 gf180mcu_as_sc_mcu7t3v3__nand3_2_65/VDD gf180mcu_as_sc_mcu7t3v3__nor2_2_9/VSS
+ VSS VSS VSS gf180mcu_as_sc_mcu7t3v3__nand3_2_65/VNW VSUBS gf180mcu_as_sc_mcu7t3v3__nand2_2
Xgf180mcu_as_sc_mcu7t3v3__nand2_2_20 gf180mcu_as_sc_mcu7t3v3__nor2_2_4/VDD gf180mcu_as_sc_mcu7t3v3__nor2_2_4/VSS
+ VSS VSS VSS gf180mcu_as_sc_mcu7t3v3__nor2_2_4/VNW VSUBS gf180mcu_as_sc_mcu7t3v3__nand2_2
Xgf180mcu_as_sc_mcu7t3v3__nand2_2_31 gf180mcu_as_sc_mcu7t3v3__nand3_2_9/VDD gf180mcu_as_sc_mcu7t3v3__nor2_2_4/VSS
+ VSS VSS VSS gf180mcu_as_sc_mcu7t3v3__nand3_2_9/VNW VSUBS gf180mcu_as_sc_mcu7t3v3__nand2_2
Xu_t020_000 VSS u_t020_000/c0_w0_br VSS u_t020_000/c0_w1_br u_t020_000/c0_r0_rbl u_t020_000/c0_r1_rbl
+ VSS VSS VSS VSS VSS VSS u_t020_000/c2_w0_bl u_t020_000/c2_w0_br u_t020_000/c2_w1_bl
+ u_t020_000/c2_w1_br u_t020_000/c2_r0_rbl u_t020_000/c2_r1_rbl u_t020_000/c3_w0_bl
+ u_t020_000/c3_w0_br u_t020_000/c3_w1_bl u_t020_000/c3_w1_br u_t020_000/c3_r0_rbl
+ u_t020_000/c3_r1_rbl VSS VSS VSS VSS VSS VSS VSS VSS VSS VSS VSS VSS VSS VSS VSS
+ VSS VSS VSS VSS VSS VSS VSS VSS VSS VSS VSS VSS VSS VSS VSS VSS VSS u_t020_000/m2_2573_2126#
+ VSS VSS VSS VSS VSS u_t020_000/m2_2573_336# VSS VSS VSS VSS VSS VSS VSS VSS VSS
+ u_t020_000/m2_2573_2898# VSS VSS VSUBS detronyx_12t_2w2r_rc4_4x4_routed_5layer_direct
Xu_t020_011 u_t020_011/c0_w0_bl u_t020_011/c0_w0_br u_t020_011/c0_w1_bl u_t020_011/c0_w1_br
+ u_t020_011/c0_r0_rbl u_t020_011/c0_r1_rbl u_t020_011/c1_w0_bl u_t020_011/c1_w0_br
+ u_t020_011/c1_w1_bl u_t020_011/c1_w1_br u_t020_011/c1_r0_rbl u_t020_011/c1_r1_rbl
+ u_t020_011/c2_w0_bl u_t020_011/c2_w0_br u_t020_011/c2_w1_bl u_t020_011/c2_w1_br
+ u_t020_011/c2_r0_rbl u_t020_011/c2_r1_rbl u_t020_011/c3_w0_bl u_t020_011/c3_w0_br
+ u_t020_011/c3_w1_bl u_t020_011/c3_w1_br u_t020_011/c3_r0_rbl u_t020_011/c3_r1_rbl
+ u_t020_011/r0_w0_wl u_t020_011/r0_w1_wl u_t020_011/r0_r0_rwl u_t020_011/r0_r1_rwl
+ u_t020_011/r1_w0_wl u_t020_011/r1_w1_wl u_t020_011/r1_r0_rwl u_t020_011/r1_r1_rwl
+ u_t020_011/r2_w0_wl u_t020_011/r2_w1_wl u_t020_011/r2_r0_rwl u_t020_011/r2_r1_rwl
+ u_t020_011/r3_w0_wl u_t020_011/r3_w1_wl u_t020_011/r3_r0_rwl u_t020_011/r3_r1_rwl
+ u_t020_011/VDD u_t020_011/VSS u_t020_011/m2_717_1265# u_t020_011/m2_603_2031# u_t020_011/m2_1290_336#
+ u_t020_011/m2_2000_2037# u_t020_011/m2_791_2909# u_t020_011/m2_7_2126# u_t020_011/m2_2154_2081#
+ u_t020_011/m2_1795_2037# u_t020_011/m2_871_303# u_t020_011/m2_431_438# u_t020_011/m2_1290_2898#
+ u_t020_011/m2_1714_1210# u_t020_011/m2_431_1982# u_t020_011/m2_512_1265# u_t020_011/m2_2573_2126#
+ u_t020_011/m2_603_1259# u_t020_011/m2_2074_2909# u_t020_011/m2_7_336# u_t020_011/m2_717_2037#
+ u_t020_011/m2_1886_2031# u_t020_011/m2_2573_336# u_t020_011/m2_7_2898# u_t020_011/m2_2000_1265#
+ u_t020_011/m2_512_2037# u_t020_011/m2_1795_1265# u_t020_011/m2_1714_1982# u_t020_011/m2_1886_1259#
+ u_t020_011/m2_1290_2126# u_t020_011/m2_1714_438# u_t020_011/m2_431_1210# u_t020_011/m2_2573_2898#
+ u_t020_011/m2_2154_303# u_t020_011/m2_871_2081# VSUBS detronyx_12t_2w2r_rc4_4x4_routed_5layer_direct
Xgf180mcu_as_sc_mcu7t3v3__inv_2_1404 gf180mcu_as_sc_mcu7t3v3__inv_2_1406/VDD gf180mcu_as_sc_mcu7t3v3__inv_2_1406/VSS
+ VSS gf180mcu_as_sc_mcu7t3v3__inv_2_1409/A gf180mcu_as_sc_mcu7t3v3__inv_2_1406/VNW
+ VSUBS gf180mcu_as_sc_mcu7t3v3__inv_2
Xgf180mcu_as_sc_mcu7t3v3__inv_2_1459 VSS gf180mcu_as_sc_mcu7t3v3__inv_2_1511/VDD VSS
+ VSS gf180mcu_as_sc_mcu7t3v3__inv_2_1461/VNW VSUBS gf180mcu_as_sc_mcu7t3v3__inv_2
Xgf180mcu_as_sc_mcu7t3v3__inv_2_1415 gf180mcu_as_sc_mcu7t3v3__inv_2_1416/VDD VSS gf180mcu_as_sc_mcu7t3v3__inv_2_1415/Y
+ VSS gf180mcu_as_sc_mcu7t3v3__inv_2_1416/VNW VSUBS gf180mcu_as_sc_mcu7t3v3__inv_2
Xgf180mcu_as_sc_mcu7t3v3__inv_2_1448 VSS gf180mcu_as_sc_mcu7t3v3__inv_2_1452/VDD VSS
+ VSS gf180mcu_as_sc_mcu7t3v3__inv_2_1449/VNW VSUBS gf180mcu_as_sc_mcu7t3v3__inv_2
Xgf180mcu_as_sc_mcu7t3v3__inv_2_1437 VSS VSS VSS VSS gf180mcu_as_sc_mcu7t3v3__inv_2_1437/VNW
+ VSUBS gf180mcu_as_sc_mcu7t3v3__inv_2
Xgf180mcu_as_sc_mcu7t3v3__inv_2_1426 VSS VSS VSS VSS gf180mcu_as_sc_mcu7t3v3__inv_2_1428/VNW
+ VSUBS gf180mcu_as_sc_mcu7t3v3__inv_2
Xu_t011_011 u_t011_011/c0_w0_bl u_t011_011/c0_w0_br u_t011_011/c0_w1_bl u_t011_011/c0_w1_br
+ u_t011_011/c0_r0_rbl u_t011_011/c0_r1_rbl u_t011_011/c1_w0_bl u_t011_011/c1_w0_br
+ u_t011_011/c1_w1_bl u_t011_011/c1_w1_br u_t011_011/c1_r0_rbl u_t011_011/c1_r1_rbl
+ u_t011_011/c2_w0_bl u_t011_011/c2_w0_br u_t011_011/c2_w1_bl u_t011_011/c2_w1_br
+ u_t011_011/c2_r0_rbl u_t011_011/c2_r1_rbl u_t011_011/c3_w0_bl u_t011_011/c3_w0_br
+ u_t011_011/c3_w1_bl u_t011_011/c3_w1_br u_t011_011/c3_r0_rbl u_t011_011/c3_r1_rbl
+ u_t011_011/r0_w0_wl u_t011_011/r0_w1_wl u_t011_011/r0_r0_rwl u_t011_011/r0_r1_rwl
+ u_t011_011/r1_w0_wl u_t011_011/r1_w1_wl u_t011_011/r1_r0_rwl u_t011_011/r1_r1_rwl
+ u_t011_011/r2_w0_wl u_t011_011/r2_w1_wl u_t011_011/r2_r0_rwl u_t011_011/r2_r1_rwl
+ u_t011_011/r3_w0_wl u_t011_011/r3_w1_wl u_t011_011/r3_r0_rwl u_t011_011/r3_r1_rwl
+ u_t011_011/VDD u_t011_011/VSS u_t011_011/m2_717_1265# u_t011_011/m2_603_2031# u_t011_011/m2_1290_336#
+ u_t011_011/m2_2000_2037# u_t011_011/m2_791_2909# u_t011_011/m2_7_2126# u_t011_011/m2_2154_2081#
+ u_t011_011/m2_1795_2037# u_t011_011/m2_871_303# u_t011_011/m2_431_438# u_t011_011/m2_1290_2898#
+ u_t011_011/m2_1714_1210# u_t011_011/m2_431_1982# u_t011_011/m2_512_1265# u_t011_011/m2_2573_2126#
+ u_t011_011/m2_603_1259# u_t011_011/m2_2074_2909# u_t011_011/m2_7_336# u_t011_011/m2_717_2037#
+ u_t011_011/m2_1886_2031# u_t011_011/m2_2573_336# u_t011_011/m2_7_2898# u_t011_011/m2_2000_1265#
+ u_t011_011/m2_512_2037# u_t011_011/m2_1795_1265# u_t011_011/m2_1714_1982# u_t011_011/m2_1886_1259#
+ u_t011_011/m2_1290_2126# u_t011_011/m2_1714_438# u_t011_011/m2_431_1210# u_t011_011/m2_2573_2898#
+ u_t011_011/m2_2154_303# u_t011_011/m2_871_2081# VSUBS detronyx_12t_2w2r_rc4_4x4_routed_5layer_direct
Xu_t011_000 VSS u_t011_000/c0_w0_br VSS u_t011_000/c0_w1_br u_t011_000/c0_r0_rbl u_t011_000/c0_r1_rbl
+ VSS VSS VSS VSS VSS VSS u_t011_000/c2_w0_bl u_t011_000/c2_w0_br u_t011_000/c2_w1_bl
+ u_t011_000/c2_w1_br u_t011_000/c2_r0_rbl u_t011_000/c2_r1_rbl u_t011_000/c3_w0_bl
+ u_t011_000/c3_w0_br u_t011_000/c3_w1_bl u_t011_000/c3_w1_br u_t011_000/c3_r0_rbl
+ u_t011_000/c3_r1_rbl VSS VSS VSS VSS VSS VSS VSS VSS VSS VSS VSS VSS VSS VSS VSS
+ VSS VSS VSS u_t011_000/m2_717_1265# u_t011_000/m2_603_2031# u_t011_000/m2_1290_336#
+ u_t011_000/m2_2000_2037# u_t011_000/m2_791_2909# u_t011_000/m2_7_2126# u_t011_000/m2_2154_2081#
+ u_t011_000/m2_1795_2037# u_t011_000/m2_871_303# u_t011_000/m2_431_438# u_t011_000/m2_1290_2898#
+ u_t011_000/m2_1714_1210# u_t011_000/m2_431_1982# u_t011_000/m2_512_1265# u_t011_000/m2_2573_2126#
+ u_t011_000/m2_603_1259# u_t011_000/m2_2074_2909# u_t011_000/m2_7_336# u_t011_000/m2_717_2037#
+ u_t011_000/m2_1886_2031# u_t011_000/m2_2573_336# u_t011_000/m2_7_2898# u_t011_000/m2_2000_1265#
+ u_t011_000/m2_512_2037# u_t011_000/m2_1795_1265# u_t011_000/m2_1714_1982# u_t011_000/m2_1886_1259#
+ u_t011_000/m2_1290_2126# u_t011_000/m2_1714_438# u_t011_000/m2_431_1210# u_t011_000/m2_2573_2898#
+ u_t011_000/m2_2154_303# u_t011_000/m2_871_2081# VSUBS detronyx_12t_2w2r_rc4_4x4_routed_5layer_direct
Xgf180mcu_as_sc_mcu7t3v3__nand4_2_209 gf180mcu_as_sc_mcu7t3v3__inv_2_678/VDD gf180mcu_as_sc_mcu7t3v3__inv_2_689/VDD
+ VSS VSS VSS VSS VSS gf180mcu_as_sc_mcu7t3v3__inv_2_678/VNW VSUBS gf180mcu_as_sc_mcu7t3v3__nand4_2
Xu_t002_011 u_t002_011/c0_w0_bl u_t002_011/c0_w0_br u_t002_011/c0_w1_bl u_t002_011/c0_w1_br
+ u_t002_011/c0_r0_rbl u_t002_011/c0_r1_rbl u_t002_011/c1_w0_bl u_t002_011/c1_w0_br
+ u_t002_011/c1_w1_bl u_t002_011/c1_w1_br u_t002_011/c1_r0_rbl u_t002_011/c1_r1_rbl
+ u_t002_011/c2_w0_bl u_t002_011/c2_w0_br u_t002_011/c2_w1_bl u_t002_011/c2_w1_br
+ u_t002_011/c2_r0_rbl u_t002_011/c2_r1_rbl u_t002_011/c3_w0_bl u_t002_011/c3_w0_br
+ u_t002_011/c3_w1_bl u_t002_011/c3_w1_br u_t002_011/c3_r0_rbl u_t002_011/c3_r1_rbl
+ u_t002_011/r0_w0_wl u_t002_011/r0_w1_wl u_t002_011/r0_r0_rwl u_t002_011/r0_r1_rwl
+ u_t002_011/r1_w0_wl u_t002_011/r1_w1_wl u_t002_011/r1_r0_rwl u_t002_011/r1_r1_rwl
+ u_t002_011/r2_w0_wl u_t002_011/r2_w1_wl u_t002_011/r2_r0_rwl u_t002_011/r2_r1_rwl
+ u_t002_011/r3_w0_wl u_t002_011/r3_w1_wl u_t002_011/r3_r0_rwl u_t002_011/r3_r1_rwl
+ u_t002_011/VDD u_t002_011/VSS u_t002_011/m2_717_1265# u_t002_011/m2_603_2031# u_t002_011/m2_1290_336#
+ u_t002_011/m2_2000_2037# u_t002_011/m2_791_2909# u_t002_011/m2_7_2126# u_t002_011/m2_2154_2081#
+ u_t002_011/m2_1795_2037# u_t002_011/m2_871_303# u_t002_011/m2_431_438# u_t002_011/m2_1290_2898#
+ u_t002_011/m2_1714_1210# u_t002_011/m2_431_1982# u_t002_011/m2_512_1265# u_t002_011/m2_2573_2126#
+ u_t002_011/m2_603_1259# u_t002_011/m2_2074_2909# u_t002_011/m2_7_336# u_t002_011/m2_717_2037#
+ u_t002_011/m2_1886_2031# u_t002_011/m2_2573_336# u_t002_011/m2_7_2898# u_t002_011/m2_2000_1265#
+ u_t002_011/m2_512_2037# u_t002_011/m2_1795_1265# u_t002_011/m2_1714_1982# u_t002_011/m2_1886_1259#
+ u_t002_011/m2_1290_2126# u_t002_011/m2_1714_438# u_t002_011/m2_431_1210# u_t002_011/m2_2573_2898#
+ u_t002_011/m2_2154_303# u_t002_011/m2_871_2081# VSUBS detronyx_12t_2w2r_rc4_4x4_routed_5layer_direct
Xu_t002_000 VSS u_t002_000/c0_w0_br VSS u_t002_000/c0_w1_br u_t002_000/c0_r0_rbl u_t002_000/c0_r1_rbl
+ VSS VSS VSS VSS VSS VSS u_t002_000/c2_w0_bl u_t002_000/c2_w0_br u_t002_000/c2_w1_bl
+ u_t002_000/c2_w1_br u_t002_000/c2_r0_rbl u_t002_000/c2_r1_rbl u_t002_000/c3_w0_bl
+ u_t002_000/c3_w0_br u_t002_000/c3_w1_bl u_t002_000/c3_w1_br u_t002_000/c3_r0_rbl
+ u_t002_000/c3_r1_rbl VSS VSS VSS VSS VSS VSS VSS VSS VSS VSS VSS VSS VSS VSS VSS
+ VSS VSS VSS u_t002_000/m2_717_1265# u_t002_000/m2_603_2031# u_t002_000/m2_1290_336#
+ u_t002_000/m2_2000_2037# u_t002_000/m2_791_2909# u_t002_000/m2_7_2126# u_t002_000/m2_2154_2081#
+ u_t002_000/m2_1795_2037# u_t002_000/m2_871_303# u_t002_000/m2_431_438# u_t002_000/m2_1290_2898#
+ u_t002_000/m2_1714_1210# u_t002_000/m2_431_1982# u_t002_000/m2_512_1265# u_t002_000/m2_2573_2126#
+ u_t002_000/m2_603_1259# u_t002_000/m2_2074_2909# u_t002_000/m2_7_336# u_t002_000/m2_717_2037#
+ u_t002_000/m2_1886_2031# u_t002_000/m2_2573_336# u_t002_000/m2_7_2898# u_t002_000/m2_2000_1265#
+ u_t002_000/m2_512_2037# u_t002_000/m2_1795_1265# u_t002_000/m2_1714_1982# u_t002_000/m2_1886_1259#
+ u_t002_000/m2_1290_2126# u_t002_000/m2_1714_438# u_t002_000/m2_431_1210# u_t002_000/m2_2573_2898#
+ u_t002_000/m2_2154_303# u_t002_000/m2_871_2081# VSUBS detronyx_12t_2w2r_rc4_4x4_routed_5layer_direct
Xgf180mcu_as_sc_mcu7t3v3__inv_2_1201 gf180mcu_as_sc_mcu7t3v3__nor2_2_9/VDD gf180mcu_as_sc_mcu7t3v3__nor2_2_9/VSS
+ gf180mcu_as_sc_mcu7t3v3__inv_2_1201/Y VSS gf180mcu_as_sc_mcu7t3v3__nor2_2_9/VNW
+ VSUBS gf180mcu_as_sc_mcu7t3v3__inv_2
Xgf180mcu_as_sc_mcu7t3v3__inv_2_1245 gf180mcu_as_sc_mcu7t3v3__nor2_2_9/VDD gf180mcu_as_sc_mcu7t3v3__nand3_2_63/VSS
+ VSS VSS gf180mcu_as_sc_mcu7t3v3__nor2_2_9/VNW VSUBS gf180mcu_as_sc_mcu7t3v3__inv_2
Xgf180mcu_as_sc_mcu7t3v3__inv_2_1234 gf180mcu_as_sc_mcu7t3v3__nor2_2_9/VDD gf180mcu_as_sc_mcu7t3v3__nand3_2_63/VSS
+ VSS VSS gf180mcu_as_sc_mcu7t3v3__nor2_2_9/VNW VSUBS gf180mcu_as_sc_mcu7t3v3__inv_2
Xgf180mcu_as_sc_mcu7t3v3__inv_2_1267 gf180mcu_as_sc_mcu7t3v3__nor2_2_9/VDD gf180mcu_as_sc_mcu7t3v3__nand3_2_63/VSS
+ VSS VSS gf180mcu_as_sc_mcu7t3v3__nor2_2_9/VNW VSUBS gf180mcu_as_sc_mcu7t3v3__inv_2
Xgf180mcu_as_sc_mcu7t3v3__inv_2_1212 gf180mcu_as_sc_mcu7t3v3__nor2_2_9/VDD gf180mcu_as_sc_mcu7t3v3__nand3_2_63/VSS
+ gf180mcu_as_sc_mcu7t3v3__inv_2_1212/Y VSS gf180mcu_as_sc_mcu7t3v3__nor2_2_9/VNW
+ VSUBS gf180mcu_as_sc_mcu7t3v3__inv_2
Xgf180mcu_as_sc_mcu7t3v3__inv_2_1256 gf180mcu_as_sc_mcu7t3v3__nor2_2_9/VDD gf180mcu_as_sc_mcu7t3v3__nor2_2_9/VSS
+ gf180mcu_as_sc_mcu7t3v3__inv_2_1256/Y VSS gf180mcu_as_sc_mcu7t3v3__nor2_2_9/VNW
+ VSUBS gf180mcu_as_sc_mcu7t3v3__inv_2
Xgf180mcu_as_sc_mcu7t3v3__inv_2_1223 VSS VSS VSS VSS gf180mcu_as_sc_mcu7t3v3__inv_2_1276/VNW
+ VSUBS gf180mcu_as_sc_mcu7t3v3__inv_2
Xgf180mcu_as_sc_mcu7t3v3__inv_2_1278 VSS VSS VSS VSS gf180mcu_as_sc_mcu7t3v3__inv_2_1278/VNW
+ VSUBS gf180mcu_as_sc_mcu7t3v3__inv_2
Xgf180mcu_as_sc_mcu7t3v3__inv_2_1289 VSS VSS VSS VSS gf180mcu_as_sc_mcu7t3v3__inv_2_1289/VNW
+ VSUBS gf180mcu_as_sc_mcu7t3v3__inv_2
Xgf180mcu_as_sc_mcu7t3v3__inv_2_718 VSS VSS gf180mcu_as_sc_mcu7t3v3__inv_2_718/Y gf180mcu_as_sc_mcu7t3v3__inv_2_722/A
+ gf180mcu_as_sc_mcu7t3v3__inv_2_720/VNW VSUBS gf180mcu_as_sc_mcu7t3v3__inv_2
Xgf180mcu_as_sc_mcu7t3v3__inv_2_707 gf180mcu_as_sc_mcu7t3v3__inv_2_730/VDD VSS gf180mcu_as_sc_mcu7t3v3__inv_2_707/Y
+ gf180mcu_as_sc_mcu7t3v3__inv_2_730/Y gf180mcu_as_sc_mcu7t3v3__inv_2_730/VNW VSUBS
+ gf180mcu_as_sc_mcu7t3v3__inv_2
Xgf180mcu_as_sc_mcu7t3v3__inv_2_729 gf180mcu_as_sc_mcu7t3v3__inv_2_731/VDD gf180mcu_as_sc_mcu7t3v3__inv_2_741/VDD
+ gf180mcu_as_sc_mcu7t3v3__inv_2_729/Y gf180mcu_as_sc_mcu7t3v3__inv_2_731/Y gf180mcu_as_sc_mcu7t3v3__inv_2_731/VNW
+ VSUBS gf180mcu_as_sc_mcu7t3v3__inv_2
Xgf180mcu_as_sc_mcu7t3v3__inv_2_1031 VSS gf180mcu_as_sc_mcu7t3v3__inv_2_1036/VDD gf180mcu_as_sc_mcu7t3v3__inv_2_1306/Y
+ gf180mcu_as_sc_mcu7t3v3__inv_2_1032/Y gf180mcu_as_sc_mcu7t3v3__inv_2_1032/VNW VSUBS
+ gf180mcu_as_sc_mcu7t3v3__inv_2
Xgf180mcu_as_sc_mcu7t3v3__inv_2_1042 VSS gf180mcu_as_sc_mcu7t3v3__inv_2_1048/VDD VSS
+ gf180mcu_as_sc_mcu7t3v3__inv_2_962/A gf180mcu_as_sc_mcu7t3v3__inv_2_1044/VNW VSUBS
+ gf180mcu_as_sc_mcu7t3v3__inv_2
Xgf180mcu_as_sc_mcu7t3v3__inv_2_1053 gf180mcu_as_sc_mcu7t3v3__inv_2_1053/VDD VSS gf180mcu_as_sc_mcu7t3v3__inv_2_1053/Y
+ gf180mcu_as_sc_mcu7t3v3__inv_2_1053/A gf180mcu_as_sc_mcu7t3v3__inv_2_1053/VNW VSUBS
+ gf180mcu_as_sc_mcu7t3v3__inv_2
Xgf180mcu_as_sc_mcu7t3v3__inv_2_83 gf180mcu_as_sc_mcu7t3v3__inv_2_94/VDD gf180mcu_as_sc_mcu7t3v3__inv_2_94/VDD
+ VSS VSS gf180mcu_as_sc_mcu7t3v3__inv_2_92/VNW VSUBS gf180mcu_as_sc_mcu7t3v3__inv_2
Xgf180mcu_as_sc_mcu7t3v3__inv_2_94 gf180mcu_as_sc_mcu7t3v3__inv_2_94/VDD gf180mcu_as_sc_mcu7t3v3__inv_2_94/VSS
+ gf180mcu_as_sc_mcu7t3v3__inv_2_94/Y VSS gf180mcu_as_sc_mcu7t3v3__inv_2_94/VNW VSUBS
+ gf180mcu_as_sc_mcu7t3v3__inv_2
Xgf180mcu_as_sc_mcu7t3v3__inv_2_50 gf180mcu_as_sc_mcu7t3v3__inv_2_66/VSS gf180mcu_as_sc_mcu7t3v3__inv_2_66/VSS
+ gf180mcu_as_sc_mcu7t3v3__inv_2_66/Y gf180mcu_as_sc_mcu7t3v3__inv_2_66/Y gf180mcu_as_sc_mcu7t3v3__inv_2_66/VNW
+ VSUBS gf180mcu_as_sc_mcu7t3v3__inv_2
Xgf180mcu_as_sc_mcu7t3v3__inv_2_72 gf180mcu_as_sc_mcu7t3v3__inv_2_73/VDD gf180mcu_as_sc_mcu7t3v3__inv_2_9/VDD
+ gf180mcu_as_sc_mcu7t3v3__inv_2_72/Y gf180mcu_as_sc_mcu7t3v3__inv_2_73/Y gf180mcu_as_sc_mcu7t3v3__inv_2_73/VNW
+ VSUBS gf180mcu_as_sc_mcu7t3v3__inv_2
Xgf180mcu_as_sc_mcu7t3v3__inv_2_61 gf180mcu_as_sc_mcu7t3v3__inv_2_61/VDD gf180mcu_as_sc_mcu7t3v3__inv_2_69/VDD
+ gf180mcu_as_sc_mcu7t3v3__inv_2_61/Y VSS gf180mcu_as_sc_mcu7t3v3__inv_2_61/VNW VSUBS
+ gf180mcu_as_sc_mcu7t3v3__inv_2
Xgf180mcu_as_sc_mcu7t3v3__inv_2_1020 gf180mcu_as_sc_mcu7t3v3__inv_2_1058/VSS VSS gf180mcu_as_sc_mcu7t3v3__inv_2_1020/Y
+ VSS gf180mcu_as_sc_mcu7t3v3__inv_2_1020/VNW VSUBS gf180mcu_as_sc_mcu7t3v3__inv_2
Xgf180mcu_as_sc_mcu7t3v3__inv_2_1075 gf180mcu_as_sc_mcu7t3v3__inv_2_1075/VDD gf180mcu_as_sc_mcu7t3v3__inv_2_1079/VDD
+ gf180mcu_as_sc_mcu7t3v3__inv_2_1075/Y VSS gf180mcu_as_sc_mcu7t3v3__inv_2_1075/VNW
+ VSUBS gf180mcu_as_sc_mcu7t3v3__inv_2
Xgf180mcu_as_sc_mcu7t3v3__inv_2_1086 gf180mcu_as_sc_mcu7t3v3__inv_2_1087/VDD gf180mcu_as_sc_mcu7t3v3__inv_2_1091/VDD
+ gf180mcu_as_sc_mcu7t3v3__inv_2_1086/Y gf180mcu_as_sc_mcu7t3v3__inv_2_1087/Y gf180mcu_as_sc_mcu7t3v3__inv_2_1087/VNW
+ VSUBS gf180mcu_as_sc_mcu7t3v3__inv_2
Xgf180mcu_as_sc_mcu7t3v3__inv_2_1097 VSS gf180mcu_as_sc_mcu7t3v3__inv_2_1103/VDD VSS
+ gf180mcu_as_sc_mcu7t3v3__inv_2_1101/A gf180mcu_as_sc_mcu7t3v3__inv_2_1099/VNW VSUBS
+ gf180mcu_as_sc_mcu7t3v3__inv_2
Xgf180mcu_as_sc_mcu7t3v3__inv_2_1064 gf180mcu_as_sc_mcu7t3v3__inv_2_1111/VSS VSS gf180mcu_as_sc_mcu7t3v3__inv_2_1064/Y
+ VSS gf180mcu_as_sc_mcu7t3v3__inv_2_1064/VNW VSUBS gf180mcu_as_sc_mcu7t3v3__inv_2
Xgf180mcu_as_sc_mcu7t3v3__nand4_2_9 gf180mcu_as_sc_mcu7t3v3__nand4_2_9/VDD VSS VSS
+ VSS VSS VSS gf180mcu_as_sc_mcu7t3v3__nand4_2_9/Y gf180mcu_as_sc_mcu7t3v3__nand4_2_9/VNW
+ VSUBS gf180mcu_as_sc_mcu7t3v3__nand4_2
Xgf180mcu_as_sc_mcu7t3v3__inv_2_548 VSS VSS VSS VSS gf180mcu_as_sc_mcu7t3v3__inv_2_548/VNW
+ VSUBS gf180mcu_as_sc_mcu7t3v3__inv_2
Xgf180mcu_as_sc_mcu7t3v3__inv_2_526 gf180mcu_as_sc_mcu7t3v3__nor2_2_4/VDD gf180mcu_as_sc_mcu7t3v3__nor2_2_4/VSS
+ VSS VSS gf180mcu_as_sc_mcu7t3v3__nor2_2_4/VNW VSUBS gf180mcu_as_sc_mcu7t3v3__inv_2
Xgf180mcu_as_sc_mcu7t3v3__inv_2_559 VSS VSS VSS VSS gf180mcu_as_sc_mcu7t3v3__inv_2_559/VNW
+ VSUBS gf180mcu_as_sc_mcu7t3v3__inv_2
Xgf180mcu_as_sc_mcu7t3v3__inv_2_504 VSS VSS VSS VSS gf180mcu_as_sc_mcu7t3v3__inv_2_537/VNW
+ VSUBS gf180mcu_as_sc_mcu7t3v3__inv_2
Xgf180mcu_as_sc_mcu7t3v3__inv_2_537 VSS VSS VSS VSS gf180mcu_as_sc_mcu7t3v3__inv_2_537/VNW
+ VSUBS gf180mcu_as_sc_mcu7t3v3__inv_2
Xgf180mcu_as_sc_mcu7t3v3__inv_2_515 VSS VSS VSS VSS gf180mcu_as_sc_mcu7t3v3__inv_2_562/VNW
+ VSUBS gf180mcu_as_sc_mcu7t3v3__inv_2
Xgf180mcu_as_sc_mcu7t3v3__nand4_2_370 VSS VSS VSS VSS VSS VSS gf180mcu_as_sc_mcu7t3v3__nand4_2_370/Y
+ gf180mcu_as_sc_mcu7t3v3__inv_2_1280/VNW VSUBS gf180mcu_as_sc_mcu7t3v3__nand4_2
Xgf180mcu_as_sc_mcu7t3v3__nand4_2_381 gf180mcu_as_sc_mcu7t3v3__inv_2_1457/VSS gf180mcu_as_sc_mcu7t3v3__inv_2_1416/VDD
+ VSS VSS VSS VSS gf180mcu_as_sc_mcu7t3v3__nand4_2_381/Y gf180mcu_as_sc_mcu7t3v3__inv_2_1413/VNW
+ VSUBS gf180mcu_as_sc_mcu7t3v3__nand4_2
Xgf180mcu_as_sc_mcu7t3v3__nand4_2_392 gf180mcu_as_sc_mcu7t3v3__inv_2_1446/VDD VSS
+ VSS VSS VSS VSS VSS gf180mcu_as_sc_mcu7t3v3__inv_2_1446/VNW VSUBS gf180mcu_as_sc_mcu7t3v3__nand4_2
Xgf180mcu_as_sc_mcu7t3v3__inv_2_301 gf180mcu_as_sc_mcu7t3v3__inv_2_301/VDD VSS gf180mcu_as_sc_mcu7t3v3__inv_2_301/Y
+ VSS gf180mcu_as_sc_mcu7t3v3__inv_2_301/VNW VSUBS gf180mcu_as_sc_mcu7t3v3__inv_2
Xgf180mcu_as_sc_mcu7t3v3__inv_2_334 VSS gf180mcu_as_sc_mcu7t3v3__inv_2_338/VDD gf180mcu_as_sc_mcu7t3v3__inv_2_341/Y
+ gf180mcu_as_sc_mcu7t3v3__inv_2_341/Y gf180mcu_as_sc_mcu7t3v3__inv_2_335/VNW VSUBS
+ gf180mcu_as_sc_mcu7t3v3__inv_2
Xgf180mcu_as_sc_mcu7t3v3__inv_2_323 gf180mcu_as_sc_mcu7t3v3__inv_2_323/VDD VSS gf180mcu_as_sc_mcu7t3v3__inv_2_341/Y
+ VSS gf180mcu_as_sc_mcu7t3v3__inv_2_323/VNW VSUBS gf180mcu_as_sc_mcu7t3v3__inv_2
Xgf180mcu_as_sc_mcu7t3v3__inv_2_312 VSS VSS VSS gf180mcu_as_sc_mcu7t3v3__inv_2_341/Y
+ gf180mcu_as_sc_mcu7t3v3__inv_2_314/VNW VSUBS gf180mcu_as_sc_mcu7t3v3__inv_2
Xgf180mcu_as_sc_mcu7t3v3__inv_2_378 gf180mcu_as_sc_mcu7t3v3__nor2_2_6/VDD gf180mcu_as_sc_mcu7t3v3__nand3_2_4/VSS
+ VSS VSS gf180mcu_as_sc_mcu7t3v3__nor2_2_6/VNW VSUBS gf180mcu_as_sc_mcu7t3v3__inv_2
Xgf180mcu_as_sc_mcu7t3v3__inv_2_389 gf180mcu_as_sc_mcu7t3v3__nand3_2_9/VDD gf180mcu_as_sc_mcu7t3v3__nor2_2_7/VSS
+ VSS VSS gf180mcu_as_sc_mcu7t3v3__nand3_2_9/VNW VSUBS gf180mcu_as_sc_mcu7t3v3__inv_2
Xgf180mcu_as_sc_mcu7t3v3__inv_2_367 VSS gf180mcu_as_sc_mcu7t3v3__inv_2_53/VDD gf180mcu_as_sc_mcu7t3v3__inv_2_61/Y
+ gf180mcu_as_sc_mcu7t3v3__inv_2_61/Y gf180mcu_as_sc_mcu7t3v3__inv_2_368/VNW VSUBS
+ gf180mcu_as_sc_mcu7t3v3__inv_2
Xgf180mcu_as_sc_mcu7t3v3__inv_2_356 VSS VSS gf180mcu_as_sc_mcu7t3v3__inv_2_359/Y VSS
+ gf180mcu_as_sc_mcu7t3v3__inv_2_356/VNW VSUBS gf180mcu_as_sc_mcu7t3v3__inv_2
Xgf180mcu_as_sc_mcu7t3v3__inv_2_345 VSS gf180mcu_as_sc_mcu7t3v3__inv_2_350/VDD VSS
+ gf180mcu_as_sc_mcu7t3v3__inv_2_350/Y gf180mcu_as_sc_mcu7t3v3__inv_2_347/VNW VSUBS
+ gf180mcu_as_sc_mcu7t3v3__inv_2
Xu_t027_006 u_t027_006/c0_w0_bl u_t027_006/c0_w0_br u_t027_006/c0_w1_bl u_t027_006/c0_w1_br
+ u_t027_006/c0_r0_rbl u_t027_006/c0_r1_rbl u_t027_006/c1_w0_bl u_t027_006/c1_w0_br
+ u_t027_006/c1_w1_bl u_t027_006/c1_w1_br u_t027_006/c1_r0_rbl u_t027_006/c1_r1_rbl
+ u_t027_006/c2_w0_bl u_t027_006/c2_w0_br u_t027_006/c2_w1_bl u_t027_006/c2_w1_br
+ u_t027_006/c2_r0_rbl u_t027_006/c2_r1_rbl u_t027_006/c3_w0_bl u_t027_006/c3_w0_br
+ u_t027_006/c3_w1_bl u_t027_006/c3_w1_br u_t027_006/c3_r0_rbl u_t027_006/c3_r1_rbl
+ u_t027_006/r0_w0_wl u_t027_006/r0_w1_wl u_t027_006/r0_r0_rwl u_t027_006/r0_r1_rwl
+ u_t027_006/r1_w0_wl u_t027_006/r1_w1_wl u_t027_006/r1_r0_rwl u_t027_006/r1_r1_rwl
+ u_t027_006/r2_w0_wl u_t027_006/r2_w1_wl u_t027_006/r2_r0_rwl u_t027_006/r2_r1_rwl
+ u_t027_006/r3_w0_wl u_t027_006/r3_w1_wl u_t027_006/r3_r0_rwl u_t027_006/r3_r1_rwl
+ u_t027_006/VDD u_t027_009/VSS u_t027_006/m2_717_1265# u_t027_006/m2_603_2031# u_t027_006/m2_1290_336#
+ u_t027_006/m2_2000_2037# u_t027_006/m2_791_2909# u_t027_006/m2_7_2126# u_t027_006/m2_2154_2081#
+ u_t027_006/m2_1795_2037# u_t027_006/m2_871_303# u_t027_006/m2_431_438# u_t027_006/m2_1290_2898#
+ u_t027_006/m2_1714_1210# u_t027_006/m2_431_1982# u_t027_006/m2_512_1265# u_t027_006/m2_2573_2126#
+ u_t027_006/m2_603_1259# u_t027_006/m2_2074_2909# u_t027_006/m2_7_336# u_t027_006/m2_717_2037#
+ u_t027_006/m2_1886_2031# u_t027_006/m2_2573_336# u_t027_006/m2_7_2898# u_t027_006/m2_2000_1265#
+ u_t027_006/m2_512_2037# u_t027_006/m2_1795_1265# u_t027_006/m2_1714_1982# u_t027_006/m2_1886_1259#
+ u_t027_006/m2_1290_2126# u_t027_006/m2_1714_438# u_t027_006/m2_431_1210# u_t027_006/m2_2573_2898#
+ u_t027_006/m2_2154_303# u_t027_006/m2_871_2081# VSUBS detronyx_12t_2w2r_rc4_4x4_routed_5layer_direct
Xgf180mcu_as_sc_mcu7t3v3__inv_2_890 VSS VSS VSS VSS gf180mcu_as_sc_mcu7t3v3__inv_2_949/VNW
+ VSUBS gf180mcu_as_sc_mcu7t3v3__inv_2
Xu_t018_006 u_t018_006/c0_w0_bl u_t018_006/c0_w0_br u_t018_006/c0_w1_bl u_t018_006/c0_w1_br
+ u_t018_006/c0_r0_rbl u_t018_006/c0_r1_rbl u_t018_006/c1_w0_bl u_t018_006/c1_w0_br
+ u_t018_006/c1_w1_bl u_t018_006/c1_w1_br u_t018_006/c1_r0_rbl u_t018_006/c1_r1_rbl
+ u_t018_006/c2_w0_bl u_t018_006/c2_w0_br u_t018_006/c2_w1_bl u_t018_006/c2_w1_br
+ u_t018_006/c2_r0_rbl u_t018_006/c2_r1_rbl u_t018_006/c3_w0_bl u_t018_006/c3_w0_br
+ u_t018_006/c3_w1_bl u_t018_006/c3_w1_br u_t018_006/c3_r0_rbl u_t018_006/c3_r1_rbl
+ u_t018_006/r0_w0_wl u_t018_006/r0_w1_wl u_t018_006/r0_r0_rwl u_t018_006/r0_r1_rwl
+ u_t018_006/r1_w0_wl u_t018_006/r1_w1_wl u_t018_006/r1_r0_rwl u_t018_006/r1_r1_rwl
+ u_t018_006/r2_w0_wl u_t018_006/r2_w1_wl u_t018_006/r2_r0_rwl u_t018_006/r2_r1_rwl
+ u_t018_006/r3_w0_wl u_t018_006/r3_w1_wl u_t018_006/r3_r0_rwl u_t018_006/r3_r1_rwl
+ u_t018_006/VDD u_t018_009/VSS u_t018_006/m2_717_1265# u_t018_006/m2_603_2031# u_t018_006/m2_1290_336#
+ u_t018_006/m2_2000_2037# u_t018_006/m2_791_2909# u_t018_006/m2_7_2126# u_t018_006/m2_2154_2081#
+ u_t018_006/m2_1795_2037# u_t018_006/m2_871_303# u_t018_006/m2_431_438# u_t018_006/m2_1290_2898#
+ u_t018_006/m2_1714_1210# u_t018_006/m2_431_1982# u_t018_006/m2_512_1265# u_t018_006/m2_2573_2126#
+ u_t018_006/m2_603_1259# u_t018_006/m2_2074_2909# u_t018_006/m2_7_336# u_t018_006/m2_717_2037#
+ u_t018_006/m2_1886_2031# u_t018_006/m2_2573_336# u_t018_006/m2_7_2898# u_t018_006/m2_2000_1265#
+ u_t018_006/m2_512_2037# u_t018_006/m2_1795_1265# u_t018_006/m2_1714_1982# u_t018_006/m2_1886_1259#
+ u_t018_006/m2_1290_2126# u_t018_006/m2_1714_438# u_t018_006/m2_431_1210# u_t018_006/m2_2573_2898#
+ u_t018_006/m2_2154_303# u_t018_006/m2_871_2081# VSUBS detronyx_12t_2w2r_rc4_4x4_routed_5layer_direct
Xu_t009_006 u_t009_006/c0_w0_bl u_t009_006/c0_w0_br u_t009_006/c0_w1_bl u_t009_006/c0_w1_br
+ u_t009_006/c0_r0_rbl u_t009_006/c0_r1_rbl u_t009_006/c1_w0_bl u_t009_006/c1_w0_br
+ u_t009_006/c1_w1_bl u_t009_006/c1_w1_br u_t009_006/c1_r0_rbl u_t009_006/c1_r1_rbl
+ u_t009_006/c2_w0_bl u_t009_006/c2_w0_br u_t009_006/c2_w1_bl u_t009_006/c2_w1_br
+ u_t009_006/c2_r0_rbl u_t009_006/c2_r1_rbl u_t009_006/c3_w0_bl u_t009_006/c3_w0_br
+ u_t009_006/c3_w1_bl u_t009_006/c3_w1_br u_t009_006/c3_r0_rbl u_t009_006/c3_r1_rbl
+ u_t009_006/r0_w0_wl u_t009_006/r0_w1_wl u_t009_006/r0_r0_rwl u_t009_006/r0_r1_rwl
+ u_t009_006/r1_w0_wl u_t009_006/r1_w1_wl u_t009_006/r1_r0_rwl u_t009_006/r1_r1_rwl
+ u_t009_006/r2_w0_wl u_t009_006/r2_w1_wl u_t009_006/r2_r0_rwl u_t009_006/r2_r1_rwl
+ u_t009_006/r3_w0_wl u_t009_006/r3_w1_wl u_t009_006/r3_r0_rwl u_t009_006/r3_r1_rwl
+ u_t009_006/VDD VSS u_t009_006/m2_717_1265# u_t009_006/m2_603_2031# u_t009_006/m2_1290_336#
+ u_t009_006/m2_2000_2037# u_t009_006/m2_791_2909# u_t009_006/m2_7_2126# u_t009_006/m2_2154_2081#
+ u_t009_006/m2_1795_2037# u_t009_006/m2_871_303# u_t009_006/m2_431_438# u_t009_006/m2_1290_2898#
+ u_t009_006/m2_1714_1210# u_t009_006/m2_431_1982# u_t009_006/m2_512_1265# u_t009_006/m2_2573_2126#
+ u_t009_006/m2_603_1259# u_t009_006/m2_2074_2909# u_t009_006/m2_7_336# u_t009_006/m2_717_2037#
+ u_t009_006/m2_1886_2031# u_t009_006/m2_2573_336# u_t009_006/m2_7_2898# u_t009_006/m2_2000_1265#
+ u_t009_006/m2_512_2037# u_t009_006/m2_1795_1265# u_t009_006/m2_1714_1982# u_t009_006/m2_1886_1259#
+ u_t009_006/m2_1290_2126# u_t009_006/m2_1714_438# u_t009_006/m2_431_1210# u_t009_006/m2_2573_2898#
+ u_t009_006/m2_2154_303# u_t009_006/m2_871_2081# VSUBS detronyx_12t_2w2r_rc4_4x4_routed_5layer_direct
Xu_t024_009 u_t024_009/c0_w0_bl u_t024_009/c0_w0_br u_t024_009/c0_w1_bl u_t024_009/c0_w1_br
+ u_t024_009/c0_r0_rbl u_t024_009/c0_r1_rbl u_t024_009/c1_w0_bl u_t024_009/c1_w0_br
+ u_t024_009/c1_w1_bl u_t024_009/c1_w1_br u_t024_009/c1_r0_rbl u_t024_009/c1_r1_rbl
+ u_t024_009/c2_w0_bl u_t024_009/c2_w0_br u_t024_009/c2_w1_bl u_t024_009/c2_w1_br
+ u_t024_009/c2_r0_rbl u_t024_009/c2_r1_rbl u_t024_009/c3_w0_bl u_t024_009/c3_w0_br
+ u_t024_009/c3_w1_bl u_t024_009/c3_w1_br u_t024_009/c3_r0_rbl u_t024_009/c3_r1_rbl
+ u_t024_009/r0_w0_wl u_t024_009/r0_w1_wl u_t024_009/r0_r0_rwl u_t024_009/r0_r1_rwl
+ u_t024_009/r1_w0_wl u_t024_009/r1_w1_wl u_t024_009/r1_r0_rwl u_t024_009/r1_r1_rwl
+ u_t024_009/r2_w0_wl u_t024_009/r2_w1_wl u_t024_009/r2_r0_rwl u_t024_009/r2_r1_rwl
+ u_t024_009/r3_w0_wl u_t024_009/r3_w1_wl u_t024_009/r3_r0_rwl u_t024_009/r3_r1_rwl
+ VSS u_t024_009/VSS u_t024_009/m2_717_1265# u_t024_009/m2_603_2031# u_t024_009/m2_1290_336#
+ u_t024_009/m2_2000_2037# u_t024_009/m2_791_2909# u_t024_009/m2_7_2126# u_t024_009/m2_2154_2081#
+ u_t024_009/m2_1795_2037# u_t024_009/m2_871_303# u_t024_009/m2_431_438# u_t024_009/m2_1290_2898#
+ u_t024_009/m2_1714_1210# u_t024_009/m2_431_1982# u_t024_009/m2_512_1265# u_t024_009/m2_2573_2126#
+ u_t024_009/m2_603_1259# u_t024_009/m2_2074_2909# u_t024_009/m2_7_336# u_t024_009/m2_717_2037#
+ u_t024_009/m2_1886_2031# u_t024_009/m2_2573_336# u_t024_009/m2_7_2898# u_t024_009/m2_2000_1265#
+ u_t024_009/m2_512_2037# u_t024_009/m2_1795_1265# u_t024_009/m2_1714_1982# u_t024_009/m2_1886_1259#
+ u_t024_009/m2_1290_2126# u_t024_009/m2_1714_438# u_t024_009/m2_431_1210# u_t024_009/m2_2573_2898#
+ u_t024_009/m2_2154_303# u_t024_009/m2_871_2081# VSUBS detronyx_12t_2w2r_rc4_4x4_routed_5layer_direct
Xgf180mcu_as_sc_mcu7t3v3__inv_2_153 VSS VSS gf180mcu_as_sc_mcu7t3v3__inv_2_153/Y VSS
+ gf180mcu_as_sc_mcu7t3v3__inv_2_155/VNW VSUBS gf180mcu_as_sc_mcu7t3v3__inv_2
Xgf180mcu_as_sc_mcu7t3v3__inv_2_142 gf180mcu_as_sc_mcu7t3v3__inv_2_143/VDD gf180mcu_as_sc_mcu7t3v3__inv_2_146/VDD
+ gf180mcu_as_sc_mcu7t3v3__inv_2_142/Y VSS gf180mcu_as_sc_mcu7t3v3__inv_2_143/VNW
+ VSUBS gf180mcu_as_sc_mcu7t3v3__inv_2
Xgf180mcu_as_sc_mcu7t3v3__inv_2_131 gf180mcu_as_sc_mcu7t3v3__inv_2_131/VDD gf180mcu_as_sc_mcu7t3v3__inv_2_134/VDD
+ gf180mcu_as_sc_mcu7t3v3__inv_2_131/Y VSS gf180mcu_as_sc_mcu7t3v3__inv_2_131/VNW
+ VSUBS gf180mcu_as_sc_mcu7t3v3__inv_2
Xgf180mcu_as_sc_mcu7t3v3__inv_2_120 gf180mcu_as_sc_mcu7t3v3__inv_2_122/VDD gf180mcu_as_sc_mcu7t3v3__inv_2_125/VDD
+ gf180mcu_as_sc_mcu7t3v3__inv_2_120/Y VSS gf180mcu_as_sc_mcu7t3v3__inv_2_122/VNW
+ VSUBS gf180mcu_as_sc_mcu7t3v3__inv_2
Xgf180mcu_as_sc_mcu7t3v3__inv_2_175 gf180mcu_as_sc_mcu7t3v3__inv_2_182/VDD gf180mcu_as_sc_mcu7t3v3__inv_2_371/VDD
+ gf180mcu_as_sc_mcu7t3v3__inv_2_175/Y VSS gf180mcu_as_sc_mcu7t3v3__inv_2_182/VNW
+ VSUBS gf180mcu_as_sc_mcu7t3v3__inv_2
Xgf180mcu_as_sc_mcu7t3v3__inv_2_186 VSS gf180mcu_as_sc_mcu7t3v3__inv_2_190/VDD VSS
+ VSS gf180mcu_as_sc_mcu7t3v3__inv_2_187/VNW VSUBS gf180mcu_as_sc_mcu7t3v3__inv_2
Xgf180mcu_as_sc_mcu7t3v3__inv_2_164 gf180mcu_as_sc_mcu7t3v3__inv_2_206/VSS gf180mcu_as_sc_mcu7t3v3__inv_2_177/VDD
+ VSS VSS gf180mcu_as_sc_mcu7t3v3__inv_2_165/VNW VSUBS gf180mcu_as_sc_mcu7t3v3__inv_2
Xgf180mcu_as_sc_mcu7t3v3__inv_2_1619 gf180mcu_as_sc_mcu7t3v3__inv_2_1689/VSS VSS VSS
+ gf180mcu_as_sc_mcu7t3v3__inv_2_1689/A gf180mcu_as_sc_mcu7t3v3__inv_2_1627/VNW VSUBS
+ gf180mcu_as_sc_mcu7t3v3__inv_2
Xgf180mcu_as_sc_mcu7t3v3__inv_2_1608 gf180mcu_as_sc_mcu7t3v3__inv_2_1691/VSS gf180mcu_as_sc_mcu7t3v3__inv_2_1694/VDD
+ VSS gf180mcu_as_sc_mcu7t3v3__inv_2_1694/Y gf180mcu_as_sc_mcu7t3v3__inv_2_1610/VNW
+ VSUBS gf180mcu_as_sc_mcu7t3v3__inv_2
Xgf180mcu_as_sc_mcu7t3v3__inv_2_197 gf180mcu_as_sc_mcu7t3v3__inv_2_203/VSS VSS gf180mcu_as_sc_mcu7t3v3__inv_2_197/Y
+ VSS gf180mcu_as_sc_mcu7t3v3__inv_2_197/VNW VSUBS gf180mcu_as_sc_mcu7t3v3__inv_2
Xu_t015_009 u_t015_009/c0_w0_bl u_t015_009/c0_w0_br u_t015_009/c0_w1_bl u_t015_009/c0_w1_br
+ u_t015_009/c0_r0_rbl u_t015_009/c0_r1_rbl u_t015_009/c1_w0_bl u_t015_009/c1_w0_br
+ u_t015_009/c1_w1_bl u_t015_009/c1_w1_br u_t015_009/c1_r0_rbl u_t015_009/c1_r1_rbl
+ u_t015_009/c2_w0_bl u_t015_009/c2_w0_br u_t015_009/c2_w1_bl u_t015_009/c2_w1_br
+ u_t015_009/c2_r0_rbl u_t015_009/c2_r1_rbl u_t015_009/c3_w0_bl u_t015_009/c3_w0_br
+ u_t015_009/c3_w1_bl u_t015_009/c3_w1_br u_t015_009/c3_r0_rbl u_t015_009/c3_r1_rbl
+ u_t015_009/r0_w0_wl u_t015_009/r0_w1_wl u_t015_009/r0_r0_rwl u_t015_009/r0_r1_rwl
+ u_t015_009/r1_w0_wl u_t015_009/r1_w1_wl u_t015_009/r1_r0_rwl u_t015_009/r1_r1_rwl
+ u_t015_009/r2_w0_wl u_t015_009/r2_w1_wl u_t015_009/r2_r0_rwl u_t015_009/r2_r1_rwl
+ u_t015_009/r3_w0_wl u_t015_009/r3_w1_wl u_t015_009/r3_r0_rwl u_t015_009/r3_r1_rwl
+ VSS u_t015_009/VSS u_t015_009/m2_717_1265# u_t015_009/m2_603_2031# u_t015_009/m2_1290_336#
+ u_t015_009/m2_2000_2037# u_t015_009/m2_791_2909# u_t015_009/m2_7_2126# u_t015_009/m2_2154_2081#
+ u_t015_009/m2_1795_2037# u_t015_009/m2_871_303# u_t015_009/m2_431_438# u_t015_009/m2_1290_2898#
+ u_t015_009/m2_1714_1210# u_t015_009/m2_431_1982# u_t015_009/m2_512_1265# u_t015_009/m2_2573_2126#
+ u_t015_009/m2_603_1259# u_t015_009/m2_2074_2909# u_t015_009/m2_7_336# u_t015_009/m2_717_2037#
+ u_t015_009/m2_1886_2031# u_t015_009/m2_2573_336# u_t015_009/m2_7_2898# u_t015_009/m2_2000_1265#
+ u_t015_009/m2_512_2037# u_t015_009/m2_1795_1265# u_t015_009/m2_1714_1982# u_t015_009/m2_1886_1259#
+ u_t015_009/m2_1290_2126# u_t015_009/m2_1714_438# u_t015_009/m2_431_1210# u_t015_009/m2_2573_2898#
+ u_t015_009/m2_2154_303# u_t015_009/m2_871_2081# VSUBS detronyx_12t_2w2r_rc4_4x4_routed_5layer_direct
Xu_t006_009 u_t006_009/c0_w0_bl u_t006_009/c0_w0_br u_t006_009/c0_w1_bl u_t006_009/c0_w1_br
+ u_t006_009/c0_r0_rbl u_t006_009/c0_r1_rbl u_t006_009/c1_w0_bl u_t006_009/c1_w0_br
+ u_t006_009/c1_w1_bl u_t006_009/c1_w1_br u_t006_009/c1_r0_rbl u_t006_009/c1_r1_rbl
+ u_t006_009/c2_w0_bl u_t006_009/c2_w0_br u_t006_009/c2_w1_bl u_t006_009/c2_w1_br
+ u_t006_009/c2_r0_rbl u_t006_009/c2_r1_rbl u_t006_009/c3_w0_bl u_t006_009/c3_w0_br
+ u_t006_009/c3_w1_bl u_t006_009/c3_w1_br u_t006_009/c3_r0_rbl u_t006_009/c3_r1_rbl
+ u_t006_009/r0_w0_wl u_t006_009/r0_w1_wl u_t006_009/r0_r0_rwl u_t006_009/r0_r1_rwl
+ u_t006_009/r1_w0_wl u_t006_009/r1_w1_wl u_t006_009/r1_r0_rwl u_t006_009/r1_r1_rwl
+ u_t006_009/r2_w0_wl u_t006_009/r2_w1_wl u_t006_009/r2_r0_rwl u_t006_009/r2_r1_rwl
+ u_t006_009/r3_w0_wl u_t006_009/r3_w1_wl u_t006_009/r3_r0_rwl u_t006_009/r3_r1_rwl
+ VSS u_t006_009/VSS u_t006_009/m2_717_1265# u_t006_009/m2_603_2031# u_t006_009/m2_1290_336#
+ u_t006_009/m2_2000_2037# u_t006_009/m2_791_2909# u_t006_009/m2_7_2126# u_t006_009/m2_2154_2081#
+ u_t006_009/m2_1795_2037# u_t006_009/m2_871_303# u_t006_009/m2_431_438# u_t006_009/m2_1290_2898#
+ u_t006_009/m2_1714_1210# u_t006_009/m2_431_1982# u_t006_009/m2_512_1265# u_t006_009/m2_2573_2126#
+ u_t006_009/m2_603_1259# u_t006_009/m2_2074_2909# u_t006_009/m2_7_336# u_t006_009/m2_717_2037#
+ u_t006_009/m2_1886_2031# u_t006_009/m2_2573_336# u_t006_009/m2_7_2898# u_t006_009/m2_2000_1265#
+ u_t006_009/m2_512_2037# u_t006_009/m2_1795_1265# u_t006_009/m2_1714_1982# u_t006_009/m2_1886_1259#
+ u_t006_009/m2_1290_2126# u_t006_009/m2_1714_438# u_t006_009/m2_431_1210# u_t006_009/m2_2573_2898#
+ u_t006_009/m2_2154_303# u_t006_009/m2_871_2081# VSUBS detronyx_12t_2w2r_rc4_4x4_routed_5layer_direct
Xgf180mcu_as_sc_mcu7t3v3__nand2_2_43 gf180mcu_as_sc_mcu7t3v3__nand3_2_65/VDD gf180mcu_as_sc_mcu7t3v3__nand3_2_62/VSS
+ VSS VSS VSS gf180mcu_as_sc_mcu7t3v3__nand3_2_65/VNW VSUBS gf180mcu_as_sc_mcu7t3v3__nand2_2
Xgf180mcu_as_sc_mcu7t3v3__nand2_2_10 gf180mcu_as_sc_mcu7t3v3__nor2_2_4/VDD gf180mcu_as_sc_mcu7t3v3__nor2_2_4/VSS
+ VSS VSS VSS gf180mcu_as_sc_mcu7t3v3__nor2_2_4/VNW VSUBS gf180mcu_as_sc_mcu7t3v3__nand2_2
Xgf180mcu_as_sc_mcu7t3v3__nand2_2_21 gf180mcu_as_sc_mcu7t3v3__nor2_2_4/VDD gf180mcu_as_sc_mcu7t3v3__nand2_2_3/VSS
+ VSS VSS VSS gf180mcu_as_sc_mcu7t3v3__nor2_2_4/VNW VSUBS gf180mcu_as_sc_mcu7t3v3__nand2_2
Xgf180mcu_as_sc_mcu7t3v3__nand2_2_32 gf180mcu_as_sc_mcu7t3v3__nor2_2_4/VDD gf180mcu_as_sc_mcu7t3v3__nor2_2_4/VSS
+ VSS VSS VSS gf180mcu_as_sc_mcu7t3v3__nor2_2_4/VNW VSUBS gf180mcu_as_sc_mcu7t3v3__nand2_2
Xu_t020_012 u_t020_012/c0_w0_bl u_t020_012/c0_w0_br u_t020_012/c0_w1_bl u_t020_012/c0_w1_br
+ u_t020_012/c0_r0_rbl u_t020_012/c0_r1_rbl u_t020_012/c1_w0_bl u_t020_012/c1_w0_br
+ u_t020_012/c1_w1_bl u_t020_012/c1_w1_br u_t020_012/c1_r0_rbl u_t020_012/c1_r1_rbl
+ u_t020_012/c2_w0_bl u_t020_012/c2_w0_br u_t020_012/c2_w1_bl u_t020_012/c2_w1_br
+ u_t020_012/c2_r0_rbl u_t020_012/c2_r1_rbl u_t020_012/c3_w0_bl u_t020_012/c3_w0_br
+ u_t020_012/c3_w1_bl u_t020_012/c3_w1_br u_t020_012/c3_r0_rbl u_t020_012/c3_r1_rbl
+ u_t020_012/r0_w0_wl u_t020_012/r0_w1_wl u_t020_012/r0_r0_rwl u_t020_012/r0_r1_rwl
+ u_t020_012/r1_w0_wl u_t020_012/r1_w1_wl u_t020_012/r1_r0_rwl u_t020_012/r1_r1_rwl
+ u_t020_012/r2_w0_wl u_t020_012/r2_w1_wl u_t020_012/r2_r0_rwl u_t020_012/r2_r1_rwl
+ u_t020_012/r3_w0_wl u_t020_012/r3_w1_wl u_t020_012/r3_r0_rwl u_t020_012/r3_r1_rwl
+ u_t020_012/VDD u_t020_012/VSS u_t020_012/m2_717_1265# u_t020_012/m2_603_2031# u_t020_012/m2_1290_336#
+ u_t020_012/m2_2000_2037# u_t020_012/m2_791_2909# u_t020_012/m2_7_2126# u_t020_012/m2_2154_2081#
+ u_t020_012/m2_1795_2037# u_t020_012/m2_871_303# u_t020_012/m2_431_438# u_t020_012/m2_1290_2898#
+ u_t020_012/m2_1714_1210# u_t020_012/m2_431_1982# u_t020_012/m2_512_1265# u_t020_012/m2_2573_2126#
+ u_t020_012/m2_603_1259# u_t020_012/m2_2074_2909# u_t020_012/m2_7_336# u_t020_012/m2_717_2037#
+ u_t020_012/m2_1886_2031# u_t020_012/m2_2573_336# u_t020_012/m2_7_2898# u_t020_012/m2_2000_1265#
+ u_t020_012/m2_512_2037# u_t020_012/m2_1795_1265# u_t020_012/m2_1714_1982# u_t020_012/m2_1886_1259#
+ u_t020_012/m2_1290_2126# u_t020_012/m2_1714_438# u_t020_012/m2_431_1210# u_t020_012/m2_2573_2898#
+ u_t020_012/m2_2154_303# u_t020_012/m2_871_2081# VSUBS detronyx_12t_2w2r_rc4_4x4_routed_5layer_direct
Xu_t020_001 u_t020_001/c0_w0_bl u_t020_001/c0_w0_br u_t020_001/c0_w1_bl u_t020_001/c0_w1_br
+ u_t020_001/c0_r0_rbl u_t020_001/c0_r1_rbl u_t020_001/c1_w0_bl u_t020_001/c1_w0_br
+ u_t020_001/c1_w1_bl u_t020_001/c1_w1_br u_t020_001/c1_r0_rbl u_t020_001/c1_r1_rbl
+ u_t020_001/c2_w0_bl u_t020_001/c2_w0_br u_t020_001/c2_w1_bl u_t020_001/c2_w1_br
+ u_t020_001/c2_r0_rbl u_t020_001/c2_r1_rbl u_t020_001/c3_w0_bl u_t020_001/c3_w0_br
+ u_t020_001/c3_w1_bl u_t020_001/c3_w1_br u_t020_001/c3_r0_rbl u_t020_001/c3_r1_rbl
+ u_t020_001/r0_w0_wl u_t020_001/r0_w1_wl u_t020_001/r0_r0_rwl u_t020_001/r0_r1_rwl
+ u_t020_001/r1_w0_wl u_t020_001/r1_w1_wl u_t020_001/r1_r0_rwl u_t020_001/r1_r1_rwl
+ u_t020_001/r2_w0_wl u_t020_001/r2_w1_wl u_t020_001/r2_r0_rwl u_t020_001/r2_r1_rwl
+ u_t020_001/r3_w0_wl u_t020_001/r3_w1_wl u_t020_001/r3_r0_rwl u_t020_001/r3_r1_rwl
+ VSS VSS u_t020_001/m2_717_1265# u_t020_001/m2_603_2031# u_t020_001/m2_1290_336#
+ u_t020_001/m2_2000_2037# u_t020_001/m2_791_2909# u_t020_001/m2_7_2126# u_t020_001/m2_2154_2081#
+ u_t020_001/m2_1795_2037# u_t020_001/m2_871_303# u_t020_001/m2_431_438# u_t020_001/m2_1290_2898#
+ u_t020_001/m2_1714_1210# u_t020_001/m2_431_1982# u_t020_001/m2_512_1265# u_t020_001/m2_2573_2126#
+ u_t020_001/m2_603_1259# u_t020_001/m2_2074_2909# u_t020_001/m2_7_336# u_t020_001/m2_717_2037#
+ u_t020_001/m2_1886_2031# u_t020_001/m2_2573_336# u_t020_001/m2_7_2898# u_t020_001/m2_2000_1265#
+ u_t020_001/m2_512_2037# u_t020_001/m2_1795_1265# u_t020_001/m2_1714_1982# u_t020_001/m2_1886_1259#
+ u_t020_001/m2_1290_2126# u_t020_001/m2_1714_438# u_t020_001/m2_431_1210# u_t020_001/m2_2573_2898#
+ u_t020_001/m2_2154_303# u_t020_001/m2_871_2081# VSUBS detronyx_12t_2w2r_rc4_4x4_routed_5layer_direct
Xgf180mcu_as_sc_mcu7t3v3__inv_2_1405 gf180mcu_as_sc_mcu7t3v3__inv_2_1406/VDD gf180mcu_as_sc_mcu7t3v3__inv_2_1406/VSS
+ gf180mcu_as_sc_mcu7t3v3__inv_2_1405/Y gf180mcu_as_sc_mcu7t3v3__inv_2_1409/A gf180mcu_as_sc_mcu7t3v3__inv_2_1406/VNW
+ VSUBS gf180mcu_as_sc_mcu7t3v3__inv_2
Xgf180mcu_as_sc_mcu7t3v3__inv_2_1416 gf180mcu_as_sc_mcu7t3v3__inv_2_1416/VDD VSS gf180mcu_as_sc_mcu7t3v3__inv_2_1416/Y
+ VSS gf180mcu_as_sc_mcu7t3v3__inv_2_1416/VNW VSUBS gf180mcu_as_sc_mcu7t3v3__inv_2
Xgf180mcu_as_sc_mcu7t3v3__inv_2_1449 VSS gf180mcu_as_sc_mcu7t3v3__inv_2_1452/VDD VSS
+ VSS gf180mcu_as_sc_mcu7t3v3__inv_2_1449/VNW VSUBS gf180mcu_as_sc_mcu7t3v3__inv_2
Xgf180mcu_as_sc_mcu7t3v3__inv_2_1438 VSS gf180mcu_as_sc_mcu7t3v3__inv_2_1443/VDD VSS
+ VSS gf180mcu_as_sc_mcu7t3v3__inv_2_1440/VNW VSUBS gf180mcu_as_sc_mcu7t3v3__inv_2
Xgf180mcu_as_sc_mcu7t3v3__inv_2_1427 VSS VSS VSS VSS gf180mcu_as_sc_mcu7t3v3__inv_2_1428/VNW
+ VSUBS gf180mcu_as_sc_mcu7t3v3__inv_2
Xu_t011_012 u_t011_012/c0_w0_bl u_t011_012/c0_w0_br u_t011_012/c0_w1_bl u_t011_012/c0_w1_br
+ u_t011_012/c0_r0_rbl u_t011_012/c0_r1_rbl u_t011_012/c1_w0_bl u_t011_012/c1_w0_br
+ u_t011_012/c1_w1_bl u_t011_012/c1_w1_br u_t011_012/c1_r0_rbl u_t011_012/c1_r1_rbl
+ u_t011_012/c2_w0_bl u_t011_012/c2_w0_br u_t011_012/c2_w1_bl u_t011_012/c2_w1_br
+ u_t011_012/c2_r0_rbl u_t011_012/c2_r1_rbl u_t011_012/c3_w0_bl u_t011_012/c3_w0_br
+ u_t011_012/c3_w1_bl u_t011_012/c3_w1_br u_t011_012/c3_r0_rbl u_t011_012/c3_r1_rbl
+ u_t011_012/r0_w0_wl u_t011_012/r0_w1_wl u_t011_012/r0_r0_rwl u_t011_012/r0_r1_rwl
+ u_t011_012/r1_w0_wl u_t011_012/r1_w1_wl u_t011_012/r1_r0_rwl u_t011_012/r1_r1_rwl
+ u_t011_012/r2_w0_wl u_t011_012/r2_w1_wl u_t011_012/r2_r0_rwl u_t011_012/r2_r1_rwl
+ u_t011_012/r3_w0_wl u_t011_012/r3_w1_wl u_t011_012/r3_r0_rwl u_t011_012/r3_r1_rwl
+ u_t011_012/VDD u_t011_012/VSS u_t011_012/m2_717_1265# u_t011_012/m2_603_2031# u_t011_012/m2_1290_336#
+ u_t011_012/m2_2000_2037# u_t011_012/m2_791_2909# u_t011_012/m2_7_2126# u_t011_012/m2_2154_2081#
+ u_t011_012/m2_1795_2037# u_t011_012/m2_871_303# u_t011_012/m2_431_438# u_t011_012/m2_1290_2898#
+ u_t011_012/m2_1714_1210# u_t011_012/m2_431_1982# u_t011_012/m2_512_1265# u_t011_012/m2_2573_2126#
+ u_t011_012/m2_603_1259# u_t011_012/m2_2074_2909# u_t011_012/m2_7_336# u_t011_012/m2_717_2037#
+ u_t011_012/m2_1886_2031# u_t011_012/m2_2573_336# u_t011_012/m2_7_2898# u_t011_012/m2_2000_1265#
+ u_t011_012/m2_512_2037# u_t011_012/m2_1795_1265# u_t011_012/m2_1714_1982# u_t011_012/m2_1886_1259#
+ u_t011_012/m2_1290_2126# u_t011_012/m2_1714_438# u_t011_012/m2_431_1210# u_t011_012/m2_2573_2898#
+ u_t011_012/m2_2154_303# u_t011_012/m2_871_2081# VSUBS detronyx_12t_2w2r_rc4_4x4_routed_5layer_direct
Xu_t011_001 u_t011_001/c0_w0_bl u_t011_001/c0_w0_br u_t011_001/c0_w1_bl u_t011_001/c0_w1_br
+ u_t011_001/c0_r0_rbl u_t011_001/c0_r1_rbl u_t011_001/c1_w0_bl u_t011_001/c1_w0_br
+ u_t011_001/c1_w1_bl u_t011_001/c1_w1_br u_t011_001/c1_r0_rbl u_t011_001/c1_r1_rbl
+ u_t011_001/c2_w0_bl u_t011_001/c2_w0_br u_t011_001/c2_w1_bl u_t011_001/c2_w1_br
+ u_t011_001/c2_r0_rbl u_t011_001/c2_r1_rbl u_t011_001/c3_w0_bl u_t011_001/c3_w0_br
+ u_t011_001/c3_w1_bl u_t011_001/c3_w1_br u_t011_001/c3_r0_rbl u_t011_001/c3_r1_rbl
+ u_t011_001/r0_w0_wl u_t011_001/r0_w1_wl u_t011_001/r0_r0_rwl u_t011_001/r0_r1_rwl
+ u_t011_001/r1_w0_wl u_t011_001/r1_w1_wl u_t011_001/r1_r0_rwl u_t011_001/r1_r1_rwl
+ u_t011_001/r2_w0_wl u_t011_001/r2_w1_wl u_t011_001/r2_r0_rwl u_t011_001/r2_r1_rwl
+ u_t011_001/r3_w0_wl u_t011_001/r3_w1_wl u_t011_001/r3_r0_rwl u_t011_001/r3_r1_rwl
+ VSS VSS u_t011_001/m2_717_1265# u_t011_001/m2_603_2031# u_t011_001/m2_1290_336#
+ u_t011_001/m2_2000_2037# u_t011_001/m2_791_2909# u_t011_001/m2_7_2126# u_t011_001/m2_2154_2081#
+ u_t011_001/m2_1795_2037# u_t011_001/m2_871_303# u_t011_001/m2_431_438# u_t011_001/m2_1290_2898#
+ u_t011_001/m2_1714_1210# u_t011_001/m2_431_1982# u_t011_001/m2_512_1265# u_t011_001/m2_2573_2126#
+ u_t011_001/m2_603_1259# u_t011_001/m2_2074_2909# u_t011_001/m2_7_336# u_t011_001/m2_717_2037#
+ u_t011_001/m2_1886_2031# u_t011_001/m2_2573_336# u_t011_001/m2_7_2898# u_t011_001/m2_2000_1265#
+ u_t011_001/m2_512_2037# u_t011_001/m2_1795_1265# u_t011_001/m2_1714_1982# u_t011_001/m2_1886_1259#
+ u_t011_001/m2_1290_2126# u_t011_001/m2_1714_438# u_t011_001/m2_431_1210# u_t011_001/m2_2573_2898#
+ u_t011_001/m2_2154_303# u_t011_001/m2_871_2081# VSUBS detronyx_12t_2w2r_rc4_4x4_routed_5layer_direct
Xu_t002_012 u_t002_012/c0_w0_bl u_t002_012/c0_w0_br u_t002_012/c0_w1_bl u_t002_012/c0_w1_br
+ u_t002_012/c0_r0_rbl u_t002_012/c0_r1_rbl u_t002_012/c1_w0_bl u_t002_012/c1_w0_br
+ u_t002_012/c1_w1_bl u_t002_012/c1_w1_br u_t002_012/c1_r0_rbl u_t002_012/c1_r1_rbl
+ u_t002_012/c2_w0_bl u_t002_012/c2_w0_br u_t002_012/c2_w1_bl u_t002_012/c2_w1_br
+ u_t002_012/c2_r0_rbl u_t002_012/c2_r1_rbl u_t002_012/c3_w0_bl u_t002_012/c3_w0_br
+ u_t002_012/c3_w1_bl u_t002_012/c3_w1_br u_t002_012/c3_r0_rbl u_t002_012/c3_r1_rbl
+ u_t002_012/r0_w0_wl u_t002_012/r0_w1_wl u_t002_012/r0_r0_rwl u_t002_012/r0_r1_rwl
+ u_t002_012/r1_w0_wl u_t002_012/r1_w1_wl u_t002_012/r1_r0_rwl u_t002_012/r1_r1_rwl
+ u_t002_012/r2_w0_wl u_t002_012/r2_w1_wl u_t002_012/r2_r0_rwl u_t002_012/r2_r1_rwl
+ u_t002_012/r3_w0_wl u_t002_012/r3_w1_wl u_t002_012/r3_r0_rwl u_t002_012/r3_r1_rwl
+ u_t002_012/VDD u_t002_012/VSS u_t002_012/m2_717_1265# u_t002_012/m2_603_2031# u_t002_012/m2_1290_336#
+ u_t002_012/m2_2000_2037# u_t002_012/m2_791_2909# u_t002_012/m2_7_2126# u_t002_012/m2_2154_2081#
+ u_t002_012/m2_1795_2037# u_t002_012/m2_871_303# u_t002_012/m2_431_438# u_t002_012/m2_1290_2898#
+ u_t002_012/m2_1714_1210# u_t002_012/m2_431_1982# u_t002_012/m2_512_1265# u_t002_012/m2_2573_2126#
+ u_t002_012/m2_603_1259# u_t002_012/m2_2074_2909# u_t002_012/m2_7_336# u_t002_012/m2_717_2037#
+ u_t002_012/m2_1886_2031# u_t002_012/m2_2573_336# u_t002_012/m2_7_2898# u_t002_012/m2_2000_1265#
+ u_t002_012/m2_512_2037# u_t002_012/m2_1795_1265# u_t002_012/m2_1714_1982# u_t002_012/m2_1886_1259#
+ u_t002_012/m2_1290_2126# u_t002_012/m2_1714_438# u_t002_012/m2_431_1210# u_t002_012/m2_2573_2898#
+ u_t002_012/m2_2154_303# u_t002_012/m2_871_2081# VSUBS detronyx_12t_2w2r_rc4_4x4_routed_5layer_direct
Xu_t002_001 u_t002_001/c0_w0_bl u_t002_001/c0_w0_br u_t002_001/c0_w1_bl u_t002_001/c0_w1_br
+ u_t002_001/c0_r0_rbl u_t002_001/c0_r1_rbl u_t002_001/c1_w0_bl u_t002_001/c1_w0_br
+ u_t002_001/c1_w1_bl u_t002_001/c1_w1_br u_t002_001/c1_r0_rbl u_t002_001/c1_r1_rbl
+ u_t002_001/c2_w0_bl u_t002_001/c2_w0_br u_t002_001/c2_w1_bl u_t002_001/c2_w1_br
+ u_t002_001/c2_r0_rbl u_t002_001/c2_r1_rbl u_t002_001/c3_w0_bl u_t002_001/c3_w0_br
+ u_t002_001/c3_w1_bl u_t002_001/c3_w1_br u_t002_001/c3_r0_rbl u_t002_001/c3_r1_rbl
+ u_t002_001/r0_w0_wl u_t002_001/r0_w1_wl u_t002_001/r0_r0_rwl u_t002_001/r0_r1_rwl
+ u_t002_001/r1_w0_wl u_t002_001/r1_w1_wl u_t002_001/r1_r0_rwl u_t002_001/r1_r1_rwl
+ u_t002_001/r2_w0_wl u_t002_001/r2_w1_wl u_t002_001/r2_r0_rwl u_t002_001/r2_r1_rwl
+ u_t002_001/r3_w0_wl u_t002_001/r3_w1_wl u_t002_001/r3_r0_rwl u_t002_001/r3_r1_rwl
+ VSS VSS u_t002_001/m2_717_1265# u_t002_001/m2_603_2031# u_t002_001/m2_1290_336#
+ u_t002_001/m2_2000_2037# u_t002_001/m2_791_2909# u_t002_001/m2_7_2126# u_t002_001/m2_2154_2081#
+ u_t002_001/m2_1795_2037# u_t002_001/m2_871_303# u_t002_001/m2_431_438# u_t002_001/m2_1290_2898#
+ u_t002_001/m2_1714_1210# u_t002_001/m2_431_1982# u_t002_001/m2_512_1265# u_t002_001/m2_2573_2126#
+ u_t002_001/m2_603_1259# u_t002_001/m2_2074_2909# u_t002_001/m2_7_336# u_t002_001/m2_717_2037#
+ u_t002_001/m2_1886_2031# u_t002_001/m2_2573_336# u_t002_001/m2_7_2898# u_t002_001/m2_2000_1265#
+ u_t002_001/m2_512_2037# u_t002_001/m2_1795_1265# u_t002_001/m2_1714_1982# u_t002_001/m2_1886_1259#
+ u_t002_001/m2_1290_2126# u_t002_001/m2_1714_438# u_t002_001/m2_431_1210# u_t002_001/m2_2573_2898#
+ u_t002_001/m2_2154_303# u_t002_001/m2_871_2081# VSUBS detronyx_12t_2w2r_rc4_4x4_routed_5layer_direct
Xgf180mcu_as_sc_mcu7t3v3__inv_2_1235 gf180mcu_as_sc_mcu7t3v3__nor2_2_9/VDD gf180mcu_as_sc_mcu7t3v3__nor2_2_9/VSS
+ VSS VSS gf180mcu_as_sc_mcu7t3v3__nor2_2_9/VNW VSUBS gf180mcu_as_sc_mcu7t3v3__inv_2
Xgf180mcu_as_sc_mcu7t3v3__inv_2_1213 gf180mcu_as_sc_mcu7t3v3__nor2_2_9/VDD gf180mcu_as_sc_mcu7t3v3__nor2_2_9/VSS
+ gf180mcu_as_sc_mcu7t3v3__inv_2_1213/Y VSS gf180mcu_as_sc_mcu7t3v3__nor2_2_9/VNW
+ VSUBS gf180mcu_as_sc_mcu7t3v3__inv_2
Xgf180mcu_as_sc_mcu7t3v3__inv_2_1202 gf180mcu_as_sc_mcu7t3v3__nand3_2_65/VDD gf180mcu_as_sc_mcu7t3v3__nand3_2_62/VSS
+ gf180mcu_as_sc_mcu7t3v3__inv_2_1202/Y VSS gf180mcu_as_sc_mcu7t3v3__nand3_2_65/VNW
+ VSUBS gf180mcu_as_sc_mcu7t3v3__inv_2
Xgf180mcu_as_sc_mcu7t3v3__inv_2_1224 VSS VSS VSS VSS gf180mcu_as_sc_mcu7t3v3__inv_2_1276/VNW
+ VSUBS gf180mcu_as_sc_mcu7t3v3__inv_2
Xgf180mcu_as_sc_mcu7t3v3__inv_2_1246 gf180mcu_as_sc_mcu7t3v3__nor2_2_9/VDD gf180mcu_as_sc_mcu7t3v3__nor2_2_9/VSS
+ VSS VSS gf180mcu_as_sc_mcu7t3v3__nor2_2_9/VNW VSUBS gf180mcu_as_sc_mcu7t3v3__inv_2
Xgf180mcu_as_sc_mcu7t3v3__inv_2_1257 gf180mcu_as_sc_mcu7t3v3__nand3_2_65/VDD gf180mcu_as_sc_mcu7t3v3__nand3_2_62/VSS
+ gf180mcu_as_sc_mcu7t3v3__inv_2_1257/Y VSS gf180mcu_as_sc_mcu7t3v3__nand3_2_65/VNW
+ VSUBS gf180mcu_as_sc_mcu7t3v3__inv_2
Xgf180mcu_as_sc_mcu7t3v3__inv_2_1279 VSS VSS VSS VSS gf180mcu_as_sc_mcu7t3v3__inv_2_1279/VNW
+ VSUBS gf180mcu_as_sc_mcu7t3v3__inv_2
Xgf180mcu_as_sc_mcu7t3v3__inv_2_1268 VSS VSS VSS VSS gf180mcu_as_sc_mcu7t3v3__inv_2_1268/VNW
+ VSUBS gf180mcu_as_sc_mcu7t3v3__inv_2
Xgf180mcu_as_sc_mcu7t3v3__inv_2_719 VSS VSS gf180mcu_as_sc_mcu7t3v3__inv_2_719/Y gf180mcu_as_sc_mcu7t3v3__inv_2_720/Y
+ gf180mcu_as_sc_mcu7t3v3__inv_2_720/VNW VSUBS gf180mcu_as_sc_mcu7t3v3__inv_2
Xgf180mcu_as_sc_mcu7t3v3__inv_2_708 VSS gf180mcu_as_sc_mcu7t3v3__inv_2_712/VDD gf180mcu_as_sc_mcu7t3v3__inv_2_708/Y
+ VSS gf180mcu_as_sc_mcu7t3v3__inv_2_708/VNW VSUBS gf180mcu_as_sc_mcu7t3v3__inv_2
Xgf180mcu_as_sc_mcu7t3v3__inv_2_1065 gf180mcu_as_sc_mcu7t3v3__inv_2_1100/VSS VSS VSS
+ gf180mcu_as_sc_mcu7t3v3__inv_2_1149/A gf180mcu_as_sc_mcu7t3v3__inv_2_1067/VNW VSUBS
+ gf180mcu_as_sc_mcu7t3v3__inv_2
Xgf180mcu_as_sc_mcu7t3v3__inv_2_1076 VSS VSS gf180mcu_as_sc_mcu7t3v3__inv_2_1306/Y
+ gf180mcu_as_sc_mcu7t3v3__inv_2_1080/Y gf180mcu_as_sc_mcu7t3v3__inv_2_1080/VNW VSUBS
+ gf180mcu_as_sc_mcu7t3v3__inv_2
Xgf180mcu_as_sc_mcu7t3v3__inv_2_1010 gf180mcu_as_sc_mcu7t3v3__inv_2_1036/VSS VSS VSS
+ gf180mcu_as_sc_mcu7t3v3__inv_2_1306/Y gf180mcu_as_sc_mcu7t3v3__inv_2_1012/VNW VSUBS
+ gf180mcu_as_sc_mcu7t3v3__inv_2
Xgf180mcu_as_sc_mcu7t3v3__inv_2_1032 VSS gf180mcu_as_sc_mcu7t3v3__inv_2_1036/VDD gf180mcu_as_sc_mcu7t3v3__inv_2_1032/Y
+ VSS gf180mcu_as_sc_mcu7t3v3__inv_2_1032/VNW VSUBS gf180mcu_as_sc_mcu7t3v3__inv_2
Xgf180mcu_as_sc_mcu7t3v3__inv_2_1021 VSS VSS gf180mcu_as_sc_mcu7t3v3__inv_2_1021/Y
+ VSS gf180mcu_as_sc_mcu7t3v3__inv_2_1057/VNW VSUBS gf180mcu_as_sc_mcu7t3v3__inv_2
Xgf180mcu_as_sc_mcu7t3v3__inv_2_1043 VSS gf180mcu_as_sc_mcu7t3v3__inv_2_1048/VDD gf180mcu_as_sc_mcu7t3v3__inv_2_1043/Y
+ gf180mcu_as_sc_mcu7t3v3__inv_2_1044/Y gf180mcu_as_sc_mcu7t3v3__inv_2_1044/VNW VSUBS
+ gf180mcu_as_sc_mcu7t3v3__inv_2
Xgf180mcu_as_sc_mcu7t3v3__inv_2_1054 VSS gf180mcu_as_sc_mcu7t3v3__inv_2_1058/VDD VSS
+ gf180mcu_as_sc_mcu7t3v3__inv_2_962/A gf180mcu_as_sc_mcu7t3v3__inv_2_1056/VNW VSUBS
+ gf180mcu_as_sc_mcu7t3v3__inv_2
Xgf180mcu_as_sc_mcu7t3v3__inv_2_84 gf180mcu_as_sc_mcu7t3v3__inv_2_94/VSS gf180mcu_as_sc_mcu7t3v3__inv_2_91/VSS
+ gf180mcu_as_sc_mcu7t3v3__inv_2_84/Y VSS gf180mcu_as_sc_mcu7t3v3__inv_2_91/VNW VSUBS
+ gf180mcu_as_sc_mcu7t3v3__inv_2
Xgf180mcu_as_sc_mcu7t3v3__inv_2_95 gf180mcu_as_sc_mcu7t3v3__inv_2_97/VDD gf180mcu_as_sc_mcu7t3v3__inv_2_98/VDD
+ gf180mcu_as_sc_mcu7t3v3__inv_2_95/Y VSS gf180mcu_as_sc_mcu7t3v3__inv_2_97/VNW VSUBS
+ gf180mcu_as_sc_mcu7t3v3__inv_2
Xgf180mcu_as_sc_mcu7t3v3__inv_2_62 gf180mcu_as_sc_mcu7t3v3__inv_2_62/VDD VSS gf180mcu_as_sc_mcu7t3v3__inv_2_9/Y
+ VSS gf180mcu_as_sc_mcu7t3v3__inv_2_62/VNW VSUBS gf180mcu_as_sc_mcu7t3v3__inv_2
Xgf180mcu_as_sc_mcu7t3v3__inv_2_40 VSS gf180mcu_as_sc_mcu7t3v3__inv_2_46/VDD VSS gf180mcu_as_sc_mcu7t3v3__inv_2_9/Y
+ gf180mcu_as_sc_mcu7t3v3__inv_2_42/VNW VSUBS gf180mcu_as_sc_mcu7t3v3__inv_2
Xgf180mcu_as_sc_mcu7t3v3__inv_2_73 gf180mcu_as_sc_mcu7t3v3__inv_2_73/VDD gf180mcu_as_sc_mcu7t3v3__inv_2_9/VDD
+ gf180mcu_as_sc_mcu7t3v3__inv_2_73/Y VSS gf180mcu_as_sc_mcu7t3v3__inv_2_73/VNW VSUBS
+ gf180mcu_as_sc_mcu7t3v3__inv_2
Xgf180mcu_as_sc_mcu7t3v3__inv_2_51 gf180mcu_as_sc_mcu7t3v3__inv_2_53/VDD gf180mcu_as_sc_mcu7t3v3__inv_2_57/VDD
+ VSS gf180mcu_as_sc_mcu7t3v3__inv_2_61/Y gf180mcu_as_sc_mcu7t3v3__inv_2_53/VNW VSUBS
+ gf180mcu_as_sc_mcu7t3v3__inv_2
Xgf180mcu_as_sc_mcu7t3v3__inv_2_1087 gf180mcu_as_sc_mcu7t3v3__inv_2_1087/VDD gf180mcu_as_sc_mcu7t3v3__inv_2_1091/VDD
+ gf180mcu_as_sc_mcu7t3v3__inv_2_1087/Y VSS gf180mcu_as_sc_mcu7t3v3__inv_2_1087/VNW
+ VSUBS gf180mcu_as_sc_mcu7t3v3__inv_2
Xgf180mcu_as_sc_mcu7t3v3__inv_2_1098 VSS gf180mcu_as_sc_mcu7t3v3__inv_2_1103/VDD gf180mcu_as_sc_mcu7t3v3__inv_2_1098/Y
+ gf180mcu_as_sc_mcu7t3v3__inv_2_1099/Y gf180mcu_as_sc_mcu7t3v3__inv_2_1099/VNW VSUBS
+ gf180mcu_as_sc_mcu7t3v3__inv_2
Xgf180mcu_as_sc_mcu7t3v3__inv_2_527 gf180mcu_as_sc_mcu7t3v3__nor2_2_4/VDD gf180mcu_as_sc_mcu7t3v3__nand2_2_3/VSS
+ VSS VSS gf180mcu_as_sc_mcu7t3v3__nor2_2_4/VNW VSUBS gf180mcu_as_sc_mcu7t3v3__inv_2
Xgf180mcu_as_sc_mcu7t3v3__inv_2_516 VSS VSS VSS VSS gf180mcu_as_sc_mcu7t3v3__inv_2_559/VNW
+ VSUBS gf180mcu_as_sc_mcu7t3v3__inv_2
Xgf180mcu_as_sc_mcu7t3v3__inv_2_505 VSS VSS gf180mcu_as_sc_mcu7t3v3__inv_2_505/Y VSS
+ gf180mcu_as_sc_mcu7t3v3__inv_2_537/VNW VSUBS gf180mcu_as_sc_mcu7t3v3__inv_2
Xgf180mcu_as_sc_mcu7t3v3__inv_2_549 VSS VSS VSS VSS gf180mcu_as_sc_mcu7t3v3__inv_2_549/VNW
+ VSUBS gf180mcu_as_sc_mcu7t3v3__inv_2
Xgf180mcu_as_sc_mcu7t3v3__inv_2_538 VSS VSS VSS VSS gf180mcu_as_sc_mcu7t3v3__inv_2_538/VNW
+ VSUBS gf180mcu_as_sc_mcu7t3v3__inv_2
Xgf180mcu_as_sc_mcu7t3v3__nand4_2_371 VSS VSS VSS VSS VSS VSS VSS gf180mcu_as_sc_mcu7t3v3__inv_2_1272/VNW
+ VSUBS gf180mcu_as_sc_mcu7t3v3__nand4_2
Xgf180mcu_as_sc_mcu7t3v3__nand4_2_360 VSS VSS VSS VSS VSS VSS gf180mcu_as_sc_mcu7t3v3__nand4_2_360/Y
+ gf180mcu_as_sc_mcu7t3v3__inv_2_1295/VNW VSUBS gf180mcu_as_sc_mcu7t3v3__nand4_2
Xgf180mcu_as_sc_mcu7t3v3__nand4_2_382 gf180mcu_as_sc_mcu7t3v3__inv_2_1416/VDD VSS
+ VSS VSS VSS VSS gf180mcu_as_sc_mcu7t3v3__nand4_2_382/Y gf180mcu_as_sc_mcu7t3v3__inv_2_1416/VNW
+ VSUBS gf180mcu_as_sc_mcu7t3v3__nand4_2
Xgf180mcu_as_sc_mcu7t3v3__nand4_2_393 VSS gf180mcu_as_sc_mcu7t3v3__inv_2_1452/VDD
+ VSS VSS VSS VSS VSS gf180mcu_as_sc_mcu7t3v3__inv_2_1449/VNW VSUBS gf180mcu_as_sc_mcu7t3v3__nand4_2
Xgf180mcu_as_sc_mcu7t3v3__inv_2_368 VSS gf180mcu_as_sc_mcu7t3v3__inv_2_53/VDD gf180mcu_as_sc_mcu7t3v3__inv_2_61/Y
+ VSS gf180mcu_as_sc_mcu7t3v3__inv_2_368/VNW VSUBS gf180mcu_as_sc_mcu7t3v3__inv_2
Xgf180mcu_as_sc_mcu7t3v3__inv_2_302 VSS gf180mcu_as_sc_mcu7t3v3__inv_2_308/VDD gf180mcu_as_sc_mcu7t3v3__inv_2_302/Y
+ gf180mcu_as_sc_mcu7t3v3__inv_2_61/Y gf180mcu_as_sc_mcu7t3v3__inv_2_302/VNW VSUBS
+ gf180mcu_as_sc_mcu7t3v3__inv_2
Xgf180mcu_as_sc_mcu7t3v3__inv_2_357 VSS gf180mcu_as_sc_mcu7t3v3__inv_2_365/VDD VSS
+ gf180mcu_as_sc_mcu7t3v3__inv_2_359/Y gf180mcu_as_sc_mcu7t3v3__inv_2_359/VNW VSUBS
+ gf180mcu_as_sc_mcu7t3v3__inv_2
Xgf180mcu_as_sc_mcu7t3v3__inv_2_346 VSS gf180mcu_as_sc_mcu7t3v3__inv_2_350/VDD gf180mcu_as_sc_mcu7t3v3__inv_2_346/Y
+ gf180mcu_as_sc_mcu7t3v3__inv_2_350/Y gf180mcu_as_sc_mcu7t3v3__inv_2_347/VNW VSUBS
+ gf180mcu_as_sc_mcu7t3v3__inv_2
Xgf180mcu_as_sc_mcu7t3v3__inv_2_335 VSS gf180mcu_as_sc_mcu7t3v3__inv_2_338/VDD gf180mcu_as_sc_mcu7t3v3__inv_2_341/Y
+ VSS gf180mcu_as_sc_mcu7t3v3__inv_2_335/VNW VSUBS gf180mcu_as_sc_mcu7t3v3__inv_2
Xgf180mcu_as_sc_mcu7t3v3__inv_2_324 VSS gf180mcu_as_sc_mcu7t3v3__inv_2_329/VDD VSS
+ gf180mcu_as_sc_mcu7t3v3__inv_2_341/Y gf180mcu_as_sc_mcu7t3v3__inv_2_326/VNW VSUBS
+ gf180mcu_as_sc_mcu7t3v3__inv_2
Xgf180mcu_as_sc_mcu7t3v3__inv_2_313 VSS VSS gf180mcu_as_sc_mcu7t3v3__inv_2_341/Y gf180mcu_as_sc_mcu7t3v3__inv_2_341/Y
+ gf180mcu_as_sc_mcu7t3v3__inv_2_314/VNW VSUBS gf180mcu_as_sc_mcu7t3v3__inv_2
Xgf180mcu_as_sc_mcu7t3v3__inv_2_379 gf180mcu_as_sc_mcu7t3v3__nor2_2_6/VDD gf180mcu_as_sc_mcu7t3v3__nor2_2_6/VSS
+ VSS VSS gf180mcu_as_sc_mcu7t3v3__nor2_2_6/VNW VSUBS gf180mcu_as_sc_mcu7t3v3__inv_2
Xu_t027_007 u_t027_007/c0_w0_bl u_t027_007/c0_w0_br u_t027_007/c0_w1_bl u_t027_007/c0_w1_br
+ u_t027_007/c0_r0_rbl u_t027_007/c0_r1_rbl u_t027_007/c1_w0_bl u_t027_007/c1_w0_br
+ u_t027_007/c1_w1_bl u_t027_007/c1_w1_br u_t027_007/c1_r0_rbl u_t027_007/c1_r1_rbl
+ u_t027_007/c2_w0_bl u_t027_007/c2_w0_br u_t027_007/c2_w1_bl u_t027_007/c2_w1_br
+ u_t027_007/c2_r0_rbl u_t027_007/c2_r1_rbl u_t027_007/c3_w0_bl u_t027_007/c3_w0_br
+ u_t027_007/c3_w1_bl u_t027_007/c3_w1_br u_t027_007/c3_r0_rbl u_t027_007/c3_r1_rbl
+ u_t027_007/r0_w0_wl u_t027_007/r0_w1_wl u_t027_007/r0_r0_rwl u_t027_007/r0_r1_rwl
+ u_t027_007/r1_w0_wl u_t027_007/r1_w1_wl u_t027_007/r1_r0_rwl u_t027_007/r1_r1_rwl
+ u_t027_007/r2_w0_wl u_t027_007/r2_w1_wl u_t027_007/r2_r0_rwl u_t027_007/r2_r1_rwl
+ u_t027_007/r3_w0_wl u_t027_007/r3_w1_wl u_t027_007/r3_r0_rwl u_t027_007/r3_r1_rwl
+ VSS u_t027_009/VSS u_t027_007/m2_717_1265# u_t027_007/m2_603_2031# u_t027_007/m2_1290_336#
+ u_t027_007/m2_2000_2037# u_t027_007/m2_791_2909# u_t027_007/m2_7_2126# u_t027_007/m2_2154_2081#
+ u_t027_007/m2_1795_2037# u_t027_007/m2_871_303# u_t027_007/m2_431_438# u_t027_007/m2_1290_2898#
+ u_t027_007/m2_1714_1210# u_t027_007/m2_431_1982# u_t027_007/m2_512_1265# u_t027_007/m2_2573_2126#
+ u_t027_007/m2_603_1259# u_t027_007/m2_2074_2909# u_t027_007/m2_7_336# u_t027_007/m2_717_2037#
+ u_t027_007/m2_1886_2031# u_t027_007/m2_2573_336# u_t027_007/m2_7_2898# u_t027_007/m2_2000_1265#
+ u_t027_007/m2_512_2037# u_t027_007/m2_1795_1265# u_t027_007/m2_1714_1982# u_t027_007/m2_1886_1259#
+ u_t027_007/m2_1290_2126# u_t027_007/m2_1714_438# u_t027_007/m2_431_1210# u_t027_007/m2_2573_2898#
+ u_t027_007/m2_2154_303# u_t027_007/m2_871_2081# VSUBS detronyx_12t_2w2r_rc4_4x4_routed_5layer_direct
Xgf180mcu_as_sc_mcu7t3v3__inv_2_891 VSS VSS gf180mcu_as_sc_mcu7t3v3__inv_2_891/Y VSS
+ gf180mcu_as_sc_mcu7t3v3__inv_2_949/VNW VSUBS gf180mcu_as_sc_mcu7t3v3__inv_2
Xgf180mcu_as_sc_mcu7t3v3__inv_2_880 VSS VSS VSS VSS gf180mcu_as_sc_mcu7t3v3__inv_2_941/VNW
+ VSUBS gf180mcu_as_sc_mcu7t3v3__inv_2
Xu_t018_007 u_t018_007/c0_w0_bl u_t018_007/c0_w0_br u_t018_007/c0_w1_bl u_t018_007/c0_w1_br
+ u_t018_007/c0_r0_rbl u_t018_007/c0_r1_rbl u_t018_007/c1_w0_bl u_t018_007/c1_w0_br
+ u_t018_007/c1_w1_bl u_t018_007/c1_w1_br u_t018_007/c1_r0_rbl u_t018_007/c1_r1_rbl
+ u_t018_007/c2_w0_bl u_t018_007/c2_w0_br u_t018_007/c2_w1_bl u_t018_007/c2_w1_br
+ u_t018_007/c2_r0_rbl u_t018_007/c2_r1_rbl u_t018_007/c3_w0_bl u_t018_007/c3_w0_br
+ u_t018_007/c3_w1_bl u_t018_007/c3_w1_br u_t018_007/c3_r0_rbl u_t018_007/c3_r1_rbl
+ u_t018_007/r0_w0_wl u_t018_007/r0_w1_wl u_t018_007/r0_r0_rwl u_t018_007/r0_r1_rwl
+ u_t018_007/r1_w0_wl u_t018_007/r1_w1_wl u_t018_007/r1_r0_rwl u_t018_007/r1_r1_rwl
+ u_t018_007/r2_w0_wl u_t018_007/r2_w1_wl u_t018_007/r2_r0_rwl u_t018_007/r2_r1_rwl
+ u_t018_007/r3_w0_wl u_t018_007/r3_w1_wl u_t018_007/r3_r0_rwl u_t018_007/r3_r1_rwl
+ VSS u_t018_009/VSS u_t018_007/m2_717_1265# u_t018_007/m2_603_2031# u_t018_007/m2_1290_336#
+ u_t018_007/m2_2000_2037# u_t018_007/m2_791_2909# u_t018_007/m2_7_2126# u_t018_007/m2_2154_2081#
+ u_t018_007/m2_1795_2037# u_t018_007/m2_871_303# u_t018_007/m2_431_438# u_t018_007/m2_1290_2898#
+ u_t018_007/m2_1714_1210# u_t018_007/m2_431_1982# u_t018_007/m2_512_1265# u_t018_007/m2_2573_2126#
+ u_t018_007/m2_603_1259# u_t018_007/m2_2074_2909# u_t018_007/m2_7_336# u_t018_007/m2_717_2037#
+ u_t018_007/m2_1886_2031# u_t018_007/m2_2573_336# u_t018_007/m2_7_2898# u_t018_007/m2_2000_1265#
+ u_t018_007/m2_512_2037# u_t018_007/m2_1795_1265# u_t018_007/m2_1714_1982# u_t018_007/m2_1886_1259#
+ u_t018_007/m2_1290_2126# u_t018_007/m2_1714_438# u_t018_007/m2_431_1210# u_t018_007/m2_2573_2898#
+ u_t018_007/m2_2154_303# u_t018_007/m2_871_2081# VSUBS detronyx_12t_2w2r_rc4_4x4_routed_5layer_direct
Xgf180mcu_as_sc_mcu7t3v3__nand4_2_190 gf180mcu_as_sc_mcu7t3v3__inv_2_730/VDD VSS VSS
+ VSS VSS VSS VSS gf180mcu_as_sc_mcu7t3v3__inv_2_730/VNW VSUBS gf180mcu_as_sc_mcu7t3v3__nand4_2
Xu_t009_007 u_t009_007/c0_w0_bl u_t009_007/c0_w0_br u_t009_007/c0_w1_bl u_t009_007/c0_w1_br
+ u_t009_007/c0_r0_rbl u_t009_007/c0_r1_rbl u_t009_007/c1_w0_bl u_t009_007/c1_w0_br
+ u_t009_007/c1_w1_bl u_t009_007/c1_w1_br u_t009_007/c1_r0_rbl u_t009_007/c1_r1_rbl
+ u_t009_007/c2_w0_bl u_t009_007/c2_w0_br u_t009_007/c2_w1_bl u_t009_007/c2_w1_br
+ u_t009_007/c2_r0_rbl u_t009_007/c2_r1_rbl u_t009_007/c3_w0_bl u_t009_007/c3_w0_br
+ u_t009_007/c3_w1_bl u_t009_007/c3_w1_br u_t009_007/c3_r0_rbl u_t009_007/c3_r1_rbl
+ u_t009_007/r0_w0_wl u_t009_007/r0_w1_wl u_t009_007/r0_r0_rwl u_t009_007/r0_r1_rwl
+ u_t009_007/r1_w0_wl u_t009_007/r1_w1_wl u_t009_007/r1_r0_rwl u_t009_007/r1_r1_rwl
+ u_t009_007/r2_w0_wl u_t009_007/r2_w1_wl u_t009_007/r2_r0_rwl u_t009_007/r2_r1_rwl
+ u_t009_007/r3_w0_wl u_t009_007/r3_w1_wl u_t009_007/r3_r0_rwl u_t009_007/r3_r1_rwl
+ VSS VSS u_t009_007/m2_717_1265# u_t009_007/m2_603_2031# u_t009_007/m2_1290_336#
+ u_t009_007/m2_2000_2037# u_t009_007/m2_791_2909# u_t009_007/m2_7_2126# u_t009_007/m2_2154_2081#
+ u_t009_007/m2_1795_2037# u_t009_007/m2_871_303# u_t009_007/m2_431_438# u_t009_007/m2_1290_2898#
+ u_t009_007/m2_1714_1210# u_t009_007/m2_431_1982# u_t009_007/m2_512_1265# u_t009_007/m2_2573_2126#
+ u_t009_007/m2_603_1259# u_t009_007/m2_2074_2909# u_t009_007/m2_7_336# u_t009_007/m2_717_2037#
+ u_t009_007/m2_1886_2031# u_t009_007/m2_2573_336# u_t009_007/m2_7_2898# u_t009_007/m2_2000_1265#
+ u_t009_007/m2_512_2037# u_t009_007/m2_1795_1265# u_t009_007/m2_1714_1982# u_t009_007/m2_1886_1259#
+ u_t009_007/m2_1290_2126# u_t009_007/m2_1714_438# u_t009_007/m2_431_1210# u_t009_007/m2_2573_2898#
+ u_t009_007/m2_2154_303# u_t009_007/m2_871_2081# VSUBS detronyx_12t_2w2r_rc4_4x4_routed_5layer_direct
Xgf180mcu_as_sc_mcu7t3v3__inv_2_154 VSS VSS VSS VSS gf180mcu_as_sc_mcu7t3v3__inv_2_155/VNW
+ VSUBS gf180mcu_as_sc_mcu7t3v3__inv_2
Xgf180mcu_as_sc_mcu7t3v3__inv_2_143 gf180mcu_as_sc_mcu7t3v3__inv_2_143/VDD gf180mcu_as_sc_mcu7t3v3__inv_2_146/VDD
+ gf180mcu_as_sc_mcu7t3v3__inv_2_143/Y VSS gf180mcu_as_sc_mcu7t3v3__inv_2_143/VNW
+ VSUBS gf180mcu_as_sc_mcu7t3v3__inv_2
Xgf180mcu_as_sc_mcu7t3v3__inv_2_132 gf180mcu_as_sc_mcu7t3v3__inv_2_134/VDD gf180mcu_as_sc_mcu7t3v3__inv_2_137/VDD
+ gf180mcu_as_sc_mcu7t3v3__inv_2_132/Y VSS gf180mcu_as_sc_mcu7t3v3__inv_2_134/VNW
+ VSUBS gf180mcu_as_sc_mcu7t3v3__inv_2
Xgf180mcu_as_sc_mcu7t3v3__inv_2_121 gf180mcu_as_sc_mcu7t3v3__inv_2_122/VDD gf180mcu_as_sc_mcu7t3v3__inv_2_125/VDD
+ gf180mcu_as_sc_mcu7t3v3__inv_2_121/Y VSS gf180mcu_as_sc_mcu7t3v3__inv_2_122/VNW
+ VSUBS gf180mcu_as_sc_mcu7t3v3__inv_2
Xgf180mcu_as_sc_mcu7t3v3__inv_2_110 gf180mcu_as_sc_mcu7t3v3__inv_2_371/VSS gf180mcu_as_sc_mcu7t3v3__inv_2_113/VDD
+ VSS VSS gf180mcu_as_sc_mcu7t3v3__inv_2_110/VNW VSUBS gf180mcu_as_sc_mcu7t3v3__inv_2
Xgf180mcu_as_sc_mcu7t3v3__inv_2_198 VSS VSS gf180mcu_as_sc_mcu7t3v3__inv_2_198/Y VSS
+ gf180mcu_as_sc_mcu7t3v3__inv_2_200/VNW VSUBS gf180mcu_as_sc_mcu7t3v3__inv_2
Xgf180mcu_as_sc_mcu7t3v3__inv_2_187 VSS gf180mcu_as_sc_mcu7t3v3__inv_2_190/VDD VSS
+ VSS gf180mcu_as_sc_mcu7t3v3__inv_2_187/VNW VSUBS gf180mcu_as_sc_mcu7t3v3__inv_2
Xgf180mcu_as_sc_mcu7t3v3__inv_2_165 gf180mcu_as_sc_mcu7t3v3__inv_2_206/VSS gf180mcu_as_sc_mcu7t3v3__inv_2_177/VDD
+ VSS VSS gf180mcu_as_sc_mcu7t3v3__inv_2_165/VNW VSUBS gf180mcu_as_sc_mcu7t3v3__inv_2
Xgf180mcu_as_sc_mcu7t3v3__inv_2_176 gf180mcu_as_sc_mcu7t3v3__inv_2_177/VDD gf180mcu_as_sc_mcu7t3v3__inv_2_177/VSS
+ gf180mcu_as_sc_mcu7t3v3__inv_2_176/Y VSS gf180mcu_as_sc_mcu7t3v3__inv_2_177/VNW
+ VSUBS gf180mcu_as_sc_mcu7t3v3__inv_2
Xgf180mcu_as_sc_mcu7t3v3__inv_2_1609 gf180mcu_as_sc_mcu7t3v3__inv_2_1691/VSS gf180mcu_as_sc_mcu7t3v3__inv_2_1694/VDD
+ gf180mcu_as_sc_mcu7t3v3__inv_2_1609/Y gf180mcu_as_sc_mcu7t3v3__inv_2_1694/Y gf180mcu_as_sc_mcu7t3v3__inv_2_1610/VNW
+ VSUBS gf180mcu_as_sc_mcu7t3v3__inv_2
Xu_t023_010 u_t023_010/c0_w0_bl u_t023_010/c0_w0_br u_t023_010/c0_w1_bl u_t023_010/c0_w1_br
+ u_t023_010/c0_r0_rbl u_t023_010/c0_r1_rbl u_t023_010/c1_w0_bl u_t023_010/c1_w0_br
+ u_t023_010/c1_w1_bl u_t023_010/c1_w1_br u_t023_010/c1_r0_rbl u_t023_010/c1_r1_rbl
+ u_t023_010/c2_w0_bl u_t023_010/c2_w0_br u_t023_010/c2_w1_bl u_t023_010/c2_w1_br
+ u_t023_010/c2_r0_rbl u_t023_010/c2_r1_rbl u_t023_010/c3_w0_bl u_t023_010/c3_w0_br
+ u_t023_010/c3_w1_bl u_t023_010/c3_w1_br u_t023_010/c3_r0_rbl u_t023_010/c3_r1_rbl
+ u_t023_010/r0_w0_wl u_t023_010/r0_w1_wl u_t023_010/r0_r0_rwl u_t023_010/r0_r1_rwl
+ u_t023_010/r1_w0_wl u_t023_010/r1_w1_wl u_t023_010/r1_r0_rwl u_t023_010/r1_r1_rwl
+ u_t023_010/r2_w0_wl u_t023_010/r2_w1_wl u_t023_010/r2_r0_rwl u_t023_010/r2_r1_rwl
+ u_t023_010/r3_w0_wl u_t023_010/r3_w1_wl u_t023_010/r3_r0_rwl u_t023_010/r3_r1_rwl
+ VSS u_t023_010/VSS u_t023_010/m2_717_1265# u_t023_010/m2_603_2031# u_t023_010/m2_1290_336#
+ u_t023_010/m2_2000_2037# u_t023_010/m2_791_2909# u_t023_010/m2_7_2126# u_t023_010/m2_2154_2081#
+ u_t023_010/m2_1795_2037# u_t023_010/m2_871_303# u_t023_010/m2_431_438# u_t023_010/m2_1290_2898#
+ u_t023_010/m2_1714_1210# u_t023_010/m2_431_1982# u_t023_010/m2_512_1265# u_t023_010/m2_2573_2126#
+ u_t023_010/m2_603_1259# u_t023_010/m2_2074_2909# u_t023_010/m2_7_336# u_t023_010/m2_717_2037#
+ u_t023_010/m2_1886_2031# u_t023_010/m2_2573_336# u_t023_010/m2_7_2898# u_t023_010/m2_2000_1265#
+ u_t023_010/m2_512_2037# u_t023_010/m2_1795_1265# u_t023_010/m2_1714_1982# u_t023_010/m2_1886_1259#
+ u_t023_010/m2_1290_2126# u_t023_010/m2_1714_438# u_t023_010/m2_431_1210# u_t023_010/m2_2573_2898#
+ u_t023_010/m2_2154_303# u_t023_010/m2_871_2081# VSUBS detronyx_12t_2w2r_rc4_4x4_routed_5layer_direct
Xu_t014_010 u_t014_010/c0_w0_bl u_t014_010/c0_w0_br u_t014_010/c0_w1_bl u_t014_010/c0_w1_br
+ u_t014_010/c0_r0_rbl u_t014_010/c0_r1_rbl u_t014_010/c1_w0_bl u_t014_010/c1_w0_br
+ u_t014_010/c1_w1_bl u_t014_010/c1_w1_br u_t014_010/c1_r0_rbl u_t014_010/c1_r1_rbl
+ u_t014_010/c2_w0_bl u_t014_010/c2_w0_br u_t014_010/c2_w1_bl u_t014_010/c2_w1_br
+ u_t014_010/c2_r0_rbl u_t014_010/c2_r1_rbl u_t014_010/c3_w0_bl u_t014_010/c3_w0_br
+ u_t014_010/c3_w1_bl u_t014_010/c3_w1_br u_t014_010/c3_r0_rbl u_t014_010/c3_r1_rbl
+ u_t014_010/r0_w0_wl u_t014_010/r0_w1_wl u_t014_010/r0_r0_rwl u_t014_010/r0_r1_rwl
+ u_t014_010/r1_w0_wl u_t014_010/r1_w1_wl u_t014_010/r1_r0_rwl u_t014_010/r1_r1_rwl
+ u_t014_010/r2_w0_wl u_t014_010/r2_w1_wl u_t014_010/r2_r0_rwl u_t014_010/r2_r1_rwl
+ u_t014_010/r3_w0_wl u_t014_010/r3_w1_wl u_t014_010/r3_r0_rwl u_t014_010/r3_r1_rwl
+ VSS u_t014_010/VSS u_t014_010/m2_717_1265# u_t014_010/m2_603_2031# u_t014_010/m2_1290_336#
+ u_t014_010/m2_2000_2037# u_t014_010/m2_791_2909# u_t014_010/m2_7_2126# u_t014_010/m2_2154_2081#
+ u_t014_010/m2_1795_2037# u_t014_010/m2_871_303# u_t014_010/m2_431_438# u_t014_010/m2_1290_2898#
+ u_t014_010/m2_1714_1210# u_t014_010/m2_431_1982# u_t014_010/m2_512_1265# u_t014_010/m2_2573_2126#
+ u_t014_010/m2_603_1259# u_t014_010/m2_2074_2909# u_t014_010/m2_7_336# u_t014_010/m2_717_2037#
+ u_t014_010/m2_1886_2031# u_t014_010/m2_2573_336# u_t014_010/m2_7_2898# u_t014_010/m2_2000_1265#
+ u_t014_010/m2_512_2037# u_t014_010/m2_1795_1265# u_t014_010/m2_1714_1982# u_t014_010/m2_1886_1259#
+ u_t014_010/m2_1290_2126# u_t014_010/m2_1714_438# u_t014_010/m2_431_1210# u_t014_010/m2_2573_2898#
+ u_t014_010/m2_2154_303# u_t014_010/m2_871_2081# VSUBS detronyx_12t_2w2r_rc4_4x4_routed_5layer_direct
Xgf180mcu_as_sc_mcu7t3v3__nand2_2_44 gf180mcu_as_sc_mcu7t3v3__nor2_2_9/VDD gf180mcu_as_sc_mcu7t3v3__nand3_2_63/VSS
+ VSS VSS VSS gf180mcu_as_sc_mcu7t3v3__nor2_2_9/VNW VSUBS gf180mcu_as_sc_mcu7t3v3__nand2_2
Xgf180mcu_as_sc_mcu7t3v3__nand2_2_22 gf180mcu_as_sc_mcu7t3v3__nor2_2_6/VDD gf180mcu_as_sc_mcu7t3v3__nand3_2_4/VSS
+ VSS VSS VSS gf180mcu_as_sc_mcu7t3v3__nor2_2_6/VNW VSUBS gf180mcu_as_sc_mcu7t3v3__nand2_2
Xgf180mcu_as_sc_mcu7t3v3__nand2_2_11 gf180mcu_as_sc_mcu7t3v3__nor2_2_4/VDD gf180mcu_as_sc_mcu7t3v3__nand2_2_3/VSS
+ VSS VSS VSS gf180mcu_as_sc_mcu7t3v3__nor2_2_4/VNW VSUBS gf180mcu_as_sc_mcu7t3v3__nand2_2
Xgf180mcu_as_sc_mcu7t3v3__nand2_2_33 gf180mcu_as_sc_mcu7t3v3__nor2_2_4/VDD gf180mcu_as_sc_mcu7t3v3__nand2_2_3/VSS
+ VSS VSS VSS gf180mcu_as_sc_mcu7t3v3__nor2_2_4/VNW VSUBS gf180mcu_as_sc_mcu7t3v3__nand2_2
Xu_t020_013 u_t020_013/c0_w0_bl u_t020_013/c0_w0_br u_t020_013/c0_w1_bl u_t020_013/c0_w1_br
+ u_t020_013/c0_r0_rbl u_t020_013/c0_r1_rbl u_t020_013/c1_w0_bl u_t020_013/c1_w0_br
+ u_t020_013/c1_w1_bl u_t020_013/c1_w1_br u_t020_013/c1_r0_rbl u_t020_013/c1_r1_rbl
+ u_t020_013/c2_w0_bl u_t020_013/c2_w0_br u_t020_013/c2_w1_bl u_t020_013/c2_w1_br
+ u_t020_013/c2_r0_rbl u_t020_013/c2_r1_rbl u_t020_013/c3_w0_bl u_t020_013/c3_w0_br
+ u_t020_013/c3_w1_bl u_t020_013/c3_w1_br u_t020_013/c3_r0_rbl u_t020_013/c3_r1_rbl
+ u_t020_013/r0_w0_wl u_t020_013/r0_w1_wl u_t020_013/r0_r0_rwl u_t020_013/r0_r1_rwl
+ u_t020_013/r1_w0_wl u_t020_013/r1_w1_wl u_t020_013/r1_r0_rwl u_t020_013/r1_r1_rwl
+ u_t020_013/r2_w0_wl u_t020_013/r2_w1_wl u_t020_013/r2_r0_rwl u_t020_013/r2_r1_rwl
+ u_t020_013/r3_w0_wl u_t020_013/r3_w1_wl u_t020_013/r3_r0_rwl u_t020_013/r3_r1_rwl
+ u_t020_013/VDD u_t020_013/VSS u_t020_013/m2_717_1265# u_t020_013/m2_603_2031# u_t020_013/m2_1290_336#
+ u_t020_013/m2_2000_2037# u_t020_013/m2_791_2909# u_t020_013/m2_7_2126# u_t020_013/m2_2154_2081#
+ u_t020_013/m2_1795_2037# u_t020_013/m2_871_303# u_t020_013/m2_431_438# u_t020_013/m2_1290_2898#
+ u_t020_013/m2_1714_1210# u_t020_013/m2_431_1982# u_t020_013/m2_512_1265# u_t020_013/m2_2573_2126#
+ u_t020_013/m2_603_1259# u_t020_013/m2_2074_2909# u_t020_013/m2_7_336# u_t020_013/m2_717_2037#
+ u_t020_013/m2_1886_2031# u_t020_013/m2_2573_336# u_t020_013/m2_7_2898# u_t020_013/m2_2000_1265#
+ u_t020_013/m2_512_2037# u_t020_013/m2_1795_1265# u_t020_013/m2_1714_1982# u_t020_013/m2_1886_1259#
+ u_t020_013/m2_1290_2126# u_t020_013/m2_1714_438# u_t020_013/m2_431_1210# u_t020_013/m2_2573_2898#
+ u_t020_013/m2_2154_303# u_t020_013/m2_871_2081# VSUBS detronyx_12t_2w2r_rc4_4x4_routed_5layer_direct
Xu_t005_010 u_t005_010/c0_w0_bl u_t005_010/c0_w0_br u_t005_010/c0_w1_bl u_t005_010/c0_w1_br
+ u_t005_010/c0_r0_rbl u_t005_010/c0_r1_rbl u_t005_010/c1_w0_bl u_t005_010/c1_w0_br
+ u_t005_010/c1_w1_bl u_t005_010/c1_w1_br u_t005_010/c1_r0_rbl u_t005_010/c1_r1_rbl
+ u_t005_010/c2_w0_bl u_t005_010/c2_w0_br u_t005_010/c2_w1_bl u_t005_010/c2_w1_br
+ u_t005_010/c2_r0_rbl u_t005_010/c2_r1_rbl u_t005_010/c3_w0_bl u_t005_010/c3_w0_br
+ u_t005_010/c3_w1_bl u_t005_010/c3_w1_br u_t005_010/c3_r0_rbl u_t005_010/c3_r1_rbl
+ u_t005_010/r0_w0_wl u_t005_010/r0_w1_wl u_t005_010/r0_r0_rwl u_t005_010/r0_r1_rwl
+ u_t005_010/r1_w0_wl u_t005_010/r1_w1_wl u_t005_010/r1_r0_rwl u_t005_010/r1_r1_rwl
+ u_t005_010/r2_w0_wl u_t005_010/r2_w1_wl u_t005_010/r2_r0_rwl u_t005_010/r2_r1_rwl
+ u_t005_010/r3_w0_wl u_t005_010/r3_w1_wl u_t005_010/r3_r0_rwl u_t005_010/r3_r1_rwl
+ VSS VSS u_t005_010/m2_717_1265# u_t005_010/m2_603_2031# u_t005_010/m2_1290_336#
+ u_t005_010/m2_2000_2037# u_t005_010/m2_791_2909# u_t005_010/m2_7_2126# u_t005_010/m2_2154_2081#
+ u_t005_010/m2_1795_2037# u_t005_010/m2_871_303# u_t005_010/m2_431_438# u_t005_010/m2_1290_2898#
+ u_t005_010/m2_1714_1210# u_t005_010/m2_431_1982# u_t005_010/m2_512_1265# u_t005_010/m2_2573_2126#
+ u_t005_010/m2_603_1259# u_t005_010/m2_2074_2909# u_t005_010/m2_7_336# u_t005_010/m2_717_2037#
+ u_t005_010/m2_1886_2031# u_t005_010/m2_2573_336# u_t005_010/m2_7_2898# u_t005_010/m2_2000_1265#
+ u_t005_010/m2_512_2037# u_t005_010/m2_1795_1265# u_t005_010/m2_1714_1982# u_t005_010/m2_1886_1259#
+ u_t005_010/m2_1290_2126# u_t005_010/m2_1714_438# u_t005_010/m2_431_1210# u_t005_010/m2_2573_2898#
+ u_t005_010/m2_2154_303# u_t005_010/m2_871_2081# VSUBS detronyx_12t_2w2r_rc4_4x4_routed_5layer_direct
Xu_t020_002 u_t020_002/c0_w0_bl u_t020_002/c0_w0_br u_t020_002/c0_w1_bl u_t020_002/c0_w1_br
+ u_t020_002/c0_r0_rbl u_t020_002/c0_r1_rbl u_t020_002/c1_w0_bl u_t020_002/c1_w0_br
+ u_t020_002/c1_w1_bl u_t020_002/c1_w1_br u_t020_002/c1_r0_rbl u_t020_002/c1_r1_rbl
+ u_t020_002/c2_w0_bl u_t020_002/c2_w0_br u_t020_002/c2_w1_bl u_t020_002/c2_w1_br
+ u_t020_002/c2_r0_rbl u_t020_002/c2_r1_rbl u_t020_002/c3_w0_bl u_t020_002/c3_w0_br
+ u_t020_002/c3_w1_bl u_t020_002/c3_w1_br u_t020_002/c3_r0_rbl u_t020_002/c3_r1_rbl
+ u_t020_002/r0_w0_wl u_t020_002/r0_w1_wl u_t020_002/r0_r0_rwl u_t020_002/r0_r1_rwl
+ u_t020_002/r1_w0_wl u_t020_002/r1_w1_wl u_t020_002/r1_r0_rwl u_t020_002/r1_r1_rwl
+ u_t020_002/r2_w0_wl u_t020_002/r2_w1_wl u_t020_002/r2_r0_rwl u_t020_002/r2_r1_rwl
+ u_t020_002/r3_w0_wl u_t020_002/r3_w1_wl u_t020_002/r3_r0_rwl u_t020_002/r3_r1_rwl
+ VSS VSS u_t020_002/m2_717_1265# u_t020_002/m2_603_2031# u_t020_002/m2_1290_336#
+ u_t020_002/m2_2000_2037# u_t020_002/m2_791_2909# u_t020_002/m2_7_2126# u_t020_002/m2_2154_2081#
+ u_t020_002/m2_1795_2037# u_t020_002/m2_871_303# u_t020_002/m2_431_438# u_t020_002/m2_1290_2898#
+ u_t020_002/m2_1714_1210# u_t020_002/m2_431_1982# u_t020_002/m2_512_1265# u_t020_002/m2_2573_2126#
+ u_t020_002/m2_603_1259# u_t020_002/m2_2074_2909# u_t020_002/m2_7_336# u_t020_002/m2_717_2037#
+ u_t020_002/m2_1886_2031# u_t020_002/m2_2573_336# u_t020_002/m2_7_2898# u_t020_002/m2_2000_1265#
+ u_t020_002/m2_512_2037# u_t020_002/m2_1795_1265# u_t020_002/m2_1714_1982# u_t020_002/m2_1886_1259#
+ u_t020_002/m2_1290_2126# u_t020_002/m2_1714_438# u_t020_002/m2_431_1210# u_t020_002/m2_2573_2898#
+ u_t020_002/m2_2154_303# u_t020_002/m2_871_2081# VSUBS detronyx_12t_2w2r_rc4_4x4_routed_5layer_direct
Xgf180mcu_as_sc_mcu7t3v3__inv_2_1406 gf180mcu_as_sc_mcu7t3v3__inv_2_1406/VDD gf180mcu_as_sc_mcu7t3v3__inv_2_1406/VSS
+ gf180mcu_as_sc_mcu7t3v3__inv_2_1409/A VSS gf180mcu_as_sc_mcu7t3v3__inv_2_1406/VNW
+ VSUBS gf180mcu_as_sc_mcu7t3v3__inv_2
Xgf180mcu_as_sc_mcu7t3v3__inv_2_1417 VSS VSS VSS VSS gf180mcu_as_sc_mcu7t3v3__inv_2_1419/VNW
+ VSUBS gf180mcu_as_sc_mcu7t3v3__inv_2
Xgf180mcu_as_sc_mcu7t3v3__inv_2_1439 VSS gf180mcu_as_sc_mcu7t3v3__inv_2_1443/VDD gf180mcu_as_sc_mcu7t3v3__inv_2_1439/Y
+ VSS gf180mcu_as_sc_mcu7t3v3__inv_2_1440/VNW VSUBS gf180mcu_as_sc_mcu7t3v3__inv_2
Xgf180mcu_as_sc_mcu7t3v3__inv_2_1428 VSS VSS VSS VSS gf180mcu_as_sc_mcu7t3v3__inv_2_1428/VNW
+ VSUBS gf180mcu_as_sc_mcu7t3v3__inv_2
Xu_t011_013 u_t011_013/c0_w0_bl u_t011_013/c0_w0_br u_t011_013/c0_w1_bl u_t011_013/c0_w1_br
+ u_t011_013/c0_r0_rbl u_t011_013/c0_r1_rbl u_t011_013/c1_w0_bl u_t011_013/c1_w0_br
+ u_t011_013/c1_w1_bl u_t011_013/c1_w1_br u_t011_013/c1_r0_rbl u_t011_013/c1_r1_rbl
+ u_t011_013/c2_w0_bl u_t011_013/c2_w0_br u_t011_013/c2_w1_bl u_t011_013/c2_w1_br
+ u_t011_013/c2_r0_rbl u_t011_013/c2_r1_rbl u_t011_013/c3_w0_bl u_t011_013/c3_w0_br
+ u_t011_013/c3_w1_bl u_t011_013/c3_w1_br u_t011_013/c3_r0_rbl u_t011_013/c3_r1_rbl
+ u_t011_013/r0_w0_wl u_t011_013/r0_w1_wl u_t011_013/r0_r0_rwl u_t011_013/r0_r1_rwl
+ u_t011_013/r1_w0_wl u_t011_013/r1_w1_wl u_t011_013/r1_r0_rwl u_t011_013/r1_r1_rwl
+ u_t011_013/r2_w0_wl u_t011_013/r2_w1_wl u_t011_013/r2_r0_rwl u_t011_013/r2_r1_rwl
+ u_t011_013/r3_w0_wl u_t011_013/r3_w1_wl u_t011_013/r3_r0_rwl u_t011_013/r3_r1_rwl
+ u_t011_013/VDD u_t011_013/VSS u_t011_013/m2_717_1265# u_t011_013/m2_603_2031# u_t011_013/m2_1290_336#
+ u_t011_013/m2_2000_2037# u_t011_013/m2_791_2909# u_t011_013/m2_7_2126# u_t011_013/m2_2154_2081#
+ u_t011_013/m2_1795_2037# u_t011_013/m2_871_303# u_t011_013/m2_431_438# u_t011_013/m2_1290_2898#
+ u_t011_013/m2_1714_1210# u_t011_013/m2_431_1982# u_t011_013/m2_512_1265# u_t011_013/m2_2573_2126#
+ u_t011_013/m2_603_1259# u_t011_013/m2_2074_2909# u_t011_013/m2_7_336# u_t011_013/m2_717_2037#
+ u_t011_013/m2_1886_2031# u_t011_013/m2_2573_336# u_t011_013/m2_7_2898# u_t011_013/m2_2000_1265#
+ u_t011_013/m2_512_2037# u_t011_013/m2_1795_1265# u_t011_013/m2_1714_1982# u_t011_013/m2_1886_1259#
+ u_t011_013/m2_1290_2126# u_t011_013/m2_1714_438# u_t011_013/m2_431_1210# u_t011_013/m2_2573_2898#
+ u_t011_013/m2_2154_303# u_t011_013/m2_871_2081# VSUBS detronyx_12t_2w2r_rc4_4x4_routed_5layer_direct
Xu_t011_002 u_t011_002/c0_w0_bl u_t011_002/c0_w0_br u_t011_002/c0_w1_bl u_t011_002/c0_w1_br
+ u_t011_002/c0_r0_rbl u_t011_002/c0_r1_rbl u_t011_002/c1_w0_bl u_t011_002/c1_w0_br
+ u_t011_002/c1_w1_bl u_t011_002/c1_w1_br u_t011_002/c1_r0_rbl u_t011_002/c1_r1_rbl
+ u_t011_002/c2_w0_bl u_t011_002/c2_w0_br u_t011_002/c2_w1_bl u_t011_002/c2_w1_br
+ u_t011_002/c2_r0_rbl u_t011_002/c2_r1_rbl u_t011_002/c3_w0_bl u_t011_002/c3_w0_br
+ u_t011_002/c3_w1_bl u_t011_002/c3_w1_br u_t011_002/c3_r0_rbl u_t011_002/c3_r1_rbl
+ u_t011_002/r0_w0_wl u_t011_002/r0_w1_wl u_t011_002/r0_r0_rwl u_t011_002/r0_r1_rwl
+ u_t011_002/r1_w0_wl u_t011_002/r1_w1_wl u_t011_002/r1_r0_rwl u_t011_002/r1_r1_rwl
+ u_t011_002/r2_w0_wl u_t011_002/r2_w1_wl u_t011_002/r2_r0_rwl u_t011_002/r2_r1_rwl
+ u_t011_002/r3_w0_wl u_t011_002/r3_w1_wl u_t011_002/r3_r0_rwl u_t011_002/r3_r1_rwl
+ VSS VSS u_t011_002/m2_717_1265# u_t011_002/m2_603_2031# u_t011_002/m2_1290_336#
+ u_t011_002/m2_2000_2037# u_t011_002/m2_791_2909# u_t011_002/m2_7_2126# u_t011_002/m2_2154_2081#
+ u_t011_002/m2_1795_2037# u_t011_002/m2_871_303# u_t011_002/m2_431_438# u_t011_002/m2_1290_2898#
+ u_t011_002/m2_1714_1210# u_t011_002/m2_431_1982# u_t011_002/m2_512_1265# u_t011_002/m2_2573_2126#
+ u_t011_002/m2_603_1259# u_t011_002/m2_2074_2909# u_t011_002/m2_7_336# u_t011_002/m2_717_2037#
+ u_t011_002/m2_1886_2031# u_t011_002/m2_2573_336# u_t011_002/m2_7_2898# u_t011_002/m2_2000_1265#
+ u_t011_002/m2_512_2037# u_t011_002/m2_1795_1265# u_t011_002/m2_1714_1982# u_t011_002/m2_1886_1259#
+ u_t011_002/m2_1290_2126# u_t011_002/m2_1714_438# u_t011_002/m2_431_1210# u_t011_002/m2_2573_2898#
+ u_t011_002/m2_2154_303# u_t011_002/m2_871_2081# VSUBS detronyx_12t_2w2r_rc4_4x4_routed_5layer_direct
Xu_t002_013 u_t002_013/c0_w0_bl u_t002_013/c0_w0_br u_t002_013/c0_w1_bl u_t002_013/c0_w1_br
+ u_t002_013/c0_r0_rbl u_t002_013/c0_r1_rbl u_t002_013/c1_w0_bl u_t002_013/c1_w0_br
+ u_t002_013/c1_w1_bl u_t002_013/c1_w1_br u_t002_013/c1_r0_rbl u_t002_013/c1_r1_rbl
+ u_t002_013/c2_w0_bl u_t002_013/c2_w0_br u_t002_013/c2_w1_bl u_t002_013/c2_w1_br
+ u_t002_013/c2_r0_rbl u_t002_013/c2_r1_rbl u_t002_013/c3_w0_bl u_t002_013/c3_w0_br
+ u_t002_013/c3_w1_bl u_t002_013/c3_w1_br u_t002_013/c3_r0_rbl u_t002_013/c3_r1_rbl
+ u_t002_013/r0_w0_wl u_t002_013/r0_w1_wl u_t002_013/r0_r0_rwl u_t002_013/r0_r1_rwl
+ u_t002_013/r1_w0_wl u_t002_013/r1_w1_wl u_t002_013/r1_r0_rwl u_t002_013/r1_r1_rwl
+ u_t002_013/r2_w0_wl u_t002_013/r2_w1_wl u_t002_013/r2_r0_rwl u_t002_013/r2_r1_rwl
+ u_t002_013/r3_w0_wl u_t002_013/r3_w1_wl u_t002_013/r3_r0_rwl u_t002_013/r3_r1_rwl
+ u_t002_013/VDD u_t002_013/VSS u_t002_013/m2_717_1265# u_t002_013/m2_603_2031# u_t002_013/m2_1290_336#
+ u_t002_013/m2_2000_2037# u_t002_013/m2_791_2909# u_t002_013/m2_7_2126# u_t002_013/m2_2154_2081#
+ u_t002_013/m2_1795_2037# u_t002_013/m2_871_303# u_t002_013/m2_431_438# u_t002_013/m2_1290_2898#
+ u_t002_013/m2_1714_1210# u_t002_013/m2_431_1982# u_t002_013/m2_512_1265# u_t002_013/m2_2573_2126#
+ u_t002_013/m2_603_1259# u_t002_013/m2_2074_2909# u_t002_013/m2_7_336# u_t002_013/m2_717_2037#
+ u_t002_013/m2_1886_2031# u_t002_013/m2_2573_336# u_t002_013/m2_7_2898# u_t002_013/m2_2000_1265#
+ u_t002_013/m2_512_2037# u_t002_013/m2_1795_1265# u_t002_013/m2_1714_1982# u_t002_013/m2_1886_1259#
+ u_t002_013/m2_1290_2126# u_t002_013/m2_1714_438# u_t002_013/m2_431_1210# u_t002_013/m2_2573_2898#
+ u_t002_013/m2_2154_303# u_t002_013/m2_871_2081# VSUBS detronyx_12t_2w2r_rc4_4x4_routed_5layer_direct
Xu_t002_002 u_t002_002/c0_w0_bl u_t002_002/c0_w0_br u_t002_002/c0_w1_bl u_t002_002/c0_w1_br
+ u_t002_002/c0_r0_rbl u_t002_002/c0_r1_rbl u_t002_002/c1_w0_bl u_t002_002/c1_w0_br
+ u_t002_002/c1_w1_bl u_t002_002/c1_w1_br u_t002_002/c1_r0_rbl u_t002_002/c1_r1_rbl
+ u_t002_002/c2_w0_bl u_t002_002/c2_w0_br u_t002_002/c2_w1_bl u_t002_002/c2_w1_br
+ u_t002_002/c2_r0_rbl u_t002_002/c2_r1_rbl u_t002_002/c3_w0_bl u_t002_002/c3_w0_br
+ u_t002_002/c3_w1_bl u_t002_002/c3_w1_br u_t002_002/c3_r0_rbl u_t002_002/c3_r1_rbl
+ u_t002_002/r0_w0_wl u_t002_002/r0_w1_wl u_t002_002/r0_r0_rwl u_t002_002/r0_r1_rwl
+ u_t002_002/r1_w0_wl u_t002_002/r1_w1_wl u_t002_002/r1_r0_rwl u_t002_002/r1_r1_rwl
+ u_t002_002/r2_w0_wl u_t002_002/r2_w1_wl u_t002_002/r2_r0_rwl u_t002_002/r2_r1_rwl
+ u_t002_002/r3_w0_wl u_t002_002/r3_w1_wl u_t002_002/r3_r0_rwl u_t002_002/r3_r1_rwl
+ VSS VSS u_t002_002/m2_717_1265# u_t002_002/m2_603_2031# u_t002_002/m2_1290_336#
+ u_t002_002/m2_2000_2037# u_t002_002/m2_791_2909# u_t002_002/m2_7_2126# u_t002_002/m2_2154_2081#
+ u_t002_002/m2_1795_2037# u_t002_002/m2_871_303# u_t002_002/m2_431_438# u_t002_002/m2_1290_2898#
+ u_t002_002/m2_1714_1210# u_t002_002/m2_431_1982# u_t002_002/m2_512_1265# u_t002_002/m2_2573_2126#
+ u_t002_002/m2_603_1259# u_t002_002/m2_2074_2909# u_t002_002/m2_7_336# u_t002_002/m2_717_2037#
+ u_t002_002/m2_1886_2031# u_t002_002/m2_2573_336# u_t002_002/m2_7_2898# u_t002_002/m2_2000_1265#
+ u_t002_002/m2_512_2037# u_t002_002/m2_1795_1265# u_t002_002/m2_1714_1982# u_t002_002/m2_1886_1259#
+ u_t002_002/m2_1290_2126# u_t002_002/m2_1714_438# u_t002_002/m2_431_1210# u_t002_002/m2_2573_2898#
+ u_t002_002/m2_2154_303# u_t002_002/m2_871_2081# VSUBS detronyx_12t_2w2r_rc4_4x4_routed_5layer_direct
Xgf180mcu_as_sc_mcu7t3v3__inv_2_1269 gf180mcu_as_sc_mcu7t3v3__nor2_2_9/VDD gf180mcu_as_sc_mcu7t3v3__nor2_2_9/VSS
+ VSS VSS gf180mcu_as_sc_mcu7t3v3__nor2_2_9/VNW VSUBS gf180mcu_as_sc_mcu7t3v3__inv_2
Xgf180mcu_as_sc_mcu7t3v3__inv_2_1258 gf180mcu_as_sc_mcu7t3v3__nand3_2_65/VDD gf180mcu_as_sc_mcu7t3v3__nor2_2_9/VSS
+ VSS VSS gf180mcu_as_sc_mcu7t3v3__nand3_2_65/VNW VSUBS gf180mcu_as_sc_mcu7t3v3__inv_2
Xgf180mcu_as_sc_mcu7t3v3__inv_2_1203 gf180mcu_as_sc_mcu7t3v3__nand3_2_65/VDD gf180mcu_as_sc_mcu7t3v3__nor2_2_9/VSS
+ VSS VSS gf180mcu_as_sc_mcu7t3v3__nand3_2_65/VNW VSUBS gf180mcu_as_sc_mcu7t3v3__inv_2
Xgf180mcu_as_sc_mcu7t3v3__inv_2_1247 gf180mcu_as_sc_mcu7t3v3__nand3_2_65/VDD gf180mcu_as_sc_mcu7t3v3__nand3_2_62/VSS
+ VSS VSS gf180mcu_as_sc_mcu7t3v3__nand3_2_65/VNW VSUBS gf180mcu_as_sc_mcu7t3v3__inv_2
Xgf180mcu_as_sc_mcu7t3v3__inv_2_1236 gf180mcu_as_sc_mcu7t3v3__nand3_2_65/VDD gf180mcu_as_sc_mcu7t3v3__nand3_2_62/VSS
+ VSS VSS gf180mcu_as_sc_mcu7t3v3__nand3_2_65/VNW VSUBS gf180mcu_as_sc_mcu7t3v3__inv_2
Xgf180mcu_as_sc_mcu7t3v3__inv_2_1225 VSS VSS VSS VSS gf180mcu_as_sc_mcu7t3v3__inv_2_1282/VNW
+ VSUBS gf180mcu_as_sc_mcu7t3v3__inv_2
Xgf180mcu_as_sc_mcu7t3v3__inv_2_1214 VSS VSS VSS VSS gf180mcu_as_sc_mcu7t3v3__inv_2_1283/VNW
+ VSUBS gf180mcu_as_sc_mcu7t3v3__inv_2
Xgf180mcu_as_sc_mcu7t3v3__inv_2_709 VSS gf180mcu_as_sc_mcu7t3v3__inv_2_731/VDD gf180mcu_as_sc_mcu7t3v3__inv_2_709/Y
+ gf180mcu_as_sc_mcu7t3v3__inv_2_742/A gf180mcu_as_sc_mcu7t3v3__inv_2_717/VNW VSUBS
+ gf180mcu_as_sc_mcu7t3v3__inv_2
Xgf180mcu_as_sc_mcu7t3v3__inv_2_30 gf180mcu_as_sc_mcu7t3v3__inv_2_32/VDD gf180mcu_as_sc_mcu7t3v3__inv_2_4/VDD
+ VSS gf180mcu_as_sc_mcu7t3v3__inv_2_66/Y gf180mcu_as_sc_mcu7t3v3__inv_2_32/VNW VSUBS
+ gf180mcu_as_sc_mcu7t3v3__inv_2
Xgf180mcu_as_sc_mcu7t3v3__inv_2_41 VSS gf180mcu_as_sc_mcu7t3v3__inv_2_46/VDD gf180mcu_as_sc_mcu7t3v3__inv_2_9/Y
+ gf180mcu_as_sc_mcu7t3v3__inv_2_9/Y gf180mcu_as_sc_mcu7t3v3__inv_2_42/VNW VSUBS gf180mcu_as_sc_mcu7t3v3__inv_2
Xgf180mcu_as_sc_mcu7t3v3__inv_2_52 gf180mcu_as_sc_mcu7t3v3__inv_2_53/VDD gf180mcu_as_sc_mcu7t3v3__inv_2_57/VDD
+ gf180mcu_as_sc_mcu7t3v3__inv_2_61/Y gf180mcu_as_sc_mcu7t3v3__inv_2_61/Y gf180mcu_as_sc_mcu7t3v3__inv_2_53/VNW
+ VSUBS gf180mcu_as_sc_mcu7t3v3__inv_2
Xgf180mcu_as_sc_mcu7t3v3__inv_2_1066 gf180mcu_as_sc_mcu7t3v3__inv_2_1100/VSS VSS gf180mcu_as_sc_mcu7t3v3__inv_2_1149/A
+ gf180mcu_as_sc_mcu7t3v3__inv_2_1067/Y gf180mcu_as_sc_mcu7t3v3__inv_2_1067/VNW VSUBS
+ gf180mcu_as_sc_mcu7t3v3__inv_2
Xgf180mcu_as_sc_mcu7t3v3__inv_2_1077 gf180mcu_as_sc_mcu7t3v3__inv_2_1079/VDD VSS VSS
+ gf180mcu_as_sc_mcu7t3v3__inv_2_1149/A gf180mcu_as_sc_mcu7t3v3__inv_2_1079/VNW VSUBS
+ gf180mcu_as_sc_mcu7t3v3__inv_2
Xgf180mcu_as_sc_mcu7t3v3__inv_2_1099 VSS gf180mcu_as_sc_mcu7t3v3__inv_2_1103/VDD gf180mcu_as_sc_mcu7t3v3__inv_2_1099/Y
+ VSS gf180mcu_as_sc_mcu7t3v3__inv_2_1099/VNW VSUBS gf180mcu_as_sc_mcu7t3v3__inv_2
Xgf180mcu_as_sc_mcu7t3v3__inv_2_1088 VSS gf180mcu_as_sc_mcu7t3v3__inv_2_1112/VDD VSS
+ gf180mcu_as_sc_mcu7t3v3__inv_2_1306/Y gf180mcu_as_sc_mcu7t3v3__inv_2_1096/VNW VSUBS
+ gf180mcu_as_sc_mcu7t3v3__inv_2
Xgf180mcu_as_sc_mcu7t3v3__inv_2_1011 gf180mcu_as_sc_mcu7t3v3__inv_2_1036/VSS VSS gf180mcu_as_sc_mcu7t3v3__inv_2_1306/Y
+ gf180mcu_as_sc_mcu7t3v3__inv_2_1012/Y gf180mcu_as_sc_mcu7t3v3__inv_2_1012/VNW VSUBS
+ gf180mcu_as_sc_mcu7t3v3__inv_2
Xgf180mcu_as_sc_mcu7t3v3__inv_2_1033 VSS gf180mcu_as_sc_mcu7t3v3__inv_2_1053/VDD gf180mcu_as_sc_mcu7t3v3__inv_2_1033/Y
+ gf180mcu_as_sc_mcu7t3v3__inv_2_1037/Y gf180mcu_as_sc_mcu7t3v3__inv_2_1037/VNW VSUBS
+ gf180mcu_as_sc_mcu7t3v3__inv_2
Xgf180mcu_as_sc_mcu7t3v3__inv_2_1044 VSS gf180mcu_as_sc_mcu7t3v3__inv_2_1048/VDD gf180mcu_as_sc_mcu7t3v3__inv_2_1044/Y
+ VSS gf180mcu_as_sc_mcu7t3v3__inv_2_1044/VNW VSUBS gf180mcu_as_sc_mcu7t3v3__inv_2
Xgf180mcu_as_sc_mcu7t3v3__inv_2_1055 VSS gf180mcu_as_sc_mcu7t3v3__inv_2_1058/VDD gf180mcu_as_sc_mcu7t3v3__inv_2_962/A
+ gf180mcu_as_sc_mcu7t3v3__inv_2_1056/Y gf180mcu_as_sc_mcu7t3v3__inv_2_1056/VNW VSUBS
+ gf180mcu_as_sc_mcu7t3v3__inv_2
Xgf180mcu_as_sc_mcu7t3v3__inv_2_85 gf180mcu_as_sc_mcu7t3v3__inv_2_94/VSS gf180mcu_as_sc_mcu7t3v3__inv_2_91/VSS
+ gf180mcu_as_sc_mcu7t3v3__inv_2_85/Y VSS gf180mcu_as_sc_mcu7t3v3__inv_2_91/VNW VSUBS
+ gf180mcu_as_sc_mcu7t3v3__inv_2
Xgf180mcu_as_sc_mcu7t3v3__inv_2_96 gf180mcu_as_sc_mcu7t3v3__inv_2_97/VDD gf180mcu_as_sc_mcu7t3v3__inv_2_98/VDD
+ gf180mcu_as_sc_mcu7t3v3__inv_2_96/Y VSS gf180mcu_as_sc_mcu7t3v3__inv_2_97/VNW VSUBS
+ gf180mcu_as_sc_mcu7t3v3__inv_2
Xgf180mcu_as_sc_mcu7t3v3__inv_2_74 VSS gf180mcu_as_sc_mcu7t3v3__inv_2_0/VSS gf180mcu_as_sc_mcu7t3v3__inv_2_9/Y
+ gf180mcu_as_sc_mcu7t3v3__inv_2_9/Y gf180mcu_as_sc_mcu7t3v3__inv_2_0/VNW VSUBS gf180mcu_as_sc_mcu7t3v3__inv_2
Xgf180mcu_as_sc_mcu7t3v3__inv_2_63 gf180mcu_as_sc_mcu7t3v3__inv_2_69/VDD gf180mcu_as_sc_mcu7t3v3__inv_2_69/VDD
+ VSS gf180mcu_as_sc_mcu7t3v3__inv_2_73/Y gf180mcu_as_sc_mcu7t3v3__inv_2_65/VNW VSUBS
+ gf180mcu_as_sc_mcu7t3v3__inv_2
Xgf180mcu_as_sc_mcu7t3v3__inv_2_1000 gf180mcu_as_sc_mcu7t3v3__inv_2_999/VDD VSS gf180mcu_as_sc_mcu7t3v3__inv_2_999/A
+ VSS gf180mcu_as_sc_mcu7t3v3__inv_2_999/VNW VSUBS gf180mcu_as_sc_mcu7t3v3__inv_2
Xgf180mcu_as_sc_mcu7t3v3__inv_2_1022 VSS gf180mcu_as_sc_mcu7t3v3__inv_2_1061/VDD VSS
+ gf180mcu_as_sc_mcu7t3v3__inv_2_962/A gf180mcu_as_sc_mcu7t3v3__inv_2_1024/VNW VSUBS
+ gf180mcu_as_sc_mcu7t3v3__inv_2
Xgf180mcu_as_sc_mcu7t3v3__inv_2_528 gf180mcu_as_sc_mcu7t3v3__nand3_2_9/VDD gf180mcu_as_sc_mcu7t3v3__nor2_2_7/VSS
+ VSS VSS gf180mcu_as_sc_mcu7t3v3__nand3_2_9/VNW VSUBS gf180mcu_as_sc_mcu7t3v3__inv_2
Xgf180mcu_as_sc_mcu7t3v3__inv_2_517 VSS VSS gf180mcu_as_sc_mcu7t3v3__inv_2_517/Y VSS
+ gf180mcu_as_sc_mcu7t3v3__inv_2_559/VNW VSUBS gf180mcu_as_sc_mcu7t3v3__inv_2
Xgf180mcu_as_sc_mcu7t3v3__inv_2_539 VSS VSS VSS VSS gf180mcu_as_sc_mcu7t3v3__inv_2_539/VNW
+ VSUBS gf180mcu_as_sc_mcu7t3v3__inv_2
Xgf180mcu_as_sc_mcu7t3v3__inv_2_506 VSS VSS VSS VSS gf180mcu_as_sc_mcu7t3v3__inv_2_538/VNW
+ VSUBS gf180mcu_as_sc_mcu7t3v3__inv_2
Xgf180mcu_as_sc_mcu7t3v3__nand3_2_0 gf180mcu_as_sc_mcu7t3v3__nor2_2_6/VDD gf180mcu_as_sc_mcu7t3v3__nand3_2_4/VSS
+ VSS VSS VSS VSS gf180mcu_as_sc_mcu7t3v3__nor2_2_6/VNW VSUBS gf180mcu_as_sc_mcu7t3v3__nand3_2
Xgf180mcu_as_sc_mcu7t3v3__nand4_2_372 VSS VSS VSS VSS VSS VSS gf180mcu_as_sc_mcu7t3v3__nand4_2_372/Y
+ gf180mcu_as_sc_mcu7t3v3__inv_2_1274/VNW VSUBS gf180mcu_as_sc_mcu7t3v3__nand4_2
Xgf180mcu_as_sc_mcu7t3v3__nand4_2_361 VSS VSS VSS VSS VSS VSS VSS gf180mcu_as_sc_mcu7t3v3__inv_2_1296/VNW
+ VSUBS gf180mcu_as_sc_mcu7t3v3__nand4_2
Xgf180mcu_as_sc_mcu7t3v3__nand4_2_350 VSS VSS VSS VSS VSS VSS gf180mcu_as_sc_mcu7t3v3__nand4_2_350/Y
+ gf180mcu_as_sc_mcu7t3v3__inv_2_1298/VNW VSUBS gf180mcu_as_sc_mcu7t3v3__nand4_2
Xgf180mcu_as_sc_mcu7t3v3__nand4_2_383 VSS VSS VSS VSS VSS VSS VSS gf180mcu_as_sc_mcu7t3v3__inv_2_1419/VNW
+ VSUBS gf180mcu_as_sc_mcu7t3v3__nand4_2
Xgf180mcu_as_sc_mcu7t3v3__nand4_2_394 gf180mcu_as_sc_mcu7t3v3__inv_2_1452/VDD gf180mcu_as_sc_mcu7t3v3__inv_2_1455/VDD
+ VSS VSS VSS VSS gf180mcu_as_sc_mcu7t3v3__nand4_2_394/Y gf180mcu_as_sc_mcu7t3v3__inv_2_1452/VNW
+ VSUBS gf180mcu_as_sc_mcu7t3v3__nand4_2
Xgf180mcu_as_sc_mcu7t3v3__inv_2_369 gf180mcu_as_sc_mcu7t3v3__inv_2_371/VDD gf180mcu_as_sc_mcu7t3v3__inv_2_371/VSS
+ gf180mcu_as_sc_mcu7t3v3__inv_2_369/Y VSS gf180mcu_as_sc_mcu7t3v3__inv_2_371/VNW
+ VSUBS gf180mcu_as_sc_mcu7t3v3__inv_2
Xgf180mcu_as_sc_mcu7t3v3__inv_2_303 gf180mcu_as_sc_mcu7t3v3__inv_2_304/VSS VSS VSS
+ gf180mcu_as_sc_mcu7t3v3__inv_2_304/A gf180mcu_as_sc_mcu7t3v3__inv_2_303/VNW VSUBS
+ gf180mcu_as_sc_mcu7t3v3__inv_2
Xgf180mcu_as_sc_mcu7t3v3__inv_2_358 VSS gf180mcu_as_sc_mcu7t3v3__inv_2_365/VDD gf180mcu_as_sc_mcu7t3v3__inv_2_358/Y
+ gf180mcu_as_sc_mcu7t3v3__inv_2_359/Y gf180mcu_as_sc_mcu7t3v3__inv_2_359/VNW VSUBS
+ gf180mcu_as_sc_mcu7t3v3__inv_2
Xgf180mcu_as_sc_mcu7t3v3__inv_2_347 VSS gf180mcu_as_sc_mcu7t3v3__inv_2_350/VDD gf180mcu_as_sc_mcu7t3v3__inv_2_350/Y
+ VSS gf180mcu_as_sc_mcu7t3v3__inv_2_347/VNW VSUBS gf180mcu_as_sc_mcu7t3v3__inv_2
Xgf180mcu_as_sc_mcu7t3v3__inv_2_336 gf180mcu_as_sc_mcu7t3v3__inv_2_338/VDD gf180mcu_as_sc_mcu7t3v3__inv_2_341/VDD
+ VSS gf180mcu_as_sc_mcu7t3v3__inv_2_341/Y gf180mcu_as_sc_mcu7t3v3__inv_2_338/VNW
+ VSUBS gf180mcu_as_sc_mcu7t3v3__inv_2
Xgf180mcu_as_sc_mcu7t3v3__inv_2_325 VSS gf180mcu_as_sc_mcu7t3v3__inv_2_329/VDD gf180mcu_as_sc_mcu7t3v3__inv_2_325/Y
+ gf180mcu_as_sc_mcu7t3v3__inv_2_341/Y gf180mcu_as_sc_mcu7t3v3__inv_2_326/VNW VSUBS
+ gf180mcu_as_sc_mcu7t3v3__inv_2
Xgf180mcu_as_sc_mcu7t3v3__inv_2_314 VSS VSS gf180mcu_as_sc_mcu7t3v3__inv_2_341/Y VSS
+ gf180mcu_as_sc_mcu7t3v3__inv_2_314/VNW VSUBS gf180mcu_as_sc_mcu7t3v3__inv_2
Xu_t027_008 u_t027_008/c0_w0_bl u_t027_008/c0_w0_br u_t027_008/c0_w1_bl u_t027_008/c0_w1_br
+ u_t027_008/c0_r0_rbl u_t027_008/c0_r1_rbl u_t027_008/c1_w0_bl u_t027_008/c1_w0_br
+ u_t027_008/c1_w1_bl u_t027_008/c1_w1_br u_t027_008/c1_r0_rbl u_t027_008/c1_r1_rbl
+ u_t027_008/c2_w0_bl u_t027_008/c2_w0_br u_t027_008/c2_w1_bl u_t027_008/c2_w1_br
+ u_t027_008/c2_r0_rbl u_t027_008/c2_r1_rbl u_t027_008/c3_w0_bl u_t027_008/c3_w0_br
+ u_t027_008/c3_w1_bl u_t027_008/c3_w1_br u_t027_008/c3_r0_rbl u_t027_008/c3_r1_rbl
+ u_t027_008/r0_w0_wl u_t027_008/r0_w1_wl u_t027_008/r0_r0_rwl u_t027_008/r0_r1_rwl
+ u_t027_008/r1_w0_wl u_t027_008/r1_w1_wl u_t027_008/r1_r0_rwl u_t027_008/r1_r1_rwl
+ u_t027_008/r2_w0_wl u_t027_008/r2_w1_wl u_t027_008/r2_r0_rwl u_t027_008/r2_r1_rwl
+ u_t027_008/r3_w0_wl u_t027_008/r3_w1_wl u_t027_008/r3_r0_rwl u_t027_008/r3_r1_rwl
+ VSS u_t027_009/VSS u_t027_008/m2_717_1265# u_t027_008/m2_603_2031# u_t027_008/m2_1290_336#
+ u_t027_008/m2_2000_2037# u_t027_008/m2_791_2909# u_t027_008/m2_7_2126# u_t027_008/m2_2154_2081#
+ u_t027_008/m2_1795_2037# u_t027_008/m2_871_303# u_t027_008/m2_431_438# u_t027_008/m2_1290_2898#
+ u_t027_008/m2_1714_1210# u_t027_008/m2_431_1982# u_t027_008/m2_512_1265# u_t027_008/m2_2573_2126#
+ u_t027_008/m2_603_1259# u_t027_008/m2_2074_2909# u_t027_008/m2_7_336# u_t027_008/m2_717_2037#
+ u_t027_008/m2_1886_2031# u_t027_008/m2_2573_336# u_t027_008/m2_7_2898# u_t027_008/m2_2000_1265#
+ u_t027_008/m2_512_2037# u_t027_008/m2_1795_1265# u_t027_008/m2_1714_1982# u_t027_008/m2_1886_1259#
+ u_t027_008/m2_1290_2126# u_t027_008/m2_1714_438# u_t027_008/m2_431_1210# u_t027_008/m2_2573_2898#
+ u_t027_008/m2_2154_303# u_t027_008/m2_871_2081# VSUBS detronyx_12t_2w2r_rc4_4x4_routed_5layer_direct
Xgf180mcu_as_sc_mcu7t3v3__inv_2_881 VSS VSS VSS VSS gf180mcu_as_sc_mcu7t3v3__inv_2_933/VNW
+ VSUBS gf180mcu_as_sc_mcu7t3v3__inv_2
Xgf180mcu_as_sc_mcu7t3v3__inv_2_870 VSS VSS VSS VSS gf180mcu_as_sc_mcu7t3v3__inv_2_929/VNW
+ VSUBS gf180mcu_as_sc_mcu7t3v3__inv_2
Xgf180mcu_as_sc_mcu7t3v3__inv_2_892 VSS VSS VSS VSS gf180mcu_as_sc_mcu7t3v3__inv_2_925/VNW
+ VSUBS gf180mcu_as_sc_mcu7t3v3__inv_2
Xu_t018_008 u_t018_008/c0_w0_bl u_t018_008/c0_w0_br u_t018_008/c0_w1_bl u_t018_008/c0_w1_br
+ u_t018_008/c0_r0_rbl u_t018_008/c0_r1_rbl u_t018_008/c1_w0_bl u_t018_008/c1_w0_br
+ u_t018_008/c1_w1_bl u_t018_008/c1_w1_br u_t018_008/c1_r0_rbl u_t018_008/c1_r1_rbl
+ u_t018_008/c2_w0_bl u_t018_008/c2_w0_br u_t018_008/c2_w1_bl u_t018_008/c2_w1_br
+ u_t018_008/c2_r0_rbl u_t018_008/c2_r1_rbl u_t018_008/c3_w0_bl u_t018_008/c3_w0_br
+ u_t018_008/c3_w1_bl u_t018_008/c3_w1_br u_t018_008/c3_r0_rbl u_t018_008/c3_r1_rbl
+ u_t018_008/r0_w0_wl u_t018_008/r0_w1_wl u_t018_008/r0_r0_rwl u_t018_008/r0_r1_rwl
+ u_t018_008/r1_w0_wl u_t018_008/r1_w1_wl u_t018_008/r1_r0_rwl u_t018_008/r1_r1_rwl
+ u_t018_008/r2_w0_wl u_t018_008/r2_w1_wl u_t018_008/r2_r0_rwl u_t018_008/r2_r1_rwl
+ u_t018_008/r3_w0_wl u_t018_008/r3_w1_wl u_t018_008/r3_r0_rwl u_t018_008/r3_r1_rwl
+ VSS u_t018_009/VSS u_t018_008/m2_717_1265# u_t018_008/m2_603_2031# u_t018_008/m2_1290_336#
+ u_t018_008/m2_2000_2037# u_t018_008/m2_791_2909# u_t018_008/m2_7_2126# u_t018_008/m2_2154_2081#
+ u_t018_008/m2_1795_2037# u_t018_008/m2_871_303# u_t018_008/m2_431_438# u_t018_008/m2_1290_2898#
+ u_t018_008/m2_1714_1210# u_t018_008/m2_431_1982# u_t018_008/m2_512_1265# u_t018_008/m2_2573_2126#
+ u_t018_008/m2_603_1259# u_t018_008/m2_2074_2909# u_t018_008/m2_7_336# u_t018_008/m2_717_2037#
+ u_t018_008/m2_1886_2031# u_t018_008/m2_2573_336# u_t018_008/m2_7_2898# u_t018_008/m2_2000_1265#
+ u_t018_008/m2_512_2037# u_t018_008/m2_1795_1265# u_t018_008/m2_1714_1982# u_t018_008/m2_1886_1259#
+ u_t018_008/m2_1290_2126# u_t018_008/m2_1714_438# u_t018_008/m2_431_1210# u_t018_008/m2_2573_2898#
+ u_t018_008/m2_2154_303# u_t018_008/m2_871_2081# VSUBS detronyx_12t_2w2r_rc4_4x4_routed_5layer_direct
Xgf180mcu_as_sc_mcu7t3v3__nand4_2_180 VSS VSS VSS VSS VSS VSS VSS gf180mcu_as_sc_mcu7t3v3__inv_2_650/VNW
+ VSUBS gf180mcu_as_sc_mcu7t3v3__nand4_2
Xgf180mcu_as_sc_mcu7t3v3__nand4_2_191 VSS VSS VSS VSS VSS VSS VSS gf180mcu_as_sc_mcu7t3v3__inv_2_736/VNW
+ VSUBS gf180mcu_as_sc_mcu7t3v3__nand4_2
Xu_t009_008 u_t009_008/c0_w0_bl u_t009_008/c0_w0_br u_t009_008/c0_w1_bl u_t009_008/c0_w1_br
+ u_t009_008/c0_r0_rbl u_t009_008/c0_r1_rbl u_t009_008/c1_w0_bl u_t009_008/c1_w0_br
+ u_t009_008/c1_w1_bl u_t009_008/c1_w1_br u_t009_008/c1_r0_rbl u_t009_008/c1_r1_rbl
+ u_t009_008/c2_w0_bl u_t009_008/c2_w0_br u_t009_008/c2_w1_bl u_t009_008/c2_w1_br
+ u_t009_008/c2_r0_rbl u_t009_008/c2_r1_rbl u_t009_008/c3_w0_bl u_t009_008/c3_w0_br
+ u_t009_008/c3_w1_bl u_t009_008/c3_w1_br u_t009_008/c3_r0_rbl u_t009_008/c3_r1_rbl
+ u_t009_008/r0_w0_wl u_t009_008/r0_w1_wl u_t009_008/r0_r0_rwl u_t009_008/r0_r1_rwl
+ u_t009_008/r1_w0_wl u_t009_008/r1_w1_wl u_t009_008/r1_r0_rwl u_t009_008/r1_r1_rwl
+ u_t009_008/r2_w0_wl u_t009_008/r2_w1_wl u_t009_008/r2_r0_rwl u_t009_008/r2_r1_rwl
+ u_t009_008/r3_w0_wl u_t009_008/r3_w1_wl u_t009_008/r3_r0_rwl u_t009_008/r3_r1_rwl
+ VSS VSS u_t009_008/m2_717_1265# u_t009_008/m2_603_2031# u_t009_008/m2_1290_336#
+ u_t009_008/m2_2000_2037# u_t009_008/m2_791_2909# u_t009_008/m2_7_2126# u_t009_008/m2_2154_2081#
+ u_t009_008/m2_1795_2037# u_t009_008/m2_871_303# u_t009_008/m2_431_438# u_t009_008/m2_1290_2898#
+ u_t009_008/m2_1714_1210# u_t009_008/m2_431_1982# u_t009_008/m2_512_1265# u_t009_008/m2_2573_2126#
+ u_t009_008/m2_603_1259# u_t009_008/m2_2074_2909# u_t009_008/m2_7_336# u_t009_008/m2_717_2037#
+ u_t009_008/m2_1886_2031# u_t009_008/m2_2573_336# u_t009_008/m2_7_2898# u_t009_008/m2_2000_1265#
+ u_t009_008/m2_512_2037# u_t009_008/m2_1795_1265# u_t009_008/m2_1714_1982# u_t009_008/m2_1886_1259#
+ u_t009_008/m2_1290_2126# u_t009_008/m2_1714_438# u_t009_008/m2_431_1210# u_t009_008/m2_2573_2898#
+ u_t009_008/m2_2154_303# u_t009_008/m2_871_2081# VSUBS detronyx_12t_2w2r_rc4_4x4_routed_5layer_direct
Xgf180mcu_as_sc_mcu7t3v3__inv_2_100 VSS gf180mcu_as_sc_mcu7t3v3__inv_2_99/VSS gf180mcu_as_sc_mcu7t3v3__inv_2_100/Y
+ VSS gf180mcu_as_sc_mcu7t3v3__inv_2_99/VNW VSUBS gf180mcu_as_sc_mcu7t3v3__inv_2
Xgf180mcu_as_sc_mcu7t3v3__inv_2_155 VSS VSS VSS VSS gf180mcu_as_sc_mcu7t3v3__inv_2_155/VNW
+ VSUBS gf180mcu_as_sc_mcu7t3v3__inv_2
Xgf180mcu_as_sc_mcu7t3v3__inv_2_144 gf180mcu_as_sc_mcu7t3v3__inv_2_146/VDD VSS gf180mcu_as_sc_mcu7t3v3__inv_2_144/Y
+ VSS gf180mcu_as_sc_mcu7t3v3__inv_2_146/VNW VSUBS gf180mcu_as_sc_mcu7t3v3__inv_2
Xgf180mcu_as_sc_mcu7t3v3__inv_2_133 gf180mcu_as_sc_mcu7t3v3__inv_2_134/VDD gf180mcu_as_sc_mcu7t3v3__inv_2_137/VDD
+ gf180mcu_as_sc_mcu7t3v3__inv_2_133/Y VSS gf180mcu_as_sc_mcu7t3v3__inv_2_134/VNW
+ VSUBS gf180mcu_as_sc_mcu7t3v3__inv_2
Xgf180mcu_as_sc_mcu7t3v3__inv_2_122 gf180mcu_as_sc_mcu7t3v3__inv_2_122/VDD gf180mcu_as_sc_mcu7t3v3__inv_2_125/VDD
+ gf180mcu_as_sc_mcu7t3v3__inv_2_122/Y VSS gf180mcu_as_sc_mcu7t3v3__inv_2_122/VNW
+ VSUBS gf180mcu_as_sc_mcu7t3v3__inv_2
Xgf180mcu_as_sc_mcu7t3v3__inv_2_111 gf180mcu_as_sc_mcu7t3v3__inv_2_113/VDD gf180mcu_as_sc_mcu7t3v3__inv_2_116/VDD
+ gf180mcu_as_sc_mcu7t3v3__inv_2_111/Y VSS gf180mcu_as_sc_mcu7t3v3__inv_2_113/VNW
+ VSUBS gf180mcu_as_sc_mcu7t3v3__inv_2
Xgf180mcu_as_sc_mcu7t3v3__inv_2_166 VSS gf180mcu_as_sc_mcu7t3v3__inv_2_171/VDD gf180mcu_as_sc_mcu7t3v3__inv_2_166/Y
+ VSS gf180mcu_as_sc_mcu7t3v3__inv_2_168/VNW VSUBS gf180mcu_as_sc_mcu7t3v3__inv_2
Xgf180mcu_as_sc_mcu7t3v3__inv_2_199 VSS VSS VSS VSS gf180mcu_as_sc_mcu7t3v3__inv_2_200/VNW
+ VSUBS gf180mcu_as_sc_mcu7t3v3__inv_2
Xgf180mcu_as_sc_mcu7t3v3__inv_2_188 gf180mcu_as_sc_mcu7t3v3__inv_2_190/VDD gf180mcu_as_sc_mcu7t3v3__inv_2_193/VDD
+ gf180mcu_as_sc_mcu7t3v3__inv_2_188/Y VSS gf180mcu_as_sc_mcu7t3v3__inv_2_190/VNW
+ VSUBS gf180mcu_as_sc_mcu7t3v3__inv_2
Xgf180mcu_as_sc_mcu7t3v3__inv_2_177 gf180mcu_as_sc_mcu7t3v3__inv_2_177/VDD gf180mcu_as_sc_mcu7t3v3__inv_2_177/VSS
+ VSS VSS gf180mcu_as_sc_mcu7t3v3__inv_2_177/VNW VSUBS gf180mcu_as_sc_mcu7t3v3__inv_2
Xu_t023_011 u_t023_011/c0_w0_bl u_t023_011/c0_w0_br u_t023_011/c0_w1_bl u_t023_011/c0_w1_br
+ u_t023_011/c0_r0_rbl u_t023_011/c0_r1_rbl u_t023_011/c1_w0_bl u_t023_011/c1_w0_br
+ u_t023_011/c1_w1_bl u_t023_011/c1_w1_br u_t023_011/c1_r0_rbl u_t023_011/c1_r1_rbl
+ u_t023_011/c2_w0_bl u_t023_011/c2_w0_br u_t023_011/c2_w1_bl u_t023_011/c2_w1_br
+ u_t023_011/c2_r0_rbl u_t023_011/c2_r1_rbl u_t023_011/c3_w0_bl u_t023_011/c3_w0_br
+ u_t023_011/c3_w1_bl u_t023_011/c3_w1_br u_t023_011/c3_r0_rbl u_t023_011/c3_r1_rbl
+ u_t023_011/r0_w0_wl u_t023_011/r0_w1_wl u_t023_011/r0_r0_rwl u_t023_011/r0_r1_rwl
+ u_t023_011/r1_w0_wl u_t023_011/r1_w1_wl u_t023_011/r1_r0_rwl u_t023_011/r1_r1_rwl
+ u_t023_011/r2_w0_wl u_t023_011/r2_w1_wl u_t023_011/r2_r0_rwl u_t023_011/r2_r1_rwl
+ u_t023_011/r3_w0_wl u_t023_011/r3_w1_wl u_t023_011/r3_r0_rwl u_t023_011/r3_r1_rwl
+ u_t023_011/VDD u_t023_011/VSS u_t023_011/m2_717_1265# u_t023_011/m2_603_2031# u_t023_011/m2_1290_336#
+ u_t023_011/m2_2000_2037# u_t023_011/m2_791_2909# u_t023_011/m2_7_2126# u_t023_011/m2_2154_2081#
+ u_t023_011/m2_1795_2037# u_t023_011/m2_871_303# u_t023_011/m2_431_438# u_t023_011/m2_1290_2898#
+ u_t023_011/m2_1714_1210# u_t023_011/m2_431_1982# u_t023_011/m2_512_1265# u_t023_011/m2_2573_2126#
+ u_t023_011/m2_603_1259# u_t023_011/m2_2074_2909# u_t023_011/m2_7_336# u_t023_011/m2_717_2037#
+ u_t023_011/m2_1886_2031# u_t023_011/m2_2573_336# u_t023_011/m2_7_2898# u_t023_011/m2_2000_1265#
+ u_t023_011/m2_512_2037# u_t023_011/m2_1795_1265# u_t023_011/m2_1714_1982# u_t023_011/m2_1886_1259#
+ u_t023_011/m2_1290_2126# u_t023_011/m2_1714_438# u_t023_011/m2_431_1210# u_t023_011/m2_2573_2898#
+ u_t023_011/m2_2154_303# u_t023_011/m2_871_2081# VSUBS detronyx_12t_2w2r_rc4_4x4_routed_5layer_direct
Xu_t023_000 VSS u_t023_000/c0_w0_br VSS u_t023_000/c0_w1_br u_t023_000/c0_r0_rbl u_t023_000/c0_r1_rbl
+ VSS VSS VSS VSS VSS VSS u_t023_000/c2_w0_bl u_t023_000/c2_w0_br u_t023_000/c2_w1_bl
+ u_t023_000/c2_w1_br u_t023_000/c2_r0_rbl u_t023_000/c2_r1_rbl u_t023_000/c3_w0_bl
+ u_t023_000/c3_w0_br u_t023_000/c3_w1_bl u_t023_000/c3_w1_br u_t023_000/c3_r0_rbl
+ u_t023_000/c3_r1_rbl VSS VSS VSS VSS VSS VSS VSS VSS VSS VSS VSS VSS VSS VSS VSS
+ VSS VSS VSS u_t023_000/m2_717_1265# VSS VSS VSS VSS VSS VSS VSS VSS VSS VSS VSS
+ VSS u_t023_000/m2_512_1265# u_t023_000/m2_2573_2126# VSS VSS VSS VSS VSS u_t023_000/m2_2573_336#
+ VSS u_t023_000/m2_2000_1265# VSS u_t023_000/m2_1795_1265# VSS VSS VSS VSS VSS u_t023_000/m2_2573_2898#
+ VSS VSS VSUBS detronyx_12t_2w2r_rc4_4x4_routed_5layer_direct
Xgf180mcu_as_sc_mcu7t3v3__nand2_2_23 gf180mcu_as_sc_mcu7t3v3__nor2_2_7/VDD gf180mcu_as_sc_mcu7t3v3__nand3_2_4/VSS
+ VSS VSS VSS gf180mcu_as_sc_mcu7t3v3__nor2_2_7/VNW VSUBS gf180mcu_as_sc_mcu7t3v3__nand2_2
Xgf180mcu_as_sc_mcu7t3v3__nand2_2_12 gf180mcu_as_sc_mcu7t3v3__nor2_2_4/VDD gf180mcu_as_sc_mcu7t3v3__nor2_2_4/VSS
+ VSS VSS VSS gf180mcu_as_sc_mcu7t3v3__nor2_2_4/VNW VSUBS gf180mcu_as_sc_mcu7t3v3__nand2_2
Xu_t014_011 u_t014_011/c0_w0_bl u_t014_011/c0_w0_br u_t014_011/c0_w1_bl u_t014_011/c0_w1_br
+ u_t014_011/c0_r0_rbl u_t014_011/c0_r1_rbl u_t014_011/c1_w0_bl u_t014_011/c1_w0_br
+ u_t014_011/c1_w1_bl u_t014_011/c1_w1_br u_t014_011/c1_r0_rbl u_t014_011/c1_r1_rbl
+ u_t014_011/c2_w0_bl u_t014_011/c2_w0_br u_t014_011/c2_w1_bl u_t014_011/c2_w1_br
+ u_t014_011/c2_r0_rbl u_t014_011/c2_r1_rbl u_t014_011/c3_w0_bl u_t014_011/c3_w0_br
+ u_t014_011/c3_w1_bl u_t014_011/c3_w1_br u_t014_011/c3_r0_rbl u_t014_011/c3_r1_rbl
+ u_t014_011/r0_w0_wl u_t014_011/r0_w1_wl u_t014_011/r0_r0_rwl u_t014_011/r0_r1_rwl
+ u_t014_011/r1_w0_wl u_t014_011/r1_w1_wl u_t014_011/r1_r0_rwl u_t014_011/r1_r1_rwl
+ u_t014_011/r2_w0_wl u_t014_011/r2_w1_wl u_t014_011/r2_r0_rwl u_t014_011/r2_r1_rwl
+ u_t014_011/r3_w0_wl u_t014_011/r3_w1_wl u_t014_011/r3_r0_rwl u_t014_011/r3_r1_rwl
+ u_t014_011/VDD u_t014_011/VSS u_t014_011/m2_717_1265# u_t014_011/m2_603_2031# u_t014_011/m2_1290_336#
+ u_t014_011/m2_2000_2037# u_t014_011/m2_791_2909# u_t014_011/m2_7_2126# u_t014_011/m2_2154_2081#
+ u_t014_011/m2_1795_2037# u_t014_011/m2_871_303# u_t014_011/m2_431_438# u_t014_011/m2_1290_2898#
+ u_t014_011/m2_1714_1210# u_t014_011/m2_431_1982# u_t014_011/m2_512_1265# u_t014_011/m2_2573_2126#
+ u_t014_011/m2_603_1259# u_t014_011/m2_2074_2909# u_t014_011/m2_7_336# u_t014_011/m2_717_2037#
+ u_t014_011/m2_1886_2031# u_t014_011/m2_2573_336# u_t014_011/m2_7_2898# u_t014_011/m2_2000_1265#
+ u_t014_011/m2_512_2037# u_t014_011/m2_1795_1265# u_t014_011/m2_1714_1982# u_t014_011/m2_1886_1259#
+ u_t014_011/m2_1290_2126# u_t014_011/m2_1714_438# u_t014_011/m2_431_1210# u_t014_011/m2_2573_2898#
+ u_t014_011/m2_2154_303# u_t014_011/m2_871_2081# VSUBS detronyx_12t_2w2r_rc4_4x4_routed_5layer_direct
Xgf180mcu_as_sc_mcu7t3v3__nand2_2_34 gf180mcu_as_sc_mcu7t3v3__nor2_2_9/VDD gf180mcu_as_sc_mcu7t3v3__nand3_2_63/VSS
+ VSS VSS VSS gf180mcu_as_sc_mcu7t3v3__nor2_2_9/VNW VSUBS gf180mcu_as_sc_mcu7t3v3__nand2_2
Xgf180mcu_as_sc_mcu7t3v3__nand2_2_45 gf180mcu_as_sc_mcu7t3v3__nand3_2_65/VDD gf180mcu_as_sc_mcu7t3v3__nand3_2_62/VSS
+ VSS VSS VSS gf180mcu_as_sc_mcu7t3v3__nand3_2_65/VNW VSUBS gf180mcu_as_sc_mcu7t3v3__nand2_2
Xu_t014_000 VSS u_t014_000/c0_w0_br VSS u_t014_000/c0_w1_br u_t014_000/c0_r0_rbl u_t014_000/c0_r1_rbl
+ VSS VSS VSS VSS VSS VSS u_t014_000/c2_w0_bl u_t014_000/c2_w0_br u_t014_000/c2_w1_bl
+ u_t014_000/c2_w1_br u_t014_000/c2_r0_rbl u_t014_000/c2_r1_rbl u_t014_000/c3_w0_bl
+ u_t014_000/c3_w0_br u_t014_000/c3_w1_bl u_t014_000/c3_w1_br u_t014_000/c3_r0_rbl
+ u_t014_000/c3_r1_rbl VSS VSS VSS VSS VSS VSS VSS VSS VSS VSS VSS VSS VSS VSS VSS
+ VSS VSS VSS u_t014_000/m2_717_1265# u_t014_000/m2_603_2031# u_t014_000/m2_1290_336#
+ u_t014_000/m2_2000_2037# u_t014_000/m2_791_2909# u_t014_000/m2_7_2126# u_t014_000/m2_2154_2081#
+ u_t014_000/m2_1795_2037# u_t014_000/m2_871_303# u_t014_000/m2_431_438# u_t014_000/m2_1290_2898#
+ u_t014_000/m2_1714_1210# u_t014_000/m2_431_1982# u_t014_000/m2_512_1265# u_t014_000/m2_2573_2126#
+ u_t014_000/m2_603_1259# u_t014_000/m2_2074_2909# u_t014_000/m2_7_336# u_t014_000/m2_717_2037#
+ u_t014_000/m2_1886_2031# u_t014_000/m2_2573_336# u_t014_000/m2_7_2898# u_t014_000/m2_2000_1265#
+ u_t014_000/m2_512_2037# u_t014_000/m2_1795_1265# u_t014_000/m2_1714_1982# u_t014_000/m2_1886_1259#
+ u_t014_000/m2_1290_2126# u_t014_000/m2_1714_438# u_t014_000/m2_431_1210# u_t014_000/m2_2573_2898#
+ u_t014_000/m2_2154_303# u_t014_000/m2_871_2081# VSUBS detronyx_12t_2w2r_rc4_4x4_routed_5layer_direct
Xu_t005_011 u_t005_011/c0_w0_bl u_t005_011/c0_w0_br u_t005_011/c0_w1_bl u_t005_011/c0_w1_br
+ u_t005_011/c0_r0_rbl u_t005_011/c0_r1_rbl u_t005_011/c1_w0_bl u_t005_011/c1_w0_br
+ u_t005_011/c1_w1_bl u_t005_011/c1_w1_br u_t005_011/c1_r0_rbl u_t005_011/c1_r1_rbl
+ u_t005_011/c2_w0_bl u_t005_011/c2_w0_br u_t005_011/c2_w1_bl u_t005_011/c2_w1_br
+ u_t005_011/c2_r0_rbl u_t005_011/c2_r1_rbl u_t005_011/c3_w0_bl u_t005_011/c3_w0_br
+ u_t005_011/c3_w1_bl u_t005_011/c3_w1_br u_t005_011/c3_r0_rbl u_t005_011/c3_r1_rbl
+ u_t005_011/r0_w0_wl u_t005_011/r0_w1_wl u_t005_011/r0_r0_rwl u_t005_011/r0_r1_rwl
+ u_t005_011/r1_w0_wl u_t005_011/r1_w1_wl u_t005_011/r1_r0_rwl u_t005_011/r1_r1_rwl
+ u_t005_011/r2_w0_wl u_t005_011/r2_w1_wl u_t005_011/r2_r0_rwl u_t005_011/r2_r1_rwl
+ u_t005_011/r3_w0_wl u_t005_011/r3_w1_wl u_t005_011/r3_r0_rwl u_t005_011/r3_r1_rwl
+ u_t005_011/VDD VSS u_t005_011/m2_717_1265# u_t005_011/m2_603_2031# u_t005_011/m2_1290_336#
+ u_t005_011/m2_2000_2037# u_t005_011/m2_791_2909# u_t005_011/m2_7_2126# u_t005_011/m2_2154_2081#
+ u_t005_011/m2_1795_2037# u_t005_011/m2_871_303# u_t005_011/m2_431_438# u_t005_011/m2_1290_2898#
+ u_t005_011/m2_1714_1210# u_t005_011/m2_431_1982# u_t005_011/m2_512_1265# u_t005_011/m2_2573_2126#
+ u_t005_011/m2_603_1259# u_t005_011/m2_2074_2909# u_t005_011/m2_7_336# u_t005_011/m2_717_2037#
+ u_t005_011/m2_1886_2031# u_t005_011/m2_2573_336# u_t005_011/m2_7_2898# u_t005_011/m2_2000_1265#
+ u_t005_011/m2_512_2037# u_t005_011/m2_1795_1265# u_t005_011/m2_1714_1982# u_t005_011/m2_1886_1259#
+ u_t005_011/m2_1290_2126# u_t005_011/m2_1714_438# u_t005_011/m2_431_1210# u_t005_011/m2_2573_2898#
+ u_t005_011/m2_2154_303# u_t005_011/m2_871_2081# VSUBS detronyx_12t_2w2r_rc4_4x4_routed_5layer_direct
Xu_t005_000 VSS u_t005_000/c0_w0_br VSS u_t005_000/c0_w1_br u_t005_000/c0_r0_rbl u_t005_000/c0_r1_rbl
+ VSS VSS VSS VSS VSS VSS u_t005_000/c2_w0_bl u_t005_000/c2_w0_br u_t005_000/c2_w1_bl
+ u_t005_000/c2_w1_br u_t005_000/c2_r0_rbl u_t005_000/c2_r1_rbl u_t005_000/c3_w0_bl
+ u_t005_000/c3_w0_br u_t005_000/c3_w1_bl u_t005_000/c3_w1_br u_t005_000/c3_r0_rbl
+ u_t005_000/c3_r1_rbl VSS VSS VSS VSS VSS VSS VSS VSS VSS VSS VSS VSS VSS VSS VSS
+ VSS VSS VSS u_t005_000/m2_717_1265# u_t005_000/m2_603_2031# u_t005_000/m2_1290_336#
+ u_t005_000/m2_2000_2037# u_t005_000/m2_791_2909# u_t005_000/m2_7_2126# u_t005_000/m2_2154_2081#
+ u_t005_000/m2_1795_2037# u_t005_000/m2_871_303# u_t005_000/m2_431_438# u_t005_000/m2_1290_2898#
+ u_t005_000/m2_1714_1210# u_t005_000/m2_431_1982# u_t005_000/m2_512_1265# u_t005_000/m2_2573_2126#
+ u_t005_000/m2_603_1259# u_t005_000/m2_2074_2909# u_t005_000/m2_7_336# u_t005_000/m2_717_2037#
+ u_t005_000/m2_1886_2031# u_t005_000/m2_2573_336# u_t005_000/m2_7_2898# u_t005_000/m2_2000_1265#
+ u_t005_000/m2_512_2037# u_t005_000/m2_1795_1265# u_t005_000/m2_1714_1982# u_t005_000/m2_1886_1259#
+ u_t005_000/m2_1290_2126# u_t005_000/m2_1714_438# u_t005_000/m2_431_1210# u_t005_000/m2_2573_2898#
+ u_t005_000/m2_2154_303# u_t005_000/m2_871_2081# VSUBS detronyx_12t_2w2r_rc4_4x4_routed_5layer_direct
Xu_t020_014 u_t020_014/c0_w0_bl u_t020_014/c0_w0_br u_t020_014/c0_w1_bl u_t020_014/c0_w1_br
+ u_t020_014/c0_r0_rbl u_t020_014/c0_r1_rbl u_t020_014/c1_w0_bl u_t020_014/c1_w0_br
+ u_t020_014/c1_w1_bl u_t020_014/c1_w1_br u_t020_014/c1_r0_rbl u_t020_014/c1_r1_rbl
+ u_t020_014/c2_w0_bl u_t020_014/c2_w0_br u_t020_014/c2_w1_bl u_t020_014/c2_w1_br
+ u_t020_014/c2_r0_rbl u_t020_014/c2_r1_rbl u_t020_014/c3_w0_bl u_t020_014/c3_w0_br
+ u_t020_014/c3_w1_bl u_t020_014/c3_w1_br u_t020_014/c3_r0_rbl u_t020_014/c3_r1_rbl
+ u_t020_014/r0_w0_wl u_t020_014/r0_w1_wl u_t020_014/r0_r0_rwl u_t020_014/r0_r1_rwl
+ u_t020_014/r1_w0_wl u_t020_014/r1_w1_wl u_t020_014/r1_r0_rwl u_t020_014/r1_r1_rwl
+ u_t020_014/r2_w0_wl u_t020_014/r2_w1_wl u_t020_014/r2_r0_rwl u_t020_014/r2_r1_rwl
+ u_t020_014/r3_w0_wl u_t020_014/r3_w1_wl u_t020_014/r3_r0_rwl u_t020_014/r3_r1_rwl
+ u_t020_014/VDD u_t020_015/VSS u_t020_014/m2_717_1265# u_t020_014/m2_603_2031# u_t020_014/m2_1290_336#
+ u_t020_014/m2_2000_2037# u_t020_014/m2_791_2909# u_t020_014/m2_7_2126# u_t020_014/m2_2154_2081#
+ u_t020_014/m2_1795_2037# u_t020_014/m2_871_303# u_t020_014/m2_431_438# u_t020_014/m2_1290_2898#
+ u_t020_014/m2_1714_1210# u_t020_014/m2_431_1982# u_t020_014/m2_512_1265# u_t020_014/m2_2573_2126#
+ u_t020_014/m2_603_1259# u_t020_014/m2_2074_2909# u_t020_014/m2_7_336# u_t020_014/m2_717_2037#
+ u_t020_014/m2_1886_2031# u_t020_014/m2_2573_336# u_t020_014/m2_7_2898# u_t020_014/m2_2000_1265#
+ u_t020_014/m2_512_2037# u_t020_014/m2_1795_1265# u_t020_014/m2_1714_1982# u_t020_014/m2_1886_1259#
+ u_t020_014/m2_1290_2126# u_t020_014/m2_1714_438# u_t020_014/m2_431_1210# u_t020_014/m2_2573_2898#
+ u_t020_014/m2_2154_303# u_t020_014/m2_871_2081# VSUBS detronyx_12t_2w2r_rc4_4x4_routed_5layer_direct
Xu_t020_003 u_t020_003/c0_w0_bl u_t020_003/c0_w0_br u_t020_003/c0_w1_bl u_t020_003/c0_w1_br
+ u_t020_003/c0_r0_rbl u_t020_003/c0_r1_rbl u_t020_003/c1_w0_bl u_t020_003/c1_w0_br
+ u_t020_003/c1_w1_bl u_t020_003/c1_w1_br u_t020_003/c1_r0_rbl u_t020_003/c1_r1_rbl
+ u_t020_003/c2_w0_bl u_t020_003/c2_w0_br u_t020_003/c2_w1_bl u_t020_003/c2_w1_br
+ u_t020_003/c2_r0_rbl u_t020_003/c2_r1_rbl u_t020_003/c3_w0_bl u_t020_003/c3_w0_br
+ u_t020_003/c3_w1_bl u_t020_003/c3_w1_br u_t020_003/c3_r0_rbl u_t020_003/c3_r1_rbl
+ u_t020_003/r0_w0_wl u_t020_003/r0_w1_wl u_t020_003/r0_r0_rwl u_t020_003/r0_r1_rwl
+ u_t020_003/r1_w0_wl u_t020_003/r1_w1_wl u_t020_003/r1_r0_rwl u_t020_003/r1_r1_rwl
+ u_t020_003/r2_w0_wl u_t020_003/r2_w1_wl u_t020_003/r2_r0_rwl u_t020_003/r2_r1_rwl
+ u_t020_003/r3_w0_wl u_t020_003/r3_w1_wl u_t020_003/r3_r0_rwl u_t020_003/r3_r1_rwl
+ u_t020_003/VDD u_t020_003/VSS u_t020_003/m2_717_1265# u_t020_003/m2_603_2031# u_t020_003/m2_1290_336#
+ u_t020_003/m2_2000_2037# u_t020_003/m2_791_2909# u_t020_003/m2_7_2126# u_t020_003/m2_2154_2081#
+ u_t020_003/m2_1795_2037# u_t020_003/m2_871_303# u_t020_003/m2_431_438# u_t020_003/m2_1290_2898#
+ u_t020_003/m2_1714_1210# u_t020_003/m2_431_1982# u_t020_003/m2_512_1265# u_t020_003/m2_2573_2126#
+ u_t020_003/m2_603_1259# u_t020_003/m2_2074_2909# u_t020_003/m2_7_336# u_t020_003/m2_717_2037#
+ u_t020_003/m2_1886_2031# u_t020_003/m2_2573_336# u_t020_003/m2_7_2898# u_t020_003/m2_2000_1265#
+ u_t020_003/m2_512_2037# u_t020_003/m2_1795_1265# u_t020_003/m2_1714_1982# u_t020_003/m2_1886_1259#
+ u_t020_003/m2_1290_2126# u_t020_003/m2_1714_438# u_t020_003/m2_431_1210# u_t020_003/m2_2573_2898#
+ u_t020_003/m2_2154_303# u_t020_003/m2_871_2081# VSUBS detronyx_12t_2w2r_rc4_4x4_routed_5layer_direct
Xgf180mcu_as_sc_mcu7t3v3__inv_2_1407 gf180mcu_as_sc_mcu7t3v3__inv_2_1409/VDD gf180mcu_as_sc_mcu7t3v3__inv_2_1409/VSS
+ gf180mcu_as_sc_mcu7t3v3__inv_2_1407/Y gf180mcu_as_sc_mcu7t3v3__inv_2_1409/A gf180mcu_as_sc_mcu7t3v3__inv_2_1409/VNW
+ VSUBS gf180mcu_as_sc_mcu7t3v3__inv_2
Xgf180mcu_as_sc_mcu7t3v3__inv_2_1418 VSS VSS VSS VSS gf180mcu_as_sc_mcu7t3v3__inv_2_1419/VNW
+ VSUBS gf180mcu_as_sc_mcu7t3v3__inv_2
Xgf180mcu_as_sc_mcu7t3v3__inv_2_1429 VSS gf180mcu_as_sc_mcu7t3v3__inv_2_1434/VDD VSS
+ VSS gf180mcu_as_sc_mcu7t3v3__inv_2_1431/VNW VSUBS gf180mcu_as_sc_mcu7t3v3__inv_2
Xu_t011_014 u_t011_014/c0_w0_bl u_t011_014/c0_w0_br u_t011_014/c0_w1_bl u_t011_014/c0_w1_br
+ u_t011_014/c0_r0_rbl u_t011_014/c0_r1_rbl u_t011_014/c1_w0_bl u_t011_014/c1_w0_br
+ u_t011_014/c1_w1_bl u_t011_014/c1_w1_br u_t011_014/c1_r0_rbl u_t011_014/c1_r1_rbl
+ u_t011_014/c2_w0_bl u_t011_014/c2_w0_br u_t011_014/c2_w1_bl u_t011_014/c2_w1_br
+ u_t011_014/c2_r0_rbl u_t011_014/c2_r1_rbl u_t011_014/c3_w0_bl u_t011_014/c3_w0_br
+ u_t011_014/c3_w1_bl u_t011_014/c3_w1_br u_t011_014/c3_r0_rbl u_t011_014/c3_r1_rbl
+ u_t011_014/r0_w0_wl u_t011_014/r0_w1_wl u_t011_014/r0_r0_rwl u_t011_014/r0_r1_rwl
+ u_t011_014/r1_w0_wl u_t011_014/r1_w1_wl u_t011_014/r1_r0_rwl u_t011_014/r1_r1_rwl
+ u_t011_014/r2_w0_wl u_t011_014/r2_w1_wl u_t011_014/r2_r0_rwl u_t011_014/r2_r1_rwl
+ u_t011_014/r3_w0_wl u_t011_014/r3_w1_wl u_t011_014/r3_r0_rwl u_t011_014/r3_r1_rwl
+ u_t011_014/VDD u_t011_015/VSS u_t011_014/m2_717_1265# u_t011_014/m2_603_2031# u_t011_014/m2_1290_336#
+ u_t011_014/m2_2000_2037# u_t011_014/m2_791_2909# u_t011_014/m2_7_2126# u_t011_014/m2_2154_2081#
+ u_t011_014/m2_1795_2037# u_t011_014/m2_871_303# u_t011_014/m2_431_438# u_t011_014/m2_1290_2898#
+ u_t011_014/m2_1714_1210# u_t011_014/m2_431_1982# u_t011_014/m2_512_1265# u_t011_014/m2_2573_2126#
+ u_t011_014/m2_603_1259# u_t011_014/m2_2074_2909# u_t011_014/m2_7_336# u_t011_014/m2_717_2037#
+ u_t011_014/m2_1886_2031# u_t011_014/m2_2573_336# u_t011_014/m2_7_2898# u_t011_014/m2_2000_1265#
+ u_t011_014/m2_512_2037# u_t011_014/m2_1795_1265# u_t011_014/m2_1714_1982# u_t011_014/m2_1886_1259#
+ u_t011_014/m2_1290_2126# u_t011_014/m2_1714_438# u_t011_014/m2_431_1210# u_t011_014/m2_2573_2898#
+ u_t011_014/m2_2154_303# u_t011_014/m2_871_2081# VSUBS detronyx_12t_2w2r_rc4_4x4_routed_5layer_direct
Xu_t011_003 u_t011_003/c0_w0_bl u_t011_003/c0_w0_br u_t011_003/c0_w1_bl u_t011_003/c0_w1_br
+ u_t011_003/c0_r0_rbl u_t011_003/c0_r1_rbl u_t011_003/c1_w0_bl u_t011_003/c1_w0_br
+ u_t011_003/c1_w1_bl u_t011_003/c1_w1_br u_t011_003/c1_r0_rbl u_t011_003/c1_r1_rbl
+ u_t011_003/c2_w0_bl u_t011_003/c2_w0_br u_t011_003/c2_w1_bl u_t011_003/c2_w1_br
+ u_t011_003/c2_r0_rbl u_t011_003/c2_r1_rbl u_t011_003/c3_w0_bl u_t011_003/c3_w0_br
+ u_t011_003/c3_w1_bl u_t011_003/c3_w1_br u_t011_003/c3_r0_rbl u_t011_003/c3_r1_rbl
+ u_t011_003/r0_w0_wl u_t011_003/r0_w1_wl u_t011_003/r0_r0_rwl u_t011_003/r0_r1_rwl
+ u_t011_003/r1_w0_wl u_t011_003/r1_w1_wl u_t011_003/r1_r0_rwl u_t011_003/r1_r1_rwl
+ u_t011_003/r2_w0_wl u_t011_003/r2_w1_wl u_t011_003/r2_r0_rwl u_t011_003/r2_r1_rwl
+ u_t011_003/r3_w0_wl u_t011_003/r3_w1_wl u_t011_003/r3_r0_rwl u_t011_003/r3_r1_rwl
+ u_t011_003/VDD u_t011_003/VSS u_t011_003/m2_717_1265# u_t011_003/m2_603_2031# u_t011_003/m2_1290_336#
+ u_t011_003/m2_2000_2037# u_t011_003/m2_791_2909# u_t011_003/m2_7_2126# u_t011_003/m2_2154_2081#
+ u_t011_003/m2_1795_2037# u_t011_003/m2_871_303# u_t011_003/m2_431_438# u_t011_003/m2_1290_2898#
+ u_t011_003/m2_1714_1210# u_t011_003/m2_431_1982# u_t011_003/m2_512_1265# u_t011_003/m2_2573_2126#
+ u_t011_003/m2_603_1259# u_t011_003/m2_2074_2909# u_t011_003/m2_7_336# u_t011_003/m2_717_2037#
+ u_t011_003/m2_1886_2031# u_t011_003/m2_2573_336# u_t011_003/m2_7_2898# u_t011_003/m2_2000_1265#
+ u_t011_003/m2_512_2037# u_t011_003/m2_1795_1265# u_t011_003/m2_1714_1982# u_t011_003/m2_1886_1259#
+ u_t011_003/m2_1290_2126# u_t011_003/m2_1714_438# u_t011_003/m2_431_1210# u_t011_003/m2_2573_2898#
+ u_t011_003/m2_2154_303# u_t011_003/m2_871_2081# VSUBS detronyx_12t_2w2r_rc4_4x4_routed_5layer_direct
Xu_t002_014 u_t002_014/c0_w0_bl u_t002_014/c0_w0_br u_t002_014/c0_w1_bl u_t002_014/c0_w1_br
+ u_t002_014/c0_r0_rbl u_t002_014/c0_r1_rbl u_t002_014/c1_w0_bl u_t002_014/c1_w0_br
+ u_t002_014/c1_w1_bl u_t002_014/c1_w1_br u_t002_014/c1_r0_rbl u_t002_014/c1_r1_rbl
+ u_t002_014/c2_w0_bl u_t002_014/c2_w0_br u_t002_014/c2_w1_bl u_t002_014/c2_w1_br
+ u_t002_014/c2_r0_rbl u_t002_014/c2_r1_rbl u_t002_014/c3_w0_bl u_t002_014/c3_w0_br
+ u_t002_014/c3_w1_bl u_t002_014/c3_w1_br u_t002_014/c3_r0_rbl u_t002_014/c3_r1_rbl
+ u_t002_014/r0_w0_wl u_t002_014/r0_w1_wl u_t002_014/r0_r0_rwl u_t002_014/r0_r1_rwl
+ u_t002_014/r1_w0_wl u_t002_014/r1_w1_wl u_t002_014/r1_r0_rwl u_t002_014/r1_r1_rwl
+ u_t002_014/r2_w0_wl u_t002_014/r2_w1_wl u_t002_014/r2_r0_rwl u_t002_014/r2_r1_rwl
+ u_t002_014/r3_w0_wl u_t002_014/r3_w1_wl u_t002_014/r3_r0_rwl u_t002_014/r3_r1_rwl
+ u_t002_014/VDD u_t002_015/VSS u_t002_014/m2_717_1265# u_t002_014/m2_603_2031# u_t002_014/m2_1290_336#
+ u_t002_014/m2_2000_2037# u_t002_014/m2_791_2909# u_t002_014/m2_7_2126# u_t002_014/m2_2154_2081#
+ u_t002_014/m2_1795_2037# u_t002_014/m2_871_303# u_t002_014/m2_431_438# u_t002_014/m2_1290_2898#
+ u_t002_014/m2_1714_1210# u_t002_014/m2_431_1982# u_t002_014/m2_512_1265# u_t002_014/m2_2573_2126#
+ u_t002_014/m2_603_1259# u_t002_014/m2_2074_2909# u_t002_014/m2_7_336# u_t002_014/m2_717_2037#
+ u_t002_014/m2_1886_2031# u_t002_014/m2_2573_336# u_t002_014/m2_7_2898# u_t002_014/m2_2000_1265#
+ u_t002_014/m2_512_2037# u_t002_014/m2_1795_1265# u_t002_014/m2_1714_1982# u_t002_014/m2_1886_1259#
+ u_t002_014/m2_1290_2126# u_t002_014/m2_1714_438# u_t002_014/m2_431_1210# u_t002_014/m2_2573_2898#
+ u_t002_014/m2_2154_303# u_t002_014/m2_871_2081# VSUBS detronyx_12t_2w2r_rc4_4x4_routed_5layer_direct
Xu_t002_003 u_t002_003/c0_w0_bl u_t002_003/c0_w0_br u_t002_003/c0_w1_bl u_t002_003/c0_w1_br
+ u_t002_003/c0_r0_rbl u_t002_003/c0_r1_rbl u_t002_003/c1_w0_bl u_t002_003/c1_w0_br
+ u_t002_003/c1_w1_bl u_t002_003/c1_w1_br u_t002_003/c1_r0_rbl u_t002_003/c1_r1_rbl
+ u_t002_003/c2_w0_bl u_t002_003/c2_w0_br u_t002_003/c2_w1_bl u_t002_003/c2_w1_br
+ u_t002_003/c2_r0_rbl u_t002_003/c2_r1_rbl u_t002_003/c3_w0_bl u_t002_003/c3_w0_br
+ u_t002_003/c3_w1_bl u_t002_003/c3_w1_br u_t002_003/c3_r0_rbl u_t002_003/c3_r1_rbl
+ u_t002_003/r0_w0_wl u_t002_003/r0_w1_wl u_t002_003/r0_r0_rwl u_t002_003/r0_r1_rwl
+ u_t002_003/r1_w0_wl u_t002_003/r1_w1_wl u_t002_003/r1_r0_rwl u_t002_003/r1_r1_rwl
+ u_t002_003/r2_w0_wl u_t002_003/r2_w1_wl u_t002_003/r2_r0_rwl u_t002_003/r2_r1_rwl
+ u_t002_003/r3_w0_wl u_t002_003/r3_w1_wl u_t002_003/r3_r0_rwl u_t002_003/r3_r1_rwl
+ u_t002_003/VDD u_t002_003/VSS u_t002_003/m2_717_1265# u_t002_003/m2_603_2031# u_t002_003/m2_1290_336#
+ u_t002_003/m2_2000_2037# u_t002_003/m2_791_2909# u_t002_003/m2_7_2126# u_t002_003/m2_2154_2081#
+ u_t002_003/m2_1795_2037# u_t002_003/m2_871_303# u_t002_003/m2_431_438# u_t002_003/m2_1290_2898#
+ u_t002_003/m2_1714_1210# u_t002_003/m2_431_1982# u_t002_003/m2_512_1265# u_t002_003/m2_2573_2126#
+ u_t002_003/m2_603_1259# u_t002_003/m2_2074_2909# u_t002_003/m2_7_336# u_t002_003/m2_717_2037#
+ u_t002_003/m2_1886_2031# u_t002_003/m2_2573_336# u_t002_003/m2_7_2898# u_t002_003/m2_2000_1265#
+ u_t002_003/m2_512_2037# u_t002_003/m2_1795_1265# u_t002_003/m2_1714_1982# u_t002_003/m2_1886_1259#
+ u_t002_003/m2_1290_2126# u_t002_003/m2_1714_438# u_t002_003/m2_431_1210# u_t002_003/m2_2573_2898#
+ u_t002_003/m2_2154_303# u_t002_003/m2_871_2081# VSUBS detronyx_12t_2w2r_rc4_4x4_routed_5layer_direct
Xgf180mcu_as_sc_mcu7t3v3__inv_2_1259 gf180mcu_as_sc_mcu7t3v3__nor2_2_9/VDD gf180mcu_as_sc_mcu7t3v3__nand3_2_63/VSS
+ VSS VSS gf180mcu_as_sc_mcu7t3v3__nor2_2_9/VNW VSUBS gf180mcu_as_sc_mcu7t3v3__inv_2
Xgf180mcu_as_sc_mcu7t3v3__inv_2_1248 gf180mcu_as_sc_mcu7t3v3__nand3_2_65/VDD gf180mcu_as_sc_mcu7t3v3__nor2_2_9/VSS
+ VSS VSS gf180mcu_as_sc_mcu7t3v3__nand3_2_65/VNW VSUBS gf180mcu_as_sc_mcu7t3v3__inv_2
Xgf180mcu_as_sc_mcu7t3v3__inv_2_1204 gf180mcu_as_sc_mcu7t3v3__nor2_2_9/VDD gf180mcu_as_sc_mcu7t3v3__nand3_2_63/VSS
+ VSS VSS gf180mcu_as_sc_mcu7t3v3__nor2_2_9/VNW VSUBS gf180mcu_as_sc_mcu7t3v3__inv_2
Xgf180mcu_as_sc_mcu7t3v3__inv_2_1237 gf180mcu_as_sc_mcu7t3v3__nand3_2_65/VDD gf180mcu_as_sc_mcu7t3v3__nor2_2_9/VSS
+ VSS VSS gf180mcu_as_sc_mcu7t3v3__nand3_2_65/VNW VSUBS gf180mcu_as_sc_mcu7t3v3__inv_2
Xgf180mcu_as_sc_mcu7t3v3__inv_2_1226 VSS VSS VSS VSS gf180mcu_as_sc_mcu7t3v3__inv_2_1277/VNW
+ VSUBS gf180mcu_as_sc_mcu7t3v3__inv_2
Xgf180mcu_as_sc_mcu7t3v3__inv_2_1215 VSS VSS VSS VSS gf180mcu_as_sc_mcu7t3v3__inv_2_1281/VNW
+ VSUBS gf180mcu_as_sc_mcu7t3v3__inv_2
Xgf180mcu_as_sc_mcu7t3v3__nand4_2_510 gf180mcu_as_sc_mcu7t3v3__inv_2_1717/VDD VSS
+ VSS VSS VSS VSS VSS gf180mcu_as_sc_mcu7t3v3__inv_2_1717/VNW VSUBS gf180mcu_as_sc_mcu7t3v3__nand4_2
Xgf180mcu_as_sc_mcu7t3v3__inv_2_31 gf180mcu_as_sc_mcu7t3v3__inv_2_32/VDD gf180mcu_as_sc_mcu7t3v3__inv_2_4/VDD
+ gf180mcu_as_sc_mcu7t3v3__inv_2_31/Y gf180mcu_as_sc_mcu7t3v3__inv_2_66/Y gf180mcu_as_sc_mcu7t3v3__inv_2_32/VNW
+ VSUBS gf180mcu_as_sc_mcu7t3v3__inv_2
Xgf180mcu_as_sc_mcu7t3v3__inv_2_20 gf180mcu_as_sc_mcu7t3v3__inv_2_20/VDD gf180mcu_as_sc_mcu7t3v3__inv_2_24/VDD
+ gf180mcu_as_sc_mcu7t3v3__inv_2_24/Y VSS gf180mcu_as_sc_mcu7t3v3__inv_2_20/VNW VSUBS
+ gf180mcu_as_sc_mcu7t3v3__inv_2
Xgf180mcu_as_sc_mcu7t3v3__inv_2_86 gf180mcu_as_sc_mcu7t3v3__inv_2_98/VDD VSS VSS VSS
+ gf180mcu_as_sc_mcu7t3v3__inv_2_98/VNW VSUBS gf180mcu_as_sc_mcu7t3v3__inv_2
Xgf180mcu_as_sc_mcu7t3v3__inv_2_42 VSS gf180mcu_as_sc_mcu7t3v3__inv_2_46/VDD gf180mcu_as_sc_mcu7t3v3__inv_2_9/Y
+ VSS gf180mcu_as_sc_mcu7t3v3__inv_2_42/VNW VSUBS gf180mcu_as_sc_mcu7t3v3__inv_2
Xgf180mcu_as_sc_mcu7t3v3__inv_2_75 gf180mcu_as_sc_mcu7t3v3__inv_2_9/VDD gf180mcu_as_sc_mcu7t3v3__inv_2_9/VDD
+ VSS gf180mcu_as_sc_mcu7t3v3__inv_2_9/Y gf180mcu_as_sc_mcu7t3v3__inv_2_77/VNW VSUBS
+ gf180mcu_as_sc_mcu7t3v3__inv_2
Xgf180mcu_as_sc_mcu7t3v3__inv_2_64 gf180mcu_as_sc_mcu7t3v3__inv_2_69/VDD gf180mcu_as_sc_mcu7t3v3__inv_2_69/VDD
+ gf180mcu_as_sc_mcu7t3v3__inv_2_73/Y gf180mcu_as_sc_mcu7t3v3__inv_2_73/Y gf180mcu_as_sc_mcu7t3v3__inv_2_65/VNW
+ VSUBS gf180mcu_as_sc_mcu7t3v3__inv_2
Xgf180mcu_as_sc_mcu7t3v3__inv_2_53 gf180mcu_as_sc_mcu7t3v3__inv_2_53/VDD gf180mcu_as_sc_mcu7t3v3__inv_2_57/VDD
+ gf180mcu_as_sc_mcu7t3v3__inv_2_61/Y VSS gf180mcu_as_sc_mcu7t3v3__inv_2_53/VNW VSUBS
+ gf180mcu_as_sc_mcu7t3v3__inv_2
Xgf180mcu_as_sc_mcu7t3v3__inv_2_1001 VSS VSS gf180mcu_as_sc_mcu7t3v3__inv_2_997/A
+ VSS gf180mcu_as_sc_mcu7t3v3__inv_2_997/VNW VSUBS gf180mcu_as_sc_mcu7t3v3__inv_2
Xgf180mcu_as_sc_mcu7t3v3__inv_2_1078 gf180mcu_as_sc_mcu7t3v3__inv_2_1079/VDD VSS gf180mcu_as_sc_mcu7t3v3__inv_2_1149/A
+ gf180mcu_as_sc_mcu7t3v3__inv_2_1079/Y gf180mcu_as_sc_mcu7t3v3__inv_2_1079/VNW VSUBS
+ gf180mcu_as_sc_mcu7t3v3__inv_2
Xgf180mcu_as_sc_mcu7t3v3__inv_2_1067 gf180mcu_as_sc_mcu7t3v3__inv_2_1100/VSS VSS gf180mcu_as_sc_mcu7t3v3__inv_2_1067/Y
+ VSS gf180mcu_as_sc_mcu7t3v3__inv_2_1067/VNW VSUBS gf180mcu_as_sc_mcu7t3v3__inv_2
Xgf180mcu_as_sc_mcu7t3v3__inv_2_1089 gf180mcu_as_sc_mcu7t3v3__inv_2_1091/VDD VSS VSS
+ gf180mcu_as_sc_mcu7t3v3__inv_2_1149/A gf180mcu_as_sc_mcu7t3v3__inv_2_1091/VNW VSUBS
+ gf180mcu_as_sc_mcu7t3v3__inv_2
Xgf180mcu_as_sc_mcu7t3v3__inv_2_1034 gf180mcu_as_sc_mcu7t3v3__inv_2_1036/VDD gf180mcu_as_sc_mcu7t3v3__inv_2_1036/VSS
+ VSS gf180mcu_as_sc_mcu7t3v3__inv_2_1306/Y gf180mcu_as_sc_mcu7t3v3__inv_2_1036/VNW
+ VSUBS gf180mcu_as_sc_mcu7t3v3__inv_2
Xgf180mcu_as_sc_mcu7t3v3__inv_2_1012 gf180mcu_as_sc_mcu7t3v3__inv_2_1036/VSS VSS gf180mcu_as_sc_mcu7t3v3__inv_2_1012/Y
+ VSS gf180mcu_as_sc_mcu7t3v3__inv_2_1012/VNW VSUBS gf180mcu_as_sc_mcu7t3v3__inv_2
Xgf180mcu_as_sc_mcu7t3v3__inv_2_1045 gf180mcu_as_sc_mcu7t3v3__inv_2_1049/VDD VSS gf180mcu_as_sc_mcu7t3v3__inv_2_1045/Y
+ gf180mcu_as_sc_mcu7t3v3__inv_2_1049/Y gf180mcu_as_sc_mcu7t3v3__inv_2_1049/VNW VSUBS
+ gf180mcu_as_sc_mcu7t3v3__inv_2
Xgf180mcu_as_sc_mcu7t3v3__inv_2_1056 VSS gf180mcu_as_sc_mcu7t3v3__inv_2_1058/VDD gf180mcu_as_sc_mcu7t3v3__inv_2_1056/Y
+ VSS gf180mcu_as_sc_mcu7t3v3__inv_2_1056/VNW VSUBS gf180mcu_as_sc_mcu7t3v3__inv_2
Xgf180mcu_as_sc_mcu7t3v3__inv_2_97 gf180mcu_as_sc_mcu7t3v3__inv_2_97/VDD gf180mcu_as_sc_mcu7t3v3__inv_2_98/VDD
+ gf180mcu_as_sc_mcu7t3v3__inv_2_97/Y VSS gf180mcu_as_sc_mcu7t3v3__inv_2_97/VNW VSUBS
+ gf180mcu_as_sc_mcu7t3v3__inv_2
Xgf180mcu_as_sc_mcu7t3v3__inv_2_1023 VSS gf180mcu_as_sc_mcu7t3v3__inv_2_1061/VDD gf180mcu_as_sc_mcu7t3v3__inv_2_962/A
+ gf180mcu_as_sc_mcu7t3v3__inv_2_1024/Y gf180mcu_as_sc_mcu7t3v3__inv_2_1024/VNW VSUBS
+ gf180mcu_as_sc_mcu7t3v3__inv_2
Xgf180mcu_as_sc_mcu7t3v3__inv_2_529 gf180mcu_as_sc_mcu7t3v3__nand3_2_9/VDD gf180mcu_as_sc_mcu7t3v3__nor2_2_4/VSS
+ VSS VSS gf180mcu_as_sc_mcu7t3v3__nand3_2_9/VNW VSUBS gf180mcu_as_sc_mcu7t3v3__inv_2
Xgf180mcu_as_sc_mcu7t3v3__inv_2_507 VSS VSS gf180mcu_as_sc_mcu7t3v3__inv_2_507/Y VSS
+ gf180mcu_as_sc_mcu7t3v3__inv_2_538/VNW VSUBS gf180mcu_as_sc_mcu7t3v3__inv_2
Xgf180mcu_as_sc_mcu7t3v3__inv_2_518 VSS VSS gf180mcu_as_sc_mcu7t3v3__inv_2_518/Y VSS
+ gf180mcu_as_sc_mcu7t3v3__inv_2_562/VNW VSUBS gf180mcu_as_sc_mcu7t3v3__inv_2
Xgf180mcu_as_sc_mcu7t3v3__inv_2_1590 gf180mcu_as_sc_mcu7t3v3__inv_2_1591/VDD gf180mcu_as_sc_mcu7t3v3__inv_2_1594/VDD
+ gf180mcu_as_sc_mcu7t3v3__inv_2_1590/Y VSS gf180mcu_as_sc_mcu7t3v3__inv_2_1591/VNW
+ VSUBS gf180mcu_as_sc_mcu7t3v3__inv_2
Xgf180mcu_as_sc_mcu7t3v3__nand3_2_1 gf180mcu_as_sc_mcu7t3v3__nor2_2_6/VDD gf180mcu_as_sc_mcu7t3v3__nor2_2_6/VSS
+ VSS VSS VSS VSS gf180mcu_as_sc_mcu7t3v3__nor2_2_6/VNW VSUBS gf180mcu_as_sc_mcu7t3v3__nand3_2
Xgf180mcu_as_sc_mcu7t3v3__nand4_2_340 VSS gf180mcu_as_sc_mcu7t3v3__inv_2_1148/VDD
+ VSS VSS VSS VSS VSS gf180mcu_as_sc_mcu7t3v3__inv_2_1145/VNW VSUBS gf180mcu_as_sc_mcu7t3v3__nand4_2
Xgf180mcu_as_sc_mcu7t3v3__nand4_2_351 VSS VSS VSS VSS VSS VSS gf180mcu_as_sc_mcu7t3v3__nand4_2_351/Y
+ gf180mcu_as_sc_mcu7t3v3__inv_2_1291/VNW VSUBS gf180mcu_as_sc_mcu7t3v3__nand4_2
Xgf180mcu_as_sc_mcu7t3v3__nand4_2_362 VSS VSS VSS VSS VSS VSS gf180mcu_as_sc_mcu7t3v3__nand4_2_362/Y
+ gf180mcu_as_sc_mcu7t3v3__inv_2_1288/VNW VSUBS gf180mcu_as_sc_mcu7t3v3__nand4_2
Xgf180mcu_as_sc_mcu7t3v3__nand4_2_373 VSS VSS VSS VSS VSS VSS gf180mcu_as_sc_mcu7t3v3__nand4_2_373/Y
+ gf180mcu_as_sc_mcu7t3v3__inv_2_1281/VNW VSUBS gf180mcu_as_sc_mcu7t3v3__nand4_2
Xgf180mcu_as_sc_mcu7t3v3__nand4_2_384 VSS gf180mcu_as_sc_mcu7t3v3__inv_2_1720/VDD
+ VSS VSS VSS VSS gf180mcu_as_sc_mcu7t3v3__nand4_2_384/Y gf180mcu_as_sc_mcu7t3v3__inv_2_1422/VNW
+ VSUBS gf180mcu_as_sc_mcu7t3v3__nand4_2
Xgf180mcu_as_sc_mcu7t3v3__nand4_2_395 gf180mcu_as_sc_mcu7t3v3__inv_2_1455/VDD VSS
+ VSS VSS VSS VSS VSS gf180mcu_as_sc_mcu7t3v3__inv_2_1455/VNW VSUBS gf180mcu_as_sc_mcu7t3v3__nand4_2
Xgf180mcu_as_sc_mcu7t3v3__inv_2_304 gf180mcu_as_sc_mcu7t3v3__inv_2_304/VDD gf180mcu_as_sc_mcu7t3v3__inv_2_304/VSS
+ gf180mcu_as_sc_mcu7t3v3__inv_2_304/Y gf180mcu_as_sc_mcu7t3v3__inv_2_304/A gf180mcu_as_sc_mcu7t3v3__inv_2_304/VNW
+ VSUBS gf180mcu_as_sc_mcu7t3v3__inv_2
Xgf180mcu_as_sc_mcu7t3v3__inv_2_359 VSS gf180mcu_as_sc_mcu7t3v3__inv_2_365/VDD gf180mcu_as_sc_mcu7t3v3__inv_2_359/Y
+ VSS gf180mcu_as_sc_mcu7t3v3__inv_2_359/VNW VSUBS gf180mcu_as_sc_mcu7t3v3__inv_2
Xgf180mcu_as_sc_mcu7t3v3__inv_2_348 gf180mcu_as_sc_mcu7t3v3__inv_2_350/VDD VSS VSS
+ gf180mcu_as_sc_mcu7t3v3__inv_2_350/Y gf180mcu_as_sc_mcu7t3v3__inv_2_350/VNW VSUBS
+ gf180mcu_as_sc_mcu7t3v3__inv_2
Xgf180mcu_as_sc_mcu7t3v3__inv_2_337 gf180mcu_as_sc_mcu7t3v3__inv_2_338/VDD gf180mcu_as_sc_mcu7t3v3__inv_2_341/VDD
+ gf180mcu_as_sc_mcu7t3v3__inv_2_337/Y gf180mcu_as_sc_mcu7t3v3__inv_2_341/Y gf180mcu_as_sc_mcu7t3v3__inv_2_338/VNW
+ VSUBS gf180mcu_as_sc_mcu7t3v3__inv_2
Xgf180mcu_as_sc_mcu7t3v3__inv_2_326 VSS gf180mcu_as_sc_mcu7t3v3__inv_2_329/VDD gf180mcu_as_sc_mcu7t3v3__inv_2_341/Y
+ VSS gf180mcu_as_sc_mcu7t3v3__inv_2_326/VNW VSUBS gf180mcu_as_sc_mcu7t3v3__inv_2
Xgf180mcu_as_sc_mcu7t3v3__inv_2_315 VSS gf180mcu_as_sc_mcu7t3v3__inv_2_320/VDD VSS
+ gf180mcu_as_sc_mcu7t3v3__inv_2_341/Y gf180mcu_as_sc_mcu7t3v3__inv_2_317/VNW VSUBS
+ gf180mcu_as_sc_mcu7t3v3__inv_2
Xu_t027_009 u_t027_009/c0_w0_bl u_t027_009/c0_w0_br u_t027_009/c0_w1_bl u_t027_009/c0_w1_br
+ u_t027_009/c0_r0_rbl u_t027_009/c0_r1_rbl u_t027_009/c1_w0_bl u_t027_009/c1_w0_br
+ u_t027_009/c1_w1_bl u_t027_009/c1_w1_br u_t027_009/c1_r0_rbl u_t027_009/c1_r1_rbl
+ u_t027_009/c2_w0_bl u_t027_009/c2_w0_br u_t027_009/c2_w1_bl u_t027_009/c2_w1_br
+ u_t027_009/c2_r0_rbl u_t027_009/c2_r1_rbl u_t027_009/c3_w0_bl u_t027_009/c3_w0_br
+ u_t027_009/c3_w1_bl u_t027_009/c3_w1_br u_t027_009/c3_r0_rbl u_t027_009/c3_r1_rbl
+ u_t027_009/r0_w0_wl u_t027_009/r0_w1_wl u_t027_009/r0_r0_rwl u_t027_009/r0_r1_rwl
+ u_t027_009/r1_w0_wl u_t027_009/r1_w1_wl u_t027_009/r1_r0_rwl u_t027_009/r1_r1_rwl
+ u_t027_009/r2_w0_wl u_t027_009/r2_w1_wl u_t027_009/r2_r0_rwl u_t027_009/r2_r1_rwl
+ u_t027_009/r3_w0_wl u_t027_009/r3_w1_wl u_t027_009/r3_r0_rwl u_t027_009/r3_r1_rwl
+ VSS u_t027_009/VSS u_t027_009/m2_717_1265# u_t027_009/m2_603_2031# u_t027_009/m2_1290_336#
+ u_t027_009/m2_2000_2037# u_t027_009/m2_791_2909# u_t027_009/m2_7_2126# u_t027_009/m2_2154_2081#
+ u_t027_009/m2_1795_2037# u_t027_009/m2_871_303# u_t027_009/m2_431_438# u_t027_009/m2_1290_2898#
+ u_t027_009/m2_1714_1210# u_t027_009/m2_431_1982# u_t027_009/m2_512_1265# u_t027_009/m2_2573_2126#
+ u_t027_009/m2_603_1259# u_t027_009/m2_2074_2909# u_t027_009/m2_7_336# u_t027_009/m2_717_2037#
+ u_t027_009/m2_1886_2031# u_t027_009/m2_2573_336# u_t027_009/m2_7_2898# u_t027_009/m2_2000_1265#
+ u_t027_009/m2_512_2037# u_t027_009/m2_1795_1265# u_t027_009/m2_1714_1982# u_t027_009/m2_1886_1259#
+ u_t027_009/m2_1290_2126# u_t027_009/m2_1714_438# u_t027_009/m2_431_1210# u_t027_009/m2_2573_2898#
+ u_t027_009/m2_2154_303# u_t027_009/m2_871_2081# VSUBS detronyx_12t_2w2r_rc4_4x4_routed_5layer_direct
Xgf180mcu_as_sc_mcu7t3v3__inv_2_860 VSS VSS VSS VSS gf180mcu_as_sc_mcu7t3v3__inv_2_937/VNW
+ VSUBS gf180mcu_as_sc_mcu7t3v3__inv_2
Xgf180mcu_as_sc_mcu7t3v3__inv_2_882 VSS VSS VSS VSS gf180mcu_as_sc_mcu7t3v3__inv_2_933/VNW
+ VSUBS gf180mcu_as_sc_mcu7t3v3__inv_2
Xgf180mcu_as_sc_mcu7t3v3__inv_2_871 VSS VSS VSS VSS gf180mcu_as_sc_mcu7t3v3__inv_2_929/VNW
+ VSUBS gf180mcu_as_sc_mcu7t3v3__inv_2
Xgf180mcu_as_sc_mcu7t3v3__inv_2_893 VSS VSS VSS VSS gf180mcu_as_sc_mcu7t3v3__inv_2_925/VNW
+ VSUBS gf180mcu_as_sc_mcu7t3v3__inv_2
Xu_t018_009 u_t018_009/c0_w0_bl u_t018_009/c0_w0_br u_t018_009/c0_w1_bl u_t018_009/c0_w1_br
+ u_t018_009/c0_r0_rbl u_t018_009/c0_r1_rbl u_t018_009/c1_w0_bl u_t018_009/c1_w0_br
+ u_t018_009/c1_w1_bl u_t018_009/c1_w1_br u_t018_009/c1_r0_rbl u_t018_009/c1_r1_rbl
+ u_t018_009/c2_w0_bl u_t018_009/c2_w0_br u_t018_009/c2_w1_bl u_t018_009/c2_w1_br
+ u_t018_009/c2_r0_rbl u_t018_009/c2_r1_rbl u_t018_009/c3_w0_bl u_t018_009/c3_w0_br
+ u_t018_009/c3_w1_bl u_t018_009/c3_w1_br u_t018_009/c3_r0_rbl u_t018_009/c3_r1_rbl
+ u_t018_009/r0_w0_wl u_t018_009/r0_w1_wl u_t018_009/r0_r0_rwl u_t018_009/r0_r1_rwl
+ u_t018_009/r1_w0_wl u_t018_009/r1_w1_wl u_t018_009/r1_r0_rwl u_t018_009/r1_r1_rwl
+ u_t018_009/r2_w0_wl u_t018_009/r2_w1_wl u_t018_009/r2_r0_rwl u_t018_009/r2_r1_rwl
+ u_t018_009/r3_w0_wl u_t018_009/r3_w1_wl u_t018_009/r3_r0_rwl u_t018_009/r3_r1_rwl
+ VSS u_t018_009/VSS u_t018_009/m2_717_1265# u_t018_009/m2_603_2031# u_t018_009/m2_1290_336#
+ u_t018_009/m2_2000_2037# u_t018_009/m2_791_2909# u_t018_009/m2_7_2126# u_t018_009/m2_2154_2081#
+ u_t018_009/m2_1795_2037# u_t018_009/m2_871_303# u_t018_009/m2_431_438# u_t018_009/m2_1290_2898#
+ u_t018_009/m2_1714_1210# u_t018_009/m2_431_1982# u_t018_009/m2_512_1265# u_t018_009/m2_2573_2126#
+ u_t018_009/m2_603_1259# u_t018_009/m2_2074_2909# u_t018_009/m2_7_336# u_t018_009/m2_717_2037#
+ u_t018_009/m2_1886_2031# u_t018_009/m2_2573_336# u_t018_009/m2_7_2898# u_t018_009/m2_2000_1265#
+ u_t018_009/m2_512_2037# u_t018_009/m2_1795_1265# u_t018_009/m2_1714_1982# u_t018_009/m2_1886_1259#
+ u_t018_009/m2_1290_2126# u_t018_009/m2_1714_438# u_t018_009/m2_431_1210# u_t018_009/m2_2573_2898#
+ u_t018_009/m2_2154_303# u_t018_009/m2_871_2081# VSUBS detronyx_12t_2w2r_rc4_4x4_routed_5layer_direct
Xgf180mcu_as_sc_mcu7t3v3__nand4_2_170 gf180mcu_as_sc_mcu7t3v3__inv_2_602/VDD gf180mcu_as_sc_mcu7t3v3__inv_2_606/VDD
+ VSS VSS VSS VSS VSS gf180mcu_as_sc_mcu7t3v3__inv_2_602/VNW VSUBS gf180mcu_as_sc_mcu7t3v3__nand4_2
Xgf180mcu_as_sc_mcu7t3v3__nand4_2_181 VSS VSS VSS VSS VSS VSS VSS gf180mcu_as_sc_mcu7t3v3__inv_2_733/VNW
+ VSUBS gf180mcu_as_sc_mcu7t3v3__nand4_2
Xgf180mcu_as_sc_mcu7t3v3__nand4_2_192 VSS gf180mcu_as_sc_mcu7t3v3__inv_2_743/VDD VSS
+ VSS VSS VSS VSS gf180mcu_as_sc_mcu7t3v3__inv_2_740/VNW VSUBS gf180mcu_as_sc_mcu7t3v3__nand4_2
Xu_t009_009 u_t009_009/c0_w0_bl u_t009_009/c0_w0_br u_t009_009/c0_w1_bl u_t009_009/c0_w1_br
+ u_t009_009/c0_r0_rbl u_t009_009/c0_r1_rbl u_t009_009/c1_w0_bl u_t009_009/c1_w0_br
+ u_t009_009/c1_w1_bl u_t009_009/c1_w1_br u_t009_009/c1_r0_rbl u_t009_009/c1_r1_rbl
+ u_t009_009/c2_w0_bl u_t009_009/c2_w0_br u_t009_009/c2_w1_bl u_t009_009/c2_w1_br
+ u_t009_009/c2_r0_rbl u_t009_009/c2_r1_rbl u_t009_009/c3_w0_bl u_t009_009/c3_w0_br
+ u_t009_009/c3_w1_bl u_t009_009/c3_w1_br u_t009_009/c3_r0_rbl u_t009_009/c3_r1_rbl
+ u_t009_009/r0_w0_wl u_t009_009/r0_w1_wl u_t009_009/r0_r0_rwl u_t009_009/r0_r1_rwl
+ u_t009_009/r1_w0_wl u_t009_009/r1_w1_wl u_t009_009/r1_r0_rwl u_t009_009/r1_r1_rwl
+ u_t009_009/r2_w0_wl u_t009_009/r2_w1_wl u_t009_009/r2_r0_rwl u_t009_009/r2_r1_rwl
+ u_t009_009/r3_w0_wl u_t009_009/r3_w1_wl u_t009_009/r3_r0_rwl u_t009_009/r3_r1_rwl
+ VSS VSS u_t009_009/m2_717_1265# u_t009_009/m2_603_2031# u_t009_009/m2_1290_336#
+ u_t009_009/m2_2000_2037# u_t009_009/m2_791_2909# u_t009_009/m2_7_2126# u_t009_009/m2_2154_2081#
+ u_t009_009/m2_1795_2037# u_t009_009/m2_871_303# u_t009_009/m2_431_438# u_t009_009/m2_1290_2898#
+ u_t009_009/m2_1714_1210# u_t009_009/m2_431_1982# u_t009_009/m2_512_1265# u_t009_009/m2_2573_2126#
+ u_t009_009/m2_603_1259# u_t009_009/m2_2074_2909# u_t009_009/m2_7_336# u_t009_009/m2_717_2037#
+ u_t009_009/m2_1886_2031# u_t009_009/m2_2573_336# u_t009_009/m2_7_2898# u_t009_009/m2_2000_1265#
+ u_t009_009/m2_512_2037# u_t009_009/m2_1795_1265# u_t009_009/m2_1714_1982# u_t009_009/m2_1886_1259#
+ u_t009_009/m2_1290_2126# u_t009_009/m2_1714_438# u_t009_009/m2_431_1210# u_t009_009/m2_2573_2898#
+ u_t009_009/m2_2154_303# u_t009_009/m2_871_2081# VSUBS detronyx_12t_2w2r_rc4_4x4_routed_5layer_direct
Xgf180mcu_as_sc_mcu7t3v3__inv_2_101 gf180mcu_as_sc_mcu7t3v3__inv_2_91/VSS gf180mcu_as_sc_mcu7t3v3__inv_2_91/VSS
+ gf180mcu_as_sc_mcu7t3v3__inv_2_101/Y VSS gf180mcu_as_sc_mcu7t3v3__nand4_2_3/VNW
+ VSUBS gf180mcu_as_sc_mcu7t3v3__inv_2
Xgf180mcu_as_sc_mcu7t3v3__inv_2_134 gf180mcu_as_sc_mcu7t3v3__inv_2_134/VDD gf180mcu_as_sc_mcu7t3v3__inv_2_137/VDD
+ gf180mcu_as_sc_mcu7t3v3__inv_2_134/Y VSS gf180mcu_as_sc_mcu7t3v3__inv_2_134/VNW
+ VSUBS gf180mcu_as_sc_mcu7t3v3__inv_2
Xgf180mcu_as_sc_mcu7t3v3__inv_2_123 gf180mcu_as_sc_mcu7t3v3__inv_2_125/VDD gf180mcu_as_sc_mcu7t3v3__inv_2_131/VDD
+ gf180mcu_as_sc_mcu7t3v3__inv_2_123/Y VSS gf180mcu_as_sc_mcu7t3v3__inv_2_125/VNW
+ VSUBS gf180mcu_as_sc_mcu7t3v3__inv_2
Xgf180mcu_as_sc_mcu7t3v3__inv_2_112 gf180mcu_as_sc_mcu7t3v3__inv_2_113/VDD gf180mcu_as_sc_mcu7t3v3__inv_2_116/VDD
+ gf180mcu_as_sc_mcu7t3v3__inv_2_112/Y VSS gf180mcu_as_sc_mcu7t3v3__inv_2_113/VNW
+ VSUBS gf180mcu_as_sc_mcu7t3v3__inv_2
Xgf180mcu_as_sc_mcu7t3v3__inv_2_145 gf180mcu_as_sc_mcu7t3v3__inv_2_146/VDD VSS VSS
+ VSS gf180mcu_as_sc_mcu7t3v3__inv_2_146/VNW VSUBS gf180mcu_as_sc_mcu7t3v3__inv_2
Xgf180mcu_as_sc_mcu7t3v3__inv_2_167 VSS gf180mcu_as_sc_mcu7t3v3__inv_2_171/VDD gf180mcu_as_sc_mcu7t3v3__inv_2_167/Y
+ VSS gf180mcu_as_sc_mcu7t3v3__inv_2_168/VNW VSUBS gf180mcu_as_sc_mcu7t3v3__inv_2
Xgf180mcu_as_sc_mcu7t3v3__inv_2_178 VSS gf180mcu_as_sc_mcu7t3v3__inv_2_182/VDD gf180mcu_as_sc_mcu7t3v3__inv_2_178/Y
+ VSS gf180mcu_as_sc_mcu7t3v3__inv_2_180/VNW VSUBS gf180mcu_as_sc_mcu7t3v3__inv_2
Xgf180mcu_as_sc_mcu7t3v3__inv_2_189 gf180mcu_as_sc_mcu7t3v3__inv_2_190/VDD gf180mcu_as_sc_mcu7t3v3__inv_2_193/VDD
+ gf180mcu_as_sc_mcu7t3v3__inv_2_189/Y VSS gf180mcu_as_sc_mcu7t3v3__inv_2_190/VNW
+ VSUBS gf180mcu_as_sc_mcu7t3v3__inv_2
Xgf180mcu_as_sc_mcu7t3v3__inv_2_156 gf180mcu_as_sc_mcu7t3v3__inv_2_206/VSS gf180mcu_as_sc_mcu7t3v3__inv_2_177/VDD
+ gf180mcu_as_sc_mcu7t3v3__inv_2_156/Y VSS gf180mcu_as_sc_mcu7t3v3__inv_2_165/VNW
+ VSUBS gf180mcu_as_sc_mcu7t3v3__inv_2
Xu_t023_012 u_t023_012/c0_w0_bl u_t023_012/c0_w0_br u_t023_012/c0_w1_bl u_t023_012/c0_w1_br
+ u_t023_012/c0_r0_rbl u_t023_012/c0_r1_rbl u_t023_012/c1_w0_bl u_t023_012/c1_w0_br
+ u_t023_012/c1_w1_bl u_t023_012/c1_w1_br u_t023_012/c1_r0_rbl u_t023_012/c1_r1_rbl
+ u_t023_012/c2_w0_bl u_t023_012/c2_w0_br u_t023_012/c2_w1_bl u_t023_012/c2_w1_br
+ u_t023_012/c2_r0_rbl u_t023_012/c2_r1_rbl u_t023_012/c3_w0_bl u_t023_012/c3_w0_br
+ u_t023_012/c3_w1_bl u_t023_012/c3_w1_br u_t023_012/c3_r0_rbl u_t023_012/c3_r1_rbl
+ u_t023_012/r0_w0_wl u_t023_012/r0_w1_wl u_t023_012/r0_r0_rwl u_t023_012/r0_r1_rwl
+ u_t023_012/r1_w0_wl u_t023_012/r1_w1_wl u_t023_012/r1_r0_rwl u_t023_012/r1_r1_rwl
+ u_t023_012/r2_w0_wl u_t023_012/r2_w1_wl u_t023_012/r2_r0_rwl u_t023_012/r2_r1_rwl
+ u_t023_012/r3_w0_wl u_t023_012/r3_w1_wl u_t023_012/r3_r0_rwl u_t023_012/r3_r1_rwl
+ u_t023_012/VDD u_t023_012/VSS u_t023_012/m2_717_1265# u_t023_012/m2_603_2031# u_t023_012/m2_1290_336#
+ u_t023_012/m2_2000_2037# u_t023_012/m2_791_2909# u_t023_012/m2_7_2126# u_t023_012/m2_2154_2081#
+ u_t023_012/m2_1795_2037# u_t023_012/m2_871_303# u_t023_012/m2_431_438# u_t023_012/m2_1290_2898#
+ u_t023_012/m2_1714_1210# u_t023_012/m2_431_1982# u_t023_012/m2_512_1265# u_t023_012/m2_2573_2126#
+ u_t023_012/m2_603_1259# u_t023_012/m2_2074_2909# u_t023_012/m2_7_336# u_t023_012/m2_717_2037#
+ u_t023_012/m2_1886_2031# u_t023_012/m2_2573_336# u_t023_012/m2_7_2898# u_t023_012/m2_2000_1265#
+ u_t023_012/m2_512_2037# u_t023_012/m2_1795_1265# u_t023_012/m2_1714_1982# u_t023_012/m2_1886_1259#
+ u_t023_012/m2_1290_2126# u_t023_012/m2_1714_438# u_t023_012/m2_431_1210# u_t023_012/m2_2573_2898#
+ u_t023_012/m2_2154_303# u_t023_012/m2_871_2081# VSUBS detronyx_12t_2w2r_rc4_4x4_routed_5layer_direct
Xu_t023_001 u_t023_001/c0_w0_bl u_t023_001/c0_w0_br u_t023_001/c0_w1_bl u_t023_001/c0_w1_br
+ u_t023_001/c0_r0_rbl u_t023_001/c0_r1_rbl u_t023_001/c1_w0_bl u_t023_001/c1_w0_br
+ u_t023_001/c1_w1_bl u_t023_001/c1_w1_br u_t023_001/c1_r0_rbl u_t023_001/c1_r1_rbl
+ u_t023_001/c2_w0_bl u_t023_001/c2_w0_br u_t023_001/c2_w1_bl u_t023_001/c2_w1_br
+ u_t023_001/c2_r0_rbl u_t023_001/c2_r1_rbl u_t023_001/c3_w0_bl u_t023_001/c3_w0_br
+ u_t023_001/c3_w1_bl u_t023_001/c3_w1_br u_t023_001/c3_r0_rbl u_t023_001/c3_r1_rbl
+ u_t023_001/r0_w0_wl u_t023_001/r0_w1_wl u_t023_001/r0_r0_rwl u_t023_001/r0_r1_rwl
+ u_t023_001/r1_w0_wl u_t023_001/r1_w1_wl u_t023_001/r1_r0_rwl u_t023_001/r1_r1_rwl
+ u_t023_001/r2_w0_wl u_t023_001/r2_w1_wl u_t023_001/r2_r0_rwl u_t023_001/r2_r1_rwl
+ u_t023_001/r3_w0_wl u_t023_001/r3_w1_wl u_t023_001/r3_r0_rwl u_t023_001/r3_r1_rwl
+ VSS VSS u_t023_001/m2_717_1265# u_t023_001/m2_603_2031# u_t023_001/m2_1290_336#
+ u_t023_001/m2_2000_2037# u_t023_001/m2_791_2909# u_t023_001/m2_7_2126# u_t023_001/m2_2154_2081#
+ u_t023_001/m2_1795_2037# u_t023_001/m2_871_303# u_t023_001/m2_431_438# u_t023_001/m2_1290_2898#
+ u_t023_001/m2_1714_1210# u_t023_001/m2_431_1982# u_t023_001/m2_512_1265# u_t023_001/m2_2573_2126#
+ u_t023_001/m2_603_1259# u_t023_001/m2_2074_2909# u_t023_001/m2_7_336# u_t023_001/m2_717_2037#
+ u_t023_001/m2_1886_2031# u_t023_001/m2_2573_336# u_t023_001/m2_7_2898# u_t023_001/m2_2000_1265#
+ u_t023_001/m2_512_2037# u_t023_001/m2_1795_1265# u_t023_001/m2_1714_1982# u_t023_001/m2_1886_1259#
+ u_t023_001/m2_1290_2126# u_t023_001/m2_1714_438# u_t023_001/m2_431_1210# u_t023_001/m2_2573_2898#
+ u_t023_001/m2_2154_303# u_t023_001/m2_871_2081# VSUBS detronyx_12t_2w2r_rc4_4x4_routed_5layer_direct
Xgf180mcu_as_sc_mcu7t3v3__inv_2_690 VSS VSS gf180mcu_as_sc_mcu7t3v3__inv_2_690/Y gf180mcu_as_sc_mcu7t3v3__inv_2_853/Y
+ gf180mcu_as_sc_mcu7t3v3__inv_2_692/VNW VSUBS gf180mcu_as_sc_mcu7t3v3__inv_2
Xgf180mcu_as_sc_mcu7t3v3__nand2_2_46 gf180mcu_as_sc_mcu7t3v3__nor2_2_9/VDD gf180mcu_as_sc_mcu7t3v3__nand3_2_63/VSS
+ VSS VSS VSS gf180mcu_as_sc_mcu7t3v3__nor2_2_9/VNW VSUBS gf180mcu_as_sc_mcu7t3v3__nand2_2
Xgf180mcu_as_sc_mcu7t3v3__nand2_2_35 gf180mcu_as_sc_mcu7t3v3__nor2_2_9/VDD gf180mcu_as_sc_mcu7t3v3__nor2_2_9/VSS
+ VSS VSS VSS gf180mcu_as_sc_mcu7t3v3__nor2_2_9/VNW VSUBS gf180mcu_as_sc_mcu7t3v3__nand2_2
Xgf180mcu_as_sc_mcu7t3v3__nand2_2_13 gf180mcu_as_sc_mcu7t3v3__nor2_2_4/VDD gf180mcu_as_sc_mcu7t3v3__nand2_2_3/VSS
+ VSS VSS VSS gf180mcu_as_sc_mcu7t3v3__nor2_2_4/VNW VSUBS gf180mcu_as_sc_mcu7t3v3__nand2_2
Xgf180mcu_as_sc_mcu7t3v3__nand2_2_24 gf180mcu_as_sc_mcu7t3v3__nand3_2_9/VDD gf180mcu_as_sc_mcu7t3v3__nor2_2_7/VSS
+ VSS VSS VSS gf180mcu_as_sc_mcu7t3v3__nand3_2_9/VNW VSUBS gf180mcu_as_sc_mcu7t3v3__nand2_2
Xu_t014_012 u_t014_012/c0_w0_bl u_t014_012/c0_w0_br u_t014_012/c0_w1_bl u_t014_012/c0_w1_br
+ u_t014_012/c0_r0_rbl u_t014_012/c0_r1_rbl u_t014_012/c1_w0_bl u_t014_012/c1_w0_br
+ u_t014_012/c1_w1_bl u_t014_012/c1_w1_br u_t014_012/c1_r0_rbl u_t014_012/c1_r1_rbl
+ u_t014_012/c2_w0_bl u_t014_012/c2_w0_br u_t014_012/c2_w1_bl u_t014_012/c2_w1_br
+ u_t014_012/c2_r0_rbl u_t014_012/c2_r1_rbl u_t014_012/c3_w0_bl u_t014_012/c3_w0_br
+ u_t014_012/c3_w1_bl u_t014_012/c3_w1_br u_t014_012/c3_r0_rbl u_t014_012/c3_r1_rbl
+ u_t014_012/r0_w0_wl u_t014_012/r0_w1_wl u_t014_012/r0_r0_rwl u_t014_012/r0_r1_rwl
+ u_t014_012/r1_w0_wl u_t014_012/r1_w1_wl u_t014_012/r1_r0_rwl u_t014_012/r1_r1_rwl
+ u_t014_012/r2_w0_wl u_t014_012/r2_w1_wl u_t014_012/r2_r0_rwl u_t014_012/r2_r1_rwl
+ u_t014_012/r3_w0_wl u_t014_012/r3_w1_wl u_t014_012/r3_r0_rwl u_t014_012/r3_r1_rwl
+ u_t014_012/VDD u_t014_012/VSS u_t014_012/m2_717_1265# u_t014_012/m2_603_2031# u_t014_012/m2_1290_336#
+ u_t014_012/m2_2000_2037# u_t014_012/m2_791_2909# u_t014_012/m2_7_2126# u_t014_012/m2_2154_2081#
+ u_t014_012/m2_1795_2037# u_t014_012/m2_871_303# u_t014_012/m2_431_438# u_t014_012/m2_1290_2898#
+ u_t014_012/m2_1714_1210# u_t014_012/m2_431_1982# u_t014_012/m2_512_1265# u_t014_012/m2_2573_2126#
+ u_t014_012/m2_603_1259# u_t014_012/m2_2074_2909# u_t014_012/m2_7_336# u_t014_012/m2_717_2037#
+ u_t014_012/m2_1886_2031# u_t014_012/m2_2573_336# u_t014_012/m2_7_2898# u_t014_012/m2_2000_1265#
+ u_t014_012/m2_512_2037# u_t014_012/m2_1795_1265# u_t014_012/m2_1714_1982# u_t014_012/m2_1886_1259#
+ u_t014_012/m2_1290_2126# u_t014_012/m2_1714_438# u_t014_012/m2_431_1210# u_t014_012/m2_2573_2898#
+ u_t014_012/m2_2154_303# u_t014_012/m2_871_2081# VSUBS detronyx_12t_2w2r_rc4_4x4_routed_5layer_direct
Xu_t014_001 u_t014_001/c0_w0_bl u_t014_001/c0_w0_br u_t014_001/c0_w1_bl u_t014_001/c0_w1_br
+ u_t014_001/c0_r0_rbl u_t014_001/c0_r1_rbl u_t014_001/c1_w0_bl u_t014_001/c1_w0_br
+ u_t014_001/c1_w1_bl u_t014_001/c1_w1_br u_t014_001/c1_r0_rbl u_t014_001/c1_r1_rbl
+ u_t014_001/c2_w0_bl u_t014_001/c2_w0_br u_t014_001/c2_w1_bl u_t014_001/c2_w1_br
+ u_t014_001/c2_r0_rbl u_t014_001/c2_r1_rbl u_t014_001/c3_w0_bl u_t014_001/c3_w0_br
+ u_t014_001/c3_w1_bl u_t014_001/c3_w1_br u_t014_001/c3_r0_rbl u_t014_001/c3_r1_rbl
+ u_t014_001/r0_w0_wl u_t014_001/r0_w1_wl u_t014_001/r0_r0_rwl u_t014_001/r0_r1_rwl
+ u_t014_001/r1_w0_wl u_t014_001/r1_w1_wl u_t014_001/r1_r0_rwl u_t014_001/r1_r1_rwl
+ u_t014_001/r2_w0_wl u_t014_001/r2_w1_wl u_t014_001/r2_r0_rwl u_t014_001/r2_r1_rwl
+ u_t014_001/r3_w0_wl u_t014_001/r3_w1_wl u_t014_001/r3_r0_rwl u_t014_001/r3_r1_rwl
+ VSS VSS u_t014_001/m2_717_1265# u_t014_001/m2_603_2031# u_t014_001/m2_1290_336#
+ u_t014_001/m2_2000_2037# u_t014_001/m2_791_2909# u_t014_001/m2_7_2126# u_t014_001/m2_2154_2081#
+ u_t014_001/m2_1795_2037# u_t014_001/m2_871_303# u_t014_001/m2_431_438# u_t014_001/m2_1290_2898#
+ u_t014_001/m2_1714_1210# u_t014_001/m2_431_1982# u_t014_001/m2_512_1265# u_t014_001/m2_2573_2126#
+ u_t014_001/m2_603_1259# u_t014_001/m2_2074_2909# u_t014_001/m2_7_336# u_t014_001/m2_717_2037#
+ u_t014_001/m2_1886_2031# u_t014_001/m2_2573_336# u_t014_001/m2_7_2898# u_t014_001/m2_2000_1265#
+ u_t014_001/m2_512_2037# u_t014_001/m2_1795_1265# u_t014_001/m2_1714_1982# u_t014_001/m2_1886_1259#
+ u_t014_001/m2_1290_2126# u_t014_001/m2_1714_438# u_t014_001/m2_431_1210# u_t014_001/m2_2573_2898#
+ u_t014_001/m2_2154_303# u_t014_001/m2_871_2081# VSUBS detronyx_12t_2w2r_rc4_4x4_routed_5layer_direct
Xu_t005_012 u_t005_012/c0_w0_bl u_t005_012/c0_w0_br u_t005_012/c0_w1_bl u_t005_012/c0_w1_br
+ u_t005_012/c0_r0_rbl u_t005_012/c0_r1_rbl u_t005_012/c1_w0_bl u_t005_012/c1_w0_br
+ u_t005_012/c1_w1_bl u_t005_012/c1_w1_br u_t005_012/c1_r0_rbl u_t005_012/c1_r1_rbl
+ u_t005_012/c2_w0_bl u_t005_012/c2_w0_br u_t005_012/c2_w1_bl u_t005_012/c2_w1_br
+ u_t005_012/c2_r0_rbl u_t005_012/c2_r1_rbl u_t005_012/c3_w0_bl u_t005_012/c3_w0_br
+ u_t005_012/c3_w1_bl u_t005_012/c3_w1_br u_t005_012/c3_r0_rbl u_t005_012/c3_r1_rbl
+ u_t005_012/r0_w0_wl u_t005_012/r0_w1_wl u_t005_012/r0_r0_rwl u_t005_012/r0_r1_rwl
+ u_t005_012/r1_w0_wl u_t005_012/r1_w1_wl u_t005_012/r1_r0_rwl u_t005_012/r1_r1_rwl
+ u_t005_012/r2_w0_wl u_t005_012/r2_w1_wl u_t005_012/r2_r0_rwl u_t005_012/r2_r1_rwl
+ u_t005_012/r3_w0_wl u_t005_012/r3_w1_wl u_t005_012/r3_r0_rwl u_t005_012/r3_r1_rwl
+ u_t005_012/VDD VSS u_t005_012/m2_717_1265# u_t005_012/m2_603_2031# u_t005_012/m2_1290_336#
+ u_t005_012/m2_2000_2037# u_t005_012/m2_791_2909# u_t005_012/m2_7_2126# u_t005_012/m2_2154_2081#
+ u_t005_012/m2_1795_2037# u_t005_012/m2_871_303# u_t005_012/m2_431_438# u_t005_012/m2_1290_2898#
+ u_t005_012/m2_1714_1210# u_t005_012/m2_431_1982# u_t005_012/m2_512_1265# u_t005_012/m2_2573_2126#
+ u_t005_012/m2_603_1259# u_t005_012/m2_2074_2909# u_t005_012/m2_7_336# u_t005_012/m2_717_2037#
+ u_t005_012/m2_1886_2031# u_t005_012/m2_2573_336# u_t005_012/m2_7_2898# u_t005_012/m2_2000_1265#
+ u_t005_012/m2_512_2037# u_t005_012/m2_1795_1265# u_t005_012/m2_1714_1982# u_t005_012/m2_1886_1259#
+ u_t005_012/m2_1290_2126# u_t005_012/m2_1714_438# u_t005_012/m2_431_1210# u_t005_012/m2_2573_2898#
+ u_t005_012/m2_2154_303# u_t005_012/m2_871_2081# VSUBS detronyx_12t_2w2r_rc4_4x4_routed_5layer_direct
Xu_t005_001 u_t005_001/c0_w0_bl u_t005_001/c0_w0_br u_t005_001/c0_w1_bl u_t005_001/c0_w1_br
+ u_t005_001/c0_r0_rbl u_t005_001/c0_r1_rbl u_t005_001/c1_w0_bl u_t005_001/c1_w0_br
+ u_t005_001/c1_w1_bl u_t005_001/c1_w1_br u_t005_001/c1_r0_rbl u_t005_001/c1_r1_rbl
+ u_t005_001/c2_w0_bl u_t005_001/c2_w0_br u_t005_001/c2_w1_bl u_t005_001/c2_w1_br
+ u_t005_001/c2_r0_rbl u_t005_001/c2_r1_rbl u_t005_001/c3_w0_bl u_t005_001/c3_w0_br
+ u_t005_001/c3_w1_bl u_t005_001/c3_w1_br u_t005_001/c3_r0_rbl u_t005_001/c3_r1_rbl
+ u_t005_001/r0_w0_wl u_t005_001/r0_w1_wl u_t005_001/r0_r0_rwl u_t005_001/r0_r1_rwl
+ u_t005_001/r1_w0_wl u_t005_001/r1_w1_wl u_t005_001/r1_r0_rwl u_t005_001/r1_r1_rwl
+ u_t005_001/r2_w0_wl u_t005_001/r2_w1_wl u_t005_001/r2_r0_rwl u_t005_001/r2_r1_rwl
+ u_t005_001/r3_w0_wl u_t005_001/r3_w1_wl u_t005_001/r3_r0_rwl u_t005_001/r3_r1_rwl
+ VSS VSS u_t005_001/m2_717_1265# u_t005_001/m2_603_2031# u_t005_001/m2_1290_336#
+ u_t005_001/m2_2000_2037# u_t005_001/m2_791_2909# u_t005_001/m2_7_2126# u_t005_001/m2_2154_2081#
+ u_t005_001/m2_1795_2037# u_t005_001/m2_871_303# u_t005_001/m2_431_438# u_t005_001/m2_1290_2898#
+ u_t005_001/m2_1714_1210# u_t005_001/m2_431_1982# u_t005_001/m2_512_1265# u_t005_001/m2_2573_2126#
+ u_t005_001/m2_603_1259# u_t005_001/m2_2074_2909# u_t005_001/m2_7_336# u_t005_001/m2_717_2037#
+ u_t005_001/m2_1886_2031# u_t005_001/m2_2573_336# u_t005_001/m2_7_2898# u_t005_001/m2_2000_1265#
+ u_t005_001/m2_512_2037# u_t005_001/m2_1795_1265# u_t005_001/m2_1714_1982# u_t005_001/m2_1886_1259#
+ u_t005_001/m2_1290_2126# u_t005_001/m2_1714_438# u_t005_001/m2_431_1210# u_t005_001/m2_2573_2898#
+ u_t005_001/m2_2154_303# u_t005_001/m2_871_2081# VSUBS detronyx_12t_2w2r_rc4_4x4_routed_5layer_direct
Xu_t020_015 u_t020_015/c0_w0_bl u_t020_015/c0_w0_br u_t020_015/c0_w1_bl u_t020_015/c0_w1_br
+ u_t020_015/c0_r0_rbl u_t020_015/c0_r1_rbl u_t020_015/c1_w0_bl u_t020_015/c1_w0_br
+ u_t020_015/c1_w1_bl u_t020_015/c1_w1_br u_t020_015/c1_r0_rbl u_t020_015/c1_r1_rbl
+ u_t020_015/c2_w0_bl u_t020_015/c2_w0_br u_t020_015/c2_w1_bl u_t020_015/c2_w1_br
+ u_t020_015/c2_r0_rbl u_t020_015/c2_r1_rbl u_t020_015/c3_w0_bl u_t020_015/c3_w0_br
+ u_t020_015/c3_w1_bl u_t020_015/c3_w1_br u_t020_015/c3_r0_rbl u_t020_015/c3_r1_rbl
+ u_t020_015/r0_w0_wl u_t020_015/r0_w1_wl u_t020_015/r0_r0_rwl u_t020_015/r0_r1_rwl
+ u_t020_015/r1_w0_wl u_t020_015/r1_w1_wl u_t020_015/r1_r0_rwl u_t020_015/r1_r1_rwl
+ u_t020_015/r2_w0_wl u_t020_015/r2_w1_wl u_t020_015/r2_r0_rwl u_t020_015/r2_r1_rwl
+ u_t020_015/r3_w0_wl u_t020_015/r3_w1_wl u_t020_015/r3_r0_rwl u_t020_015/r3_r1_rwl
+ VSS u_t020_015/VSS u_t020_015/m2_717_1265# u_t020_015/m2_603_2031# u_t020_015/m2_1290_336#
+ u_t020_015/m2_2000_2037# u_t020_015/m2_791_2909# u_t020_015/m2_7_2126# u_t020_015/m2_2154_2081#
+ u_t020_015/m2_1795_2037# u_t020_015/m2_871_303# u_t020_015/m2_431_438# u_t020_015/m2_1290_2898#
+ u_t020_015/m2_1714_1210# u_t020_015/m2_431_1982# u_t020_015/m2_512_1265# u_t020_015/m2_2573_2126#
+ u_t020_015/m2_603_1259# u_t020_015/m2_2074_2909# u_t020_015/m2_7_336# u_t020_015/m2_717_2037#
+ u_t020_015/m2_1886_2031# u_t020_015/m2_2573_336# u_t020_015/m2_7_2898# u_t020_015/m2_2000_1265#
+ u_t020_015/m2_512_2037# u_t020_015/m2_1795_1265# u_t020_015/m2_1714_1982# u_t020_015/m2_1886_1259#
+ u_t020_015/m2_1290_2126# u_t020_015/m2_1714_438# u_t020_015/m2_431_1210# u_t020_015/m2_2573_2898#
+ u_t020_015/m2_2154_303# u_t020_015/m2_871_2081# VSUBS detronyx_12t_2w2r_rc4_4x4_routed_5layer_direct
Xu_t020_004 u_t020_004/c0_w0_bl u_t020_004/c0_w0_br u_t020_004/c0_w1_bl u_t020_004/c0_w1_br
+ u_t020_004/c0_r0_rbl u_t020_004/c0_r1_rbl u_t020_004/c1_w0_bl u_t020_004/c1_w0_br
+ u_t020_004/c1_w1_bl u_t020_004/c1_w1_br u_t020_004/c1_r0_rbl u_t020_004/c1_r1_rbl
+ u_t020_004/c2_w0_bl u_t020_004/c2_w0_br u_t020_004/c2_w1_bl u_t020_004/c2_w1_br
+ u_t020_004/c2_r0_rbl u_t020_004/c2_r1_rbl u_t020_004/c3_w0_bl u_t020_004/c3_w0_br
+ u_t020_004/c3_w1_bl u_t020_004/c3_w1_br u_t020_004/c3_r0_rbl u_t020_004/c3_r1_rbl
+ u_t020_004/r0_w0_wl u_t020_004/r0_w1_wl u_t020_004/r0_r0_rwl u_t020_004/r0_r1_rwl
+ u_t020_004/r1_w0_wl u_t020_004/r1_w1_wl u_t020_004/r1_r0_rwl u_t020_004/r1_r1_rwl
+ u_t020_004/r2_w0_wl u_t020_004/r2_w1_wl u_t020_004/r2_r0_rwl u_t020_004/r2_r1_rwl
+ u_t020_004/r3_w0_wl u_t020_004/r3_w1_wl u_t020_004/r3_r0_rwl u_t020_004/r3_r1_rwl
+ u_t020_004/VDD u_t020_004/VSS u_t020_004/m2_717_1265# u_t020_004/m2_603_2031# u_t020_004/m2_1290_336#
+ u_t020_004/m2_2000_2037# u_t020_004/m2_791_2909# u_t020_004/m2_7_2126# u_t020_004/m2_2154_2081#
+ u_t020_004/m2_1795_2037# u_t020_004/m2_871_303# u_t020_004/m2_431_438# u_t020_004/m2_1290_2898#
+ u_t020_004/m2_1714_1210# u_t020_004/m2_431_1982# u_t020_004/m2_512_1265# u_t020_004/m2_2573_2126#
+ u_t020_004/m2_603_1259# u_t020_004/m2_2074_2909# u_t020_004/m2_7_336# u_t020_004/m2_717_2037#
+ u_t020_004/m2_1886_2031# u_t020_004/m2_2573_336# u_t020_004/m2_7_2898# u_t020_004/m2_2000_1265#
+ u_t020_004/m2_512_2037# u_t020_004/m2_1795_1265# u_t020_004/m2_1714_1982# u_t020_004/m2_1886_1259#
+ u_t020_004/m2_1290_2126# u_t020_004/m2_1714_438# u_t020_004/m2_431_1210# u_t020_004/m2_2573_2898#
+ u_t020_004/m2_2154_303# u_t020_004/m2_871_2081# VSUBS detronyx_12t_2w2r_rc4_4x4_routed_5layer_direct
Xgf180mcu_as_sc_mcu7t3v3__inv_2_1408 gf180mcu_as_sc_mcu7t3v3__inv_2_1409/VDD gf180mcu_as_sc_mcu7t3v3__inv_2_1409/VSS
+ gf180mcu_as_sc_mcu7t3v3__inv_2_1409/A VSS gf180mcu_as_sc_mcu7t3v3__inv_2_1409/VNW
+ VSUBS gf180mcu_as_sc_mcu7t3v3__inv_2
Xgf180mcu_as_sc_mcu7t3v3__inv_2_1419 VSS VSS VSS VSS gf180mcu_as_sc_mcu7t3v3__inv_2_1419/VNW
+ VSUBS gf180mcu_as_sc_mcu7t3v3__inv_2
Xu_t011_015 u_t011_015/c0_w0_bl u_t011_015/c0_w0_br u_t011_015/c0_w1_bl u_t011_015/c0_w1_br
+ u_t011_015/c0_r0_rbl u_t011_015/c0_r1_rbl u_t011_015/c1_w0_bl u_t011_015/c1_w0_br
+ u_t011_015/c1_w1_bl u_t011_015/c1_w1_br u_t011_015/c1_r0_rbl u_t011_015/c1_r1_rbl
+ u_t011_015/c2_w0_bl u_t011_015/c2_w0_br u_t011_015/c2_w1_bl u_t011_015/c2_w1_br
+ u_t011_015/c2_r0_rbl u_t011_015/c2_r1_rbl u_t011_015/c3_w0_bl u_t011_015/c3_w0_br
+ u_t011_015/c3_w1_bl u_t011_015/c3_w1_br u_t011_015/c3_r0_rbl u_t011_015/c3_r1_rbl
+ u_t011_015/r0_w0_wl u_t011_015/r0_w1_wl u_t011_015/r0_r0_rwl u_t011_015/r0_r1_rwl
+ u_t011_015/r1_w0_wl u_t011_015/r1_w1_wl u_t011_015/r1_r0_rwl u_t011_015/r1_r1_rwl
+ u_t011_015/r2_w0_wl u_t011_015/r2_w1_wl u_t011_015/r2_r0_rwl u_t011_015/r2_r1_rwl
+ u_t011_015/r3_w0_wl u_t011_015/r3_w1_wl u_t011_015/r3_r0_rwl u_t011_015/r3_r1_rwl
+ VSS u_t011_015/VSS u_t011_015/m2_717_1265# u_t011_015/m2_603_2031# u_t011_015/m2_1290_336#
+ u_t011_015/m2_2000_2037# u_t011_015/m2_791_2909# u_t011_015/m2_7_2126# u_t011_015/m2_2154_2081#
+ u_t011_015/m2_1795_2037# u_t011_015/m2_871_303# u_t011_015/m2_431_438# u_t011_015/m2_1290_2898#
+ u_t011_015/m2_1714_1210# u_t011_015/m2_431_1982# u_t011_015/m2_512_1265# u_t011_015/m2_2573_2126#
+ u_t011_015/m2_603_1259# u_t011_015/m2_2074_2909# u_t011_015/m2_7_336# u_t011_015/m2_717_2037#
+ u_t011_015/m2_1886_2031# u_t011_015/m2_2573_336# u_t011_015/m2_7_2898# u_t011_015/m2_2000_1265#
+ u_t011_015/m2_512_2037# u_t011_015/m2_1795_1265# u_t011_015/m2_1714_1982# u_t011_015/m2_1886_1259#
+ u_t011_015/m2_1290_2126# u_t011_015/m2_1714_438# u_t011_015/m2_431_1210# u_t011_015/m2_2573_2898#
+ u_t011_015/m2_2154_303# u_t011_015/m2_871_2081# VSUBS detronyx_12t_2w2r_rc4_4x4_routed_5layer_direct
Xu_t011_004 u_t011_004/c0_w0_bl u_t011_004/c0_w0_br u_t011_004/c0_w1_bl u_t011_004/c0_w1_br
+ u_t011_004/c0_r0_rbl u_t011_004/c0_r1_rbl u_t011_004/c1_w0_bl u_t011_004/c1_w0_br
+ u_t011_004/c1_w1_bl u_t011_004/c1_w1_br u_t011_004/c1_r0_rbl u_t011_004/c1_r1_rbl
+ u_t011_004/c2_w0_bl u_t011_004/c2_w0_br u_t011_004/c2_w1_bl u_t011_004/c2_w1_br
+ u_t011_004/c2_r0_rbl u_t011_004/c2_r1_rbl u_t011_004/c3_w0_bl u_t011_004/c3_w0_br
+ u_t011_004/c3_w1_bl u_t011_004/c3_w1_br u_t011_004/c3_r0_rbl u_t011_004/c3_r1_rbl
+ u_t011_004/r0_w0_wl u_t011_004/r0_w1_wl u_t011_004/r0_r0_rwl u_t011_004/r0_r1_rwl
+ u_t011_004/r1_w0_wl u_t011_004/r1_w1_wl u_t011_004/r1_r0_rwl u_t011_004/r1_r1_rwl
+ u_t011_004/r2_w0_wl u_t011_004/r2_w1_wl u_t011_004/r2_r0_rwl u_t011_004/r2_r1_rwl
+ u_t011_004/r3_w0_wl u_t011_004/r3_w1_wl u_t011_004/r3_r0_rwl u_t011_004/r3_r1_rwl
+ u_t011_004/VDD u_t011_004/VSS u_t011_004/m2_717_1265# u_t011_004/m2_603_2031# u_t011_004/m2_1290_336#
+ u_t011_004/m2_2000_2037# u_t011_004/m2_791_2909# u_t011_004/m2_7_2126# u_t011_004/m2_2154_2081#
+ u_t011_004/m2_1795_2037# u_t011_004/m2_871_303# u_t011_004/m2_431_438# u_t011_004/m2_1290_2898#
+ u_t011_004/m2_1714_1210# u_t011_004/m2_431_1982# u_t011_004/m2_512_1265# u_t011_004/m2_2573_2126#
+ u_t011_004/m2_603_1259# u_t011_004/m2_2074_2909# u_t011_004/m2_7_336# u_t011_004/m2_717_2037#
+ u_t011_004/m2_1886_2031# u_t011_004/m2_2573_336# u_t011_004/m2_7_2898# u_t011_004/m2_2000_1265#
+ u_t011_004/m2_512_2037# u_t011_004/m2_1795_1265# u_t011_004/m2_1714_1982# u_t011_004/m2_1886_1259#
+ u_t011_004/m2_1290_2126# u_t011_004/m2_1714_438# u_t011_004/m2_431_1210# u_t011_004/m2_2573_2898#
+ u_t011_004/m2_2154_303# u_t011_004/m2_871_2081# VSUBS detronyx_12t_2w2r_rc4_4x4_routed_5layer_direct
Xu_t002_015 u_t002_015/c0_w0_bl u_t002_015/c0_w0_br u_t002_015/c0_w1_bl u_t002_015/c0_w1_br
+ u_t002_015/c0_r0_rbl u_t002_015/c0_r1_rbl u_t002_015/c1_w0_bl u_t002_015/c1_w0_br
+ u_t002_015/c1_w1_bl u_t002_015/c1_w1_br u_t002_015/c1_r0_rbl u_t002_015/c1_r1_rbl
+ u_t002_015/c2_w0_bl u_t002_015/c2_w0_br u_t002_015/c2_w1_bl u_t002_015/c2_w1_br
+ u_t002_015/c2_r0_rbl u_t002_015/c2_r1_rbl u_t002_015/c3_w0_bl u_t002_015/c3_w0_br
+ u_t002_015/c3_w1_bl u_t002_015/c3_w1_br u_t002_015/c3_r0_rbl u_t002_015/c3_r1_rbl
+ u_t002_015/r0_w0_wl u_t002_015/r0_w1_wl u_t002_015/r0_r0_rwl u_t002_015/r0_r1_rwl
+ u_t002_015/r1_w0_wl u_t002_015/r1_w1_wl u_t002_015/r1_r0_rwl u_t002_015/r1_r1_rwl
+ u_t002_015/r2_w0_wl u_t002_015/r2_w1_wl u_t002_015/r2_r0_rwl u_t002_015/r2_r1_rwl
+ u_t002_015/r3_w0_wl u_t002_015/r3_w1_wl u_t002_015/r3_r0_rwl u_t002_015/r3_r1_rwl
+ VSS u_t002_015/VSS u_t002_015/m2_717_1265# u_t002_015/m2_603_2031# u_t002_015/m2_1290_336#
+ u_t002_015/m2_2000_2037# u_t002_015/m2_791_2909# u_t002_015/m2_7_2126# u_t002_015/m2_2154_2081#
+ u_t002_015/m2_1795_2037# u_t002_015/m2_871_303# u_t002_015/m2_431_438# u_t002_015/m2_1290_2898#
+ u_t002_015/m2_1714_1210# u_t002_015/m2_431_1982# u_t002_015/m2_512_1265# u_t002_015/m2_2573_2126#
+ u_t002_015/m2_603_1259# u_t002_015/m2_2074_2909# u_t002_015/m2_7_336# u_t002_015/m2_717_2037#
+ u_t002_015/m2_1886_2031# u_t002_015/m2_2573_336# u_t002_015/m2_7_2898# u_t002_015/m2_2000_1265#
+ u_t002_015/m2_512_2037# u_t002_015/m2_1795_1265# u_t002_015/m2_1714_1982# u_t002_015/m2_1886_1259#
+ u_t002_015/m2_1290_2126# u_t002_015/m2_1714_438# u_t002_015/m2_431_1210# u_t002_015/m2_2573_2898#
+ u_t002_015/m2_2154_303# u_t002_015/m2_871_2081# VSUBS detronyx_12t_2w2r_rc4_4x4_routed_5layer_direct
Xu_t002_004 u_t002_004/c0_w0_bl u_t002_004/c0_w0_br u_t002_004/c0_w1_bl u_t002_004/c0_w1_br
+ u_t002_004/c0_r0_rbl u_t002_004/c0_r1_rbl u_t002_004/c1_w0_bl u_t002_004/c1_w0_br
+ u_t002_004/c1_w1_bl u_t002_004/c1_w1_br u_t002_004/c1_r0_rbl u_t002_004/c1_r1_rbl
+ u_t002_004/c2_w0_bl u_t002_004/c2_w0_br u_t002_004/c2_w1_bl u_t002_004/c2_w1_br
+ u_t002_004/c2_r0_rbl u_t002_004/c2_r1_rbl u_t002_004/c3_w0_bl u_t002_004/c3_w0_br
+ u_t002_004/c3_w1_bl u_t002_004/c3_w1_br u_t002_004/c3_r0_rbl u_t002_004/c3_r1_rbl
+ u_t002_004/r0_w0_wl u_t002_004/r0_w1_wl u_t002_004/r0_r0_rwl u_t002_004/r0_r1_rwl
+ u_t002_004/r1_w0_wl u_t002_004/r1_w1_wl u_t002_004/r1_r0_rwl u_t002_004/r1_r1_rwl
+ u_t002_004/r2_w0_wl u_t002_004/r2_w1_wl u_t002_004/r2_r0_rwl u_t002_004/r2_r1_rwl
+ u_t002_004/r3_w0_wl u_t002_004/r3_w1_wl u_t002_004/r3_r0_rwl u_t002_004/r3_r1_rwl
+ u_t002_004/VDD u_t002_004/VSS u_t002_004/m2_717_1265# u_t002_004/m2_603_2031# u_t002_004/m2_1290_336#
+ u_t002_004/m2_2000_2037# u_t002_004/m2_791_2909# u_t002_004/m2_7_2126# u_t002_004/m2_2154_2081#
+ u_t002_004/m2_1795_2037# u_t002_004/m2_871_303# u_t002_004/m2_431_438# u_t002_004/m2_1290_2898#
+ u_t002_004/m2_1714_1210# u_t002_004/m2_431_1982# u_t002_004/m2_512_1265# u_t002_004/m2_2573_2126#
+ u_t002_004/m2_603_1259# u_t002_004/m2_2074_2909# u_t002_004/m2_7_336# u_t002_004/m2_717_2037#
+ u_t002_004/m2_1886_2031# u_t002_004/m2_2573_336# u_t002_004/m2_7_2898# u_t002_004/m2_2000_1265#
+ u_t002_004/m2_512_2037# u_t002_004/m2_1795_1265# u_t002_004/m2_1714_1982# u_t002_004/m2_1886_1259#
+ u_t002_004/m2_1290_2126# u_t002_004/m2_1714_438# u_t002_004/m2_431_1210# u_t002_004/m2_2573_2898#
+ u_t002_004/m2_2154_303# u_t002_004/m2_871_2081# VSUBS detronyx_12t_2w2r_rc4_4x4_routed_5layer_direct
Xgf180mcu_as_sc_mcu7t3v3__inv_2_1249 gf180mcu_as_sc_mcu7t3v3__nor2_2_9/VDD gf180mcu_as_sc_mcu7t3v3__nand3_2_63/VSS
+ VSS VSS gf180mcu_as_sc_mcu7t3v3__nor2_2_9/VNW VSUBS gf180mcu_as_sc_mcu7t3v3__inv_2
Xgf180mcu_as_sc_mcu7t3v3__inv_2_1238 gf180mcu_as_sc_mcu7t3v3__nor2_2_9/VDD gf180mcu_as_sc_mcu7t3v3__nand3_2_63/VSS
+ VSS VSS gf180mcu_as_sc_mcu7t3v3__nor2_2_9/VNW VSUBS gf180mcu_as_sc_mcu7t3v3__inv_2
Xgf180mcu_as_sc_mcu7t3v3__inv_2_1205 gf180mcu_as_sc_mcu7t3v3__nor2_2_9/VDD gf180mcu_as_sc_mcu7t3v3__nor2_2_9/VSS
+ VSS VSS gf180mcu_as_sc_mcu7t3v3__nor2_2_9/VNW VSUBS gf180mcu_as_sc_mcu7t3v3__inv_2
Xgf180mcu_as_sc_mcu7t3v3__inv_2_1216 gf180mcu_as_sc_mcu7t3v3__nand3_2_65/VDD gf180mcu_as_sc_mcu7t3v3__nor2_2_9/VSS
+ VSS VSS gf180mcu_as_sc_mcu7t3v3__nand3_2_65/VNW VSUBS gf180mcu_as_sc_mcu7t3v3__inv_2
Xgf180mcu_as_sc_mcu7t3v3__inv_2_1227 VSS VSS gf180mcu_as_sc_mcu7t3v3__inv_2_1227/Y
+ VSS gf180mcu_as_sc_mcu7t3v3__inv_2_1277/VNW VSUBS gf180mcu_as_sc_mcu7t3v3__inv_2
Xgf180mcu_as_sc_mcu7t3v3__nand4_2_500 gf180mcu_as_sc_mcu7t3v3__inv_2_1638/VDD VSS
+ VSS VSS VSS VSS VSS gf180mcu_as_sc_mcu7t3v3__inv_2_1638/VNW VSUBS gf180mcu_as_sc_mcu7t3v3__nand4_2
Xgf180mcu_as_sc_mcu7t3v3__nand4_2_511 gf180mcu_as_sc_mcu7t3v3__inv_2_1720/VDD VSS
+ VSS VSS VSS VSS gf180mcu_as_sc_mcu7t3v3__nand4_2_511/Y gf180mcu_as_sc_mcu7t3v3__inv_2_1720/VNW
+ VSUBS gf180mcu_as_sc_mcu7t3v3__nand4_2
Xgf180mcu_as_sc_mcu7t3v3__inv_2_1013 gf180mcu_as_sc_mcu7t3v3__inv_2_1058/VDD gf180mcu_as_sc_mcu7t3v3__inv_2_1058/VSS
+ gf180mcu_as_sc_mcu7t3v3__inv_2_1013/Y VSS gf180mcu_as_sc_mcu7t3v3__inv_2_1058/VNW
+ VSUBS gf180mcu_as_sc_mcu7t3v3__inv_2
Xgf180mcu_as_sc_mcu7t3v3__inv_2_32 gf180mcu_as_sc_mcu7t3v3__inv_2_32/VDD gf180mcu_as_sc_mcu7t3v3__inv_2_4/VDD
+ gf180mcu_as_sc_mcu7t3v3__inv_2_66/Y VSS gf180mcu_as_sc_mcu7t3v3__inv_2_32/VNW VSUBS
+ gf180mcu_as_sc_mcu7t3v3__inv_2
Xgf180mcu_as_sc_mcu7t3v3__inv_2_10 gf180mcu_as_sc_mcu7t3v3__inv_2_8/VSS gf180mcu_as_sc_mcu7t3v3__inv_2_8/VSS
+ VSS gf180mcu_as_sc_mcu7t3v3__inv_2_24/Y gf180mcu_as_sc_mcu7t3v3__inv_2_12/VNW VSUBS
+ gf180mcu_as_sc_mcu7t3v3__inv_2
Xgf180mcu_as_sc_mcu7t3v3__inv_2_98 gf180mcu_as_sc_mcu7t3v3__inv_2_98/VDD VSS gf180mcu_as_sc_mcu7t3v3__inv_2_98/Y
+ VSS gf180mcu_as_sc_mcu7t3v3__inv_2_98/VNW VSUBS gf180mcu_as_sc_mcu7t3v3__inv_2
Xgf180mcu_as_sc_mcu7t3v3__inv_2_87 gf180mcu_as_sc_mcu7t3v3__inv_2_98/VDD VSS VSS VSS
+ gf180mcu_as_sc_mcu7t3v3__inv_2_98/VNW VSUBS gf180mcu_as_sc_mcu7t3v3__inv_2
Xgf180mcu_as_sc_mcu7t3v3__inv_2_43 gf180mcu_as_sc_mcu7t3v3__inv_2_0/VSS gf180mcu_as_sc_mcu7t3v3__inv_2_49/VDD
+ gf180mcu_as_sc_mcu7t3v3__inv_2_9/Y VSS gf180mcu_as_sc_mcu7t3v3__inv_2_43/VNW VSUBS
+ gf180mcu_as_sc_mcu7t3v3__inv_2
Xgf180mcu_as_sc_mcu7t3v3__inv_2_54 gf180mcu_as_sc_mcu7t3v3__inv_2_62/VDD VSS VSS gf180mcu_as_sc_mcu7t3v3__inv_2_9/Y
+ gf180mcu_as_sc_mcu7t3v3__inv_2_62/VNW VSUBS gf180mcu_as_sc_mcu7t3v3__inv_2
Xgf180mcu_as_sc_mcu7t3v3__inv_2_21 gf180mcu_as_sc_mcu7t3v3__inv_2_9/VSS gf180mcu_as_sc_mcu7t3v3__inv_2_38/VDD
+ gf180mcu_as_sc_mcu7t3v3__inv_2_21/Y gf180mcu_as_sc_mcu7t3v3__inv_2_9/Y gf180mcu_as_sc_mcu7t3v3__inv_2_25/VNW
+ VSUBS gf180mcu_as_sc_mcu7t3v3__inv_2
Xgf180mcu_as_sc_mcu7t3v3__inv_2_76 gf180mcu_as_sc_mcu7t3v3__inv_2_9/VDD gf180mcu_as_sc_mcu7t3v3__inv_2_9/VDD
+ gf180mcu_as_sc_mcu7t3v3__inv_2_9/Y gf180mcu_as_sc_mcu7t3v3__inv_2_9/Y gf180mcu_as_sc_mcu7t3v3__inv_2_77/VNW
+ VSUBS gf180mcu_as_sc_mcu7t3v3__inv_2
Xgf180mcu_as_sc_mcu7t3v3__inv_2_65 gf180mcu_as_sc_mcu7t3v3__inv_2_69/VDD gf180mcu_as_sc_mcu7t3v3__inv_2_69/VDD
+ gf180mcu_as_sc_mcu7t3v3__inv_2_73/Y VSS gf180mcu_as_sc_mcu7t3v3__inv_2_65/VNW VSUBS
+ gf180mcu_as_sc_mcu7t3v3__inv_2
Xgf180mcu_as_sc_mcu7t3v3__inv_2_1002 VSS VSS VSS gf180mcu_as_sc_mcu7t3v3__inv_2_1724/A
+ gf180mcu_as_sc_mcu7t3v3__inv_2_1004/VNW VSUBS gf180mcu_as_sc_mcu7t3v3__inv_2
Xgf180mcu_as_sc_mcu7t3v3__inv_2_1024 VSS gf180mcu_as_sc_mcu7t3v3__inv_2_1061/VDD gf180mcu_as_sc_mcu7t3v3__inv_2_1024/Y
+ VSS gf180mcu_as_sc_mcu7t3v3__inv_2_1024/VNW VSUBS gf180mcu_as_sc_mcu7t3v3__inv_2
Xgf180mcu_as_sc_mcu7t3v3__inv_2_1068 VSS gf180mcu_as_sc_mcu7t3v3__inv_2_1100/VSS gf180mcu_as_sc_mcu7t3v3__inv_2_1100/A
+ VSS gf180mcu_as_sc_mcu7t3v3__inv_2_1100/VNW VSUBS gf180mcu_as_sc_mcu7t3v3__inv_2
Xgf180mcu_as_sc_mcu7t3v3__inv_2_1079 gf180mcu_as_sc_mcu7t3v3__inv_2_1079/VDD VSS gf180mcu_as_sc_mcu7t3v3__inv_2_1079/Y
+ VSS gf180mcu_as_sc_mcu7t3v3__inv_2_1079/VNW VSUBS gf180mcu_as_sc_mcu7t3v3__inv_2
Xgf180mcu_as_sc_mcu7t3v3__inv_2_1035 gf180mcu_as_sc_mcu7t3v3__inv_2_1036/VDD gf180mcu_as_sc_mcu7t3v3__inv_2_1036/VSS
+ gf180mcu_as_sc_mcu7t3v3__inv_2_1035/Y gf180mcu_as_sc_mcu7t3v3__inv_2_1036/Y gf180mcu_as_sc_mcu7t3v3__inv_2_1036/VNW
+ VSUBS gf180mcu_as_sc_mcu7t3v3__inv_2
Xgf180mcu_as_sc_mcu7t3v3__inv_2_1057 VSS VSS VSS gf180mcu_as_sc_mcu7t3v3__inv_2_1057/A
+ gf180mcu_as_sc_mcu7t3v3__inv_2_1057/VNW VSUBS gf180mcu_as_sc_mcu7t3v3__inv_2
Xgf180mcu_as_sc_mcu7t3v3__inv_2_1046 gf180mcu_as_sc_mcu7t3v3__inv_2_1048/VDD gf180mcu_as_sc_mcu7t3v3__inv_2_1052/VDD
+ VSS gf180mcu_as_sc_mcu7t3v3__inv_2_962/A gf180mcu_as_sc_mcu7t3v3__inv_2_1048/VNW
+ VSUBS gf180mcu_as_sc_mcu7t3v3__inv_2
Xgf180mcu_as_sc_mcu7t3v3__inv_2_519 VSS VSS VSS VSS gf180mcu_as_sc_mcu7t3v3__inv_2_560/VNW
+ VSUBS gf180mcu_as_sc_mcu7t3v3__inv_2
Xgf180mcu_as_sc_mcu7t3v3__inv_2_508 VSS VSS VSS VSS gf180mcu_as_sc_mcu7t3v3__inv_2_539/VNW
+ VSUBS gf180mcu_as_sc_mcu7t3v3__inv_2
Xgf180mcu_as_sc_mcu7t3v3__inv_2_1580 gf180mcu_as_sc_mcu7t3v3__inv_2_1582/VDD VSS VSS
+ VSS gf180mcu_as_sc_mcu7t3v3__inv_2_1582/VNW VSUBS gf180mcu_as_sc_mcu7t3v3__inv_2
Xgf180mcu_as_sc_mcu7t3v3__inv_2_1591 gf180mcu_as_sc_mcu7t3v3__inv_2_1591/VDD gf180mcu_as_sc_mcu7t3v3__inv_2_1594/VDD
+ gf180mcu_as_sc_mcu7t3v3__inv_2_1591/Y VSS gf180mcu_as_sc_mcu7t3v3__inv_2_1591/VNW
+ VSUBS gf180mcu_as_sc_mcu7t3v3__inv_2
Xgf180mcu_as_sc_mcu7t3v3__nand3_2_2 gf180mcu_as_sc_mcu7t3v3__nor2_2_7/VDD gf180mcu_as_sc_mcu7t3v3__nand3_2_4/VSS
+ VSS VSS VSS VSS gf180mcu_as_sc_mcu7t3v3__nor2_2_7/VNW VSUBS gf180mcu_as_sc_mcu7t3v3__nand3_2
Xgf180mcu_as_sc_mcu7t3v3__nand4_2_374 VSS VSS VSS VSS VSS VSS VSS gf180mcu_as_sc_mcu7t3v3__inv_2_1275/VNW
+ VSUBS gf180mcu_as_sc_mcu7t3v3__nand4_2
Xgf180mcu_as_sc_mcu7t3v3__nand4_2_341 gf180mcu_as_sc_mcu7t3v3__inv_2_1148/VDD gf180mcu_as_sc_mcu7t3v3__inv_2_1148/VSS
+ VSS VSS VSS VSS VSS gf180mcu_as_sc_mcu7t3v3__inv_2_1148/VNW VSUBS gf180mcu_as_sc_mcu7t3v3__nand4_2
Xgf180mcu_as_sc_mcu7t3v3__nand4_2_363 VSS VSS VSS VSS VSS VSS gf180mcu_as_sc_mcu7t3v3__nand4_2_363/Y
+ gf180mcu_as_sc_mcu7t3v3__inv_2_1297/VNW VSUBS gf180mcu_as_sc_mcu7t3v3__nand4_2
Xgf180mcu_as_sc_mcu7t3v3__nand4_2_352 VSS VSS VSS VSS VSS VSS gf180mcu_as_sc_mcu7t3v3__nand4_2_352/Y
+ gf180mcu_as_sc_mcu7t3v3__inv_2_1300/VNW VSUBS gf180mcu_as_sc_mcu7t3v3__nand4_2
Xgf180mcu_as_sc_mcu7t3v3__nand4_2_330 gf180mcu_as_sc_mcu7t3v3__inv_2_1111/VSS VSS
+ VSS VSS VSS VSS VSS gf180mcu_as_sc_mcu7t3v3__inv_2_1064/VNW VSUBS gf180mcu_as_sc_mcu7t3v3__nand4_2
Xgf180mcu_as_sc_mcu7t3v3__nand4_2_385 gf180mcu_as_sc_mcu7t3v3__inv_2_1511/VSS VSS
+ VSS VSS VSS VSS gf180mcu_as_sc_mcu7t3v3__nand4_2_385/Y gf180mcu_as_sc_mcu7t3v3__inv_2_1425/VNW
+ VSUBS gf180mcu_as_sc_mcu7t3v3__nand4_2
Xgf180mcu_as_sc_mcu7t3v3__nand4_2_396 gf180mcu_as_sc_mcu7t3v3__inv_2_1508/VSS VSS
+ VSS VSS VSS VSS VSS gf180mcu_as_sc_mcu7t3v3__inv_2_1479/VNW VSUBS gf180mcu_as_sc_mcu7t3v3__nand4_2
Xgf180mcu_as_sc_mcu7t3v3__inv_2_305 gf180mcu_as_sc_mcu7t3v3__inv_2_307/VDD gf180mcu_as_sc_mcu7t3v3__inv_2_311/VDD
+ VSS gf180mcu_as_sc_mcu7t3v3__inv_2_365/Y gf180mcu_as_sc_mcu7t3v3__inv_2_307/VNW
+ VSUBS gf180mcu_as_sc_mcu7t3v3__inv_2
Xgf180mcu_as_sc_mcu7t3v3__inv_2_316 VSS gf180mcu_as_sc_mcu7t3v3__inv_2_320/VDD gf180mcu_as_sc_mcu7t3v3__inv_2_316/Y
+ gf180mcu_as_sc_mcu7t3v3__inv_2_341/Y gf180mcu_as_sc_mcu7t3v3__inv_2_317/VNW VSUBS
+ gf180mcu_as_sc_mcu7t3v3__inv_2
Xgf180mcu_as_sc_mcu7t3v3__inv_2_349 gf180mcu_as_sc_mcu7t3v3__inv_2_350/VDD VSS gf180mcu_as_sc_mcu7t3v3__inv_2_349/Y
+ gf180mcu_as_sc_mcu7t3v3__inv_2_350/Y gf180mcu_as_sc_mcu7t3v3__inv_2_350/VNW VSUBS
+ gf180mcu_as_sc_mcu7t3v3__inv_2
Xgf180mcu_as_sc_mcu7t3v3__inv_2_338 gf180mcu_as_sc_mcu7t3v3__inv_2_338/VDD gf180mcu_as_sc_mcu7t3v3__inv_2_341/VDD
+ gf180mcu_as_sc_mcu7t3v3__inv_2_341/Y VSS gf180mcu_as_sc_mcu7t3v3__inv_2_338/VNW
+ VSUBS gf180mcu_as_sc_mcu7t3v3__inv_2
Xgf180mcu_as_sc_mcu7t3v3__inv_2_327 gf180mcu_as_sc_mcu7t3v3__inv_2_329/VDD gf180mcu_as_sc_mcu7t3v3__inv_2_332/VDD
+ VSS gf180mcu_as_sc_mcu7t3v3__inv_2_341/Y gf180mcu_as_sc_mcu7t3v3__inv_2_329/VNW
+ VSUBS gf180mcu_as_sc_mcu7t3v3__inv_2
Xgf180mcu_as_sc_mcu7t3v3__inv_2_850 VSS VSS VSS VSS gf180mcu_as_sc_mcu7t3v3__inv_2_850/VNW
+ VSUBS gf180mcu_as_sc_mcu7t3v3__inv_2
Xgf180mcu_as_sc_mcu7t3v3__inv_2_872 VSS VSS gf180mcu_as_sc_mcu7t3v3__inv_2_872/Y VSS
+ gf180mcu_as_sc_mcu7t3v3__inv_2_940/VNW VSUBS gf180mcu_as_sc_mcu7t3v3__inv_2
Xgf180mcu_as_sc_mcu7t3v3__inv_2_861 VSS VSS gf180mcu_as_sc_mcu7t3v3__inv_2_861/Y VSS
+ gf180mcu_as_sc_mcu7t3v3__inv_2_937/VNW VSUBS gf180mcu_as_sc_mcu7t3v3__inv_2
Xgf180mcu_as_sc_mcu7t3v3__inv_2_883 VSS VSS gf180mcu_as_sc_mcu7t3v3__inv_2_883/Y VSS
+ gf180mcu_as_sc_mcu7t3v3__inv_2_941/VNW VSUBS gf180mcu_as_sc_mcu7t3v3__inv_2
Xgf180mcu_as_sc_mcu7t3v3__inv_2_894 VSS VSS VSS VSS gf180mcu_as_sc_mcu7t3v3__inv_2_957/VNW
+ VSUBS gf180mcu_as_sc_mcu7t3v3__inv_2
Xu_t026_010 u_t026_010/c0_w0_bl u_t026_010/c0_w0_br u_t026_010/c0_w1_bl u_t026_010/c0_w1_br
+ u_t026_010/c0_r0_rbl u_t026_010/c0_r1_rbl u_t026_010/c1_w0_bl u_t026_010/c1_w0_br
+ u_t026_010/c1_w1_bl u_t026_010/c1_w1_br u_t026_010/c1_r0_rbl u_t026_010/c1_r1_rbl
+ u_t026_010/c2_w0_bl u_t026_010/c2_w0_br u_t026_010/c2_w1_bl u_t026_010/c2_w1_br
+ u_t026_010/c2_r0_rbl u_t026_010/c2_r1_rbl u_t026_010/c3_w0_bl u_t026_010/c3_w0_br
+ u_t026_010/c3_w1_bl u_t026_010/c3_w1_br u_t026_010/c3_r0_rbl u_t026_010/c3_r1_rbl
+ u_t026_010/r0_w0_wl u_t026_010/r0_w1_wl u_t026_010/r0_r0_rwl u_t026_010/r0_r1_rwl
+ u_t026_010/r1_w0_wl u_t026_010/r1_w1_wl u_t026_010/r1_r0_rwl u_t026_010/r1_r1_rwl
+ u_t026_010/r2_w0_wl u_t026_010/r2_w1_wl u_t026_010/r2_r0_rwl u_t026_010/r2_r1_rwl
+ u_t026_010/r3_w0_wl u_t026_010/r3_w1_wl u_t026_010/r3_r0_rwl u_t026_010/r3_r1_rwl
+ VSS VSS u_t026_010/m2_717_1265# u_t026_010/m2_603_2031# u_t026_010/m2_1290_336#
+ u_t026_010/m2_2000_2037# u_t026_010/m2_791_2909# u_t026_010/m2_7_2126# u_t026_010/m2_2154_2081#
+ u_t026_010/m2_1795_2037# u_t026_010/m2_871_303# u_t026_010/m2_431_438# u_t026_010/m2_1290_2898#
+ u_t026_010/m2_1714_1210# u_t026_010/m2_431_1982# u_t026_010/m2_512_1265# u_t026_010/m2_2573_2126#
+ u_t026_010/m2_603_1259# u_t026_010/m2_2074_2909# u_t026_010/m2_7_336# u_t026_010/m2_717_2037#
+ u_t026_010/m2_1886_2031# u_t026_010/m2_2573_336# u_t026_010/m2_7_2898# u_t026_010/m2_2000_1265#
+ u_t026_010/m2_512_2037# u_t026_010/m2_1795_1265# u_t026_010/m2_1714_1982# u_t026_010/m2_1886_1259#
+ u_t026_010/m2_1290_2126# u_t026_010/m2_1714_438# u_t026_010/m2_431_1210# u_t026_010/m2_2573_2898#
+ u_t026_010/m2_2154_303# u_t026_010/m2_871_2081# VSUBS detronyx_12t_2w2r_rc4_4x4_routed_5layer_direct
Xgf180mcu_as_sc_mcu7t3v3__nand4_2_160 gf180mcu_as_sc_mcu7t3v3__inv_2_579/VDD gf180mcu_as_sc_mcu7t3v3__inv_2_584/VDD
+ VSS VSS VSS VSS VSS gf180mcu_as_sc_mcu7t3v3__inv_2_579/VNW VSUBS gf180mcu_as_sc_mcu7t3v3__nand4_2
Xgf180mcu_as_sc_mcu7t3v3__nand4_2_171 gf180mcu_as_sc_mcu7t3v3__inv_2_606/VDD VSS VSS
+ VSS VSS VSS VSS gf180mcu_as_sc_mcu7t3v3__inv_2_606/VNW VSUBS gf180mcu_as_sc_mcu7t3v3__nand4_2
Xgf180mcu_as_sc_mcu7t3v3__nand4_2_182 VSS gf180mcu_as_sc_mcu7t3v3__inv_2_737/VSS VSS
+ VSS VSS VSS VSS gf180mcu_as_sc_mcu7t3v3__inv_2_737/VNW VSUBS gf180mcu_as_sc_mcu7t3v3__nand4_2
Xgf180mcu_as_sc_mcu7t3v3__nand4_2_193 gf180mcu_as_sc_mcu7t3v3__inv_2_743/VDD gf180mcu_as_sc_mcu7t3v3__inv_2_743/VSS
+ VSS VSS VSS VSS VSS gf180mcu_as_sc_mcu7t3v3__inv_2_743/VNW VSUBS gf180mcu_as_sc_mcu7t3v3__nand4_2
Xu_t017_010 u_t017_010/c0_w0_bl u_t017_010/c0_w0_br u_t017_010/c0_w1_bl u_t017_010/c0_w1_br
+ u_t017_010/c0_r0_rbl u_t017_010/c0_r1_rbl u_t017_010/c1_w0_bl u_t017_010/c1_w0_br
+ u_t017_010/c1_w1_bl u_t017_010/c1_w1_br u_t017_010/c1_r0_rbl u_t017_010/c1_r1_rbl
+ u_t017_010/c2_w0_bl u_t017_010/c2_w0_br u_t017_010/c2_w1_bl u_t017_010/c2_w1_br
+ u_t017_010/c2_r0_rbl u_t017_010/c2_r1_rbl u_t017_010/c3_w0_bl u_t017_010/c3_w0_br
+ u_t017_010/c3_w1_bl u_t017_010/c3_w1_br u_t017_010/c3_r0_rbl u_t017_010/c3_r1_rbl
+ u_t017_010/r0_w0_wl u_t017_010/r0_w1_wl u_t017_010/r0_r0_rwl u_t017_010/r0_r1_rwl
+ u_t017_010/r1_w0_wl u_t017_010/r1_w1_wl u_t017_010/r1_r0_rwl u_t017_010/r1_r1_rwl
+ u_t017_010/r2_w0_wl u_t017_010/r2_w1_wl u_t017_010/r2_r0_rwl u_t017_010/r2_r1_rwl
+ u_t017_010/r3_w0_wl u_t017_010/r3_w1_wl u_t017_010/r3_r0_rwl u_t017_010/r3_r1_rwl
+ VSS VSS u_t017_010/m2_717_1265# u_t017_010/m2_603_2031# u_t017_010/m2_1290_336#
+ u_t017_010/m2_2000_2037# u_t017_010/m2_791_2909# u_t017_010/m2_7_2126# u_t017_010/m2_2154_2081#
+ u_t017_010/m2_1795_2037# u_t017_010/m2_871_303# u_t017_010/m2_431_438# u_t017_010/m2_1290_2898#
+ u_t017_010/m2_1714_1210# u_t017_010/m2_431_1982# u_t017_010/m2_512_1265# u_t017_010/m2_2573_2126#
+ u_t017_010/m2_603_1259# u_t017_010/m2_2074_2909# u_t017_010/m2_7_336# u_t017_010/m2_717_2037#
+ u_t017_010/m2_1886_2031# u_t017_010/m2_2573_336# u_t017_010/m2_7_2898# u_t017_010/m2_2000_1265#
+ u_t017_010/m2_512_2037# u_t017_010/m2_1795_1265# u_t017_010/m2_1714_1982# u_t017_010/m2_1886_1259#
+ u_t017_010/m2_1290_2126# u_t017_010/m2_1714_438# u_t017_010/m2_431_1210# u_t017_010/m2_2573_2898#
+ u_t017_010/m2_2154_303# u_t017_010/m2_871_2081# VSUBS detronyx_12t_2w2r_rc4_4x4_routed_5layer_direct
Xgf180mcu_as_sc_mcu7t3v3__inv_2_102 gf180mcu_as_sc_mcu7t3v3__inv_2_91/VSS gf180mcu_as_sc_mcu7t3v3__inv_2_91/VSS
+ VSS VSS gf180mcu_as_sc_mcu7t3v3__nand4_2_3/VNW VSUBS gf180mcu_as_sc_mcu7t3v3__inv_2
Xgf180mcu_as_sc_mcu7t3v3__inv_2_146 gf180mcu_as_sc_mcu7t3v3__inv_2_146/VDD VSS VSS
+ VSS gf180mcu_as_sc_mcu7t3v3__inv_2_146/VNW VSUBS gf180mcu_as_sc_mcu7t3v3__inv_2
Xgf180mcu_as_sc_mcu7t3v3__inv_2_135 gf180mcu_as_sc_mcu7t3v3__inv_2_137/VDD VSS gf180mcu_as_sc_mcu7t3v3__inv_2_135/Y
+ VSS gf180mcu_as_sc_mcu7t3v3__inv_2_137/VNW VSUBS gf180mcu_as_sc_mcu7t3v3__inv_2
Xgf180mcu_as_sc_mcu7t3v3__inv_2_124 gf180mcu_as_sc_mcu7t3v3__inv_2_125/VDD gf180mcu_as_sc_mcu7t3v3__inv_2_131/VDD
+ gf180mcu_as_sc_mcu7t3v3__inv_2_124/Y VSS gf180mcu_as_sc_mcu7t3v3__inv_2_125/VNW
+ VSUBS gf180mcu_as_sc_mcu7t3v3__inv_2
Xgf180mcu_as_sc_mcu7t3v3__inv_2_113 gf180mcu_as_sc_mcu7t3v3__inv_2_113/VDD gf180mcu_as_sc_mcu7t3v3__inv_2_116/VDD
+ gf180mcu_as_sc_mcu7t3v3__inv_2_113/Y VSS gf180mcu_as_sc_mcu7t3v3__inv_2_113/VNW
+ VSUBS gf180mcu_as_sc_mcu7t3v3__inv_2
Xgf180mcu_as_sc_mcu7t3v3__inv_2_168 VSS gf180mcu_as_sc_mcu7t3v3__inv_2_171/VDD gf180mcu_as_sc_mcu7t3v3__inv_2_168/Y
+ VSS gf180mcu_as_sc_mcu7t3v3__inv_2_168/VNW VSUBS gf180mcu_as_sc_mcu7t3v3__inv_2
Xgf180mcu_as_sc_mcu7t3v3__inv_2_157 gf180mcu_as_sc_mcu7t3v3__inv_2_177/VDD gf180mcu_as_sc_mcu7t3v3__inv_2_177/VSS
+ VSS VSS gf180mcu_as_sc_mcu7t3v3__inv_2_177/VNW VSUBS gf180mcu_as_sc_mcu7t3v3__inv_2
Xgf180mcu_as_sc_mcu7t3v3__inv_2_179 VSS gf180mcu_as_sc_mcu7t3v3__inv_2_182/VDD VSS
+ VSS gf180mcu_as_sc_mcu7t3v3__inv_2_180/VNW VSUBS gf180mcu_as_sc_mcu7t3v3__inv_2
Xu_t008_010 u_t008_010/c0_w0_bl u_t008_010/c0_w0_br u_t008_010/c0_w1_bl u_t008_010/c0_w1_br
+ u_t008_010/c0_r0_rbl u_t008_010/c0_r1_rbl u_t008_010/c1_w0_bl u_t008_010/c1_w0_br
+ u_t008_010/c1_w1_bl u_t008_010/c1_w1_br u_t008_010/c1_r0_rbl u_t008_010/c1_r1_rbl
+ u_t008_010/c2_w0_bl u_t008_010/c2_w0_br u_t008_010/c2_w1_bl u_t008_010/c2_w1_br
+ u_t008_010/c2_r0_rbl u_t008_010/c2_r1_rbl u_t008_010/c3_w0_bl u_t008_010/c3_w0_br
+ u_t008_010/c3_w1_bl u_t008_010/c3_w1_br u_t008_010/c3_r0_rbl u_t008_010/c3_r1_rbl
+ u_t008_010/r0_w0_wl u_t008_010/r0_w1_wl u_t008_010/r0_r0_rwl u_t008_010/r0_r1_rwl
+ u_t008_010/r1_w0_wl u_t008_010/r1_w1_wl u_t008_010/r1_r0_rwl u_t008_010/r1_r1_rwl
+ u_t008_010/r2_w0_wl u_t008_010/r2_w1_wl u_t008_010/r2_r0_rwl u_t008_010/r2_r1_rwl
+ u_t008_010/r3_w0_wl u_t008_010/r3_w1_wl u_t008_010/r3_r0_rwl u_t008_010/r3_r1_rwl
+ VSS VSS u_t008_010/m2_717_1265# u_t008_010/m2_603_2031# u_t008_010/m2_1290_336#
+ u_t008_010/m2_2000_2037# u_t008_010/m2_791_2909# u_t008_010/m2_7_2126# u_t008_010/m2_2154_2081#
+ u_t008_010/m2_1795_2037# u_t008_010/m2_871_303# u_t008_010/m2_431_438# u_t008_010/m2_1290_2898#
+ u_t008_010/m2_1714_1210# u_t008_010/m2_431_1982# u_t008_010/m2_512_1265# u_t008_010/m2_2573_2126#
+ u_t008_010/m2_603_1259# u_t008_010/m2_2074_2909# u_t008_010/m2_7_336# u_t008_010/m2_717_2037#
+ u_t008_010/m2_1886_2031# u_t008_010/m2_2573_336# u_t008_010/m2_7_2898# u_t008_010/m2_2000_1265#
+ u_t008_010/m2_512_2037# u_t008_010/m2_1795_1265# u_t008_010/m2_1714_1982# u_t008_010/m2_1886_1259#
+ u_t008_010/m2_1290_2126# u_t008_010/m2_1714_438# u_t008_010/m2_431_1210# u_t008_010/m2_2573_2898#
+ u_t008_010/m2_2154_303# u_t008_010/m2_871_2081# VSUBS detronyx_12t_2w2r_rc4_4x4_routed_5layer_direct
Xu_t023_013 u_t023_013/c0_w0_bl u_t023_013/c0_w0_br u_t023_013/c0_w1_bl u_t023_013/c0_w1_br
+ u_t023_013/c0_r0_rbl u_t023_013/c0_r1_rbl u_t023_013/c1_w0_bl u_t023_013/c1_w0_br
+ u_t023_013/c1_w1_bl u_t023_013/c1_w1_br u_t023_013/c1_r0_rbl u_t023_013/c1_r1_rbl
+ u_t023_013/c2_w0_bl u_t023_013/c2_w0_br u_t023_013/c2_w1_bl u_t023_013/c2_w1_br
+ u_t023_013/c2_r0_rbl u_t023_013/c2_r1_rbl u_t023_013/c3_w0_bl u_t023_013/c3_w0_br
+ u_t023_013/c3_w1_bl u_t023_013/c3_w1_br u_t023_013/c3_r0_rbl u_t023_013/c3_r1_rbl
+ u_t023_013/r0_w0_wl u_t023_013/r0_w1_wl u_t023_013/r0_r0_rwl u_t023_013/r0_r1_rwl
+ u_t023_013/r1_w0_wl u_t023_013/r1_w1_wl u_t023_013/r1_r0_rwl u_t023_013/r1_r1_rwl
+ u_t023_013/r2_w0_wl u_t023_013/r2_w1_wl u_t023_013/r2_r0_rwl u_t023_013/r2_r1_rwl
+ u_t023_013/r3_w0_wl u_t023_013/r3_w1_wl u_t023_013/r3_r0_rwl u_t023_013/r3_r1_rwl
+ u_t023_013/VDD u_t023_013/VSS u_t023_013/m2_717_1265# u_t023_013/m2_603_2031# u_t023_013/m2_1290_336#
+ u_t023_013/m2_2000_2037# u_t023_013/m2_791_2909# u_t023_013/m2_7_2126# u_t023_013/m2_2154_2081#
+ u_t023_013/m2_1795_2037# u_t023_013/m2_871_303# u_t023_013/m2_431_438# u_t023_013/m2_1290_2898#
+ u_t023_013/m2_1714_1210# u_t023_013/m2_431_1982# u_t023_013/m2_512_1265# u_t023_013/m2_2573_2126#
+ u_t023_013/m2_603_1259# u_t023_013/m2_2074_2909# u_t023_013/m2_7_336# u_t023_013/m2_717_2037#
+ u_t023_013/m2_1886_2031# u_t023_013/m2_2573_336# u_t023_013/m2_7_2898# u_t023_013/m2_2000_1265#
+ u_t023_013/m2_512_2037# u_t023_013/m2_1795_1265# u_t023_013/m2_1714_1982# u_t023_013/m2_1886_1259#
+ u_t023_013/m2_1290_2126# u_t023_013/m2_1714_438# u_t023_013/m2_431_1210# u_t023_013/m2_2573_2898#
+ u_t023_013/m2_2154_303# u_t023_013/m2_871_2081# VSUBS detronyx_12t_2w2r_rc4_4x4_routed_5layer_direct
Xu_t023_002 u_t023_002/c0_w0_bl u_t023_002/c0_w0_br u_t023_002/c0_w1_bl u_t023_002/c0_w1_br
+ u_t023_002/c0_r0_rbl u_t023_002/c0_r1_rbl u_t023_002/c1_w0_bl u_t023_002/c1_w0_br
+ u_t023_002/c1_w1_bl u_t023_002/c1_w1_br u_t023_002/c1_r0_rbl u_t023_002/c1_r1_rbl
+ u_t023_002/c2_w0_bl u_t023_002/c2_w0_br u_t023_002/c2_w1_bl u_t023_002/c2_w1_br
+ u_t023_002/c2_r0_rbl u_t023_002/c2_r1_rbl u_t023_002/c3_w0_bl u_t023_002/c3_w0_br
+ u_t023_002/c3_w1_bl u_t023_002/c3_w1_br u_t023_002/c3_r0_rbl u_t023_002/c3_r1_rbl
+ u_t023_002/r0_w0_wl u_t023_002/r0_w1_wl u_t023_002/r0_r0_rwl u_t023_002/r0_r1_rwl
+ u_t023_002/r1_w0_wl u_t023_002/r1_w1_wl u_t023_002/r1_r0_rwl u_t023_002/r1_r1_rwl
+ u_t023_002/r2_w0_wl u_t023_002/r2_w1_wl u_t023_002/r2_r0_rwl u_t023_002/r2_r1_rwl
+ u_t023_002/r3_w0_wl u_t023_002/r3_w1_wl u_t023_002/r3_r0_rwl u_t023_002/r3_r1_rwl
+ VSS VSS u_t023_002/m2_717_1265# u_t023_002/m2_603_2031# u_t023_002/m2_1290_336#
+ u_t023_002/m2_2000_2037# u_t023_002/m2_791_2909# u_t023_002/m2_7_2126# u_t023_002/m2_2154_2081#
+ u_t023_002/m2_1795_2037# u_t023_002/m2_871_303# u_t023_002/m2_431_438# u_t023_002/m2_1290_2898#
+ u_t023_002/m2_1714_1210# u_t023_002/m2_431_1982# u_t023_002/m2_512_1265# u_t023_002/m2_2573_2126#
+ u_t023_002/m2_603_1259# u_t023_002/m2_2074_2909# u_t023_002/m2_7_336# u_t023_002/m2_717_2037#
+ u_t023_002/m2_1886_2031# u_t023_002/m2_2573_336# u_t023_002/m2_7_2898# u_t023_002/m2_2000_1265#
+ u_t023_002/m2_512_2037# u_t023_002/m2_1795_1265# u_t023_002/m2_1714_1982# u_t023_002/m2_1886_1259#
+ u_t023_002/m2_1290_2126# u_t023_002/m2_1714_438# u_t023_002/m2_431_1210# u_t023_002/m2_2573_2898#
+ u_t023_002/m2_2154_303# u_t023_002/m2_871_2081# VSUBS detronyx_12t_2w2r_rc4_4x4_routed_5layer_direct
Xgf180mcu_as_sc_mcu7t3v3__inv_2_691 VSS VSS gf180mcu_as_sc_mcu7t3v3__inv_2_853/Y gf180mcu_as_sc_mcu7t3v3__inv_2_692/Y
+ gf180mcu_as_sc_mcu7t3v3__inv_2_692/VNW VSUBS gf180mcu_as_sc_mcu7t3v3__inv_2
Xgf180mcu_as_sc_mcu7t3v3__inv_2_680 VSS VSS gf180mcu_as_sc_mcu7t3v3__inv_2_680/Y VSS
+ gf180mcu_as_sc_mcu7t3v3__inv_2_680/VNW VSUBS gf180mcu_as_sc_mcu7t3v3__inv_2
Xu_t014_013 u_t014_013/c0_w0_bl u_t014_013/c0_w0_br u_t014_013/c0_w1_bl u_t014_013/c0_w1_br
+ u_t014_013/c0_r0_rbl u_t014_013/c0_r1_rbl u_t014_013/c1_w0_bl u_t014_013/c1_w0_br
+ u_t014_013/c1_w1_bl u_t014_013/c1_w1_br u_t014_013/c1_r0_rbl u_t014_013/c1_r1_rbl
+ u_t014_013/c2_w0_bl u_t014_013/c2_w0_br u_t014_013/c2_w1_bl u_t014_013/c2_w1_br
+ u_t014_013/c2_r0_rbl u_t014_013/c2_r1_rbl u_t014_013/c3_w0_bl u_t014_013/c3_w0_br
+ u_t014_013/c3_w1_bl u_t014_013/c3_w1_br u_t014_013/c3_r0_rbl u_t014_013/c3_r1_rbl
+ u_t014_013/r0_w0_wl u_t014_013/r0_w1_wl u_t014_013/r0_r0_rwl u_t014_013/r0_r1_rwl
+ u_t014_013/r1_w0_wl u_t014_013/r1_w1_wl u_t014_013/r1_r0_rwl u_t014_013/r1_r1_rwl
+ u_t014_013/r2_w0_wl u_t014_013/r2_w1_wl u_t014_013/r2_r0_rwl u_t014_013/r2_r1_rwl
+ u_t014_013/r3_w0_wl u_t014_013/r3_w1_wl u_t014_013/r3_r0_rwl u_t014_013/r3_r1_rwl
+ u_t014_013/VDD u_t014_013/VSS u_t014_013/m2_717_1265# u_t014_013/m2_603_2031# u_t014_013/m2_1290_336#
+ u_t014_013/m2_2000_2037# u_t014_013/m2_791_2909# u_t014_013/m2_7_2126# u_t014_013/m2_2154_2081#
+ u_t014_013/m2_1795_2037# u_t014_013/m2_871_303# u_t014_013/m2_431_438# u_t014_013/m2_1290_2898#
+ u_t014_013/m2_1714_1210# u_t014_013/m2_431_1982# u_t014_013/m2_512_1265# u_t014_013/m2_2573_2126#
+ u_t014_013/m2_603_1259# u_t014_013/m2_2074_2909# u_t014_013/m2_7_336# u_t014_013/m2_717_2037#
+ u_t014_013/m2_1886_2031# u_t014_013/m2_2573_336# u_t014_013/m2_7_2898# u_t014_013/m2_2000_1265#
+ u_t014_013/m2_512_2037# u_t014_013/m2_1795_1265# u_t014_013/m2_1714_1982# u_t014_013/m2_1886_1259#
+ u_t014_013/m2_1290_2126# u_t014_013/m2_1714_438# u_t014_013/m2_431_1210# u_t014_013/m2_2573_2898#
+ u_t014_013/m2_2154_303# u_t014_013/m2_871_2081# VSUBS detronyx_12t_2w2r_rc4_4x4_routed_5layer_direct
Xu_t014_002 u_t014_002/c0_w0_bl u_t014_002/c0_w0_br u_t014_002/c0_w1_bl u_t014_002/c0_w1_br
+ u_t014_002/c0_r0_rbl u_t014_002/c0_r1_rbl u_t014_002/c1_w0_bl u_t014_002/c1_w0_br
+ u_t014_002/c1_w1_bl u_t014_002/c1_w1_br u_t014_002/c1_r0_rbl u_t014_002/c1_r1_rbl
+ u_t014_002/c2_w0_bl u_t014_002/c2_w0_br u_t014_002/c2_w1_bl u_t014_002/c2_w1_br
+ u_t014_002/c2_r0_rbl u_t014_002/c2_r1_rbl u_t014_002/c3_w0_bl u_t014_002/c3_w0_br
+ u_t014_002/c3_w1_bl u_t014_002/c3_w1_br u_t014_002/c3_r0_rbl u_t014_002/c3_r1_rbl
+ u_t014_002/r0_w0_wl u_t014_002/r0_w1_wl u_t014_002/r0_r0_rwl u_t014_002/r0_r1_rwl
+ u_t014_002/r1_w0_wl u_t014_002/r1_w1_wl u_t014_002/r1_r0_rwl u_t014_002/r1_r1_rwl
+ u_t014_002/r2_w0_wl u_t014_002/r2_w1_wl u_t014_002/r2_r0_rwl u_t014_002/r2_r1_rwl
+ u_t014_002/r3_w0_wl u_t014_002/r3_w1_wl u_t014_002/r3_r0_rwl u_t014_002/r3_r1_rwl
+ VSS VSS u_t014_002/m2_717_1265# u_t014_002/m2_603_2031# u_t014_002/m2_1290_336#
+ u_t014_002/m2_2000_2037# u_t014_002/m2_791_2909# u_t014_002/m2_7_2126# u_t014_002/m2_2154_2081#
+ u_t014_002/m2_1795_2037# u_t014_002/m2_871_303# u_t014_002/m2_431_438# u_t014_002/m2_1290_2898#
+ u_t014_002/m2_1714_1210# u_t014_002/m2_431_1982# u_t014_002/m2_512_1265# u_t014_002/m2_2573_2126#
+ u_t014_002/m2_603_1259# u_t014_002/m2_2074_2909# u_t014_002/m2_7_336# u_t014_002/m2_717_2037#
+ u_t014_002/m2_1886_2031# u_t014_002/m2_2573_336# u_t014_002/m2_7_2898# u_t014_002/m2_2000_1265#
+ u_t014_002/m2_512_2037# u_t014_002/m2_1795_1265# u_t014_002/m2_1714_1982# u_t014_002/m2_1886_1259#
+ u_t014_002/m2_1290_2126# u_t014_002/m2_1714_438# u_t014_002/m2_431_1210# u_t014_002/m2_2573_2898#
+ u_t014_002/m2_2154_303# u_t014_002/m2_871_2081# VSUBS detronyx_12t_2w2r_rc4_4x4_routed_5layer_direct
Xgf180mcu_as_sc_mcu7t3v3__nand2_2_36 gf180mcu_as_sc_mcu7t3v3__nor2_2_9/VDD gf180mcu_as_sc_mcu7t3v3__nor2_2_9/VSS
+ VSS VSS VSS gf180mcu_as_sc_mcu7t3v3__nor2_2_9/VNW VSUBS gf180mcu_as_sc_mcu7t3v3__nand2_2
Xgf180mcu_as_sc_mcu7t3v3__nand2_2_47 gf180mcu_as_sc_mcu7t3v3__nand3_2_65/VDD gf180mcu_as_sc_mcu7t3v3__nor2_2_9/VSS
+ VSS VSS VSS gf180mcu_as_sc_mcu7t3v3__nand3_2_65/VNW VSUBS gf180mcu_as_sc_mcu7t3v3__nand2_2
Xgf180mcu_as_sc_mcu7t3v3__nand2_2_25 gf180mcu_as_sc_mcu7t3v3__nor2_2_6/VDD gf180mcu_as_sc_mcu7t3v3__nor2_2_6/VSS
+ VSS VSS VSS gf180mcu_as_sc_mcu7t3v3__nor2_2_6/VNW VSUBS gf180mcu_as_sc_mcu7t3v3__nand2_2
Xgf180mcu_as_sc_mcu7t3v3__nand2_2_14 gf180mcu_as_sc_mcu7t3v3__nor2_2_6/VDD gf180mcu_as_sc_mcu7t3v3__nor2_2_6/VSS
+ VSS VSS VSS gf180mcu_as_sc_mcu7t3v3__nor2_2_6/VNW VSUBS gf180mcu_as_sc_mcu7t3v3__nand2_2
Xu_t005_013 u_t005_013/c0_w0_bl u_t005_013/c0_w0_br u_t005_013/c0_w1_bl u_t005_013/c0_w1_br
+ u_t005_013/c0_r0_rbl u_t005_013/c0_r1_rbl u_t005_013/c1_w0_bl u_t005_013/c1_w0_br
+ u_t005_013/c1_w1_bl u_t005_013/c1_w1_br u_t005_013/c1_r0_rbl u_t005_013/c1_r1_rbl
+ u_t005_013/c2_w0_bl u_t005_013/c2_w0_br u_t005_013/c2_w1_bl u_t005_013/c2_w1_br
+ u_t005_013/c2_r0_rbl u_t005_013/c2_r1_rbl u_t005_013/c3_w0_bl u_t005_013/c3_w0_br
+ u_t005_013/c3_w1_bl u_t005_013/c3_w1_br u_t005_013/c3_r0_rbl u_t005_013/c3_r1_rbl
+ u_t005_013/r0_w0_wl u_t005_013/r0_w1_wl u_t005_013/r0_r0_rwl u_t005_013/r0_r1_rwl
+ u_t005_013/r1_w0_wl u_t005_013/r1_w1_wl u_t005_013/r1_r0_rwl u_t005_013/r1_r1_rwl
+ u_t005_013/r2_w0_wl u_t005_013/r2_w1_wl u_t005_013/r2_r0_rwl u_t005_013/r2_r1_rwl
+ u_t005_013/r3_w0_wl u_t005_013/r3_w1_wl u_t005_013/r3_r0_rwl u_t005_013/r3_r1_rwl
+ u_t005_013/VDD VSS u_t005_013/m2_717_1265# u_t005_013/m2_603_2031# u_t005_013/m2_1290_336#
+ u_t005_013/m2_2000_2037# u_t005_013/m2_791_2909# u_t005_013/m2_7_2126# u_t005_013/m2_2154_2081#
+ u_t005_013/m2_1795_2037# u_t005_013/m2_871_303# u_t005_013/m2_431_438# u_t005_013/m2_1290_2898#
+ u_t005_013/m2_1714_1210# u_t005_013/m2_431_1982# u_t005_013/m2_512_1265# u_t005_013/m2_2573_2126#
+ u_t005_013/m2_603_1259# u_t005_013/m2_2074_2909# u_t005_013/m2_7_336# u_t005_013/m2_717_2037#
+ u_t005_013/m2_1886_2031# u_t005_013/m2_2573_336# u_t005_013/m2_7_2898# u_t005_013/m2_2000_1265#
+ u_t005_013/m2_512_2037# u_t005_013/m2_1795_1265# u_t005_013/m2_1714_1982# u_t005_013/m2_1886_1259#
+ u_t005_013/m2_1290_2126# u_t005_013/m2_1714_438# u_t005_013/m2_431_1210# u_t005_013/m2_2573_2898#
+ u_t005_013/m2_2154_303# u_t005_013/m2_871_2081# VSUBS detronyx_12t_2w2r_rc4_4x4_routed_5layer_direct
Xu_t020_005 u_t020_005/c0_w0_bl u_t020_005/c0_w0_br u_t020_005/c0_w1_bl u_t020_005/c0_w1_br
+ u_t020_005/c0_r0_rbl u_t020_005/c0_r1_rbl u_t020_005/c1_w0_bl u_t020_005/c1_w0_br
+ u_t020_005/c1_w1_bl u_t020_005/c1_w1_br u_t020_005/c1_r0_rbl u_t020_005/c1_r1_rbl
+ u_t020_005/c2_w0_bl u_t020_005/c2_w0_br u_t020_005/c2_w1_bl u_t020_005/c2_w1_br
+ u_t020_005/c2_r0_rbl u_t020_005/c2_r1_rbl u_t020_005/c3_w0_bl u_t020_005/c3_w0_br
+ u_t020_005/c3_w1_bl u_t020_005/c3_w1_br u_t020_005/c3_r0_rbl u_t020_005/c3_r1_rbl
+ u_t020_005/r0_w0_wl u_t020_005/r0_w1_wl u_t020_005/r0_r0_rwl u_t020_005/r0_r1_rwl
+ u_t020_005/r1_w0_wl u_t020_005/r1_w1_wl u_t020_005/r1_r0_rwl u_t020_005/r1_r1_rwl
+ u_t020_005/r2_w0_wl u_t020_005/r2_w1_wl u_t020_005/r2_r0_rwl u_t020_005/r2_r1_rwl
+ u_t020_005/r3_w0_wl u_t020_005/r3_w1_wl u_t020_005/r3_r0_rwl u_t020_005/r3_r1_rwl
+ u_t020_005/VDD u_t020_005/VSS u_t020_005/m2_717_1265# u_t020_005/m2_603_2031# u_t020_005/m2_1290_336#
+ u_t020_005/m2_2000_2037# u_t020_005/m2_791_2909# u_t020_005/m2_7_2126# u_t020_005/m2_2154_2081#
+ u_t020_005/m2_1795_2037# u_t020_005/m2_871_303# u_t020_005/m2_431_438# u_t020_005/m2_1290_2898#
+ u_t020_005/m2_1714_1210# u_t020_005/m2_431_1982# u_t020_005/m2_512_1265# u_t020_005/m2_2573_2126#
+ u_t020_005/m2_603_1259# u_t020_005/m2_2074_2909# u_t020_005/m2_7_336# u_t020_005/m2_717_2037#
+ u_t020_005/m2_1886_2031# u_t020_005/m2_2573_336# u_t020_005/m2_7_2898# u_t020_005/m2_2000_1265#
+ u_t020_005/m2_512_2037# u_t020_005/m2_1795_1265# u_t020_005/m2_1714_1982# u_t020_005/m2_1886_1259#
+ u_t020_005/m2_1290_2126# u_t020_005/m2_1714_438# u_t020_005/m2_431_1210# u_t020_005/m2_2573_2898#
+ u_t020_005/m2_2154_303# u_t020_005/m2_871_2081# VSUBS detronyx_12t_2w2r_rc4_4x4_routed_5layer_direct
Xu_t005_002 u_t005_002/c0_w0_bl u_t005_002/c0_w0_br u_t005_002/c0_w1_bl u_t005_002/c0_w1_br
+ u_t005_002/c0_r0_rbl u_t005_002/c0_r1_rbl u_t005_002/c1_w0_bl u_t005_002/c1_w0_br
+ u_t005_002/c1_w1_bl u_t005_002/c1_w1_br u_t005_002/c1_r0_rbl u_t005_002/c1_r1_rbl
+ u_t005_002/c2_w0_bl u_t005_002/c2_w0_br u_t005_002/c2_w1_bl u_t005_002/c2_w1_br
+ u_t005_002/c2_r0_rbl u_t005_002/c2_r1_rbl u_t005_002/c3_w0_bl u_t005_002/c3_w0_br
+ u_t005_002/c3_w1_bl u_t005_002/c3_w1_br u_t005_002/c3_r0_rbl u_t005_002/c3_r1_rbl
+ u_t005_002/r0_w0_wl u_t005_002/r0_w1_wl u_t005_002/r0_r0_rwl u_t005_002/r0_r1_rwl
+ u_t005_002/r1_w0_wl u_t005_002/r1_w1_wl u_t005_002/r1_r0_rwl u_t005_002/r1_r1_rwl
+ u_t005_002/r2_w0_wl u_t005_002/r2_w1_wl u_t005_002/r2_r0_rwl u_t005_002/r2_r1_rwl
+ u_t005_002/r3_w0_wl u_t005_002/r3_w1_wl u_t005_002/r3_r0_rwl u_t005_002/r3_r1_rwl
+ VSS VSS u_t005_002/m2_717_1265# u_t005_002/m2_603_2031# u_t005_002/m2_1290_336#
+ u_t005_002/m2_2000_2037# u_t005_002/m2_791_2909# u_t005_002/m2_7_2126# u_t005_002/m2_2154_2081#
+ u_t005_002/m2_1795_2037# u_t005_002/m2_871_303# u_t005_002/m2_431_438# u_t005_002/m2_1290_2898#
+ u_t005_002/m2_1714_1210# u_t005_002/m2_431_1982# u_t005_002/m2_512_1265# u_t005_002/m2_2573_2126#
+ u_t005_002/m2_603_1259# u_t005_002/m2_2074_2909# u_t005_002/m2_7_336# u_t005_002/m2_717_2037#
+ u_t005_002/m2_1886_2031# u_t005_002/m2_2573_336# u_t005_002/m2_7_2898# u_t005_002/m2_2000_1265#
+ u_t005_002/m2_512_2037# u_t005_002/m2_1795_1265# u_t005_002/m2_1714_1982# u_t005_002/m2_1886_1259#
+ u_t005_002/m2_1290_2126# u_t005_002/m2_1714_438# u_t005_002/m2_431_1210# u_t005_002/m2_2573_2898#
+ u_t005_002/m2_2154_303# u_t005_002/m2_871_2081# VSUBS detronyx_12t_2w2r_rc4_4x4_routed_5layer_direct
Xgf180mcu_as_sc_mcu7t3v3__inv_2_1409 gf180mcu_as_sc_mcu7t3v3__inv_2_1409/VDD gf180mcu_as_sc_mcu7t3v3__inv_2_1409/VSS
+ VSS gf180mcu_as_sc_mcu7t3v3__inv_2_1409/A gf180mcu_as_sc_mcu7t3v3__inv_2_1409/VNW
+ VSUBS gf180mcu_as_sc_mcu7t3v3__inv_2
Xu_t011_005 u_t011_005/c0_w0_bl u_t011_005/c0_w0_br u_t011_005/c0_w1_bl u_t011_005/c0_w1_br
+ u_t011_005/c0_r0_rbl u_t011_005/c0_r1_rbl u_t011_005/c1_w0_bl u_t011_005/c1_w0_br
+ u_t011_005/c1_w1_bl u_t011_005/c1_w1_br u_t011_005/c1_r0_rbl u_t011_005/c1_r1_rbl
+ u_t011_005/c2_w0_bl u_t011_005/c2_w0_br u_t011_005/c2_w1_bl u_t011_005/c2_w1_br
+ u_t011_005/c2_r0_rbl u_t011_005/c2_r1_rbl u_t011_005/c3_w0_bl u_t011_005/c3_w0_br
+ u_t011_005/c3_w1_bl u_t011_005/c3_w1_br u_t011_005/c3_r0_rbl u_t011_005/c3_r1_rbl
+ u_t011_005/r0_w0_wl u_t011_005/r0_w1_wl u_t011_005/r0_r0_rwl u_t011_005/r0_r1_rwl
+ u_t011_005/r1_w0_wl u_t011_005/r1_w1_wl u_t011_005/r1_r0_rwl u_t011_005/r1_r1_rwl
+ u_t011_005/r2_w0_wl u_t011_005/r2_w1_wl u_t011_005/r2_r0_rwl u_t011_005/r2_r1_rwl
+ u_t011_005/r3_w0_wl u_t011_005/r3_w1_wl u_t011_005/r3_r0_rwl u_t011_005/r3_r1_rwl
+ u_t011_005/VDD u_t011_005/VSS u_t011_005/m2_717_1265# u_t011_005/m2_603_2031# u_t011_005/m2_1290_336#
+ u_t011_005/m2_2000_2037# u_t011_005/m2_791_2909# u_t011_005/m2_7_2126# u_t011_005/m2_2154_2081#
+ u_t011_005/m2_1795_2037# u_t011_005/m2_871_303# u_t011_005/m2_431_438# u_t011_005/m2_1290_2898#
+ u_t011_005/m2_1714_1210# u_t011_005/m2_431_1982# u_t011_005/m2_512_1265# u_t011_005/m2_2573_2126#
+ u_t011_005/m2_603_1259# u_t011_005/m2_2074_2909# u_t011_005/m2_7_336# u_t011_005/m2_717_2037#
+ u_t011_005/m2_1886_2031# u_t011_005/m2_2573_336# u_t011_005/m2_7_2898# u_t011_005/m2_2000_1265#
+ u_t011_005/m2_512_2037# u_t011_005/m2_1795_1265# u_t011_005/m2_1714_1982# u_t011_005/m2_1886_1259#
+ u_t011_005/m2_1290_2126# u_t011_005/m2_1714_438# u_t011_005/m2_431_1210# u_t011_005/m2_2573_2898#
+ u_t011_005/m2_2154_303# u_t011_005/m2_871_2081# VSUBS detronyx_12t_2w2r_rc4_4x4_routed_5layer_direct
Xu_t002_005 u_t002_005/c0_w0_bl u_t002_005/c0_w0_br u_t002_005/c0_w1_bl u_t002_005/c0_w1_br
+ u_t002_005/c0_r0_rbl u_t002_005/c0_r1_rbl u_t002_005/c1_w0_bl u_t002_005/c1_w0_br
+ u_t002_005/c1_w1_bl u_t002_005/c1_w1_br u_t002_005/c1_r0_rbl u_t002_005/c1_r1_rbl
+ u_t002_005/c2_w0_bl u_t002_005/c2_w0_br u_t002_005/c2_w1_bl u_t002_005/c2_w1_br
+ u_t002_005/c2_r0_rbl u_t002_005/c2_r1_rbl u_t002_005/c3_w0_bl u_t002_005/c3_w0_br
+ u_t002_005/c3_w1_bl u_t002_005/c3_w1_br u_t002_005/c3_r0_rbl u_t002_005/c3_r1_rbl
+ u_t002_005/r0_w0_wl u_t002_005/r0_w1_wl u_t002_005/r0_r0_rwl u_t002_005/r0_r1_rwl
+ u_t002_005/r1_w0_wl u_t002_005/r1_w1_wl u_t002_005/r1_r0_rwl u_t002_005/r1_r1_rwl
+ u_t002_005/r2_w0_wl u_t002_005/r2_w1_wl u_t002_005/r2_r0_rwl u_t002_005/r2_r1_rwl
+ u_t002_005/r3_w0_wl u_t002_005/r3_w1_wl u_t002_005/r3_r0_rwl u_t002_005/r3_r1_rwl
+ u_t002_005/VDD u_t002_005/VSS u_t002_005/m2_717_1265# u_t002_005/m2_603_2031# u_t002_005/m2_1290_336#
+ u_t002_005/m2_2000_2037# u_t002_005/m2_791_2909# u_t002_005/m2_7_2126# u_t002_005/m2_2154_2081#
+ u_t002_005/m2_1795_2037# u_t002_005/m2_871_303# u_t002_005/m2_431_438# u_t002_005/m2_1290_2898#
+ u_t002_005/m2_1714_1210# u_t002_005/m2_431_1982# u_t002_005/m2_512_1265# u_t002_005/m2_2573_2126#
+ u_t002_005/m2_603_1259# u_t002_005/m2_2074_2909# u_t002_005/m2_7_336# u_t002_005/m2_717_2037#
+ u_t002_005/m2_1886_2031# u_t002_005/m2_2573_336# u_t002_005/m2_7_2898# u_t002_005/m2_2000_1265#
+ u_t002_005/m2_512_2037# u_t002_005/m2_1795_1265# u_t002_005/m2_1714_1982# u_t002_005/m2_1886_1259#
+ u_t002_005/m2_1290_2126# u_t002_005/m2_1714_438# u_t002_005/m2_431_1210# u_t002_005/m2_2573_2898#
+ u_t002_005/m2_2154_303# u_t002_005/m2_871_2081# VSUBS detronyx_12t_2w2r_rc4_4x4_routed_5layer_direct
Xgf180mcu_as_sc_mcu7t3v3__inv_2_1206 gf180mcu_as_sc_mcu7t3v3__nand3_2_65/VDD gf180mcu_as_sc_mcu7t3v3__nand3_2_62/VSS
+ VSS VSS gf180mcu_as_sc_mcu7t3v3__nand3_2_65/VNW VSUBS gf180mcu_as_sc_mcu7t3v3__inv_2
Xgf180mcu_as_sc_mcu7t3v3__inv_2_1217 VSS VSS gf180mcu_as_sc_mcu7t3v3__inv_2_1217/Y
+ VSS gf180mcu_as_sc_mcu7t3v3__inv_2_1281/VNW VSUBS gf180mcu_as_sc_mcu7t3v3__inv_2
Xgf180mcu_as_sc_mcu7t3v3__inv_2_1239 gf180mcu_as_sc_mcu7t3v3__nor2_2_9/VDD gf180mcu_as_sc_mcu7t3v3__nor2_2_9/VSS
+ VSS VSS gf180mcu_as_sc_mcu7t3v3__nor2_2_9/VNW VSUBS gf180mcu_as_sc_mcu7t3v3__inv_2
Xgf180mcu_as_sc_mcu7t3v3__inv_2_1228 VSS VSS VSS VSS gf180mcu_as_sc_mcu7t3v3__inv_2_1282/VNW
+ VSUBS gf180mcu_as_sc_mcu7t3v3__inv_2
Xgf180mcu_as_sc_mcu7t3v3__nand4_2_501 VSS gf180mcu_as_sc_mcu7t3v3__inv_2_1649/VDD
+ VSS VSS VSS VSS VSS gf180mcu_as_sc_mcu7t3v3__inv_2_1642/VNW VSUBS gf180mcu_as_sc_mcu7t3v3__nand4_2
Xgf180mcu_as_sc_mcu7t3v3__nand4_2_512 VSS VSS VSS VSS VSS VSS gf180mcu_as_sc_mcu7t3v3__nand4_2_512/Y
+ gf180mcu_as_sc_mcu7t3v3__inv_2_1723/VNW VSUBS gf180mcu_as_sc_mcu7t3v3__nand4_2
Xgf180mcu_as_sc_mcu7t3v3__inv_2_1036 gf180mcu_as_sc_mcu7t3v3__inv_2_1036/VDD gf180mcu_as_sc_mcu7t3v3__inv_2_1036/VSS
+ gf180mcu_as_sc_mcu7t3v3__inv_2_1036/Y VSS gf180mcu_as_sc_mcu7t3v3__inv_2_1036/VNW
+ VSUBS gf180mcu_as_sc_mcu7t3v3__inv_2
Xgf180mcu_as_sc_mcu7t3v3__inv_2_1014 VSS gf180mcu_as_sc_mcu7t3v3__inv_2_1028/VDD VSS
+ gf180mcu_as_sc_mcu7t3v3__inv_2_1041/A gf180mcu_as_sc_mcu7t3v3__inv_2_1016/VNW VSUBS
+ gf180mcu_as_sc_mcu7t3v3__inv_2
Xgf180mcu_as_sc_mcu7t3v3__inv_2_1025 gf180mcu_as_sc_mcu7t3v3__inv_2_1053/VDD VSS VSS
+ gf180mcu_as_sc_mcu7t3v3__inv_2_1057/A gf180mcu_as_sc_mcu7t3v3__inv_2_1053/VNW VSUBS
+ gf180mcu_as_sc_mcu7t3v3__inv_2
Xgf180mcu_as_sc_mcu7t3v3__inv_2_1047 gf180mcu_as_sc_mcu7t3v3__inv_2_1048/VDD gf180mcu_as_sc_mcu7t3v3__inv_2_1052/VDD
+ gf180mcu_as_sc_mcu7t3v3__inv_2_1047/Y gf180mcu_as_sc_mcu7t3v3__inv_2_1048/Y gf180mcu_as_sc_mcu7t3v3__inv_2_1048/VNW
+ VSUBS gf180mcu_as_sc_mcu7t3v3__inv_2
Xgf180mcu_as_sc_mcu7t3v3__inv_2_1058 gf180mcu_as_sc_mcu7t3v3__inv_2_1058/VDD gf180mcu_as_sc_mcu7t3v3__inv_2_1058/VSS
+ VSS gf180mcu_as_sc_mcu7t3v3__inv_2_962/A gf180mcu_as_sc_mcu7t3v3__inv_2_1058/VNW
+ VSUBS gf180mcu_as_sc_mcu7t3v3__inv_2
Xgf180mcu_as_sc_mcu7t3v3__inv_2_11 gf180mcu_as_sc_mcu7t3v3__inv_2_8/VSS gf180mcu_as_sc_mcu7t3v3__inv_2_8/VSS
+ gf180mcu_as_sc_mcu7t3v3__inv_2_24/Y gf180mcu_as_sc_mcu7t3v3__inv_2_24/Y gf180mcu_as_sc_mcu7t3v3__inv_2_12/VNW
+ VSUBS gf180mcu_as_sc_mcu7t3v3__inv_2
Xgf180mcu_as_sc_mcu7t3v3__inv_2_22 gf180mcu_as_sc_mcu7t3v3__inv_2_24/VDD VSS VSS gf180mcu_as_sc_mcu7t3v3__inv_2_24/Y
+ gf180mcu_as_sc_mcu7t3v3__inv_2_24/VNW VSUBS gf180mcu_as_sc_mcu7t3v3__inv_2
Xgf180mcu_as_sc_mcu7t3v3__inv_2_88 gf180mcu_as_sc_mcu7t3v3__inv_2_91/VSS gf180mcu_as_sc_mcu7t3v3__inv_2_97/VDD
+ gf180mcu_as_sc_mcu7t3v3__inv_2_88/Y VSS gf180mcu_as_sc_mcu7t3v3__inv_2_90/VNW VSUBS
+ gf180mcu_as_sc_mcu7t3v3__inv_2
Xgf180mcu_as_sc_mcu7t3v3__inv_2_99 VSS gf180mcu_as_sc_mcu7t3v3__inv_2_99/VSS gf180mcu_as_sc_mcu7t3v3__inv_2_99/Y
+ VSS gf180mcu_as_sc_mcu7t3v3__inv_2_99/VNW VSUBS gf180mcu_as_sc_mcu7t3v3__inv_2
Xgf180mcu_as_sc_mcu7t3v3__inv_2_66 gf180mcu_as_sc_mcu7t3v3__inv_2_66/VSS gf180mcu_as_sc_mcu7t3v3__inv_2_66/VSS
+ gf180mcu_as_sc_mcu7t3v3__inv_2_66/Y VSS gf180mcu_as_sc_mcu7t3v3__inv_2_66/VNW VSUBS
+ gf180mcu_as_sc_mcu7t3v3__inv_2
Xgf180mcu_as_sc_mcu7t3v3__inv_2_44 gf180mcu_as_sc_mcu7t3v3__inv_2_46/VDD gf180mcu_as_sc_mcu7t3v3__inv_2_62/VDD
+ VSS gf180mcu_as_sc_mcu7t3v3__inv_2_9/Y gf180mcu_as_sc_mcu7t3v3__inv_2_46/VNW VSUBS
+ gf180mcu_as_sc_mcu7t3v3__inv_2
Xgf180mcu_as_sc_mcu7t3v3__inv_2_33 gf180mcu_as_sc_mcu7t3v3__inv_2_38/VDD VSS VSS gf180mcu_as_sc_mcu7t3v3__inv_2_9/Y
+ gf180mcu_as_sc_mcu7t3v3__inv_2_38/VNW VSUBS gf180mcu_as_sc_mcu7t3v3__inv_2
Xgf180mcu_as_sc_mcu7t3v3__inv_2_77 gf180mcu_as_sc_mcu7t3v3__inv_2_9/VDD gf180mcu_as_sc_mcu7t3v3__inv_2_9/VDD
+ gf180mcu_as_sc_mcu7t3v3__inv_2_9/Y VSS gf180mcu_as_sc_mcu7t3v3__inv_2_77/VNW VSUBS
+ gf180mcu_as_sc_mcu7t3v3__inv_2
Xgf180mcu_as_sc_mcu7t3v3__inv_2_55 gf180mcu_as_sc_mcu7t3v3__inv_2_57/VDD gf180mcu_as_sc_mcu7t3v3__inv_2_61/VDD
+ VSS gf180mcu_as_sc_mcu7t3v3__inv_2_61/Y gf180mcu_as_sc_mcu7t3v3__inv_2_57/VNW VSUBS
+ gf180mcu_as_sc_mcu7t3v3__inv_2
Xgf180mcu_as_sc_mcu7t3v3__inv_2_1003 VSS VSS gf180mcu_as_sc_mcu7t3v3__inv_2_1724/A
+ gf180mcu_as_sc_mcu7t3v3__inv_2_1004/Y gf180mcu_as_sc_mcu7t3v3__inv_2_1004/VNW VSUBS
+ gf180mcu_as_sc_mcu7t3v3__inv_2
Xgf180mcu_as_sc_mcu7t3v3__inv_2_1069 VSS gf180mcu_as_sc_mcu7t3v3__inv_2_1075/VDD VSS
+ gf180mcu_as_sc_mcu7t3v3__inv_2_1149/A gf180mcu_as_sc_mcu7t3v3__inv_2_1071/VNW VSUBS
+ gf180mcu_as_sc_mcu7t3v3__inv_2
Xgf180mcu_as_sc_mcu7t3v3__inv_2_509 VSS VSS VSS VSS gf180mcu_as_sc_mcu7t3v3__inv_2_539/VNW
+ VSUBS gf180mcu_as_sc_mcu7t3v3__inv_2
Xgf180mcu_as_sc_mcu7t3v3__inv_2_1592 gf180mcu_as_sc_mcu7t3v3__inv_2_1594/VDD VSS VSS
+ VSS gf180mcu_as_sc_mcu7t3v3__inv_2_1594/VNW VSUBS gf180mcu_as_sc_mcu7t3v3__inv_2
Xgf180mcu_as_sc_mcu7t3v3__inv_2_1570 gf180mcu_as_sc_mcu7t3v3__inv_2_1588/VSS gf180mcu_as_sc_mcu7t3v3__inv_2_1573/VDD
+ gf180mcu_as_sc_mcu7t3v3__inv_2_1570/Y VSS gf180mcu_as_sc_mcu7t3v3__inv_2_1570/VNW
+ VSUBS gf180mcu_as_sc_mcu7t3v3__inv_2
Xgf180mcu_as_sc_mcu7t3v3__inv_2_1581 gf180mcu_as_sc_mcu7t3v3__inv_2_1582/VDD VSS gf180mcu_as_sc_mcu7t3v3__inv_2_1581/Y
+ VSS gf180mcu_as_sc_mcu7t3v3__inv_2_1582/VNW VSUBS gf180mcu_as_sc_mcu7t3v3__inv_2
Xgf180mcu_as_sc_mcu7t3v3__nand3_2_3 gf180mcu_as_sc_mcu7t3v3__nor2_2_6/VDD gf180mcu_as_sc_mcu7t3v3__nand3_2_4/VSS
+ VSS VSS VSS VSS gf180mcu_as_sc_mcu7t3v3__nor2_2_6/VNW VSUBS gf180mcu_as_sc_mcu7t3v3__nand3_2
Xgf180mcu_as_sc_mcu7t3v3__nand4_2_375 VSS VSS VSS VSS VSS VSS VSS gf180mcu_as_sc_mcu7t3v3__inv_2_1276/VNW
+ VSUBS gf180mcu_as_sc_mcu7t3v3__nand4_2
Xgf180mcu_as_sc_mcu7t3v3__nand4_2_342 gf180mcu_as_sc_mcu7t3v3__inv_2_1148/VSS VSS
+ VSS VSS VSS VSS VSS gf180mcu_as_sc_mcu7t3v3__inv_2_1115/VNW VSUBS gf180mcu_as_sc_mcu7t3v3__nand4_2
Xgf180mcu_as_sc_mcu7t3v3__nand4_2_364 VSS VSS VSS VSS VSS VSS gf180mcu_as_sc_mcu7t3v3__nand4_2_364/Y
+ gf180mcu_as_sc_mcu7t3v3__inv_2_1263/VNW VSUBS gf180mcu_as_sc_mcu7t3v3__nand4_2
Xgf180mcu_as_sc_mcu7t3v3__nand4_2_353 VSS VSS VSS VSS VSS VSS VSS gf180mcu_as_sc_mcu7t3v3__inv_2_1292/VNW
+ VSUBS gf180mcu_as_sc_mcu7t3v3__nand4_2
Xgf180mcu_as_sc_mcu7t3v3__nand4_2_320 gf180mcu_as_sc_mcu7t3v3__inv_2_1075/VDD gf180mcu_as_sc_mcu7t3v3__inv_2_1079/VDD
+ VSS VSS VSS VSS VSS gf180mcu_as_sc_mcu7t3v3__inv_2_1075/VNW VSUBS gf180mcu_as_sc_mcu7t3v3__nand4_2
Xgf180mcu_as_sc_mcu7t3v3__nand4_2_331 VSS VSS VSS VSS VSS VSS VSS gf180mcu_as_sc_mcu7t3v3__inv_2_1080/VNW
+ VSUBS gf180mcu_as_sc_mcu7t3v3__nand4_2
Xgf180mcu_as_sc_mcu7t3v3__nand4_2_386 VSS VSS VSS VSS VSS VSS VSS gf180mcu_as_sc_mcu7t3v3__inv_2_1428/VNW
+ VSUBS gf180mcu_as_sc_mcu7t3v3__nand4_2
Xgf180mcu_as_sc_mcu7t3v3__nand4_2_397 VSS gf180mcu_as_sc_mcu7t3v3__inv_2_1511/VDD
+ VSS VSS VSS VSS VSS gf180mcu_as_sc_mcu7t3v3__inv_2_1461/VNW VSUBS gf180mcu_as_sc_mcu7t3v3__nand4_2
Xgf180mcu_as_sc_mcu7t3v3__inv_2_306 gf180mcu_as_sc_mcu7t3v3__inv_2_307/VDD gf180mcu_as_sc_mcu7t3v3__inv_2_311/VDD
+ gf180mcu_as_sc_mcu7t3v3__inv_2_365/Y gf180mcu_as_sc_mcu7t3v3__inv_2_365/Y gf180mcu_as_sc_mcu7t3v3__inv_2_307/VNW
+ VSUBS gf180mcu_as_sc_mcu7t3v3__inv_2
Xgf180mcu_as_sc_mcu7t3v3__inv_2_339 gf180mcu_as_sc_mcu7t3v3__inv_2_341/VDD VSS VSS
+ gf180mcu_as_sc_mcu7t3v3__inv_2_341/Y gf180mcu_as_sc_mcu7t3v3__inv_2_341/VNW VSUBS
+ gf180mcu_as_sc_mcu7t3v3__inv_2
Xgf180mcu_as_sc_mcu7t3v3__inv_2_328 gf180mcu_as_sc_mcu7t3v3__inv_2_329/VDD gf180mcu_as_sc_mcu7t3v3__inv_2_332/VDD
+ gf180mcu_as_sc_mcu7t3v3__inv_2_328/Y gf180mcu_as_sc_mcu7t3v3__inv_2_341/Y gf180mcu_as_sc_mcu7t3v3__inv_2_329/VNW
+ VSUBS gf180mcu_as_sc_mcu7t3v3__inv_2
Xgf180mcu_as_sc_mcu7t3v3__inv_2_317 VSS gf180mcu_as_sc_mcu7t3v3__inv_2_320/VDD gf180mcu_as_sc_mcu7t3v3__inv_2_341/Y
+ VSS gf180mcu_as_sc_mcu7t3v3__inv_2_317/VNW VSUBS gf180mcu_as_sc_mcu7t3v3__inv_2
Xgf180mcu_as_sc_mcu7t3v3__inv_2_895 VSS VSS VSS VSS gf180mcu_as_sc_mcu7t3v3__inv_2_926/VNW
+ VSUBS gf180mcu_as_sc_mcu7t3v3__inv_2
Xgf180mcu_as_sc_mcu7t3v3__inv_2_851 VSS VSS VSS VSS gf180mcu_as_sc_mcu7t3v3__inv_2_851/VNW
+ VSUBS gf180mcu_as_sc_mcu7t3v3__inv_2
Xgf180mcu_as_sc_mcu7t3v3__inv_2_840 VSS VSS VSS VSS gf180mcu_as_sc_mcu7t3v3__inv_2_840/VNW
+ VSUBS gf180mcu_as_sc_mcu7t3v3__inv_2
Xgf180mcu_as_sc_mcu7t3v3__inv_2_884 VSS VSS VSS VSS gf180mcu_as_sc_mcu7t3v3__inv_2_934/VNW
+ VSUBS gf180mcu_as_sc_mcu7t3v3__inv_2
Xgf180mcu_as_sc_mcu7t3v3__inv_2_873 VSS VSS VSS VSS gf180mcu_as_sc_mcu7t3v3__inv_2_930/VNW
+ VSUBS gf180mcu_as_sc_mcu7t3v3__inv_2
Xgf180mcu_as_sc_mcu7t3v3__inv_2_862 VSS VSS VSS VSS gf180mcu_as_sc_mcu7t3v3__inv_2_942/VNW
+ VSUBS gf180mcu_as_sc_mcu7t3v3__inv_2
Xu_t026_011 u_t026_011/c0_w0_bl u_t026_011/c0_w0_br u_t026_011/c0_w1_bl u_t026_011/c0_w1_br
+ u_t026_011/c0_r0_rbl u_t026_011/c0_r1_rbl u_t026_011/c1_w0_bl u_t026_011/c1_w0_br
+ u_t026_011/c1_w1_bl u_t026_011/c1_w1_br u_t026_011/c1_r0_rbl u_t026_011/c1_r1_rbl
+ u_t026_011/c2_w0_bl u_t026_011/c2_w0_br u_t026_011/c2_w1_bl u_t026_011/c2_w1_br
+ u_t026_011/c2_r0_rbl u_t026_011/c2_r1_rbl u_t026_011/c3_w0_bl u_t026_011/c3_w0_br
+ u_t026_011/c3_w1_bl u_t026_011/c3_w1_br u_t026_011/c3_r0_rbl u_t026_011/c3_r1_rbl
+ u_t026_011/r0_w0_wl u_t026_011/r0_w1_wl u_t026_011/r0_r0_rwl u_t026_011/r0_r1_rwl
+ u_t026_011/r1_w0_wl u_t026_011/r1_w1_wl u_t026_011/r1_r0_rwl u_t026_011/r1_r1_rwl
+ u_t026_011/r2_w0_wl u_t026_011/r2_w1_wl u_t026_011/r2_r0_rwl u_t026_011/r2_r1_rwl
+ u_t026_011/r3_w0_wl u_t026_011/r3_w1_wl u_t026_011/r3_r0_rwl u_t026_011/r3_r1_rwl
+ u_t026_011/VDD VSS u_t026_011/m2_717_1265# u_t026_011/m2_603_2031# u_t026_011/m2_1290_336#
+ u_t026_011/m2_2000_2037# u_t026_011/m2_791_2909# u_t026_011/m2_7_2126# u_t026_011/m2_2154_2081#
+ u_t026_011/m2_1795_2037# u_t026_011/m2_871_303# u_t026_011/m2_431_438# u_t026_011/m2_1290_2898#
+ u_t026_011/m2_1714_1210# u_t026_011/m2_431_1982# u_t026_011/m2_512_1265# u_t026_011/m2_2573_2126#
+ u_t026_011/m2_603_1259# u_t026_011/m2_2074_2909# u_t026_011/m2_7_336# u_t026_011/m2_717_2037#
+ u_t026_011/m2_1886_2031# u_t026_011/m2_2573_336# u_t026_011/m2_7_2898# u_t026_011/m2_2000_1265#
+ u_t026_011/m2_512_2037# u_t026_011/m2_1795_1265# u_t026_011/m2_1714_1982# u_t026_011/m2_1886_1259#
+ u_t026_011/m2_1290_2126# u_t026_011/m2_1714_438# u_t026_011/m2_431_1210# u_t026_011/m2_2573_2898#
+ u_t026_011/m2_2154_303# u_t026_011/m2_871_2081# VSUBS detronyx_12t_2w2r_rc4_4x4_routed_5layer_direct
Xu_t026_000 VSS u_t026_000/c0_w0_br VSS u_t026_000/c0_w1_br u_t026_000/c0_r0_rbl u_t026_000/c0_r1_rbl
+ VSS VSS VSS VSS VSS VSS u_t026_000/c2_w0_bl u_t026_000/c2_w0_br u_t026_000/c2_w1_bl
+ u_t026_000/c2_w1_br u_t026_000/c2_r0_rbl u_t026_000/c2_r1_rbl u_t026_000/c3_w0_bl
+ u_t026_000/c3_w0_br u_t026_000/c3_w1_bl u_t026_000/c3_w1_br u_t026_000/c3_r0_rbl
+ u_t026_000/c3_r1_rbl VSS VSS VSS VSS VSS VSS VSS VSS VSS VSS VSS VSS VSS VSS VSS
+ VSS VSS VSS u_t026_000/m2_717_1265# VSS VSS VSS VSS u_t026_000/m2_7_2126# VSS VSS
+ VSS VSS VSS VSS VSS u_t026_000/m2_512_1265# u_t026_000/m2_2573_2126# u_t026_000/m2_603_1259#
+ VSS VSS VSS VSS u_t026_000/m2_2573_336# VSS u_t026_000/m2_2000_1265# VSS u_t026_000/m2_1795_1265#
+ VSS u_t026_000/m2_1886_1259# u_t026_000/m2_1290_2126# VSS VSS u_t026_000/m2_2573_2898#
+ VSS VSS VSUBS detronyx_12t_2w2r_rc4_4x4_routed_5layer_direct
Xgf180mcu_as_sc_mcu7t3v3__nand4_2_161 gf180mcu_as_sc_mcu7t3v3__inv_2_584/VDD VSS VSS
+ VSS VSS VSS VSS gf180mcu_as_sc_mcu7t3v3__inv_2_584/VNW VSUBS gf180mcu_as_sc_mcu7t3v3__nand4_2
Xgf180mcu_as_sc_mcu7t3v3__nand4_2_150 gf180mcu_as_sc_mcu7t3v3__nor2_2_4/VDD gf180mcu_as_sc_mcu7t3v3__nor2_2_4/VSS
+ VSS VSS VSS VSS VSS gf180mcu_as_sc_mcu7t3v3__nor2_2_4/VNW VSUBS gf180mcu_as_sc_mcu7t3v3__nand4_2
Xgf180mcu_as_sc_mcu7t3v3__nand4_2_172 VSS gf180mcu_as_sc_mcu7t3v3__inv_2_617/VDD VSS
+ VSS VSS VSS VSS gf180mcu_as_sc_mcu7t3v3__inv_2_610/VNW VSUBS gf180mcu_as_sc_mcu7t3v3__nand4_2
Xgf180mcu_as_sc_mcu7t3v3__nand4_2_183 gf180mcu_as_sc_mcu7t3v3__inv_2_737/VSS gf180mcu_as_sc_mcu7t3v3__inv_2_730/VDD
+ VSS VSS VSS VSS VSS gf180mcu_as_sc_mcu7t3v3__inv_2_704/VNW VSUBS gf180mcu_as_sc_mcu7t3v3__nand4_2
Xgf180mcu_as_sc_mcu7t3v3__nand4_2_194 gf180mcu_as_sc_mcu7t3v3__inv_2_743/VSS VSS VSS
+ VSS VSS VSS VSS gf180mcu_as_sc_mcu7t3v3__inv_2_701/VNW VSUBS gf180mcu_as_sc_mcu7t3v3__nand4_2
Xu_t017_011 u_t017_011/c0_w0_bl u_t017_011/c0_w0_br u_t017_011/c0_w1_bl u_t017_011/c0_w1_br
+ u_t017_011/c0_r0_rbl u_t017_011/c0_r1_rbl u_t017_011/c1_w0_bl u_t017_011/c1_w0_br
+ u_t017_011/c1_w1_bl u_t017_011/c1_w1_br u_t017_011/c1_r0_rbl u_t017_011/c1_r1_rbl
+ u_t017_011/c2_w0_bl u_t017_011/c2_w0_br u_t017_011/c2_w1_bl u_t017_011/c2_w1_br
+ u_t017_011/c2_r0_rbl u_t017_011/c2_r1_rbl u_t017_011/c3_w0_bl u_t017_011/c3_w0_br
+ u_t017_011/c3_w1_bl u_t017_011/c3_w1_br u_t017_011/c3_r0_rbl u_t017_011/c3_r1_rbl
+ u_t017_011/r0_w0_wl u_t017_011/r0_w1_wl u_t017_011/r0_r0_rwl u_t017_011/r0_r1_rwl
+ u_t017_011/r1_w0_wl u_t017_011/r1_w1_wl u_t017_011/r1_r0_rwl u_t017_011/r1_r1_rwl
+ u_t017_011/r2_w0_wl u_t017_011/r2_w1_wl u_t017_011/r2_r0_rwl u_t017_011/r2_r1_rwl
+ u_t017_011/r3_w0_wl u_t017_011/r3_w1_wl u_t017_011/r3_r0_rwl u_t017_011/r3_r1_rwl
+ u_t017_011/VDD VSS u_t017_011/m2_717_1265# u_t017_011/m2_603_2031# u_t017_011/m2_1290_336#
+ u_t017_011/m2_2000_2037# u_t017_011/m2_791_2909# u_t017_011/m2_7_2126# u_t017_011/m2_2154_2081#
+ u_t017_011/m2_1795_2037# u_t017_011/m2_871_303# u_t017_011/m2_431_438# u_t017_011/m2_1290_2898#
+ u_t017_011/m2_1714_1210# u_t017_011/m2_431_1982# u_t017_011/m2_512_1265# u_t017_011/m2_2573_2126#
+ u_t017_011/m2_603_1259# u_t017_011/m2_2074_2909# u_t017_011/m2_7_336# u_t017_011/m2_717_2037#
+ u_t017_011/m2_1886_2031# u_t017_011/m2_2573_336# u_t017_011/m2_7_2898# u_t017_011/m2_2000_1265#
+ u_t017_011/m2_512_2037# u_t017_011/m2_1795_1265# u_t017_011/m2_1714_1982# u_t017_011/m2_1886_1259#
+ u_t017_011/m2_1290_2126# u_t017_011/m2_1714_438# u_t017_011/m2_431_1210# u_t017_011/m2_2573_2898#
+ u_t017_011/m2_2154_303# u_t017_011/m2_871_2081# VSUBS detronyx_12t_2w2r_rc4_4x4_routed_5layer_direct
Xgf180mcu_as_sc_mcu7t3v3__inv_2_103 gf180mcu_as_sc_mcu7t3v3__inv_2_91/VSS gf180mcu_as_sc_mcu7t3v3__inv_2_91/VSS
+ VSS VSS gf180mcu_as_sc_mcu7t3v3__nand4_2_3/VNW VSUBS gf180mcu_as_sc_mcu7t3v3__inv_2
Xgf180mcu_as_sc_mcu7t3v3__inv_2_147 VSS gf180mcu_as_sc_mcu7t3v3__inv_2_152/VDD gf180mcu_as_sc_mcu7t3v3__inv_2_147/Y
+ VSS gf180mcu_as_sc_mcu7t3v3__inv_2_149/VNW VSUBS gf180mcu_as_sc_mcu7t3v3__inv_2
Xgf180mcu_as_sc_mcu7t3v3__inv_2_136 gf180mcu_as_sc_mcu7t3v3__inv_2_137/VDD VSS VSS
+ VSS gf180mcu_as_sc_mcu7t3v3__inv_2_137/VNW VSUBS gf180mcu_as_sc_mcu7t3v3__inv_2
Xgf180mcu_as_sc_mcu7t3v3__inv_2_125 gf180mcu_as_sc_mcu7t3v3__inv_2_125/VDD gf180mcu_as_sc_mcu7t3v3__inv_2_131/VDD
+ gf180mcu_as_sc_mcu7t3v3__inv_2_125/Y VSS gf180mcu_as_sc_mcu7t3v3__inv_2_125/VNW
+ VSUBS gf180mcu_as_sc_mcu7t3v3__inv_2
Xgf180mcu_as_sc_mcu7t3v3__inv_2_114 gf180mcu_as_sc_mcu7t3v3__inv_2_116/VDD gf180mcu_as_sc_mcu7t3v3__inv_2_122/VDD
+ gf180mcu_as_sc_mcu7t3v3__inv_2_114/Y VSS gf180mcu_as_sc_mcu7t3v3__inv_2_116/VNW
+ VSUBS gf180mcu_as_sc_mcu7t3v3__inv_2
Xgf180mcu_as_sc_mcu7t3v3__inv_2_169 gf180mcu_as_sc_mcu7t3v3__inv_2_171/VDD VSS gf180mcu_as_sc_mcu7t3v3__inv_2_169/Y
+ VSS gf180mcu_as_sc_mcu7t3v3__inv_2_171/VNW VSUBS gf180mcu_as_sc_mcu7t3v3__inv_2
Xgf180mcu_as_sc_mcu7t3v3__inv_2_158 gf180mcu_as_sc_mcu7t3v3__inv_2_177/VSS gf180mcu_as_sc_mcu7t3v3__inv_2_163/VDD
+ gf180mcu_as_sc_mcu7t3v3__inv_2_158/Y VSS gf180mcu_as_sc_mcu7t3v3__inv_2_160/VNW
+ VSUBS gf180mcu_as_sc_mcu7t3v3__inv_2
Xu_t017_000 VSS u_t017_000/c0_w0_br VSS u_t017_000/c0_w1_br u_t017_000/c0_r0_rbl u_t017_000/c0_r1_rbl
+ VSS VSS VSS VSS VSS VSS u_t017_000/c2_w0_bl u_t017_000/c2_w0_br u_t017_000/c2_w1_bl
+ u_t017_000/c2_w1_br u_t017_000/c2_r0_rbl u_t017_000/c2_r1_rbl u_t017_000/c3_w0_bl
+ u_t017_000/c3_w0_br u_t017_000/c3_w1_bl u_t017_000/c3_w1_br u_t017_000/c3_r0_rbl
+ u_t017_000/c3_r1_rbl VSS VSS VSS VSS VSS VSS VSS VSS VSS VSS VSS VSS VSS VSS VSS
+ VSS VSS VSS VSS VSS VSS VSS VSS VSS VSS VSS VSS VSS u_t017_000/m2_1290_2898# VSS
+ VSS VSS u_t017_000/m2_2573_2126# VSS VSS VSS VSS VSS u_t017_000/m2_2573_336# u_t017_000/m2_7_2898#
+ VSS VSS VSS u_t017_000/m2_1714_1982# VSS VSS u_t017_000/m2_1714_438# VSS u_t017_000/m2_2573_2898#
+ VSS VSS VSUBS detronyx_12t_2w2r_rc4_4x4_routed_5layer_direct
Xu_t008_011 u_t008_011/c0_w0_bl u_t008_011/c0_w0_br u_t008_011/c0_w1_bl u_t008_011/c0_w1_br
+ u_t008_011/c0_r0_rbl u_t008_011/c0_r1_rbl u_t008_011/c1_w0_bl u_t008_011/c1_w0_br
+ u_t008_011/c1_w1_bl u_t008_011/c1_w1_br u_t008_011/c1_r0_rbl u_t008_011/c1_r1_rbl
+ u_t008_011/c2_w0_bl u_t008_011/c2_w0_br u_t008_011/c2_w1_bl u_t008_011/c2_w1_br
+ u_t008_011/c2_r0_rbl u_t008_011/c2_r1_rbl u_t008_011/c3_w0_bl u_t008_011/c3_w0_br
+ u_t008_011/c3_w1_bl u_t008_011/c3_w1_br u_t008_011/c3_r0_rbl u_t008_011/c3_r1_rbl
+ u_t008_011/r0_w0_wl u_t008_011/r0_w1_wl u_t008_011/r0_r0_rwl u_t008_011/r0_r1_rwl
+ u_t008_011/r1_w0_wl u_t008_011/r1_w1_wl u_t008_011/r1_r0_rwl u_t008_011/r1_r1_rwl
+ u_t008_011/r2_w0_wl u_t008_011/r2_w1_wl u_t008_011/r2_r0_rwl u_t008_011/r2_r1_rwl
+ u_t008_011/r3_w0_wl u_t008_011/r3_w1_wl u_t008_011/r3_r0_rwl u_t008_011/r3_r1_rwl
+ u_t008_011/VDD VSS u_t008_011/m2_717_1265# u_t008_011/m2_603_2031# u_t008_011/m2_1290_336#
+ u_t008_011/m2_2000_2037# u_t008_011/m2_791_2909# u_t008_011/m2_7_2126# u_t008_011/m2_2154_2081#
+ u_t008_011/m2_1795_2037# u_t008_011/m2_871_303# u_t008_011/m2_431_438# u_t008_011/m2_1290_2898#
+ u_t008_011/m2_1714_1210# u_t008_011/m2_431_1982# u_t008_011/m2_512_1265# u_t008_011/m2_2573_2126#
+ u_t008_011/m2_603_1259# u_t008_011/m2_2074_2909# u_t008_011/m2_7_336# u_t008_011/m2_717_2037#
+ u_t008_011/m2_1886_2031# u_t008_011/m2_2573_336# u_t008_011/m2_7_2898# u_t008_011/m2_2000_1265#
+ u_t008_011/m2_512_2037# u_t008_011/m2_1795_1265# u_t008_011/m2_1714_1982# u_t008_011/m2_1886_1259#
+ u_t008_011/m2_1290_2126# u_t008_011/m2_1714_438# u_t008_011/m2_431_1210# u_t008_011/m2_2573_2898#
+ u_t008_011/m2_2154_303# u_t008_011/m2_871_2081# VSUBS detronyx_12t_2w2r_rc4_4x4_routed_5layer_direct
Xu_t008_000 VSS u_t008_000/c0_w0_br VSS u_t008_000/c0_w1_br u_t008_000/c0_r0_rbl u_t008_000/c0_r1_rbl
+ VSS VSS VSS VSS VSS VSS u_t008_000/c2_w0_bl u_t008_000/c2_w0_br u_t008_000/c2_w1_bl
+ u_t008_000/c2_w1_br u_t008_000/c2_r0_rbl u_t008_000/c2_r1_rbl u_t008_000/c3_w0_bl
+ u_t008_000/c3_w0_br u_t008_000/c3_w1_bl u_t008_000/c3_w1_br u_t008_000/c3_r0_rbl
+ u_t008_000/c3_r1_rbl VSS VSS VSS VSS VSS VSS VSS VSS VSS VSS VSS VSS VSS VSS VSS
+ VSS VSS VSS u_t008_000/m2_717_1265# u_t008_000/m2_603_2031# u_t008_000/m2_1290_336#
+ u_t008_000/m2_2000_2037# u_t008_000/m2_791_2909# u_t008_000/m2_7_2126# u_t008_000/m2_2154_2081#
+ u_t008_000/m2_1795_2037# u_t008_000/m2_871_303# u_t008_000/m2_431_438# u_t008_000/m2_1290_2898#
+ u_t008_000/m2_1714_1210# u_t008_000/m2_431_1982# u_t008_000/m2_512_1265# u_t008_000/m2_2573_2126#
+ u_t008_000/m2_603_1259# u_t008_000/m2_2074_2909# u_t008_000/m2_7_336# u_t008_000/m2_717_2037#
+ u_t008_000/m2_1886_2031# u_t008_000/m2_2573_336# u_t008_000/m2_7_2898# u_t008_000/m2_2000_1265#
+ u_t008_000/m2_512_2037# u_t008_000/m2_1795_1265# u_t008_000/m2_1714_1982# u_t008_000/m2_1886_1259#
+ u_t008_000/m2_1290_2126# u_t008_000/m2_1714_438# u_t008_000/m2_431_1210# u_t008_000/m2_2573_2898#
+ u_t008_000/m2_2154_303# u_t008_000/m2_871_2081# VSUBS detronyx_12t_2w2r_rc4_4x4_routed_5layer_direct
Xu_t023_014 u_t023_014/c0_w0_bl u_t023_014/c0_w0_br u_t023_014/c0_w1_bl u_t023_014/c0_w1_br
+ u_t023_014/c0_r0_rbl u_t023_014/c0_r1_rbl u_t023_014/c1_w0_bl u_t023_014/c1_w0_br
+ u_t023_014/c1_w1_bl u_t023_014/c1_w1_br u_t023_014/c1_r0_rbl u_t023_014/c1_r1_rbl
+ u_t023_014/c2_w0_bl u_t023_014/c2_w0_br u_t023_014/c2_w1_bl u_t023_014/c2_w1_br
+ u_t023_014/c2_r0_rbl u_t023_014/c2_r1_rbl u_t023_014/c3_w0_bl u_t023_014/c3_w0_br
+ u_t023_014/c3_w1_bl u_t023_014/c3_w1_br u_t023_014/c3_r0_rbl u_t023_014/c3_r1_rbl
+ u_t023_014/r0_w0_wl u_t023_014/r0_w1_wl u_t023_014/r0_r0_rwl u_t023_014/r0_r1_rwl
+ u_t023_014/r1_w0_wl u_t023_014/r1_w1_wl u_t023_014/r1_r0_rwl u_t023_014/r1_r1_rwl
+ u_t023_014/r2_w0_wl u_t023_014/r2_w1_wl u_t023_014/r2_r0_rwl u_t023_014/r2_r1_rwl
+ u_t023_014/r3_w0_wl u_t023_014/r3_w1_wl u_t023_014/r3_r0_rwl u_t023_014/r3_r1_rwl
+ u_t023_014/VDD u_t023_015/VSS u_t023_014/m2_717_1265# u_t023_014/m2_603_2031# u_t023_014/m2_1290_336#
+ u_t023_014/m2_2000_2037# u_t023_014/m2_791_2909# u_t023_014/m2_7_2126# u_t023_014/m2_2154_2081#
+ u_t023_014/m2_1795_2037# u_t023_014/m2_871_303# u_t023_014/m2_431_438# u_t023_014/m2_1290_2898#
+ u_t023_014/m2_1714_1210# u_t023_014/m2_431_1982# u_t023_014/m2_512_1265# u_t023_014/m2_2573_2126#
+ u_t023_014/m2_603_1259# u_t023_014/m2_2074_2909# u_t023_014/m2_7_336# u_t023_014/m2_717_2037#
+ u_t023_014/m2_1886_2031# u_t023_014/m2_2573_336# u_t023_014/m2_7_2898# u_t023_014/m2_2000_1265#
+ u_t023_014/m2_512_2037# u_t023_014/m2_1795_1265# u_t023_014/m2_1714_1982# u_t023_014/m2_1886_1259#
+ u_t023_014/m2_1290_2126# u_t023_014/m2_1714_438# u_t023_014/m2_431_1210# u_t023_014/m2_2573_2898#
+ u_t023_014/m2_2154_303# u_t023_014/m2_871_2081# VSUBS detronyx_12t_2w2r_rc4_4x4_routed_5layer_direct
Xu_t023_003 u_t023_003/c0_w0_bl u_t023_003/c0_w0_br u_t023_003/c0_w1_bl u_t023_003/c0_w1_br
+ u_t023_003/c0_r0_rbl u_t023_003/c0_r1_rbl u_t023_003/c1_w0_bl u_t023_003/c1_w0_br
+ u_t023_003/c1_w1_bl u_t023_003/c1_w1_br u_t023_003/c1_r0_rbl u_t023_003/c1_r1_rbl
+ u_t023_003/c2_w0_bl u_t023_003/c2_w0_br u_t023_003/c2_w1_bl u_t023_003/c2_w1_br
+ u_t023_003/c2_r0_rbl u_t023_003/c2_r1_rbl u_t023_003/c3_w0_bl u_t023_003/c3_w0_br
+ u_t023_003/c3_w1_bl u_t023_003/c3_w1_br u_t023_003/c3_r0_rbl u_t023_003/c3_r1_rbl
+ u_t023_003/r0_w0_wl u_t023_003/r0_w1_wl u_t023_003/r0_r0_rwl u_t023_003/r0_r1_rwl
+ u_t023_003/r1_w0_wl u_t023_003/r1_w1_wl u_t023_003/r1_r0_rwl u_t023_003/r1_r1_rwl
+ u_t023_003/r2_w0_wl u_t023_003/r2_w1_wl u_t023_003/r2_r0_rwl u_t023_003/r2_r1_rwl
+ u_t023_003/r3_w0_wl u_t023_003/r3_w1_wl u_t023_003/r3_r0_rwl u_t023_003/r3_r1_rwl
+ u_t023_003/VDD u_t023_003/VSS u_t023_003/m2_717_1265# u_t023_003/m2_603_2031# u_t023_003/m2_1290_336#
+ u_t023_003/m2_2000_2037# u_t023_003/m2_791_2909# u_t023_003/m2_7_2126# u_t023_003/m2_2154_2081#
+ u_t023_003/m2_1795_2037# u_t023_003/m2_871_303# u_t023_003/m2_431_438# u_t023_003/m2_1290_2898#
+ u_t023_003/m2_1714_1210# u_t023_003/m2_431_1982# u_t023_003/m2_512_1265# u_t023_003/m2_2573_2126#
+ u_t023_003/m2_603_1259# u_t023_003/m2_2074_2909# u_t023_003/m2_7_336# u_t023_003/m2_717_2037#
+ u_t023_003/m2_1886_2031# u_t023_003/m2_2573_336# u_t023_003/m2_7_2898# u_t023_003/m2_2000_1265#
+ u_t023_003/m2_512_2037# u_t023_003/m2_1795_1265# u_t023_003/m2_1714_1982# u_t023_003/m2_1886_1259#
+ u_t023_003/m2_1290_2126# u_t023_003/m2_1714_438# u_t023_003/m2_431_1210# u_t023_003/m2_2573_2898#
+ u_t023_003/m2_2154_303# u_t023_003/m2_871_2081# VSUBS detronyx_12t_2w2r_rc4_4x4_routed_5layer_direct
Xgf180mcu_as_sc_mcu7t3v3__inv_2_692 VSS VSS gf180mcu_as_sc_mcu7t3v3__inv_2_692/Y VSS
+ gf180mcu_as_sc_mcu7t3v3__inv_2_692/VNW VSUBS gf180mcu_as_sc_mcu7t3v3__inv_2
Xgf180mcu_as_sc_mcu7t3v3__inv_2_670 gf180mcu_as_sc_mcu7t3v3__inv_2_746/VSS gf180mcu_as_sc_mcu7t3v3__inv_2_674/VDD
+ gf180mcu_as_sc_mcu7t3v3__inv_2_670/Y VSS gf180mcu_as_sc_mcu7t3v3__inv_2_670/VNW
+ VSUBS gf180mcu_as_sc_mcu7t3v3__inv_2
Xgf180mcu_as_sc_mcu7t3v3__inv_2_681 gf180mcu_as_sc_mcu7t3v3__inv_2_689/VDD gf180mcu_as_sc_mcu7t3v3__inv_2_689/VSS
+ gf180mcu_as_sc_mcu7t3v3__inv_2_681/Y gf180mcu_as_sc_mcu7t3v3__inv_2_744/A gf180mcu_as_sc_mcu7t3v3__inv_2_689/VNW
+ VSUBS gf180mcu_as_sc_mcu7t3v3__inv_2
Xu_t014_014 u_t014_014/c0_w0_bl u_t014_014/c0_w0_br u_t014_014/c0_w1_bl u_t014_014/c0_w1_br
+ u_t014_014/c0_r0_rbl u_t014_014/c0_r1_rbl u_t014_014/c1_w0_bl u_t014_014/c1_w0_br
+ u_t014_014/c1_w1_bl u_t014_014/c1_w1_br u_t014_014/c1_r0_rbl u_t014_014/c1_r1_rbl
+ u_t014_014/c2_w0_bl u_t014_014/c2_w0_br u_t014_014/c2_w1_bl u_t014_014/c2_w1_br
+ u_t014_014/c2_r0_rbl u_t014_014/c2_r1_rbl u_t014_014/c3_w0_bl u_t014_014/c3_w0_br
+ u_t014_014/c3_w1_bl u_t014_014/c3_w1_br u_t014_014/c3_r0_rbl u_t014_014/c3_r1_rbl
+ u_t014_014/r0_w0_wl u_t014_014/r0_w1_wl u_t014_014/r0_r0_rwl u_t014_014/r0_r1_rwl
+ u_t014_014/r1_w0_wl u_t014_014/r1_w1_wl u_t014_014/r1_r0_rwl u_t014_014/r1_r1_rwl
+ u_t014_014/r2_w0_wl u_t014_014/r2_w1_wl u_t014_014/r2_r0_rwl u_t014_014/r2_r1_rwl
+ u_t014_014/r3_w0_wl u_t014_014/r3_w1_wl u_t014_014/r3_r0_rwl u_t014_014/r3_r1_rwl
+ u_t014_014/VDD u_t014_015/VSS u_t014_014/m2_717_1265# u_t014_014/m2_603_2031# u_t014_014/m2_1290_336#
+ u_t014_014/m2_2000_2037# u_t014_014/m2_791_2909# u_t014_014/m2_7_2126# u_t014_014/m2_2154_2081#
+ u_t014_014/m2_1795_2037# u_t014_014/m2_871_303# u_t014_014/m2_431_438# u_t014_014/m2_1290_2898#
+ u_t014_014/m2_1714_1210# u_t014_014/m2_431_1982# u_t014_014/m2_512_1265# u_t014_014/m2_2573_2126#
+ u_t014_014/m2_603_1259# u_t014_014/m2_2074_2909# u_t014_014/m2_7_336# u_t014_014/m2_717_2037#
+ u_t014_014/m2_1886_2031# u_t014_014/m2_2573_336# u_t014_014/m2_7_2898# u_t014_014/m2_2000_1265#
+ u_t014_014/m2_512_2037# u_t014_014/m2_1795_1265# u_t014_014/m2_1714_1982# u_t014_014/m2_1886_1259#
+ u_t014_014/m2_1290_2126# u_t014_014/m2_1714_438# u_t014_014/m2_431_1210# u_t014_014/m2_2573_2898#
+ u_t014_014/m2_2154_303# u_t014_014/m2_871_2081# VSUBS detronyx_12t_2w2r_rc4_4x4_routed_5layer_direct
Xu_t014_003 u_t014_003/c0_w0_bl u_t014_003/c0_w0_br u_t014_003/c0_w1_bl u_t014_003/c0_w1_br
+ u_t014_003/c0_r0_rbl u_t014_003/c0_r1_rbl u_t014_003/c1_w0_bl u_t014_003/c1_w0_br
+ u_t014_003/c1_w1_bl u_t014_003/c1_w1_br u_t014_003/c1_r0_rbl u_t014_003/c1_r1_rbl
+ u_t014_003/c2_w0_bl u_t014_003/c2_w0_br u_t014_003/c2_w1_bl u_t014_003/c2_w1_br
+ u_t014_003/c2_r0_rbl u_t014_003/c2_r1_rbl u_t014_003/c3_w0_bl u_t014_003/c3_w0_br
+ u_t014_003/c3_w1_bl u_t014_003/c3_w1_br u_t014_003/c3_r0_rbl u_t014_003/c3_r1_rbl
+ u_t014_003/r0_w0_wl u_t014_003/r0_w1_wl u_t014_003/r0_r0_rwl u_t014_003/r0_r1_rwl
+ u_t014_003/r1_w0_wl u_t014_003/r1_w1_wl u_t014_003/r1_r0_rwl u_t014_003/r1_r1_rwl
+ u_t014_003/r2_w0_wl u_t014_003/r2_w1_wl u_t014_003/r2_r0_rwl u_t014_003/r2_r1_rwl
+ u_t014_003/r3_w0_wl u_t014_003/r3_w1_wl u_t014_003/r3_r0_rwl u_t014_003/r3_r1_rwl
+ u_t014_003/VDD u_t014_003/VSS u_t014_003/m2_717_1265# u_t014_003/m2_603_2031# u_t014_003/m2_1290_336#
+ u_t014_003/m2_2000_2037# u_t014_003/m2_791_2909# u_t014_003/m2_7_2126# u_t014_003/m2_2154_2081#
+ u_t014_003/m2_1795_2037# u_t014_003/m2_871_303# u_t014_003/m2_431_438# u_t014_003/m2_1290_2898#
+ u_t014_003/m2_1714_1210# u_t014_003/m2_431_1982# u_t014_003/m2_512_1265# u_t014_003/m2_2573_2126#
+ u_t014_003/m2_603_1259# u_t014_003/m2_2074_2909# u_t014_003/m2_7_336# u_t014_003/m2_717_2037#
+ u_t014_003/m2_1886_2031# u_t014_003/m2_2573_336# u_t014_003/m2_7_2898# u_t014_003/m2_2000_1265#
+ u_t014_003/m2_512_2037# u_t014_003/m2_1795_1265# u_t014_003/m2_1714_1982# u_t014_003/m2_1886_1259#
+ u_t014_003/m2_1290_2126# u_t014_003/m2_1714_438# u_t014_003/m2_431_1210# u_t014_003/m2_2573_2898#
+ u_t014_003/m2_2154_303# u_t014_003/m2_871_2081# VSUBS detronyx_12t_2w2r_rc4_4x4_routed_5layer_direct
Xgf180mcu_as_sc_mcu7t3v3__nand2_2_37 gf180mcu_as_sc_mcu7t3v3__nand3_2_65/VDD gf180mcu_as_sc_mcu7t3v3__nor2_2_9/VSS
+ VSS VSS VSS gf180mcu_as_sc_mcu7t3v3__nand3_2_65/VNW VSUBS gf180mcu_as_sc_mcu7t3v3__nand2_2
Xgf180mcu_as_sc_mcu7t3v3__nand2_2_48 gf180mcu_as_sc_mcu7t3v3__nand3_2_65/VDD gf180mcu_as_sc_mcu7t3v3__nand3_2_62/VSS
+ VSS VSS VSS gf180mcu_as_sc_mcu7t3v3__nand3_2_65/VNW VSUBS gf180mcu_as_sc_mcu7t3v3__nand2_2
Xgf180mcu_as_sc_mcu7t3v3__nand2_2_26 gf180mcu_as_sc_mcu7t3v3__nor2_2_6/VDD gf180mcu_as_sc_mcu7t3v3__nand3_2_4/VSS
+ VSS VSS VSS gf180mcu_as_sc_mcu7t3v3__nor2_2_6/VNW VSUBS gf180mcu_as_sc_mcu7t3v3__nand2_2
Xgf180mcu_as_sc_mcu7t3v3__nand2_2_15 gf180mcu_as_sc_mcu7t3v3__nor2_2_6/VDD gf180mcu_as_sc_mcu7t3v3__nand3_2_4/VSS
+ VSS VSS VSS gf180mcu_as_sc_mcu7t3v3__nor2_2_6/VNW VSUBS gf180mcu_as_sc_mcu7t3v3__nand2_2
Xu_t005_014 u_t005_014/c0_w0_bl u_t005_014/c0_w0_br u_t005_014/c0_w1_bl u_t005_014/c0_w1_br
+ u_t005_014/c0_r0_rbl u_t005_014/c0_r1_rbl u_t005_014/c1_w0_bl u_t005_014/c1_w0_br
+ u_t005_014/c1_w1_bl u_t005_014/c1_w1_br u_t005_014/c1_r0_rbl u_t005_014/c1_r1_rbl
+ u_t005_014/c2_w0_bl u_t005_014/c2_w0_br u_t005_014/c2_w1_bl u_t005_014/c2_w1_br
+ u_t005_014/c2_r0_rbl u_t005_014/c2_r1_rbl u_t005_014/c3_w0_bl u_t005_014/c3_w0_br
+ u_t005_014/c3_w1_bl u_t005_014/c3_w1_br u_t005_014/c3_r0_rbl u_t005_014/c3_r1_rbl
+ u_t005_014/r0_w0_wl u_t005_014/r0_w1_wl u_t005_014/r0_r0_rwl u_t005_014/r0_r1_rwl
+ u_t005_014/r1_w0_wl u_t005_014/r1_w1_wl u_t005_014/r1_r0_rwl u_t005_014/r1_r1_rwl
+ u_t005_014/r2_w0_wl u_t005_014/r2_w1_wl u_t005_014/r2_r0_rwl u_t005_014/r2_r1_rwl
+ u_t005_014/r3_w0_wl u_t005_014/r3_w1_wl u_t005_014/r3_r0_rwl u_t005_014/r3_r1_rwl
+ u_t005_014/VDD VSS u_t005_014/m2_717_1265# u_t005_014/m2_603_2031# u_t005_014/m2_1290_336#
+ u_t005_014/m2_2000_2037# u_t005_014/m2_791_2909# u_t005_014/m2_7_2126# u_t005_014/m2_2154_2081#
+ u_t005_014/m2_1795_2037# u_t005_014/m2_871_303# u_t005_014/m2_431_438# u_t005_014/m2_1290_2898#
+ u_t005_014/m2_1714_1210# u_t005_014/m2_431_1982# u_t005_014/m2_512_1265# u_t005_014/m2_2573_2126#
+ u_t005_014/m2_603_1259# u_t005_014/m2_2074_2909# u_t005_014/m2_7_336# u_t005_014/m2_717_2037#
+ u_t005_014/m2_1886_2031# u_t005_014/m2_2573_336# u_t005_014/m2_7_2898# u_t005_014/m2_2000_1265#
+ u_t005_014/m2_512_2037# u_t005_014/m2_1795_1265# u_t005_014/m2_1714_1982# u_t005_014/m2_1886_1259#
+ u_t005_014/m2_1290_2126# u_t005_014/m2_1714_438# u_t005_014/m2_431_1210# u_t005_014/m2_2573_2898#
+ u_t005_014/m2_2154_303# u_t005_014/m2_871_2081# VSUBS detronyx_12t_2w2r_rc4_4x4_routed_5layer_direct
Xu_t020_006 u_t020_006/c0_w0_bl u_t020_006/c0_w0_br u_t020_006/c0_w1_bl u_t020_006/c0_w1_br
+ u_t020_006/c0_r0_rbl u_t020_006/c0_r1_rbl u_t020_006/c1_w0_bl u_t020_006/c1_w0_br
+ u_t020_006/c1_w1_bl u_t020_006/c1_w1_br u_t020_006/c1_r0_rbl u_t020_006/c1_r1_rbl
+ u_t020_006/c2_w0_bl u_t020_006/c2_w0_br u_t020_006/c2_w1_bl u_t020_006/c2_w1_br
+ u_t020_006/c2_r0_rbl u_t020_006/c2_r1_rbl u_t020_006/c3_w0_bl u_t020_006/c3_w0_br
+ u_t020_006/c3_w1_bl u_t020_006/c3_w1_br u_t020_006/c3_r0_rbl u_t020_006/c3_r1_rbl
+ u_t020_006/r0_w0_wl u_t020_006/r0_w1_wl u_t020_006/r0_r0_rwl u_t020_006/r0_r1_rwl
+ u_t020_006/r1_w0_wl u_t020_006/r1_w1_wl u_t020_006/r1_r0_rwl u_t020_006/r1_r1_rwl
+ u_t020_006/r2_w0_wl u_t020_006/r2_w1_wl u_t020_006/r2_r0_rwl u_t020_006/r2_r1_rwl
+ u_t020_006/r3_w0_wl u_t020_006/r3_w1_wl u_t020_006/r3_r0_rwl u_t020_006/r3_r1_rwl
+ u_t020_006/VDD u_t020_009/VSS u_t020_006/m2_717_1265# u_t020_006/m2_603_2031# u_t020_006/m2_1290_336#
+ u_t020_006/m2_2000_2037# u_t020_006/m2_791_2909# u_t020_006/m2_7_2126# u_t020_006/m2_2154_2081#
+ u_t020_006/m2_1795_2037# u_t020_006/m2_871_303# u_t020_006/m2_431_438# u_t020_006/m2_1290_2898#
+ u_t020_006/m2_1714_1210# u_t020_006/m2_431_1982# u_t020_006/m2_512_1265# u_t020_006/m2_2573_2126#
+ u_t020_006/m2_603_1259# u_t020_006/m2_2074_2909# u_t020_006/m2_7_336# u_t020_006/m2_717_2037#
+ u_t020_006/m2_1886_2031# u_t020_006/m2_2573_336# u_t020_006/m2_7_2898# u_t020_006/m2_2000_1265#
+ u_t020_006/m2_512_2037# u_t020_006/m2_1795_1265# u_t020_006/m2_1714_1982# u_t020_006/m2_1886_1259#
+ u_t020_006/m2_1290_2126# u_t020_006/m2_1714_438# u_t020_006/m2_431_1210# u_t020_006/m2_2573_2898#
+ u_t020_006/m2_2154_303# u_t020_006/m2_871_2081# VSUBS detronyx_12t_2w2r_rc4_4x4_routed_5layer_direct
Xu_t005_003 u_t005_003/c0_w0_bl u_t005_003/c0_w0_br u_t005_003/c0_w1_bl u_t005_003/c0_w1_br
+ u_t005_003/c0_r0_rbl u_t005_003/c0_r1_rbl u_t005_003/c1_w0_bl u_t005_003/c1_w0_br
+ u_t005_003/c1_w1_bl u_t005_003/c1_w1_br u_t005_003/c1_r0_rbl u_t005_003/c1_r1_rbl
+ u_t005_003/c2_w0_bl u_t005_003/c2_w0_br u_t005_003/c2_w1_bl u_t005_003/c2_w1_br
+ u_t005_003/c2_r0_rbl u_t005_003/c2_r1_rbl u_t005_003/c3_w0_bl u_t005_003/c3_w0_br
+ u_t005_003/c3_w1_bl u_t005_003/c3_w1_br u_t005_003/c3_r0_rbl u_t005_003/c3_r1_rbl
+ u_t005_003/r0_w0_wl u_t005_003/r0_w1_wl u_t005_003/r0_r0_rwl u_t005_003/r0_r1_rwl
+ u_t005_003/r1_w0_wl u_t005_003/r1_w1_wl u_t005_003/r1_r0_rwl u_t005_003/r1_r1_rwl
+ u_t005_003/r2_w0_wl u_t005_003/r2_w1_wl u_t005_003/r2_r0_rwl u_t005_003/r2_r1_rwl
+ u_t005_003/r3_w0_wl u_t005_003/r3_w1_wl u_t005_003/r3_r0_rwl u_t005_003/r3_r1_rwl
+ u_t005_003/VDD VSS u_t005_003/m2_717_1265# u_t005_003/m2_603_2031# u_t005_003/m2_1290_336#
+ u_t005_003/m2_2000_2037# u_t005_003/m2_791_2909# u_t005_003/m2_7_2126# u_t005_003/m2_2154_2081#
+ u_t005_003/m2_1795_2037# u_t005_003/m2_871_303# u_t005_003/m2_431_438# u_t005_003/m2_1290_2898#
+ u_t005_003/m2_1714_1210# u_t005_003/m2_431_1982# u_t005_003/m2_512_1265# u_t005_003/m2_2573_2126#
+ u_t005_003/m2_603_1259# u_t005_003/m2_2074_2909# u_t005_003/m2_7_336# u_t005_003/m2_717_2037#
+ u_t005_003/m2_1886_2031# u_t005_003/m2_2573_336# u_t005_003/m2_7_2898# u_t005_003/m2_2000_1265#
+ u_t005_003/m2_512_2037# u_t005_003/m2_1795_1265# u_t005_003/m2_1714_1982# u_t005_003/m2_1886_1259#
+ u_t005_003/m2_1290_2126# u_t005_003/m2_1714_438# u_t005_003/m2_431_1210# u_t005_003/m2_2573_2898#
+ u_t005_003/m2_2154_303# u_t005_003/m2_871_2081# VSUBS detronyx_12t_2w2r_rc4_4x4_routed_5layer_direct
Xu_t011_006 u_t011_006/c0_w0_bl u_t011_006/c0_w0_br u_t011_006/c0_w1_bl u_t011_006/c0_w1_br
+ u_t011_006/c0_r0_rbl u_t011_006/c0_r1_rbl u_t011_006/c1_w0_bl u_t011_006/c1_w0_br
+ u_t011_006/c1_w1_bl u_t011_006/c1_w1_br u_t011_006/c1_r0_rbl u_t011_006/c1_r1_rbl
+ u_t011_006/c2_w0_bl u_t011_006/c2_w0_br u_t011_006/c2_w1_bl u_t011_006/c2_w1_br
+ u_t011_006/c2_r0_rbl u_t011_006/c2_r1_rbl u_t011_006/c3_w0_bl u_t011_006/c3_w0_br
+ u_t011_006/c3_w1_bl u_t011_006/c3_w1_br u_t011_006/c3_r0_rbl u_t011_006/c3_r1_rbl
+ u_t011_006/r0_w0_wl u_t011_006/r0_w1_wl u_t011_006/r0_r0_rwl u_t011_006/r0_r1_rwl
+ u_t011_006/r1_w0_wl u_t011_006/r1_w1_wl u_t011_006/r1_r0_rwl u_t011_006/r1_r1_rwl
+ u_t011_006/r2_w0_wl u_t011_006/r2_w1_wl u_t011_006/r2_r0_rwl u_t011_006/r2_r1_rwl
+ u_t011_006/r3_w0_wl u_t011_006/r3_w1_wl u_t011_006/r3_r0_rwl u_t011_006/r3_r1_rwl
+ u_t011_006/VDD u_t011_009/VSS u_t011_006/m2_717_1265# u_t011_006/m2_603_2031# u_t011_006/m2_1290_336#
+ u_t011_006/m2_2000_2037# u_t011_006/m2_791_2909# u_t011_006/m2_7_2126# u_t011_006/m2_2154_2081#
+ u_t011_006/m2_1795_2037# u_t011_006/m2_871_303# u_t011_006/m2_431_438# u_t011_006/m2_1290_2898#
+ u_t011_006/m2_1714_1210# u_t011_006/m2_431_1982# u_t011_006/m2_512_1265# u_t011_006/m2_2573_2126#
+ u_t011_006/m2_603_1259# u_t011_006/m2_2074_2909# u_t011_006/m2_7_336# u_t011_006/m2_717_2037#
+ u_t011_006/m2_1886_2031# u_t011_006/m2_2573_336# u_t011_006/m2_7_2898# u_t011_006/m2_2000_1265#
+ u_t011_006/m2_512_2037# u_t011_006/m2_1795_1265# u_t011_006/m2_1714_1982# u_t011_006/m2_1886_1259#
+ u_t011_006/m2_1290_2126# u_t011_006/m2_1714_438# u_t011_006/m2_431_1210# u_t011_006/m2_2573_2898#
+ u_t011_006/m2_2154_303# u_t011_006/m2_871_2081# VSUBS detronyx_12t_2w2r_rc4_4x4_routed_5layer_direct
Xu_t002_006 u_t002_006/c0_w0_bl u_t002_006/c0_w0_br u_t002_006/c0_w1_bl u_t002_006/c0_w1_br
+ u_t002_006/c0_r0_rbl u_t002_006/c0_r1_rbl u_t002_006/c1_w0_bl u_t002_006/c1_w0_br
+ u_t002_006/c1_w1_bl u_t002_006/c1_w1_br u_t002_006/c1_r0_rbl u_t002_006/c1_r1_rbl
+ u_t002_006/c2_w0_bl u_t002_006/c2_w0_br u_t002_006/c2_w1_bl u_t002_006/c2_w1_br
+ u_t002_006/c2_r0_rbl u_t002_006/c2_r1_rbl u_t002_006/c3_w0_bl u_t002_006/c3_w0_br
+ u_t002_006/c3_w1_bl u_t002_006/c3_w1_br u_t002_006/c3_r0_rbl u_t002_006/c3_r1_rbl
+ u_t002_006/r0_w0_wl u_t002_006/r0_w1_wl u_t002_006/r0_r0_rwl u_t002_006/r0_r1_rwl
+ u_t002_006/r1_w0_wl u_t002_006/r1_w1_wl u_t002_006/r1_r0_rwl u_t002_006/r1_r1_rwl
+ u_t002_006/r2_w0_wl u_t002_006/r2_w1_wl u_t002_006/r2_r0_rwl u_t002_006/r2_r1_rwl
+ u_t002_006/r3_w0_wl u_t002_006/r3_w1_wl u_t002_006/r3_r0_rwl u_t002_006/r3_r1_rwl
+ u_t002_006/VDD u_t002_009/VSS u_t002_006/m2_717_1265# u_t002_006/m2_603_2031# u_t002_006/m2_1290_336#
+ u_t002_006/m2_2000_2037# u_t002_006/m2_791_2909# u_t002_006/m2_7_2126# u_t002_006/m2_2154_2081#
+ u_t002_006/m2_1795_2037# u_t002_006/m2_871_303# u_t002_006/m2_431_438# u_t002_006/m2_1290_2898#
+ u_t002_006/m2_1714_1210# u_t002_006/m2_431_1982# u_t002_006/m2_512_1265# u_t002_006/m2_2573_2126#
+ u_t002_006/m2_603_1259# u_t002_006/m2_2074_2909# u_t002_006/m2_7_336# u_t002_006/m2_717_2037#
+ u_t002_006/m2_1886_2031# u_t002_006/m2_2573_336# u_t002_006/m2_7_2898# u_t002_006/m2_2000_1265#
+ u_t002_006/m2_512_2037# u_t002_006/m2_1795_1265# u_t002_006/m2_1714_1982# u_t002_006/m2_1886_1259#
+ u_t002_006/m2_1290_2126# u_t002_006/m2_1714_438# u_t002_006/m2_431_1210# u_t002_006/m2_2573_2898#
+ u_t002_006/m2_2154_303# u_t002_006/m2_871_2081# VSUBS detronyx_12t_2w2r_rc4_4x4_routed_5layer_direct
Xgf180mcu_as_sc_mcu7t3v3__inv_2_1207 gf180mcu_as_sc_mcu7t3v3__nand3_2_65/VDD gf180mcu_as_sc_mcu7t3v3__nor2_2_9/VSS
+ VSS VSS gf180mcu_as_sc_mcu7t3v3__nand3_2_65/VNW VSUBS gf180mcu_as_sc_mcu7t3v3__inv_2
Xgf180mcu_as_sc_mcu7t3v3__inv_2_1218 VSS VSS VSS VSS gf180mcu_as_sc_mcu7t3v3__inv_2_1274/VNW
+ VSUBS gf180mcu_as_sc_mcu7t3v3__inv_2
Xgf180mcu_as_sc_mcu7t3v3__inv_2_1229 VSS VSS VSS VSS gf180mcu_as_sc_mcu7t3v3__inv_2_1278/VNW
+ VSUBS gf180mcu_as_sc_mcu7t3v3__inv_2
Xgf180mcu_as_sc_mcu7t3v3__nand4_2_502 gf180mcu_as_sc_mcu7t3v3__inv_2_1649/VDD gf180mcu_as_sc_mcu7t3v3__inv_2_1665/VDD
+ VSS VSS VSS VSS VSS gf180mcu_as_sc_mcu7t3v3__inv_2_1649/VNW VSUBS gf180mcu_as_sc_mcu7t3v3__nand4_2
Xgf180mcu_as_sc_mcu7t3v3__nand4_2_513 gf180mcu_as_sc_mcu7t3v3__inv_2_960/VSS VSS VSS
+ VSS VSS VSS VSS gf180mcu_as_sc_mcu7t3v3__inv_2_1726/VNW VSUBS gf180mcu_as_sc_mcu7t3v3__nand4_2
Xgf180mcu_as_sc_mcu7t3v3__inv_2_34 gf180mcu_as_sc_mcu7t3v3__inv_2_4/VDD gf180mcu_as_sc_mcu7t3v3__inv_2_4/VDD
+ VSS gf180mcu_as_sc_mcu7t3v3__inv_2_8/Y gf180mcu_as_sc_mcu7t3v3__inv_2_36/VNW VSUBS
+ gf180mcu_as_sc_mcu7t3v3__inv_2
Xgf180mcu_as_sc_mcu7t3v3__inv_2_12 gf180mcu_as_sc_mcu7t3v3__inv_2_8/VSS gf180mcu_as_sc_mcu7t3v3__inv_2_8/VSS
+ gf180mcu_as_sc_mcu7t3v3__inv_2_24/Y VSS gf180mcu_as_sc_mcu7t3v3__inv_2_12/VNW VSUBS
+ gf180mcu_as_sc_mcu7t3v3__inv_2
Xgf180mcu_as_sc_mcu7t3v3__inv_2_23 gf180mcu_as_sc_mcu7t3v3__inv_2_24/VDD VSS gf180mcu_as_sc_mcu7t3v3__inv_2_24/Y
+ gf180mcu_as_sc_mcu7t3v3__inv_2_24/Y gf180mcu_as_sc_mcu7t3v3__inv_2_24/VNW VSUBS
+ gf180mcu_as_sc_mcu7t3v3__inv_2
Xgf180mcu_as_sc_mcu7t3v3__inv_2_1015 VSS gf180mcu_as_sc_mcu7t3v3__inv_2_1028/VDD gf180mcu_as_sc_mcu7t3v3__inv_2_1041/A
+ gf180mcu_as_sc_mcu7t3v3__inv_2_1016/Y gf180mcu_as_sc_mcu7t3v3__inv_2_1016/VNW VSUBS
+ gf180mcu_as_sc_mcu7t3v3__inv_2
Xgf180mcu_as_sc_mcu7t3v3__inv_2_1026 gf180mcu_as_sc_mcu7t3v3__inv_2_1028/VDD gf180mcu_as_sc_mcu7t3v3__inv_2_1049/VDD
+ VSS gf180mcu_as_sc_mcu7t3v3__inv_2_1041/A gf180mcu_as_sc_mcu7t3v3__inv_2_1028/VNW
+ VSUBS gf180mcu_as_sc_mcu7t3v3__inv_2
Xgf180mcu_as_sc_mcu7t3v3__inv_2_1037 VSS gf180mcu_as_sc_mcu7t3v3__inv_2_1053/VDD gf180mcu_as_sc_mcu7t3v3__inv_2_1037/Y
+ VSS gf180mcu_as_sc_mcu7t3v3__inv_2_1037/VNW VSUBS gf180mcu_as_sc_mcu7t3v3__inv_2
Xgf180mcu_as_sc_mcu7t3v3__inv_2_1048 gf180mcu_as_sc_mcu7t3v3__inv_2_1048/VDD gf180mcu_as_sc_mcu7t3v3__inv_2_1052/VDD
+ gf180mcu_as_sc_mcu7t3v3__inv_2_1048/Y VSS gf180mcu_as_sc_mcu7t3v3__inv_2_1048/VNW
+ VSUBS gf180mcu_as_sc_mcu7t3v3__inv_2
Xgf180mcu_as_sc_mcu7t3v3__inv_2_78 gf180mcu_as_sc_mcu7t3v3__inv_2_94/VDD gf180mcu_as_sc_mcu7t3v3__inv_2_94/VSS
+ gf180mcu_as_sc_mcu7t3v3__inv_2_78/Y VSS gf180mcu_as_sc_mcu7t3v3__inv_2_94/VNW VSUBS
+ gf180mcu_as_sc_mcu7t3v3__inv_2
Xgf180mcu_as_sc_mcu7t3v3__inv_2_89 gf180mcu_as_sc_mcu7t3v3__inv_2_91/VSS gf180mcu_as_sc_mcu7t3v3__inv_2_97/VDD
+ gf180mcu_as_sc_mcu7t3v3__inv_2_89/Y VSS gf180mcu_as_sc_mcu7t3v3__inv_2_90/VNW VSUBS
+ gf180mcu_as_sc_mcu7t3v3__inv_2
Xgf180mcu_as_sc_mcu7t3v3__inv_2_45 gf180mcu_as_sc_mcu7t3v3__inv_2_46/VDD gf180mcu_as_sc_mcu7t3v3__inv_2_62/VDD
+ gf180mcu_as_sc_mcu7t3v3__inv_2_45/Y gf180mcu_as_sc_mcu7t3v3__inv_2_9/Y gf180mcu_as_sc_mcu7t3v3__inv_2_46/VNW
+ VSUBS gf180mcu_as_sc_mcu7t3v3__inv_2
Xgf180mcu_as_sc_mcu7t3v3__inv_2_67 gf180mcu_as_sc_mcu7t3v3__inv_2_69/VDD gf180mcu_as_sc_mcu7t3v3__inv_2_73/VDD
+ VSS gf180mcu_as_sc_mcu7t3v3__inv_2_73/Y gf180mcu_as_sc_mcu7t3v3__inv_2_69/VNW VSUBS
+ gf180mcu_as_sc_mcu7t3v3__inv_2
Xgf180mcu_as_sc_mcu7t3v3__inv_2_56 gf180mcu_as_sc_mcu7t3v3__inv_2_57/VDD gf180mcu_as_sc_mcu7t3v3__inv_2_61/VDD
+ gf180mcu_as_sc_mcu7t3v3__inv_2_56/Y gf180mcu_as_sc_mcu7t3v3__inv_2_61/Y gf180mcu_as_sc_mcu7t3v3__inv_2_57/VNW
+ VSUBS gf180mcu_as_sc_mcu7t3v3__inv_2
Xgf180mcu_as_sc_mcu7t3v3__inv_2_1004 VSS VSS gf180mcu_as_sc_mcu7t3v3__inv_2_1004/Y
+ VSS gf180mcu_as_sc_mcu7t3v3__inv_2_1004/VNW VSUBS gf180mcu_as_sc_mcu7t3v3__inv_2
Xgf180mcu_as_sc_mcu7t3v3__inv_2_1059 gf180mcu_as_sc_mcu7t3v3__inv_2_1061/VDD gf180mcu_as_sc_mcu7t3v3__inv_2_964/VDD
+ VSS gf180mcu_as_sc_mcu7t3v3__inv_2_962/A gf180mcu_as_sc_mcu7t3v3__inv_2_1061/VNW
+ VSUBS gf180mcu_as_sc_mcu7t3v3__inv_2
Xgf180mcu_as_sc_mcu7t3v3__inv_2_1593 gf180mcu_as_sc_mcu7t3v3__inv_2_1594/VDD VSS VSS
+ VSS gf180mcu_as_sc_mcu7t3v3__inv_2_1594/VNW VSUBS gf180mcu_as_sc_mcu7t3v3__inv_2
Xgf180mcu_as_sc_mcu7t3v3__inv_2_1571 gf180mcu_as_sc_mcu7t3v3__inv_2_1573/VDD VSS VSS
+ VSS gf180mcu_as_sc_mcu7t3v3__inv_2_1573/VNW VSUBS gf180mcu_as_sc_mcu7t3v3__inv_2
Xgf180mcu_as_sc_mcu7t3v3__inv_2_1582 gf180mcu_as_sc_mcu7t3v3__inv_2_1582/VDD VSS gf180mcu_as_sc_mcu7t3v3__inv_2_1582/Y
+ VSS gf180mcu_as_sc_mcu7t3v3__inv_2_1582/VNW VSUBS gf180mcu_as_sc_mcu7t3v3__inv_2
Xgf180mcu_as_sc_mcu7t3v3__inv_2_1560 gf180mcu_as_sc_mcu7t3v3__inv_2_1562/VDD gf180mcu_as_sc_mcu7t3v3__inv_2_1562/VSS
+ VSS VSS gf180mcu_as_sc_mcu7t3v3__inv_2_1562/VNW VSUBS gf180mcu_as_sc_mcu7t3v3__inv_2
Xgf180mcu_as_sc_mcu7t3v3__nand3_2_4 gf180mcu_as_sc_mcu7t3v3__nor2_2_7/VDD gf180mcu_as_sc_mcu7t3v3__nand3_2_4/VSS
+ VSS VSS VSS VSS gf180mcu_as_sc_mcu7t3v3__nor2_2_7/VNW VSUBS gf180mcu_as_sc_mcu7t3v3__nand3_2
Xgf180mcu_as_sc_mcu7t3v3__nand4_2_310 gf180mcu_as_sc_mcu7t3v3__inv_2_1058/VSS VSS
+ VSS VSS VSS VSS VSS gf180mcu_as_sc_mcu7t3v3__inv_2_1020/VNW VSUBS gf180mcu_as_sc_mcu7t3v3__nand4_2
Xgf180mcu_as_sc_mcu7t3v3__nand4_2_376 VSS VSS VSS VSS VSS VSS gf180mcu_as_sc_mcu7t3v3__nand4_2_376/Y
+ gf180mcu_as_sc_mcu7t3v3__inv_2_1277/VNW VSUBS gf180mcu_as_sc_mcu7t3v3__nand4_2
Xgf180mcu_as_sc_mcu7t3v3__nand4_2_365 VSS VSS VSS VSS VSS VSS VSS gf180mcu_as_sc_mcu7t3v3__inv_2_1278/VNW
+ VSUBS gf180mcu_as_sc_mcu7t3v3__nand4_2
Xgf180mcu_as_sc_mcu7t3v3__nand4_2_343 VSS VSS VSS VSS VSS VSS VSS gf180mcu_as_sc_mcu7t3v3__inv_2_1118/VNW
+ VSUBS gf180mcu_as_sc_mcu7t3v3__nand4_2
Xgf180mcu_as_sc_mcu7t3v3__nand4_2_321 gf180mcu_as_sc_mcu7t3v3__inv_2_1079/VDD VSS
+ VSS VSS VSS VSS VSS gf180mcu_as_sc_mcu7t3v3__inv_2_1079/VNW VSUBS gf180mcu_as_sc_mcu7t3v3__nand4_2
Xgf180mcu_as_sc_mcu7t3v3__nand4_2_354 VSS VSS VSS VSS VSS VSS VSS gf180mcu_as_sc_mcu7t3v3__inv_2_1293/VNW
+ VSUBS gf180mcu_as_sc_mcu7t3v3__nand4_2
Xgf180mcu_as_sc_mcu7t3v3__nand4_2_332 VSS gf180mcu_as_sc_mcu7t3v3__inv_2_1112/VDD
+ VSS VSS VSS VSS VSS gf180mcu_as_sc_mcu7t3v3__inv_2_1096/VNW VSUBS gf180mcu_as_sc_mcu7t3v3__nand4_2
Xgf180mcu_as_sc_mcu7t3v3__nand4_2_398 gf180mcu_as_sc_mcu7t3v3__inv_2_1476/VSS gf180mcu_as_sc_mcu7t3v3__inv_2_1482/VDD
+ VSS VSS VSS VSS gf180mcu_as_sc_mcu7t3v3__nand4_2_398/Y gf180mcu_as_sc_mcu7t3v3__inv_2_1464/VNW
+ VSUBS gf180mcu_as_sc_mcu7t3v3__nand4_2
Xgf180mcu_as_sc_mcu7t3v3__nand4_2_387 VSS gf180mcu_as_sc_mcu7t3v3__inv_2_1434/VDD
+ VSS VSS VSS VSS gf180mcu_as_sc_mcu7t3v3__nand4_2_387/Y gf180mcu_as_sc_mcu7t3v3__inv_2_1431/VNW
+ VSUBS gf180mcu_as_sc_mcu7t3v3__nand4_2
Xgf180mcu_as_sc_mcu7t3v3__inv_2_307 gf180mcu_as_sc_mcu7t3v3__inv_2_307/VDD gf180mcu_as_sc_mcu7t3v3__inv_2_311/VDD
+ gf180mcu_as_sc_mcu7t3v3__inv_2_365/Y VSS gf180mcu_as_sc_mcu7t3v3__inv_2_307/VNW
+ VSUBS gf180mcu_as_sc_mcu7t3v3__inv_2
Xgf180mcu_as_sc_mcu7t3v3__inv_2_329 gf180mcu_as_sc_mcu7t3v3__inv_2_329/VDD gf180mcu_as_sc_mcu7t3v3__inv_2_332/VDD
+ gf180mcu_as_sc_mcu7t3v3__inv_2_341/Y VSS gf180mcu_as_sc_mcu7t3v3__inv_2_329/VNW
+ VSUBS gf180mcu_as_sc_mcu7t3v3__inv_2
Xgf180mcu_as_sc_mcu7t3v3__inv_2_318 gf180mcu_as_sc_mcu7t3v3__inv_2_320/VDD gf180mcu_as_sc_mcu7t3v3__inv_2_323/VDD
+ VSS gf180mcu_as_sc_mcu7t3v3__inv_2_341/Y gf180mcu_as_sc_mcu7t3v3__inv_2_320/VNW
+ VSUBS gf180mcu_as_sc_mcu7t3v3__inv_2
Xgf180mcu_as_sc_mcu7t3v3__inv_2_1390 VSS gf180mcu_as_sc_mcu7t3v3__inv_2_1394/VDD gf180mcu_as_sc_mcu7t3v3__inv_2_1394/Y
+ VSS gf180mcu_as_sc_mcu7t3v3__inv_2_1390/VNW VSUBS gf180mcu_as_sc_mcu7t3v3__inv_2
Xgf180mcu_as_sc_mcu7t3v3__inv_2_896 VSS VSS VSS VSS gf180mcu_as_sc_mcu7t3v3__inv_2_926/VNW
+ VSUBS gf180mcu_as_sc_mcu7t3v3__inv_2
Xgf180mcu_as_sc_mcu7t3v3__inv_2_852 gf180mcu_as_sc_mcu7t3v3__inv_2_854/VDD gf180mcu_as_sc_mcu7t3v3__inv_2_854/VSS
+ gf180mcu_as_sc_mcu7t3v3__inv_2_852/Y gf180mcu_as_sc_mcu7t3v3__inv_2_853/Y gf180mcu_as_sc_mcu7t3v3__inv_2_854/VNW
+ VSUBS gf180mcu_as_sc_mcu7t3v3__inv_2
Xgf180mcu_as_sc_mcu7t3v3__inv_2_830 VSS VSS VSS VSS gf180mcu_as_sc_mcu7t3v3__inv_2_830/VNW
+ VSUBS gf180mcu_as_sc_mcu7t3v3__inv_2
Xgf180mcu_as_sc_mcu7t3v3__inv_2_841 VSS VSS VSS VSS gf180mcu_as_sc_mcu7t3v3__inv_2_841/VNW
+ VSUBS gf180mcu_as_sc_mcu7t3v3__inv_2
Xgf180mcu_as_sc_mcu7t3v3__inv_2_863 VSS VSS VSS VSS gf180mcu_as_sc_mcu7t3v3__inv_2_938/VNW
+ VSUBS gf180mcu_as_sc_mcu7t3v3__inv_2
Xgf180mcu_as_sc_mcu7t3v3__inv_2_885 VSS VSS gf180mcu_as_sc_mcu7t3v3__inv_2_885/Y VSS
+ gf180mcu_as_sc_mcu7t3v3__inv_2_934/VNW VSUBS gf180mcu_as_sc_mcu7t3v3__inv_2
Xgf180mcu_as_sc_mcu7t3v3__inv_2_874 VSS VSS gf180mcu_as_sc_mcu7t3v3__inv_2_874/Y VSS
+ gf180mcu_as_sc_mcu7t3v3__inv_2_930/VNW VSUBS gf180mcu_as_sc_mcu7t3v3__inv_2
Xgf180mcu_as_sc_mcu7t3v3__nand4_2_151 gf180mcu_as_sc_mcu7t3v3__nor2_2_4/VDD gf180mcu_as_sc_mcu7t3v3__nand2_2_3/VSS
+ VSS VSS VSS VSS VSS gf180mcu_as_sc_mcu7t3v3__nor2_2_4/VNW VSUBS gf180mcu_as_sc_mcu7t3v3__nand4_2
Xgf180mcu_as_sc_mcu7t3v3__nand4_2_140 VSS VSS VSS VSS VSS VSS gf180mcu_as_sc_mcu7t3v3__nand4_2_140/Y
+ gf180mcu_as_sc_mcu7t3v3__inv_2_537/VNW VSUBS gf180mcu_as_sc_mcu7t3v3__nand4_2
Xgf180mcu_as_sc_mcu7t3v3__nand4_2_162 gf180mcu_as_sc_mcu7t3v3__inv_2_854/VSS gf180mcu_as_sc_mcu7t3v3__inv_2_620/VDD
+ VSS VSS VSS VSS VSS gf180mcu_as_sc_mcu7t3v3__inv_2_616/VNW VSUBS gf180mcu_as_sc_mcu7t3v3__nand4_2
Xu_t026_012 u_t026_012/c0_w0_bl u_t026_012/c0_w0_br u_t026_012/c0_w1_bl u_t026_012/c0_w1_br
+ u_t026_012/c0_r0_rbl u_t026_012/c0_r1_rbl u_t026_012/c1_w0_bl u_t026_012/c1_w0_br
+ u_t026_012/c1_w1_bl u_t026_012/c1_w1_br u_t026_012/c1_r0_rbl u_t026_012/c1_r1_rbl
+ u_t026_012/c2_w0_bl u_t026_012/c2_w0_br u_t026_012/c2_w1_bl u_t026_012/c2_w1_br
+ u_t026_012/c2_r0_rbl u_t026_012/c2_r1_rbl u_t026_012/c3_w0_bl u_t026_012/c3_w0_br
+ u_t026_012/c3_w1_bl u_t026_012/c3_w1_br u_t026_012/c3_r0_rbl u_t026_012/c3_r1_rbl
+ u_t026_012/r0_w0_wl u_t026_012/r0_w1_wl u_t026_012/r0_r0_rwl u_t026_012/r0_r1_rwl
+ u_t026_012/r1_w0_wl u_t026_012/r1_w1_wl u_t026_012/r1_r0_rwl u_t026_012/r1_r1_rwl
+ u_t026_012/r2_w0_wl u_t026_012/r2_w1_wl u_t026_012/r2_r0_rwl u_t026_012/r2_r1_rwl
+ u_t026_012/r3_w0_wl u_t026_012/r3_w1_wl u_t026_012/r3_r0_rwl u_t026_012/r3_r1_rwl
+ u_t026_012/VDD VSS u_t026_012/m2_717_1265# u_t026_012/m2_603_2031# u_t026_012/m2_1290_336#
+ u_t026_012/m2_2000_2037# u_t026_012/m2_791_2909# u_t026_012/m2_7_2126# u_t026_012/m2_2154_2081#
+ u_t026_012/m2_1795_2037# u_t026_012/m2_871_303# u_t026_012/m2_431_438# u_t026_012/m2_1290_2898#
+ u_t026_012/m2_1714_1210# u_t026_012/m2_431_1982# u_t026_012/m2_512_1265# u_t026_012/m2_2573_2126#
+ u_t026_012/m2_603_1259# u_t026_012/m2_2074_2909# u_t026_012/m2_7_336# u_t026_012/m2_717_2037#
+ u_t026_012/m2_1886_2031# u_t026_012/m2_2573_336# u_t026_012/m2_7_2898# u_t026_012/m2_2000_1265#
+ u_t026_012/m2_512_2037# u_t026_012/m2_1795_1265# u_t026_012/m2_1714_1982# u_t026_012/m2_1886_1259#
+ u_t026_012/m2_1290_2126# u_t026_012/m2_1714_438# u_t026_012/m2_431_1210# u_t026_012/m2_2573_2898#
+ u_t026_012/m2_2154_303# u_t026_012/m2_871_2081# VSUBS detronyx_12t_2w2r_rc4_4x4_routed_5layer_direct
Xu_t026_001 u_t026_001/c0_w0_bl u_t026_001/c0_w0_br u_t026_001/c0_w1_bl u_t026_001/c0_w1_br
+ u_t026_001/c0_r0_rbl u_t026_001/c0_r1_rbl u_t026_001/c1_w0_bl u_t026_001/c1_w0_br
+ u_t026_001/c1_w1_bl u_t026_001/c1_w1_br u_t026_001/c1_r0_rbl u_t026_001/c1_r1_rbl
+ u_t026_001/c2_w0_bl u_t026_001/c2_w0_br u_t026_001/c2_w1_bl u_t026_001/c2_w1_br
+ u_t026_001/c2_r0_rbl u_t026_001/c2_r1_rbl u_t026_001/c3_w0_bl u_t026_001/c3_w0_br
+ u_t026_001/c3_w1_bl u_t026_001/c3_w1_br u_t026_001/c3_r0_rbl u_t026_001/c3_r1_rbl
+ u_t026_001/r0_w0_wl u_t026_001/r0_w1_wl u_t026_001/r0_r0_rwl u_t026_001/r0_r1_rwl
+ u_t026_001/r1_w0_wl u_t026_001/r1_w1_wl u_t026_001/r1_r0_rwl u_t026_001/r1_r1_rwl
+ u_t026_001/r2_w0_wl u_t026_001/r2_w1_wl u_t026_001/r2_r0_rwl u_t026_001/r2_r1_rwl
+ u_t026_001/r3_w0_wl u_t026_001/r3_w1_wl u_t026_001/r3_r0_rwl u_t026_001/r3_r1_rwl
+ VSS VSS u_t026_001/m2_717_1265# u_t026_001/m2_603_2031# u_t026_001/m2_1290_336#
+ u_t026_001/m2_2000_2037# u_t026_001/m2_791_2909# u_t026_001/m2_7_2126# u_t026_001/m2_2154_2081#
+ u_t026_001/m2_1795_2037# u_t026_001/m2_871_303# u_t026_001/m2_431_438# u_t026_001/m2_1290_2898#
+ u_t026_001/m2_1714_1210# u_t026_001/m2_431_1982# u_t026_001/m2_512_1265# u_t026_001/m2_2573_2126#
+ u_t026_001/m2_603_1259# u_t026_001/m2_2074_2909# u_t026_001/m2_7_336# u_t026_001/m2_717_2037#
+ u_t026_001/m2_1886_2031# u_t026_001/m2_2573_336# u_t026_001/m2_7_2898# u_t026_001/m2_2000_1265#
+ u_t026_001/m2_512_2037# u_t026_001/m2_1795_1265# u_t026_001/m2_1714_1982# u_t026_001/m2_1886_1259#
+ u_t026_001/m2_1290_2126# u_t026_001/m2_1714_438# u_t026_001/m2_431_1210# u_t026_001/m2_2573_2898#
+ u_t026_001/m2_2154_303# u_t026_001/m2_871_2081# VSUBS detronyx_12t_2w2r_rc4_4x4_routed_5layer_direct
Xgf180mcu_as_sc_mcu7t3v3__nand4_2_173 gf180mcu_as_sc_mcu7t3v3__inv_2_617/VDD gf180mcu_as_sc_mcu7t3v3__inv_2_633/VDD
+ VSS VSS VSS VSS VSS gf180mcu_as_sc_mcu7t3v3__inv_2_617/VNW VSUBS gf180mcu_as_sc_mcu7t3v3__nand4_2
Xgf180mcu_as_sc_mcu7t3v3__nand4_2_90 VSS gf180mcu_as_sc_mcu7t3v3__inv_2_46/VDD VSS
+ VSS VSS VSS VSS gf180mcu_as_sc_mcu7t3v3__inv_2_42/VNW VSUBS gf180mcu_as_sc_mcu7t3v3__nand4_2
Xgf180mcu_as_sc_mcu7t3v3__nand4_2_184 VSS gf180mcu_as_sc_mcu7t3v3__inv_2_712/VDD VSS
+ VSS VSS VSS VSS gf180mcu_as_sc_mcu7t3v3__inv_2_708/VNW VSUBS gf180mcu_as_sc_mcu7t3v3__nand4_2
Xgf180mcu_as_sc_mcu7t3v3__nand4_2_195 VSS gf180mcu_as_sc_mcu7t3v3__inv_2_731/VDD VSS
+ VSS VSS VSS VSS gf180mcu_as_sc_mcu7t3v3__inv_2_717/VNW VSUBS gf180mcu_as_sc_mcu7t3v3__nand4_2
Xu_t017_012 u_t017_012/c0_w0_bl u_t017_012/c0_w0_br u_t017_012/c0_w1_bl u_t017_012/c0_w1_br
+ u_t017_012/c0_r0_rbl u_t017_012/c0_r1_rbl u_t017_012/c1_w0_bl u_t017_012/c1_w0_br
+ u_t017_012/c1_w1_bl u_t017_012/c1_w1_br u_t017_012/c1_r0_rbl u_t017_012/c1_r1_rbl
+ u_t017_012/c2_w0_bl u_t017_012/c2_w0_br u_t017_012/c2_w1_bl u_t017_012/c2_w1_br
+ u_t017_012/c2_r0_rbl u_t017_012/c2_r1_rbl u_t017_012/c3_w0_bl u_t017_012/c3_w0_br
+ u_t017_012/c3_w1_bl u_t017_012/c3_w1_br u_t017_012/c3_r0_rbl u_t017_012/c3_r1_rbl
+ u_t017_012/r0_w0_wl u_t017_012/r0_w1_wl u_t017_012/r0_r0_rwl u_t017_012/r0_r1_rwl
+ u_t017_012/r1_w0_wl u_t017_012/r1_w1_wl u_t017_012/r1_r0_rwl u_t017_012/r1_r1_rwl
+ u_t017_012/r2_w0_wl u_t017_012/r2_w1_wl u_t017_012/r2_r0_rwl u_t017_012/r2_r1_rwl
+ u_t017_012/r3_w0_wl u_t017_012/r3_w1_wl u_t017_012/r3_r0_rwl u_t017_012/r3_r1_rwl
+ u_t017_012/VDD VSS u_t017_012/m2_717_1265# u_t017_012/m2_603_2031# u_t017_012/m2_1290_336#
+ u_t017_012/m2_2000_2037# u_t017_012/m2_791_2909# u_t017_012/m2_7_2126# u_t017_012/m2_2154_2081#
+ u_t017_012/m2_1795_2037# u_t017_012/m2_871_303# u_t017_012/m2_431_438# u_t017_012/m2_1290_2898#
+ u_t017_012/m2_1714_1210# u_t017_012/m2_431_1982# u_t017_012/m2_512_1265# u_t017_012/m2_2573_2126#
+ u_t017_012/m2_603_1259# u_t017_012/m2_2074_2909# u_t017_012/m2_7_336# u_t017_012/m2_717_2037#
+ u_t017_012/m2_1886_2031# u_t017_012/m2_2573_336# u_t017_012/m2_7_2898# u_t017_012/m2_2000_1265#
+ u_t017_012/m2_512_2037# u_t017_012/m2_1795_1265# u_t017_012/m2_1714_1982# u_t017_012/m2_1886_1259#
+ u_t017_012/m2_1290_2126# u_t017_012/m2_1714_438# u_t017_012/m2_431_1210# u_t017_012/m2_2573_2898#
+ u_t017_012/m2_2154_303# u_t017_012/m2_871_2081# VSUBS detronyx_12t_2w2r_rc4_4x4_routed_5layer_direct
Xu_t017_001 u_t017_001/c0_w0_bl u_t017_001/c0_w0_br u_t017_001/c0_w1_bl u_t017_001/c0_w1_br
+ u_t017_001/c0_r0_rbl u_t017_001/c0_r1_rbl u_t017_001/c1_w0_bl u_t017_001/c1_w0_br
+ u_t017_001/c1_w1_bl u_t017_001/c1_w1_br u_t017_001/c1_r0_rbl u_t017_001/c1_r1_rbl
+ u_t017_001/c2_w0_bl u_t017_001/c2_w0_br u_t017_001/c2_w1_bl u_t017_001/c2_w1_br
+ u_t017_001/c2_r0_rbl u_t017_001/c2_r1_rbl u_t017_001/c3_w0_bl u_t017_001/c3_w0_br
+ u_t017_001/c3_w1_bl u_t017_001/c3_w1_br u_t017_001/c3_r0_rbl u_t017_001/c3_r1_rbl
+ u_t017_001/r0_w0_wl u_t017_001/r0_w1_wl u_t017_001/r0_r0_rwl u_t017_001/r0_r1_rwl
+ u_t017_001/r1_w0_wl u_t017_001/r1_w1_wl u_t017_001/r1_r0_rwl u_t017_001/r1_r1_rwl
+ u_t017_001/r2_w0_wl u_t017_001/r2_w1_wl u_t017_001/r2_r0_rwl u_t017_001/r2_r1_rwl
+ u_t017_001/r3_w0_wl u_t017_001/r3_w1_wl u_t017_001/r3_r0_rwl u_t017_001/r3_r1_rwl
+ VSS VSS u_t017_001/m2_717_1265# u_t017_001/m2_603_2031# u_t017_001/m2_1290_336#
+ u_t017_001/m2_2000_2037# u_t017_001/m2_791_2909# u_t017_001/m2_7_2126# u_t017_001/m2_2154_2081#
+ u_t017_001/m2_1795_2037# u_t017_001/m2_871_303# u_t017_001/m2_431_438# u_t017_001/m2_1290_2898#
+ u_t017_001/m2_1714_1210# u_t017_001/m2_431_1982# u_t017_001/m2_512_1265# u_t017_001/m2_2573_2126#
+ u_t017_001/m2_603_1259# u_t017_001/m2_2074_2909# u_t017_001/m2_7_336# u_t017_001/m2_717_2037#
+ u_t017_001/m2_1886_2031# u_t017_001/m2_2573_336# u_t017_001/m2_7_2898# u_t017_001/m2_2000_1265#
+ u_t017_001/m2_512_2037# u_t017_001/m2_1795_1265# u_t017_001/m2_1714_1982# u_t017_001/m2_1886_1259#
+ u_t017_001/m2_1290_2126# u_t017_001/m2_1714_438# u_t017_001/m2_431_1210# u_t017_001/m2_2573_2898#
+ u_t017_001/m2_2154_303# u_t017_001/m2_871_2081# VSUBS detronyx_12t_2w2r_rc4_4x4_routed_5layer_direct
Xgf180mcu_as_sc_mcu7t3v3__inv_2_104 VSS gf180mcu_as_sc_mcu7t3v3__inv_2_99/VSS gf180mcu_as_sc_mcu7t3v3__inv_2_104/Y
+ VSS gf180mcu_as_sc_mcu7t3v3__inv_2_99/VNW VSUBS gf180mcu_as_sc_mcu7t3v3__inv_2
Xgf180mcu_as_sc_mcu7t3v3__inv_2_148 VSS gf180mcu_as_sc_mcu7t3v3__inv_2_152/VDD VSS
+ VSS gf180mcu_as_sc_mcu7t3v3__inv_2_149/VNW VSUBS gf180mcu_as_sc_mcu7t3v3__inv_2
Xgf180mcu_as_sc_mcu7t3v3__inv_2_137 gf180mcu_as_sc_mcu7t3v3__inv_2_137/VDD VSS VSS
+ VSS gf180mcu_as_sc_mcu7t3v3__inv_2_137/VNW VSUBS gf180mcu_as_sc_mcu7t3v3__inv_2
Xgf180mcu_as_sc_mcu7t3v3__inv_2_126 gf180mcu_as_sc_mcu7t3v3__inv_2_131/VDD gf180mcu_as_sc_mcu7t3v3__inv_2_131/VDD
+ gf180mcu_as_sc_mcu7t3v3__inv_2_126/Y VSS gf180mcu_as_sc_mcu7t3v3__inv_2_128/VNW
+ VSUBS gf180mcu_as_sc_mcu7t3v3__inv_2
Xgf180mcu_as_sc_mcu7t3v3__inv_2_115 gf180mcu_as_sc_mcu7t3v3__inv_2_116/VDD gf180mcu_as_sc_mcu7t3v3__inv_2_122/VDD
+ gf180mcu_as_sc_mcu7t3v3__inv_2_115/Y VSS gf180mcu_as_sc_mcu7t3v3__inv_2_116/VNW
+ VSUBS gf180mcu_as_sc_mcu7t3v3__inv_2
Xgf180mcu_as_sc_mcu7t3v3__inv_2_159 gf180mcu_as_sc_mcu7t3v3__inv_2_177/VSS gf180mcu_as_sc_mcu7t3v3__inv_2_163/VDD
+ gf180mcu_as_sc_mcu7t3v3__inv_2_159/Y VSS gf180mcu_as_sc_mcu7t3v3__inv_2_160/VNW
+ VSUBS gf180mcu_as_sc_mcu7t3v3__inv_2
Xu_t008_012 u_t008_012/c0_w0_bl u_t008_012/c0_w0_br u_t008_012/c0_w1_bl u_t008_012/c0_w1_br
+ u_t008_012/c0_r0_rbl u_t008_012/c0_r1_rbl u_t008_012/c1_w0_bl u_t008_012/c1_w0_br
+ u_t008_012/c1_w1_bl u_t008_012/c1_w1_br u_t008_012/c1_r0_rbl u_t008_012/c1_r1_rbl
+ u_t008_012/c2_w0_bl u_t008_012/c2_w0_br u_t008_012/c2_w1_bl u_t008_012/c2_w1_br
+ u_t008_012/c2_r0_rbl u_t008_012/c2_r1_rbl u_t008_012/c3_w0_bl u_t008_012/c3_w0_br
+ u_t008_012/c3_w1_bl u_t008_012/c3_w1_br u_t008_012/c3_r0_rbl u_t008_012/c3_r1_rbl
+ u_t008_012/r0_w0_wl u_t008_012/r0_w1_wl u_t008_012/r0_r0_rwl u_t008_012/r0_r1_rwl
+ u_t008_012/r1_w0_wl u_t008_012/r1_w1_wl u_t008_012/r1_r0_rwl u_t008_012/r1_r1_rwl
+ u_t008_012/r2_w0_wl u_t008_012/r2_w1_wl u_t008_012/r2_r0_rwl u_t008_012/r2_r1_rwl
+ u_t008_012/r3_w0_wl u_t008_012/r3_w1_wl u_t008_012/r3_r0_rwl u_t008_012/r3_r1_rwl
+ u_t008_012/VDD VSS u_t008_012/m2_717_1265# u_t008_012/m2_603_2031# u_t008_012/m2_1290_336#
+ u_t008_012/m2_2000_2037# u_t008_012/m2_791_2909# u_t008_012/m2_7_2126# u_t008_012/m2_2154_2081#
+ u_t008_012/m2_1795_2037# u_t008_012/m2_871_303# u_t008_012/m2_431_438# u_t008_012/m2_1290_2898#
+ u_t008_012/m2_1714_1210# u_t008_012/m2_431_1982# u_t008_012/m2_512_1265# u_t008_012/m2_2573_2126#
+ u_t008_012/m2_603_1259# u_t008_012/m2_2074_2909# u_t008_012/m2_7_336# u_t008_012/m2_717_2037#
+ u_t008_012/m2_1886_2031# u_t008_012/m2_2573_336# u_t008_012/m2_7_2898# u_t008_012/m2_2000_1265#
+ u_t008_012/m2_512_2037# u_t008_012/m2_1795_1265# u_t008_012/m2_1714_1982# u_t008_012/m2_1886_1259#
+ u_t008_012/m2_1290_2126# u_t008_012/m2_1714_438# u_t008_012/m2_431_1210# u_t008_012/m2_2573_2898#
+ u_t008_012/m2_2154_303# u_t008_012/m2_871_2081# VSUBS detronyx_12t_2w2r_rc4_4x4_routed_5layer_direct
Xu_t023_004 u_t023_004/c0_w0_bl u_t023_004/c0_w0_br u_t023_004/c0_w1_bl u_t023_004/c0_w1_br
+ u_t023_004/c0_r0_rbl u_t023_004/c0_r1_rbl u_t023_004/c1_w0_bl u_t023_004/c1_w0_br
+ u_t023_004/c1_w1_bl u_t023_004/c1_w1_br u_t023_004/c1_r0_rbl u_t023_004/c1_r1_rbl
+ u_t023_004/c2_w0_bl u_t023_004/c2_w0_br u_t023_004/c2_w1_bl u_t023_004/c2_w1_br
+ u_t023_004/c2_r0_rbl u_t023_004/c2_r1_rbl u_t023_004/c3_w0_bl u_t023_004/c3_w0_br
+ u_t023_004/c3_w1_bl u_t023_004/c3_w1_br u_t023_004/c3_r0_rbl u_t023_004/c3_r1_rbl
+ u_t023_004/r0_w0_wl u_t023_004/r0_w1_wl u_t023_004/r0_r0_rwl u_t023_004/r0_r1_rwl
+ u_t023_004/r1_w0_wl u_t023_004/r1_w1_wl u_t023_004/r1_r0_rwl u_t023_004/r1_r1_rwl
+ u_t023_004/r2_w0_wl u_t023_004/r2_w1_wl u_t023_004/r2_r0_rwl u_t023_004/r2_r1_rwl
+ u_t023_004/r3_w0_wl u_t023_004/r3_w1_wl u_t023_004/r3_r0_rwl u_t023_004/r3_r1_rwl
+ u_t023_004/VDD u_t023_004/VSS u_t023_004/m2_717_1265# u_t023_004/m2_603_2031# u_t023_004/m2_1290_336#
+ u_t023_004/m2_2000_2037# u_t023_004/m2_791_2909# u_t023_004/m2_7_2126# u_t023_004/m2_2154_2081#
+ u_t023_004/m2_1795_2037# u_t023_004/m2_871_303# u_t023_004/m2_431_438# u_t023_004/m2_1290_2898#
+ u_t023_004/m2_1714_1210# u_t023_004/m2_431_1982# u_t023_004/m2_512_1265# u_t023_004/m2_2573_2126#
+ u_t023_004/m2_603_1259# u_t023_004/m2_2074_2909# u_t023_004/m2_7_336# u_t023_004/m2_717_2037#
+ u_t023_004/m2_1886_2031# u_t023_004/m2_2573_336# u_t023_004/m2_7_2898# u_t023_004/m2_2000_1265#
+ u_t023_004/m2_512_2037# u_t023_004/m2_1795_1265# u_t023_004/m2_1714_1982# u_t023_004/m2_1886_1259#
+ u_t023_004/m2_1290_2126# u_t023_004/m2_1714_438# u_t023_004/m2_431_1210# u_t023_004/m2_2573_2898#
+ u_t023_004/m2_2154_303# u_t023_004/m2_871_2081# VSUBS detronyx_12t_2w2r_rc4_4x4_routed_5layer_direct
Xu_t008_001 u_t008_001/c0_w0_bl u_t008_001/c0_w0_br u_t008_001/c0_w1_bl u_t008_001/c0_w1_br
+ u_t008_001/c0_r0_rbl u_t008_001/c0_r1_rbl u_t008_001/c1_w0_bl u_t008_001/c1_w0_br
+ u_t008_001/c1_w1_bl u_t008_001/c1_w1_br u_t008_001/c1_r0_rbl u_t008_001/c1_r1_rbl
+ u_t008_001/c2_w0_bl u_t008_001/c2_w0_br u_t008_001/c2_w1_bl u_t008_001/c2_w1_br
+ u_t008_001/c2_r0_rbl u_t008_001/c2_r1_rbl u_t008_001/c3_w0_bl u_t008_001/c3_w0_br
+ u_t008_001/c3_w1_bl u_t008_001/c3_w1_br u_t008_001/c3_r0_rbl u_t008_001/c3_r1_rbl
+ u_t008_001/r0_w0_wl u_t008_001/r0_w1_wl u_t008_001/r0_r0_rwl u_t008_001/r0_r1_rwl
+ u_t008_001/r1_w0_wl u_t008_001/r1_w1_wl u_t008_001/r1_r0_rwl u_t008_001/r1_r1_rwl
+ u_t008_001/r2_w0_wl u_t008_001/r2_w1_wl u_t008_001/r2_r0_rwl u_t008_001/r2_r1_rwl
+ u_t008_001/r3_w0_wl u_t008_001/r3_w1_wl u_t008_001/r3_r0_rwl u_t008_001/r3_r1_rwl
+ VSS VSS u_t008_001/m2_717_1265# u_t008_001/m2_603_2031# u_t008_001/m2_1290_336#
+ u_t008_001/m2_2000_2037# u_t008_001/m2_791_2909# u_t008_001/m2_7_2126# u_t008_001/m2_2154_2081#
+ u_t008_001/m2_1795_2037# u_t008_001/m2_871_303# u_t008_001/m2_431_438# u_t008_001/m2_1290_2898#
+ u_t008_001/m2_1714_1210# u_t008_001/m2_431_1982# u_t008_001/m2_512_1265# u_t008_001/m2_2573_2126#
+ u_t008_001/m2_603_1259# u_t008_001/m2_2074_2909# u_t008_001/m2_7_336# u_t008_001/m2_717_2037#
+ u_t008_001/m2_1886_2031# u_t008_001/m2_2573_336# u_t008_001/m2_7_2898# u_t008_001/m2_2000_1265#
+ u_t008_001/m2_512_2037# u_t008_001/m2_1795_1265# u_t008_001/m2_1714_1982# u_t008_001/m2_1886_1259#
+ u_t008_001/m2_1290_2126# u_t008_001/m2_1714_438# u_t008_001/m2_431_1210# u_t008_001/m2_2573_2898#
+ u_t008_001/m2_2154_303# u_t008_001/m2_871_2081# VSUBS detronyx_12t_2w2r_rc4_4x4_routed_5layer_direct
Xu_t023_015 u_t023_015/c0_w0_bl u_t023_015/c0_w0_br u_t023_015/c0_w1_bl u_t023_015/c0_w1_br
+ u_t023_015/c0_r0_rbl u_t023_015/c0_r1_rbl u_t023_015/c1_w0_bl u_t023_015/c1_w0_br
+ u_t023_015/c1_w1_bl u_t023_015/c1_w1_br u_t023_015/c1_r0_rbl u_t023_015/c1_r1_rbl
+ u_t023_015/c2_w0_bl u_t023_015/c2_w0_br u_t023_015/c2_w1_bl u_t023_015/c2_w1_br
+ u_t023_015/c2_r0_rbl u_t023_015/c2_r1_rbl u_t023_015/c3_w0_bl u_t023_015/c3_w0_br
+ u_t023_015/c3_w1_bl u_t023_015/c3_w1_br u_t023_015/c3_r0_rbl u_t023_015/c3_r1_rbl
+ u_t023_015/r0_w0_wl u_t023_015/r0_w1_wl u_t023_015/r0_r0_rwl u_t023_015/r0_r1_rwl
+ u_t023_015/r1_w0_wl u_t023_015/r1_w1_wl u_t023_015/r1_r0_rwl u_t023_015/r1_r1_rwl
+ u_t023_015/r2_w0_wl u_t023_015/r2_w1_wl u_t023_015/r2_r0_rwl u_t023_015/r2_r1_rwl
+ u_t023_015/r3_w0_wl u_t023_015/r3_w1_wl u_t023_015/r3_r0_rwl u_t023_015/r3_r1_rwl
+ VSS u_t023_015/VSS u_t023_015/m2_717_1265# u_t023_015/m2_603_2031# u_t023_015/m2_1290_336#
+ u_t023_015/m2_2000_2037# u_t023_015/m2_791_2909# u_t023_015/m2_7_2126# u_t023_015/m2_2154_2081#
+ u_t023_015/m2_1795_2037# u_t023_015/m2_871_303# u_t023_015/m2_431_438# u_t023_015/m2_1290_2898#
+ u_t023_015/m2_1714_1210# u_t023_015/m2_431_1982# u_t023_015/m2_512_1265# u_t023_015/m2_2573_2126#
+ u_t023_015/m2_603_1259# u_t023_015/m2_2074_2909# u_t023_015/m2_7_336# u_t023_015/m2_717_2037#
+ u_t023_015/m2_1886_2031# u_t023_015/m2_2573_336# u_t023_015/m2_7_2898# u_t023_015/m2_2000_1265#
+ u_t023_015/m2_512_2037# u_t023_015/m2_1795_1265# u_t023_015/m2_1714_1982# u_t023_015/m2_1886_1259#
+ u_t023_015/m2_1290_2126# u_t023_015/m2_1714_438# u_t023_015/m2_431_1210# u_t023_015/m2_2573_2898#
+ u_t023_015/m2_2154_303# u_t023_015/m2_871_2081# VSUBS detronyx_12t_2w2r_rc4_4x4_routed_5layer_direct
Xgf180mcu_as_sc_mcu7t3v3__inv_2_682 VSS gf180mcu_as_sc_mcu7t3v3__inv_2_688/VDD gf180mcu_as_sc_mcu7t3v3__inv_2_682/Y
+ gf180mcu_as_sc_mcu7t3v3__inv_2_853/Y gf180mcu_as_sc_mcu7t3v3__inv_2_684/VNW VSUBS
+ gf180mcu_as_sc_mcu7t3v3__inv_2
Xgf180mcu_as_sc_mcu7t3v3__inv_2_660 VSS gf180mcu_as_sc_mcu7t3v3__inv_2_664/VDD gf180mcu_as_sc_mcu7t3v3__inv_2_660/Y
+ VSS gf180mcu_as_sc_mcu7t3v3__inv_2_660/VNW VSUBS gf180mcu_as_sc_mcu7t3v3__inv_2
Xgf180mcu_as_sc_mcu7t3v3__inv_2_671 VSS gf180mcu_as_sc_mcu7t3v3__inv_2_679/VSS VSS
+ gf180mcu_as_sc_mcu7t3v3__inv_2_675/Y gf180mcu_as_sc_mcu7t3v3__inv_2_679/VNW VSUBS
+ gf180mcu_as_sc_mcu7t3v3__inv_2
Xgf180mcu_as_sc_mcu7t3v3__inv_2_693 gf180mcu_as_sc_mcu7t3v3__inv_2_743/VDD gf180mcu_as_sc_mcu7t3v3__inv_2_743/VSS
+ gf180mcu_as_sc_mcu7t3v3__inv_2_743/A VSS gf180mcu_as_sc_mcu7t3v3__inv_2_743/VNW
+ VSUBS gf180mcu_as_sc_mcu7t3v3__inv_2
Xu_t014_015 u_t014_015/c0_w0_bl u_t014_015/c0_w0_br u_t014_015/c0_w1_bl u_t014_015/c0_w1_br
+ u_t014_015/c0_r0_rbl u_t014_015/c0_r1_rbl u_t014_015/c1_w0_bl u_t014_015/c1_w0_br
+ u_t014_015/c1_w1_bl u_t014_015/c1_w1_br u_t014_015/c1_r0_rbl u_t014_015/c1_r1_rbl
+ u_t014_015/c2_w0_bl u_t014_015/c2_w0_br u_t014_015/c2_w1_bl u_t014_015/c2_w1_br
+ u_t014_015/c2_r0_rbl u_t014_015/c2_r1_rbl u_t014_015/c3_w0_bl u_t014_015/c3_w0_br
+ u_t014_015/c3_w1_bl u_t014_015/c3_w1_br u_t014_015/c3_r0_rbl u_t014_015/c3_r1_rbl
+ u_t014_015/r0_w0_wl u_t014_015/r0_w1_wl u_t014_015/r0_r0_rwl u_t014_015/r0_r1_rwl
+ u_t014_015/r1_w0_wl u_t014_015/r1_w1_wl u_t014_015/r1_r0_rwl u_t014_015/r1_r1_rwl
+ u_t014_015/r2_w0_wl u_t014_015/r2_w1_wl u_t014_015/r2_r0_rwl u_t014_015/r2_r1_rwl
+ u_t014_015/r3_w0_wl u_t014_015/r3_w1_wl u_t014_015/r3_r0_rwl u_t014_015/r3_r1_rwl
+ VSS u_t014_015/VSS u_t014_015/m2_717_1265# u_t014_015/m2_603_2031# u_t014_015/m2_1290_336#
+ u_t014_015/m2_2000_2037# u_t014_015/m2_791_2909# u_t014_015/m2_7_2126# u_t014_015/m2_2154_2081#
+ u_t014_015/m2_1795_2037# u_t014_015/m2_871_303# u_t014_015/m2_431_438# u_t014_015/m2_1290_2898#
+ u_t014_015/m2_1714_1210# u_t014_015/m2_431_1982# u_t014_015/m2_512_1265# u_t014_015/m2_2573_2126#
+ u_t014_015/m2_603_1259# u_t014_015/m2_2074_2909# u_t014_015/m2_7_336# u_t014_015/m2_717_2037#
+ u_t014_015/m2_1886_2031# u_t014_015/m2_2573_336# u_t014_015/m2_7_2898# u_t014_015/m2_2000_1265#
+ u_t014_015/m2_512_2037# u_t014_015/m2_1795_1265# u_t014_015/m2_1714_1982# u_t014_015/m2_1886_1259#
+ u_t014_015/m2_1290_2126# u_t014_015/m2_1714_438# u_t014_015/m2_431_1210# u_t014_015/m2_2573_2898#
+ u_t014_015/m2_2154_303# u_t014_015/m2_871_2081# VSUBS detronyx_12t_2w2r_rc4_4x4_routed_5layer_direct
Xu_t014_004 u_t014_004/c0_w0_bl u_t014_004/c0_w0_br u_t014_004/c0_w1_bl u_t014_004/c0_w1_br
+ u_t014_004/c0_r0_rbl u_t014_004/c0_r1_rbl u_t014_004/c1_w0_bl u_t014_004/c1_w0_br
+ u_t014_004/c1_w1_bl u_t014_004/c1_w1_br u_t014_004/c1_r0_rbl u_t014_004/c1_r1_rbl
+ u_t014_004/c2_w0_bl u_t014_004/c2_w0_br u_t014_004/c2_w1_bl u_t014_004/c2_w1_br
+ u_t014_004/c2_r0_rbl u_t014_004/c2_r1_rbl u_t014_004/c3_w0_bl u_t014_004/c3_w0_br
+ u_t014_004/c3_w1_bl u_t014_004/c3_w1_br u_t014_004/c3_r0_rbl u_t014_004/c3_r1_rbl
+ u_t014_004/r0_w0_wl u_t014_004/r0_w1_wl u_t014_004/r0_r0_rwl u_t014_004/r0_r1_rwl
+ u_t014_004/r1_w0_wl u_t014_004/r1_w1_wl u_t014_004/r1_r0_rwl u_t014_004/r1_r1_rwl
+ u_t014_004/r2_w0_wl u_t014_004/r2_w1_wl u_t014_004/r2_r0_rwl u_t014_004/r2_r1_rwl
+ u_t014_004/r3_w0_wl u_t014_004/r3_w1_wl u_t014_004/r3_r0_rwl u_t014_004/r3_r1_rwl
+ u_t014_004/VDD u_t014_004/VSS u_t014_004/m2_717_1265# u_t014_004/m2_603_2031# u_t014_004/m2_1290_336#
+ u_t014_004/m2_2000_2037# u_t014_004/m2_791_2909# u_t014_004/m2_7_2126# u_t014_004/m2_2154_2081#
+ u_t014_004/m2_1795_2037# u_t014_004/m2_871_303# u_t014_004/m2_431_438# u_t014_004/m2_1290_2898#
+ u_t014_004/m2_1714_1210# u_t014_004/m2_431_1982# u_t014_004/m2_512_1265# u_t014_004/m2_2573_2126#
+ u_t014_004/m2_603_1259# u_t014_004/m2_2074_2909# u_t014_004/m2_7_336# u_t014_004/m2_717_2037#
+ u_t014_004/m2_1886_2031# u_t014_004/m2_2573_336# u_t014_004/m2_7_2898# u_t014_004/m2_2000_1265#
+ u_t014_004/m2_512_2037# u_t014_004/m2_1795_1265# u_t014_004/m2_1714_1982# u_t014_004/m2_1886_1259#
+ u_t014_004/m2_1290_2126# u_t014_004/m2_1714_438# u_t014_004/m2_431_1210# u_t014_004/m2_2573_2898#
+ u_t014_004/m2_2154_303# u_t014_004/m2_871_2081# VSUBS detronyx_12t_2w2r_rc4_4x4_routed_5layer_direct
Xgf180mcu_as_sc_mcu7t3v3__nand2_2_49 gf180mcu_as_sc_mcu7t3v3__nor2_2_9/VDD gf180mcu_as_sc_mcu7t3v3__nand3_2_63/VSS
+ VSS VSS VSS gf180mcu_as_sc_mcu7t3v3__nor2_2_9/VNW VSUBS gf180mcu_as_sc_mcu7t3v3__nand2_2
Xgf180mcu_as_sc_mcu7t3v3__nand2_2_38 gf180mcu_as_sc_mcu7t3v3__nor2_2_9/VDD gf180mcu_as_sc_mcu7t3v3__nand3_2_63/VSS
+ VSS VSS VSS gf180mcu_as_sc_mcu7t3v3__nor2_2_9/VNW VSUBS gf180mcu_as_sc_mcu7t3v3__nand2_2
Xgf180mcu_as_sc_mcu7t3v3__nand2_2_27 gf180mcu_as_sc_mcu7t3v3__nor2_2_7/VDD gf180mcu_as_sc_mcu7t3v3__nand3_2_4/VSS
+ VSS VSS VSS gf180mcu_as_sc_mcu7t3v3__nor2_2_7/VNW VSUBS gf180mcu_as_sc_mcu7t3v3__nand2_2
Xgf180mcu_as_sc_mcu7t3v3__nand2_2_16 gf180mcu_as_sc_mcu7t3v3__nor2_2_7/VDD gf180mcu_as_sc_mcu7t3v3__nand3_2_4/VSS
+ VSS VSS VSS gf180mcu_as_sc_mcu7t3v3__nor2_2_7/VNW VSUBS gf180mcu_as_sc_mcu7t3v3__nand2_2
Xu_t005_004 u_t005_004/c0_w0_bl u_t005_004/c0_w0_br u_t005_004/c0_w1_bl u_t005_004/c0_w1_br
+ u_t005_004/c0_r0_rbl u_t005_004/c0_r1_rbl u_t005_004/c1_w0_bl u_t005_004/c1_w0_br
+ u_t005_004/c1_w1_bl u_t005_004/c1_w1_br u_t005_004/c1_r0_rbl u_t005_004/c1_r1_rbl
+ u_t005_004/c2_w0_bl u_t005_004/c2_w0_br u_t005_004/c2_w1_bl u_t005_004/c2_w1_br
+ u_t005_004/c2_r0_rbl u_t005_004/c2_r1_rbl u_t005_004/c3_w0_bl u_t005_004/c3_w0_br
+ u_t005_004/c3_w1_bl u_t005_004/c3_w1_br u_t005_004/c3_r0_rbl u_t005_004/c3_r1_rbl
+ u_t005_004/r0_w0_wl u_t005_004/r0_w1_wl u_t005_004/r0_r0_rwl u_t005_004/r0_r1_rwl
+ u_t005_004/r1_w0_wl u_t005_004/r1_w1_wl u_t005_004/r1_r0_rwl u_t005_004/r1_r1_rwl
+ u_t005_004/r2_w0_wl u_t005_004/r2_w1_wl u_t005_004/r2_r0_rwl u_t005_004/r2_r1_rwl
+ u_t005_004/r3_w0_wl u_t005_004/r3_w1_wl u_t005_004/r3_r0_rwl u_t005_004/r3_r1_rwl
+ u_t005_004/VDD VSS u_t005_004/m2_717_1265# u_t005_004/m2_603_2031# u_t005_004/m2_1290_336#
+ u_t005_004/m2_2000_2037# u_t005_004/m2_791_2909# u_t005_004/m2_7_2126# u_t005_004/m2_2154_2081#
+ u_t005_004/m2_1795_2037# u_t005_004/m2_871_303# u_t005_004/m2_431_438# u_t005_004/m2_1290_2898#
+ u_t005_004/m2_1714_1210# u_t005_004/m2_431_1982# u_t005_004/m2_512_1265# u_t005_004/m2_2573_2126#
+ u_t005_004/m2_603_1259# u_t005_004/m2_2074_2909# u_t005_004/m2_7_336# u_t005_004/m2_717_2037#
+ u_t005_004/m2_1886_2031# u_t005_004/m2_2573_336# u_t005_004/m2_7_2898# u_t005_004/m2_2000_1265#
+ u_t005_004/m2_512_2037# u_t005_004/m2_1795_1265# u_t005_004/m2_1714_1982# u_t005_004/m2_1886_1259#
+ u_t005_004/m2_1290_2126# u_t005_004/m2_1714_438# u_t005_004/m2_431_1210# u_t005_004/m2_2573_2898#
+ u_t005_004/m2_2154_303# u_t005_004/m2_871_2081# VSUBS detronyx_12t_2w2r_rc4_4x4_routed_5layer_direct
Xu_t005_015 u_t005_015/c0_w0_bl u_t005_015/c0_w0_br u_t005_015/c0_w1_bl u_t005_015/c0_w1_br
+ u_t005_015/c0_r0_rbl u_t005_015/c0_r1_rbl u_t005_015/c1_w0_bl u_t005_015/c1_w0_br
+ u_t005_015/c1_w1_bl u_t005_015/c1_w1_br u_t005_015/c1_r0_rbl u_t005_015/c1_r1_rbl
+ u_t005_015/c2_w0_bl u_t005_015/c2_w0_br u_t005_015/c2_w1_bl u_t005_015/c2_w1_br
+ u_t005_015/c2_r0_rbl u_t005_015/c2_r1_rbl u_t005_015/c3_w0_bl u_t005_015/c3_w0_br
+ u_t005_015/c3_w1_bl u_t005_015/c3_w1_br u_t005_015/c3_r0_rbl u_t005_015/c3_r1_rbl
+ u_t005_015/r0_w0_wl u_t005_015/r0_w1_wl u_t005_015/r0_r0_rwl u_t005_015/r0_r1_rwl
+ u_t005_015/r1_w0_wl u_t005_015/r1_w1_wl u_t005_015/r1_r0_rwl u_t005_015/r1_r1_rwl
+ u_t005_015/r2_w0_wl u_t005_015/r2_w1_wl u_t005_015/r2_r0_rwl u_t005_015/r2_r1_rwl
+ u_t005_015/r3_w0_wl u_t005_015/r3_w1_wl u_t005_015/r3_r0_rwl u_t005_015/r3_r1_rwl
+ VSS VSS u_t005_015/m2_717_1265# u_t005_015/m2_603_2031# u_t005_015/m2_1290_336#
+ u_t005_015/m2_2000_2037# u_t005_015/m2_791_2909# u_t005_015/m2_7_2126# u_t005_015/m2_2154_2081#
+ u_t005_015/m2_1795_2037# u_t005_015/m2_871_303# u_t005_015/m2_431_438# u_t005_015/m2_1290_2898#
+ u_t005_015/m2_1714_1210# u_t005_015/m2_431_1982# u_t005_015/m2_512_1265# u_t005_015/m2_2573_2126#
+ u_t005_015/m2_603_1259# u_t005_015/m2_2074_2909# u_t005_015/m2_7_336# u_t005_015/m2_717_2037#
+ u_t005_015/m2_1886_2031# u_t005_015/m2_2573_336# u_t005_015/m2_7_2898# u_t005_015/m2_2000_1265#
+ u_t005_015/m2_512_2037# u_t005_015/m2_1795_1265# u_t005_015/m2_1714_1982# u_t005_015/m2_1886_1259#
+ u_t005_015/m2_1290_2126# u_t005_015/m2_1714_438# u_t005_015/m2_431_1210# u_t005_015/m2_2573_2898#
+ u_t005_015/m2_2154_303# u_t005_015/m2_871_2081# VSUBS detronyx_12t_2w2r_rc4_4x4_routed_5layer_direct
Xu_t020_007 u_t020_007/c0_w0_bl u_t020_007/c0_w0_br u_t020_007/c0_w1_bl u_t020_007/c0_w1_br
+ u_t020_007/c0_r0_rbl u_t020_007/c0_r1_rbl u_t020_007/c1_w0_bl u_t020_007/c1_w0_br
+ u_t020_007/c1_w1_bl u_t020_007/c1_w1_br u_t020_007/c1_r0_rbl u_t020_007/c1_r1_rbl
+ u_t020_007/c2_w0_bl u_t020_007/c2_w0_br u_t020_007/c2_w1_bl u_t020_007/c2_w1_br
+ u_t020_007/c2_r0_rbl u_t020_007/c2_r1_rbl u_t020_007/c3_w0_bl u_t020_007/c3_w0_br
+ u_t020_007/c3_w1_bl u_t020_007/c3_w1_br u_t020_007/c3_r0_rbl u_t020_007/c3_r1_rbl
+ u_t020_007/r0_w0_wl u_t020_007/r0_w1_wl u_t020_007/r0_r0_rwl u_t020_007/r0_r1_rwl
+ u_t020_007/r1_w0_wl u_t020_007/r1_w1_wl u_t020_007/r1_r0_rwl u_t020_007/r1_r1_rwl
+ u_t020_007/r2_w0_wl u_t020_007/r2_w1_wl u_t020_007/r2_r0_rwl u_t020_007/r2_r1_rwl
+ u_t020_007/r3_w0_wl u_t020_007/r3_w1_wl u_t020_007/r3_r0_rwl u_t020_007/r3_r1_rwl
+ VSS u_t020_009/VSS u_t020_007/m2_717_1265# u_t020_007/m2_603_2031# u_t020_007/m2_1290_336#
+ u_t020_007/m2_2000_2037# u_t020_007/m2_791_2909# u_t020_007/m2_7_2126# u_t020_007/m2_2154_2081#
+ u_t020_007/m2_1795_2037# u_t020_007/m2_871_303# u_t020_007/m2_431_438# u_t020_007/m2_1290_2898#
+ u_t020_007/m2_1714_1210# u_t020_007/m2_431_1982# u_t020_007/m2_512_1265# u_t020_007/m2_2573_2126#
+ u_t020_007/m2_603_1259# u_t020_007/m2_2074_2909# u_t020_007/m2_7_336# u_t020_007/m2_717_2037#
+ u_t020_007/m2_1886_2031# u_t020_007/m2_2573_336# u_t020_007/m2_7_2898# u_t020_007/m2_2000_1265#
+ u_t020_007/m2_512_2037# u_t020_007/m2_1795_1265# u_t020_007/m2_1714_1982# u_t020_007/m2_1886_1259#
+ u_t020_007/m2_1290_2126# u_t020_007/m2_1714_438# u_t020_007/m2_431_1210# u_t020_007/m2_2573_2898#
+ u_t020_007/m2_2154_303# u_t020_007/m2_871_2081# VSUBS detronyx_12t_2w2r_rc4_4x4_routed_5layer_direct
Xgf180mcu_as_sc_mcu7t3v3__inv_2_490 VSS VSS VSS VSS gf180mcu_as_sc_mcu7t3v3__inv_2_560/VNW
+ VSUBS gf180mcu_as_sc_mcu7t3v3__inv_2
Xu_t011_007 u_t011_007/c0_w0_bl u_t011_007/c0_w0_br u_t011_007/c0_w1_bl u_t011_007/c0_w1_br
+ u_t011_007/c0_r0_rbl u_t011_007/c0_r1_rbl u_t011_007/c1_w0_bl u_t011_007/c1_w0_br
+ u_t011_007/c1_w1_bl u_t011_007/c1_w1_br u_t011_007/c1_r0_rbl u_t011_007/c1_r1_rbl
+ u_t011_007/c2_w0_bl u_t011_007/c2_w0_br u_t011_007/c2_w1_bl u_t011_007/c2_w1_br
+ u_t011_007/c2_r0_rbl u_t011_007/c2_r1_rbl u_t011_007/c3_w0_bl u_t011_007/c3_w0_br
+ u_t011_007/c3_w1_bl u_t011_007/c3_w1_br u_t011_007/c3_r0_rbl u_t011_007/c3_r1_rbl
+ u_t011_007/r0_w0_wl u_t011_007/r0_w1_wl u_t011_007/r0_r0_rwl u_t011_007/r0_r1_rwl
+ u_t011_007/r1_w0_wl u_t011_007/r1_w1_wl u_t011_007/r1_r0_rwl u_t011_007/r1_r1_rwl
+ u_t011_007/r2_w0_wl u_t011_007/r2_w1_wl u_t011_007/r2_r0_rwl u_t011_007/r2_r1_rwl
+ u_t011_007/r3_w0_wl u_t011_007/r3_w1_wl u_t011_007/r3_r0_rwl u_t011_007/r3_r1_rwl
+ VSS u_t011_009/VSS u_t011_007/m2_717_1265# u_t011_007/m2_603_2031# u_t011_007/m2_1290_336#
+ u_t011_007/m2_2000_2037# u_t011_007/m2_791_2909# u_t011_007/m2_7_2126# u_t011_007/m2_2154_2081#
+ u_t011_007/m2_1795_2037# u_t011_007/m2_871_303# u_t011_007/m2_431_438# u_t011_007/m2_1290_2898#
+ u_t011_007/m2_1714_1210# u_t011_007/m2_431_1982# u_t011_007/m2_512_1265# u_t011_007/m2_2573_2126#
+ u_t011_007/m2_603_1259# u_t011_007/m2_2074_2909# u_t011_007/m2_7_336# u_t011_007/m2_717_2037#
+ u_t011_007/m2_1886_2031# u_t011_007/m2_2573_336# u_t011_007/m2_7_2898# u_t011_007/m2_2000_1265#
+ u_t011_007/m2_512_2037# u_t011_007/m2_1795_1265# u_t011_007/m2_1714_1982# u_t011_007/m2_1886_1259#
+ u_t011_007/m2_1290_2126# u_t011_007/m2_1714_438# u_t011_007/m2_431_1210# u_t011_007/m2_2573_2898#
+ u_t011_007/m2_2154_303# u_t011_007/m2_871_2081# VSUBS detronyx_12t_2w2r_rc4_4x4_routed_5layer_direct
Xu_t002_007 u_t002_007/c0_w0_bl u_t002_007/c0_w0_br u_t002_007/c0_w1_bl u_t002_007/c0_w1_br
+ u_t002_007/c0_r0_rbl u_t002_007/c0_r1_rbl u_t002_007/c1_w0_bl u_t002_007/c1_w0_br
+ u_t002_007/c1_w1_bl u_t002_007/c1_w1_br u_t002_007/c1_r0_rbl u_t002_007/c1_r1_rbl
+ u_t002_007/c2_w0_bl u_t002_007/c2_w0_br u_t002_007/c2_w1_bl u_t002_007/c2_w1_br
+ u_t002_007/c2_r0_rbl u_t002_007/c2_r1_rbl u_t002_007/c3_w0_bl u_t002_007/c3_w0_br
+ u_t002_007/c3_w1_bl u_t002_007/c3_w1_br u_t002_007/c3_r0_rbl u_t002_007/c3_r1_rbl
+ u_t002_007/r0_w0_wl u_t002_007/r0_w1_wl u_t002_007/r0_r0_rwl u_t002_007/r0_r1_rwl
+ u_t002_007/r1_w0_wl u_t002_007/r1_w1_wl u_t002_007/r1_r0_rwl u_t002_007/r1_r1_rwl
+ u_t002_007/r2_w0_wl u_t002_007/r2_w1_wl u_t002_007/r2_r0_rwl u_t002_007/r2_r1_rwl
+ u_t002_007/r3_w0_wl u_t002_007/r3_w1_wl u_t002_007/r3_r0_rwl u_t002_007/r3_r1_rwl
+ VSS u_t002_009/VSS u_t002_007/m2_717_1265# u_t002_007/m2_603_2031# u_t002_007/m2_1290_336#
+ u_t002_007/m2_2000_2037# u_t002_007/m2_791_2909# u_t002_007/m2_7_2126# u_t002_007/m2_2154_2081#
+ u_t002_007/m2_1795_2037# u_t002_007/m2_871_303# u_t002_007/m2_431_438# u_t002_007/m2_1290_2898#
+ u_t002_007/m2_1714_1210# u_t002_007/m2_431_1982# u_t002_007/m2_512_1265# u_t002_007/m2_2573_2126#
+ u_t002_007/m2_603_1259# u_t002_007/m2_2074_2909# u_t002_007/m2_7_336# u_t002_007/m2_717_2037#
+ u_t002_007/m2_1886_2031# u_t002_007/m2_2573_336# u_t002_007/m2_7_2898# u_t002_007/m2_2000_1265#
+ u_t002_007/m2_512_2037# u_t002_007/m2_1795_1265# u_t002_007/m2_1714_1982# u_t002_007/m2_1886_1259#
+ u_t002_007/m2_1290_2126# u_t002_007/m2_1714_438# u_t002_007/m2_431_1210# u_t002_007/m2_2573_2898#
+ u_t002_007/m2_2154_303# u_t002_007/m2_871_2081# VSUBS detronyx_12t_2w2r_rc4_4x4_routed_5layer_direct
Xgf180mcu_as_sc_mcu7t3v3__inv_2_1208 gf180mcu_as_sc_mcu7t3v3__nor2_2_9/VDD gf180mcu_as_sc_mcu7t3v3__nand3_2_63/VSS
+ VSS VSS gf180mcu_as_sc_mcu7t3v3__nor2_2_9/VNW VSUBS gf180mcu_as_sc_mcu7t3v3__inv_2
Xgf180mcu_as_sc_mcu7t3v3__inv_2_1219 VSS VSS gf180mcu_as_sc_mcu7t3v3__inv_2_1219/Y
+ VSS gf180mcu_as_sc_mcu7t3v3__inv_2_1274/VNW VSUBS gf180mcu_as_sc_mcu7t3v3__inv_2
Xgf180mcu_as_sc_mcu7t3v3__inv_2_1720 gf180mcu_as_sc_mcu7t3v3__inv_2_1720/VDD VSS gf180mcu_as_sc_mcu7t3v3__inv_2_1720/Y
+ VSS gf180mcu_as_sc_mcu7t3v3__inv_2_1720/VNW VSUBS gf180mcu_as_sc_mcu7t3v3__inv_2
Xgf180mcu_as_sc_mcu7t3v3__nand4_2_503 gf180mcu_as_sc_mcu7t3v3__inv_2_1665/VDD VSS
+ VSS VSS VSS VSS VSS gf180mcu_as_sc_mcu7t3v3__inv_2_1665/VNW VSUBS gf180mcu_as_sc_mcu7t3v3__nand4_2
Xgf180mcu_as_sc_mcu7t3v3__inv_2_35 gf180mcu_as_sc_mcu7t3v3__inv_2_4/VDD gf180mcu_as_sc_mcu7t3v3__inv_2_4/VDD
+ gf180mcu_as_sc_mcu7t3v3__inv_2_8/Y gf180mcu_as_sc_mcu7t3v3__inv_2_8/Y gf180mcu_as_sc_mcu7t3v3__inv_2_36/VNW
+ VSUBS gf180mcu_as_sc_mcu7t3v3__inv_2
Xgf180mcu_as_sc_mcu7t3v3__inv_2_24 gf180mcu_as_sc_mcu7t3v3__inv_2_24/VDD VSS gf180mcu_as_sc_mcu7t3v3__inv_2_24/Y
+ VSS gf180mcu_as_sc_mcu7t3v3__inv_2_24/VNW VSUBS gf180mcu_as_sc_mcu7t3v3__inv_2
Xgf180mcu_as_sc_mcu7t3v3__inv_2_13 gf180mcu_as_sc_mcu7t3v3__inv_2_66/VSS gf180mcu_as_sc_mcu7t3v3__inv_2_66/VSS
+ VSS gf180mcu_as_sc_mcu7t3v3__inv_2_66/Y gf180mcu_as_sc_mcu7t3v3__inv_2_66/VNW VSUBS
+ gf180mcu_as_sc_mcu7t3v3__inv_2
Xgf180mcu_as_sc_mcu7t3v3__inv_2_46 gf180mcu_as_sc_mcu7t3v3__inv_2_46/VDD gf180mcu_as_sc_mcu7t3v3__inv_2_62/VDD
+ gf180mcu_as_sc_mcu7t3v3__inv_2_9/Y VSS gf180mcu_as_sc_mcu7t3v3__inv_2_46/VNW VSUBS
+ gf180mcu_as_sc_mcu7t3v3__inv_2
Xgf180mcu_as_sc_mcu7t3v3__inv_2_68 gf180mcu_as_sc_mcu7t3v3__inv_2_69/VDD gf180mcu_as_sc_mcu7t3v3__inv_2_73/VDD
+ gf180mcu_as_sc_mcu7t3v3__inv_2_68/Y gf180mcu_as_sc_mcu7t3v3__inv_2_73/Y gf180mcu_as_sc_mcu7t3v3__inv_2_69/VNW
+ VSUBS gf180mcu_as_sc_mcu7t3v3__inv_2
Xgf180mcu_as_sc_mcu7t3v3__inv_2_57 gf180mcu_as_sc_mcu7t3v3__inv_2_57/VDD gf180mcu_as_sc_mcu7t3v3__inv_2_61/VDD
+ gf180mcu_as_sc_mcu7t3v3__inv_2_61/Y VSS gf180mcu_as_sc_mcu7t3v3__inv_2_57/VNW VSUBS
+ gf180mcu_as_sc_mcu7t3v3__inv_2
Xgf180mcu_as_sc_mcu7t3v3__inv_2_1027 gf180mcu_as_sc_mcu7t3v3__inv_2_1028/VDD gf180mcu_as_sc_mcu7t3v3__inv_2_1049/VDD
+ gf180mcu_as_sc_mcu7t3v3__inv_2_1027/Y gf180mcu_as_sc_mcu7t3v3__inv_2_1028/Y gf180mcu_as_sc_mcu7t3v3__inv_2_1028/VNW
+ VSUBS gf180mcu_as_sc_mcu7t3v3__inv_2
Xgf180mcu_as_sc_mcu7t3v3__inv_2_1016 VSS gf180mcu_as_sc_mcu7t3v3__inv_2_1028/VDD gf180mcu_as_sc_mcu7t3v3__inv_2_1016/Y
+ VSS gf180mcu_as_sc_mcu7t3v3__inv_2_1016/VNW VSUBS gf180mcu_as_sc_mcu7t3v3__inv_2
Xgf180mcu_as_sc_mcu7t3v3__inv_2_1049 gf180mcu_as_sc_mcu7t3v3__inv_2_1049/VDD VSS gf180mcu_as_sc_mcu7t3v3__inv_2_1049/Y
+ VSS gf180mcu_as_sc_mcu7t3v3__inv_2_1049/VNW VSUBS gf180mcu_as_sc_mcu7t3v3__inv_2
Xgf180mcu_as_sc_mcu7t3v3__inv_2_1038 VSS VSS VSS gf180mcu_as_sc_mcu7t3v3__inv_2_962/A
+ gf180mcu_as_sc_mcu7t3v3__inv_2_1040/VNW VSUBS gf180mcu_as_sc_mcu7t3v3__inv_2
Xgf180mcu_as_sc_mcu7t3v3__inv_2_79 gf180mcu_as_sc_mcu7t3v3__inv_2_99/VSS gf180mcu_as_sc_mcu7t3v3__inv_2_94/VDD
+ gf180mcu_as_sc_mcu7t3v3__inv_2_79/Y VSS gf180mcu_as_sc_mcu7t3v3__inv_2_81/VNW VSUBS
+ gf180mcu_as_sc_mcu7t3v3__inv_2
Xgf180mcu_as_sc_mcu7t3v3__inv_2_1005 gf180mcu_as_sc_mcu7t3v3__inv_2_989/VDD gf180mcu_as_sc_mcu7t3v3__inv_2_989/VSS
+ gf180mcu_as_sc_mcu7t3v3__inv_2_1005/Y gf180mcu_as_sc_mcu7t3v3__inv_2_973/Y gf180mcu_as_sc_mcu7t3v3__inv_2_989/VNW
+ VSUBS gf180mcu_as_sc_mcu7t3v3__inv_2
Xgf180mcu_as_sc_mcu7t3v3__inv_2_1594 gf180mcu_as_sc_mcu7t3v3__inv_2_1594/VDD VSS VSS
+ VSS gf180mcu_as_sc_mcu7t3v3__inv_2_1594/VNW VSUBS gf180mcu_as_sc_mcu7t3v3__inv_2
Xgf180mcu_as_sc_mcu7t3v3__inv_2_1572 gf180mcu_as_sc_mcu7t3v3__inv_2_1573/VDD VSS gf180mcu_as_sc_mcu7t3v3__inv_2_1572/Y
+ VSS gf180mcu_as_sc_mcu7t3v3__inv_2_1573/VNW VSUBS gf180mcu_as_sc_mcu7t3v3__inv_2
Xgf180mcu_as_sc_mcu7t3v3__inv_2_1583 VSS VSS VSS VSS gf180mcu_as_sc_mcu7t3v3__inv_2_1585/VNW
+ VSUBS gf180mcu_as_sc_mcu7t3v3__inv_2
Xgf180mcu_as_sc_mcu7t3v3__inv_2_1550 VSS gf180mcu_as_sc_mcu7t3v3__inv_2_1553/VDD gf180mcu_as_sc_mcu7t3v3__inv_2_1550/Y
+ VSS gf180mcu_as_sc_mcu7t3v3__inv_2_1550/VNW VSUBS gf180mcu_as_sc_mcu7t3v3__inv_2
Xgf180mcu_as_sc_mcu7t3v3__inv_2_1561 gf180mcu_as_sc_mcu7t3v3__inv_2_1562/VDD gf180mcu_as_sc_mcu7t3v3__inv_2_1562/VSS
+ gf180mcu_as_sc_mcu7t3v3__inv_2_1561/Y VSS gf180mcu_as_sc_mcu7t3v3__inv_2_1562/VNW
+ VSUBS gf180mcu_as_sc_mcu7t3v3__inv_2
Xgf180mcu_as_sc_mcu7t3v3__nand3_2_5 gf180mcu_as_sc_mcu7t3v3__nor2_2_7/VDD gf180mcu_as_sc_mcu7t3v3__nor2_2_7/VSS
+ VSS VSS VSS VSS gf180mcu_as_sc_mcu7t3v3__nor2_2_7/VNW VSUBS gf180mcu_as_sc_mcu7t3v3__nand3_2
Xgf180mcu_as_sc_mcu7t3v3__nand4_2_344 VSS VSS VSS VSS VSS VSS VSS gf180mcu_as_sc_mcu7t3v3__inv_2_1121/VNW
+ VSUBS gf180mcu_as_sc_mcu7t3v3__nand4_2
Xgf180mcu_as_sc_mcu7t3v3__nand4_2_322 VSS gf180mcu_as_sc_mcu7t3v3__inv_2_1087/VDD
+ VSS VSS VSS VSS VSS gf180mcu_as_sc_mcu7t3v3__inv_2_1083/VNW VSUBS gf180mcu_as_sc_mcu7t3v3__nand4_2
Xgf180mcu_as_sc_mcu7t3v3__nand4_2_333 gf180mcu_as_sc_mcu7t3v3__inv_2_1112/VDD VSS
+ VSS VSS VSS VSS VSS gf180mcu_as_sc_mcu7t3v3__inv_2_1112/VNW VSUBS gf180mcu_as_sc_mcu7t3v3__nand4_2
Xgf180mcu_as_sc_mcu7t3v3__nand4_2_300 gf180mcu_as_sc_mcu7t3v3__inv_2_985/VDD VSS VSS
+ VSS VSS VSS VSS gf180mcu_as_sc_mcu7t3v3__inv_2_985/VNW VSUBS gf180mcu_as_sc_mcu7t3v3__nand4_2
Xgf180mcu_as_sc_mcu7t3v3__nand4_2_311 VSS gf180mcu_as_sc_mcu7t3v3__inv_2_1061/VDD
+ VSS VSS VSS VSS VSS gf180mcu_as_sc_mcu7t3v3__inv_2_1024/VNW VSUBS gf180mcu_as_sc_mcu7t3v3__nand4_2
Xgf180mcu_as_sc_mcu7t3v3__nand4_2_366 VSS VSS VSS VSS VSS VSS VSS gf180mcu_as_sc_mcu7t3v3__inv_2_1282/VNW
+ VSUBS gf180mcu_as_sc_mcu7t3v3__nand4_2
Xgf180mcu_as_sc_mcu7t3v3__nand4_2_377 VSS VSS VSS VSS VSS VSS gf180mcu_as_sc_mcu7t3v3__nand4_2_377/Y
+ gf180mcu_as_sc_mcu7t3v3__inv_2_1286/VNW VSUBS gf180mcu_as_sc_mcu7t3v3__nand4_2
Xgf180mcu_as_sc_mcu7t3v3__nand4_2_355 VSS VSS VSS VSS VSS VSS gf180mcu_as_sc_mcu7t3v3__nand4_2_355/Y
+ gf180mcu_as_sc_mcu7t3v3__inv_2_1301/VNW VSUBS gf180mcu_as_sc_mcu7t3v3__nand4_2
Xgf180mcu_as_sc_mcu7t3v3__nand4_2_399 VSS gf180mcu_as_sc_mcu7t3v3__inv_2_1470/VDD
+ VSS VSS VSS VSS VSS gf180mcu_as_sc_mcu7t3v3__inv_2_1467/VNW VSUBS gf180mcu_as_sc_mcu7t3v3__nand4_2
Xgf180mcu_as_sc_mcu7t3v3__nand4_2_388 gf180mcu_as_sc_mcu7t3v3__inv_2_1434/VDD VSS
+ VSS VSS VSS VSS gf180mcu_as_sc_mcu7t3v3__nand4_2_388/Y gf180mcu_as_sc_mcu7t3v3__inv_2_1434/VNW
+ VSUBS gf180mcu_as_sc_mcu7t3v3__nand4_2
Xu_t029_010 u_t029_010/c0_w0_bl u_t029_010/c0_w0_br u_t029_010/c0_w1_bl u_t029_010/c0_w1_br
+ u_t029_010/c0_r0_rbl u_t029_010/c0_r1_rbl u_t029_010/c1_w0_bl u_t029_010/c1_w0_br
+ u_t029_010/c1_w1_bl u_t029_010/c1_w1_br u_t029_010/c1_r0_rbl u_t029_010/c1_r1_rbl
+ u_t029_010/c2_w0_bl u_t029_010/c2_w0_br u_t029_010/c2_w1_bl u_t029_010/c2_w1_br
+ u_t029_010/c2_r0_rbl u_t029_010/c2_r1_rbl u_t029_010/c3_w0_bl u_t029_010/c3_w0_br
+ u_t029_010/c3_w1_bl u_t029_010/c3_w1_br u_t029_010/c3_r0_rbl u_t029_010/c3_r1_rbl
+ u_t029_010/r0_w0_wl u_t029_010/r0_w1_wl u_t029_010/r0_r0_rwl u_t029_010/r0_r1_rwl
+ u_t029_010/r1_w0_wl u_t029_010/r1_w1_wl u_t029_010/r1_r0_rwl u_t029_010/r1_r1_rwl
+ u_t029_010/r2_w0_wl u_t029_010/r2_w1_wl u_t029_010/r2_r0_rwl u_t029_010/r2_r1_rwl
+ u_t029_010/r3_w0_wl u_t029_010/r3_w1_wl u_t029_010/r3_r0_rwl u_t029_010/r3_r1_rwl
+ VSS VSS u_t029_010/m2_717_1265# u_t029_010/m2_603_2031# u_t029_010/m2_1290_336#
+ u_t029_010/m2_2000_2037# u_t029_010/m2_791_2909# u_t029_010/m2_7_2126# u_t029_010/m2_2154_2081#
+ u_t029_010/m2_1795_2037# u_t029_010/m2_871_303# u_t029_010/m2_431_438# u_t029_010/m2_1290_2898#
+ u_t029_010/m2_1714_1210# u_t029_010/m2_431_1982# u_t029_010/m2_512_1265# u_t029_010/m2_2573_2126#
+ u_t029_010/m2_603_1259# u_t029_010/m2_2074_2909# u_t029_010/m2_7_336# u_t029_010/m2_717_2037#
+ u_t029_010/m2_1886_2031# u_t029_010/m2_2573_336# u_t029_010/m2_7_2898# u_t029_010/m2_2000_1265#
+ u_t029_010/m2_512_2037# u_t029_010/m2_1795_1265# u_t029_010/m2_1714_1982# u_t029_010/m2_1886_1259#
+ u_t029_010/m2_1290_2126# u_t029_010/m2_1714_438# u_t029_010/m2_431_1210# u_t029_010/m2_2573_2898#
+ u_t029_010/m2_2154_303# u_t029_010/m2_871_2081# VSUBS detronyx_12t_2w2r_rc4_4x4_routed_5layer_direct
Xgf180mcu_as_sc_mcu7t3v3__inv_2_308 gf180mcu_as_sc_mcu7t3v3__inv_2_308/VDD gf180mcu_as_sc_mcu7t3v3__inv_2_308/VSS
+ VSS gf180mcu_as_sc_mcu7t3v3__inv_2_61/Y gf180mcu_as_sc_mcu7t3v3__inv_2_308/VNW VSUBS
+ gf180mcu_as_sc_mcu7t3v3__inv_2
Xgf180mcu_as_sc_mcu7t3v3__inv_2_319 gf180mcu_as_sc_mcu7t3v3__inv_2_320/VDD gf180mcu_as_sc_mcu7t3v3__inv_2_323/VDD
+ gf180mcu_as_sc_mcu7t3v3__inv_2_319/Y gf180mcu_as_sc_mcu7t3v3__inv_2_341/Y gf180mcu_as_sc_mcu7t3v3__inv_2_320/VNW
+ VSUBS gf180mcu_as_sc_mcu7t3v3__inv_2
Xgf180mcu_as_sc_mcu7t3v3__inv_2_1380 gf180mcu_as_sc_mcu7t3v3__inv_2_1382/VDD VSS VSS
+ gf180mcu_as_sc_mcu7t3v3__inv_2_1382/Y gf180mcu_as_sc_mcu7t3v3__inv_2_1382/VNW VSUBS
+ gf180mcu_as_sc_mcu7t3v3__inv_2
Xgf180mcu_as_sc_mcu7t3v3__inv_2_1391 gf180mcu_as_sc_mcu7t3v3__inv_2_1391/VDD gf180mcu_as_sc_mcu7t3v3__inv_2_1403/VDD
+ gf180mcu_as_sc_mcu7t3v3__inv_2_1409/A VSS gf180mcu_as_sc_mcu7t3v3__inv_2_1391/VNW
+ VSUBS gf180mcu_as_sc_mcu7t3v3__inv_2
Xgf180mcu_as_sc_mcu7t3v3__inv_2_820 VSS VSS VSS VSS gf180mcu_as_sc_mcu7t3v3__inv_2_820/VNW
+ VSUBS gf180mcu_as_sc_mcu7t3v3__inv_2
Xgf180mcu_as_sc_mcu7t3v3__inv_2_897 VSS VSS VSS VSS gf180mcu_as_sc_mcu7t3v3__inv_2_950/VNW
+ VSUBS gf180mcu_as_sc_mcu7t3v3__inv_2
Xgf180mcu_as_sc_mcu7t3v3__inv_2_853 gf180mcu_as_sc_mcu7t3v3__inv_2_854/VDD gf180mcu_as_sc_mcu7t3v3__inv_2_854/VSS
+ gf180mcu_as_sc_mcu7t3v3__inv_2_853/Y gf180mcu_as_sc_mcu7t3v3__inv_2_854/Y gf180mcu_as_sc_mcu7t3v3__inv_2_854/VNW
+ VSUBS gf180mcu_as_sc_mcu7t3v3__inv_2
Xgf180mcu_as_sc_mcu7t3v3__inv_2_831 VSS VSS VSS VSS gf180mcu_as_sc_mcu7t3v3__inv_2_831/VNW
+ VSUBS gf180mcu_as_sc_mcu7t3v3__inv_2
Xgf180mcu_as_sc_mcu7t3v3__inv_2_842 VSS VSS VSS VSS gf180mcu_as_sc_mcu7t3v3__inv_2_842/VNW
+ VSUBS gf180mcu_as_sc_mcu7t3v3__inv_2
Xgf180mcu_as_sc_mcu7t3v3__inv_2_864 VSS VSS gf180mcu_as_sc_mcu7t3v3__inv_2_864/Y VSS
+ gf180mcu_as_sc_mcu7t3v3__inv_2_938/VNW VSUBS gf180mcu_as_sc_mcu7t3v3__inv_2
Xgf180mcu_as_sc_mcu7t3v3__inv_2_886 VSS VSS VSS VSS gf180mcu_as_sc_mcu7t3v3__inv_2_935/VNW
+ VSUBS gf180mcu_as_sc_mcu7t3v3__inv_2
Xgf180mcu_as_sc_mcu7t3v3__inv_2_875 VSS VSS VSS VSS gf180mcu_as_sc_mcu7t3v3__inv_2_931/VNW
+ VSUBS gf180mcu_as_sc_mcu7t3v3__inv_2
Xgf180mcu_as_sc_mcu7t3v3__nand4_2_152 VSS VSS VSS VSS VSS VSS VSS gf180mcu_as_sc_mcu7t3v3__inv_2_641/VNW
+ VSUBS gf180mcu_as_sc_mcu7t3v3__nand4_2
Xgf180mcu_as_sc_mcu7t3v3__nand4_2_130 VSS VSS VSS VSS VSS VSS VSS gf180mcu_as_sc_mcu7t3v3__inv_2_550/VNW
+ VSUBS gf180mcu_as_sc_mcu7t3v3__nand4_2
Xgf180mcu_as_sc_mcu7t3v3__nand4_2_174 gf180mcu_as_sc_mcu7t3v3__inv_2_633/VDD VSS VSS
+ VSS VSS VSS VSS gf180mcu_as_sc_mcu7t3v3__inv_2_633/VNW VSUBS gf180mcu_as_sc_mcu7t3v3__nand4_2
Xgf180mcu_as_sc_mcu7t3v3__nand4_2_141 VSS VSS VSS VSS VSS VSS VSS gf180mcu_as_sc_mcu7t3v3__inv_2_556/VNW
+ VSUBS gf180mcu_as_sc_mcu7t3v3__nand4_2
Xgf180mcu_as_sc_mcu7t3v3__nand4_2_163 gf180mcu_as_sc_mcu7t3v3__inv_2_620/VDD gf180mcu_as_sc_mcu7t3v3__inv_2_624/VDD
+ VSS VSS VSS VSS VSS gf180mcu_as_sc_mcu7t3v3__inv_2_620/VNW VSUBS gf180mcu_as_sc_mcu7t3v3__nand4_2
Xgf180mcu_as_sc_mcu7t3v3__nand4_2_185 gf180mcu_as_sc_mcu7t3v3__inv_2_712/VDD VSS VSS
+ VSS VSS VSS VSS gf180mcu_as_sc_mcu7t3v3__inv_2_712/VNW VSUBS gf180mcu_as_sc_mcu7t3v3__nand4_2
Xgf180mcu_as_sc_mcu7t3v3__nand4_2_196 gf180mcu_as_sc_mcu7t3v3__inv_2_731/VDD gf180mcu_as_sc_mcu7t3v3__inv_2_741/VDD
+ VSS VSS VSS VSS VSS gf180mcu_as_sc_mcu7t3v3__inv_2_731/VNW VSUBS gf180mcu_as_sc_mcu7t3v3__nand4_2
Xu_t026_013 u_t026_013/c0_w0_bl u_t026_013/c0_w0_br u_t026_013/c0_w1_bl u_t026_013/c0_w1_br
+ u_t026_013/c0_r0_rbl u_t026_013/c0_r1_rbl u_t026_013/c1_w0_bl u_t026_013/c1_w0_br
+ u_t026_013/c1_w1_bl u_t026_013/c1_w1_br u_t026_013/c1_r0_rbl u_t026_013/c1_r1_rbl
+ u_t026_013/c2_w0_bl u_t026_013/c2_w0_br u_t026_013/c2_w1_bl u_t026_013/c2_w1_br
+ u_t026_013/c2_r0_rbl u_t026_013/c2_r1_rbl u_t026_013/c3_w0_bl u_t026_013/c3_w0_br
+ u_t026_013/c3_w1_bl u_t026_013/c3_w1_br u_t026_013/c3_r0_rbl u_t026_013/c3_r1_rbl
+ u_t026_013/r0_w0_wl u_t026_013/r0_w1_wl u_t026_013/r0_r0_rwl u_t026_013/r0_r1_rwl
+ u_t026_013/r1_w0_wl u_t026_013/r1_w1_wl u_t026_013/r1_r0_rwl u_t026_013/r1_r1_rwl
+ u_t026_013/r2_w0_wl u_t026_013/r2_w1_wl u_t026_013/r2_r0_rwl u_t026_013/r2_r1_rwl
+ u_t026_013/r3_w0_wl u_t026_013/r3_w1_wl u_t026_013/r3_r0_rwl u_t026_013/r3_r1_rwl
+ u_t026_013/VDD VSS u_t026_013/m2_717_1265# u_t026_013/m2_603_2031# u_t026_013/m2_1290_336#
+ u_t026_013/m2_2000_2037# u_t026_013/m2_791_2909# u_t026_013/m2_7_2126# u_t026_013/m2_2154_2081#
+ u_t026_013/m2_1795_2037# u_t026_013/m2_871_303# u_t026_013/m2_431_438# u_t026_013/m2_1290_2898#
+ u_t026_013/m2_1714_1210# u_t026_013/m2_431_1982# u_t026_013/m2_512_1265# u_t026_013/m2_2573_2126#
+ u_t026_013/m2_603_1259# u_t026_013/m2_2074_2909# u_t026_013/m2_7_336# u_t026_013/m2_717_2037#
+ u_t026_013/m2_1886_2031# u_t026_013/m2_2573_336# u_t026_013/m2_7_2898# u_t026_013/m2_2000_1265#
+ u_t026_013/m2_512_2037# u_t026_013/m2_1795_1265# u_t026_013/m2_1714_1982# u_t026_013/m2_1886_1259#
+ u_t026_013/m2_1290_2126# u_t026_013/m2_1714_438# u_t026_013/m2_431_1210# u_t026_013/m2_2573_2898#
+ u_t026_013/m2_2154_303# u_t026_013/m2_871_2081# VSUBS detronyx_12t_2w2r_rc4_4x4_routed_5layer_direct
Xu_t026_002 u_t026_002/c0_w0_bl u_t026_002/c0_w0_br u_t026_002/c0_w1_bl u_t026_002/c0_w1_br
+ u_t026_002/c0_r0_rbl u_t026_002/c0_r1_rbl u_t026_002/c1_w0_bl u_t026_002/c1_w0_br
+ u_t026_002/c1_w1_bl u_t026_002/c1_w1_br u_t026_002/c1_r0_rbl u_t026_002/c1_r1_rbl
+ u_t026_002/c2_w0_bl u_t026_002/c2_w0_br u_t026_002/c2_w1_bl u_t026_002/c2_w1_br
+ u_t026_002/c2_r0_rbl u_t026_002/c2_r1_rbl u_t026_002/c3_w0_bl u_t026_002/c3_w0_br
+ u_t026_002/c3_w1_bl u_t026_002/c3_w1_br u_t026_002/c3_r0_rbl u_t026_002/c3_r1_rbl
+ u_t026_002/r0_w0_wl u_t026_002/r0_w1_wl u_t026_002/r0_r0_rwl u_t026_002/r0_r1_rwl
+ u_t026_002/r1_w0_wl u_t026_002/r1_w1_wl u_t026_002/r1_r0_rwl u_t026_002/r1_r1_rwl
+ u_t026_002/r2_w0_wl u_t026_002/r2_w1_wl u_t026_002/r2_r0_rwl u_t026_002/r2_r1_rwl
+ u_t026_002/r3_w0_wl u_t026_002/r3_w1_wl u_t026_002/r3_r0_rwl u_t026_002/r3_r1_rwl
+ VSS VSS u_t026_002/m2_717_1265# u_t026_002/m2_603_2031# u_t026_002/m2_1290_336#
+ u_t026_002/m2_2000_2037# u_t026_002/m2_791_2909# u_t026_002/m2_7_2126# u_t026_002/m2_2154_2081#
+ u_t026_002/m2_1795_2037# u_t026_002/m2_871_303# u_t026_002/m2_431_438# u_t026_002/m2_1290_2898#
+ u_t026_002/m2_1714_1210# u_t026_002/m2_431_1982# u_t026_002/m2_512_1265# u_t026_002/m2_2573_2126#
+ u_t026_002/m2_603_1259# u_t026_002/m2_2074_2909# u_t026_002/m2_7_336# u_t026_002/m2_717_2037#
+ u_t026_002/m2_1886_2031# u_t026_002/m2_2573_336# u_t026_002/m2_7_2898# u_t026_002/m2_2000_1265#
+ u_t026_002/m2_512_2037# u_t026_002/m2_1795_1265# u_t026_002/m2_1714_1982# u_t026_002/m2_1886_1259#
+ u_t026_002/m2_1290_2126# u_t026_002/m2_1714_438# u_t026_002/m2_431_1210# u_t026_002/m2_2573_2898#
+ u_t026_002/m2_2154_303# u_t026_002/m2_871_2081# VSUBS detronyx_12t_2w2r_rc4_4x4_routed_5layer_direct
Xgf180mcu_as_sc_mcu7t3v3__nand4_2_91 gf180mcu_as_sc_mcu7t3v3__inv_2_46/VDD gf180mcu_as_sc_mcu7t3v3__inv_2_62/VDD
+ VSS VSS VSS VSS VSS gf180mcu_as_sc_mcu7t3v3__inv_2_46/VNW VSUBS gf180mcu_as_sc_mcu7t3v3__nand4_2
Xgf180mcu_as_sc_mcu7t3v3__nand4_2_80 gf180mcu_as_sc_mcu7t3v3__inv_2_53/VDD gf180mcu_as_sc_mcu7t3v3__inv_2_57/VDD
+ VSS VSS VSS VSS VSS gf180mcu_as_sc_mcu7t3v3__inv_2_53/VNW VSUBS gf180mcu_as_sc_mcu7t3v3__nand4_2
Xu_t017_013 u_t017_013/c0_w0_bl u_t017_013/c0_w0_br u_t017_013/c0_w1_bl u_t017_013/c0_w1_br
+ u_t017_013/c0_r0_rbl u_t017_013/c0_r1_rbl u_t017_013/c1_w0_bl u_t017_013/c1_w0_br
+ u_t017_013/c1_w1_bl u_t017_013/c1_w1_br u_t017_013/c1_r0_rbl u_t017_013/c1_r1_rbl
+ u_t017_013/c2_w0_bl u_t017_013/c2_w0_br u_t017_013/c2_w1_bl u_t017_013/c2_w1_br
+ u_t017_013/c2_r0_rbl u_t017_013/c2_r1_rbl u_t017_013/c3_w0_bl u_t017_013/c3_w0_br
+ u_t017_013/c3_w1_bl u_t017_013/c3_w1_br u_t017_013/c3_r0_rbl u_t017_013/c3_r1_rbl
+ u_t017_013/r0_w0_wl u_t017_013/r0_w1_wl u_t017_013/r0_r0_rwl u_t017_013/r0_r1_rwl
+ u_t017_013/r1_w0_wl u_t017_013/r1_w1_wl u_t017_013/r1_r0_rwl u_t017_013/r1_r1_rwl
+ u_t017_013/r2_w0_wl u_t017_013/r2_w1_wl u_t017_013/r2_r0_rwl u_t017_013/r2_r1_rwl
+ u_t017_013/r3_w0_wl u_t017_013/r3_w1_wl u_t017_013/r3_r0_rwl u_t017_013/r3_r1_rwl
+ u_t017_013/VDD VSS u_t017_013/m2_717_1265# u_t017_013/m2_603_2031# u_t017_013/m2_1290_336#
+ u_t017_013/m2_2000_2037# u_t017_013/m2_791_2909# u_t017_013/m2_7_2126# u_t017_013/m2_2154_2081#
+ u_t017_013/m2_1795_2037# u_t017_013/m2_871_303# u_t017_013/m2_431_438# u_t017_013/m2_1290_2898#
+ u_t017_013/m2_1714_1210# u_t017_013/m2_431_1982# u_t017_013/m2_512_1265# u_t017_013/m2_2573_2126#
+ u_t017_013/m2_603_1259# u_t017_013/m2_2074_2909# u_t017_013/m2_7_336# u_t017_013/m2_717_2037#
+ u_t017_013/m2_1886_2031# u_t017_013/m2_2573_336# u_t017_013/m2_7_2898# u_t017_013/m2_2000_1265#
+ u_t017_013/m2_512_2037# u_t017_013/m2_1795_1265# u_t017_013/m2_1714_1982# u_t017_013/m2_1886_1259#
+ u_t017_013/m2_1290_2126# u_t017_013/m2_1714_438# u_t017_013/m2_431_1210# u_t017_013/m2_2573_2898#
+ u_t017_013/m2_2154_303# u_t017_013/m2_871_2081# VSUBS detronyx_12t_2w2r_rc4_4x4_routed_5layer_direct
Xu_t017_002 u_t017_002/c0_w0_bl u_t017_002/c0_w0_br u_t017_002/c0_w1_bl u_t017_002/c0_w1_br
+ u_t017_002/c0_r0_rbl u_t017_002/c0_r1_rbl u_t017_002/c1_w0_bl u_t017_002/c1_w0_br
+ u_t017_002/c1_w1_bl u_t017_002/c1_w1_br u_t017_002/c1_r0_rbl u_t017_002/c1_r1_rbl
+ u_t017_002/c2_w0_bl u_t017_002/c2_w0_br u_t017_002/c2_w1_bl u_t017_002/c2_w1_br
+ u_t017_002/c2_r0_rbl u_t017_002/c2_r1_rbl u_t017_002/c3_w0_bl u_t017_002/c3_w0_br
+ u_t017_002/c3_w1_bl u_t017_002/c3_w1_br u_t017_002/c3_r0_rbl u_t017_002/c3_r1_rbl
+ u_t017_002/r0_w0_wl u_t017_002/r0_w1_wl u_t017_002/r0_r0_rwl u_t017_002/r0_r1_rwl
+ u_t017_002/r1_w0_wl u_t017_002/r1_w1_wl u_t017_002/r1_r0_rwl u_t017_002/r1_r1_rwl
+ u_t017_002/r2_w0_wl u_t017_002/r2_w1_wl u_t017_002/r2_r0_rwl u_t017_002/r2_r1_rwl
+ u_t017_002/r3_w0_wl u_t017_002/r3_w1_wl u_t017_002/r3_r0_rwl u_t017_002/r3_r1_rwl
+ VSS VSS u_t017_002/m2_717_1265# u_t017_002/m2_603_2031# u_t017_002/m2_1290_336#
+ u_t017_002/m2_2000_2037# u_t017_002/m2_791_2909# u_t017_002/m2_7_2126# u_t017_002/m2_2154_2081#
+ u_t017_002/m2_1795_2037# u_t017_002/m2_871_303# u_t017_002/m2_431_438# u_t017_002/m2_1290_2898#
+ u_t017_002/m2_1714_1210# u_t017_002/m2_431_1982# u_t017_002/m2_512_1265# u_t017_002/m2_2573_2126#
+ u_t017_002/m2_603_1259# u_t017_002/m2_2074_2909# u_t017_002/m2_7_336# u_t017_002/m2_717_2037#
+ u_t017_002/m2_1886_2031# u_t017_002/m2_2573_336# u_t017_002/m2_7_2898# u_t017_002/m2_2000_1265#
+ u_t017_002/m2_512_2037# u_t017_002/m2_1795_1265# u_t017_002/m2_1714_1982# u_t017_002/m2_1886_1259#
+ u_t017_002/m2_1290_2126# u_t017_002/m2_1714_438# u_t017_002/m2_431_1210# u_t017_002/m2_2573_2898#
+ u_t017_002/m2_2154_303# u_t017_002/m2_871_2081# VSUBS detronyx_12t_2w2r_rc4_4x4_routed_5layer_direct
Xgf180mcu_as_sc_mcu7t3v3__inv_2_105 gf180mcu_as_sc_mcu7t3v3__nand4_2_9/VDD VSS gf180mcu_as_sc_mcu7t3v3__inv_2_105/Y
+ VSS gf180mcu_as_sc_mcu7t3v3__nand4_2_9/VNW VSUBS gf180mcu_as_sc_mcu7t3v3__inv_2
Xgf180mcu_as_sc_mcu7t3v3__inv_2_116 gf180mcu_as_sc_mcu7t3v3__inv_2_116/VDD gf180mcu_as_sc_mcu7t3v3__inv_2_122/VDD
+ gf180mcu_as_sc_mcu7t3v3__inv_2_116/Y VSS gf180mcu_as_sc_mcu7t3v3__inv_2_116/VNW
+ VSUBS gf180mcu_as_sc_mcu7t3v3__inv_2
Xgf180mcu_as_sc_mcu7t3v3__inv_2_149 VSS gf180mcu_as_sc_mcu7t3v3__inv_2_152/VDD VSS
+ VSS gf180mcu_as_sc_mcu7t3v3__inv_2_149/VNW VSUBS gf180mcu_as_sc_mcu7t3v3__inv_2
Xgf180mcu_as_sc_mcu7t3v3__inv_2_138 VSS gf180mcu_as_sc_mcu7t3v3__inv_2_143/VDD gf180mcu_as_sc_mcu7t3v3__inv_2_138/Y
+ VSS gf180mcu_as_sc_mcu7t3v3__inv_2_140/VNW VSUBS gf180mcu_as_sc_mcu7t3v3__inv_2
Xgf180mcu_as_sc_mcu7t3v3__inv_2_127 gf180mcu_as_sc_mcu7t3v3__inv_2_131/VDD gf180mcu_as_sc_mcu7t3v3__inv_2_131/VDD
+ VSS VSS gf180mcu_as_sc_mcu7t3v3__inv_2_128/VNW VSUBS gf180mcu_as_sc_mcu7t3v3__inv_2
Xu_t008_013 u_t008_013/c0_w0_bl u_t008_013/c0_w0_br u_t008_013/c0_w1_bl u_t008_013/c0_w1_br
+ u_t008_013/c0_r0_rbl u_t008_013/c0_r1_rbl u_t008_013/c1_w0_bl u_t008_013/c1_w0_br
+ u_t008_013/c1_w1_bl u_t008_013/c1_w1_br u_t008_013/c1_r0_rbl u_t008_013/c1_r1_rbl
+ u_t008_013/c2_w0_bl u_t008_013/c2_w0_br u_t008_013/c2_w1_bl u_t008_013/c2_w1_br
+ u_t008_013/c2_r0_rbl u_t008_013/c2_r1_rbl u_t008_013/c3_w0_bl u_t008_013/c3_w0_br
+ u_t008_013/c3_w1_bl u_t008_013/c3_w1_br u_t008_013/c3_r0_rbl u_t008_013/c3_r1_rbl
+ u_t008_013/r0_w0_wl u_t008_013/r0_w1_wl u_t008_013/r0_r0_rwl u_t008_013/r0_r1_rwl
+ u_t008_013/r1_w0_wl u_t008_013/r1_w1_wl u_t008_013/r1_r0_rwl u_t008_013/r1_r1_rwl
+ u_t008_013/r2_w0_wl u_t008_013/r2_w1_wl u_t008_013/r2_r0_rwl u_t008_013/r2_r1_rwl
+ u_t008_013/r3_w0_wl u_t008_013/r3_w1_wl u_t008_013/r3_r0_rwl u_t008_013/r3_r1_rwl
+ u_t008_013/VDD VSS u_t008_013/m2_717_1265# u_t008_013/m2_603_2031# u_t008_013/m2_1290_336#
+ u_t008_013/m2_2000_2037# u_t008_013/m2_791_2909# u_t008_013/m2_7_2126# u_t008_013/m2_2154_2081#
+ u_t008_013/m2_1795_2037# u_t008_013/m2_871_303# u_t008_013/m2_431_438# u_t008_013/m2_1290_2898#
+ u_t008_013/m2_1714_1210# u_t008_013/m2_431_1982# u_t008_013/m2_512_1265# u_t008_013/m2_2573_2126#
+ u_t008_013/m2_603_1259# u_t008_013/m2_2074_2909# u_t008_013/m2_7_336# u_t008_013/m2_717_2037#
+ u_t008_013/m2_1886_2031# u_t008_013/m2_2573_336# u_t008_013/m2_7_2898# u_t008_013/m2_2000_1265#
+ u_t008_013/m2_512_2037# u_t008_013/m2_1795_1265# u_t008_013/m2_1714_1982# u_t008_013/m2_1886_1259#
+ u_t008_013/m2_1290_2126# u_t008_013/m2_1714_438# u_t008_013/m2_431_1210# u_t008_013/m2_2573_2898#
+ u_t008_013/m2_2154_303# u_t008_013/m2_871_2081# VSUBS detronyx_12t_2w2r_rc4_4x4_routed_5layer_direct
Xu_t023_005 u_t023_005/c0_w0_bl u_t023_005/c0_w0_br u_t023_005/c0_w1_bl u_t023_005/c0_w1_br
+ u_t023_005/c0_r0_rbl u_t023_005/c0_r1_rbl u_t023_005/c1_w0_bl u_t023_005/c1_w0_br
+ u_t023_005/c1_w1_bl u_t023_005/c1_w1_br u_t023_005/c1_r0_rbl u_t023_005/c1_r1_rbl
+ u_t023_005/c2_w0_bl u_t023_005/c2_w0_br u_t023_005/c2_w1_bl u_t023_005/c2_w1_br
+ u_t023_005/c2_r0_rbl u_t023_005/c2_r1_rbl u_t023_005/c3_w0_bl u_t023_005/c3_w0_br
+ u_t023_005/c3_w1_bl u_t023_005/c3_w1_br u_t023_005/c3_r0_rbl u_t023_005/c3_r1_rbl
+ u_t023_005/r0_w0_wl u_t023_005/r0_w1_wl u_t023_005/r0_r0_rwl u_t023_005/r0_r1_rwl
+ u_t023_005/r1_w0_wl u_t023_005/r1_w1_wl u_t023_005/r1_r0_rwl u_t023_005/r1_r1_rwl
+ u_t023_005/r2_w0_wl u_t023_005/r2_w1_wl u_t023_005/r2_r0_rwl u_t023_005/r2_r1_rwl
+ u_t023_005/r3_w0_wl u_t023_005/r3_w1_wl u_t023_005/r3_r0_rwl u_t023_005/r3_r1_rwl
+ u_t023_005/VDD u_t023_005/VSS u_t023_005/m2_717_1265# u_t023_005/m2_603_2031# u_t023_005/m2_1290_336#
+ u_t023_005/m2_2000_2037# u_t023_005/m2_791_2909# u_t023_005/m2_7_2126# u_t023_005/m2_2154_2081#
+ u_t023_005/m2_1795_2037# u_t023_005/m2_871_303# u_t023_005/m2_431_438# u_t023_005/m2_1290_2898#
+ u_t023_005/m2_1714_1210# u_t023_005/m2_431_1982# u_t023_005/m2_512_1265# u_t023_005/m2_2573_2126#
+ u_t023_005/m2_603_1259# u_t023_005/m2_2074_2909# u_t023_005/m2_7_336# u_t023_005/m2_717_2037#
+ u_t023_005/m2_1886_2031# u_t023_005/m2_2573_336# u_t023_005/m2_7_2898# u_t023_005/m2_2000_1265#
+ u_t023_005/m2_512_2037# u_t023_005/m2_1795_1265# u_t023_005/m2_1714_1982# u_t023_005/m2_1886_1259#
+ u_t023_005/m2_1290_2126# u_t023_005/m2_1714_438# u_t023_005/m2_431_1210# u_t023_005/m2_2573_2898#
+ u_t023_005/m2_2154_303# u_t023_005/m2_871_2081# VSUBS detronyx_12t_2w2r_rc4_4x4_routed_5layer_direct
Xu_t008_002 u_t008_002/c0_w0_bl u_t008_002/c0_w0_br u_t008_002/c0_w1_bl u_t008_002/c0_w1_br
+ u_t008_002/c0_r0_rbl u_t008_002/c0_r1_rbl u_t008_002/c1_w0_bl u_t008_002/c1_w0_br
+ u_t008_002/c1_w1_bl u_t008_002/c1_w1_br u_t008_002/c1_r0_rbl u_t008_002/c1_r1_rbl
+ u_t008_002/c2_w0_bl u_t008_002/c2_w0_br u_t008_002/c2_w1_bl u_t008_002/c2_w1_br
+ u_t008_002/c2_r0_rbl u_t008_002/c2_r1_rbl u_t008_002/c3_w0_bl u_t008_002/c3_w0_br
+ u_t008_002/c3_w1_bl u_t008_002/c3_w1_br u_t008_002/c3_r0_rbl u_t008_002/c3_r1_rbl
+ u_t008_002/r0_w0_wl u_t008_002/r0_w1_wl u_t008_002/r0_r0_rwl u_t008_002/r0_r1_rwl
+ u_t008_002/r1_w0_wl u_t008_002/r1_w1_wl u_t008_002/r1_r0_rwl u_t008_002/r1_r1_rwl
+ u_t008_002/r2_w0_wl u_t008_002/r2_w1_wl u_t008_002/r2_r0_rwl u_t008_002/r2_r1_rwl
+ u_t008_002/r3_w0_wl u_t008_002/r3_w1_wl u_t008_002/r3_r0_rwl u_t008_002/r3_r1_rwl
+ VSS VSS u_t008_002/m2_717_1265# u_t008_002/m2_603_2031# u_t008_002/m2_1290_336#
+ u_t008_002/m2_2000_2037# u_t008_002/m2_791_2909# u_t008_002/m2_7_2126# u_t008_002/m2_2154_2081#
+ u_t008_002/m2_1795_2037# u_t008_002/m2_871_303# u_t008_002/m2_431_438# u_t008_002/m2_1290_2898#
+ u_t008_002/m2_1714_1210# u_t008_002/m2_431_1982# u_t008_002/m2_512_1265# u_t008_002/m2_2573_2126#
+ u_t008_002/m2_603_1259# u_t008_002/m2_2074_2909# u_t008_002/m2_7_336# u_t008_002/m2_717_2037#
+ u_t008_002/m2_1886_2031# u_t008_002/m2_2573_336# u_t008_002/m2_7_2898# u_t008_002/m2_2000_1265#
+ u_t008_002/m2_512_2037# u_t008_002/m2_1795_1265# u_t008_002/m2_1714_1982# u_t008_002/m2_1886_1259#
+ u_t008_002/m2_1290_2126# u_t008_002/m2_1714_438# u_t008_002/m2_431_1210# u_t008_002/m2_2573_2898#
+ u_t008_002/m2_2154_303# u_t008_002/m2_871_2081# VSUBS detronyx_12t_2w2r_rc4_4x4_routed_5layer_direct
Xgf180mcu_as_sc_mcu7t3v3__inv_2_650 VSS VSS gf180mcu_as_sc_mcu7t3v3__inv_2_650/Y VSS
+ gf180mcu_as_sc_mcu7t3v3__inv_2_650/VNW VSUBS gf180mcu_as_sc_mcu7t3v3__inv_2
Xgf180mcu_as_sc_mcu7t3v3__inv_2_661 gf180mcu_as_sc_mcu7t3v3__inv_2_689/VSS VSS gf180mcu_as_sc_mcu7t3v3__inv_2_661/Y
+ VSS gf180mcu_as_sc_mcu7t3v3__inv_2_661/VNW VSUBS gf180mcu_as_sc_mcu7t3v3__inv_2
Xgf180mcu_as_sc_mcu7t3v3__inv_2_672 gf180mcu_as_sc_mcu7t3v3__inv_2_674/VDD gf180mcu_as_sc_mcu7t3v3__inv_2_678/VDD
+ gf180mcu_as_sc_mcu7t3v3__inv_2_672/Y gf180mcu_as_sc_mcu7t3v3__inv_2_744/A gf180mcu_as_sc_mcu7t3v3__inv_2_674/VNW
+ VSUBS gf180mcu_as_sc_mcu7t3v3__inv_2
Xgf180mcu_as_sc_mcu7t3v3__inv_2_683 VSS gf180mcu_as_sc_mcu7t3v3__inv_2_688/VDD gf180mcu_as_sc_mcu7t3v3__inv_2_683/Y
+ gf180mcu_as_sc_mcu7t3v3__inv_2_684/Y gf180mcu_as_sc_mcu7t3v3__inv_2_684/VNW VSUBS
+ gf180mcu_as_sc_mcu7t3v3__inv_2
Xgf180mcu_as_sc_mcu7t3v3__inv_2_694 gf180mcu_as_sc_mcu7t3v3__inv_2_741/VDD VSS gf180mcu_as_sc_mcu7t3v3__inv_2_742/A
+ gf180mcu_as_sc_mcu7t3v3__inv_2_705/Y gf180mcu_as_sc_mcu7t3v3__inv_2_741/VNW VSUBS
+ gf180mcu_as_sc_mcu7t3v3__inv_2
Xgf180mcu_as_sc_mcu7t3v3__nand2_2_17 gf180mcu_as_sc_mcu7t3v3__nor2_2_7/VDD gf180mcu_as_sc_mcu7t3v3__nor2_2_7/VSS
+ VSS VSS VSS gf180mcu_as_sc_mcu7t3v3__nor2_2_7/VNW VSUBS gf180mcu_as_sc_mcu7t3v3__nand2_2
Xgf180mcu_as_sc_mcu7t3v3__nand2_2_28 gf180mcu_as_sc_mcu7t3v3__nor2_2_7/VDD gf180mcu_as_sc_mcu7t3v3__nor2_2_7/VSS
+ VSS VSS VSS gf180mcu_as_sc_mcu7t3v3__nor2_2_7/VNW VSUBS gf180mcu_as_sc_mcu7t3v3__nand2_2
Xu_t014_005 u_t014_005/c0_w0_bl u_t014_005/c0_w0_br u_t014_005/c0_w1_bl u_t014_005/c0_w1_br
+ u_t014_005/c0_r0_rbl u_t014_005/c0_r1_rbl u_t014_005/c1_w0_bl u_t014_005/c1_w0_br
+ u_t014_005/c1_w1_bl u_t014_005/c1_w1_br u_t014_005/c1_r0_rbl u_t014_005/c1_r1_rbl
+ u_t014_005/c2_w0_bl u_t014_005/c2_w0_br u_t014_005/c2_w1_bl u_t014_005/c2_w1_br
+ u_t014_005/c2_r0_rbl u_t014_005/c2_r1_rbl u_t014_005/c3_w0_bl u_t014_005/c3_w0_br
+ u_t014_005/c3_w1_bl u_t014_005/c3_w1_br u_t014_005/c3_r0_rbl u_t014_005/c3_r1_rbl
+ u_t014_005/r0_w0_wl u_t014_005/r0_w1_wl u_t014_005/r0_r0_rwl u_t014_005/r0_r1_rwl
+ u_t014_005/r1_w0_wl u_t014_005/r1_w1_wl u_t014_005/r1_r0_rwl u_t014_005/r1_r1_rwl
+ u_t014_005/r2_w0_wl u_t014_005/r2_w1_wl u_t014_005/r2_r0_rwl u_t014_005/r2_r1_rwl
+ u_t014_005/r3_w0_wl u_t014_005/r3_w1_wl u_t014_005/r3_r0_rwl u_t014_005/r3_r1_rwl
+ u_t014_005/VDD u_t014_005/VSS u_t014_005/m2_717_1265# u_t014_005/m2_603_2031# u_t014_005/m2_1290_336#
+ u_t014_005/m2_2000_2037# u_t014_005/m2_791_2909# u_t014_005/m2_7_2126# u_t014_005/m2_2154_2081#
+ u_t014_005/m2_1795_2037# u_t014_005/m2_871_303# u_t014_005/m2_431_438# u_t014_005/m2_1290_2898#
+ u_t014_005/m2_1714_1210# u_t014_005/m2_431_1982# u_t014_005/m2_512_1265# u_t014_005/m2_2573_2126#
+ u_t014_005/m2_603_1259# u_t014_005/m2_2074_2909# u_t014_005/m2_7_336# u_t014_005/m2_717_2037#
+ u_t014_005/m2_1886_2031# u_t014_005/m2_2573_336# u_t014_005/m2_7_2898# u_t014_005/m2_2000_1265#
+ u_t014_005/m2_512_2037# u_t014_005/m2_1795_1265# u_t014_005/m2_1714_1982# u_t014_005/m2_1886_1259#
+ u_t014_005/m2_1290_2126# u_t014_005/m2_1714_438# u_t014_005/m2_431_1210# u_t014_005/m2_2573_2898#
+ u_t014_005/m2_2154_303# u_t014_005/m2_871_2081# VSUBS detronyx_12t_2w2r_rc4_4x4_routed_5layer_direct
Xgf180mcu_as_sc_mcu7t3v3__nand2_2_39 gf180mcu_as_sc_mcu7t3v3__nor2_2_9/VDD gf180mcu_as_sc_mcu7t3v3__nor2_2_9/VSS
+ VSS VSS VSS gf180mcu_as_sc_mcu7t3v3__nor2_2_9/VNW VSUBS gf180mcu_as_sc_mcu7t3v3__nand2_2
Xu_t005_005 u_t005_005/c0_w0_bl u_t005_005/c0_w0_br u_t005_005/c0_w1_bl u_t005_005/c0_w1_br
+ u_t005_005/c0_r0_rbl u_t005_005/c0_r1_rbl u_t005_005/c1_w0_bl u_t005_005/c1_w0_br
+ u_t005_005/c1_w1_bl u_t005_005/c1_w1_br u_t005_005/c1_r0_rbl u_t005_005/c1_r1_rbl
+ u_t005_005/c2_w0_bl u_t005_005/c2_w0_br u_t005_005/c2_w1_bl u_t005_005/c2_w1_br
+ u_t005_005/c2_r0_rbl u_t005_005/c2_r1_rbl u_t005_005/c3_w0_bl u_t005_005/c3_w0_br
+ u_t005_005/c3_w1_bl u_t005_005/c3_w1_br u_t005_005/c3_r0_rbl u_t005_005/c3_r1_rbl
+ u_t005_005/r0_w0_wl u_t005_005/r0_w1_wl u_t005_005/r0_r0_rwl u_t005_005/r0_r1_rwl
+ u_t005_005/r1_w0_wl u_t005_005/r1_w1_wl u_t005_005/r1_r0_rwl u_t005_005/r1_r1_rwl
+ u_t005_005/r2_w0_wl u_t005_005/r2_w1_wl u_t005_005/r2_r0_rwl u_t005_005/r2_r1_rwl
+ u_t005_005/r3_w0_wl u_t005_005/r3_w1_wl u_t005_005/r3_r0_rwl u_t005_005/r3_r1_rwl
+ u_t005_005/VDD VSS u_t005_005/m2_717_1265# u_t005_005/m2_603_2031# u_t005_005/m2_1290_336#
+ u_t005_005/m2_2000_2037# u_t005_005/m2_791_2909# u_t005_005/m2_7_2126# u_t005_005/m2_2154_2081#
+ u_t005_005/m2_1795_2037# u_t005_005/m2_871_303# u_t005_005/m2_431_438# u_t005_005/m2_1290_2898#
+ u_t005_005/m2_1714_1210# u_t005_005/m2_431_1982# u_t005_005/m2_512_1265# u_t005_005/m2_2573_2126#
+ u_t005_005/m2_603_1259# u_t005_005/m2_2074_2909# u_t005_005/m2_7_336# u_t005_005/m2_717_2037#
+ u_t005_005/m2_1886_2031# u_t005_005/m2_2573_336# u_t005_005/m2_7_2898# u_t005_005/m2_2000_1265#
+ u_t005_005/m2_512_2037# u_t005_005/m2_1795_1265# u_t005_005/m2_1714_1982# u_t005_005/m2_1886_1259#
+ u_t005_005/m2_1290_2126# u_t005_005/m2_1714_438# u_t005_005/m2_431_1210# u_t005_005/m2_2573_2898#
+ u_t005_005/m2_2154_303# u_t005_005/m2_871_2081# VSUBS detronyx_12t_2w2r_rc4_4x4_routed_5layer_direct
Xu_t020_008 u_t020_008/c0_w0_bl u_t020_008/c0_w0_br u_t020_008/c0_w1_bl u_t020_008/c0_w1_br
+ u_t020_008/c0_r0_rbl u_t020_008/c0_r1_rbl u_t020_008/c1_w0_bl u_t020_008/c1_w0_br
+ u_t020_008/c1_w1_bl u_t020_008/c1_w1_br u_t020_008/c1_r0_rbl u_t020_008/c1_r1_rbl
+ u_t020_008/c2_w0_bl u_t020_008/c2_w0_br u_t020_008/c2_w1_bl u_t020_008/c2_w1_br
+ u_t020_008/c2_r0_rbl u_t020_008/c2_r1_rbl u_t020_008/c3_w0_bl u_t020_008/c3_w0_br
+ u_t020_008/c3_w1_bl u_t020_008/c3_w1_br u_t020_008/c3_r0_rbl u_t020_008/c3_r1_rbl
+ u_t020_008/r0_w0_wl u_t020_008/r0_w1_wl u_t020_008/r0_r0_rwl u_t020_008/r0_r1_rwl
+ u_t020_008/r1_w0_wl u_t020_008/r1_w1_wl u_t020_008/r1_r0_rwl u_t020_008/r1_r1_rwl
+ u_t020_008/r2_w0_wl u_t020_008/r2_w1_wl u_t020_008/r2_r0_rwl u_t020_008/r2_r1_rwl
+ u_t020_008/r3_w0_wl u_t020_008/r3_w1_wl u_t020_008/r3_r0_rwl u_t020_008/r3_r1_rwl
+ VSS u_t020_009/VSS u_t020_008/m2_717_1265# u_t020_008/m2_603_2031# u_t020_008/m2_1290_336#
+ u_t020_008/m2_2000_2037# u_t020_008/m2_791_2909# u_t020_008/m2_7_2126# u_t020_008/m2_2154_2081#
+ u_t020_008/m2_1795_2037# u_t020_008/m2_871_303# u_t020_008/m2_431_438# u_t020_008/m2_1290_2898#
+ u_t020_008/m2_1714_1210# u_t020_008/m2_431_1982# u_t020_008/m2_512_1265# u_t020_008/m2_2573_2126#
+ u_t020_008/m2_603_1259# u_t020_008/m2_2074_2909# u_t020_008/m2_7_336# u_t020_008/m2_717_2037#
+ u_t020_008/m2_1886_2031# u_t020_008/m2_2573_336# u_t020_008/m2_7_2898# u_t020_008/m2_2000_1265#
+ u_t020_008/m2_512_2037# u_t020_008/m2_1795_1265# u_t020_008/m2_1714_1982# u_t020_008/m2_1886_1259#
+ u_t020_008/m2_1290_2126# u_t020_008/m2_1714_438# u_t020_008/m2_431_1210# u_t020_008/m2_2573_2898#
+ u_t020_008/m2_2154_303# u_t020_008/m2_871_2081# VSUBS detronyx_12t_2w2r_rc4_4x4_routed_5layer_direct
Xu_t011_008 u_t011_008/c0_w0_bl u_t011_008/c0_w0_br u_t011_008/c0_w1_bl u_t011_008/c0_w1_br
+ u_t011_008/c0_r0_rbl u_t011_008/c0_r1_rbl u_t011_008/c1_w0_bl u_t011_008/c1_w0_br
+ u_t011_008/c1_w1_bl u_t011_008/c1_w1_br u_t011_008/c1_r0_rbl u_t011_008/c1_r1_rbl
+ u_t011_008/c2_w0_bl u_t011_008/c2_w0_br u_t011_008/c2_w1_bl u_t011_008/c2_w1_br
+ u_t011_008/c2_r0_rbl u_t011_008/c2_r1_rbl u_t011_008/c3_w0_bl u_t011_008/c3_w0_br
+ u_t011_008/c3_w1_bl u_t011_008/c3_w1_br u_t011_008/c3_r0_rbl u_t011_008/c3_r1_rbl
+ u_t011_008/r0_w0_wl u_t011_008/r0_w1_wl u_t011_008/r0_r0_rwl u_t011_008/r0_r1_rwl
+ u_t011_008/r1_w0_wl u_t011_008/r1_w1_wl u_t011_008/r1_r0_rwl u_t011_008/r1_r1_rwl
+ u_t011_008/r2_w0_wl u_t011_008/r2_w1_wl u_t011_008/r2_r0_rwl u_t011_008/r2_r1_rwl
+ u_t011_008/r3_w0_wl u_t011_008/r3_w1_wl u_t011_008/r3_r0_rwl u_t011_008/r3_r1_rwl
+ VSS u_t011_009/VSS u_t011_008/m2_717_1265# u_t011_008/m2_603_2031# u_t011_008/m2_1290_336#
+ u_t011_008/m2_2000_2037# u_t011_008/m2_791_2909# u_t011_008/m2_7_2126# u_t011_008/m2_2154_2081#
+ u_t011_008/m2_1795_2037# u_t011_008/m2_871_303# u_t011_008/m2_431_438# u_t011_008/m2_1290_2898#
+ u_t011_008/m2_1714_1210# u_t011_008/m2_431_1982# u_t011_008/m2_512_1265# u_t011_008/m2_2573_2126#
+ u_t011_008/m2_603_1259# u_t011_008/m2_2074_2909# u_t011_008/m2_7_336# u_t011_008/m2_717_2037#
+ u_t011_008/m2_1886_2031# u_t011_008/m2_2573_336# u_t011_008/m2_7_2898# u_t011_008/m2_2000_1265#
+ u_t011_008/m2_512_2037# u_t011_008/m2_1795_1265# u_t011_008/m2_1714_1982# u_t011_008/m2_1886_1259#
+ u_t011_008/m2_1290_2126# u_t011_008/m2_1714_438# u_t011_008/m2_431_1210# u_t011_008/m2_2573_2898#
+ u_t011_008/m2_2154_303# u_t011_008/m2_871_2081# VSUBS detronyx_12t_2w2r_rc4_4x4_routed_5layer_direct
Xgf180mcu_as_sc_mcu7t3v3__inv_2_480 gf180mcu_as_sc_mcu7t3v3__nor2_2_6/VDD gf180mcu_as_sc_mcu7t3v3__nand3_2_4/VSS
+ gf180mcu_as_sc_mcu7t3v3__inv_2_480/Y VSS gf180mcu_as_sc_mcu7t3v3__nor2_2_6/VNW VSUBS
+ gf180mcu_as_sc_mcu7t3v3__inv_2
Xgf180mcu_as_sc_mcu7t3v3__inv_2_491 VSS VSS VSS VSS gf180mcu_as_sc_mcu7t3v3__inv_2_553/VNW
+ VSUBS gf180mcu_as_sc_mcu7t3v3__inv_2
Xu_t002_008 u_t002_008/c0_w0_bl u_t002_008/c0_w0_br u_t002_008/c0_w1_bl u_t002_008/c0_w1_br
+ u_t002_008/c0_r0_rbl u_t002_008/c0_r1_rbl u_t002_008/c1_w0_bl u_t002_008/c1_w0_br
+ u_t002_008/c1_w1_bl u_t002_008/c1_w1_br u_t002_008/c1_r0_rbl u_t002_008/c1_r1_rbl
+ u_t002_008/c2_w0_bl u_t002_008/c2_w0_br u_t002_008/c2_w1_bl u_t002_008/c2_w1_br
+ u_t002_008/c2_r0_rbl u_t002_008/c2_r1_rbl u_t002_008/c3_w0_bl u_t002_008/c3_w0_br
+ u_t002_008/c3_w1_bl u_t002_008/c3_w1_br u_t002_008/c3_r0_rbl u_t002_008/c3_r1_rbl
+ u_t002_008/r0_w0_wl u_t002_008/r0_w1_wl u_t002_008/r0_r0_rwl u_t002_008/r0_r1_rwl
+ u_t002_008/r1_w0_wl u_t002_008/r1_w1_wl u_t002_008/r1_r0_rwl u_t002_008/r1_r1_rwl
+ u_t002_008/r2_w0_wl u_t002_008/r2_w1_wl u_t002_008/r2_r0_rwl u_t002_008/r2_r1_rwl
+ u_t002_008/r3_w0_wl u_t002_008/r3_w1_wl u_t002_008/r3_r0_rwl u_t002_008/r3_r1_rwl
+ VSS u_t002_009/VSS u_t002_008/m2_717_1265# u_t002_008/m2_603_2031# u_t002_008/m2_1290_336#
+ u_t002_008/m2_2000_2037# u_t002_008/m2_791_2909# u_t002_008/m2_7_2126# u_t002_008/m2_2154_2081#
+ u_t002_008/m2_1795_2037# u_t002_008/m2_871_303# u_t002_008/m2_431_438# u_t002_008/m2_1290_2898#
+ u_t002_008/m2_1714_1210# u_t002_008/m2_431_1982# u_t002_008/m2_512_1265# u_t002_008/m2_2573_2126#
+ u_t002_008/m2_603_1259# u_t002_008/m2_2074_2909# u_t002_008/m2_7_336# u_t002_008/m2_717_2037#
+ u_t002_008/m2_1886_2031# u_t002_008/m2_2573_336# u_t002_008/m2_7_2898# u_t002_008/m2_2000_1265#
+ u_t002_008/m2_512_2037# u_t002_008/m2_1795_1265# u_t002_008/m2_1714_1982# u_t002_008/m2_1886_1259#
+ u_t002_008/m2_1290_2126# u_t002_008/m2_1714_438# u_t002_008/m2_431_1210# u_t002_008/m2_2573_2898#
+ u_t002_008/m2_2154_303# u_t002_008/m2_871_2081# VSUBS detronyx_12t_2w2r_rc4_4x4_routed_5layer_direct
Xgf180mcu_as_sc_mcu7t3v3__inv_2_1209 gf180mcu_as_sc_mcu7t3v3__nor2_2_9/VDD gf180mcu_as_sc_mcu7t3v3__nor2_2_9/VSS
+ VSS VSS gf180mcu_as_sc_mcu7t3v3__nor2_2_9/VNW VSUBS gf180mcu_as_sc_mcu7t3v3__inv_2
Xgf180mcu_as_sc_mcu7t3v3__inv_2_1710 gf180mcu_as_sc_mcu7t3v3__nor2_2_7/VDD gf180mcu_as_sc_mcu7t3v3__nor2_2_7/VSS
+ VSS VSS gf180mcu_as_sc_mcu7t3v3__nor2_2_7/VNW VSUBS gf180mcu_as_sc_mcu7t3v3__inv_2
Xgf180mcu_as_sc_mcu7t3v3__inv_2_1721 VSS VSS VSS VSS gf180mcu_as_sc_mcu7t3v3__inv_2_1723/VNW
+ VSUBS gf180mcu_as_sc_mcu7t3v3__inv_2
Xgf180mcu_as_sc_mcu7t3v3__nand4_2_504 VSS gf180mcu_as_sc_mcu7t3v3__inv_2_1689/VDD
+ VSS VSS VSS VSS VSS gf180mcu_as_sc_mcu7t3v3__inv_2_1681/VNW VSUBS gf180mcu_as_sc_mcu7t3v3__nand4_2
Xgf180mcu_as_sc_mcu7t3v3__inv_2_36 gf180mcu_as_sc_mcu7t3v3__inv_2_4/VDD gf180mcu_as_sc_mcu7t3v3__inv_2_4/VDD
+ gf180mcu_as_sc_mcu7t3v3__inv_2_8/Y VSS gf180mcu_as_sc_mcu7t3v3__inv_2_36/VNW VSUBS
+ gf180mcu_as_sc_mcu7t3v3__inv_2
Xgf180mcu_as_sc_mcu7t3v3__inv_2_14 gf180mcu_as_sc_mcu7t3v3__inv_2_8/VSS gf180mcu_as_sc_mcu7t3v3__inv_2_20/VDD
+ VSS gf180mcu_as_sc_mcu7t3v3__inv_2_24/Y gf180mcu_as_sc_mcu7t3v3__inv_2_16/VNW VSUBS
+ gf180mcu_as_sc_mcu7t3v3__inv_2
Xgf180mcu_as_sc_mcu7t3v3__inv_2_47 gf180mcu_as_sc_mcu7t3v3__inv_2_49/VDD gf180mcu_as_sc_mcu7t3v3__inv_2_66/VSS
+ VSS gf180mcu_as_sc_mcu7t3v3__inv_2_9/Y gf180mcu_as_sc_mcu7t3v3__inv_2_49/VNW VSUBS
+ gf180mcu_as_sc_mcu7t3v3__inv_2
Xgf180mcu_as_sc_mcu7t3v3__inv_2_58 gf180mcu_as_sc_mcu7t3v3__inv_2_62/VDD VSS gf180mcu_as_sc_mcu7t3v3__inv_2_9/Y
+ gf180mcu_as_sc_mcu7t3v3__inv_2_9/Y gf180mcu_as_sc_mcu7t3v3__inv_2_62/VNW VSUBS gf180mcu_as_sc_mcu7t3v3__inv_2
Xgf180mcu_as_sc_mcu7t3v3__inv_2_25 gf180mcu_as_sc_mcu7t3v3__inv_2_9/VSS gf180mcu_as_sc_mcu7t3v3__inv_2_38/VDD
+ gf180mcu_as_sc_mcu7t3v3__inv_2_9/Y VSS gf180mcu_as_sc_mcu7t3v3__inv_2_25/VNW VSUBS
+ gf180mcu_as_sc_mcu7t3v3__inv_2
Xgf180mcu_as_sc_mcu7t3v3__inv_2_69 gf180mcu_as_sc_mcu7t3v3__inv_2_69/VDD gf180mcu_as_sc_mcu7t3v3__inv_2_73/VDD
+ gf180mcu_as_sc_mcu7t3v3__inv_2_73/Y VSS gf180mcu_as_sc_mcu7t3v3__inv_2_69/VNW VSUBS
+ gf180mcu_as_sc_mcu7t3v3__inv_2
Xgf180mcu_as_sc_mcu7t3v3__inv_2_1006 VSS gf180mcu_as_sc_mcu7t3v3__inv_2_960/VSS gf180mcu_as_sc_mcu7t3v3__inv_2_1006/Y
+ gf180mcu_as_sc_mcu7t3v3__inv_2_1724/A gf180mcu_as_sc_mcu7t3v3__inv_2_960/VNW VSUBS
+ gf180mcu_as_sc_mcu7t3v3__inv_2
Xgf180mcu_as_sc_mcu7t3v3__inv_2_1017 VSS VSS gf180mcu_as_sc_mcu7t3v3__inv_2_1057/A
+ gf180mcu_as_sc_mcu7t3v3__inv_2_1021/Y gf180mcu_as_sc_mcu7t3v3__inv_2_1057/VNW VSUBS
+ gf180mcu_as_sc_mcu7t3v3__inv_2
Xgf180mcu_as_sc_mcu7t3v3__inv_2_1028 gf180mcu_as_sc_mcu7t3v3__inv_2_1028/VDD gf180mcu_as_sc_mcu7t3v3__inv_2_1049/VDD
+ gf180mcu_as_sc_mcu7t3v3__inv_2_1028/Y VSS gf180mcu_as_sc_mcu7t3v3__inv_2_1028/VNW
+ VSUBS gf180mcu_as_sc_mcu7t3v3__inv_2
Xgf180mcu_as_sc_mcu7t3v3__inv_2_1039 VSS VSS gf180mcu_as_sc_mcu7t3v3__inv_2_962/A
+ gf180mcu_as_sc_mcu7t3v3__inv_2_1040/Y gf180mcu_as_sc_mcu7t3v3__inv_2_1040/VNW VSUBS
+ gf180mcu_as_sc_mcu7t3v3__inv_2
Xgf180mcu_as_sc_mcu7t3v3__inv_2_1551 gf180mcu_as_sc_mcu7t3v3__inv_2_1553/VDD gf180mcu_as_sc_mcu7t3v3__inv_2_1556/VDD
+ VSS VSS gf180mcu_as_sc_mcu7t3v3__inv_2_1553/VNW VSUBS gf180mcu_as_sc_mcu7t3v3__inv_2
Xgf180mcu_as_sc_mcu7t3v3__inv_2_1562 gf180mcu_as_sc_mcu7t3v3__inv_2_1562/VDD gf180mcu_as_sc_mcu7t3v3__inv_2_1562/VSS
+ gf180mcu_as_sc_mcu7t3v3__inv_2_1562/Y VSS gf180mcu_as_sc_mcu7t3v3__inv_2_1562/VNW
+ VSUBS gf180mcu_as_sc_mcu7t3v3__inv_2
Xgf180mcu_as_sc_mcu7t3v3__inv_2_1540 gf180mcu_as_sc_mcu7t3v3__inv_2_1541/VDD gf180mcu_as_sc_mcu7t3v3__inv_2_1697/VDD
+ gf180mcu_as_sc_mcu7t3v3__inv_2_1540/Y VSS gf180mcu_as_sc_mcu7t3v3__inv_2_1541/VNW
+ VSUBS gf180mcu_as_sc_mcu7t3v3__inv_2
Xgf180mcu_as_sc_mcu7t3v3__inv_2_1595 VSS gf180mcu_as_sc_mcu7t3v3__inv_2_1598/VDD VSS
+ VSS gf180mcu_as_sc_mcu7t3v3__inv_2_1597/VNW VSUBS gf180mcu_as_sc_mcu7t3v3__inv_2
Xgf180mcu_as_sc_mcu7t3v3__inv_2_1573 gf180mcu_as_sc_mcu7t3v3__inv_2_1573/VDD VSS gf180mcu_as_sc_mcu7t3v3__inv_2_1573/Y
+ VSS gf180mcu_as_sc_mcu7t3v3__inv_2_1573/VNW VSUBS gf180mcu_as_sc_mcu7t3v3__inv_2
Xgf180mcu_as_sc_mcu7t3v3__inv_2_1584 VSS VSS VSS VSS gf180mcu_as_sc_mcu7t3v3__inv_2_1585/VNW
+ VSUBS gf180mcu_as_sc_mcu7t3v3__inv_2
Xgf180mcu_as_sc_mcu7t3v3__nand3_2_6 gf180mcu_as_sc_mcu7t3v3__nand3_2_9/VDD gf180mcu_as_sc_mcu7t3v3__nor2_2_7/VSS
+ VSS VSS VSS VSS gf180mcu_as_sc_mcu7t3v3__nand3_2_9/VNW VSUBS gf180mcu_as_sc_mcu7t3v3__nand3_2
Xgf180mcu_as_sc_mcu7t3v3__nand4_2_367 VSS VSS VSS VSS VSS VSS VSS gf180mcu_as_sc_mcu7t3v3__inv_2_1279/VNW
+ VSUBS gf180mcu_as_sc_mcu7t3v3__nand4_2
Xgf180mcu_as_sc_mcu7t3v3__nand4_2_334 VSS gf180mcu_as_sc_mcu7t3v3__inv_2_1100/VSS
+ VSS VSS VSS VSS VSS gf180mcu_as_sc_mcu7t3v3__inv_2_1100/VNW VSUBS gf180mcu_as_sc_mcu7t3v3__nand4_2
Xgf180mcu_as_sc_mcu7t3v3__nand4_2_345 VSS VSS VSS VSS VSS VSS VSS gf180mcu_as_sc_mcu7t3v3__inv_2_1124/VNW
+ VSUBS gf180mcu_as_sc_mcu7t3v3__nand4_2
Xgf180mcu_as_sc_mcu7t3v3__nand4_2_323 gf180mcu_as_sc_mcu7t3v3__inv_2_1087/VDD gf180mcu_as_sc_mcu7t3v3__inv_2_1091/VDD
+ VSS VSS VSS VSS VSS gf180mcu_as_sc_mcu7t3v3__inv_2_1087/VNW VSUBS gf180mcu_as_sc_mcu7t3v3__nand4_2
Xgf180mcu_as_sc_mcu7t3v3__nand4_2_356 VSS VSS VSS VSS VSS VSS VSS gf180mcu_as_sc_mcu7t3v3__inv_2_1271/VNW
+ VSUBS gf180mcu_as_sc_mcu7t3v3__nand4_2
Xgf180mcu_as_sc_mcu7t3v3__nand4_2_378 VSS VSS VSS VSS VSS VSS VSS gf180mcu_as_sc_mcu7t3v3__inv_2_1304/VNW
+ VSUBS gf180mcu_as_sc_mcu7t3v3__nand4_2
Xgf180mcu_as_sc_mcu7t3v3__nand4_2_312 gf180mcu_as_sc_mcu7t3v3__inv_2_1028/VDD gf180mcu_as_sc_mcu7t3v3__inv_2_1049/VDD
+ VSS VSS VSS VSS VSS gf180mcu_as_sc_mcu7t3v3__inv_2_1028/VNW VSUBS gf180mcu_as_sc_mcu7t3v3__nand4_2
Xgf180mcu_as_sc_mcu7t3v3__nand4_2_301 VSS VSS VSS VSS VSS VSS VSS gf180mcu_as_sc_mcu7t3v3__inv_2_997/VNW
+ VSUBS gf180mcu_as_sc_mcu7t3v3__nand4_2
Xgf180mcu_as_sc_mcu7t3v3__nand4_2_389 VSS VSS VSS VSS VSS VSS VSS gf180mcu_as_sc_mcu7t3v3__inv_2_1437/VNW
+ VSUBS gf180mcu_as_sc_mcu7t3v3__nand4_2
Xu_t029_011 u_t029_011/c0_w0_bl u_t029_011/c0_w0_br u_t029_011/c0_w1_bl u_t029_011/c0_w1_br
+ u_t029_011/c0_r0_rbl u_t029_011/c0_r1_rbl u_t029_011/c1_w0_bl u_t029_011/c1_w0_br
+ u_t029_011/c1_w1_bl u_t029_011/c1_w1_br u_t029_011/c1_r0_rbl u_t029_011/c1_r1_rbl
+ u_t029_011/c2_w0_bl u_t029_011/c2_w0_br u_t029_011/c2_w1_bl u_t029_011/c2_w1_br
+ u_t029_011/c2_r0_rbl u_t029_011/c2_r1_rbl u_t029_011/c3_w0_bl u_t029_011/c3_w0_br
+ u_t029_011/c3_w1_bl u_t029_011/c3_w1_br u_t029_011/c3_r0_rbl u_t029_011/c3_r1_rbl
+ u_t029_011/r0_w0_wl u_t029_011/r0_w1_wl u_t029_011/r0_r0_rwl u_t029_011/r0_r1_rwl
+ u_t029_011/r1_w0_wl u_t029_011/r1_w1_wl u_t029_011/r1_r0_rwl u_t029_011/r1_r1_rwl
+ u_t029_011/r2_w0_wl u_t029_011/r2_w1_wl u_t029_011/r2_r0_rwl u_t029_011/r2_r1_rwl
+ u_t029_011/r3_w0_wl u_t029_011/r3_w1_wl u_t029_011/r3_r0_rwl u_t029_011/r3_r1_rwl
+ u_t029_011/VDD VSS u_t029_011/m2_717_1265# u_t029_011/m2_603_2031# u_t029_011/m2_1290_336#
+ u_t029_011/m2_2000_2037# u_t029_011/m2_791_2909# u_t029_011/m2_7_2126# u_t029_011/m2_2154_2081#
+ u_t029_011/m2_1795_2037# u_t029_011/m2_871_303# u_t029_011/m2_431_438# u_t029_011/m2_1290_2898#
+ u_t029_011/m2_1714_1210# u_t029_011/m2_431_1982# u_t029_011/m2_512_1265# u_t029_011/m2_2573_2126#
+ u_t029_011/m2_603_1259# u_t029_011/m2_2074_2909# u_t029_011/m2_7_336# u_t029_011/m2_717_2037#
+ u_t029_011/m2_1886_2031# u_t029_011/m2_2573_336# u_t029_011/m2_7_2898# u_t029_011/m2_2000_1265#
+ u_t029_011/m2_512_2037# u_t029_011/m2_1795_1265# u_t029_011/m2_1714_1982# u_t029_011/m2_1886_1259#
+ u_t029_011/m2_1290_2126# u_t029_011/m2_1714_438# u_t029_011/m2_431_1210# u_t029_011/m2_2573_2898#
+ u_t029_011/m2_2154_303# u_t029_011/m2_871_2081# VSUBS detronyx_12t_2w2r_rc4_4x4_routed_5layer_direct
Xu_t029_000 VSS u_t029_000/c0_w0_br VSS u_t029_000/c0_w1_br u_t029_000/c0_r0_rbl u_t029_000/c0_r1_rbl
+ VSS VSS VSS VSS VSS VSS u_t029_000/c2_w0_bl u_t029_000/c2_w0_br u_t029_000/c2_w1_bl
+ u_t029_000/c2_w1_br u_t029_000/c2_r0_rbl u_t029_000/c2_r1_rbl u_t029_000/c3_w0_bl
+ u_t029_000/c3_w0_br u_t029_000/c3_w1_bl u_t029_000/c3_w1_br u_t029_000/c3_r0_rbl
+ u_t029_000/c3_r1_rbl VSS VSS VSS VSS VSS VSS VSS VSS VSS VSS VSS VSS VSS VSS VSS
+ VSS VSS VSS u_t029_000/m2_717_1265# VSS VSS VSS VSS u_t029_000/m2_7_2126# VSS VSS
+ VSS VSS VSS VSS VSS u_t029_000/m2_512_1265# VSS u_t029_000/m2_603_1259# VSS VSS
+ VSS VSS VSS VSS u_t029_000/m2_2000_1265# VSS u_t029_000/m2_1795_1265# VSS u_t029_000/m2_1886_1259#
+ u_t029_000/m2_1290_2126# VSS VSS VSS VSS VSS VSUBS detronyx_12t_2w2r_rc4_4x4_routed_5layer_direct
Xgf180mcu_as_sc_mcu7t3v3__inv_2_309 gf180mcu_as_sc_mcu7t3v3__inv_2_311/VDD gf180mcu_as_sc_mcu7t3v3__inv_2_311/VSS
+ VSS gf180mcu_as_sc_mcu7t3v3__inv_2_365/Y gf180mcu_as_sc_mcu7t3v3__inv_2_311/VNW
+ VSUBS gf180mcu_as_sc_mcu7t3v3__inv_2
Xgf180mcu_as_sc_mcu7t3v3__inv_2_1370 gf180mcu_as_sc_mcu7t3v3__inv_2_1370/VDD VSS gf180mcu_as_sc_mcu7t3v3__inv_2_1694/Y
+ VSS gf180mcu_as_sc_mcu7t3v3__inv_2_1370/VNW VSUBS gf180mcu_as_sc_mcu7t3v3__inv_2
Xgf180mcu_as_sc_mcu7t3v3__inv_2_1381 gf180mcu_as_sc_mcu7t3v3__inv_2_1382/VDD VSS gf180mcu_as_sc_mcu7t3v3__inv_2_1381/Y
+ gf180mcu_as_sc_mcu7t3v3__inv_2_1382/Y gf180mcu_as_sc_mcu7t3v3__inv_2_1382/VNW VSUBS
+ gf180mcu_as_sc_mcu7t3v3__inv_2
Xgf180mcu_as_sc_mcu7t3v3__inv_2_1392 gf180mcu_as_sc_mcu7t3v3__inv_2_1394/VDD VSS VSS
+ gf180mcu_as_sc_mcu7t3v3__inv_2_1394/Y gf180mcu_as_sc_mcu7t3v3__inv_2_1394/VNW VSUBS
+ gf180mcu_as_sc_mcu7t3v3__inv_2
Xgf180mcu_as_sc_mcu7t3v3__inv_2_854 gf180mcu_as_sc_mcu7t3v3__inv_2_854/VDD gf180mcu_as_sc_mcu7t3v3__inv_2_854/VSS
+ gf180mcu_as_sc_mcu7t3v3__inv_2_854/Y VSS gf180mcu_as_sc_mcu7t3v3__inv_2_854/VNW
+ VSUBS gf180mcu_as_sc_mcu7t3v3__inv_2
Xgf180mcu_as_sc_mcu7t3v3__inv_2_821 VSS VSS VSS VSS gf180mcu_as_sc_mcu7t3v3__inv_2_821/VNW
+ VSUBS gf180mcu_as_sc_mcu7t3v3__inv_2
Xgf180mcu_as_sc_mcu7t3v3__inv_2_832 VSS VSS VSS VSS gf180mcu_as_sc_mcu7t3v3__inv_2_832/VNW
+ VSUBS gf180mcu_as_sc_mcu7t3v3__inv_2
Xgf180mcu_as_sc_mcu7t3v3__inv_2_810 VSS VSS gf180mcu_as_sc_mcu7t3v3__inv_2_810/Y VSS
+ gf180mcu_as_sc_mcu7t3v3__inv_2_848/VNW VSUBS gf180mcu_as_sc_mcu7t3v3__inv_2
Xgf180mcu_as_sc_mcu7t3v3__inv_2_843 VSS VSS VSS VSS gf180mcu_as_sc_mcu7t3v3__inv_2_843/VNW
+ VSUBS gf180mcu_as_sc_mcu7t3v3__inv_2
Xgf180mcu_as_sc_mcu7t3v3__inv_2_898 VSS VSS VSS VSS gf180mcu_as_sc_mcu7t3v3__inv_2_927/VNW
+ VSUBS gf180mcu_as_sc_mcu7t3v3__inv_2
Xgf180mcu_as_sc_mcu7t3v3__inv_2_865 VSS VSS VSS VSS gf180mcu_as_sc_mcu7t3v3__inv_2_939/VNW
+ VSUBS gf180mcu_as_sc_mcu7t3v3__inv_2
Xgf180mcu_as_sc_mcu7t3v3__inv_2_887 VSS VSS VSS VSS gf180mcu_as_sc_mcu7t3v3__inv_2_935/VNW
+ VSUBS gf180mcu_as_sc_mcu7t3v3__inv_2
Xgf180mcu_as_sc_mcu7t3v3__inv_2_876 VSS VSS gf180mcu_as_sc_mcu7t3v3__inv_2_876/Y VSS
+ gf180mcu_as_sc_mcu7t3v3__inv_2_931/VNW VSUBS gf180mcu_as_sc_mcu7t3v3__inv_2
Xu_t026_014 u_t026_014/c0_w0_bl u_t026_014/c0_w0_br u_t026_014/c0_w1_bl u_t026_014/c0_w1_br
+ u_t026_014/c0_r0_rbl u_t026_014/c0_r1_rbl u_t026_014/c1_w0_bl u_t026_014/c1_w0_br
+ u_t026_014/c1_w1_bl u_t026_014/c1_w1_br u_t026_014/c1_r0_rbl u_t026_014/c1_r1_rbl
+ u_t026_014/c2_w0_bl u_t026_014/c2_w0_br u_t026_014/c2_w1_bl u_t026_014/c2_w1_br
+ u_t026_014/c2_r0_rbl u_t026_014/c2_r1_rbl u_t026_014/c3_w0_bl u_t026_014/c3_w0_br
+ u_t026_014/c3_w1_bl u_t026_014/c3_w1_br u_t026_014/c3_r0_rbl u_t026_014/c3_r1_rbl
+ u_t026_014/r0_w0_wl u_t026_014/r0_w1_wl u_t026_014/r0_r0_rwl u_t026_014/r0_r1_rwl
+ u_t026_014/r1_w0_wl u_t026_014/r1_w1_wl u_t026_014/r1_r0_rwl u_t026_014/r1_r1_rwl
+ u_t026_014/r2_w0_wl u_t026_014/r2_w1_wl u_t026_014/r2_r0_rwl u_t026_014/r2_r1_rwl
+ u_t026_014/r3_w0_wl u_t026_014/r3_w1_wl u_t026_014/r3_r0_rwl u_t026_014/r3_r1_rwl
+ u_t026_014/VDD VSS u_t026_014/m2_717_1265# u_t026_014/m2_603_2031# u_t026_014/m2_1290_336#
+ u_t026_014/m2_2000_2037# u_t026_014/m2_791_2909# u_t026_014/m2_7_2126# u_t026_014/m2_2154_2081#
+ u_t026_014/m2_1795_2037# u_t026_014/m2_871_303# u_t026_014/m2_431_438# u_t026_014/m2_1290_2898#
+ u_t026_014/m2_1714_1210# u_t026_014/m2_431_1982# u_t026_014/m2_512_1265# u_t026_014/m2_2573_2126#
+ u_t026_014/m2_603_1259# u_t026_014/m2_2074_2909# u_t026_014/m2_7_336# u_t026_014/m2_717_2037#
+ u_t026_014/m2_1886_2031# u_t026_014/m2_2573_336# u_t026_014/m2_7_2898# u_t026_014/m2_2000_1265#
+ u_t026_014/m2_512_2037# u_t026_014/m2_1795_1265# u_t026_014/m2_1714_1982# u_t026_014/m2_1886_1259#
+ u_t026_014/m2_1290_2126# u_t026_014/m2_1714_438# u_t026_014/m2_431_1210# u_t026_014/m2_2573_2898#
+ u_t026_014/m2_2154_303# u_t026_014/m2_871_2081# VSUBS detronyx_12t_2w2r_rc4_4x4_routed_5layer_direct
Xu_t026_003 u_t026_003/c0_w0_bl u_t026_003/c0_w0_br u_t026_003/c0_w1_bl u_t026_003/c0_w1_br
+ u_t026_003/c0_r0_rbl u_t026_003/c0_r1_rbl u_t026_003/c1_w0_bl u_t026_003/c1_w0_br
+ u_t026_003/c1_w1_bl u_t026_003/c1_w1_br u_t026_003/c1_r0_rbl u_t026_003/c1_r1_rbl
+ u_t026_003/c2_w0_bl u_t026_003/c2_w0_br u_t026_003/c2_w1_bl u_t026_003/c2_w1_br
+ u_t026_003/c2_r0_rbl u_t026_003/c2_r1_rbl u_t026_003/c3_w0_bl u_t026_003/c3_w0_br
+ u_t026_003/c3_w1_bl u_t026_003/c3_w1_br u_t026_003/c3_r0_rbl u_t026_003/c3_r1_rbl
+ u_t026_003/r0_w0_wl u_t026_003/r0_w1_wl u_t026_003/r0_r0_rwl u_t026_003/r0_r1_rwl
+ u_t026_003/r1_w0_wl u_t026_003/r1_w1_wl u_t026_003/r1_r0_rwl u_t026_003/r1_r1_rwl
+ u_t026_003/r2_w0_wl u_t026_003/r2_w1_wl u_t026_003/r2_r0_rwl u_t026_003/r2_r1_rwl
+ u_t026_003/r3_w0_wl u_t026_003/r3_w1_wl u_t026_003/r3_r0_rwl u_t026_003/r3_r1_rwl
+ u_t026_003/VDD VSS u_t026_003/m2_717_1265# u_t026_003/m2_603_2031# u_t026_003/m2_1290_336#
+ u_t026_003/m2_2000_2037# u_t026_003/m2_791_2909# u_t026_003/m2_7_2126# u_t026_003/m2_2154_2081#
+ u_t026_003/m2_1795_2037# u_t026_003/m2_871_303# u_t026_003/m2_431_438# u_t026_003/m2_1290_2898#
+ u_t026_003/m2_1714_1210# u_t026_003/m2_431_1982# u_t026_003/m2_512_1265# u_t026_003/m2_2573_2126#
+ u_t026_003/m2_603_1259# u_t026_003/m2_2074_2909# u_t026_003/m2_7_336# u_t026_003/m2_717_2037#
+ u_t026_003/m2_1886_2031# u_t026_003/m2_2573_336# u_t026_003/m2_7_2898# u_t026_003/m2_2000_1265#
+ u_t026_003/m2_512_2037# u_t026_003/m2_1795_1265# u_t026_003/m2_1714_1982# u_t026_003/m2_1886_1259#
+ u_t026_003/m2_1290_2126# u_t026_003/m2_1714_438# u_t026_003/m2_431_1210# u_t026_003/m2_2573_2898#
+ u_t026_003/m2_2154_303# u_t026_003/m2_871_2081# VSUBS detronyx_12t_2w2r_rc4_4x4_routed_5layer_direct
Xgf180mcu_as_sc_mcu7t3v3__nand4_2_153 VSS gf180mcu_as_sc_mcu7t3v3__inv_2_588/VDD VSS
+ VSS VSS VSS VSS gf180mcu_as_sc_mcu7t3v3__inv_2_585/VNW VSUBS gf180mcu_as_sc_mcu7t3v3__nand4_2
Xgf180mcu_as_sc_mcu7t3v3__nand4_2_175 gf180mcu_as_sc_mcu7t3v3__inv_2_607/VDD gf180mcu_as_sc_mcu7t3v3__inv_2_637/VDD
+ VSS VSS VSS VSS VSS gf180mcu_as_sc_mcu7t3v3__inv_2_607/VNW VSUBS gf180mcu_as_sc_mcu7t3v3__nand4_2
Xgf180mcu_as_sc_mcu7t3v3__nand4_2_131 VSS VSS VSS VSS VSS VSS gf180mcu_as_sc_mcu7t3v3__nand4_2_131/Y
+ gf180mcu_as_sc_mcu7t3v3__inv_2_544/VNW VSUBS gf180mcu_as_sc_mcu7t3v3__nand4_2
Xgf180mcu_as_sc_mcu7t3v3__nand4_2_164 gf180mcu_as_sc_mcu7t3v3__inv_2_624/VDD gf180mcu_as_sc_mcu7t3v3__inv_2_632/VDD
+ VSS VSS VSS VSS VSS gf180mcu_as_sc_mcu7t3v3__inv_2_624/VNW VSUBS gf180mcu_as_sc_mcu7t3v3__nand4_2
Xgf180mcu_as_sc_mcu7t3v3__nand4_2_142 VSS VSS VSS VSS VSS VSS gf180mcu_as_sc_mcu7t3v3__nand4_2_142/Y
+ gf180mcu_as_sc_mcu7t3v3__inv_2_538/VNW VSUBS gf180mcu_as_sc_mcu7t3v3__nand4_2
Xgf180mcu_as_sc_mcu7t3v3__nand4_2_120 gf180mcu_as_sc_mcu7t3v3__inv_2_301/VDD VSS VSS
+ VSS VSS VSS VSS gf180mcu_as_sc_mcu7t3v3__inv_2_301/VNW VSUBS gf180mcu_as_sc_mcu7t3v3__nand4_2
Xgf180mcu_as_sc_mcu7t3v3__nand4_2_186 VSS VSS VSS VSS VSS VSS VSS gf180mcu_as_sc_mcu7t3v3__inv_2_716/VNW
+ VSUBS gf180mcu_as_sc_mcu7t3v3__nand4_2
Xgf180mcu_as_sc_mcu7t3v3__nand4_2_197 gf180mcu_as_sc_mcu7t3v3__inv_2_741/VDD VSS VSS
+ VSS VSS VSS VSS gf180mcu_as_sc_mcu7t3v3__inv_2_741/VNW VSUBS gf180mcu_as_sc_mcu7t3v3__nand4_2
Xgf180mcu_as_sc_mcu7t3v3__nand4_2_92 gf180mcu_as_sc_mcu7t3v3__inv_2_62/VDD VSS VSS
+ VSS VSS VSS VSS gf180mcu_as_sc_mcu7t3v3__inv_2_62/VNW VSUBS gf180mcu_as_sc_mcu7t3v3__nand4_2
Xgf180mcu_as_sc_mcu7t3v3__nand4_2_81 gf180mcu_as_sc_mcu7t3v3__inv_2_57/VDD gf180mcu_as_sc_mcu7t3v3__inv_2_61/VDD
+ VSS VSS VSS VSS VSS gf180mcu_as_sc_mcu7t3v3__inv_2_57/VNW VSUBS gf180mcu_as_sc_mcu7t3v3__nand4_2
Xgf180mcu_as_sc_mcu7t3v3__nand4_2_70 VSS VSS VSS VSS VSS VSS VSS gf180mcu_as_sc_mcu7t3v3__inv_2_314/VNW
+ VSUBS gf180mcu_as_sc_mcu7t3v3__nand4_2
Xu_t017_014 u_t017_014/c0_w0_bl u_t017_014/c0_w0_br u_t017_014/c0_w1_bl u_t017_014/c0_w1_br
+ u_t017_014/c0_r0_rbl u_t017_014/c0_r1_rbl u_t017_014/c1_w0_bl u_t017_014/c1_w0_br
+ u_t017_014/c1_w1_bl u_t017_014/c1_w1_br u_t017_014/c1_r0_rbl u_t017_014/c1_r1_rbl
+ u_t017_014/c2_w0_bl u_t017_014/c2_w0_br u_t017_014/c2_w1_bl u_t017_014/c2_w1_br
+ u_t017_014/c2_r0_rbl u_t017_014/c2_r1_rbl u_t017_014/c3_w0_bl u_t017_014/c3_w0_br
+ u_t017_014/c3_w1_bl u_t017_014/c3_w1_br u_t017_014/c3_r0_rbl u_t017_014/c3_r1_rbl
+ u_t017_014/r0_w0_wl u_t017_014/r0_w1_wl u_t017_014/r0_r0_rwl u_t017_014/r0_r1_rwl
+ u_t017_014/r1_w0_wl u_t017_014/r1_w1_wl u_t017_014/r1_r0_rwl u_t017_014/r1_r1_rwl
+ u_t017_014/r2_w0_wl u_t017_014/r2_w1_wl u_t017_014/r2_r0_rwl u_t017_014/r2_r1_rwl
+ u_t017_014/r3_w0_wl u_t017_014/r3_w1_wl u_t017_014/r3_r0_rwl u_t017_014/r3_r1_rwl
+ u_t017_014/VDD VSS u_t017_014/m2_717_1265# u_t017_014/m2_603_2031# u_t017_014/m2_1290_336#
+ u_t017_014/m2_2000_2037# u_t017_014/m2_791_2909# u_t017_014/m2_7_2126# u_t017_014/m2_2154_2081#
+ u_t017_014/m2_1795_2037# u_t017_014/m2_871_303# u_t017_014/m2_431_438# u_t017_014/m2_1290_2898#
+ u_t017_014/m2_1714_1210# u_t017_014/m2_431_1982# u_t017_014/m2_512_1265# u_t017_014/m2_2573_2126#
+ u_t017_014/m2_603_1259# u_t017_014/m2_2074_2909# u_t017_014/m2_7_336# u_t017_014/m2_717_2037#
+ u_t017_014/m2_1886_2031# u_t017_014/m2_2573_336# u_t017_014/m2_7_2898# u_t017_014/m2_2000_1265#
+ u_t017_014/m2_512_2037# u_t017_014/m2_1795_1265# u_t017_014/m2_1714_1982# u_t017_014/m2_1886_1259#
+ u_t017_014/m2_1290_2126# u_t017_014/m2_1714_438# u_t017_014/m2_431_1210# u_t017_014/m2_2573_2898#
+ u_t017_014/m2_2154_303# u_t017_014/m2_871_2081# VSUBS detronyx_12t_2w2r_rc4_4x4_routed_5layer_direct
Xu_t017_003 u_t017_003/c0_w0_bl u_t017_003/c0_w0_br u_t017_003/c0_w1_bl u_t017_003/c0_w1_br
+ u_t017_003/c0_r0_rbl u_t017_003/c0_r1_rbl u_t017_003/c1_w0_bl u_t017_003/c1_w0_br
+ u_t017_003/c1_w1_bl u_t017_003/c1_w1_br u_t017_003/c1_r0_rbl u_t017_003/c1_r1_rbl
+ u_t017_003/c2_w0_bl u_t017_003/c2_w0_br u_t017_003/c2_w1_bl u_t017_003/c2_w1_br
+ u_t017_003/c2_r0_rbl u_t017_003/c2_r1_rbl u_t017_003/c3_w0_bl u_t017_003/c3_w0_br
+ u_t017_003/c3_w1_bl u_t017_003/c3_w1_br u_t017_003/c3_r0_rbl u_t017_003/c3_r1_rbl
+ u_t017_003/r0_w0_wl u_t017_003/r0_w1_wl u_t017_003/r0_r0_rwl u_t017_003/r0_r1_rwl
+ u_t017_003/r1_w0_wl u_t017_003/r1_w1_wl u_t017_003/r1_r0_rwl u_t017_003/r1_r1_rwl
+ u_t017_003/r2_w0_wl u_t017_003/r2_w1_wl u_t017_003/r2_r0_rwl u_t017_003/r2_r1_rwl
+ u_t017_003/r3_w0_wl u_t017_003/r3_w1_wl u_t017_003/r3_r0_rwl u_t017_003/r3_r1_rwl
+ u_t017_003/VDD VSS u_t017_003/m2_717_1265# u_t017_003/m2_603_2031# u_t017_003/m2_1290_336#
+ u_t017_003/m2_2000_2037# u_t017_003/m2_791_2909# u_t017_003/m2_7_2126# u_t017_003/m2_2154_2081#
+ u_t017_003/m2_1795_2037# u_t017_003/m2_871_303# u_t017_003/m2_431_438# u_t017_003/m2_1290_2898#
+ u_t017_003/m2_1714_1210# u_t017_003/m2_431_1982# u_t017_003/m2_512_1265# u_t017_003/m2_2573_2126#
+ u_t017_003/m2_603_1259# u_t017_003/m2_2074_2909# u_t017_003/m2_7_336# u_t017_003/m2_717_2037#
+ u_t017_003/m2_1886_2031# u_t017_003/m2_2573_336# u_t017_003/m2_7_2898# u_t017_003/m2_2000_1265#
+ u_t017_003/m2_512_2037# u_t017_003/m2_1795_1265# u_t017_003/m2_1714_1982# u_t017_003/m2_1886_1259#
+ u_t017_003/m2_1290_2126# u_t017_003/m2_1714_438# u_t017_003/m2_431_1210# u_t017_003/m2_2573_2898#
+ u_t017_003/m2_2154_303# u_t017_003/m2_871_2081# VSUBS detronyx_12t_2w2r_rc4_4x4_routed_5layer_direct
Xgf180mcu_as_sc_mcu7t3v3__inv_2_106 gf180mcu_as_sc_mcu7t3v3__nand4_2_9/VDD VSS gf180mcu_as_sc_mcu7t3v3__inv_2_106/Y
+ VSS gf180mcu_as_sc_mcu7t3v3__nand4_2_9/VNW VSUBS gf180mcu_as_sc_mcu7t3v3__inv_2
Xgf180mcu_as_sc_mcu7t3v3__inv_2_139 VSS gf180mcu_as_sc_mcu7t3v3__inv_2_143/VDD VSS
+ VSS gf180mcu_as_sc_mcu7t3v3__inv_2_140/VNW VSUBS gf180mcu_as_sc_mcu7t3v3__inv_2
Xgf180mcu_as_sc_mcu7t3v3__inv_2_128 gf180mcu_as_sc_mcu7t3v3__inv_2_131/VDD gf180mcu_as_sc_mcu7t3v3__inv_2_131/VDD
+ VSS VSS gf180mcu_as_sc_mcu7t3v3__inv_2_128/VNW VSUBS gf180mcu_as_sc_mcu7t3v3__inv_2
Xgf180mcu_as_sc_mcu7t3v3__inv_2_117 gf180mcu_as_sc_mcu7t3v3__inv_2_122/VDD gf180mcu_as_sc_mcu7t3v3__inv_2_122/VDD
+ gf180mcu_as_sc_mcu7t3v3__inv_2_117/Y VSS gf180mcu_as_sc_mcu7t3v3__inv_2_119/VNW
+ VSUBS gf180mcu_as_sc_mcu7t3v3__inv_2
Xu_t008_003 u_t008_003/c0_w0_bl u_t008_003/c0_w0_br u_t008_003/c0_w1_bl u_t008_003/c0_w1_br
+ u_t008_003/c0_r0_rbl u_t008_003/c0_r1_rbl u_t008_003/c1_w0_bl u_t008_003/c1_w0_br
+ u_t008_003/c1_w1_bl u_t008_003/c1_w1_br u_t008_003/c1_r0_rbl u_t008_003/c1_r1_rbl
+ u_t008_003/c2_w0_bl u_t008_003/c2_w0_br u_t008_003/c2_w1_bl u_t008_003/c2_w1_br
+ u_t008_003/c2_r0_rbl u_t008_003/c2_r1_rbl u_t008_003/c3_w0_bl u_t008_003/c3_w0_br
+ u_t008_003/c3_w1_bl u_t008_003/c3_w1_br u_t008_003/c3_r0_rbl u_t008_003/c3_r1_rbl
+ u_t008_003/r0_w0_wl u_t008_003/r0_w1_wl u_t008_003/r0_r0_rwl u_t008_003/r0_r1_rwl
+ u_t008_003/r1_w0_wl u_t008_003/r1_w1_wl u_t008_003/r1_r0_rwl u_t008_003/r1_r1_rwl
+ u_t008_003/r2_w0_wl u_t008_003/r2_w1_wl u_t008_003/r2_r0_rwl u_t008_003/r2_r1_rwl
+ u_t008_003/r3_w0_wl u_t008_003/r3_w1_wl u_t008_003/r3_r0_rwl u_t008_003/r3_r1_rwl
+ u_t008_003/VDD VSS u_t008_003/m2_717_1265# u_t008_003/m2_603_2031# u_t008_003/m2_1290_336#
+ u_t008_003/m2_2000_2037# u_t008_003/m2_791_2909# u_t008_003/m2_7_2126# u_t008_003/m2_2154_2081#
+ u_t008_003/m2_1795_2037# u_t008_003/m2_871_303# u_t008_003/m2_431_438# u_t008_003/m2_1290_2898#
+ u_t008_003/m2_1714_1210# u_t008_003/m2_431_1982# u_t008_003/m2_512_1265# u_t008_003/m2_2573_2126#
+ u_t008_003/m2_603_1259# u_t008_003/m2_2074_2909# u_t008_003/m2_7_336# u_t008_003/m2_717_2037#
+ u_t008_003/m2_1886_2031# u_t008_003/m2_2573_336# u_t008_003/m2_7_2898# u_t008_003/m2_2000_1265#
+ u_t008_003/m2_512_2037# u_t008_003/m2_1795_1265# u_t008_003/m2_1714_1982# u_t008_003/m2_1886_1259#
+ u_t008_003/m2_1290_2126# u_t008_003/m2_1714_438# u_t008_003/m2_431_1210# u_t008_003/m2_2573_2898#
+ u_t008_003/m2_2154_303# u_t008_003/m2_871_2081# VSUBS detronyx_12t_2w2r_rc4_4x4_routed_5layer_direct
Xu_t008_014 u_t008_014/c0_w0_bl u_t008_014/c0_w0_br u_t008_014/c0_w1_bl u_t008_014/c0_w1_br
+ u_t008_014/c0_r0_rbl u_t008_014/c0_r1_rbl u_t008_014/c1_w0_bl u_t008_014/c1_w0_br
+ u_t008_014/c1_w1_bl u_t008_014/c1_w1_br u_t008_014/c1_r0_rbl u_t008_014/c1_r1_rbl
+ u_t008_014/c2_w0_bl u_t008_014/c2_w0_br u_t008_014/c2_w1_bl u_t008_014/c2_w1_br
+ u_t008_014/c2_r0_rbl u_t008_014/c2_r1_rbl u_t008_014/c3_w0_bl u_t008_014/c3_w0_br
+ u_t008_014/c3_w1_bl u_t008_014/c3_w1_br u_t008_014/c3_r0_rbl u_t008_014/c3_r1_rbl
+ u_t008_014/r0_w0_wl u_t008_014/r0_w1_wl u_t008_014/r0_r0_rwl u_t008_014/r0_r1_rwl
+ u_t008_014/r1_w0_wl u_t008_014/r1_w1_wl u_t008_014/r1_r0_rwl u_t008_014/r1_r1_rwl
+ u_t008_014/r2_w0_wl u_t008_014/r2_w1_wl u_t008_014/r2_r0_rwl u_t008_014/r2_r1_rwl
+ u_t008_014/r3_w0_wl u_t008_014/r3_w1_wl u_t008_014/r3_r0_rwl u_t008_014/r3_r1_rwl
+ u_t008_014/VDD VSS u_t008_014/m2_717_1265# u_t008_014/m2_603_2031# u_t008_014/m2_1290_336#
+ u_t008_014/m2_2000_2037# u_t008_014/m2_791_2909# u_t008_014/m2_7_2126# u_t008_014/m2_2154_2081#
+ u_t008_014/m2_1795_2037# u_t008_014/m2_871_303# u_t008_014/m2_431_438# u_t008_014/m2_1290_2898#
+ u_t008_014/m2_1714_1210# u_t008_014/m2_431_1982# u_t008_014/m2_512_1265# u_t008_014/m2_2573_2126#
+ u_t008_014/m2_603_1259# u_t008_014/m2_2074_2909# u_t008_014/m2_7_336# u_t008_014/m2_717_2037#
+ u_t008_014/m2_1886_2031# u_t008_014/m2_2573_336# u_t008_014/m2_7_2898# u_t008_014/m2_2000_1265#
+ u_t008_014/m2_512_2037# u_t008_014/m2_1795_1265# u_t008_014/m2_1714_1982# u_t008_014/m2_1886_1259#
+ u_t008_014/m2_1290_2126# u_t008_014/m2_1714_438# u_t008_014/m2_431_1210# u_t008_014/m2_2573_2898#
+ u_t008_014/m2_2154_303# u_t008_014/m2_871_2081# VSUBS detronyx_12t_2w2r_rc4_4x4_routed_5layer_direct
Xu_t023_006 u_t023_006/c0_w0_bl u_t023_006/c0_w0_br u_t023_006/c0_w1_bl u_t023_006/c0_w1_br
+ u_t023_006/c0_r0_rbl u_t023_006/c0_r1_rbl u_t023_006/c1_w0_bl u_t023_006/c1_w0_br
+ u_t023_006/c1_w1_bl u_t023_006/c1_w1_br u_t023_006/c1_r0_rbl u_t023_006/c1_r1_rbl
+ u_t023_006/c2_w0_bl u_t023_006/c2_w0_br u_t023_006/c2_w1_bl u_t023_006/c2_w1_br
+ u_t023_006/c2_r0_rbl u_t023_006/c2_r1_rbl u_t023_006/c3_w0_bl u_t023_006/c3_w0_br
+ u_t023_006/c3_w1_bl u_t023_006/c3_w1_br u_t023_006/c3_r0_rbl u_t023_006/c3_r1_rbl
+ u_t023_006/r0_w0_wl u_t023_006/r0_w1_wl u_t023_006/r0_r0_rwl u_t023_006/r0_r1_rwl
+ u_t023_006/r1_w0_wl u_t023_006/r1_w1_wl u_t023_006/r1_r0_rwl u_t023_006/r1_r1_rwl
+ u_t023_006/r2_w0_wl u_t023_006/r2_w1_wl u_t023_006/r2_r0_rwl u_t023_006/r2_r1_rwl
+ u_t023_006/r3_w0_wl u_t023_006/r3_w1_wl u_t023_006/r3_r0_rwl u_t023_006/r3_r1_rwl
+ u_t023_006/VDD u_t023_009/VSS u_t023_006/m2_717_1265# u_t023_006/m2_603_2031# u_t023_006/m2_1290_336#
+ u_t023_006/m2_2000_2037# u_t023_006/m2_791_2909# u_t023_006/m2_7_2126# u_t023_006/m2_2154_2081#
+ u_t023_006/m2_1795_2037# u_t023_006/m2_871_303# u_t023_006/m2_431_438# u_t023_006/m2_1290_2898#
+ u_t023_006/m2_1714_1210# u_t023_006/m2_431_1982# u_t023_006/m2_512_1265# u_t023_006/m2_2573_2126#
+ u_t023_006/m2_603_1259# u_t023_006/m2_2074_2909# u_t023_006/m2_7_336# u_t023_006/m2_717_2037#
+ u_t023_006/m2_1886_2031# u_t023_006/m2_2573_336# u_t023_006/m2_7_2898# u_t023_006/m2_2000_1265#
+ u_t023_006/m2_512_2037# u_t023_006/m2_1795_1265# u_t023_006/m2_1714_1982# u_t023_006/m2_1886_1259#
+ u_t023_006/m2_1290_2126# u_t023_006/m2_1714_438# u_t023_006/m2_431_1210# u_t023_006/m2_2573_2898#
+ u_t023_006/m2_2154_303# u_t023_006/m2_871_2081# VSUBS detronyx_12t_2w2r_rc4_4x4_routed_5layer_direct
Xgf180mcu_as_sc_mcu7t3v3__inv_2_640 VSS VSS gf180mcu_as_sc_mcu7t3v3__inv_2_640/Y gf180mcu_as_sc_mcu7t3v3__inv_2_641/Y
+ gf180mcu_as_sc_mcu7t3v3__inv_2_641/VNW VSUBS gf180mcu_as_sc_mcu7t3v3__inv_2
Xgf180mcu_as_sc_mcu7t3v3__inv_2_684 VSS gf180mcu_as_sc_mcu7t3v3__inv_2_688/VDD gf180mcu_as_sc_mcu7t3v3__inv_2_684/Y
+ VSS gf180mcu_as_sc_mcu7t3v3__inv_2_684/VNW VSUBS gf180mcu_as_sc_mcu7t3v3__inv_2
Xgf180mcu_as_sc_mcu7t3v3__inv_2_651 VSS gf180mcu_as_sc_mcu7t3v3__inv_2_656/VDD gf180mcu_as_sc_mcu7t3v3__inv_2_853/Y
+ gf180mcu_as_sc_mcu7t3v3__inv_2_652/Y gf180mcu_as_sc_mcu7t3v3__inv_2_652/VNW VSUBS
+ gf180mcu_as_sc_mcu7t3v3__inv_2
Xgf180mcu_as_sc_mcu7t3v3__inv_2_662 gf180mcu_as_sc_mcu7t3v3__inv_2_664/VDD VSS gf180mcu_as_sc_mcu7t3v3__inv_2_662/Y
+ gf180mcu_as_sc_mcu7t3v3__inv_2_662/A gf180mcu_as_sc_mcu7t3v3__inv_2_664/VNW VSUBS
+ gf180mcu_as_sc_mcu7t3v3__inv_2
Xgf180mcu_as_sc_mcu7t3v3__inv_2_673 gf180mcu_as_sc_mcu7t3v3__inv_2_674/VDD gf180mcu_as_sc_mcu7t3v3__inv_2_678/VDD
+ gf180mcu_as_sc_mcu7t3v3__inv_2_744/A gf180mcu_as_sc_mcu7t3v3__inv_2_674/Y gf180mcu_as_sc_mcu7t3v3__inv_2_674/VNW
+ VSUBS gf180mcu_as_sc_mcu7t3v3__inv_2
Xgf180mcu_as_sc_mcu7t3v3__inv_2_695 gf180mcu_as_sc_mcu7t3v3__inv_2_743/VSS VSS gf180mcu_as_sc_mcu7t3v3__inv_2_695/Y
+ gf180mcu_as_sc_mcu7t3v3__inv_2_742/A gf180mcu_as_sc_mcu7t3v3__inv_2_701/VNW VSUBS
+ gf180mcu_as_sc_mcu7t3v3__inv_2
Xgf180mcu_as_sc_mcu7t3v3__nand2_2_18 gf180mcu_as_sc_mcu7t3v3__nand3_2_9/VDD gf180mcu_as_sc_mcu7t3v3__nor2_2_7/VSS
+ VSS VSS VSS gf180mcu_as_sc_mcu7t3v3__nand3_2_9/VNW VSUBS gf180mcu_as_sc_mcu7t3v3__nand2_2
Xgf180mcu_as_sc_mcu7t3v3__nand2_2_29 gf180mcu_as_sc_mcu7t3v3__nand3_2_9/VDD gf180mcu_as_sc_mcu7t3v3__nor2_2_7/VSS
+ VSS VSS VSS gf180mcu_as_sc_mcu7t3v3__nand3_2_9/VNW VSUBS gf180mcu_as_sc_mcu7t3v3__nand2_2
Xu_t014_006 u_t014_006/c0_w0_bl u_t014_006/c0_w0_br u_t014_006/c0_w1_bl u_t014_006/c0_w1_br
+ u_t014_006/c0_r0_rbl u_t014_006/c0_r1_rbl u_t014_006/c1_w0_bl u_t014_006/c1_w0_br
+ u_t014_006/c1_w1_bl u_t014_006/c1_w1_br u_t014_006/c1_r0_rbl u_t014_006/c1_r1_rbl
+ u_t014_006/c2_w0_bl u_t014_006/c2_w0_br u_t014_006/c2_w1_bl u_t014_006/c2_w1_br
+ u_t014_006/c2_r0_rbl u_t014_006/c2_r1_rbl u_t014_006/c3_w0_bl u_t014_006/c3_w0_br
+ u_t014_006/c3_w1_bl u_t014_006/c3_w1_br u_t014_006/c3_r0_rbl u_t014_006/c3_r1_rbl
+ u_t014_006/r0_w0_wl u_t014_006/r0_w1_wl u_t014_006/r0_r0_rwl u_t014_006/r0_r1_rwl
+ u_t014_006/r1_w0_wl u_t014_006/r1_w1_wl u_t014_006/r1_r0_rwl u_t014_006/r1_r1_rwl
+ u_t014_006/r2_w0_wl u_t014_006/r2_w1_wl u_t014_006/r2_r0_rwl u_t014_006/r2_r1_rwl
+ u_t014_006/r3_w0_wl u_t014_006/r3_w1_wl u_t014_006/r3_r0_rwl u_t014_006/r3_r1_rwl
+ u_t014_006/VDD u_t014_009/VSS u_t014_006/m2_717_1265# u_t014_006/m2_603_2031# u_t014_006/m2_1290_336#
+ u_t014_006/m2_2000_2037# u_t014_006/m2_791_2909# u_t014_006/m2_7_2126# u_t014_006/m2_2154_2081#
+ u_t014_006/m2_1795_2037# u_t014_006/m2_871_303# u_t014_006/m2_431_438# u_t014_006/m2_1290_2898#
+ u_t014_006/m2_1714_1210# u_t014_006/m2_431_1982# u_t014_006/m2_512_1265# u_t014_006/m2_2573_2126#
+ u_t014_006/m2_603_1259# u_t014_006/m2_2074_2909# u_t014_006/m2_7_336# u_t014_006/m2_717_2037#
+ u_t014_006/m2_1886_2031# u_t014_006/m2_2573_336# u_t014_006/m2_7_2898# u_t014_006/m2_2000_1265#
+ u_t014_006/m2_512_2037# u_t014_006/m2_1795_1265# u_t014_006/m2_1714_1982# u_t014_006/m2_1886_1259#
+ u_t014_006/m2_1290_2126# u_t014_006/m2_1714_438# u_t014_006/m2_431_1210# u_t014_006/m2_2573_2898#
+ u_t014_006/m2_2154_303# u_t014_006/m2_871_2081# VSUBS detronyx_12t_2w2r_rc4_4x4_routed_5layer_direct
Xu_t005_006 u_t005_006/c0_w0_bl u_t005_006/c0_w0_br u_t005_006/c0_w1_bl u_t005_006/c0_w1_br
+ u_t005_006/c0_r0_rbl u_t005_006/c0_r1_rbl u_t005_006/c1_w0_bl u_t005_006/c1_w0_br
+ u_t005_006/c1_w1_bl u_t005_006/c1_w1_br u_t005_006/c1_r0_rbl u_t005_006/c1_r1_rbl
+ u_t005_006/c2_w0_bl u_t005_006/c2_w0_br u_t005_006/c2_w1_bl u_t005_006/c2_w1_br
+ u_t005_006/c2_r0_rbl u_t005_006/c2_r1_rbl u_t005_006/c3_w0_bl u_t005_006/c3_w0_br
+ u_t005_006/c3_w1_bl u_t005_006/c3_w1_br u_t005_006/c3_r0_rbl u_t005_006/c3_r1_rbl
+ u_t005_006/r0_w0_wl u_t005_006/r0_w1_wl u_t005_006/r0_r0_rwl u_t005_006/r0_r1_rwl
+ u_t005_006/r1_w0_wl u_t005_006/r1_w1_wl u_t005_006/r1_r0_rwl u_t005_006/r1_r1_rwl
+ u_t005_006/r2_w0_wl u_t005_006/r2_w1_wl u_t005_006/r2_r0_rwl u_t005_006/r2_r1_rwl
+ u_t005_006/r3_w0_wl u_t005_006/r3_w1_wl u_t005_006/r3_r0_rwl u_t005_006/r3_r1_rwl
+ u_t005_006/VDD VSS u_t005_006/m2_717_1265# u_t005_006/m2_603_2031# u_t005_006/m2_1290_336#
+ u_t005_006/m2_2000_2037# u_t005_006/m2_791_2909# u_t005_006/m2_7_2126# u_t005_006/m2_2154_2081#
+ u_t005_006/m2_1795_2037# u_t005_006/m2_871_303# u_t005_006/m2_431_438# u_t005_006/m2_1290_2898#
+ u_t005_006/m2_1714_1210# u_t005_006/m2_431_1982# u_t005_006/m2_512_1265# u_t005_006/m2_2573_2126#
+ u_t005_006/m2_603_1259# u_t005_006/m2_2074_2909# u_t005_006/m2_7_336# u_t005_006/m2_717_2037#
+ u_t005_006/m2_1886_2031# u_t005_006/m2_2573_336# u_t005_006/m2_7_2898# u_t005_006/m2_2000_1265#
+ u_t005_006/m2_512_2037# u_t005_006/m2_1795_1265# u_t005_006/m2_1714_1982# u_t005_006/m2_1886_1259#
+ u_t005_006/m2_1290_2126# u_t005_006/m2_1714_438# u_t005_006/m2_431_1210# u_t005_006/m2_2573_2898#
+ u_t005_006/m2_2154_303# u_t005_006/m2_871_2081# VSUBS detronyx_12t_2w2r_rc4_4x4_routed_5layer_direct
Xu_t020_009 u_t020_009/c0_w0_bl u_t020_009/c0_w0_br u_t020_009/c0_w1_bl u_t020_009/c0_w1_br
+ u_t020_009/c0_r0_rbl u_t020_009/c0_r1_rbl u_t020_009/c1_w0_bl u_t020_009/c1_w0_br
+ u_t020_009/c1_w1_bl u_t020_009/c1_w1_br u_t020_009/c1_r0_rbl u_t020_009/c1_r1_rbl
+ u_t020_009/c2_w0_bl u_t020_009/c2_w0_br u_t020_009/c2_w1_bl u_t020_009/c2_w1_br
+ u_t020_009/c2_r0_rbl u_t020_009/c2_r1_rbl u_t020_009/c3_w0_bl u_t020_009/c3_w0_br
+ u_t020_009/c3_w1_bl u_t020_009/c3_w1_br u_t020_009/c3_r0_rbl u_t020_009/c3_r1_rbl
+ u_t020_009/r0_w0_wl u_t020_009/r0_w1_wl u_t020_009/r0_r0_rwl u_t020_009/r0_r1_rwl
+ u_t020_009/r1_w0_wl u_t020_009/r1_w1_wl u_t020_009/r1_r0_rwl u_t020_009/r1_r1_rwl
+ u_t020_009/r2_w0_wl u_t020_009/r2_w1_wl u_t020_009/r2_r0_rwl u_t020_009/r2_r1_rwl
+ u_t020_009/r3_w0_wl u_t020_009/r3_w1_wl u_t020_009/r3_r0_rwl u_t020_009/r3_r1_rwl
+ VSS u_t020_009/VSS u_t020_009/m2_717_1265# u_t020_009/m2_603_2031# u_t020_009/m2_1290_336#
+ u_t020_009/m2_2000_2037# u_t020_009/m2_791_2909# u_t020_009/m2_7_2126# u_t020_009/m2_2154_2081#
+ u_t020_009/m2_1795_2037# u_t020_009/m2_871_303# u_t020_009/m2_431_438# u_t020_009/m2_1290_2898#
+ u_t020_009/m2_1714_1210# u_t020_009/m2_431_1982# u_t020_009/m2_512_1265# u_t020_009/m2_2573_2126#
+ u_t020_009/m2_603_1259# u_t020_009/m2_2074_2909# u_t020_009/m2_7_336# u_t020_009/m2_717_2037#
+ u_t020_009/m2_1886_2031# u_t020_009/m2_2573_336# u_t020_009/m2_7_2898# u_t020_009/m2_2000_1265#
+ u_t020_009/m2_512_2037# u_t020_009/m2_1795_1265# u_t020_009/m2_1714_1982# u_t020_009/m2_1886_1259#
+ u_t020_009/m2_1290_2126# u_t020_009/m2_1714_438# u_t020_009/m2_431_1210# u_t020_009/m2_2573_2898#
+ u_t020_009/m2_2154_303# u_t020_009/m2_871_2081# VSUBS detronyx_12t_2w2r_rc4_4x4_routed_5layer_direct
Xu_t011_009 u_t011_009/c0_w0_bl u_t011_009/c0_w0_br u_t011_009/c0_w1_bl u_t011_009/c0_w1_br
+ u_t011_009/c0_r0_rbl u_t011_009/c0_r1_rbl u_t011_009/c1_w0_bl u_t011_009/c1_w0_br
+ u_t011_009/c1_w1_bl u_t011_009/c1_w1_br u_t011_009/c1_r0_rbl u_t011_009/c1_r1_rbl
+ u_t011_009/c2_w0_bl u_t011_009/c2_w0_br u_t011_009/c2_w1_bl u_t011_009/c2_w1_br
+ u_t011_009/c2_r0_rbl u_t011_009/c2_r1_rbl u_t011_009/c3_w0_bl u_t011_009/c3_w0_br
+ u_t011_009/c3_w1_bl u_t011_009/c3_w1_br u_t011_009/c3_r0_rbl u_t011_009/c3_r1_rbl
+ u_t011_009/r0_w0_wl u_t011_009/r0_w1_wl u_t011_009/r0_r0_rwl u_t011_009/r0_r1_rwl
+ u_t011_009/r1_w0_wl u_t011_009/r1_w1_wl u_t011_009/r1_r0_rwl u_t011_009/r1_r1_rwl
+ u_t011_009/r2_w0_wl u_t011_009/r2_w1_wl u_t011_009/r2_r0_rwl u_t011_009/r2_r1_rwl
+ u_t011_009/r3_w0_wl u_t011_009/r3_w1_wl u_t011_009/r3_r0_rwl u_t011_009/r3_r1_rwl
+ VSS u_t011_009/VSS u_t011_009/m2_717_1265# u_t011_009/m2_603_2031# u_t011_009/m2_1290_336#
+ u_t011_009/m2_2000_2037# u_t011_009/m2_791_2909# u_t011_009/m2_7_2126# u_t011_009/m2_2154_2081#
+ u_t011_009/m2_1795_2037# u_t011_009/m2_871_303# u_t011_009/m2_431_438# u_t011_009/m2_1290_2898#
+ u_t011_009/m2_1714_1210# u_t011_009/m2_431_1982# u_t011_009/m2_512_1265# u_t011_009/m2_2573_2126#
+ u_t011_009/m2_603_1259# u_t011_009/m2_2074_2909# u_t011_009/m2_7_336# u_t011_009/m2_717_2037#
+ u_t011_009/m2_1886_2031# u_t011_009/m2_2573_336# u_t011_009/m2_7_2898# u_t011_009/m2_2000_1265#
+ u_t011_009/m2_512_2037# u_t011_009/m2_1795_1265# u_t011_009/m2_1714_1982# u_t011_009/m2_1886_1259#
+ u_t011_009/m2_1290_2126# u_t011_009/m2_1714_438# u_t011_009/m2_431_1210# u_t011_009/m2_2573_2898#
+ u_t011_009/m2_2154_303# u_t011_009/m2_871_2081# VSUBS detronyx_12t_2w2r_rc4_4x4_routed_5layer_direct
Xgf180mcu_as_sc_mcu7t3v3__inv_2_481 VSS VSS VSS VSS gf180mcu_as_sc_mcu7t3v3__inv_2_547/VNW
+ VSUBS gf180mcu_as_sc_mcu7t3v3__inv_2
Xgf180mcu_as_sc_mcu7t3v3__inv_2_470 gf180mcu_as_sc_mcu7t3v3__nand3_2_9/VDD gf180mcu_as_sc_mcu7t3v3__nor2_2_4/VSS
+ VSS VSS gf180mcu_as_sc_mcu7t3v3__nand3_2_9/VNW VSUBS gf180mcu_as_sc_mcu7t3v3__inv_2
Xgf180mcu_as_sc_mcu7t3v3__inv_2_492 VSS VSS VSS VSS gf180mcu_as_sc_mcu7t3v3__inv_2_553/VNW
+ VSUBS gf180mcu_as_sc_mcu7t3v3__inv_2
Xu_t002_009 u_t002_009/c0_w0_bl u_t002_009/c0_w0_br u_t002_009/c0_w1_bl u_t002_009/c0_w1_br
+ u_t002_009/c0_r0_rbl u_t002_009/c0_r1_rbl u_t002_009/c1_w0_bl u_t002_009/c1_w0_br
+ u_t002_009/c1_w1_bl u_t002_009/c1_w1_br u_t002_009/c1_r0_rbl u_t002_009/c1_r1_rbl
+ u_t002_009/c2_w0_bl u_t002_009/c2_w0_br u_t002_009/c2_w1_bl u_t002_009/c2_w1_br
+ u_t002_009/c2_r0_rbl u_t002_009/c2_r1_rbl u_t002_009/c3_w0_bl u_t002_009/c3_w0_br
+ u_t002_009/c3_w1_bl u_t002_009/c3_w1_br u_t002_009/c3_r0_rbl u_t002_009/c3_r1_rbl
+ u_t002_009/r0_w0_wl u_t002_009/r0_w1_wl u_t002_009/r0_r0_rwl u_t002_009/r0_r1_rwl
+ u_t002_009/r1_w0_wl u_t002_009/r1_w1_wl u_t002_009/r1_r0_rwl u_t002_009/r1_r1_rwl
+ u_t002_009/r2_w0_wl u_t002_009/r2_w1_wl u_t002_009/r2_r0_rwl u_t002_009/r2_r1_rwl
+ u_t002_009/r3_w0_wl u_t002_009/r3_w1_wl u_t002_009/r3_r0_rwl u_t002_009/r3_r1_rwl
+ VSS u_t002_009/VSS u_t002_009/m2_717_1265# u_t002_009/m2_603_2031# u_t002_009/m2_1290_336#
+ u_t002_009/m2_2000_2037# u_t002_009/m2_791_2909# u_t002_009/m2_7_2126# u_t002_009/m2_2154_2081#
+ u_t002_009/m2_1795_2037# u_t002_009/m2_871_303# u_t002_009/m2_431_438# u_t002_009/m2_1290_2898#
+ u_t002_009/m2_1714_1210# u_t002_009/m2_431_1982# u_t002_009/m2_512_1265# u_t002_009/m2_2573_2126#
+ u_t002_009/m2_603_1259# u_t002_009/m2_2074_2909# u_t002_009/m2_7_336# u_t002_009/m2_717_2037#
+ u_t002_009/m2_1886_2031# u_t002_009/m2_2573_336# u_t002_009/m2_7_2898# u_t002_009/m2_2000_1265#
+ u_t002_009/m2_512_2037# u_t002_009/m2_1795_1265# u_t002_009/m2_1714_1982# u_t002_009/m2_1886_1259#
+ u_t002_009/m2_1290_2126# u_t002_009/m2_1714_438# u_t002_009/m2_431_1210# u_t002_009/m2_2573_2898#
+ u_t002_009/m2_2154_303# u_t002_009/m2_871_2081# VSUBS detronyx_12t_2w2r_rc4_4x4_routed_5layer_direct
Xgf180mcu_as_sc_mcu7t3v3__inv_2_1711 gf180mcu_as_sc_mcu7t3v3__nand3_2_65/VDD gf180mcu_as_sc_mcu7t3v3__nor2_2_9/VSS
+ VSS VSS gf180mcu_as_sc_mcu7t3v3__nand3_2_65/VNW VSUBS gf180mcu_as_sc_mcu7t3v3__inv_2
Xgf180mcu_as_sc_mcu7t3v3__inv_2_1700 gf180mcu_as_sc_mcu7t3v3__nor2_2_6/VDD gf180mcu_as_sc_mcu7t3v3__nand3_2_4/VSS
+ gf180mcu_as_sc_mcu7t3v3__inv_2_1700/Y VSS gf180mcu_as_sc_mcu7t3v3__nor2_2_6/VNW
+ VSUBS gf180mcu_as_sc_mcu7t3v3__inv_2
Xgf180mcu_as_sc_mcu7t3v3__inv_2_1722 VSS VSS VSS VSS gf180mcu_as_sc_mcu7t3v3__inv_2_1723/VNW
+ VSUBS gf180mcu_as_sc_mcu7t3v3__inv_2
Xgf180mcu_as_sc_mcu7t3v3__nand4_2_505 gf180mcu_as_sc_mcu7t3v3__inv_2_1689/VDD gf180mcu_as_sc_mcu7t3v3__inv_2_1689/VSS
+ VSS VSS VSS VSS VSS gf180mcu_as_sc_mcu7t3v3__inv_2_1689/VNW VSUBS gf180mcu_as_sc_mcu7t3v3__nand4_2
Xgf180mcu_as_sc_mcu7t3v3__inv_2_1029 VSS gf180mcu_as_sc_mcu7t3v3__inv_2_1053/VDD VSS
+ gf180mcu_as_sc_mcu7t3v3__inv_2_1057/A gf180mcu_as_sc_mcu7t3v3__inv_2_1037/VNW VSUBS
+ gf180mcu_as_sc_mcu7t3v3__inv_2
Xgf180mcu_as_sc_mcu7t3v3__inv_2_15 gf180mcu_as_sc_mcu7t3v3__inv_2_8/VSS gf180mcu_as_sc_mcu7t3v3__inv_2_20/VDD
+ gf180mcu_as_sc_mcu7t3v3__inv_2_15/Y gf180mcu_as_sc_mcu7t3v3__inv_2_24/Y gf180mcu_as_sc_mcu7t3v3__inv_2_16/VNW
+ VSUBS gf180mcu_as_sc_mcu7t3v3__inv_2
Xgf180mcu_as_sc_mcu7t3v3__inv_2_26 gf180mcu_as_sc_mcu7t3v3__inv_2_66/VSS gf180mcu_as_sc_mcu7t3v3__inv_2_32/VDD
+ VSS gf180mcu_as_sc_mcu7t3v3__inv_2_66/Y gf180mcu_as_sc_mcu7t3v3__inv_2_28/VNW VSUBS
+ gf180mcu_as_sc_mcu7t3v3__inv_2
Xgf180mcu_as_sc_mcu7t3v3__inv_2_48 gf180mcu_as_sc_mcu7t3v3__inv_2_49/VDD gf180mcu_as_sc_mcu7t3v3__inv_2_66/VSS
+ gf180mcu_as_sc_mcu7t3v3__inv_2_48/Y gf180mcu_as_sc_mcu7t3v3__inv_2_9/Y gf180mcu_as_sc_mcu7t3v3__inv_2_49/VNW
+ VSUBS gf180mcu_as_sc_mcu7t3v3__inv_2
Xgf180mcu_as_sc_mcu7t3v3__inv_2_37 gf180mcu_as_sc_mcu7t3v3__inv_2_38/VDD VSS gf180mcu_as_sc_mcu7t3v3__inv_2_9/Y
+ gf180mcu_as_sc_mcu7t3v3__inv_2_9/Y gf180mcu_as_sc_mcu7t3v3__inv_2_38/VNW VSUBS gf180mcu_as_sc_mcu7t3v3__inv_2
Xgf180mcu_as_sc_mcu7t3v3__inv_2_59 gf180mcu_as_sc_mcu7t3v3__inv_2_61/VDD gf180mcu_as_sc_mcu7t3v3__inv_2_69/VDD
+ VSS gf180mcu_as_sc_mcu7t3v3__inv_2_61/Y gf180mcu_as_sc_mcu7t3v3__inv_2_61/VNW VSUBS
+ gf180mcu_as_sc_mcu7t3v3__inv_2
Xgf180mcu_as_sc_mcu7t3v3__inv_2_1007 VSS gf180mcu_as_sc_mcu7t3v3__inv_2_960/VSS gf180mcu_as_sc_mcu7t3v3__inv_2_1007/Y
+ gf180mcu_as_sc_mcu7t3v3__inv_2_960/Y gf180mcu_as_sc_mcu7t3v3__inv_2_960/VNW VSUBS
+ gf180mcu_as_sc_mcu7t3v3__inv_2
Xgf180mcu_as_sc_mcu7t3v3__inv_2_1018 gf180mcu_as_sc_mcu7t3v3__inv_2_1058/VSS VSS VSS
+ gf180mcu_as_sc_mcu7t3v3__inv_2_962/A gf180mcu_as_sc_mcu7t3v3__inv_2_1020/VNW VSUBS
+ gf180mcu_as_sc_mcu7t3v3__inv_2
Xgf180mcu_as_sc_mcu7t3v3__inv_2_1596 VSS gf180mcu_as_sc_mcu7t3v3__inv_2_1598/VDD VSS
+ VSS gf180mcu_as_sc_mcu7t3v3__inv_2_1597/VNW VSUBS gf180mcu_as_sc_mcu7t3v3__inv_2
Xgf180mcu_as_sc_mcu7t3v3__inv_2_1563 gf180mcu_as_sc_mcu7t3v3__inv_2_1598/VDD gf180mcu_as_sc_mcu7t3v3__inv_2_1598/VSS
+ gf180mcu_as_sc_mcu7t3v3__inv_2_1563/Y VSS gf180mcu_as_sc_mcu7t3v3__inv_2_1598/VNW
+ VSUBS gf180mcu_as_sc_mcu7t3v3__inv_2
Xgf180mcu_as_sc_mcu7t3v3__inv_2_1574 VSS VSS VSS VSS gf180mcu_as_sc_mcu7t3v3__inv_2_1576/VNW
+ VSUBS gf180mcu_as_sc_mcu7t3v3__inv_2
Xgf180mcu_as_sc_mcu7t3v3__inv_2_1585 VSS VSS VSS VSS gf180mcu_as_sc_mcu7t3v3__inv_2_1585/VNW
+ VSUBS gf180mcu_as_sc_mcu7t3v3__inv_2
Xgf180mcu_as_sc_mcu7t3v3__inv_2_1552 gf180mcu_as_sc_mcu7t3v3__inv_2_1553/VDD gf180mcu_as_sc_mcu7t3v3__inv_2_1556/VDD
+ gf180mcu_as_sc_mcu7t3v3__inv_2_1552/Y VSS gf180mcu_as_sc_mcu7t3v3__inv_2_1553/VNW
+ VSUBS gf180mcu_as_sc_mcu7t3v3__inv_2
Xgf180mcu_as_sc_mcu7t3v3__inv_2_1530 gf180mcu_as_sc_mcu7t3v3__inv_2_1532/VDD VSS VSS
+ VSS gf180mcu_as_sc_mcu7t3v3__inv_2_1532/VNW VSUBS gf180mcu_as_sc_mcu7t3v3__inv_2
Xgf180mcu_as_sc_mcu7t3v3__inv_2_1541 gf180mcu_as_sc_mcu7t3v3__inv_2_1541/VDD gf180mcu_as_sc_mcu7t3v3__inv_2_1697/VDD
+ gf180mcu_as_sc_mcu7t3v3__inv_2_1541/Y VSS gf180mcu_as_sc_mcu7t3v3__inv_2_1541/VNW
+ VSUBS gf180mcu_as_sc_mcu7t3v3__inv_2
Xgf180mcu_as_sc_mcu7t3v3__nand3_2_7 gf180mcu_as_sc_mcu7t3v3__nand3_2_9/VDD gf180mcu_as_sc_mcu7t3v3__nor2_2_4/VSS
+ VSS VSS VSS VSS gf180mcu_as_sc_mcu7t3v3__nand3_2_9/VNW VSUBS gf180mcu_as_sc_mcu7t3v3__nand3_2
Xgf180mcu_as_sc_mcu7t3v3__nand4_2_335 gf180mcu_as_sc_mcu7t3v3__inv_2_1129/VDD gf180mcu_as_sc_mcu7t3v3__inv_2_1133/VDD
+ VSS VSS VSS VSS VSS gf180mcu_as_sc_mcu7t3v3__inv_2_1129/VNW VSUBS gf180mcu_as_sc_mcu7t3v3__nand4_2
Xgf180mcu_as_sc_mcu7t3v3__nand4_2_368 VSS VSS VSS VSS VSS VSS gf180mcu_as_sc_mcu7t3v3__nand4_2_368/Y
+ gf180mcu_as_sc_mcu7t3v3__inv_2_1268/VNW VSUBS gf180mcu_as_sc_mcu7t3v3__nand4_2
Xgf180mcu_as_sc_mcu7t3v3__nand4_2_346 VSS VSS VSS VSS VSS VSS VSS gf180mcu_as_sc_mcu7t3v3__inv_2_1130/VNW
+ VSUBS gf180mcu_as_sc_mcu7t3v3__nand4_2
Xgf180mcu_as_sc_mcu7t3v3__nand4_2_324 gf180mcu_as_sc_mcu7t3v3__inv_2_1091/VDD VSS
+ VSS VSS VSS VSS VSS gf180mcu_as_sc_mcu7t3v3__inv_2_1091/VNW VSUBS gf180mcu_as_sc_mcu7t3v3__nand4_2
Xgf180mcu_as_sc_mcu7t3v3__nand4_2_357 VSS VSS VSS VSS VSS VSS gf180mcu_as_sc_mcu7t3v3__nand4_2_357/Y
+ gf180mcu_as_sc_mcu7t3v3__inv_2_1287/VNW VSUBS gf180mcu_as_sc_mcu7t3v3__nand4_2
Xgf180mcu_as_sc_mcu7t3v3__nand4_2_313 VSS gf180mcu_as_sc_mcu7t3v3__inv_2_1036/VDD
+ VSS VSS VSS VSS VSS gf180mcu_as_sc_mcu7t3v3__inv_2_1032/VNW VSUBS gf180mcu_as_sc_mcu7t3v3__nand4_2
Xgf180mcu_as_sc_mcu7t3v3__nand4_2_379 VSS VSS VSS VSS VSS VSS VSS gf180mcu_as_sc_mcu7t3v3__inv_2_1307/VNW
+ VSUBS gf180mcu_as_sc_mcu7t3v3__nand4_2
Xgf180mcu_as_sc_mcu7t3v3__nand4_2_302 VSS gf180mcu_as_sc_mcu7t3v3__inv_2_989/VDD VSS
+ VSS VSS VSS VSS gf180mcu_as_sc_mcu7t3v3__inv_2_969/VNW VSUBS gf180mcu_as_sc_mcu7t3v3__nand4_2
Xu_t029_012 u_t029_012/c0_w0_bl u_t029_012/c0_w0_br u_t029_012/c0_w1_bl u_t029_012/c0_w1_br
+ u_t029_012/c0_r0_rbl u_t029_012/c0_r1_rbl u_t029_012/c1_w0_bl u_t029_012/c1_w0_br
+ u_t029_012/c1_w1_bl u_t029_012/c1_w1_br u_t029_012/c1_r0_rbl u_t029_012/c1_r1_rbl
+ u_t029_012/c2_w0_bl u_t029_012/c2_w0_br u_t029_012/c2_w1_bl u_t029_012/c2_w1_br
+ u_t029_012/c2_r0_rbl u_t029_012/c2_r1_rbl u_t029_012/c3_w0_bl u_t029_012/c3_w0_br
+ u_t029_012/c3_w1_bl u_t029_012/c3_w1_br u_t029_012/c3_r0_rbl u_t029_012/c3_r1_rbl
+ u_t029_012/r0_w0_wl u_t029_012/r0_w1_wl u_t029_012/r0_r0_rwl u_t029_012/r0_r1_rwl
+ u_t029_012/r1_w0_wl u_t029_012/r1_w1_wl u_t029_012/r1_r0_rwl u_t029_012/r1_r1_rwl
+ u_t029_012/r2_w0_wl u_t029_012/r2_w1_wl u_t029_012/r2_r0_rwl u_t029_012/r2_r1_rwl
+ u_t029_012/r3_w0_wl u_t029_012/r3_w1_wl u_t029_012/r3_r0_rwl u_t029_012/r3_r1_rwl
+ u_t029_012/VDD VSS u_t029_012/m2_717_1265# u_t029_012/m2_603_2031# u_t029_012/m2_1290_336#
+ u_t029_012/m2_2000_2037# u_t029_012/m2_791_2909# u_t029_012/m2_7_2126# u_t029_012/m2_2154_2081#
+ u_t029_012/m2_1795_2037# u_t029_012/m2_871_303# u_t029_012/m2_431_438# u_t029_012/m2_1290_2898#
+ u_t029_012/m2_1714_1210# u_t029_012/m2_431_1982# u_t029_012/m2_512_1265# u_t029_012/m2_2573_2126#
+ u_t029_012/m2_603_1259# u_t029_012/m2_2074_2909# u_t029_012/m2_7_336# u_t029_012/m2_717_2037#
+ u_t029_012/m2_1886_2031# u_t029_012/m2_2573_336# u_t029_012/m2_7_2898# u_t029_012/m2_2000_1265#
+ u_t029_012/m2_512_2037# u_t029_012/m2_1795_1265# u_t029_012/m2_1714_1982# u_t029_012/m2_1886_1259#
+ u_t029_012/m2_1290_2126# u_t029_012/m2_1714_438# u_t029_012/m2_431_1210# u_t029_012/m2_2573_2898#
+ u_t029_012/m2_2154_303# u_t029_012/m2_871_2081# VSUBS detronyx_12t_2w2r_rc4_4x4_routed_5layer_direct
Xu_t029_001 u_t029_001/c0_w0_bl u_t029_001/c0_w0_br u_t029_001/c0_w1_bl u_t029_001/c0_w1_br
+ u_t029_001/c0_r0_rbl u_t029_001/c0_r1_rbl u_t029_001/c1_w0_bl u_t029_001/c1_w0_br
+ u_t029_001/c1_w1_bl u_t029_001/c1_w1_br u_t029_001/c1_r0_rbl u_t029_001/c1_r1_rbl
+ u_t029_001/c2_w0_bl u_t029_001/c2_w0_br u_t029_001/c2_w1_bl u_t029_001/c2_w1_br
+ u_t029_001/c2_r0_rbl u_t029_001/c2_r1_rbl u_t029_001/c3_w0_bl u_t029_001/c3_w0_br
+ u_t029_001/c3_w1_bl u_t029_001/c3_w1_br u_t029_001/c3_r0_rbl u_t029_001/c3_r1_rbl
+ u_t029_001/r0_w0_wl u_t029_001/r0_w1_wl u_t029_001/r0_r0_rwl u_t029_001/r0_r1_rwl
+ u_t029_001/r1_w0_wl u_t029_001/r1_w1_wl u_t029_001/r1_r0_rwl u_t029_001/r1_r1_rwl
+ u_t029_001/r2_w0_wl u_t029_001/r2_w1_wl u_t029_001/r2_r0_rwl u_t029_001/r2_r1_rwl
+ u_t029_001/r3_w0_wl u_t029_001/r3_w1_wl u_t029_001/r3_r0_rwl u_t029_001/r3_r1_rwl
+ VSS VSS u_t029_001/m2_717_1265# u_t029_001/m2_603_2031# u_t029_001/m2_1290_336#
+ u_t029_001/m2_2000_2037# u_t029_001/m2_791_2909# u_t029_001/m2_7_2126# u_t029_001/m2_2154_2081#
+ u_t029_001/m2_1795_2037# u_t029_001/m2_871_303# u_t029_001/m2_431_438# u_t029_001/m2_1290_2898#
+ u_t029_001/m2_1714_1210# u_t029_001/m2_431_1982# u_t029_001/m2_512_1265# u_t029_001/m2_2573_2126#
+ u_t029_001/m2_603_1259# u_t029_001/m2_2074_2909# u_t029_001/m2_7_336# u_t029_001/m2_717_2037#
+ u_t029_001/m2_1886_2031# u_t029_001/m2_2573_336# u_t029_001/m2_7_2898# u_t029_001/m2_2000_1265#
+ u_t029_001/m2_512_2037# u_t029_001/m2_1795_1265# u_t029_001/m2_1714_1982# u_t029_001/m2_1886_1259#
+ u_t029_001/m2_1290_2126# u_t029_001/m2_1714_438# u_t029_001/m2_431_1210# u_t029_001/m2_2573_2898#
+ u_t029_001/m2_2154_303# u_t029_001/m2_871_2081# VSUBS detronyx_12t_2w2r_rc4_4x4_routed_5layer_direct
Xgf180mcu_as_sc_mcu7t3v3__inv_2_1360 VSS gf180mcu_as_sc_mcu7t3v3__inv_2_1366/VDD VSS
+ gf180mcu_as_sc_mcu7t3v3__inv_2_1694/Y gf180mcu_as_sc_mcu7t3v3__inv_2_1362/VNW VSUBS
+ gf180mcu_as_sc_mcu7t3v3__inv_2
Xgf180mcu_as_sc_mcu7t3v3__inv_2_1382 gf180mcu_as_sc_mcu7t3v3__inv_2_1382/VDD VSS gf180mcu_as_sc_mcu7t3v3__inv_2_1382/Y
+ VSS gf180mcu_as_sc_mcu7t3v3__inv_2_1382/VNW VSUBS gf180mcu_as_sc_mcu7t3v3__inv_2
Xgf180mcu_as_sc_mcu7t3v3__inv_2_1393 gf180mcu_as_sc_mcu7t3v3__inv_2_1394/VDD VSS gf180mcu_as_sc_mcu7t3v3__inv_2_1393/Y
+ gf180mcu_as_sc_mcu7t3v3__inv_2_1394/Y gf180mcu_as_sc_mcu7t3v3__inv_2_1394/VNW VSUBS
+ gf180mcu_as_sc_mcu7t3v3__inv_2
Xgf180mcu_as_sc_mcu7t3v3__inv_2_1371 VSS gf180mcu_as_sc_mcu7t3v3__inv_2_1391/VDD gf180mcu_as_sc_mcu7t3v3__inv_2_1409/A
+ gf180mcu_as_sc_mcu7t3v3__inv_2_1409/A gf180mcu_as_sc_mcu7t3v3__inv_2_1375/VNW VSUBS
+ gf180mcu_as_sc_mcu7t3v3__inv_2
Xgf180mcu_as_sc_mcu7t3v3__inv_2_855 VSS VSS VSS VSS gf180mcu_as_sc_mcu7t3v3__inv_2_857/VNW
+ VSUBS gf180mcu_as_sc_mcu7t3v3__inv_2
Xgf180mcu_as_sc_mcu7t3v3__inv_2_822 VSS VSS VSS VSS gf180mcu_as_sc_mcu7t3v3__inv_2_822/VNW
+ VSUBS gf180mcu_as_sc_mcu7t3v3__inv_2
Xgf180mcu_as_sc_mcu7t3v3__inv_2_833 VSS VSS VSS VSS gf180mcu_as_sc_mcu7t3v3__inv_2_833/VNW
+ VSUBS gf180mcu_as_sc_mcu7t3v3__inv_2
Xgf180mcu_as_sc_mcu7t3v3__inv_2_800 VSS VSS VSS VSS gf180mcu_as_sc_mcu7t3v3__inv_2_847/VNW
+ VSUBS gf180mcu_as_sc_mcu7t3v3__inv_2
Xgf180mcu_as_sc_mcu7t3v3__inv_2_844 VSS VSS VSS VSS gf180mcu_as_sc_mcu7t3v3__inv_2_844/VNW
+ VSUBS gf180mcu_as_sc_mcu7t3v3__inv_2
Xgf180mcu_as_sc_mcu7t3v3__inv_2_811 VSS VSS VSS VSS gf180mcu_as_sc_mcu7t3v3__inv_2_840/VNW
+ VSUBS gf180mcu_as_sc_mcu7t3v3__inv_2
Xgf180mcu_as_sc_mcu7t3v3__inv_2_866 VSS VSS VSS VSS gf180mcu_as_sc_mcu7t3v3__inv_2_939/VNW
+ VSUBS gf180mcu_as_sc_mcu7t3v3__inv_2
Xgf180mcu_as_sc_mcu7t3v3__inv_2_877 VSS VSS VSS VSS gf180mcu_as_sc_mcu7t3v3__inv_2_943/VNW
+ VSUBS gf180mcu_as_sc_mcu7t3v3__inv_2
Xgf180mcu_as_sc_mcu7t3v3__inv_2_888 VSS VSS gf180mcu_as_sc_mcu7t3v3__inv_2_888/Y VSS
+ gf180mcu_as_sc_mcu7t3v3__inv_2_943/VNW VSUBS gf180mcu_as_sc_mcu7t3v3__inv_2
Xgf180mcu_as_sc_mcu7t3v3__inv_2_899 VSS VSS gf180mcu_as_sc_mcu7t3v3__inv_2_899/Y VSS
+ gf180mcu_as_sc_mcu7t3v3__inv_2_927/VNW VSUBS gf180mcu_as_sc_mcu7t3v3__inv_2
Xgf180mcu_as_sc_mcu7t3v3__nand4_2_110 gf180mcu_as_sc_mcu7t3v3__inv_2_365/VSS gf180mcu_as_sc_mcu7t3v3__inv_2_307/VDD
+ VSS VSS VSS VSS VSS gf180mcu_as_sc_mcu7t3v3__inv_2_297/VNW VSUBS gf180mcu_as_sc_mcu7t3v3__nand4_2
Xu_t026_015 u_t026_015/c0_w0_bl u_t026_015/c0_w0_br u_t026_015/c0_w1_bl u_t026_015/c0_w1_br
+ u_t026_015/c0_r0_rbl u_t026_015/c0_r1_rbl u_t026_015/c1_w0_bl u_t026_015/c1_w0_br
+ u_t026_015/c1_w1_bl u_t026_015/c1_w1_br u_t026_015/c1_r0_rbl u_t026_015/c1_r1_rbl
+ u_t026_015/c2_w0_bl u_t026_015/c2_w0_br u_t026_015/c2_w1_bl u_t026_015/c2_w1_br
+ u_t026_015/c2_r0_rbl u_t026_015/c2_r1_rbl u_t026_015/c3_w0_bl u_t026_015/c3_w0_br
+ u_t026_015/c3_w1_bl u_t026_015/c3_w1_br u_t026_015/c3_r0_rbl u_t026_015/c3_r1_rbl
+ u_t026_015/r0_w0_wl u_t026_015/r0_w1_wl u_t026_015/r0_r0_rwl u_t026_015/r0_r1_rwl
+ u_t026_015/r1_w0_wl u_t026_015/r1_w1_wl u_t026_015/r1_r0_rwl u_t026_015/r1_r1_rwl
+ u_t026_015/r2_w0_wl u_t026_015/r2_w1_wl u_t026_015/r2_r0_rwl u_t026_015/r2_r1_rwl
+ u_t026_015/r3_w0_wl u_t026_015/r3_w1_wl u_t026_015/r3_r0_rwl u_t026_015/r3_r1_rwl
+ VSS VSS u_t026_015/m2_717_1265# u_t026_015/m2_603_2031# u_t026_015/m2_1290_336#
+ u_t026_015/m2_2000_2037# u_t026_015/m2_791_2909# u_t026_015/m2_7_2126# u_t026_015/m2_2154_2081#
+ u_t026_015/m2_1795_2037# u_t026_015/m2_871_303# u_t026_015/m2_431_438# u_t026_015/m2_1290_2898#
+ u_t026_015/m2_1714_1210# u_t026_015/m2_431_1982# u_t026_015/m2_512_1265# u_t026_015/m2_2573_2126#
+ u_t026_015/m2_603_1259# u_t026_015/m2_2074_2909# u_t026_015/m2_7_336# u_t026_015/m2_717_2037#
+ u_t026_015/m2_1886_2031# u_t026_015/m2_2573_336# u_t026_015/m2_7_2898# u_t026_015/m2_2000_1265#
+ u_t026_015/m2_512_2037# u_t026_015/m2_1795_1265# u_t026_015/m2_1714_1982# u_t026_015/m2_1886_1259#
+ u_t026_015/m2_1290_2126# u_t026_015/m2_1714_438# u_t026_015/m2_431_1210# u_t026_015/m2_2573_2898#
+ u_t026_015/m2_2154_303# u_t026_015/m2_871_2081# VSUBS detronyx_12t_2w2r_rc4_4x4_routed_5layer_direct
Xu_t026_004 u_t026_004/c0_w0_bl u_t026_004/c0_w0_br u_t026_004/c0_w1_bl u_t026_004/c0_w1_br
+ u_t026_004/c0_r0_rbl u_t026_004/c0_r1_rbl u_t026_004/c1_w0_bl u_t026_004/c1_w0_br
+ u_t026_004/c1_w1_bl u_t026_004/c1_w1_br u_t026_004/c1_r0_rbl u_t026_004/c1_r1_rbl
+ u_t026_004/c2_w0_bl u_t026_004/c2_w0_br u_t026_004/c2_w1_bl u_t026_004/c2_w1_br
+ u_t026_004/c2_r0_rbl u_t026_004/c2_r1_rbl u_t026_004/c3_w0_bl u_t026_004/c3_w0_br
+ u_t026_004/c3_w1_bl u_t026_004/c3_w1_br u_t026_004/c3_r0_rbl u_t026_004/c3_r1_rbl
+ u_t026_004/r0_w0_wl u_t026_004/r0_w1_wl u_t026_004/r0_r0_rwl u_t026_004/r0_r1_rwl
+ u_t026_004/r1_w0_wl u_t026_004/r1_w1_wl u_t026_004/r1_r0_rwl u_t026_004/r1_r1_rwl
+ u_t026_004/r2_w0_wl u_t026_004/r2_w1_wl u_t026_004/r2_r0_rwl u_t026_004/r2_r1_rwl
+ u_t026_004/r3_w0_wl u_t026_004/r3_w1_wl u_t026_004/r3_r0_rwl u_t026_004/r3_r1_rwl
+ u_t026_004/VDD VSS u_t026_004/m2_717_1265# u_t026_004/m2_603_2031# u_t026_004/m2_1290_336#
+ u_t026_004/m2_2000_2037# u_t026_004/m2_791_2909# u_t026_004/m2_7_2126# u_t026_004/m2_2154_2081#
+ u_t026_004/m2_1795_2037# u_t026_004/m2_871_303# u_t026_004/m2_431_438# u_t026_004/m2_1290_2898#
+ u_t026_004/m2_1714_1210# u_t026_004/m2_431_1982# u_t026_004/m2_512_1265# u_t026_004/m2_2573_2126#
+ u_t026_004/m2_603_1259# u_t026_004/m2_2074_2909# u_t026_004/m2_7_336# u_t026_004/m2_717_2037#
+ u_t026_004/m2_1886_2031# u_t026_004/m2_2573_336# u_t026_004/m2_7_2898# u_t026_004/m2_2000_1265#
+ u_t026_004/m2_512_2037# u_t026_004/m2_1795_1265# u_t026_004/m2_1714_1982# u_t026_004/m2_1886_1259#
+ u_t026_004/m2_1290_2126# u_t026_004/m2_1714_438# u_t026_004/m2_431_1210# u_t026_004/m2_2573_2898#
+ u_t026_004/m2_2154_303# u_t026_004/m2_871_2081# VSUBS detronyx_12t_2w2r_rc4_4x4_routed_5layer_direct
Xgf180mcu_as_sc_mcu7t3v3__nand4_2_176 gf180mcu_as_sc_mcu7t3v3__inv_2_637/VDD VSS VSS
+ VSS VSS VSS VSS gf180mcu_as_sc_mcu7t3v3__inv_2_637/VNW VSUBS gf180mcu_as_sc_mcu7t3v3__nand4_2
Xgf180mcu_as_sc_mcu7t3v3__nand4_2_154 gf180mcu_as_sc_mcu7t3v3__inv_2_588/VDD gf180mcu_as_sc_mcu7t3v3__inv_2_590/VSS
+ VSS VSS VSS VSS VSS gf180mcu_as_sc_mcu7t3v3__inv_2_588/VNW VSUBS gf180mcu_as_sc_mcu7t3v3__nand4_2
Xgf180mcu_as_sc_mcu7t3v3__nand4_2_132 VSS VSS VSS VSS VSS VSS gf180mcu_as_sc_mcu7t3v3__nand4_2_132/Y
+ gf180mcu_as_sc_mcu7t3v3__inv_2_549/VNW VSUBS gf180mcu_as_sc_mcu7t3v3__nand4_2
Xgf180mcu_as_sc_mcu7t3v3__nand4_2_165 gf180mcu_as_sc_mcu7t3v3__inv_2_632/VDD gf180mcu_as_sc_mcu7t3v3__inv_2_632/VDD
+ VSS VSS VSS VSS VSS gf180mcu_as_sc_mcu7t3v3__inv_2_628/VNW VSUBS gf180mcu_as_sc_mcu7t3v3__nand4_2
Xgf180mcu_as_sc_mcu7t3v3__nand4_2_143 VSS VSS VSS VSS VSS VSS VSS gf180mcu_as_sc_mcu7t3v3__inv_2_561/VNW
+ VSUBS gf180mcu_as_sc_mcu7t3v3__nand4_2
Xgf180mcu_as_sc_mcu7t3v3__nand4_2_121 VSS VSS VSS VSS VSS VSS VSS gf180mcu_as_sc_mcu7t3v3__inv_2_280/VNW
+ VSUBS gf180mcu_as_sc_mcu7t3v3__nand4_2
Xgf180mcu_as_sc_mcu7t3v3__nand4_2_198 gf180mcu_as_sc_mcu7t3v3__inv_2_746/VDD gf180mcu_as_sc_mcu7t3v3__inv_2_746/VSS
+ VSS VSS VSS VSS VSS gf180mcu_as_sc_mcu7t3v3__inv_2_746/VNW VSUBS gf180mcu_as_sc_mcu7t3v3__nand4_2
Xgf180mcu_as_sc_mcu7t3v3__nand4_2_187 VSS VSS VSS VSS VSS VSS VSS gf180mcu_as_sc_mcu7t3v3__inv_2_720/VNW
+ VSUBS gf180mcu_as_sc_mcu7t3v3__nand4_2
Xgf180mcu_as_sc_mcu7t3v3__nand4_2_60 gf180mcu_as_sc_mcu7t3v3__inv_2_260/VDD gf180mcu_as_sc_mcu7t3v3__inv_2_260/VSS
+ VSS VSS VSS VSS gf180mcu_as_sc_mcu7t3v3__nand4_2_60/Y gf180mcu_as_sc_mcu7t3v3__inv_2_260/VNW
+ VSUBS gf180mcu_as_sc_mcu7t3v3__nand4_2
Xgf180mcu_as_sc_mcu7t3v3__nand4_2_71 VSS gf180mcu_as_sc_mcu7t3v3__inv_2_320/VDD VSS
+ VSS VSS VSS VSS gf180mcu_as_sc_mcu7t3v3__inv_2_317/VNW VSUBS gf180mcu_as_sc_mcu7t3v3__nand4_2
Xgf180mcu_as_sc_mcu7t3v3__nand4_2_93 VSS gf180mcu_as_sc_mcu7t3v3__inv_2_0/VSS VSS
+ VSS VSS VSS VSS gf180mcu_as_sc_mcu7t3v3__inv_2_0/VNW VSUBS gf180mcu_as_sc_mcu7t3v3__nand4_2
Xgf180mcu_as_sc_mcu7t3v3__nand4_2_82 gf180mcu_as_sc_mcu7t3v3__inv_2_61/VDD gf180mcu_as_sc_mcu7t3v3__inv_2_69/VDD
+ VSS VSS VSS VSS VSS gf180mcu_as_sc_mcu7t3v3__inv_2_61/VNW VSUBS gf180mcu_as_sc_mcu7t3v3__nand4_2
Xu_t017_015 u_t017_015/c0_w0_bl u_t017_015/c0_w0_br u_t017_015/c0_w1_bl u_t017_015/c0_w1_br
+ u_t017_015/c0_r0_rbl u_t017_015/c0_r1_rbl u_t017_015/c1_w0_bl u_t017_015/c1_w0_br
+ u_t017_015/c1_w1_bl u_t017_015/c1_w1_br u_t017_015/c1_r0_rbl u_t017_015/c1_r1_rbl
+ u_t017_015/c2_w0_bl u_t017_015/c2_w0_br u_t017_015/c2_w1_bl u_t017_015/c2_w1_br
+ u_t017_015/c2_r0_rbl u_t017_015/c2_r1_rbl u_t017_015/c3_w0_bl u_t017_015/c3_w0_br
+ u_t017_015/c3_w1_bl u_t017_015/c3_w1_br u_t017_015/c3_r0_rbl u_t017_015/c3_r1_rbl
+ u_t017_015/r0_w0_wl u_t017_015/r0_w1_wl u_t017_015/r0_r0_rwl u_t017_015/r0_r1_rwl
+ u_t017_015/r1_w0_wl u_t017_015/r1_w1_wl u_t017_015/r1_r0_rwl u_t017_015/r1_r1_rwl
+ u_t017_015/r2_w0_wl u_t017_015/r2_w1_wl u_t017_015/r2_r0_rwl u_t017_015/r2_r1_rwl
+ u_t017_015/r3_w0_wl u_t017_015/r3_w1_wl u_t017_015/r3_r0_rwl u_t017_015/r3_r1_rwl
+ VSS VSS u_t017_015/m2_717_1265# u_t017_015/m2_603_2031# u_t017_015/m2_1290_336#
+ u_t017_015/m2_2000_2037# u_t017_015/m2_791_2909# u_t017_015/m2_7_2126# u_t017_015/m2_2154_2081#
+ u_t017_015/m2_1795_2037# u_t017_015/m2_871_303# u_t017_015/m2_431_438# u_t017_015/m2_1290_2898#
+ u_t017_015/m2_1714_1210# u_t017_015/m2_431_1982# u_t017_015/m2_512_1265# u_t017_015/m2_2573_2126#
+ u_t017_015/m2_603_1259# u_t017_015/m2_2074_2909# u_t017_015/m2_7_336# u_t017_015/m2_717_2037#
+ u_t017_015/m2_1886_2031# u_t017_015/m2_2573_336# u_t017_015/m2_7_2898# u_t017_015/m2_2000_1265#
+ u_t017_015/m2_512_2037# u_t017_015/m2_1795_1265# u_t017_015/m2_1714_1982# u_t017_015/m2_1886_1259#
+ u_t017_015/m2_1290_2126# u_t017_015/m2_1714_438# u_t017_015/m2_431_1210# u_t017_015/m2_2573_2898#
+ u_t017_015/m2_2154_303# u_t017_015/m2_871_2081# VSUBS detronyx_12t_2w2r_rc4_4x4_routed_5layer_direct
Xu_t017_004 u_t017_004/c0_w0_bl u_t017_004/c0_w0_br u_t017_004/c0_w1_bl u_t017_004/c0_w1_br
+ u_t017_004/c0_r0_rbl u_t017_004/c0_r1_rbl u_t017_004/c1_w0_bl u_t017_004/c1_w0_br
+ u_t017_004/c1_w1_bl u_t017_004/c1_w1_br u_t017_004/c1_r0_rbl u_t017_004/c1_r1_rbl
+ u_t017_004/c2_w0_bl u_t017_004/c2_w0_br u_t017_004/c2_w1_bl u_t017_004/c2_w1_br
+ u_t017_004/c2_r0_rbl u_t017_004/c2_r1_rbl u_t017_004/c3_w0_bl u_t017_004/c3_w0_br
+ u_t017_004/c3_w1_bl u_t017_004/c3_w1_br u_t017_004/c3_r0_rbl u_t017_004/c3_r1_rbl
+ u_t017_004/r0_w0_wl u_t017_004/r0_w1_wl u_t017_004/r0_r0_rwl u_t017_004/r0_r1_rwl
+ u_t017_004/r1_w0_wl u_t017_004/r1_w1_wl u_t017_004/r1_r0_rwl u_t017_004/r1_r1_rwl
+ u_t017_004/r2_w0_wl u_t017_004/r2_w1_wl u_t017_004/r2_r0_rwl u_t017_004/r2_r1_rwl
+ u_t017_004/r3_w0_wl u_t017_004/r3_w1_wl u_t017_004/r3_r0_rwl u_t017_004/r3_r1_rwl
+ u_t017_004/VDD VSS u_t017_004/m2_717_1265# u_t017_004/m2_603_2031# u_t017_004/m2_1290_336#
+ u_t017_004/m2_2000_2037# u_t017_004/m2_791_2909# u_t017_004/m2_7_2126# u_t017_004/m2_2154_2081#
+ u_t017_004/m2_1795_2037# u_t017_004/m2_871_303# u_t017_004/m2_431_438# u_t017_004/m2_1290_2898#
+ u_t017_004/m2_1714_1210# u_t017_004/m2_431_1982# u_t017_004/m2_512_1265# u_t017_004/m2_2573_2126#
+ u_t017_004/m2_603_1259# u_t017_004/m2_2074_2909# u_t017_004/m2_7_336# u_t017_004/m2_717_2037#
+ u_t017_004/m2_1886_2031# u_t017_004/m2_2573_336# u_t017_004/m2_7_2898# u_t017_004/m2_2000_1265#
+ u_t017_004/m2_512_2037# u_t017_004/m2_1795_1265# u_t017_004/m2_1714_1982# u_t017_004/m2_1886_1259#
+ u_t017_004/m2_1290_2126# u_t017_004/m2_1714_438# u_t017_004/m2_431_1210# u_t017_004/m2_2573_2898#
+ u_t017_004/m2_2154_303# u_t017_004/m2_871_2081# VSUBS detronyx_12t_2w2r_rc4_4x4_routed_5layer_direct
Xgf180mcu_as_sc_mcu7t3v3__inv_2_107 gf180mcu_as_sc_mcu7t3v3__nand4_2_9/VDD VSS gf180mcu_as_sc_mcu7t3v3__inv_2_107/Y
+ VSS gf180mcu_as_sc_mcu7t3v3__nand4_2_9/VNW VSUBS gf180mcu_as_sc_mcu7t3v3__inv_2
Xgf180mcu_as_sc_mcu7t3v3__inv_2_129 gf180mcu_as_sc_mcu7t3v3__inv_2_131/VDD gf180mcu_as_sc_mcu7t3v3__inv_2_134/VDD
+ gf180mcu_as_sc_mcu7t3v3__inv_2_129/Y VSS gf180mcu_as_sc_mcu7t3v3__inv_2_131/VNW
+ VSUBS gf180mcu_as_sc_mcu7t3v3__inv_2
Xgf180mcu_as_sc_mcu7t3v3__inv_2_118 gf180mcu_as_sc_mcu7t3v3__inv_2_122/VDD gf180mcu_as_sc_mcu7t3v3__inv_2_122/VDD
+ VSS VSS gf180mcu_as_sc_mcu7t3v3__inv_2_119/VNW VSUBS gf180mcu_as_sc_mcu7t3v3__inv_2
Xgf180mcu_as_sc_mcu7t3v3__inv_2_1190 VSS VSS gf180mcu_as_sc_mcu7t3v3__inv_2_1190/Y
+ VSS gf180mcu_as_sc_mcu7t3v3__inv_2_1268/VNW VSUBS gf180mcu_as_sc_mcu7t3v3__inv_2
Xu_t008_015 u_t008_015/c0_w0_bl u_t008_015/c0_w0_br u_t008_015/c0_w1_bl u_t008_015/c0_w1_br
+ u_t008_015/c0_r0_rbl u_t008_015/c0_r1_rbl u_t008_015/c1_w0_bl u_t008_015/c1_w0_br
+ u_t008_015/c1_w1_bl u_t008_015/c1_w1_br u_t008_015/c1_r0_rbl u_t008_015/c1_r1_rbl
+ u_t008_015/c2_w0_bl u_t008_015/c2_w0_br u_t008_015/c2_w1_bl u_t008_015/c2_w1_br
+ u_t008_015/c2_r0_rbl u_t008_015/c2_r1_rbl u_t008_015/c3_w0_bl u_t008_015/c3_w0_br
+ u_t008_015/c3_w1_bl u_t008_015/c3_w1_br u_t008_015/c3_r0_rbl u_t008_015/c3_r1_rbl
+ u_t008_015/r0_w0_wl u_t008_015/r0_w1_wl u_t008_015/r0_r0_rwl u_t008_015/r0_r1_rwl
+ u_t008_015/r1_w0_wl u_t008_015/r1_w1_wl u_t008_015/r1_r0_rwl u_t008_015/r1_r1_rwl
+ u_t008_015/r2_w0_wl u_t008_015/r2_w1_wl u_t008_015/r2_r0_rwl u_t008_015/r2_r1_rwl
+ u_t008_015/r3_w0_wl u_t008_015/r3_w1_wl u_t008_015/r3_r0_rwl u_t008_015/r3_r1_rwl
+ VSS VSS u_t008_015/m2_717_1265# u_t008_015/m2_603_2031# u_t008_015/m2_1290_336#
+ u_t008_015/m2_2000_2037# u_t008_015/m2_791_2909# u_t008_015/m2_7_2126# u_t008_015/m2_2154_2081#
+ u_t008_015/m2_1795_2037# u_t008_015/m2_871_303# u_t008_015/m2_431_438# u_t008_015/m2_1290_2898#
+ u_t008_015/m2_1714_1210# u_t008_015/m2_431_1982# u_t008_015/m2_512_1265# u_t008_015/m2_2573_2126#
+ u_t008_015/m2_603_1259# u_t008_015/m2_2074_2909# u_t008_015/m2_7_336# u_t008_015/m2_717_2037#
+ u_t008_015/m2_1886_2031# u_t008_015/m2_2573_336# u_t008_015/m2_7_2898# u_t008_015/m2_2000_1265#
+ u_t008_015/m2_512_2037# u_t008_015/m2_1795_1265# u_t008_015/m2_1714_1982# u_t008_015/m2_1886_1259#
+ u_t008_015/m2_1290_2126# u_t008_015/m2_1714_438# u_t008_015/m2_431_1210# u_t008_015/m2_2573_2898#
+ u_t008_015/m2_2154_303# u_t008_015/m2_871_2081# VSUBS detronyx_12t_2w2r_rc4_4x4_routed_5layer_direct
Xu_t008_004 u_t008_004/c0_w0_bl u_t008_004/c0_w0_br u_t008_004/c0_w1_bl u_t008_004/c0_w1_br
+ u_t008_004/c0_r0_rbl u_t008_004/c0_r1_rbl u_t008_004/c1_w0_bl u_t008_004/c1_w0_br
+ u_t008_004/c1_w1_bl u_t008_004/c1_w1_br u_t008_004/c1_r0_rbl u_t008_004/c1_r1_rbl
+ u_t008_004/c2_w0_bl u_t008_004/c2_w0_br u_t008_004/c2_w1_bl u_t008_004/c2_w1_br
+ u_t008_004/c2_r0_rbl u_t008_004/c2_r1_rbl u_t008_004/c3_w0_bl u_t008_004/c3_w0_br
+ u_t008_004/c3_w1_bl u_t008_004/c3_w1_br u_t008_004/c3_r0_rbl u_t008_004/c3_r1_rbl
+ u_t008_004/r0_w0_wl u_t008_004/r0_w1_wl u_t008_004/r0_r0_rwl u_t008_004/r0_r1_rwl
+ u_t008_004/r1_w0_wl u_t008_004/r1_w1_wl u_t008_004/r1_r0_rwl u_t008_004/r1_r1_rwl
+ u_t008_004/r2_w0_wl u_t008_004/r2_w1_wl u_t008_004/r2_r0_rwl u_t008_004/r2_r1_rwl
+ u_t008_004/r3_w0_wl u_t008_004/r3_w1_wl u_t008_004/r3_r0_rwl u_t008_004/r3_r1_rwl
+ u_t008_004/VDD VSS u_t008_004/m2_717_1265# u_t008_004/m2_603_2031# u_t008_004/m2_1290_336#
+ u_t008_004/m2_2000_2037# u_t008_004/m2_791_2909# u_t008_004/m2_7_2126# u_t008_004/m2_2154_2081#
+ u_t008_004/m2_1795_2037# u_t008_004/m2_871_303# u_t008_004/m2_431_438# u_t008_004/m2_1290_2898#
+ u_t008_004/m2_1714_1210# u_t008_004/m2_431_1982# u_t008_004/m2_512_1265# u_t008_004/m2_2573_2126#
+ u_t008_004/m2_603_1259# u_t008_004/m2_2074_2909# u_t008_004/m2_7_336# u_t008_004/m2_717_2037#
+ u_t008_004/m2_1886_2031# u_t008_004/m2_2573_336# u_t008_004/m2_7_2898# u_t008_004/m2_2000_1265#
+ u_t008_004/m2_512_2037# u_t008_004/m2_1795_1265# u_t008_004/m2_1714_1982# u_t008_004/m2_1886_1259#
+ u_t008_004/m2_1290_2126# u_t008_004/m2_1714_438# u_t008_004/m2_431_1210# u_t008_004/m2_2573_2898#
+ u_t008_004/m2_2154_303# u_t008_004/m2_871_2081# VSUBS detronyx_12t_2w2r_rc4_4x4_routed_5layer_direct
Xu_t023_007 u_t023_007/c0_w0_bl u_t023_007/c0_w0_br u_t023_007/c0_w1_bl u_t023_007/c0_w1_br
+ u_t023_007/c0_r0_rbl u_t023_007/c0_r1_rbl u_t023_007/c1_w0_bl u_t023_007/c1_w0_br
+ u_t023_007/c1_w1_bl u_t023_007/c1_w1_br u_t023_007/c1_r0_rbl u_t023_007/c1_r1_rbl
+ u_t023_007/c2_w0_bl u_t023_007/c2_w0_br u_t023_007/c2_w1_bl u_t023_007/c2_w1_br
+ u_t023_007/c2_r0_rbl u_t023_007/c2_r1_rbl u_t023_007/c3_w0_bl u_t023_007/c3_w0_br
+ u_t023_007/c3_w1_bl u_t023_007/c3_w1_br u_t023_007/c3_r0_rbl u_t023_007/c3_r1_rbl
+ u_t023_007/r0_w0_wl u_t023_007/r0_w1_wl u_t023_007/r0_r0_rwl u_t023_007/r0_r1_rwl
+ u_t023_007/r1_w0_wl u_t023_007/r1_w1_wl u_t023_007/r1_r0_rwl u_t023_007/r1_r1_rwl
+ u_t023_007/r2_w0_wl u_t023_007/r2_w1_wl u_t023_007/r2_r0_rwl u_t023_007/r2_r1_rwl
+ u_t023_007/r3_w0_wl u_t023_007/r3_w1_wl u_t023_007/r3_r0_rwl u_t023_007/r3_r1_rwl
+ VSS u_t023_009/VSS u_t023_007/m2_717_1265# u_t023_007/m2_603_2031# u_t023_007/m2_1290_336#
+ u_t023_007/m2_2000_2037# u_t023_007/m2_791_2909# u_t023_007/m2_7_2126# u_t023_007/m2_2154_2081#
+ u_t023_007/m2_1795_2037# u_t023_007/m2_871_303# u_t023_007/m2_431_438# u_t023_007/m2_1290_2898#
+ u_t023_007/m2_1714_1210# u_t023_007/m2_431_1982# u_t023_007/m2_512_1265# u_t023_007/m2_2573_2126#
+ u_t023_007/m2_603_1259# u_t023_007/m2_2074_2909# u_t023_007/m2_7_336# u_t023_007/m2_717_2037#
+ u_t023_007/m2_1886_2031# u_t023_007/m2_2573_336# u_t023_007/m2_7_2898# u_t023_007/m2_2000_1265#
+ u_t023_007/m2_512_2037# u_t023_007/m2_1795_1265# u_t023_007/m2_1714_1982# u_t023_007/m2_1886_1259#
+ u_t023_007/m2_1290_2126# u_t023_007/m2_1714_438# u_t023_007/m2_431_1210# u_t023_007/m2_2573_2898#
+ u_t023_007/m2_2154_303# u_t023_007/m2_871_2081# VSUBS detronyx_12t_2w2r_rc4_4x4_routed_5layer_direct
Xgf180mcu_as_sc_mcu7t3v3__inv_2_641 VSS VSS gf180mcu_as_sc_mcu7t3v3__inv_2_641/Y VSS
+ gf180mcu_as_sc_mcu7t3v3__inv_2_641/VNW VSUBS gf180mcu_as_sc_mcu7t3v3__inv_2
Xgf180mcu_as_sc_mcu7t3v3__inv_2_630 gf180mcu_as_sc_mcu7t3v3__inv_2_632/VDD gf180mcu_as_sc_mcu7t3v3__inv_2_636/VDD
+ gf180mcu_as_sc_mcu7t3v3__inv_2_630/Y gf180mcu_as_sc_mcu7t3v3__inv_2_634/A gf180mcu_as_sc_mcu7t3v3__inv_2_632/VNW
+ VSUBS gf180mcu_as_sc_mcu7t3v3__inv_2
Xgf180mcu_as_sc_mcu7t3v3__inv_2_652 VSS gf180mcu_as_sc_mcu7t3v3__inv_2_656/VDD gf180mcu_as_sc_mcu7t3v3__inv_2_652/Y
+ VSS gf180mcu_as_sc_mcu7t3v3__inv_2_652/VNW VSUBS gf180mcu_as_sc_mcu7t3v3__inv_2
Xgf180mcu_as_sc_mcu7t3v3__inv_2_663 gf180mcu_as_sc_mcu7t3v3__inv_2_664/VDD VSS gf180mcu_as_sc_mcu7t3v3__inv_2_663/Y
+ gf180mcu_as_sc_mcu7t3v3__inv_2_664/Y gf180mcu_as_sc_mcu7t3v3__inv_2_664/VNW VSUBS
+ gf180mcu_as_sc_mcu7t3v3__inv_2
Xgf180mcu_as_sc_mcu7t3v3__inv_2_674 gf180mcu_as_sc_mcu7t3v3__inv_2_674/VDD gf180mcu_as_sc_mcu7t3v3__inv_2_678/VDD
+ gf180mcu_as_sc_mcu7t3v3__inv_2_674/Y VSS gf180mcu_as_sc_mcu7t3v3__inv_2_674/VNW
+ VSUBS gf180mcu_as_sc_mcu7t3v3__inv_2
Xgf180mcu_as_sc_mcu7t3v3__inv_2_685 gf180mcu_as_sc_mcu7t3v3__inv_2_689/VDD gf180mcu_as_sc_mcu7t3v3__inv_2_689/VSS
+ gf180mcu_as_sc_mcu7t3v3__inv_2_685/Y gf180mcu_as_sc_mcu7t3v3__inv_2_689/Y gf180mcu_as_sc_mcu7t3v3__inv_2_689/VNW
+ VSUBS gf180mcu_as_sc_mcu7t3v3__inv_2
Xgf180mcu_as_sc_mcu7t3v3__inv_2_696 VSS VSS gf180mcu_as_sc_mcu7t3v3__inv_2_733/A VSS
+ gf180mcu_as_sc_mcu7t3v3__inv_2_733/VNW VSUBS gf180mcu_as_sc_mcu7t3v3__inv_2
Xu_t014_007 u_t014_007/c0_w0_bl u_t014_007/c0_w0_br u_t014_007/c0_w1_bl u_t014_007/c0_w1_br
+ u_t014_007/c0_r0_rbl u_t014_007/c0_r1_rbl u_t014_007/c1_w0_bl u_t014_007/c1_w0_br
+ u_t014_007/c1_w1_bl u_t014_007/c1_w1_br u_t014_007/c1_r0_rbl u_t014_007/c1_r1_rbl
+ u_t014_007/c2_w0_bl u_t014_007/c2_w0_br u_t014_007/c2_w1_bl u_t014_007/c2_w1_br
+ u_t014_007/c2_r0_rbl u_t014_007/c2_r1_rbl u_t014_007/c3_w0_bl u_t014_007/c3_w0_br
+ u_t014_007/c3_w1_bl u_t014_007/c3_w1_br u_t014_007/c3_r0_rbl u_t014_007/c3_r1_rbl
+ u_t014_007/r0_w0_wl u_t014_007/r0_w1_wl u_t014_007/r0_r0_rwl u_t014_007/r0_r1_rwl
+ u_t014_007/r1_w0_wl u_t014_007/r1_w1_wl u_t014_007/r1_r0_rwl u_t014_007/r1_r1_rwl
+ u_t014_007/r2_w0_wl u_t014_007/r2_w1_wl u_t014_007/r2_r0_rwl u_t014_007/r2_r1_rwl
+ u_t014_007/r3_w0_wl u_t014_007/r3_w1_wl u_t014_007/r3_r0_rwl u_t014_007/r3_r1_rwl
+ VSS u_t014_009/VSS u_t014_007/m2_717_1265# u_t014_007/m2_603_2031# u_t014_007/m2_1290_336#
+ u_t014_007/m2_2000_2037# u_t014_007/m2_791_2909# u_t014_007/m2_7_2126# u_t014_007/m2_2154_2081#
+ u_t014_007/m2_1795_2037# u_t014_007/m2_871_303# u_t014_007/m2_431_438# u_t014_007/m2_1290_2898#
+ u_t014_007/m2_1714_1210# u_t014_007/m2_431_1982# u_t014_007/m2_512_1265# u_t014_007/m2_2573_2126#
+ u_t014_007/m2_603_1259# u_t014_007/m2_2074_2909# u_t014_007/m2_7_336# u_t014_007/m2_717_2037#
+ u_t014_007/m2_1886_2031# u_t014_007/m2_2573_336# u_t014_007/m2_7_2898# u_t014_007/m2_2000_1265#
+ u_t014_007/m2_512_2037# u_t014_007/m2_1795_1265# u_t014_007/m2_1714_1982# u_t014_007/m2_1886_1259#
+ u_t014_007/m2_1290_2126# u_t014_007/m2_1714_438# u_t014_007/m2_431_1210# u_t014_007/m2_2573_2898#
+ u_t014_007/m2_2154_303# u_t014_007/m2_871_2081# VSUBS detronyx_12t_2w2r_rc4_4x4_routed_5layer_direct
Xgf180mcu_as_sc_mcu7t3v3__nand2_2_19 gf180mcu_as_sc_mcu7t3v3__nand3_2_9/VDD gf180mcu_as_sc_mcu7t3v3__nor2_2_4/VSS
+ VSS VSS VSS gf180mcu_as_sc_mcu7t3v3__nand3_2_9/VNW VSUBS gf180mcu_as_sc_mcu7t3v3__nand2_2
Xu_t005_007 u_t005_007/c0_w0_bl u_t005_007/c0_w0_br u_t005_007/c0_w1_bl u_t005_007/c0_w1_br
+ u_t005_007/c0_r0_rbl u_t005_007/c0_r1_rbl u_t005_007/c1_w0_bl u_t005_007/c1_w0_br
+ u_t005_007/c1_w1_bl u_t005_007/c1_w1_br u_t005_007/c1_r0_rbl u_t005_007/c1_r1_rbl
+ u_t005_007/c2_w0_bl u_t005_007/c2_w0_br u_t005_007/c2_w1_bl u_t005_007/c2_w1_br
+ u_t005_007/c2_r0_rbl u_t005_007/c2_r1_rbl u_t005_007/c3_w0_bl u_t005_007/c3_w0_br
+ u_t005_007/c3_w1_bl u_t005_007/c3_w1_br u_t005_007/c3_r0_rbl u_t005_007/c3_r1_rbl
+ u_t005_007/r0_w0_wl u_t005_007/r0_w1_wl u_t005_007/r0_r0_rwl u_t005_007/r0_r1_rwl
+ u_t005_007/r1_w0_wl u_t005_007/r1_w1_wl u_t005_007/r1_r0_rwl u_t005_007/r1_r1_rwl
+ u_t005_007/r2_w0_wl u_t005_007/r2_w1_wl u_t005_007/r2_r0_rwl u_t005_007/r2_r1_rwl
+ u_t005_007/r3_w0_wl u_t005_007/r3_w1_wl u_t005_007/r3_r0_rwl u_t005_007/r3_r1_rwl
+ VSS VSS u_t005_007/m2_717_1265# u_t005_007/m2_603_2031# u_t005_007/m2_1290_336#
+ u_t005_007/m2_2000_2037# u_t005_007/m2_791_2909# u_t005_007/m2_7_2126# u_t005_007/m2_2154_2081#
+ u_t005_007/m2_1795_2037# u_t005_007/m2_871_303# u_t005_007/m2_431_438# u_t005_007/m2_1290_2898#
+ u_t005_007/m2_1714_1210# u_t005_007/m2_431_1982# u_t005_007/m2_512_1265# u_t005_007/m2_2573_2126#
+ u_t005_007/m2_603_1259# u_t005_007/m2_2074_2909# u_t005_007/m2_7_336# u_t005_007/m2_717_2037#
+ u_t005_007/m2_1886_2031# u_t005_007/m2_2573_336# u_t005_007/m2_7_2898# u_t005_007/m2_2000_1265#
+ u_t005_007/m2_512_2037# u_t005_007/m2_1795_1265# u_t005_007/m2_1714_1982# u_t005_007/m2_1886_1259#
+ u_t005_007/m2_1290_2126# u_t005_007/m2_1714_438# u_t005_007/m2_431_1210# u_t005_007/m2_2573_2898#
+ u_t005_007/m2_2154_303# u_t005_007/m2_871_2081# VSUBS detronyx_12t_2w2r_rc4_4x4_routed_5layer_direct
Xgf180mcu_as_sc_mcu7t3v3__inv_2_482 VSS VSS gf180mcu_as_sc_mcu7t3v3__inv_2_482/Y VSS
+ gf180mcu_as_sc_mcu7t3v3__inv_2_547/VNW VSUBS gf180mcu_as_sc_mcu7t3v3__inv_2
Xgf180mcu_as_sc_mcu7t3v3__inv_2_460 gf180mcu_as_sc_mcu7t3v3__nor2_2_6/VDD gf180mcu_as_sc_mcu7t3v3__nor2_2_6/VSS
+ gf180mcu_as_sc_mcu7t3v3__inv_2_460/Y VSS gf180mcu_as_sc_mcu7t3v3__nor2_2_6/VNW VSUBS
+ gf180mcu_as_sc_mcu7t3v3__inv_2
Xgf180mcu_as_sc_mcu7t3v3__inv_2_471 gf180mcu_as_sc_mcu7t3v3__nor2_2_6/VDD gf180mcu_as_sc_mcu7t3v3__nor2_2_6/VSS
+ VSS VSS gf180mcu_as_sc_mcu7t3v3__nor2_2_6/VNW VSUBS gf180mcu_as_sc_mcu7t3v3__inv_2
Xgf180mcu_as_sc_mcu7t3v3__inv_2_493 VSS VSS VSS VSS gf180mcu_as_sc_mcu7t3v3__inv_2_554/VNW
+ VSUBS gf180mcu_as_sc_mcu7t3v3__inv_2
Xu_t010_010 u_t010_010/c0_w0_bl u_t010_010/c0_w0_br u_t010_010/c0_w1_bl u_t010_010/c0_w1_br
+ u_t010_010/c0_r0_rbl u_t010_010/c0_r1_rbl u_t010_010/c1_w0_bl u_t010_010/c1_w0_br
+ u_t010_010/c1_w1_bl u_t010_010/c1_w1_br u_t010_010/c1_r0_rbl u_t010_010/c1_r1_rbl
+ u_t010_010/c2_w0_bl u_t010_010/c2_w0_br u_t010_010/c2_w1_bl u_t010_010/c2_w1_br
+ u_t010_010/c2_r0_rbl u_t010_010/c2_r1_rbl u_t010_010/c3_w0_bl u_t010_010/c3_w0_br
+ u_t010_010/c3_w1_bl u_t010_010/c3_w1_br u_t010_010/c3_r0_rbl u_t010_010/c3_r1_rbl
+ u_t010_010/r0_w0_wl u_t010_010/r0_w1_wl u_t010_010/r0_r0_rwl u_t010_010/r0_r1_rwl
+ u_t010_010/r1_w0_wl u_t010_010/r1_w1_wl u_t010_010/r1_r0_rwl u_t010_010/r1_r1_rwl
+ u_t010_010/r2_w0_wl u_t010_010/r2_w1_wl u_t010_010/r2_r0_rwl u_t010_010/r2_r1_rwl
+ u_t010_010/r3_w0_wl u_t010_010/r3_w1_wl u_t010_010/r3_r0_rwl u_t010_010/r3_r1_rwl
+ VSS u_t010_010/VSS u_t010_010/m2_717_1265# u_t010_010/m2_603_2031# u_t010_010/m2_1290_336#
+ u_t010_010/m2_2000_2037# u_t010_010/m2_791_2909# u_t010_010/m2_7_2126# u_t010_010/m2_2154_2081#
+ u_t010_010/m2_1795_2037# u_t010_010/m2_871_303# u_t010_010/m2_431_438# u_t010_010/m2_1290_2898#
+ u_t010_010/m2_1714_1210# u_t010_010/m2_431_1982# u_t010_010/m2_512_1265# u_t010_010/m2_2573_2126#
+ u_t010_010/m2_603_1259# u_t010_010/m2_2074_2909# u_t010_010/m2_7_336# u_t010_010/m2_717_2037#
+ u_t010_010/m2_1886_2031# u_t010_010/m2_2573_336# u_t010_010/m2_7_2898# u_t010_010/m2_2000_1265#
+ u_t010_010/m2_512_2037# u_t010_010/m2_1795_1265# u_t010_010/m2_1714_1982# u_t010_010/m2_1886_1259#
+ u_t010_010/m2_1290_2126# u_t010_010/m2_1714_438# u_t010_010/m2_431_1210# u_t010_010/m2_2573_2898#
+ u_t010_010/m2_2154_303# u_t010_010/m2_871_2081# VSUBS detronyx_12t_2w2r_rc4_4x4_routed_5layer_direct
Xu_t001_010 u_t001_010/c0_w0_bl u_t001_010/c0_w0_br u_t001_010/c0_w1_bl u_t001_010/c0_w1_br
+ u_t001_010/c0_r0_rbl u_t001_010/c0_r1_rbl u_t001_010/c1_w0_bl u_t001_010/c1_w0_br
+ u_t001_010/c1_w1_bl u_t001_010/c1_w1_br u_t001_010/c1_r0_rbl u_t001_010/c1_r1_rbl
+ u_t001_010/c2_w0_bl u_t001_010/c2_w0_br u_t001_010/c2_w1_bl u_t001_010/c2_w1_br
+ u_t001_010/c2_r0_rbl u_t001_010/c2_r1_rbl u_t001_010/c3_w0_bl u_t001_010/c3_w0_br
+ u_t001_010/c3_w1_bl u_t001_010/c3_w1_br u_t001_010/c3_r0_rbl u_t001_010/c3_r1_rbl
+ u_t001_010/r0_w0_wl u_t001_010/r0_w1_wl u_t001_010/r0_r0_rwl u_t001_010/r0_r1_rwl
+ u_t001_010/r1_w0_wl u_t001_010/r1_w1_wl u_t001_010/r1_r0_rwl u_t001_010/r1_r1_rwl
+ u_t001_010/r2_w0_wl u_t001_010/r2_w1_wl u_t001_010/r2_r0_rwl u_t001_010/r2_r1_rwl
+ u_t001_010/r3_w0_wl u_t001_010/r3_w1_wl u_t001_010/r3_r0_rwl u_t001_010/r3_r1_rwl
+ VSS VSS u_t001_010/m2_717_1265# u_t001_010/m2_603_2031# u_t001_010/m2_1290_336#
+ u_t001_010/m2_2000_2037# u_t001_010/m2_791_2909# u_t001_010/m2_7_2126# u_t001_010/m2_2154_2081#
+ u_t001_010/m2_1795_2037# u_t001_010/m2_871_303# u_t001_010/m2_431_438# u_t001_010/m2_1290_2898#
+ u_t001_010/m2_1714_1210# u_t001_010/m2_431_1982# u_t001_010/m2_512_1265# u_t001_010/m2_2573_2126#
+ u_t001_010/m2_603_1259# u_t001_010/m2_2074_2909# u_t001_010/m2_7_336# u_t001_010/m2_717_2037#
+ u_t001_010/m2_1886_2031# u_t001_010/m2_2573_336# u_t001_010/m2_7_2898# u_t001_010/m2_2000_1265#
+ u_t001_010/m2_512_2037# u_t001_010/m2_1795_1265# u_t001_010/m2_1714_1982# u_t001_010/m2_1886_1259#
+ u_t001_010/m2_1290_2126# u_t001_010/m2_1714_438# u_t001_010/m2_431_1210# u_t001_010/m2_2573_2898#
+ u_t001_010/m2_2154_303# u_t001_010/m2_871_2081# VSUBS detronyx_12t_2w2r_rc4_4x4_routed_5layer_direct
Xgf180mcu_as_sc_mcu7t3v3__inv_2_1712 gf180mcu_as_sc_mcu7t3v3__nor2_2_9/VDD gf180mcu_as_sc_mcu7t3v3__nand3_2_63/VSS
+ VSS VSS gf180mcu_as_sc_mcu7t3v3__nor2_2_9/VNW VSUBS gf180mcu_as_sc_mcu7t3v3__inv_2
Xgf180mcu_as_sc_mcu7t3v3__inv_2_1701 gf180mcu_as_sc_mcu7t3v3__nor2_2_7/VDD gf180mcu_as_sc_mcu7t3v3__nand3_2_4/VSS
+ VSS VSS gf180mcu_as_sc_mcu7t3v3__nor2_2_7/VNW VSUBS gf180mcu_as_sc_mcu7t3v3__inv_2
Xgf180mcu_as_sc_mcu7t3v3__inv_2_290 gf180mcu_as_sc_mcu7t3v3__inv_2_304/VDD gf180mcu_as_sc_mcu7t3v3__inv_2_304/VSS
+ gf180mcu_as_sc_mcu7t3v3__inv_2_304/A VSS gf180mcu_as_sc_mcu7t3v3__inv_2_304/VNW
+ VSUBS gf180mcu_as_sc_mcu7t3v3__inv_2
Xgf180mcu_as_sc_mcu7t3v3__inv_2_1723 VSS VSS gf180mcu_as_sc_mcu7t3v3__inv_2_1723/Y
+ VSS gf180mcu_as_sc_mcu7t3v3__inv_2_1723/VNW VSUBS gf180mcu_as_sc_mcu7t3v3__inv_2
Xgf180mcu_as_sc_mcu7t3v3__nand4_2_506 gf180mcu_as_sc_mcu7t3v3__inv_2_1689/VSS VSS
+ VSS VSS VSS VSS VSS gf180mcu_as_sc_mcu7t3v3__inv_2_1627/VNW VSUBS gf180mcu_as_sc_mcu7t3v3__nand4_2
Xgf180mcu_as_sc_mcu7t3v3__inv_2_16 gf180mcu_as_sc_mcu7t3v3__inv_2_8/VSS gf180mcu_as_sc_mcu7t3v3__inv_2_20/VDD
+ gf180mcu_as_sc_mcu7t3v3__inv_2_24/Y VSS gf180mcu_as_sc_mcu7t3v3__inv_2_16/VNW VSUBS
+ gf180mcu_as_sc_mcu7t3v3__inv_2
Xgf180mcu_as_sc_mcu7t3v3__inv_2_1008 gf180mcu_as_sc_mcu7t3v3__inv_2_1053/VDD VSS gf180mcu_as_sc_mcu7t3v3__inv_2_1053/A
+ VSS gf180mcu_as_sc_mcu7t3v3__inv_2_1053/VNW VSUBS gf180mcu_as_sc_mcu7t3v3__inv_2
Xgf180mcu_as_sc_mcu7t3v3__inv_2_27 gf180mcu_as_sc_mcu7t3v3__inv_2_66/VSS gf180mcu_as_sc_mcu7t3v3__inv_2_32/VDD
+ gf180mcu_as_sc_mcu7t3v3__inv_2_27/Y gf180mcu_as_sc_mcu7t3v3__inv_2_66/Y gf180mcu_as_sc_mcu7t3v3__inv_2_28/VNW
+ VSUBS gf180mcu_as_sc_mcu7t3v3__inv_2
Xgf180mcu_as_sc_mcu7t3v3__inv_2_49 gf180mcu_as_sc_mcu7t3v3__inv_2_49/VDD gf180mcu_as_sc_mcu7t3v3__inv_2_66/VSS
+ gf180mcu_as_sc_mcu7t3v3__inv_2_9/Y VSS gf180mcu_as_sc_mcu7t3v3__inv_2_49/VNW VSUBS
+ gf180mcu_as_sc_mcu7t3v3__inv_2
Xgf180mcu_as_sc_mcu7t3v3__inv_2_38 gf180mcu_as_sc_mcu7t3v3__inv_2_38/VDD VSS gf180mcu_as_sc_mcu7t3v3__inv_2_9/Y
+ VSS gf180mcu_as_sc_mcu7t3v3__inv_2_38/VNW VSUBS gf180mcu_as_sc_mcu7t3v3__inv_2
Xgf180mcu_as_sc_mcu7t3v3__inv_2_1019 gf180mcu_as_sc_mcu7t3v3__inv_2_1058/VSS VSS gf180mcu_as_sc_mcu7t3v3__inv_2_962/A
+ gf180mcu_as_sc_mcu7t3v3__inv_2_1020/Y gf180mcu_as_sc_mcu7t3v3__inv_2_1020/VNW VSUBS
+ gf180mcu_as_sc_mcu7t3v3__inv_2
Xgf180mcu_as_sc_mcu7t3v3__inv_2_1597 VSS gf180mcu_as_sc_mcu7t3v3__inv_2_1598/VDD VSS
+ VSS gf180mcu_as_sc_mcu7t3v3__inv_2_1597/VNW VSUBS gf180mcu_as_sc_mcu7t3v3__inv_2
Xgf180mcu_as_sc_mcu7t3v3__inv_2_1564 gf180mcu_as_sc_mcu7t3v3__inv_2_1598/VDD gf180mcu_as_sc_mcu7t3v3__inv_2_1598/VSS
+ gf180mcu_as_sc_mcu7t3v3__inv_2_1564/Y VSS gf180mcu_as_sc_mcu7t3v3__inv_2_1598/VNW
+ VSUBS gf180mcu_as_sc_mcu7t3v3__inv_2
Xgf180mcu_as_sc_mcu7t3v3__inv_2_1586 gf180mcu_as_sc_mcu7t3v3__inv_2_1598/VSS VSS VSS
+ VSS gf180mcu_as_sc_mcu7t3v3__inv_2_1587/VNW VSUBS gf180mcu_as_sc_mcu7t3v3__inv_2
Xgf180mcu_as_sc_mcu7t3v3__inv_2_1575 VSS VSS VSS VSS gf180mcu_as_sc_mcu7t3v3__inv_2_1576/VNW
+ VSUBS gf180mcu_as_sc_mcu7t3v3__inv_2
Xgf180mcu_as_sc_mcu7t3v3__inv_2_1542 VSS gf180mcu_as_sc_mcu7t3v3__inv_2_1547/VDD VSS
+ VSS gf180mcu_as_sc_mcu7t3v3__inv_2_1544/VNW VSUBS gf180mcu_as_sc_mcu7t3v3__inv_2
Xgf180mcu_as_sc_mcu7t3v3__inv_2_1553 gf180mcu_as_sc_mcu7t3v3__inv_2_1553/VDD gf180mcu_as_sc_mcu7t3v3__inv_2_1556/VDD
+ gf180mcu_as_sc_mcu7t3v3__inv_2_1553/Y VSS gf180mcu_as_sc_mcu7t3v3__inv_2_1553/VNW
+ VSUBS gf180mcu_as_sc_mcu7t3v3__inv_2
Xgf180mcu_as_sc_mcu7t3v3__inv_2_1520 VSS gf180mcu_as_sc_mcu7t3v3__inv_2_1523/VDD gf180mcu_as_sc_mcu7t3v3__inv_2_1520/Y
+ VSS gf180mcu_as_sc_mcu7t3v3__inv_2_1520/VNW VSUBS gf180mcu_as_sc_mcu7t3v3__inv_2
Xgf180mcu_as_sc_mcu7t3v3__inv_2_1531 gf180mcu_as_sc_mcu7t3v3__inv_2_1532/VDD VSS gf180mcu_as_sc_mcu7t3v3__inv_2_1531/Y
+ VSS gf180mcu_as_sc_mcu7t3v3__inv_2_1532/VNW VSUBS gf180mcu_as_sc_mcu7t3v3__inv_2
Xgf180mcu_as_sc_mcu7t3v3__nand3_2_8 gf180mcu_as_sc_mcu7t3v3__nor2_2_7/VDD gf180mcu_as_sc_mcu7t3v3__nor2_2_7/VSS
+ VSS VSS VSS VSS gf180mcu_as_sc_mcu7t3v3__nor2_2_7/VNW VSUBS gf180mcu_as_sc_mcu7t3v3__nand3_2
Xgf180mcu_as_sc_mcu7t3v3__nand4_2_336 gf180mcu_as_sc_mcu7t3v3__inv_2_1133/VDD VSS
+ VSS VSS VSS VSS VSS gf180mcu_as_sc_mcu7t3v3__inv_2_1133/VNW VSUBS gf180mcu_as_sc_mcu7t3v3__nand4_2
Xgf180mcu_as_sc_mcu7t3v3__nand4_2_369 VSS VSS VSS VSS VSS VSS gf180mcu_as_sc_mcu7t3v3__nand4_2_369/Y
+ gf180mcu_as_sc_mcu7t3v3__inv_2_1283/VNW VSUBS gf180mcu_as_sc_mcu7t3v3__nand4_2
Xgf180mcu_as_sc_mcu7t3v3__nand4_2_347 VSS VSS VSS VSS VSS VSS VSS gf180mcu_as_sc_mcu7t3v3__inv_2_1151/VNW
+ VSUBS gf180mcu_as_sc_mcu7t3v3__nand4_2
Xgf180mcu_as_sc_mcu7t3v3__nand4_2_358 VSS VSS VSS VSS VSS VSS gf180mcu_as_sc_mcu7t3v3__nand4_2_358/Y
+ gf180mcu_as_sc_mcu7t3v3__inv_2_1294/VNW VSUBS gf180mcu_as_sc_mcu7t3v3__nand4_2
Xgf180mcu_as_sc_mcu7t3v3__nand4_2_325 VSS VSS VSS VSS VSS VSS VSS gf180mcu_as_sc_mcu7t3v3__inv_2_1095/VNW
+ VSUBS gf180mcu_as_sc_mcu7t3v3__nand4_2
Xgf180mcu_as_sc_mcu7t3v3__nand4_2_314 gf180mcu_as_sc_mcu7t3v3__inv_2_1036/VDD gf180mcu_as_sc_mcu7t3v3__inv_2_1036/VSS
+ VSS VSS VSS VSS VSS gf180mcu_as_sc_mcu7t3v3__inv_2_1036/VNW VSUBS gf180mcu_as_sc_mcu7t3v3__nand4_2
Xgf180mcu_as_sc_mcu7t3v3__nand4_2_303 gf180mcu_as_sc_mcu7t3v3__inv_2_989/VDD gf180mcu_as_sc_mcu7t3v3__inv_2_989/VSS
+ VSS VSS VSS VSS VSS gf180mcu_as_sc_mcu7t3v3__inv_2_989/VNW VSUBS gf180mcu_as_sc_mcu7t3v3__nand4_2
Xu_t029_013 u_t029_013/c0_w0_bl u_t029_013/c0_w0_br u_t029_013/c0_w1_bl u_t029_013/c0_w1_br
+ u_t029_013/c0_r0_rbl u_t029_013/c0_r1_rbl u_t029_013/c1_w0_bl u_t029_013/c1_w0_br
+ u_t029_013/c1_w1_bl u_t029_013/c1_w1_br u_t029_013/c1_r0_rbl u_t029_013/c1_r1_rbl
+ u_t029_013/c2_w0_bl u_t029_013/c2_w0_br u_t029_013/c2_w1_bl u_t029_013/c2_w1_br
+ u_t029_013/c2_r0_rbl u_t029_013/c2_r1_rbl u_t029_013/c3_w0_bl u_t029_013/c3_w0_br
+ u_t029_013/c3_w1_bl u_t029_013/c3_w1_br u_t029_013/c3_r0_rbl u_t029_013/c3_r1_rbl
+ u_t029_013/r0_w0_wl u_t029_013/r0_w1_wl u_t029_013/r0_r0_rwl u_t029_013/r0_r1_rwl
+ u_t029_013/r1_w0_wl u_t029_013/r1_w1_wl u_t029_013/r1_r0_rwl u_t029_013/r1_r1_rwl
+ u_t029_013/r2_w0_wl u_t029_013/r2_w1_wl u_t029_013/r2_r0_rwl u_t029_013/r2_r1_rwl
+ u_t029_013/r3_w0_wl u_t029_013/r3_w1_wl u_t029_013/r3_r0_rwl u_t029_013/r3_r1_rwl
+ u_t029_013/VDD VSS u_t029_013/m2_717_1265# u_t029_013/m2_603_2031# u_t029_013/m2_1290_336#
+ u_t029_013/m2_2000_2037# u_t029_013/m2_791_2909# u_t029_013/m2_7_2126# u_t029_013/m2_2154_2081#
+ u_t029_013/m2_1795_2037# u_t029_013/m2_871_303# u_t029_013/m2_431_438# u_t029_013/m2_1290_2898#
+ u_t029_013/m2_1714_1210# u_t029_013/m2_431_1982# u_t029_013/m2_512_1265# u_t029_013/m2_2573_2126#
+ u_t029_013/m2_603_1259# u_t029_013/m2_2074_2909# u_t029_013/m2_7_336# u_t029_013/m2_717_2037#
+ u_t029_013/m2_1886_2031# u_t029_013/m2_2573_336# u_t029_013/m2_7_2898# u_t029_013/m2_2000_1265#
+ u_t029_013/m2_512_2037# u_t029_013/m2_1795_1265# u_t029_013/m2_1714_1982# u_t029_013/m2_1886_1259#
+ u_t029_013/m2_1290_2126# u_t029_013/m2_1714_438# u_t029_013/m2_431_1210# u_t029_013/m2_2573_2898#
+ u_t029_013/m2_2154_303# u_t029_013/m2_871_2081# VSUBS detronyx_12t_2w2r_rc4_4x4_routed_5layer_direct
Xu_t029_002 u_t029_002/c0_w0_bl u_t029_002/c0_w0_br u_t029_002/c0_w1_bl u_t029_002/c0_w1_br
+ u_t029_002/c0_r0_rbl u_t029_002/c0_r1_rbl u_t029_002/c1_w0_bl u_t029_002/c1_w0_br
+ u_t029_002/c1_w1_bl u_t029_002/c1_w1_br u_t029_002/c1_r0_rbl u_t029_002/c1_r1_rbl
+ u_t029_002/c2_w0_bl u_t029_002/c2_w0_br u_t029_002/c2_w1_bl u_t029_002/c2_w1_br
+ u_t029_002/c2_r0_rbl u_t029_002/c2_r1_rbl u_t029_002/c3_w0_bl u_t029_002/c3_w0_br
+ u_t029_002/c3_w1_bl u_t029_002/c3_w1_br u_t029_002/c3_r0_rbl u_t029_002/c3_r1_rbl
+ u_t029_002/r0_w0_wl u_t029_002/r0_w1_wl u_t029_002/r0_r0_rwl u_t029_002/r0_r1_rwl
+ u_t029_002/r1_w0_wl u_t029_002/r1_w1_wl u_t029_002/r1_r0_rwl u_t029_002/r1_r1_rwl
+ u_t029_002/r2_w0_wl u_t029_002/r2_w1_wl u_t029_002/r2_r0_rwl u_t029_002/r2_r1_rwl
+ u_t029_002/r3_w0_wl u_t029_002/r3_w1_wl u_t029_002/r3_r0_rwl u_t029_002/r3_r1_rwl
+ VSS VSS u_t029_002/m2_717_1265# u_t029_002/m2_603_2031# u_t029_002/m2_1290_336#
+ u_t029_002/m2_2000_2037# u_t029_002/m2_791_2909# u_t029_002/m2_7_2126# u_t029_002/m2_2154_2081#
+ u_t029_002/m2_1795_2037# u_t029_002/m2_871_303# u_t029_002/m2_431_438# u_t029_002/m2_1290_2898#
+ u_t029_002/m2_1714_1210# u_t029_002/m2_431_1982# u_t029_002/m2_512_1265# u_t029_002/m2_2573_2126#
+ u_t029_002/m2_603_1259# u_t029_002/m2_2074_2909# u_t029_002/m2_7_336# u_t029_002/m2_717_2037#
+ u_t029_002/m2_1886_2031# u_t029_002/m2_2573_336# u_t029_002/m2_7_2898# u_t029_002/m2_2000_1265#
+ u_t029_002/m2_512_2037# u_t029_002/m2_1795_1265# u_t029_002/m2_1714_1982# u_t029_002/m2_1886_1259#
+ u_t029_002/m2_1290_2126# u_t029_002/m2_1714_438# u_t029_002/m2_431_1210# u_t029_002/m2_2573_2898#
+ u_t029_002/m2_2154_303# u_t029_002/m2_871_2081# VSUBS detronyx_12t_2w2r_rc4_4x4_routed_5layer_direct
Xgf180mcu_as_sc_mcu7t3v3__inv_2_1361 VSS gf180mcu_as_sc_mcu7t3v3__inv_2_1366/VDD gf180mcu_as_sc_mcu7t3v3__inv_2_1694/Y
+ gf180mcu_as_sc_mcu7t3v3__inv_2_1694/Y gf180mcu_as_sc_mcu7t3v3__inv_2_1362/VNW VSUBS
+ gf180mcu_as_sc_mcu7t3v3__inv_2
Xgf180mcu_as_sc_mcu7t3v3__inv_2_1372 VSS gf180mcu_as_sc_mcu7t3v3__inv_2_1378/VDD VSS
+ gf180mcu_as_sc_mcu7t3v3__inv_2_1382/Y gf180mcu_as_sc_mcu7t3v3__inv_2_1374/VNW VSUBS
+ gf180mcu_as_sc_mcu7t3v3__inv_2
Xgf180mcu_as_sc_mcu7t3v3__inv_2_1394 gf180mcu_as_sc_mcu7t3v3__inv_2_1394/VDD VSS gf180mcu_as_sc_mcu7t3v3__inv_2_1394/Y
+ VSS gf180mcu_as_sc_mcu7t3v3__inv_2_1394/VNW VSUBS gf180mcu_as_sc_mcu7t3v3__inv_2
Xgf180mcu_as_sc_mcu7t3v3__inv_2_1383 gf180mcu_as_sc_mcu7t3v3__inv_2_1391/VDD gf180mcu_as_sc_mcu7t3v3__inv_2_1403/VDD
+ VSS gf180mcu_as_sc_mcu7t3v3__inv_2_1409/A gf180mcu_as_sc_mcu7t3v3__inv_2_1391/VNW
+ VSUBS gf180mcu_as_sc_mcu7t3v3__inv_2
Xgf180mcu_as_sc_mcu7t3v3__inv_2_1350 gf180mcu_as_sc_mcu7t3v3__inv_2_1352/VDD gf180mcu_as_sc_mcu7t3v3__inv_2_1355/VDD
+ VSS gf180mcu_as_sc_mcu7t3v3__inv_2_1355/Y gf180mcu_as_sc_mcu7t3v3__inv_2_1352/VNW
+ VSUBS gf180mcu_as_sc_mcu7t3v3__inv_2
Xgf180mcu_as_sc_mcu7t3v3__inv_2_856 VSS VSS VSS VSS gf180mcu_as_sc_mcu7t3v3__inv_2_857/VNW
+ VSUBS gf180mcu_as_sc_mcu7t3v3__inv_2
Xgf180mcu_as_sc_mcu7t3v3__inv_2_823 VSS VSS VSS VSS gf180mcu_as_sc_mcu7t3v3__inv_2_823/VNW
+ VSUBS gf180mcu_as_sc_mcu7t3v3__inv_2
Xgf180mcu_as_sc_mcu7t3v3__inv_2_834 VSS VSS VSS VSS gf180mcu_as_sc_mcu7t3v3__inv_2_834/VNW
+ VSUBS gf180mcu_as_sc_mcu7t3v3__inv_2
Xgf180mcu_as_sc_mcu7t3v3__inv_2_801 VSS VSS VSS VSS gf180mcu_as_sc_mcu7t3v3__inv_2_847/VNW
+ VSUBS gf180mcu_as_sc_mcu7t3v3__inv_2
Xgf180mcu_as_sc_mcu7t3v3__inv_2_845 VSS VSS VSS VSS gf180mcu_as_sc_mcu7t3v3__inv_2_845/VNW
+ VSUBS gf180mcu_as_sc_mcu7t3v3__inv_2
Xgf180mcu_as_sc_mcu7t3v3__inv_2_812 VSS VSS VSS VSS gf180mcu_as_sc_mcu7t3v3__inv_2_840/VNW
+ VSUBS gf180mcu_as_sc_mcu7t3v3__inv_2
Xgf180mcu_as_sc_mcu7t3v3__inv_2_889 VSS VSS VSS VSS gf180mcu_as_sc_mcu7t3v3__inv_2_936/VNW
+ VSUBS gf180mcu_as_sc_mcu7t3v3__inv_2
Xgf180mcu_as_sc_mcu7t3v3__inv_2_878 VSS VSS VSS VSS gf180mcu_as_sc_mcu7t3v3__inv_2_932/VNW
+ VSUBS gf180mcu_as_sc_mcu7t3v3__inv_2
Xgf180mcu_as_sc_mcu7t3v3__inv_2_867 VSS VSS VSS VSS gf180mcu_as_sc_mcu7t3v3__inv_2_928/VNW
+ VSUBS gf180mcu_as_sc_mcu7t3v3__inv_2
Xgf180mcu_as_sc_mcu7t3v3__nand4_2_133 VSS VSS VSS VSS VSS VSS VSS gf180mcu_as_sc_mcu7t3v3__inv_2_560/VNW
+ VSUBS gf180mcu_as_sc_mcu7t3v3__nand4_2
Xgf180mcu_as_sc_mcu7t3v3__nand4_2_144 VSS VSS VSS VSS VSS VSS VSS gf180mcu_as_sc_mcu7t3v3__inv_2_539/VNW
+ VSUBS gf180mcu_as_sc_mcu7t3v3__nand4_2
Xgf180mcu_as_sc_mcu7t3v3__nand4_2_122 VSS gf180mcu_as_sc_mcu7t3v3__inv_2_308/VDD VSS
+ VSS VSS VSS VSS gf180mcu_as_sc_mcu7t3v3__inv_2_302/VNW VSUBS gf180mcu_as_sc_mcu7t3v3__nand4_2
Xgf180mcu_as_sc_mcu7t3v3__nand4_2_111 gf180mcu_as_sc_mcu7t3v3__inv_2_307/VDD gf180mcu_as_sc_mcu7t3v3__inv_2_311/VDD
+ VSS VSS VSS VSS VSS gf180mcu_as_sc_mcu7t3v3__inv_2_307/VNW VSUBS gf180mcu_as_sc_mcu7t3v3__nand4_2
Xgf180mcu_as_sc_mcu7t3v3__nand4_2_100 VSS VSS VSS VSS VSS VSS VSS gf180mcu_as_sc_mcu7t3v3__inv_2_353/VNW
+ VSUBS gf180mcu_as_sc_mcu7t3v3__nand4_2
Xu_t026_005 u_t026_005/c0_w0_bl u_t026_005/c0_w0_br u_t026_005/c0_w1_bl u_t026_005/c0_w1_br
+ u_t026_005/c0_r0_rbl u_t026_005/c0_r1_rbl u_t026_005/c1_w0_bl u_t026_005/c1_w0_br
+ u_t026_005/c1_w1_bl u_t026_005/c1_w1_br u_t026_005/c1_r0_rbl u_t026_005/c1_r1_rbl
+ u_t026_005/c2_w0_bl u_t026_005/c2_w0_br u_t026_005/c2_w1_bl u_t026_005/c2_w1_br
+ u_t026_005/c2_r0_rbl u_t026_005/c2_r1_rbl u_t026_005/c3_w0_bl u_t026_005/c3_w0_br
+ u_t026_005/c3_w1_bl u_t026_005/c3_w1_br u_t026_005/c3_r0_rbl u_t026_005/c3_r1_rbl
+ u_t026_005/r0_w0_wl u_t026_005/r0_w1_wl u_t026_005/r0_r0_rwl u_t026_005/r0_r1_rwl
+ u_t026_005/r1_w0_wl u_t026_005/r1_w1_wl u_t026_005/r1_r0_rwl u_t026_005/r1_r1_rwl
+ u_t026_005/r2_w0_wl u_t026_005/r2_w1_wl u_t026_005/r2_r0_rwl u_t026_005/r2_r1_rwl
+ u_t026_005/r3_w0_wl u_t026_005/r3_w1_wl u_t026_005/r3_r0_rwl u_t026_005/r3_r1_rwl
+ u_t026_005/VDD VSS u_t026_005/m2_717_1265# u_t026_005/m2_603_2031# u_t026_005/m2_1290_336#
+ u_t026_005/m2_2000_2037# u_t026_005/m2_791_2909# u_t026_005/m2_7_2126# u_t026_005/m2_2154_2081#
+ u_t026_005/m2_1795_2037# u_t026_005/m2_871_303# u_t026_005/m2_431_438# u_t026_005/m2_1290_2898#
+ u_t026_005/m2_1714_1210# u_t026_005/m2_431_1982# u_t026_005/m2_512_1265# u_t026_005/m2_2573_2126#
+ u_t026_005/m2_603_1259# u_t026_005/m2_2074_2909# u_t026_005/m2_7_336# u_t026_005/m2_717_2037#
+ u_t026_005/m2_1886_2031# u_t026_005/m2_2573_336# u_t026_005/m2_7_2898# u_t026_005/m2_2000_1265#
+ u_t026_005/m2_512_2037# u_t026_005/m2_1795_1265# u_t026_005/m2_1714_1982# u_t026_005/m2_1886_1259#
+ u_t026_005/m2_1290_2126# u_t026_005/m2_1714_438# u_t026_005/m2_431_1210# u_t026_005/m2_2573_2898#
+ u_t026_005/m2_2154_303# u_t026_005/m2_871_2081# VSUBS detronyx_12t_2w2r_rc4_4x4_routed_5layer_direct
Xgf180mcu_as_sc_mcu7t3v3__nand4_2_61 gf180mcu_as_sc_mcu7t3v3__inv_2_4/VDD gf180mcu_as_sc_mcu7t3v3__inv_2_4/VDD
+ VSS VSS VSS VSS VSS gf180mcu_as_sc_mcu7t3v3__inv_2_36/VNW VSUBS gf180mcu_as_sc_mcu7t3v3__nand4_2
Xgf180mcu_as_sc_mcu7t3v3__nand4_2_155 gf180mcu_as_sc_mcu7t3v3__inv_2_590/VSS gf180mcu_as_sc_mcu7t3v3__inv_2_590/VSS
+ VSS VSS VSS VSS VSS gf180mcu_as_sc_mcu7t3v3__inv_2_590/VNW VSUBS gf180mcu_as_sc_mcu7t3v3__nand4_2
Xgf180mcu_as_sc_mcu7t3v3__nand4_2_94 gf180mcu_as_sc_mcu7t3v3__inv_2_0/VSS gf180mcu_as_sc_mcu7t3v3__inv_2_49/VDD
+ VSS VSS VSS VSS VSS gf180mcu_as_sc_mcu7t3v3__inv_2_43/VNW VSUBS gf180mcu_as_sc_mcu7t3v3__nand4_2
Xgf180mcu_as_sc_mcu7t3v3__nand4_2_177 VSS gf180mcu_as_sc_mcu7t3v3__inv_2_607/VDD VSS
+ VSS VSS VSS VSS gf180mcu_as_sc_mcu7t3v3__inv_2_603/VNW VSUBS gf180mcu_as_sc_mcu7t3v3__nand4_2
Xgf180mcu_as_sc_mcu7t3v3__nand4_2_166 gf180mcu_as_sc_mcu7t3v3__inv_2_632/VDD gf180mcu_as_sc_mcu7t3v3__inv_2_636/VDD
+ VSS VSS VSS VSS VSS gf180mcu_as_sc_mcu7t3v3__inv_2_632/VNW VSUBS gf180mcu_as_sc_mcu7t3v3__nand4_2
Xgf180mcu_as_sc_mcu7t3v3__nand4_2_83 gf180mcu_as_sc_mcu7t3v3__inv_2_69/VDD gf180mcu_as_sc_mcu7t3v3__inv_2_69/VDD
+ VSS VSS VSS VSS VSS gf180mcu_as_sc_mcu7t3v3__inv_2_65/VNW VSUBS gf180mcu_as_sc_mcu7t3v3__nand4_2
Xgf180mcu_as_sc_mcu7t3v3__nand4_2_199 VSS VSS VSS VSS VSS VSS VSS gf180mcu_as_sc_mcu7t3v3__inv_2_680/VNW
+ VSUBS gf180mcu_as_sc_mcu7t3v3__nand4_2
Xgf180mcu_as_sc_mcu7t3v3__nand4_2_188 VSS gf180mcu_as_sc_mcu7t3v3__inv_2_746/VDD VSS
+ VSS VSS VSS VSS gf180mcu_as_sc_mcu7t3v3__inv_2_724/VNW VSUBS gf180mcu_as_sc_mcu7t3v3__nand4_2
Xgf180mcu_as_sc_mcu7t3v3__nand4_2_50 gf180mcu_as_sc_mcu7t3v3__inv_2_260/VDD gf180mcu_as_sc_mcu7t3v3__inv_2_260/VDD
+ VSS VSS VSS VSS VSS gf180mcu_as_sc_mcu7t3v3__inv_2_230/VNW VSUBS gf180mcu_as_sc_mcu7t3v3__nand4_2
Xgf180mcu_as_sc_mcu7t3v3__nand4_2_72 gf180mcu_as_sc_mcu7t3v3__inv_2_320/VDD gf180mcu_as_sc_mcu7t3v3__inv_2_323/VDD
+ VSS VSS VSS VSS VSS gf180mcu_as_sc_mcu7t3v3__inv_2_320/VNW VSUBS gf180mcu_as_sc_mcu7t3v3__nand4_2
Xu_t017_005 u_t017_005/c0_w0_bl u_t017_005/c0_w0_br u_t017_005/c0_w1_bl u_t017_005/c0_w1_br
+ u_t017_005/c0_r0_rbl u_t017_005/c0_r1_rbl u_t017_005/c1_w0_bl u_t017_005/c1_w0_br
+ u_t017_005/c1_w1_bl u_t017_005/c1_w1_br u_t017_005/c1_r0_rbl u_t017_005/c1_r1_rbl
+ u_t017_005/c2_w0_bl u_t017_005/c2_w0_br u_t017_005/c2_w1_bl u_t017_005/c2_w1_br
+ u_t017_005/c2_r0_rbl u_t017_005/c2_r1_rbl u_t017_005/c3_w0_bl u_t017_005/c3_w0_br
+ u_t017_005/c3_w1_bl u_t017_005/c3_w1_br u_t017_005/c3_r0_rbl u_t017_005/c3_r1_rbl
+ u_t017_005/r0_w0_wl u_t017_005/r0_w1_wl u_t017_005/r0_r0_rwl u_t017_005/r0_r1_rwl
+ u_t017_005/r1_w0_wl u_t017_005/r1_w1_wl u_t017_005/r1_r0_rwl u_t017_005/r1_r1_rwl
+ u_t017_005/r2_w0_wl u_t017_005/r2_w1_wl u_t017_005/r2_r0_rwl u_t017_005/r2_r1_rwl
+ u_t017_005/r3_w0_wl u_t017_005/r3_w1_wl u_t017_005/r3_r0_rwl u_t017_005/r3_r1_rwl
+ u_t017_005/VDD VSS u_t017_005/m2_717_1265# u_t017_005/m2_603_2031# u_t017_005/m2_1290_336#
+ u_t017_005/m2_2000_2037# u_t017_005/m2_791_2909# u_t017_005/m2_7_2126# u_t017_005/m2_2154_2081#
+ u_t017_005/m2_1795_2037# u_t017_005/m2_871_303# u_t017_005/m2_431_438# u_t017_005/m2_1290_2898#
+ u_t017_005/m2_1714_1210# u_t017_005/m2_431_1982# u_t017_005/m2_512_1265# u_t017_005/m2_2573_2126#
+ u_t017_005/m2_603_1259# u_t017_005/m2_2074_2909# u_t017_005/m2_7_336# u_t017_005/m2_717_2037#
+ u_t017_005/m2_1886_2031# u_t017_005/m2_2573_336# u_t017_005/m2_7_2898# u_t017_005/m2_2000_1265#
+ u_t017_005/m2_512_2037# u_t017_005/m2_1795_1265# u_t017_005/m2_1714_1982# u_t017_005/m2_1886_1259#
+ u_t017_005/m2_1290_2126# u_t017_005/m2_1714_438# u_t017_005/m2_431_1210# u_t017_005/m2_2573_2898#
+ u_t017_005/m2_2154_303# u_t017_005/m2_871_2081# VSUBS detronyx_12t_2w2r_rc4_4x4_routed_5layer_direct
Xgf180mcu_as_sc_mcu7t3v3__inv_2_119 gf180mcu_as_sc_mcu7t3v3__inv_2_122/VDD gf180mcu_as_sc_mcu7t3v3__inv_2_122/VDD
+ VSS VSS gf180mcu_as_sc_mcu7t3v3__inv_2_119/VNW VSUBS gf180mcu_as_sc_mcu7t3v3__inv_2
Xgf180mcu_as_sc_mcu7t3v3__inv_2_108 gf180mcu_as_sc_mcu7t3v3__inv_2_371/VSS gf180mcu_as_sc_mcu7t3v3__inv_2_113/VDD
+ gf180mcu_as_sc_mcu7t3v3__inv_2_108/Y VSS gf180mcu_as_sc_mcu7t3v3__inv_2_110/VNW
+ VSUBS gf180mcu_as_sc_mcu7t3v3__inv_2
Xgf180mcu_as_sc_mcu7t3v3__inv_2_1180 VSS VSS VSS VSS gf180mcu_as_sc_mcu7t3v3__inv_2_1300/VNW
+ VSUBS gf180mcu_as_sc_mcu7t3v3__inv_2
Xgf180mcu_as_sc_mcu7t3v3__inv_2_1191 gf180mcu_as_sc_mcu7t3v3__nand3_2_65/VDD gf180mcu_as_sc_mcu7t3v3__nand3_2_62/VSS
+ gf180mcu_as_sc_mcu7t3v3__inv_2_1191/Y VSS gf180mcu_as_sc_mcu7t3v3__nand3_2_65/VNW
+ VSUBS gf180mcu_as_sc_mcu7t3v3__inv_2
Xu_t008_005 u_t008_005/c0_w0_bl u_t008_005/c0_w0_br u_t008_005/c0_w1_bl u_t008_005/c0_w1_br
+ u_t008_005/c0_r0_rbl u_t008_005/c0_r1_rbl u_t008_005/c1_w0_bl u_t008_005/c1_w0_br
+ u_t008_005/c1_w1_bl u_t008_005/c1_w1_br u_t008_005/c1_r0_rbl u_t008_005/c1_r1_rbl
+ u_t008_005/c2_w0_bl u_t008_005/c2_w0_br u_t008_005/c2_w1_bl u_t008_005/c2_w1_br
+ u_t008_005/c2_r0_rbl u_t008_005/c2_r1_rbl u_t008_005/c3_w0_bl u_t008_005/c3_w0_br
+ u_t008_005/c3_w1_bl u_t008_005/c3_w1_br u_t008_005/c3_r0_rbl u_t008_005/c3_r1_rbl
+ u_t008_005/r0_w0_wl u_t008_005/r0_w1_wl u_t008_005/r0_r0_rwl u_t008_005/r0_r1_rwl
+ u_t008_005/r1_w0_wl u_t008_005/r1_w1_wl u_t008_005/r1_r0_rwl u_t008_005/r1_r1_rwl
+ u_t008_005/r2_w0_wl u_t008_005/r2_w1_wl u_t008_005/r2_r0_rwl u_t008_005/r2_r1_rwl
+ u_t008_005/r3_w0_wl u_t008_005/r3_w1_wl u_t008_005/r3_r0_rwl u_t008_005/r3_r1_rwl
+ u_t008_005/VDD VSS u_t008_005/m2_717_1265# u_t008_005/m2_603_2031# u_t008_005/m2_1290_336#
+ u_t008_005/m2_2000_2037# u_t008_005/m2_791_2909# u_t008_005/m2_7_2126# u_t008_005/m2_2154_2081#
+ u_t008_005/m2_1795_2037# u_t008_005/m2_871_303# u_t008_005/m2_431_438# u_t008_005/m2_1290_2898#
+ u_t008_005/m2_1714_1210# u_t008_005/m2_431_1982# u_t008_005/m2_512_1265# u_t008_005/m2_2573_2126#
+ u_t008_005/m2_603_1259# u_t008_005/m2_2074_2909# u_t008_005/m2_7_336# u_t008_005/m2_717_2037#
+ u_t008_005/m2_1886_2031# u_t008_005/m2_2573_336# u_t008_005/m2_7_2898# u_t008_005/m2_2000_1265#
+ u_t008_005/m2_512_2037# u_t008_005/m2_1795_1265# u_t008_005/m2_1714_1982# u_t008_005/m2_1886_1259#
+ u_t008_005/m2_1290_2126# u_t008_005/m2_1714_438# u_t008_005/m2_431_1210# u_t008_005/m2_2573_2898#
+ u_t008_005/m2_2154_303# u_t008_005/m2_871_2081# VSUBS detronyx_12t_2w2r_rc4_4x4_routed_5layer_direct
Xgf180mcu_as_sc_mcu7t3v3__inv_2_620 gf180mcu_as_sc_mcu7t3v3__inv_2_620/VDD gf180mcu_as_sc_mcu7t3v3__inv_2_624/VDD
+ gf180mcu_as_sc_mcu7t3v3__inv_2_620/Y VSS gf180mcu_as_sc_mcu7t3v3__inv_2_620/VNW
+ VSUBS gf180mcu_as_sc_mcu7t3v3__inv_2
Xu_t023_008 u_t023_008/c0_w0_bl u_t023_008/c0_w0_br u_t023_008/c0_w1_bl u_t023_008/c0_w1_br
+ u_t023_008/c0_r0_rbl u_t023_008/c0_r1_rbl u_t023_008/c1_w0_bl u_t023_008/c1_w0_br
+ u_t023_008/c1_w1_bl u_t023_008/c1_w1_br u_t023_008/c1_r0_rbl u_t023_008/c1_r1_rbl
+ u_t023_008/c2_w0_bl u_t023_008/c2_w0_br u_t023_008/c2_w1_bl u_t023_008/c2_w1_br
+ u_t023_008/c2_r0_rbl u_t023_008/c2_r1_rbl u_t023_008/c3_w0_bl u_t023_008/c3_w0_br
+ u_t023_008/c3_w1_bl u_t023_008/c3_w1_br u_t023_008/c3_r0_rbl u_t023_008/c3_r1_rbl
+ u_t023_008/r0_w0_wl u_t023_008/r0_w1_wl u_t023_008/r0_r0_rwl u_t023_008/r0_r1_rwl
+ u_t023_008/r1_w0_wl u_t023_008/r1_w1_wl u_t023_008/r1_r0_rwl u_t023_008/r1_r1_rwl
+ u_t023_008/r2_w0_wl u_t023_008/r2_w1_wl u_t023_008/r2_r0_rwl u_t023_008/r2_r1_rwl
+ u_t023_008/r3_w0_wl u_t023_008/r3_w1_wl u_t023_008/r3_r0_rwl u_t023_008/r3_r1_rwl
+ VSS u_t023_009/VSS u_t023_008/m2_717_1265# u_t023_008/m2_603_2031# u_t023_008/m2_1290_336#
+ u_t023_008/m2_2000_2037# u_t023_008/m2_791_2909# u_t023_008/m2_7_2126# u_t023_008/m2_2154_2081#
+ u_t023_008/m2_1795_2037# u_t023_008/m2_871_303# u_t023_008/m2_431_438# u_t023_008/m2_1290_2898#
+ u_t023_008/m2_1714_1210# u_t023_008/m2_431_1982# u_t023_008/m2_512_1265# u_t023_008/m2_2573_2126#
+ u_t023_008/m2_603_1259# u_t023_008/m2_2074_2909# u_t023_008/m2_7_336# u_t023_008/m2_717_2037#
+ u_t023_008/m2_1886_2031# u_t023_008/m2_2573_336# u_t023_008/m2_7_2898# u_t023_008/m2_2000_1265#
+ u_t023_008/m2_512_2037# u_t023_008/m2_1795_1265# u_t023_008/m2_1714_1982# u_t023_008/m2_1886_1259#
+ u_t023_008/m2_1290_2126# u_t023_008/m2_1714_438# u_t023_008/m2_431_1210# u_t023_008/m2_2573_2898#
+ u_t023_008/m2_2154_303# u_t023_008/m2_871_2081# VSUBS detronyx_12t_2w2r_rc4_4x4_routed_5layer_direct
Xgf180mcu_as_sc_mcu7t3v3__inv_2_631 gf180mcu_as_sc_mcu7t3v3__inv_2_632/VDD gf180mcu_as_sc_mcu7t3v3__inv_2_636/VDD
+ gf180mcu_as_sc_mcu7t3v3__inv_2_631/Y gf180mcu_as_sc_mcu7t3v3__inv_2_632/Y gf180mcu_as_sc_mcu7t3v3__inv_2_632/VNW
+ VSUBS gf180mcu_as_sc_mcu7t3v3__inv_2
Xgf180mcu_as_sc_mcu7t3v3__inv_2_686 gf180mcu_as_sc_mcu7t3v3__inv_2_688/VDD VSS gf180mcu_as_sc_mcu7t3v3__inv_2_686/Y
+ gf180mcu_as_sc_mcu7t3v3__inv_2_853/Y gf180mcu_as_sc_mcu7t3v3__inv_2_688/VNW VSUBS
+ gf180mcu_as_sc_mcu7t3v3__inv_2
Xgf180mcu_as_sc_mcu7t3v3__inv_2_664 gf180mcu_as_sc_mcu7t3v3__inv_2_664/VDD VSS gf180mcu_as_sc_mcu7t3v3__inv_2_664/Y
+ VSS gf180mcu_as_sc_mcu7t3v3__inv_2_664/VNW VSUBS gf180mcu_as_sc_mcu7t3v3__inv_2
Xgf180mcu_as_sc_mcu7t3v3__inv_2_642 gf180mcu_as_sc_mcu7t3v3__inv_2_679/VSS gf180mcu_as_sc_mcu7t3v3__inv_2_665/VSS
+ gf180mcu_as_sc_mcu7t3v3__inv_2_643/A VSS gf180mcu_as_sc_mcu7t3v3__inv_2_665/VNW
+ VSUBS gf180mcu_as_sc_mcu7t3v3__inv_2
Xgf180mcu_as_sc_mcu7t3v3__inv_2_675 VSS gf180mcu_as_sc_mcu7t3v3__inv_2_679/VSS gf180mcu_as_sc_mcu7t3v3__inv_2_675/Y
+ gf180mcu_as_sc_mcu7t3v3__inv_2_679/Y gf180mcu_as_sc_mcu7t3v3__inv_2_679/VNW VSUBS
+ gf180mcu_as_sc_mcu7t3v3__inv_2
Xgf180mcu_as_sc_mcu7t3v3__inv_2_653 gf180mcu_as_sc_mcu7t3v3__inv_2_689/VSS VSS gf180mcu_as_sc_mcu7t3v3__inv_2_653/Y
+ gf180mcu_as_sc_mcu7t3v3__inv_2_744/A gf180mcu_as_sc_mcu7t3v3__inv_2_661/VNW VSUBS
+ gf180mcu_as_sc_mcu7t3v3__inv_2
Xgf180mcu_as_sc_mcu7t3v3__inv_2_697 gf180mcu_as_sc_mcu7t3v3__inv_2_743/VSS VSS gf180mcu_as_sc_mcu7t3v3__inv_2_742/A
+ gf180mcu_as_sc_mcu7t3v3__inv_2_701/Y gf180mcu_as_sc_mcu7t3v3__inv_2_701/VNW VSUBS
+ gf180mcu_as_sc_mcu7t3v3__inv_2
Xu_t014_008 u_t014_008/c0_w0_bl u_t014_008/c0_w0_br u_t014_008/c0_w1_bl u_t014_008/c0_w1_br
+ u_t014_008/c0_r0_rbl u_t014_008/c0_r1_rbl u_t014_008/c1_w0_bl u_t014_008/c1_w0_br
+ u_t014_008/c1_w1_bl u_t014_008/c1_w1_br u_t014_008/c1_r0_rbl u_t014_008/c1_r1_rbl
+ u_t014_008/c2_w0_bl u_t014_008/c2_w0_br u_t014_008/c2_w1_bl u_t014_008/c2_w1_br
+ u_t014_008/c2_r0_rbl u_t014_008/c2_r1_rbl u_t014_008/c3_w0_bl u_t014_008/c3_w0_br
+ u_t014_008/c3_w1_bl u_t014_008/c3_w1_br u_t014_008/c3_r0_rbl u_t014_008/c3_r1_rbl
+ u_t014_008/r0_w0_wl u_t014_008/r0_w1_wl u_t014_008/r0_r0_rwl u_t014_008/r0_r1_rwl
+ u_t014_008/r1_w0_wl u_t014_008/r1_w1_wl u_t014_008/r1_r0_rwl u_t014_008/r1_r1_rwl
+ u_t014_008/r2_w0_wl u_t014_008/r2_w1_wl u_t014_008/r2_r0_rwl u_t014_008/r2_r1_rwl
+ u_t014_008/r3_w0_wl u_t014_008/r3_w1_wl u_t014_008/r3_r0_rwl u_t014_008/r3_r1_rwl
+ VSS u_t014_009/VSS u_t014_008/m2_717_1265# u_t014_008/m2_603_2031# u_t014_008/m2_1290_336#
+ u_t014_008/m2_2000_2037# u_t014_008/m2_791_2909# u_t014_008/m2_7_2126# u_t014_008/m2_2154_2081#
+ u_t014_008/m2_1795_2037# u_t014_008/m2_871_303# u_t014_008/m2_431_438# u_t014_008/m2_1290_2898#
+ u_t014_008/m2_1714_1210# u_t014_008/m2_431_1982# u_t014_008/m2_512_1265# u_t014_008/m2_2573_2126#
+ u_t014_008/m2_603_1259# u_t014_008/m2_2074_2909# u_t014_008/m2_7_336# u_t014_008/m2_717_2037#
+ u_t014_008/m2_1886_2031# u_t014_008/m2_2573_336# u_t014_008/m2_7_2898# u_t014_008/m2_2000_1265#
+ u_t014_008/m2_512_2037# u_t014_008/m2_1795_1265# u_t014_008/m2_1714_1982# u_t014_008/m2_1886_1259#
+ u_t014_008/m2_1290_2126# u_t014_008/m2_1714_438# u_t014_008/m2_431_1210# u_t014_008/m2_2573_2898#
+ u_t014_008/m2_2154_303# u_t014_008/m2_871_2081# VSUBS detronyx_12t_2w2r_rc4_4x4_routed_5layer_direct
Xu_t005_008 u_t005_008/c0_w0_bl u_t005_008/c0_w0_br u_t005_008/c0_w1_bl u_t005_008/c0_w1_br
+ u_t005_008/c0_r0_rbl u_t005_008/c0_r1_rbl u_t005_008/c1_w0_bl u_t005_008/c1_w0_br
+ u_t005_008/c1_w1_bl u_t005_008/c1_w1_br u_t005_008/c1_r0_rbl u_t005_008/c1_r1_rbl
+ u_t005_008/c2_w0_bl u_t005_008/c2_w0_br u_t005_008/c2_w1_bl u_t005_008/c2_w1_br
+ u_t005_008/c2_r0_rbl u_t005_008/c2_r1_rbl u_t005_008/c3_w0_bl u_t005_008/c3_w0_br
+ u_t005_008/c3_w1_bl u_t005_008/c3_w1_br u_t005_008/c3_r0_rbl u_t005_008/c3_r1_rbl
+ u_t005_008/r0_w0_wl u_t005_008/r0_w1_wl u_t005_008/r0_r0_rwl u_t005_008/r0_r1_rwl
+ u_t005_008/r1_w0_wl u_t005_008/r1_w1_wl u_t005_008/r1_r0_rwl u_t005_008/r1_r1_rwl
+ u_t005_008/r2_w0_wl u_t005_008/r2_w1_wl u_t005_008/r2_r0_rwl u_t005_008/r2_r1_rwl
+ u_t005_008/r3_w0_wl u_t005_008/r3_w1_wl u_t005_008/r3_r0_rwl u_t005_008/r3_r1_rwl
+ VSS VSS u_t005_008/m2_717_1265# u_t005_008/m2_603_2031# u_t005_008/m2_1290_336#
+ u_t005_008/m2_2000_2037# u_t005_008/m2_791_2909# u_t005_008/m2_7_2126# u_t005_008/m2_2154_2081#
+ u_t005_008/m2_1795_2037# u_t005_008/m2_871_303# u_t005_008/m2_431_438# u_t005_008/m2_1290_2898#
+ u_t005_008/m2_1714_1210# u_t005_008/m2_431_1982# u_t005_008/m2_512_1265# u_t005_008/m2_2573_2126#
+ u_t005_008/m2_603_1259# u_t005_008/m2_2074_2909# u_t005_008/m2_7_336# u_t005_008/m2_717_2037#
+ u_t005_008/m2_1886_2031# u_t005_008/m2_2573_336# u_t005_008/m2_7_2898# u_t005_008/m2_2000_1265#
+ u_t005_008/m2_512_2037# u_t005_008/m2_1795_1265# u_t005_008/m2_1714_1982# u_t005_008/m2_1886_1259#
+ u_t005_008/m2_1290_2126# u_t005_008/m2_1714_438# u_t005_008/m2_431_1210# u_t005_008/m2_2573_2898#
+ u_t005_008/m2_2154_303# u_t005_008/m2_871_2081# VSUBS detronyx_12t_2w2r_rc4_4x4_routed_5layer_direct
Xgf180mcu_as_sc_mcu7t3v3__inv_2_461 gf180mcu_as_sc_mcu7t3v3__nor2_2_6/VDD gf180mcu_as_sc_mcu7t3v3__nand3_2_4/VSS
+ gf180mcu_as_sc_mcu7t3v3__inv_2_461/Y VSS gf180mcu_as_sc_mcu7t3v3__nor2_2_6/VNW VSUBS
+ gf180mcu_as_sc_mcu7t3v3__inv_2
Xgf180mcu_as_sc_mcu7t3v3__inv_2_472 gf180mcu_as_sc_mcu7t3v3__nor2_2_6/VDD gf180mcu_as_sc_mcu7t3v3__nand3_2_4/VSS
+ VSS VSS gf180mcu_as_sc_mcu7t3v3__nor2_2_6/VNW VSUBS gf180mcu_as_sc_mcu7t3v3__inv_2
Xgf180mcu_as_sc_mcu7t3v3__inv_2_450 gf180mcu_as_sc_mcu7t3v3__nand3_2_9/VDD gf180mcu_as_sc_mcu7t3v3__nor2_2_4/VSS
+ VSS VSS gf180mcu_as_sc_mcu7t3v3__nand3_2_9/VNW VSUBS gf180mcu_as_sc_mcu7t3v3__inv_2
Xgf180mcu_as_sc_mcu7t3v3__inv_2_483 VSS VSS gf180mcu_as_sc_mcu7t3v3__inv_2_483/Y VSS
+ gf180mcu_as_sc_mcu7t3v3__inv_2_549/VNW VSUBS gf180mcu_as_sc_mcu7t3v3__inv_2
Xgf180mcu_as_sc_mcu7t3v3__inv_2_494 VSS VSS gf180mcu_as_sc_mcu7t3v3__inv_2_494/Y VSS
+ gf180mcu_as_sc_mcu7t3v3__inv_2_554/VNW VSUBS gf180mcu_as_sc_mcu7t3v3__inv_2
Xu_t010_011 u_t010_011/c0_w0_bl u_t010_011/c0_w0_br u_t010_011/c0_w1_bl u_t010_011/c0_w1_br
+ u_t010_011/c0_r0_rbl u_t010_011/c0_r1_rbl u_t010_011/c1_w0_bl u_t010_011/c1_w0_br
+ u_t010_011/c1_w1_bl u_t010_011/c1_w1_br u_t010_011/c1_r0_rbl u_t010_011/c1_r1_rbl
+ u_t010_011/c2_w0_bl u_t010_011/c2_w0_br u_t010_011/c2_w1_bl u_t010_011/c2_w1_br
+ u_t010_011/c2_r0_rbl u_t010_011/c2_r1_rbl u_t010_011/c3_w0_bl u_t010_011/c3_w0_br
+ u_t010_011/c3_w1_bl u_t010_011/c3_w1_br u_t010_011/c3_r0_rbl u_t010_011/c3_r1_rbl
+ u_t010_011/r0_w0_wl u_t010_011/r0_w1_wl u_t010_011/r0_r0_rwl u_t010_011/r0_r1_rwl
+ u_t010_011/r1_w0_wl u_t010_011/r1_w1_wl u_t010_011/r1_r0_rwl u_t010_011/r1_r1_rwl
+ u_t010_011/r2_w0_wl u_t010_011/r2_w1_wl u_t010_011/r2_r0_rwl u_t010_011/r2_r1_rwl
+ u_t010_011/r3_w0_wl u_t010_011/r3_w1_wl u_t010_011/r3_r0_rwl u_t010_011/r3_r1_rwl
+ u_t010_011/VDD u_t010_011/VSS u_t010_011/m2_717_1265# u_t010_011/m2_603_2031# u_t010_011/m2_1290_336#
+ u_t010_011/m2_2000_2037# u_t010_011/m2_791_2909# u_t010_011/m2_7_2126# u_t010_011/m2_2154_2081#
+ u_t010_011/m2_1795_2037# u_t010_011/m2_871_303# u_t010_011/m2_431_438# u_t010_011/m2_1290_2898#
+ u_t010_011/m2_1714_1210# u_t010_011/m2_431_1982# u_t010_011/m2_512_1265# u_t010_011/m2_2573_2126#
+ u_t010_011/m2_603_1259# u_t010_011/m2_2074_2909# u_t010_011/m2_7_336# u_t010_011/m2_717_2037#
+ u_t010_011/m2_1886_2031# u_t010_011/m2_2573_336# u_t010_011/m2_7_2898# u_t010_011/m2_2000_1265#
+ u_t010_011/m2_512_2037# u_t010_011/m2_1795_1265# u_t010_011/m2_1714_1982# u_t010_011/m2_1886_1259#
+ u_t010_011/m2_1290_2126# u_t010_011/m2_1714_438# u_t010_011/m2_431_1210# u_t010_011/m2_2573_2898#
+ u_t010_011/m2_2154_303# u_t010_011/m2_871_2081# VSUBS detronyx_12t_2w2r_rc4_4x4_routed_5layer_direct
Xu_t010_000 VSS u_t010_000/c0_w0_br VSS u_t010_000/c0_w1_br u_t010_000/c0_r0_rbl u_t010_000/c0_r1_rbl
+ VSS VSS VSS VSS VSS VSS u_t010_000/c2_w0_bl u_t010_000/c2_w0_br u_t010_000/c2_w1_bl
+ u_t010_000/c2_w1_br u_t010_000/c2_r0_rbl u_t010_000/c2_r1_rbl u_t010_000/c3_w0_bl
+ u_t010_000/c3_w0_br u_t010_000/c3_w1_bl u_t010_000/c3_w1_br u_t010_000/c3_r0_rbl
+ u_t010_000/c3_r1_rbl VSS VSS VSS VSS VSS VSS VSS VSS VSS VSS VSS VSS VSS VSS VSS
+ VSS VSS VSS u_t010_000/m2_717_1265# u_t010_000/m2_603_2031# u_t010_000/m2_1290_336#
+ u_t010_000/m2_2000_2037# u_t010_000/m2_791_2909# u_t010_000/m2_7_2126# u_t010_000/m2_2154_2081#
+ u_t010_000/m2_1795_2037# u_t010_000/m2_871_303# u_t010_000/m2_431_438# u_t010_000/m2_1290_2898#
+ u_t010_000/m2_1714_1210# u_t010_000/m2_431_1982# u_t010_000/m2_512_1265# u_t010_000/m2_2573_2126#
+ u_t010_000/m2_603_1259# u_t010_000/m2_2074_2909# u_t010_000/m2_7_336# u_t010_000/m2_717_2037#
+ u_t010_000/m2_1886_2031# u_t010_000/m2_2573_336# u_t010_000/m2_7_2898# u_t010_000/m2_2000_1265#
+ u_t010_000/m2_512_2037# u_t010_000/m2_1795_1265# u_t010_000/m2_1714_1982# u_t010_000/m2_1886_1259#
+ u_t010_000/m2_1290_2126# u_t010_000/m2_1714_438# u_t010_000/m2_431_1210# u_t010_000/m2_2573_2898#
+ u_t010_000/m2_2154_303# u_t010_000/m2_871_2081# VSUBS detronyx_12t_2w2r_rc4_4x4_routed_5layer_direct
Xu_t001_011 u_t001_011/c0_w0_bl u_t001_011/c0_w0_br u_t001_011/c0_w1_bl u_t001_011/c0_w1_br
+ u_t001_011/c0_r0_rbl u_t001_011/c0_r1_rbl u_t001_011/c1_w0_bl u_t001_011/c1_w0_br
+ u_t001_011/c1_w1_bl u_t001_011/c1_w1_br u_t001_011/c1_r0_rbl u_t001_011/c1_r1_rbl
+ u_t001_011/c2_w0_bl u_t001_011/c2_w0_br u_t001_011/c2_w1_bl u_t001_011/c2_w1_br
+ u_t001_011/c2_r0_rbl u_t001_011/c2_r1_rbl u_t001_011/c3_w0_bl u_t001_011/c3_w0_br
+ u_t001_011/c3_w1_bl u_t001_011/c3_w1_br u_t001_011/c3_r0_rbl u_t001_011/c3_r1_rbl
+ u_t001_011/r0_w0_wl u_t001_011/r0_w1_wl u_t001_011/r0_r0_rwl u_t001_011/r0_r1_rwl
+ u_t001_011/r1_w0_wl u_t001_011/r1_w1_wl u_t001_011/r1_r0_rwl u_t001_011/r1_r1_rwl
+ u_t001_011/r2_w0_wl u_t001_011/r2_w1_wl u_t001_011/r2_r0_rwl u_t001_011/r2_r1_rwl
+ u_t001_011/r3_w0_wl u_t001_011/r3_w1_wl u_t001_011/r3_r0_rwl u_t001_011/r3_r1_rwl
+ u_t001_011/VDD VSS u_t001_011/m2_717_1265# u_t001_011/m2_603_2031# u_t001_011/m2_1290_336#
+ u_t001_011/m2_2000_2037# u_t001_011/m2_791_2909# u_t001_011/m2_7_2126# u_t001_011/m2_2154_2081#
+ u_t001_011/m2_1795_2037# u_t001_011/m2_871_303# u_t001_011/m2_431_438# u_t001_011/m2_1290_2898#
+ u_t001_011/m2_1714_1210# u_t001_011/m2_431_1982# u_t001_011/m2_512_1265# u_t001_011/m2_2573_2126#
+ u_t001_011/m2_603_1259# u_t001_011/m2_2074_2909# u_t001_011/m2_7_336# u_t001_011/m2_717_2037#
+ u_t001_011/m2_1886_2031# u_t001_011/m2_2573_336# u_t001_011/m2_7_2898# u_t001_011/m2_2000_1265#
+ u_t001_011/m2_512_2037# u_t001_011/m2_1795_1265# u_t001_011/m2_1714_1982# u_t001_011/m2_1886_1259#
+ u_t001_011/m2_1290_2126# u_t001_011/m2_1714_438# u_t001_011/m2_431_1210# u_t001_011/m2_2573_2898#
+ u_t001_011/m2_2154_303# u_t001_011/m2_871_2081# VSUBS detronyx_12t_2w2r_rc4_4x4_routed_5layer_direct
Xu_t001_000 VSS u_t001_000/c0_w0_br VSS u_t001_000/c0_w1_br u_t001_000/c0_r0_rbl u_t001_000/c0_r1_rbl
+ VSS VSS VSS VSS VSS VSS u_t001_000/c2_w0_bl u_t001_000/c2_w0_br u_t001_000/c2_w1_bl
+ u_t001_000/c2_w1_br u_t001_000/c2_r0_rbl u_t001_000/c2_r1_rbl u_t001_000/c3_w0_bl
+ u_t001_000/c3_w0_br u_t001_000/c3_w1_bl u_t001_000/c3_w1_br u_t001_000/c3_r0_rbl
+ u_t001_000/c3_r1_rbl VSS VSS VSS VSS VSS VSS VSS VSS VSS VSS VSS VSS VSS VSS VSS
+ VSS VSS VSS u_t001_000/m2_717_1265# u_t001_000/m2_603_2031# u_t001_000/m2_1290_336#
+ u_t001_000/m2_2000_2037# u_t001_000/m2_791_2909# u_t001_000/m2_7_2126# u_t001_000/m2_2154_2081#
+ u_t001_000/m2_1795_2037# u_t001_000/m2_871_303# u_t001_000/m2_431_438# u_t001_000/m2_1290_2898#
+ u_t001_000/m2_1714_1210# u_t001_000/m2_431_1982# u_t001_000/m2_512_1265# u_t001_000/m2_2573_2126#
+ u_t001_000/m2_603_1259# u_t001_000/m2_2074_2909# u_t001_000/m2_7_336# u_t001_000/m2_717_2037#
+ u_t001_000/m2_1886_2031# u_t001_000/m2_2573_336# u_t001_000/m2_7_2898# u_t001_000/m2_2000_1265#
+ u_t001_000/m2_512_2037# u_t001_000/m2_1795_1265# u_t001_000/m2_1714_1982# u_t001_000/m2_1886_1259#
+ u_t001_000/m2_1290_2126# u_t001_000/m2_1714_438# u_t001_000/m2_431_1210# u_t001_000/m2_2573_2898#
+ u_t001_000/m2_2154_303# u_t001_000/m2_871_2081# VSUBS detronyx_12t_2w2r_rc4_4x4_routed_5layer_direct
Xgf180mcu_as_sc_mcu7t3v3__inv_2_280 VSS VSS gf180mcu_as_sc_mcu7t3v3__inv_2_61/Y VSS
+ gf180mcu_as_sc_mcu7t3v3__inv_2_280/VNW VSUBS gf180mcu_as_sc_mcu7t3v3__inv_2
Xgf180mcu_as_sc_mcu7t3v3__inv_2_291 gf180mcu_as_sc_mcu7t3v3__inv_2_304/VSS VSS gf180mcu_as_sc_mcu7t3v3__inv_2_291/Y
+ gf180mcu_as_sc_mcu7t3v3__inv_2_304/A gf180mcu_as_sc_mcu7t3v3__inv_2_303/VNW VSUBS
+ gf180mcu_as_sc_mcu7t3v3__inv_2
Xgf180mcu_as_sc_mcu7t3v3__inv_2_1713 gf180mcu_as_sc_mcu7t3v3__nor2_2_9/VDD gf180mcu_as_sc_mcu7t3v3__nor2_2_9/VSS
+ VSS VSS gf180mcu_as_sc_mcu7t3v3__nor2_2_9/VNW VSUBS gf180mcu_as_sc_mcu7t3v3__inv_2
Xgf180mcu_as_sc_mcu7t3v3__inv_2_1702 gf180mcu_as_sc_mcu7t3v3__nor2_2_7/VDD gf180mcu_as_sc_mcu7t3v3__nor2_2_7/VSS
+ VSS VSS gf180mcu_as_sc_mcu7t3v3__nor2_2_7/VNW VSUBS gf180mcu_as_sc_mcu7t3v3__inv_2
Xgf180mcu_as_sc_mcu7t3v3__inv_2_1724 gf180mcu_as_sc_mcu7t3v3__inv_2_960/VSS VSS gf180mcu_as_sc_mcu7t3v3__inv_2_1724/Y
+ gf180mcu_as_sc_mcu7t3v3__inv_2_1724/A gf180mcu_as_sc_mcu7t3v3__inv_2_1726/VNW VSUBS
+ gf180mcu_as_sc_mcu7t3v3__inv_2
Xgf180mcu_as_sc_mcu7t3v3__nand4_2_507 VSS VSS VSS VSS VSS VSS VSS gf180mcu_as_sc_mcu7t3v3__inv_2_1631/VNW
+ VSUBS gf180mcu_as_sc_mcu7t3v3__nand4_2
Xgf180mcu_as_sc_mcu7t3v3__inv_2_28 gf180mcu_as_sc_mcu7t3v3__inv_2_66/VSS gf180mcu_as_sc_mcu7t3v3__inv_2_32/VDD
+ gf180mcu_as_sc_mcu7t3v3__inv_2_66/Y VSS gf180mcu_as_sc_mcu7t3v3__inv_2_28/VNW VSUBS
+ gf180mcu_as_sc_mcu7t3v3__inv_2
Xgf180mcu_as_sc_mcu7t3v3__inv_2_39 gf180mcu_as_sc_mcu7t3v3__inv_2_0/VSS gf180mcu_as_sc_mcu7t3v3__inv_2_49/VDD
+ gf180mcu_as_sc_mcu7t3v3__inv_2_39/Y gf180mcu_as_sc_mcu7t3v3__inv_2_9/Y gf180mcu_as_sc_mcu7t3v3__inv_2_43/VNW
+ VSUBS gf180mcu_as_sc_mcu7t3v3__inv_2
Xgf180mcu_as_sc_mcu7t3v3__inv_2_17 gf180mcu_as_sc_mcu7t3v3__inv_2_9/VSS gf180mcu_as_sc_mcu7t3v3__inv_2_38/VDD
+ VSS gf180mcu_as_sc_mcu7t3v3__inv_2_9/Y gf180mcu_as_sc_mcu7t3v3__inv_2_25/VNW VSUBS
+ gf180mcu_as_sc_mcu7t3v3__inv_2
Xgf180mcu_as_sc_mcu7t3v3__inv_2_1009 gf180mcu_as_sc_mcu7t3v3__inv_2_1058/VDD gf180mcu_as_sc_mcu7t3v3__inv_2_1058/VSS
+ gf180mcu_as_sc_mcu7t3v3__inv_2_1009/Y gf180mcu_as_sc_mcu7t3v3__inv_2_1013/Y gf180mcu_as_sc_mcu7t3v3__inv_2_1058/VNW
+ VSUBS gf180mcu_as_sc_mcu7t3v3__inv_2
Xgf180mcu_as_sc_mcu7t3v3__inv_2_1510 gf180mcu_as_sc_mcu7t3v3__inv_2_1511/VDD gf180mcu_as_sc_mcu7t3v3__inv_2_1511/VSS
+ gf180mcu_as_sc_mcu7t3v3__inv_2_1510/Y VSS gf180mcu_as_sc_mcu7t3v3__inv_2_1511/VNW
+ VSUBS gf180mcu_as_sc_mcu7t3v3__inv_2
Xgf180mcu_as_sc_mcu7t3v3__inv_2_1565 gf180mcu_as_sc_mcu7t3v3__inv_2_1598/VSS VSS VSS
+ VSS gf180mcu_as_sc_mcu7t3v3__inv_2_1587/VNW VSUBS gf180mcu_as_sc_mcu7t3v3__inv_2
Xgf180mcu_as_sc_mcu7t3v3__inv_2_1598 gf180mcu_as_sc_mcu7t3v3__inv_2_1598/VDD gf180mcu_as_sc_mcu7t3v3__inv_2_1598/VSS
+ VSS VSS gf180mcu_as_sc_mcu7t3v3__inv_2_1598/VNW VSUBS gf180mcu_as_sc_mcu7t3v3__inv_2
Xgf180mcu_as_sc_mcu7t3v3__inv_2_1587 gf180mcu_as_sc_mcu7t3v3__inv_2_1598/VSS VSS VSS
+ VSS gf180mcu_as_sc_mcu7t3v3__inv_2_1587/VNW VSUBS gf180mcu_as_sc_mcu7t3v3__inv_2
Xgf180mcu_as_sc_mcu7t3v3__inv_2_1576 VSS VSS VSS VSS gf180mcu_as_sc_mcu7t3v3__inv_2_1576/VNW
+ VSUBS gf180mcu_as_sc_mcu7t3v3__inv_2
Xgf180mcu_as_sc_mcu7t3v3__inv_2_1543 VSS gf180mcu_as_sc_mcu7t3v3__inv_2_1547/VDD gf180mcu_as_sc_mcu7t3v3__inv_2_1543/Y
+ VSS gf180mcu_as_sc_mcu7t3v3__inv_2_1544/VNW VSUBS gf180mcu_as_sc_mcu7t3v3__inv_2
Xgf180mcu_as_sc_mcu7t3v3__inv_2_1554 gf180mcu_as_sc_mcu7t3v3__inv_2_1556/VDD VSS VSS
+ VSS gf180mcu_as_sc_mcu7t3v3__inv_2_1556/VNW VSUBS gf180mcu_as_sc_mcu7t3v3__inv_2
Xgf180mcu_as_sc_mcu7t3v3__inv_2_1521 gf180mcu_as_sc_mcu7t3v3__inv_2_1523/VDD VSS VSS
+ VSS gf180mcu_as_sc_mcu7t3v3__inv_2_1523/VNW VSUBS gf180mcu_as_sc_mcu7t3v3__inv_2
Xgf180mcu_as_sc_mcu7t3v3__inv_2_1532 gf180mcu_as_sc_mcu7t3v3__inv_2_1532/VDD VSS gf180mcu_as_sc_mcu7t3v3__inv_2_1532/Y
+ VSS gf180mcu_as_sc_mcu7t3v3__inv_2_1532/VNW VSUBS gf180mcu_as_sc_mcu7t3v3__inv_2
Xgf180mcu_as_sc_mcu7t3v3__nand3_2_9 gf180mcu_as_sc_mcu7t3v3__nand3_2_9/VDD gf180mcu_as_sc_mcu7t3v3__nor2_2_4/VSS
+ VSS VSS VSS VSS gf180mcu_as_sc_mcu7t3v3__nand3_2_9/VNW VSUBS gf180mcu_as_sc_mcu7t3v3__nand3_2
Xgf180mcu_as_sc_mcu7t3v3__nand4_2_326 VSS gf180mcu_as_sc_mcu7t3v3__inv_2_1103/VDD
+ VSS VSS VSS VSS VSS gf180mcu_as_sc_mcu7t3v3__inv_2_1099/VNW VSUBS gf180mcu_as_sc_mcu7t3v3__nand4_2
Xgf180mcu_as_sc_mcu7t3v3__nand4_2_315 gf180mcu_as_sc_mcu7t3v3__inv_2_1049/VDD VSS
+ VSS VSS VSS VSS VSS gf180mcu_as_sc_mcu7t3v3__inv_2_1049/VNW VSUBS gf180mcu_as_sc_mcu7t3v3__nand4_2
Xgf180mcu_as_sc_mcu7t3v3__nand4_2_304 VSS VSS VSS VSS VSS VSS VSS gf180mcu_as_sc_mcu7t3v3__inv_2_1040/VNW
+ VSUBS gf180mcu_as_sc_mcu7t3v3__nand4_2
Xgf180mcu_as_sc_mcu7t3v3__nand4_2_337 VSS gf180mcu_as_sc_mcu7t3v3__inv_2_1139/VDD
+ VSS VSS VSS VSS VSS gf180mcu_as_sc_mcu7t3v3__inv_2_1136/VNW VSUBS gf180mcu_as_sc_mcu7t3v3__nand4_2
Xgf180mcu_as_sc_mcu7t3v3__nand4_2_348 VSS VSS VSS VSS VSS VSS VSS gf180mcu_as_sc_mcu7t3v3__inv_2_1289/VNW
+ VSUBS gf180mcu_as_sc_mcu7t3v3__nand4_2
Xgf180mcu_as_sc_mcu7t3v3__nand4_2_359 VSS VSS VSS VSS VSS VSS VSS gf180mcu_as_sc_mcu7t3v3__inv_2_1299/VNW
+ VSUBS gf180mcu_as_sc_mcu7t3v3__nand4_2
Xu_t029_014 u_t029_014/c0_w0_bl u_t029_014/c0_w0_br u_t029_014/c0_w1_bl u_t029_014/c0_w1_br
+ u_t029_014/c0_r0_rbl u_t029_014/c0_r1_rbl u_t029_014/c1_w0_bl u_t029_014/c1_w0_br
+ u_t029_014/c1_w1_bl u_t029_014/c1_w1_br u_t029_014/c1_r0_rbl u_t029_014/c1_r1_rbl
+ u_t029_014/c2_w0_bl u_t029_014/c2_w0_br u_t029_014/c2_w1_bl u_t029_014/c2_w1_br
+ u_t029_014/c2_r0_rbl u_t029_014/c2_r1_rbl u_t029_014/c3_w0_bl u_t029_014/c3_w0_br
+ u_t029_014/c3_w1_bl u_t029_014/c3_w1_br u_t029_014/c3_r0_rbl u_t029_014/c3_r1_rbl
+ u_t029_014/r0_w0_wl u_t029_014/r0_w1_wl u_t029_014/r0_r0_rwl u_t029_014/r0_r1_rwl
+ u_t029_014/r1_w0_wl u_t029_014/r1_w1_wl u_t029_014/r1_r0_rwl u_t029_014/r1_r1_rwl
+ u_t029_014/r2_w0_wl u_t029_014/r2_w1_wl u_t029_014/r2_r0_rwl u_t029_014/r2_r1_rwl
+ u_t029_014/r3_w0_wl u_t029_014/r3_w1_wl u_t029_014/r3_r0_rwl u_t029_014/r3_r1_rwl
+ u_t029_014/VDD VSS u_t029_014/m2_717_1265# u_t029_014/m2_603_2031# u_t029_014/m2_1290_336#
+ u_t029_014/m2_2000_2037# u_t029_014/m2_791_2909# u_t029_014/m2_7_2126# u_t029_014/m2_2154_2081#
+ u_t029_014/m2_1795_2037# u_t029_014/m2_871_303# u_t029_014/m2_431_438# u_t029_014/m2_1290_2898#
+ u_t029_014/m2_1714_1210# u_t029_014/m2_431_1982# u_t029_014/m2_512_1265# u_t029_014/m2_2573_2126#
+ u_t029_014/m2_603_1259# u_t029_014/m2_2074_2909# u_t029_014/m2_7_336# u_t029_014/m2_717_2037#
+ u_t029_014/m2_1886_2031# u_t029_014/m2_2573_336# u_t029_014/m2_7_2898# u_t029_014/m2_2000_1265#
+ u_t029_014/m2_512_2037# u_t029_014/m2_1795_1265# u_t029_014/m2_1714_1982# u_t029_014/m2_1886_1259#
+ u_t029_014/m2_1290_2126# u_t029_014/m2_1714_438# u_t029_014/m2_431_1210# u_t029_014/m2_2573_2898#
+ u_t029_014/m2_2154_303# u_t029_014/m2_871_2081# VSUBS detronyx_12t_2w2r_rc4_4x4_routed_5layer_direct
Xu_t029_003 u_t029_003/c0_w0_bl u_t029_003/c0_w0_br u_t029_003/c0_w1_bl u_t029_003/c0_w1_br
+ u_t029_003/c0_r0_rbl u_t029_003/c0_r1_rbl u_t029_003/c1_w0_bl u_t029_003/c1_w0_br
+ u_t029_003/c1_w1_bl u_t029_003/c1_w1_br u_t029_003/c1_r0_rbl u_t029_003/c1_r1_rbl
+ u_t029_003/c2_w0_bl u_t029_003/c2_w0_br u_t029_003/c2_w1_bl u_t029_003/c2_w1_br
+ u_t029_003/c2_r0_rbl u_t029_003/c2_r1_rbl u_t029_003/c3_w0_bl u_t029_003/c3_w0_br
+ u_t029_003/c3_w1_bl u_t029_003/c3_w1_br u_t029_003/c3_r0_rbl u_t029_003/c3_r1_rbl
+ u_t029_003/r0_w0_wl u_t029_003/r0_w1_wl u_t029_003/r0_r0_rwl u_t029_003/r0_r1_rwl
+ u_t029_003/r1_w0_wl u_t029_003/r1_w1_wl u_t029_003/r1_r0_rwl u_t029_003/r1_r1_rwl
+ u_t029_003/r2_w0_wl u_t029_003/r2_w1_wl u_t029_003/r2_r0_rwl u_t029_003/r2_r1_rwl
+ u_t029_003/r3_w0_wl u_t029_003/r3_w1_wl u_t029_003/r3_r0_rwl u_t029_003/r3_r1_rwl
+ u_t029_003/VDD VSS u_t029_003/m2_717_1265# u_t029_003/m2_603_2031# u_t029_003/m2_1290_336#
+ u_t029_003/m2_2000_2037# u_t029_003/m2_791_2909# u_t029_003/m2_7_2126# u_t029_003/m2_2154_2081#
+ u_t029_003/m2_1795_2037# u_t029_003/m2_871_303# u_t029_003/m2_431_438# u_t029_003/m2_1290_2898#
+ u_t029_003/m2_1714_1210# u_t029_003/m2_431_1982# u_t029_003/m2_512_1265# u_t029_003/m2_2573_2126#
+ u_t029_003/m2_603_1259# u_t029_003/m2_2074_2909# u_t029_003/m2_7_336# u_t029_003/m2_717_2037#
+ u_t029_003/m2_1886_2031# u_t029_003/m2_2573_336# u_t029_003/m2_7_2898# u_t029_003/m2_2000_1265#
+ u_t029_003/m2_512_2037# u_t029_003/m2_1795_1265# u_t029_003/m2_1714_1982# u_t029_003/m2_1886_1259#
+ u_t029_003/m2_1290_2126# u_t029_003/m2_1714_438# u_t029_003/m2_431_1210# u_t029_003/m2_2573_2898#
+ u_t029_003/m2_2154_303# u_t029_003/m2_871_2081# VSUBS detronyx_12t_2w2r_rc4_4x4_routed_5layer_direct
Xgf180mcu_as_sc_mcu7t3v3__inv_2_1362 VSS gf180mcu_as_sc_mcu7t3v3__inv_2_1366/VDD gf180mcu_as_sc_mcu7t3v3__inv_2_1694/Y
+ VSS gf180mcu_as_sc_mcu7t3v3__inv_2_1362/VNW VSUBS gf180mcu_as_sc_mcu7t3v3__inv_2
Xgf180mcu_as_sc_mcu7t3v3__inv_2_1351 gf180mcu_as_sc_mcu7t3v3__inv_2_1352/VDD gf180mcu_as_sc_mcu7t3v3__inv_2_1355/VDD
+ gf180mcu_as_sc_mcu7t3v3__inv_2_1351/Y gf180mcu_as_sc_mcu7t3v3__inv_2_1355/Y gf180mcu_as_sc_mcu7t3v3__inv_2_1352/VNW
+ VSUBS gf180mcu_as_sc_mcu7t3v3__inv_2
Xgf180mcu_as_sc_mcu7t3v3__inv_2_1340 gf180mcu_as_sc_mcu7t3v3__inv_2_1340/VDD VSS gf180mcu_as_sc_mcu7t3v3__inv_2_1340/Y
+ VSS gf180mcu_as_sc_mcu7t3v3__inv_2_1340/VNW VSUBS gf180mcu_as_sc_mcu7t3v3__inv_2
Xgf180mcu_as_sc_mcu7t3v3__inv_2_1373 VSS gf180mcu_as_sc_mcu7t3v3__inv_2_1378/VDD gf180mcu_as_sc_mcu7t3v3__inv_2_1382/Y
+ gf180mcu_as_sc_mcu7t3v3__inv_2_1382/Y gf180mcu_as_sc_mcu7t3v3__inv_2_1374/VNW VSUBS
+ gf180mcu_as_sc_mcu7t3v3__inv_2
Xgf180mcu_as_sc_mcu7t3v3__inv_2_1384 VSS VSS VSS gf180mcu_as_sc_mcu7t3v3__inv_2_1394/Y
+ gf180mcu_as_sc_mcu7t3v3__inv_2_1386/VNW VSUBS gf180mcu_as_sc_mcu7t3v3__inv_2
Xgf180mcu_as_sc_mcu7t3v3__inv_2_1395 gf180mcu_as_sc_mcu7t3v3__inv_2_1406/VSS VSS gf180mcu_as_sc_mcu7t3v3__inv_2_1409/A
+ gf180mcu_as_sc_mcu7t3v3__inv_2_1409/A gf180mcu_as_sc_mcu7t3v3__inv_2_1395/VNW VSUBS
+ gf180mcu_as_sc_mcu7t3v3__inv_2
Xgf180mcu_as_sc_mcu7t3v3__inv_2_802 VSS VSS VSS VSS gf180mcu_as_sc_mcu7t3v3__inv_2_837/VNW
+ VSUBS gf180mcu_as_sc_mcu7t3v3__inv_2
Xgf180mcu_as_sc_mcu7t3v3__inv_2_857 VSS VSS VSS VSS gf180mcu_as_sc_mcu7t3v3__inv_2_857/VNW
+ VSUBS gf180mcu_as_sc_mcu7t3v3__inv_2
Xgf180mcu_as_sc_mcu7t3v3__inv_2_824 VSS VSS VSS VSS gf180mcu_as_sc_mcu7t3v3__inv_2_824/VNW
+ VSUBS gf180mcu_as_sc_mcu7t3v3__inv_2
Xgf180mcu_as_sc_mcu7t3v3__inv_2_835 VSS VSS VSS VSS gf180mcu_as_sc_mcu7t3v3__inv_2_835/VNW
+ VSUBS gf180mcu_as_sc_mcu7t3v3__inv_2
Xgf180mcu_as_sc_mcu7t3v3__inv_2_846 VSS VSS VSS VSS gf180mcu_as_sc_mcu7t3v3__inv_2_846/VNW
+ VSUBS gf180mcu_as_sc_mcu7t3v3__inv_2
Xgf180mcu_as_sc_mcu7t3v3__inv_2_813 VSS VSS VSS VSS gf180mcu_as_sc_mcu7t3v3__inv_2_841/VNW
+ VSUBS gf180mcu_as_sc_mcu7t3v3__inv_2
Xgf180mcu_as_sc_mcu7t3v3__inv_2_879 VSS VSS VSS VSS gf180mcu_as_sc_mcu7t3v3__inv_2_932/VNW
+ VSUBS gf180mcu_as_sc_mcu7t3v3__inv_2
Xgf180mcu_as_sc_mcu7t3v3__inv_2_868 VSS VSS gf180mcu_as_sc_mcu7t3v3__inv_2_868/Y VSS
+ gf180mcu_as_sc_mcu7t3v3__inv_2_928/VNW VSUBS gf180mcu_as_sc_mcu7t3v3__inv_2
Xgf180mcu_as_sc_mcu7t3v3__nand4_2_145 VSS VSS VSS VSS VSS VSS gf180mcu_as_sc_mcu7t3v3__nand4_2_145/Y
+ gf180mcu_as_sc_mcu7t3v3__inv_2_557/VNW VSUBS gf180mcu_as_sc_mcu7t3v3__nand4_2
Xgf180mcu_as_sc_mcu7t3v3__nand4_2_156 gf180mcu_as_sc_mcu7t3v3__inv_2_590/VSS gf180mcu_as_sc_mcu7t3v3__inv_2_570/VDD
+ VSS VSS VSS VSS VSS gf180mcu_as_sc_mcu7t3v3__inv_2_567/VNW VSUBS gf180mcu_as_sc_mcu7t3v3__nand4_2
Xgf180mcu_as_sc_mcu7t3v3__nand4_2_134 VSS VSS VSS VSS VSS VSS VSS gf180mcu_as_sc_mcu7t3v3__inv_2_553/VNW
+ VSUBS gf180mcu_as_sc_mcu7t3v3__nand4_2
Xgf180mcu_as_sc_mcu7t3v3__nand4_2_167 gf180mcu_as_sc_mcu7t3v3__inv_2_636/VDD gf180mcu_as_sc_mcu7t3v3__inv_2_638/VSS
+ VSS VSS VSS VSS VSS gf180mcu_as_sc_mcu7t3v3__inv_2_636/VNW VSUBS gf180mcu_as_sc_mcu7t3v3__nand4_2
Xgf180mcu_as_sc_mcu7t3v3__nand4_2_123 gf180mcu_as_sc_mcu7t3v3__inv_2_308/VDD gf180mcu_as_sc_mcu7t3v3__inv_2_308/VSS
+ VSS VSS VSS VSS VSS gf180mcu_as_sc_mcu7t3v3__inv_2_308/VNW VSUBS gf180mcu_as_sc_mcu7t3v3__nand4_2
Xgf180mcu_as_sc_mcu7t3v3__nand4_2_112 gf180mcu_as_sc_mcu7t3v3__inv_2_311/VDD gf180mcu_as_sc_mcu7t3v3__inv_2_311/VSS
+ VSS VSS VSS VSS VSS gf180mcu_as_sc_mcu7t3v3__inv_2_311/VNW VSUBS gf180mcu_as_sc_mcu7t3v3__nand4_2
Xgf180mcu_as_sc_mcu7t3v3__nand4_2_101 VSS VSS VSS VSS VSS VSS VSS gf180mcu_as_sc_mcu7t3v3__inv_2_356/VNW
+ VSUBS gf180mcu_as_sc_mcu7t3v3__nand4_2
Xu_t026_006 u_t026_006/c0_w0_bl u_t026_006/c0_w0_br u_t026_006/c0_w1_bl u_t026_006/c0_w1_br
+ u_t026_006/c0_r0_rbl u_t026_006/c0_r1_rbl u_t026_006/c1_w0_bl u_t026_006/c1_w0_br
+ u_t026_006/c1_w1_bl u_t026_006/c1_w1_br u_t026_006/c1_r0_rbl u_t026_006/c1_r1_rbl
+ u_t026_006/c2_w0_bl u_t026_006/c2_w0_br u_t026_006/c2_w1_bl u_t026_006/c2_w1_br
+ u_t026_006/c2_r0_rbl u_t026_006/c2_r1_rbl u_t026_006/c3_w0_bl u_t026_006/c3_w0_br
+ u_t026_006/c3_w1_bl u_t026_006/c3_w1_br u_t026_006/c3_r0_rbl u_t026_006/c3_r1_rbl
+ u_t026_006/r0_w0_wl u_t026_006/r0_w1_wl u_t026_006/r0_r0_rwl u_t026_006/r0_r1_rwl
+ u_t026_006/r1_w0_wl u_t026_006/r1_w1_wl u_t026_006/r1_r0_rwl u_t026_006/r1_r1_rwl
+ u_t026_006/r2_w0_wl u_t026_006/r2_w1_wl u_t026_006/r2_r0_rwl u_t026_006/r2_r1_rwl
+ u_t026_006/r3_w0_wl u_t026_006/r3_w1_wl u_t026_006/r3_r0_rwl u_t026_006/r3_r1_rwl
+ u_t026_006/VDD VSS u_t026_006/m2_717_1265# u_t026_006/m2_603_2031# u_t026_006/m2_1290_336#
+ u_t026_006/m2_2000_2037# u_t026_006/m2_791_2909# u_t026_006/m2_7_2126# u_t026_006/m2_2154_2081#
+ u_t026_006/m2_1795_2037# u_t026_006/m2_871_303# u_t026_006/m2_431_438# u_t026_006/m2_1290_2898#
+ u_t026_006/m2_1714_1210# u_t026_006/m2_431_1982# u_t026_006/m2_512_1265# u_t026_006/m2_2573_2126#
+ u_t026_006/m2_603_1259# u_t026_006/m2_2074_2909# u_t026_006/m2_7_336# u_t026_006/m2_717_2037#
+ u_t026_006/m2_1886_2031# u_t026_006/m2_2573_336# u_t026_006/m2_7_2898# u_t026_006/m2_2000_1265#
+ u_t026_006/m2_512_2037# u_t026_006/m2_1795_1265# u_t026_006/m2_1714_1982# u_t026_006/m2_1886_1259#
+ u_t026_006/m2_1290_2126# u_t026_006/m2_1714_438# u_t026_006/m2_431_1210# u_t026_006/m2_2573_2898#
+ u_t026_006/m2_2154_303# u_t026_006/m2_871_2081# VSUBS detronyx_12t_2w2r_rc4_4x4_routed_5layer_direct
Xgf180mcu_as_sc_mcu7t3v3__nand4_2_62 gf180mcu_as_sc_mcu7t3v3__inv_2_4/VDD gf180mcu_as_sc_mcu7t3v3__inv_2_8/VDD
+ VSS VSS VSS VSS VSS gf180mcu_as_sc_mcu7t3v3__inv_2_4/VNW VSUBS gf180mcu_as_sc_mcu7t3v3__nand4_2
Xgf180mcu_as_sc_mcu7t3v3__nand4_2_95 gf180mcu_as_sc_mcu7t3v3__inv_2_66/VSS gf180mcu_as_sc_mcu7t3v3__inv_2_66/VSS
+ VSS VSS VSS VSS VSS gf180mcu_as_sc_mcu7t3v3__inv_2_66/VNW VSUBS gf180mcu_as_sc_mcu7t3v3__nand4_2
Xgf180mcu_as_sc_mcu7t3v3__nand4_2_84 gf180mcu_as_sc_mcu7t3v3__inv_2_69/VDD gf180mcu_as_sc_mcu7t3v3__inv_2_73/VDD
+ VSS VSS VSS VSS VSS gf180mcu_as_sc_mcu7t3v3__inv_2_69/VNW VSUBS gf180mcu_as_sc_mcu7t3v3__nand4_2
Xgf180mcu_as_sc_mcu7t3v3__nand4_2_40 VSS VSS VSS VSS VSS VSS VSS gf180mcu_as_sc_mcu7t3v3__inv_2_200/VNW
+ VSUBS gf180mcu_as_sc_mcu7t3v3__nand4_2
Xgf180mcu_as_sc_mcu7t3v3__nand4_2_178 gf180mcu_as_sc_mcu7t3v3__inv_2_679/VSS gf180mcu_as_sc_mcu7t3v3__inv_2_665/VSS
+ VSS VSS VSS VSS VSS gf180mcu_as_sc_mcu7t3v3__inv_2_665/VNW VSUBS gf180mcu_as_sc_mcu7t3v3__nand4_2
Xgf180mcu_as_sc_mcu7t3v3__nand4_2_189 gf180mcu_as_sc_mcu7t3v3__inv_2_746/VDD gf180mcu_as_sc_mcu7t3v3__inv_2_746/VDD
+ VSS VSS VSS VSS VSS gf180mcu_as_sc_mcu7t3v3__inv_2_728/VNW VSUBS gf180mcu_as_sc_mcu7t3v3__nand4_2
Xgf180mcu_as_sc_mcu7t3v3__nand4_2_73 gf180mcu_as_sc_mcu7t3v3__inv_2_323/VDD VSS VSS
+ VSS VSS VSS VSS gf180mcu_as_sc_mcu7t3v3__inv_2_323/VNW VSUBS gf180mcu_as_sc_mcu7t3v3__nand4_2
Xgf180mcu_as_sc_mcu7t3v3__nand4_2_51 VSS VSS VSS VSS VSS VSS VSS gf180mcu_as_sc_mcu7t3v3__inv_2_233/VNW
+ VSUBS gf180mcu_as_sc_mcu7t3v3__nand4_2
Xu_t017_006 u_t017_006/c0_w0_bl u_t017_006/c0_w0_br u_t017_006/c0_w1_bl u_t017_006/c0_w1_br
+ u_t017_006/c0_r0_rbl u_t017_006/c0_r1_rbl u_t017_006/c1_w0_bl u_t017_006/c1_w0_br
+ u_t017_006/c1_w1_bl u_t017_006/c1_w1_br u_t017_006/c1_r0_rbl u_t017_006/c1_r1_rbl
+ u_t017_006/c2_w0_bl u_t017_006/c2_w0_br u_t017_006/c2_w1_bl u_t017_006/c2_w1_br
+ u_t017_006/c2_r0_rbl u_t017_006/c2_r1_rbl u_t017_006/c3_w0_bl u_t017_006/c3_w0_br
+ u_t017_006/c3_w1_bl u_t017_006/c3_w1_br u_t017_006/c3_r0_rbl u_t017_006/c3_r1_rbl
+ u_t017_006/r0_w0_wl u_t017_006/r0_w1_wl u_t017_006/r0_r0_rwl u_t017_006/r0_r1_rwl
+ u_t017_006/r1_w0_wl u_t017_006/r1_w1_wl u_t017_006/r1_r0_rwl u_t017_006/r1_r1_rwl
+ u_t017_006/r2_w0_wl u_t017_006/r2_w1_wl u_t017_006/r2_r0_rwl u_t017_006/r2_r1_rwl
+ u_t017_006/r3_w0_wl u_t017_006/r3_w1_wl u_t017_006/r3_r0_rwl u_t017_006/r3_r1_rwl
+ u_t017_006/VDD VSS u_t017_006/m2_717_1265# u_t017_006/m2_603_2031# u_t017_006/m2_1290_336#
+ u_t017_006/m2_2000_2037# u_t017_006/m2_791_2909# u_t017_006/m2_7_2126# u_t017_006/m2_2154_2081#
+ u_t017_006/m2_1795_2037# u_t017_006/m2_871_303# u_t017_006/m2_431_438# u_t017_006/m2_1290_2898#
+ u_t017_006/m2_1714_1210# u_t017_006/m2_431_1982# u_t017_006/m2_512_1265# u_t017_006/m2_2573_2126#
+ u_t017_006/m2_603_1259# u_t017_006/m2_2074_2909# u_t017_006/m2_7_336# u_t017_006/m2_717_2037#
+ u_t017_006/m2_1886_2031# u_t017_006/m2_2573_336# u_t017_006/m2_7_2898# u_t017_006/m2_2000_1265#
+ u_t017_006/m2_512_2037# u_t017_006/m2_1795_1265# u_t017_006/m2_1714_1982# u_t017_006/m2_1886_1259#
+ u_t017_006/m2_1290_2126# u_t017_006/m2_1714_438# u_t017_006/m2_431_1210# u_t017_006/m2_2573_2898#
+ u_t017_006/m2_2154_303# u_t017_006/m2_871_2081# VSUBS detronyx_12t_2w2r_rc4_4x4_routed_5layer_direct
Xgf180mcu_as_sc_mcu7t3v3__inv_2_109 gf180mcu_as_sc_mcu7t3v3__inv_2_371/VSS gf180mcu_as_sc_mcu7t3v3__inv_2_113/VDD
+ VSS VSS gf180mcu_as_sc_mcu7t3v3__inv_2_110/VNW VSUBS gf180mcu_as_sc_mcu7t3v3__inv_2
Xgf180mcu_as_sc_mcu7t3v3__inv_2_1192 gf180mcu_as_sc_mcu7t3v3__nand3_2_65/VDD gf180mcu_as_sc_mcu7t3v3__nor2_2_9/VSS
+ VSS VSS gf180mcu_as_sc_mcu7t3v3__nand3_2_65/VNW VSUBS gf180mcu_as_sc_mcu7t3v3__inv_2
Xgf180mcu_as_sc_mcu7t3v3__inv_2_1181 VSS VSS VSS VSS gf180mcu_as_sc_mcu7t3v3__inv_2_1297/VNW
+ VSUBS gf180mcu_as_sc_mcu7t3v3__inv_2
Xgf180mcu_as_sc_mcu7t3v3__inv_2_1170 VSS VSS VSS VSS gf180mcu_as_sc_mcu7t3v3__inv_2_1271/VNW
+ VSUBS gf180mcu_as_sc_mcu7t3v3__inv_2
Xu_t023_009 u_t023_009/c0_w0_bl u_t023_009/c0_w0_br u_t023_009/c0_w1_bl u_t023_009/c0_w1_br
+ u_t023_009/c0_r0_rbl u_t023_009/c0_r1_rbl u_t023_009/c1_w0_bl u_t023_009/c1_w0_br
+ u_t023_009/c1_w1_bl u_t023_009/c1_w1_br u_t023_009/c1_r0_rbl u_t023_009/c1_r1_rbl
+ u_t023_009/c2_w0_bl u_t023_009/c2_w0_br u_t023_009/c2_w1_bl u_t023_009/c2_w1_br
+ u_t023_009/c2_r0_rbl u_t023_009/c2_r1_rbl u_t023_009/c3_w0_bl u_t023_009/c3_w0_br
+ u_t023_009/c3_w1_bl u_t023_009/c3_w1_br u_t023_009/c3_r0_rbl u_t023_009/c3_r1_rbl
+ u_t023_009/r0_w0_wl u_t023_009/r0_w1_wl u_t023_009/r0_r0_rwl u_t023_009/r0_r1_rwl
+ u_t023_009/r1_w0_wl u_t023_009/r1_w1_wl u_t023_009/r1_r0_rwl u_t023_009/r1_r1_rwl
+ u_t023_009/r2_w0_wl u_t023_009/r2_w1_wl u_t023_009/r2_r0_rwl u_t023_009/r2_r1_rwl
+ u_t023_009/r3_w0_wl u_t023_009/r3_w1_wl u_t023_009/r3_r0_rwl u_t023_009/r3_r1_rwl
+ VSS u_t023_009/VSS u_t023_009/m2_717_1265# u_t023_009/m2_603_2031# u_t023_009/m2_1290_336#
+ u_t023_009/m2_2000_2037# u_t023_009/m2_791_2909# u_t023_009/m2_7_2126# u_t023_009/m2_2154_2081#
+ u_t023_009/m2_1795_2037# u_t023_009/m2_871_303# u_t023_009/m2_431_438# u_t023_009/m2_1290_2898#
+ u_t023_009/m2_1714_1210# u_t023_009/m2_431_1982# u_t023_009/m2_512_1265# u_t023_009/m2_2573_2126#
+ u_t023_009/m2_603_1259# u_t023_009/m2_2074_2909# u_t023_009/m2_7_336# u_t023_009/m2_717_2037#
+ u_t023_009/m2_1886_2031# u_t023_009/m2_2573_336# u_t023_009/m2_7_2898# u_t023_009/m2_2000_1265#
+ u_t023_009/m2_512_2037# u_t023_009/m2_1795_1265# u_t023_009/m2_1714_1982# u_t023_009/m2_1886_1259#
+ u_t023_009/m2_1290_2126# u_t023_009/m2_1714_438# u_t023_009/m2_431_1210# u_t023_009/m2_2573_2898#
+ u_t023_009/m2_2154_303# u_t023_009/m2_871_2081# VSUBS detronyx_12t_2w2r_rc4_4x4_routed_5layer_direct
Xu_t008_006 u_t008_006/c0_w0_bl u_t008_006/c0_w0_br u_t008_006/c0_w1_bl u_t008_006/c0_w1_br
+ u_t008_006/c0_r0_rbl u_t008_006/c0_r1_rbl u_t008_006/c1_w0_bl u_t008_006/c1_w0_br
+ u_t008_006/c1_w1_bl u_t008_006/c1_w1_br u_t008_006/c1_r0_rbl u_t008_006/c1_r1_rbl
+ u_t008_006/c2_w0_bl u_t008_006/c2_w0_br u_t008_006/c2_w1_bl u_t008_006/c2_w1_br
+ u_t008_006/c2_r0_rbl u_t008_006/c2_r1_rbl u_t008_006/c3_w0_bl u_t008_006/c3_w0_br
+ u_t008_006/c3_w1_bl u_t008_006/c3_w1_br u_t008_006/c3_r0_rbl u_t008_006/c3_r1_rbl
+ u_t008_006/r0_w0_wl u_t008_006/r0_w1_wl u_t008_006/r0_r0_rwl u_t008_006/r0_r1_rwl
+ u_t008_006/r1_w0_wl u_t008_006/r1_w1_wl u_t008_006/r1_r0_rwl u_t008_006/r1_r1_rwl
+ u_t008_006/r2_w0_wl u_t008_006/r2_w1_wl u_t008_006/r2_r0_rwl u_t008_006/r2_r1_rwl
+ u_t008_006/r3_w0_wl u_t008_006/r3_w1_wl u_t008_006/r3_r0_rwl u_t008_006/r3_r1_rwl
+ u_t008_006/VDD VSS u_t008_006/m2_717_1265# u_t008_006/m2_603_2031# u_t008_006/m2_1290_336#
+ u_t008_006/m2_2000_2037# u_t008_006/m2_791_2909# u_t008_006/m2_7_2126# u_t008_006/m2_2154_2081#
+ u_t008_006/m2_1795_2037# u_t008_006/m2_871_303# u_t008_006/m2_431_438# u_t008_006/m2_1290_2898#
+ u_t008_006/m2_1714_1210# u_t008_006/m2_431_1982# u_t008_006/m2_512_1265# u_t008_006/m2_2573_2126#
+ u_t008_006/m2_603_1259# u_t008_006/m2_2074_2909# u_t008_006/m2_7_336# u_t008_006/m2_717_2037#
+ u_t008_006/m2_1886_2031# u_t008_006/m2_2573_336# u_t008_006/m2_7_2898# u_t008_006/m2_2000_1265#
+ u_t008_006/m2_512_2037# u_t008_006/m2_1795_1265# u_t008_006/m2_1714_1982# u_t008_006/m2_1886_1259#
+ u_t008_006/m2_1290_2126# u_t008_006/m2_1714_438# u_t008_006/m2_431_1210# u_t008_006/m2_2573_2898#
+ u_t008_006/m2_2154_303# u_t008_006/m2_871_2081# VSUBS detronyx_12t_2w2r_rc4_4x4_routed_5layer_direct
Xgf180mcu_as_sc_mcu7t3v3__inv_2_621 gf180mcu_as_sc_mcu7t3v3__inv_2_637/VDD VSS gf180mcu_as_sc_mcu7t3v3__inv_2_621/Y
+ gf180mcu_as_sc_mcu7t3v3__inv_2_637/Y gf180mcu_as_sc_mcu7t3v3__inv_2_637/VNW VSUBS
+ gf180mcu_as_sc_mcu7t3v3__inv_2
Xgf180mcu_as_sc_mcu7t3v3__inv_2_610 VSS gf180mcu_as_sc_mcu7t3v3__inv_2_617/VDD gf180mcu_as_sc_mcu7t3v3__inv_2_610/Y
+ VSS gf180mcu_as_sc_mcu7t3v3__inv_2_610/VNW VSUBS gf180mcu_as_sc_mcu7t3v3__inv_2
Xgf180mcu_as_sc_mcu7t3v3__inv_2_632 gf180mcu_as_sc_mcu7t3v3__inv_2_632/VDD gf180mcu_as_sc_mcu7t3v3__inv_2_636/VDD
+ gf180mcu_as_sc_mcu7t3v3__inv_2_632/Y VSS gf180mcu_as_sc_mcu7t3v3__inv_2_632/VNW
+ VSUBS gf180mcu_as_sc_mcu7t3v3__inv_2
Xgf180mcu_as_sc_mcu7t3v3__inv_2_654 gf180mcu_as_sc_mcu7t3v3__inv_2_656/VDD gf180mcu_as_sc_mcu7t3v3__inv_2_854/VDD
+ gf180mcu_as_sc_mcu7t3v3__inv_2_654/Y gf180mcu_as_sc_mcu7t3v3__inv_2_853/Y gf180mcu_as_sc_mcu7t3v3__inv_2_656/VNW
+ VSUBS gf180mcu_as_sc_mcu7t3v3__inv_2
Xgf180mcu_as_sc_mcu7t3v3__inv_2_643 gf180mcu_as_sc_mcu7t3v3__inv_2_679/VSS gf180mcu_as_sc_mcu7t3v3__inv_2_665/VSS
+ gf180mcu_as_sc_mcu7t3v3__inv_2_643/Y gf180mcu_as_sc_mcu7t3v3__inv_2_643/A gf180mcu_as_sc_mcu7t3v3__inv_2_665/VNW
+ VSUBS gf180mcu_as_sc_mcu7t3v3__inv_2
Xgf180mcu_as_sc_mcu7t3v3__inv_2_687 gf180mcu_as_sc_mcu7t3v3__inv_2_688/VDD VSS gf180mcu_as_sc_mcu7t3v3__inv_2_687/Y
+ gf180mcu_as_sc_mcu7t3v3__inv_2_688/Y gf180mcu_as_sc_mcu7t3v3__inv_2_688/VNW VSUBS
+ gf180mcu_as_sc_mcu7t3v3__inv_2
Xgf180mcu_as_sc_mcu7t3v3__inv_2_665 gf180mcu_as_sc_mcu7t3v3__inv_2_679/VSS gf180mcu_as_sc_mcu7t3v3__inv_2_665/VSS
+ gf180mcu_as_sc_mcu7t3v3__inv_2_665/Y gf180mcu_as_sc_mcu7t3v3__inv_2_675/Y gf180mcu_as_sc_mcu7t3v3__inv_2_665/VNW
+ VSUBS gf180mcu_as_sc_mcu7t3v3__inv_2
Xgf180mcu_as_sc_mcu7t3v3__inv_2_676 gf180mcu_as_sc_mcu7t3v3__inv_2_678/VDD gf180mcu_as_sc_mcu7t3v3__inv_2_689/VDD
+ gf180mcu_as_sc_mcu7t3v3__inv_2_676/Y gf180mcu_as_sc_mcu7t3v3__inv_2_744/A gf180mcu_as_sc_mcu7t3v3__inv_2_678/VNW
+ VSUBS gf180mcu_as_sc_mcu7t3v3__inv_2
Xgf180mcu_as_sc_mcu7t3v3__inv_2_698 VSS gf180mcu_as_sc_mcu7t3v3__inv_2_712/VDD gf180mcu_as_sc_mcu7t3v3__inv_2_698/Y
+ gf180mcu_as_sc_mcu7t3v3__inv_2_733/Y gf180mcu_as_sc_mcu7t3v3__inv_2_708/VNW VSUBS
+ gf180mcu_as_sc_mcu7t3v3__inv_2
Xu_t014_009 u_t014_009/c0_w0_bl u_t014_009/c0_w0_br u_t014_009/c0_w1_bl u_t014_009/c0_w1_br
+ u_t014_009/c0_r0_rbl u_t014_009/c0_r1_rbl u_t014_009/c1_w0_bl u_t014_009/c1_w0_br
+ u_t014_009/c1_w1_bl u_t014_009/c1_w1_br u_t014_009/c1_r0_rbl u_t014_009/c1_r1_rbl
+ u_t014_009/c2_w0_bl u_t014_009/c2_w0_br u_t014_009/c2_w1_bl u_t014_009/c2_w1_br
+ u_t014_009/c2_r0_rbl u_t014_009/c2_r1_rbl u_t014_009/c3_w0_bl u_t014_009/c3_w0_br
+ u_t014_009/c3_w1_bl u_t014_009/c3_w1_br u_t014_009/c3_r0_rbl u_t014_009/c3_r1_rbl
+ u_t014_009/r0_w0_wl u_t014_009/r0_w1_wl u_t014_009/r0_r0_rwl u_t014_009/r0_r1_rwl
+ u_t014_009/r1_w0_wl u_t014_009/r1_w1_wl u_t014_009/r1_r0_rwl u_t014_009/r1_r1_rwl
+ u_t014_009/r2_w0_wl u_t014_009/r2_w1_wl u_t014_009/r2_r0_rwl u_t014_009/r2_r1_rwl
+ u_t014_009/r3_w0_wl u_t014_009/r3_w1_wl u_t014_009/r3_r0_rwl u_t014_009/r3_r1_rwl
+ VSS u_t014_009/VSS u_t014_009/m2_717_1265# u_t014_009/m2_603_2031# u_t014_009/m2_1290_336#
+ u_t014_009/m2_2000_2037# u_t014_009/m2_791_2909# u_t014_009/m2_7_2126# u_t014_009/m2_2154_2081#
+ u_t014_009/m2_1795_2037# u_t014_009/m2_871_303# u_t014_009/m2_431_438# u_t014_009/m2_1290_2898#
+ u_t014_009/m2_1714_1210# u_t014_009/m2_431_1982# u_t014_009/m2_512_1265# u_t014_009/m2_2573_2126#
+ u_t014_009/m2_603_1259# u_t014_009/m2_2074_2909# u_t014_009/m2_7_336# u_t014_009/m2_717_2037#
+ u_t014_009/m2_1886_2031# u_t014_009/m2_2573_336# u_t014_009/m2_7_2898# u_t014_009/m2_2000_1265#
+ u_t014_009/m2_512_2037# u_t014_009/m2_1795_1265# u_t014_009/m2_1714_1982# u_t014_009/m2_1886_1259#
+ u_t014_009/m2_1290_2126# u_t014_009/m2_1714_438# u_t014_009/m2_431_1210# u_t014_009/m2_2573_2898#
+ u_t014_009/m2_2154_303# u_t014_009/m2_871_2081# VSUBS detronyx_12t_2w2r_rc4_4x4_routed_5layer_direct
Xu_t005_009 u_t005_009/c0_w0_bl u_t005_009/c0_w0_br u_t005_009/c0_w1_bl u_t005_009/c0_w1_br
+ u_t005_009/c0_r0_rbl u_t005_009/c0_r1_rbl u_t005_009/c1_w0_bl u_t005_009/c1_w0_br
+ u_t005_009/c1_w1_bl u_t005_009/c1_w1_br u_t005_009/c1_r0_rbl u_t005_009/c1_r1_rbl
+ u_t005_009/c2_w0_bl u_t005_009/c2_w0_br u_t005_009/c2_w1_bl u_t005_009/c2_w1_br
+ u_t005_009/c2_r0_rbl u_t005_009/c2_r1_rbl u_t005_009/c3_w0_bl u_t005_009/c3_w0_br
+ u_t005_009/c3_w1_bl u_t005_009/c3_w1_br u_t005_009/c3_r0_rbl u_t005_009/c3_r1_rbl
+ u_t005_009/r0_w0_wl u_t005_009/r0_w1_wl u_t005_009/r0_r0_rwl u_t005_009/r0_r1_rwl
+ u_t005_009/r1_w0_wl u_t005_009/r1_w1_wl u_t005_009/r1_r0_rwl u_t005_009/r1_r1_rwl
+ u_t005_009/r2_w0_wl u_t005_009/r2_w1_wl u_t005_009/r2_r0_rwl u_t005_009/r2_r1_rwl
+ u_t005_009/r3_w0_wl u_t005_009/r3_w1_wl u_t005_009/r3_r0_rwl u_t005_009/r3_r1_rwl
+ VSS VSS u_t005_009/m2_717_1265# u_t005_009/m2_603_2031# u_t005_009/m2_1290_336#
+ u_t005_009/m2_2000_2037# u_t005_009/m2_791_2909# u_t005_009/m2_7_2126# u_t005_009/m2_2154_2081#
+ u_t005_009/m2_1795_2037# u_t005_009/m2_871_303# u_t005_009/m2_431_438# u_t005_009/m2_1290_2898#
+ u_t005_009/m2_1714_1210# u_t005_009/m2_431_1982# u_t005_009/m2_512_1265# u_t005_009/m2_2573_2126#
+ u_t005_009/m2_603_1259# u_t005_009/m2_2074_2909# u_t005_009/m2_7_336# u_t005_009/m2_717_2037#
+ u_t005_009/m2_1886_2031# u_t005_009/m2_2573_336# u_t005_009/m2_7_2898# u_t005_009/m2_2000_1265#
+ u_t005_009/m2_512_2037# u_t005_009/m2_1795_1265# u_t005_009/m2_1714_1982# u_t005_009/m2_1886_1259#
+ u_t005_009/m2_1290_2126# u_t005_009/m2_1714_438# u_t005_009/m2_431_1210# u_t005_009/m2_2573_2898#
+ u_t005_009/m2_2154_303# u_t005_009/m2_871_2081# VSUBS detronyx_12t_2w2r_rc4_4x4_routed_5layer_direct
Xgf180mcu_as_sc_mcu7t3v3__inv_2_484 VSS VSS VSS VSS gf180mcu_as_sc_mcu7t3v3__inv_2_548/VNW
+ VSUBS gf180mcu_as_sc_mcu7t3v3__inv_2
Xgf180mcu_as_sc_mcu7t3v3__inv_2_440 VSS VSS VSS VSS gf180mcu_as_sc_mcu7t3v3__inv_2_551/VNW
+ VSUBS gf180mcu_as_sc_mcu7t3v3__inv_2
Xgf180mcu_as_sc_mcu7t3v3__inv_2_462 gf180mcu_as_sc_mcu7t3v3__nor2_2_7/VDD gf180mcu_as_sc_mcu7t3v3__nand3_2_4/VSS
+ gf180mcu_as_sc_mcu7t3v3__inv_2_462/Y VSS gf180mcu_as_sc_mcu7t3v3__nor2_2_7/VNW VSUBS
+ gf180mcu_as_sc_mcu7t3v3__inv_2
Xgf180mcu_as_sc_mcu7t3v3__inv_2_451 gf180mcu_as_sc_mcu7t3v3__nor2_2_4/VDD gf180mcu_as_sc_mcu7t3v3__nor2_2_4/VSS
+ VSS VSS gf180mcu_as_sc_mcu7t3v3__nor2_2_4/VNW VSUBS gf180mcu_as_sc_mcu7t3v3__inv_2
Xgf180mcu_as_sc_mcu7t3v3__inv_2_473 gf180mcu_as_sc_mcu7t3v3__nor2_2_4/VDD gf180mcu_as_sc_mcu7t3v3__nor2_2_4/VSS
+ VSS VSS gf180mcu_as_sc_mcu7t3v3__nor2_2_4/VNW VSUBS gf180mcu_as_sc_mcu7t3v3__inv_2
Xgf180mcu_as_sc_mcu7t3v3__inv_2_495 VSS VSS VSS VSS gf180mcu_as_sc_mcu7t3v3__inv_2_561/VNW
+ VSUBS gf180mcu_as_sc_mcu7t3v3__inv_2
Xu_t010_012 u_t010_012/c0_w0_bl u_t010_012/c0_w0_br u_t010_012/c0_w1_bl u_t010_012/c0_w1_br
+ u_t010_012/c0_r0_rbl u_t010_012/c0_r1_rbl u_t010_012/c1_w0_bl u_t010_012/c1_w0_br
+ u_t010_012/c1_w1_bl u_t010_012/c1_w1_br u_t010_012/c1_r0_rbl u_t010_012/c1_r1_rbl
+ u_t010_012/c2_w0_bl u_t010_012/c2_w0_br u_t010_012/c2_w1_bl u_t010_012/c2_w1_br
+ u_t010_012/c2_r0_rbl u_t010_012/c2_r1_rbl u_t010_012/c3_w0_bl u_t010_012/c3_w0_br
+ u_t010_012/c3_w1_bl u_t010_012/c3_w1_br u_t010_012/c3_r0_rbl u_t010_012/c3_r1_rbl
+ u_t010_012/r0_w0_wl u_t010_012/r0_w1_wl u_t010_012/r0_r0_rwl u_t010_012/r0_r1_rwl
+ u_t010_012/r1_w0_wl u_t010_012/r1_w1_wl u_t010_012/r1_r0_rwl u_t010_012/r1_r1_rwl
+ u_t010_012/r2_w0_wl u_t010_012/r2_w1_wl u_t010_012/r2_r0_rwl u_t010_012/r2_r1_rwl
+ u_t010_012/r3_w0_wl u_t010_012/r3_w1_wl u_t010_012/r3_r0_rwl u_t010_012/r3_r1_rwl
+ u_t010_012/VDD u_t010_012/VSS u_t010_012/m2_717_1265# u_t010_012/m2_603_2031# u_t010_012/m2_1290_336#
+ u_t010_012/m2_2000_2037# u_t010_012/m2_791_2909# u_t010_012/m2_7_2126# u_t010_012/m2_2154_2081#
+ u_t010_012/m2_1795_2037# u_t010_012/m2_871_303# u_t010_012/m2_431_438# u_t010_012/m2_1290_2898#
+ u_t010_012/m2_1714_1210# u_t010_012/m2_431_1982# u_t010_012/m2_512_1265# u_t010_012/m2_2573_2126#
+ u_t010_012/m2_603_1259# u_t010_012/m2_2074_2909# u_t010_012/m2_7_336# u_t010_012/m2_717_2037#
+ u_t010_012/m2_1886_2031# u_t010_012/m2_2573_336# u_t010_012/m2_7_2898# u_t010_012/m2_2000_1265#
+ u_t010_012/m2_512_2037# u_t010_012/m2_1795_1265# u_t010_012/m2_1714_1982# u_t010_012/m2_1886_1259#
+ u_t010_012/m2_1290_2126# u_t010_012/m2_1714_438# u_t010_012/m2_431_1210# u_t010_012/m2_2573_2898#
+ u_t010_012/m2_2154_303# u_t010_012/m2_871_2081# VSUBS detronyx_12t_2w2r_rc4_4x4_routed_5layer_direct
Xu_t010_001 u_t010_001/c0_w0_bl u_t010_001/c0_w0_br u_t010_001/c0_w1_bl u_t010_001/c0_w1_br
+ u_t010_001/c0_r0_rbl u_t010_001/c0_r1_rbl u_t010_001/c1_w0_bl u_t010_001/c1_w0_br
+ u_t010_001/c1_w1_bl u_t010_001/c1_w1_br u_t010_001/c1_r0_rbl u_t010_001/c1_r1_rbl
+ u_t010_001/c2_w0_bl u_t010_001/c2_w0_br u_t010_001/c2_w1_bl u_t010_001/c2_w1_br
+ u_t010_001/c2_r0_rbl u_t010_001/c2_r1_rbl u_t010_001/c3_w0_bl u_t010_001/c3_w0_br
+ u_t010_001/c3_w1_bl u_t010_001/c3_w1_br u_t010_001/c3_r0_rbl u_t010_001/c3_r1_rbl
+ u_t010_001/r0_w0_wl u_t010_001/r0_w1_wl u_t010_001/r0_r0_rwl u_t010_001/r0_r1_rwl
+ u_t010_001/r1_w0_wl u_t010_001/r1_w1_wl u_t010_001/r1_r0_rwl u_t010_001/r1_r1_rwl
+ u_t010_001/r2_w0_wl u_t010_001/r2_w1_wl u_t010_001/r2_r0_rwl u_t010_001/r2_r1_rwl
+ u_t010_001/r3_w0_wl u_t010_001/r3_w1_wl u_t010_001/r3_r0_rwl u_t010_001/r3_r1_rwl
+ VSS VSS u_t010_001/m2_717_1265# u_t010_001/m2_603_2031# u_t010_001/m2_1290_336#
+ u_t010_001/m2_2000_2037# u_t010_001/m2_791_2909# u_t010_001/m2_7_2126# u_t010_001/m2_2154_2081#
+ u_t010_001/m2_1795_2037# u_t010_001/m2_871_303# u_t010_001/m2_431_438# u_t010_001/m2_1290_2898#
+ u_t010_001/m2_1714_1210# u_t010_001/m2_431_1982# u_t010_001/m2_512_1265# u_t010_001/m2_2573_2126#
+ u_t010_001/m2_603_1259# u_t010_001/m2_2074_2909# u_t010_001/m2_7_336# u_t010_001/m2_717_2037#
+ u_t010_001/m2_1886_2031# u_t010_001/m2_2573_336# u_t010_001/m2_7_2898# u_t010_001/m2_2000_1265#
+ u_t010_001/m2_512_2037# u_t010_001/m2_1795_1265# u_t010_001/m2_1714_1982# u_t010_001/m2_1886_1259#
+ u_t010_001/m2_1290_2126# u_t010_001/m2_1714_438# u_t010_001/m2_431_1210# u_t010_001/m2_2573_2898#
+ u_t010_001/m2_2154_303# u_t010_001/m2_871_2081# VSUBS detronyx_12t_2w2r_rc4_4x4_routed_5layer_direct
Xu_t001_012 u_t001_012/c0_w0_bl u_t001_012/c0_w0_br u_t001_012/c0_w1_bl u_t001_012/c0_w1_br
+ u_t001_012/c0_r0_rbl u_t001_012/c0_r1_rbl u_t001_012/c1_w0_bl u_t001_012/c1_w0_br
+ u_t001_012/c1_w1_bl u_t001_012/c1_w1_br u_t001_012/c1_r0_rbl u_t001_012/c1_r1_rbl
+ u_t001_012/c2_w0_bl u_t001_012/c2_w0_br u_t001_012/c2_w1_bl u_t001_012/c2_w1_br
+ u_t001_012/c2_r0_rbl u_t001_012/c2_r1_rbl u_t001_012/c3_w0_bl u_t001_012/c3_w0_br
+ u_t001_012/c3_w1_bl u_t001_012/c3_w1_br u_t001_012/c3_r0_rbl u_t001_012/c3_r1_rbl
+ u_t001_012/r0_w0_wl u_t001_012/r0_w1_wl u_t001_012/r0_r0_rwl u_t001_012/r0_r1_rwl
+ u_t001_012/r1_w0_wl u_t001_012/r1_w1_wl u_t001_012/r1_r0_rwl u_t001_012/r1_r1_rwl
+ u_t001_012/r2_w0_wl u_t001_012/r2_w1_wl u_t001_012/r2_r0_rwl u_t001_012/r2_r1_rwl
+ u_t001_012/r3_w0_wl u_t001_012/r3_w1_wl u_t001_012/r3_r0_rwl u_t001_012/r3_r1_rwl
+ u_t001_012/VDD VSS u_t001_012/m2_717_1265# u_t001_012/m2_603_2031# u_t001_012/m2_1290_336#
+ u_t001_012/m2_2000_2037# u_t001_012/m2_791_2909# u_t001_012/m2_7_2126# u_t001_012/m2_2154_2081#
+ u_t001_012/m2_1795_2037# u_t001_012/m2_871_303# u_t001_012/m2_431_438# u_t001_012/m2_1290_2898#
+ u_t001_012/m2_1714_1210# u_t001_012/m2_431_1982# u_t001_012/m2_512_1265# u_t001_012/m2_2573_2126#
+ u_t001_012/m2_603_1259# u_t001_012/m2_2074_2909# u_t001_012/m2_7_336# u_t001_012/m2_717_2037#
+ u_t001_012/m2_1886_2031# u_t001_012/m2_2573_336# u_t001_012/m2_7_2898# u_t001_012/m2_2000_1265#
+ u_t001_012/m2_512_2037# u_t001_012/m2_1795_1265# u_t001_012/m2_1714_1982# u_t001_012/m2_1886_1259#
+ u_t001_012/m2_1290_2126# u_t001_012/m2_1714_438# u_t001_012/m2_431_1210# u_t001_012/m2_2573_2898#
+ u_t001_012/m2_2154_303# u_t001_012/m2_871_2081# VSUBS detronyx_12t_2w2r_rc4_4x4_routed_5layer_direct
Xu_t001_001 u_t001_001/c0_w0_bl u_t001_001/c0_w0_br u_t001_001/c0_w1_bl u_t001_001/c0_w1_br
+ u_t001_001/c0_r0_rbl u_t001_001/c0_r1_rbl u_t001_001/c1_w0_bl u_t001_001/c1_w0_br
+ u_t001_001/c1_w1_bl u_t001_001/c1_w1_br u_t001_001/c1_r0_rbl u_t001_001/c1_r1_rbl
+ u_t001_001/c2_w0_bl u_t001_001/c2_w0_br u_t001_001/c2_w1_bl u_t001_001/c2_w1_br
+ u_t001_001/c2_r0_rbl u_t001_001/c2_r1_rbl u_t001_001/c3_w0_bl u_t001_001/c3_w0_br
+ u_t001_001/c3_w1_bl u_t001_001/c3_w1_br u_t001_001/c3_r0_rbl u_t001_001/c3_r1_rbl
+ u_t001_001/r0_w0_wl u_t001_001/r0_w1_wl u_t001_001/r0_r0_rwl u_t001_001/r0_r1_rwl
+ u_t001_001/r1_w0_wl u_t001_001/r1_w1_wl u_t001_001/r1_r0_rwl u_t001_001/r1_r1_rwl
+ u_t001_001/r2_w0_wl u_t001_001/r2_w1_wl u_t001_001/r2_r0_rwl u_t001_001/r2_r1_rwl
+ u_t001_001/r3_w0_wl u_t001_001/r3_w1_wl u_t001_001/r3_r0_rwl u_t001_001/r3_r1_rwl
+ VSS VSS u_t001_001/m2_717_1265# u_t001_001/m2_603_2031# u_t001_001/m2_1290_336#
+ u_t001_001/m2_2000_2037# u_t001_001/m2_791_2909# u_t001_001/m2_7_2126# u_t001_001/m2_2154_2081#
+ u_t001_001/m2_1795_2037# u_t001_001/m2_871_303# u_t001_001/m2_431_438# u_t001_001/m2_1290_2898#
+ u_t001_001/m2_1714_1210# u_t001_001/m2_431_1982# u_t001_001/m2_512_1265# u_t001_001/m2_2573_2126#
+ u_t001_001/m2_603_1259# u_t001_001/m2_2074_2909# u_t001_001/m2_7_336# u_t001_001/m2_717_2037#
+ u_t001_001/m2_1886_2031# u_t001_001/m2_2573_336# u_t001_001/m2_7_2898# u_t001_001/m2_2000_1265#
+ u_t001_001/m2_512_2037# u_t001_001/m2_1795_1265# u_t001_001/m2_1714_1982# u_t001_001/m2_1886_1259#
+ u_t001_001/m2_1290_2126# u_t001_001/m2_1714_438# u_t001_001/m2_431_1210# u_t001_001/m2_2573_2898#
+ u_t001_001/m2_2154_303# u_t001_001/m2_871_2081# VSUBS detronyx_12t_2w2r_rc4_4x4_routed_5layer_direct
Xgf180mcu_as_sc_mcu7t3v3__inv_2_1703 gf180mcu_as_sc_mcu7t3v3__nand3_2_9/VDD gf180mcu_as_sc_mcu7t3v3__nor2_2_7/VSS
+ VSS VSS gf180mcu_as_sc_mcu7t3v3__nand3_2_9/VNW VSUBS gf180mcu_as_sc_mcu7t3v3__inv_2
Xgf180mcu_as_sc_mcu7t3v3__inv_2_281 gf180mcu_as_sc_mcu7t3v3__inv_2_281/VDD VSS gf180mcu_as_sc_mcu7t3v3__inv_2_61/Y
+ VSS gf180mcu_as_sc_mcu7t3v3__inv_2_281/VNW VSUBS gf180mcu_as_sc_mcu7t3v3__inv_2
Xgf180mcu_as_sc_mcu7t3v3__inv_2_292 VSS gf180mcu_as_sc_mcu7t3v3__inv_2_308/VDD gf180mcu_as_sc_mcu7t3v3__inv_2_61/Y
+ VSS gf180mcu_as_sc_mcu7t3v3__inv_2_302/VNW VSUBS gf180mcu_as_sc_mcu7t3v3__inv_2
Xgf180mcu_as_sc_mcu7t3v3__inv_2_270 VSS VSS VSS gf180mcu_as_sc_mcu7t3v3__inv_2_61/Y
+ gf180mcu_as_sc_mcu7t3v3__inv_2_280/VNW VSUBS gf180mcu_as_sc_mcu7t3v3__inv_2
Xgf180mcu_as_sc_mcu7t3v3__inv_2_1714 gf180mcu_as_sc_mcu7t3v3__nand3_2_65/VDD gf180mcu_as_sc_mcu7t3v3__nand3_2_62/VSS
+ VSS VSS gf180mcu_as_sc_mcu7t3v3__nand3_2_65/VNW VSUBS gf180mcu_as_sc_mcu7t3v3__inv_2
Xgf180mcu_as_sc_mcu7t3v3__inv_2_1725 gf180mcu_as_sc_mcu7t3v3__inv_2_960/VSS VSS gf180mcu_as_sc_mcu7t3v3__inv_2_1725/Y
+ gf180mcu_as_sc_mcu7t3v3__inv_2_1726/Y gf180mcu_as_sc_mcu7t3v3__inv_2_1726/VNW VSUBS
+ gf180mcu_as_sc_mcu7t3v3__inv_2
Xgf180mcu_as_sc_mcu7t3v3__nand4_2_508 VSS gf180mcu_as_sc_mcu7t3v3__inv_2_1685/VDD
+ VSS VSS VSS VSS VSS gf180mcu_as_sc_mcu7t3v3__inv_2_1653/VNW VSUBS gf180mcu_as_sc_mcu7t3v3__nand4_2
Xgf180mcu_as_sc_mcu7t3v3__inv_2_18 gf180mcu_as_sc_mcu7t3v3__inv_2_20/VDD gf180mcu_as_sc_mcu7t3v3__inv_2_24/VDD
+ VSS gf180mcu_as_sc_mcu7t3v3__inv_2_24/Y gf180mcu_as_sc_mcu7t3v3__inv_2_20/VNW VSUBS
+ gf180mcu_as_sc_mcu7t3v3__inv_2
Xgf180mcu_as_sc_mcu7t3v3__inv_2_29 gf180mcu_as_sc_mcu7t3v3__inv_2_0/VSS gf180mcu_as_sc_mcu7t3v3__inv_2_49/VDD
+ VSS gf180mcu_as_sc_mcu7t3v3__inv_2_9/Y gf180mcu_as_sc_mcu7t3v3__inv_2_43/VNW VSUBS
+ gf180mcu_as_sc_mcu7t3v3__inv_2
Xgf180mcu_as_sc_mcu7t3v3__inv_2_1544 VSS gf180mcu_as_sc_mcu7t3v3__inv_2_1547/VDD gf180mcu_as_sc_mcu7t3v3__inv_2_1544/Y
+ VSS gf180mcu_as_sc_mcu7t3v3__inv_2_1544/VNW VSUBS gf180mcu_as_sc_mcu7t3v3__inv_2
Xgf180mcu_as_sc_mcu7t3v3__inv_2_1522 gf180mcu_as_sc_mcu7t3v3__inv_2_1523/VDD VSS gf180mcu_as_sc_mcu7t3v3__inv_2_1522/Y
+ VSS gf180mcu_as_sc_mcu7t3v3__inv_2_1523/VNW VSUBS gf180mcu_as_sc_mcu7t3v3__inv_2
Xgf180mcu_as_sc_mcu7t3v3__inv_2_1533 VSS VSS VSS VSS gf180mcu_as_sc_mcu7t3v3__inv_2_1535/VNW
+ VSUBS gf180mcu_as_sc_mcu7t3v3__inv_2
Xgf180mcu_as_sc_mcu7t3v3__inv_2_1500 gf180mcu_as_sc_mcu7t3v3__inv_2_1500/VDD gf180mcu_as_sc_mcu7t3v3__inv_2_1503/VDD
+ gf180mcu_as_sc_mcu7t3v3__inv_2_1500/Y VSS gf180mcu_as_sc_mcu7t3v3__inv_2_1500/VNW
+ VSUBS gf180mcu_as_sc_mcu7t3v3__inv_2
Xgf180mcu_as_sc_mcu7t3v3__inv_2_1511 gf180mcu_as_sc_mcu7t3v3__inv_2_1511/VDD gf180mcu_as_sc_mcu7t3v3__inv_2_1511/VSS
+ gf180mcu_as_sc_mcu7t3v3__inv_2_1511/Y VSS gf180mcu_as_sc_mcu7t3v3__inv_2_1511/VNW
+ VSUBS gf180mcu_as_sc_mcu7t3v3__inv_2
.ends

.subckt gf180mcu_3v3_12t_2r2w_sram_1024x8
Xdetronyx_12t_write_driver_rc1_12 detronyx_12t_write_driver_rc1_12/VDD VSUBS detronyx_12t_write_driver_rc1_12/din
+ VSUBS detronyx_12t_write_driver_rc1_12/wbl0 VSUBS detronyx_12t_write_driver_rc1_12/a_240_2348#
+ detronyx_12t_write_driver_rc1
Xdetronyx_12t_write_driver_rc1_11 detronyx_12t_write_driver_rc1_11/VDD VSUBS detronyx_12t_write_driver_rc1_11/din
+ VSUBS detronyx_12t_write_driver_rc1_11/wbl0 VSUBS detronyx_12t_write_driver_rc1_11/a_240_2348#
+ detronyx_12t_write_driver_rc1
Xdetronyx_12t_write_driver_rc1_13 detronyx_12t_write_driver_rc1_13/VDD VSUBS detronyx_12t_write_driver_rc1_13/din
+ VSUBS detronyx_12t_write_driver_rc1_13/wbl0 VSUBS detronyx_12t_write_driver_rc1_13/a_240_2348#
+ detronyx_12t_write_driver_rc1
Xdetronyx_12t_write_driver_rc1_14 detronyx_12t_write_driver_rc1_14/VDD VSUBS detronyx_12t_write_driver_rc1_14/din
+ VSUBS detronyx_12t_write_driver_rc1_14/wbl0 VSUBS detronyx_12t_write_driver_rc1_14/a_240_2348#
+ detronyx_12t_write_driver_rc1
Xdetronyx_12t_write_driver_rc1_15 detronyx_12t_write_driver_rc1_15/VDD VSUBS VSUBS
+ VSUBS detronyx_12t_write_driver_rc1_15/wbl0 VSUBS VSUBS detronyx_12t_write_driver_rc1
Xdetronyx_12t_precharge_sense_rc1_10 detronyx_12t_precharge_sense_rc1_10/VDD VSUBS
+ detronyx_12t_precharge_sense_rc1_10/dout detronyx_12t_precharge_sense_rc1_10/ren
+ detronyx_12t_precharge_sense_rc1_10/ren detronyx_12t_precharge_sense_rc1_10/dout
+ detronyx_12t_precharge_sense_rc1_10/a_672_2172# detronyx_12t_precharge_sense_rc1_10/a_240_2172#
+ detronyx_12t_precharge_sense_rc1
Xdetronyx_12t_precharge_sense_rc1_11 detronyx_12t_precharge_sense_rc1_11/VDD VSUBS
+ detronyx_12t_precharge_sense_rc1_11/dout detronyx_12t_precharge_sense_rc1_11/ren
+ detronyx_12t_precharge_sense_rc1_11/ren detronyx_12t_precharge_sense_rc1_11/dout
+ detronyx_12t_precharge_sense_rc1_11/a_672_2172# detronyx_12t_precharge_sense_rc1_11/a_240_2172#
+ detronyx_12t_precharge_sense_rc1
Xdetronyx_12t_precharge_sense_rc1_12 detronyx_12t_precharge_sense_rc1_12/VDD VSUBS
+ detronyx_12t_precharge_sense_rc1_12/dout VSUBS VSUBS detronyx_12t_precharge_sense_rc1_12/dout
+ detronyx_12t_precharge_sense_rc1_12/a_672_2172# detronyx_12t_precharge_sense_rc1_12/a_240_2172#
+ detronyx_12t_precharge_sense_rc1
Xdetronyx_12t_precharge_sense_rc1_13 detronyx_12t_precharge_sense_rc1_13/VDD VSUBS
+ VSUBS VSUBS VSUBS VSUBS detronyx_12t_precharge_sense_rc1_13/a_672_2172# detronyx_12t_precharge_sense_rc1_13/a_240_2172#
+ detronyx_12t_precharge_sense_rc1
Xgf180mcu_3v3_12t_2r2w_sram_1024x8_array_control_core_0 gf180mcu_3v3_12t_2r2w_sram_1024x8_array_control_core_0/clk
+ VSUBS VSUBS detronyx_12t_write_driver_rc1_14/din detronyx_12t_write_driver_rc1_13/din
+ detronyx_12t_write_driver_rc1_12/din detronyx_12t_write_driver_rc1_11/din detronyx_12t_write_driver_rc1_10/din
+ detronyx_12t_write_driver_rc1_9/din detronyx_12t_write_driver_rc1_8/din detronyx_12t_write_driver_rc1_7/din
+ detronyx_12t_write_driver_rc1_6/din detronyx_12t_write_driver_rc1_5/din detronyx_12t_write_driver_rc1_4/din
+ detronyx_12t_write_driver_rc1_3/din detronyx_12t_write_driver_rc1_2/din detronyx_12t_write_driver_rc1_1/din
+ detronyx_12t_write_driver_rc1_0/din VSUBS VSUBS VSUBS detronyx_12t_precharge_sense_rc1_12/dout
+ detronyx_12t_precharge_sense_rc1_11/dout detronyx_12t_precharge_sense_rc1_10/dout
+ detronyx_12t_precharge_sense_rc1_9/dout VSUBS VSUBS VSUBS detronyx_12t_precharge_sense_rc1_5/dout
+ detronyx_12t_precharge_sense_rc1_4/dout detronyx_12t_precharge_sense_rc1_3/dout
+ detronyx_12t_precharge_sense_rc1_2/dout VSUBS detronyx_12t_precharge_sense_rc1_0/dout
+ VSUBS VSUBS gf180mcu_3v3_12t_2r2w_sram_1024x8_array_control_core_0/u_t023_011/c2_w0_bl
+ VSUBS VSUBS VSUBS VSUBS gf180mcu_3v3_12t_2r2w_sram_1024x8_array_control_core_0/u_t026_005/c2_w1_bl
+ VSUBS VSUBS VSUBS VSUBS VSUBS gf180mcu_3v3_12t_2r2w_sram_1024x8_array_control_core_0/u_t022_013/c2_w0_bl
+ VSUBS VSUBS VSUBS gf180mcu_3v3_12t_2r2w_sram_1024x8_array_control_core_0/u_t019_013/c2_w0_bl
+ VSUBS VSUBS VSUBS gf180mcu_3v3_12t_2r2w_sram_1024x8_array_control_core_0/u_t026_007/c2_w1_bl
+ VSUBS VSUBS VSUBS VSUBS VSUBS VSUBS VSUBS VSUBS VSUBS VSUBS VSUBS VSUBS VSUBS VSUBS
+ gf180mcu_3v3_12t_2r2w_sram_1024x8_array_control_core_0/a_200_39400# VSUBS VSUBS
+ gf180mcu_3v3_12t_2r2w_sram_1024x8_array_control_core_0/a_22600_95400# VSUBS VSUBS
+ VSUBS VSUBS VSUBS gf180mcu_3v3_12t_2r2w_sram_1024x8_array_control_core_0/u_t017_011/c2_w0_bl
+ VSUBS gf180mcu_3v3_12t_2r2w_sram_1024x8_array_control_core_0/u_t021_005/c2_w1_bl
+ VSUBS VSUBS gf180mcu_3v3_12t_2r2w_sram_1024x8_array_control_core_0/u_t019_005/c2_w1_bl
+ VSUBS VSUBS gf180mcu_3v3_12t_2r2w_sram_1024x8_array_control_core_0/u_t014_013/c2_w0_bl
+ VSUBS VSUBS VSUBS VSUBS gf180mcu_3v3_12t_2r2w_sram_1024x8_array_control_core_0/m4_10808_9273#
+ gf180mcu_3v3_12t_2r2w_sram_1024x8_array_control_core_0/u_t017_007/c2_w1_bl VSUBS
+ VSUBS gf180mcu_3v3_12t_2r2w_sram_1024x8_array_control_core_0/a_22600_3000# VSUBS
+ gf180mcu_3v3_12t_2r2w_sram_1024x8_array_control_core_0/a_14200_45000# VSUBS VSUBS
+ VSUBS VSUBS VSUBS VSUBS VSUBS VSUBS VSUBS gf180mcu_3v3_12t_2r2w_sram_1024x8_array_control_core_0/u_t011_011/c2_w0_bl
+ VSUBS VSUBS VSUBS gf180mcu_3v3_12t_2r2w_sram_1024x8_array_control_core_0/u_t009_011/c2_w0_bl
+ VSUBS gf180mcu_3v3_12t_2r2w_sram_1024x8_array_control_core_0/a_22600_120600# gf180mcu_3v3_12t_2r2w_sram_1024x8_array_control_core_0/a_200_92600#
+ gf180mcu_3v3_12t_2r2w_sram_1024x8_array_control_core_0/a_200_19800# gf180mcu_3v3_12t_2r2w_sram_1024x8_array_control_core_0/u_t014_005/c2_w1_bl
+ VSUBS gf180mcu_3v3_12t_2r2w_sram_1024x8_array_control_core_0/a_22600_75800# VSUBS
+ VSUBS VSUBS gf180mcu_3v3_12t_2r2w_sram_1024x8_array_control_core_0/u_t009_013/c2_w0_bl
+ VSUBS gf180mcu_3v3_12t_2r2w_sram_1024x8_array_control_core_0/u_t013_007/c2_w1_bl
+ VSUBS VSUBS VSUBS VSUBS VSUBS VSUBS VSUBS VSUBS VSUBS VSUBS gf180mcu_3v3_12t_2r2w_sram_1024x8_array_control_core_0/a_14200_109400#
+ VSUBS VSUBS VSUBS VSUBS VSUBS VSUBS VSUBS VSUBS VSUBS VSUBS gf180mcu_3v3_12t_2r2w_sram_1024x8_array_control_core_0/a_14200_25400#
+ VSUBS VSUBS VSUBS VSUBS VSUBS VSUBS VSUBS gf180mcu_3v3_12t_2r2w_sram_1024x8_array_control_core_0/m4_15800_9273#
+ VSUBS gf180mcu_3v3_12t_2r2w_sram_1024x8_array_control_core_0/u_t009_005/c2_w1_bl
+ VSUBS gf180mcu_3v3_12t_2r2w_sram_1024x8_array_control_core_0/u_t002_013/c2_w0_bl
+ VSUBS VSUBS VSUBS VSUBS VSUBS VSUBS VSUBS VSUBS VSUBS VSUBS VSUBS VSUBS VSUBS VSUBS
+ VSUBS VSUBS VSUBS VSUBS VSUBS VSUBS VSUBS gf180mcu_3v3_12t_2r2w_sram_1024x8_array_control_core_0/u_t030_012/c2_w0_bl
+ VSUBS VSUBS gf180mcu_3v3_12t_2r2w_sram_1024x8_array_control_core_0/a_200_28200#
+ VSUBS VSUBS gf180mcu_3v3_12t_2r2w_sram_1024x8_array_control_core_0/a_22600_84200#
+ VSUBS gf180mcu_3v3_12t_2r2w_sram_1024x8_array_control_core_0/m4_21400_9273# VSUBS
+ VSUBS gf180mcu_3v3_12t_2r2w_sram_1024x8_array_control_core_0/u_t027_014/c2_w0_bl
+ VSUBS VSUBS gf180mcu_3v3_12t_2r2w_sram_1024x8_array_control_core_0/u_t000_007/c2_w1_bl
+ VSUBS VSUBS VSUBS VSUBS VSUBS VSUBS VSUBS VSUBS VSUBS VSUBS VSUBS VSUBS VSUBS VSUBS
+ VSUBS VSUBS VSUBS VSUBS VSUBS VSUBS VSUBS VSUBS gf180mcu_3v3_12t_2r2w_sram_1024x8_array_control_core_0/u_t030_004/c2_w1_bl
+ VSUBS VSUBS VSUBS VSUBS gf180mcu_3v3_12t_2r2w_sram_1024x8_array_control_core_0/u_t026_012/c2_w0_bl
+ VSUBS VSUBS gf180mcu_3v3_12t_2r2w_sram_1024x8_array_control_core_0/u_t027_006/c2_w1_bl
+ VSUBS VSUBS VSUBS gf180mcu_3v3_12t_2r2w_sram_1024x8_array_control_core_0/u_t022_014/c2_w0_bl
+ VSUBS VSUBS VSUBS VSUBS VSUBS gf180mcu_3v3_12t_2r2w_sram_1024x8_array_control_core_0/a_200_81400#
+ VSUBS VSUBS VSUBS VSUBS gf180mcu_3v3_12t_2r2w_sram_1024x8_array_control_core_0/a_22600_64600#
+ VSUBS VSUBS VSUBS VSUBS VSUBS VSUBS VSUBS VSUBS VSUBS VSUBS VSUBS VSUBS VSUBS VSUBS
+ gf180mcu_3v3_12t_2r2w_sram_1024x8_array_control_core_0/u_t026_004/c2_w1_bl VSUBS
+ VSUBS VSUBS VSUBS gf180mcu_3v3_12t_2r2w_sram_1024x8_array_control_core_0/u_t017_012/c2_w0_bl
+ VSUBS VSUBS gf180mcu_3v3_12t_2r2w_sram_1024x8_array_control_core_0/u_t022_006/c2_w1_bl
+ VSUBS VSUBS gf180mcu_3v3_12t_2r2w_sram_1024x8_array_control_core_0/a_14200_14200#
+ VSUBS VSUBS VSUBS gf180mcu_3v3_12t_2r2w_sram_1024x8_array_control_core_0/u_t015_014/c2_w0_bl
+ VSUBS VSUBS VSUBS VSUBS VSUBS VSUBS VSUBS VSUBS VSUBS VSUBS VSUBS VSUBS VSUBS VSUBS
+ VSUBS VSUBS VSUBS VSUBS VSUBS VSUBS gf180mcu_3v3_12t_2r2w_sram_1024x8_array_control_core_0/a_200_61800#
+ VSUBS VSUBS VSUBS VSUBS gf180mcu_3v3_12t_2r2w_sram_1024x8_array_control_core_0/u_t017_004/c2_w1_bl
+ VSUBS gf180mcu_3v3_12t_2r2w_sram_1024x8_array_control_core_0/u_t013_012/c2_w0_bl
+ VSUBS VSUBS VSUBS VSUBS gf180mcu_3v3_12t_2r2w_sram_1024x8_array_control_core_0/u_t015_006/c2_w1_bl
+ VSUBS VSUBS VSUBS VSUBS VSUBS gf180mcu_3v3_12t_2r2w_sram_1024x8_array_control_core_0/u_t010_014/c2_w0_bl
+ VSUBS VSUBS VSUBS VSUBS gf180mcu_3v3_12t_2r2w_sram_1024x8_array_control_core_0/a_19800_120600#
+ VSUBS VSUBS gf180mcu_3v3_12t_2r2w_sram_1024x8_array_control_core_0/u_t009_014/c2_w0_bl
+ VSUBS VSUBS VSUBS VSUBS gf180mcu_3v3_12t_2r2w_sram_1024x8_array_control_core_0/a_200_17000#
+ VSUBS VSUBS gf180mcu_3v3_12t_2r2w_sram_1024x8_array_control_core_0/a_22600_73000#
+ VSUBS VSUBS VSUBS VSUBS VSUBS gf180mcu_3v3_12t_2r2w_sram_1024x8_array_control_core_0/u_t013_004/c2_w1_bl
+ VSUBS VSUBS VSUBS VSUBS VSUBS VSUBS VSUBS VSUBS VSUBS VSUBS gf180mcu_3v3_12t_2r2w_sram_1024x8_array_control_core_0/u_t010_006/c2_w1_bl
+ VSUBS VSUBS VSUBS VSUBS VSUBS gf180mcu_3v3_12t_2r2w_sram_1024x8_array_control_core_0/u_t009_006/c2_w1_bl
+ VSUBS VSUBS VSUBS VSUBS VSUBS VSUBS VSUBS VSUBS VSUBS VSUBS VSUBS VSUBS VSUBS VSUBS
+ VSUBS VSUBS VSUBS VSUBS VSUBS gf180mcu_3v3_12t_2r2w_sram_1024x8_array_control_core_0/a_200_70200#
+ gf180mcu_3v3_12t_2r2w_sram_1024x8_array_control_core_0/a_22600_53400# VSUBS VSUBS
+ gf180mcu_3v3_12t_2r2w_sram_1024x8_array_control_core_0/u_t001_012/c2_w0_bl VSUBS
+ VSUBS VSUBS VSUBS VSUBS VSUBS VSUBS VSUBS VSUBS VSUBS VSUBS VSUBS VSUBS VSUBS VSUBS
+ VSUBS VSUBS VSUBS VSUBS VSUBS VSUBS VSUBS gf180mcu_3v3_12t_2r2w_sram_1024x8_array_control_core_0/u_t027_011/c2_w0_bl
+ VSUBS gf180mcu_3v3_12t_2r2w_sram_1024x8_array_control_core_0/u_t000_004/c2_w1_bl
+ VSUBS VSUBS VSUBS VSUBS VSUBS VSUBS VSUBS VSUBS VSUBS gf180mcu_3v3_12t_2r2w_sram_1024x8_array_control_core_0/u_t026_013/c2_w0_bl
+ VSUBS gf180mcu_3v3_12t_2r2w_sram_1024x8_array_control_core_0/a_200_50600# VSUBS
+ VSUBS gf180mcu_3v3_12t_2r2w_sram_1024x8_array_control_core_0/u_t030_007/c2_w1_bl
+ VSUBS gf180mcu_3v3_12t_2r2w_sram_1024x8_array_control_core_0/a_22600_33800# VSUBS
+ VSUBS gf180mcu_3v3_12t_2r2w_sram_1024x8_array_control_core_0/u_t028_007/c2_w1_bl
+ VSUBS VSUBS VSUBS gf180mcu_3v3_12t_2r2w_sram_1024x8_array_control_core_0/a_22600_200#
+ gf180mcu_3v3_12t_2r2w_sram_1024x8_array_control_core_0/a_22600_117800# gf180mcu_3v3_12t_2r2w_sram_1024x8_array_control_core_0/a_200_89800#
+ VSUBS VSUBS VSUBS VSUBS gf180mcu_3v3_12t_2r2w_sram_1024x8_array_control_core_0/u_t022_011/c2_w0_bl
+ detronyx_12t_precharge_sense_rc1_0/dout VSUBS VSUBS gf180mcu_3v3_12t_2r2w_sram_1024x8_array_control_core_0/u_t026_005/c2_w1_bl
+ VSUBS gf180mcu_3v3_12t_2r2w_sram_1024x8_array_control_core_0/u_t022_013/c2_w0_bl
+ VSUBS VSUBS gf180mcu_3v3_12t_2r2w_sram_1024x8_array_control_core_0/u_t018_013/c2_w0_bl
+ VSUBS VSUBS gf180mcu_3v3_12t_2r2w_sram_1024x8_array_control_core_0/u_t023_007/c2_w1_bl
+ VSUBS VSUBS gf180mcu_3v3_12t_2r2w_sram_1024x8_array_control_core_0/a_14200_95400#
+ VSUBS VSUBS VSUBS VSUBS VSUBS VSUBS VSUBS VSUBS VSUBS VSUBS VSUBS VSUBS VSUBS VSUBS
+ VSUBS VSUBS VSUBS VSUBS VSUBS gf180mcu_3v3_12t_2r2w_sram_1024x8_array_control_core_0/u_t015_011/c2_w0_bl
+ VSUBS VSUBS VSUBS gf180mcu_3v3_12t_2r2w_sram_1024x8_array_control_core_0/u_t021_005/c2_w1_bl
+ VSUBS gf180mcu_3v3_12t_2r2w_sram_1024x8_array_control_core_0/u_t018_005/c2_w1_bl
+ VSUBS VSUBS gf180mcu_3v3_12t_2r2w_sram_1024x8_array_control_core_0/u_t013_013/c2_w0_bl
+ VSUBS VSUBS VSUBS VSUBS VSUBS gf180mcu_3v3_12t_2r2w_sram_1024x8_array_control_core_0/a_22600_42200#
+ gf180mcu_3v3_12t_2r2w_sram_1024x8_array_control_core_0/u_t017_007/c2_w1_bl VSUBS
+ VSUBS VSUBS VSUBS VSUBS VSUBS VSUBS VSUBS VSUBS VSUBS VSUBS gf180mcu_3v3_12t_2r2w_sram_1024x8_array_control_core_0/a_200_98200#
+ VSUBS gf180mcu_3v3_12t_2r2w_sram_1024x8_array_control_core_0/a_14200_75800# VSUBS
+ gf180mcu_3v3_12t_2r2w_sram_1024x8_array_control_core_0/u_t010_011/c2_w0_bl VSUBS
+ VSUBS VSUBS VSUBS VSUBS gf180mcu_3v3_12t_2r2w_sram_1024x8_array_control_core_0/u_t009_011/c2_w0_bl
+ VSUBS gf180mcu_3v3_12t_2r2w_sram_1024x8_array_control_core_0/u_t013_005/c2_w1_bl
+ VSUBS VSUBS VSUBS VSUBS VSUBS VSUBS VSUBS gf180mcu_3v3_12t_2r2w_sram_1024x8_array_control_core_0/u_t006_013/c2_w0_bl
+ gf180mcu_3v3_12t_2r2w_sram_1024x8_array_control_core_0/u_t011_007/c2_w1_bl VSUBS
+ VSUBS VSUBS VSUBS VSUBS gf180mcu_3v3_12t_2r2w_sram_1024x8_array_control_core_0/u_t009_007/c2_w1_bl
+ VSUBS VSUBS VSUBS VSUBS VSUBS VSUBS VSUBS VSUBS VSUBS gf180mcu_3v3_12t_2r2w_sram_1024x8_array_control_core_0/a_22600_22600#
+ VSUBS VSUBS VSUBS VSUBS VSUBS VSUBS VSUBS VSUBS VSUBS VSUBS VSUBS gf180mcu_3v3_12t_2r2w_sram_1024x8_array_control_core_0/a_22600_106600#
+ gf180mcu_3v3_12t_2r2w_sram_1024x8_array_control_core_0/a_200_78600# gf180mcu_3v3_12t_2r2w_sram_1024x8_array_control_core_0/u_t006_005/c2_w1_bl
+ gf180mcu_3v3_12t_2r2w_sram_1024x8_array_control_core_0/u_t001_013/c2_w0_bl VSUBS
+ VSUBS VSUBS VSUBS VSUBS VSUBS VSUBS VSUBS VSUBS VSUBS VSUBS VSUBS VSUBS VSUBS VSUBS
+ VSUBS VSUBS gf180mcu_3v3_12t_2r2w_sram_1024x8_array_control_core_0/a_14200_84200#
+ VSUBS gf180mcu_3v3_12t_2r2w_sram_1024x8_array_control_core_0/u_t030_012/c2_w0_bl
+ VSUBS VSUBS VSUBS gf180mcu_3v3_12t_2r2w_sram_1024x8_array_control_core_0/u_t028_012/c2_w0_bl
+ gf180mcu_3v3_12t_2r2w_sram_1024x8_array_control_core_0/u_t001_005/c2_w1_bl VSUBS
+ VSUBS VSUBS VSUBS VSUBS VSUBS VSUBS gf180mcu_3v3_12t_2r2w_sram_1024x8_array_control_core_0/u_t026_014/c2_w0_bl
+ VSUBS VSUBS VSUBS VSUBS VSUBS VSUBS VSUBS VSUBS VSUBS VSUBS VSUBS VSUBS VSUBS VSUBS
+ VSUBS VSUBS VSUBS gf180mcu_3v3_12t_2r2w_sram_1024x8_array_control_core_0/u_t030_004/c2_w1_bl
+ gf180mcu_3v3_12t_2r2w_sram_1024x8_array_control_core_0/a_22600_31000# VSUBS VSUBS
+ gf180mcu_3v3_12t_2r2w_sram_1024x8_array_control_core_0/u_t028_004/c2_w1_bl VSUBS
+ VSUBS VSUBS VSUBS gf180mcu_3v3_12t_2r2w_sram_1024x8_array_control_core_0/u_t023_012/c2_w0_bl
+ VSUBS VSUBS gf180mcu_3v3_12t_2r2w_sram_1024x8_array_control_core_0/u_t026_006/c2_w1_bl
+ gf180mcu_3v3_12t_2r2w_sram_1024x8_array_control_core_0/a_22600_115000# gf180mcu_3v3_12t_2r2w_sram_1024x8_array_control_core_0/a_200_87000#
+ VSUBS gf180mcu_3v3_12t_2r2w_sram_1024x8_array_control_core_0/a_14200_64600# VSUBS
+ gf180mcu_3v3_12t_2r2w_sram_1024x8_array_control_core_0/u_t022_014/c2_w0_bl VSUBS
+ VSUBS VSUBS VSUBS gf180mcu_3v3_12t_2r2w_sram_1024x8_array_control_core_0/u_t019_014/c2_w0_bl
+ VSUBS VSUBS VSUBS VSUBS VSUBS VSUBS VSUBS VSUBS VSUBS VSUBS VSUBS VSUBS VSUBS VSUBS
+ VSUBS VSUBS VSUBS VSUBS VSUBS VSUBS gf180mcu_3v3_12t_2r2w_sram_1024x8_array_control_core_0/u_t023_004/c2_w1_bl
+ VSUBS VSUBS VSUBS VSUBS VSUBS VSUBS VSUBS VSUBS gf180mcu_3v3_12t_2r2w_sram_1024x8_array_control_core_0/u_t017_012/c2_w0_bl
+ gf180mcu_3v3_12t_2r2w_sram_1024x8_array_control_core_0/u_t021_006/c2_w1_bl gf180mcu_3v3_12t_2r2w_sram_1024x8_array_control_core_0/a_22600_11400#
+ VSUBS gf180mcu_3v3_12t_2r2w_sram_1024x8_array_control_core_0/a_25400_200# VSUBS
+ VSUBS gf180mcu_3v3_12t_2r2w_sram_1024x8_array_control_core_0/u_t019_006/c2_w1_bl
+ VSUBS VSUBS VSUBS VSUBS gf180mcu_3v3_12t_2r2w_sram_1024x8_array_control_core_0/u_t014_014/c2_w0_bl
+ VSUBS VSUBS VSUBS VSUBS VSUBS VSUBS gf180mcu_3v3_12t_2r2w_sram_1024x8_array_control_core_0/a_200_67400#
+ VSUBS VSUBS gf180mcu_3v3_12t_2r2w_sram_1024x8_array_control_core_0/a_200_103800#
+ VSUBS VSUBS VSUBS VSUBS gf180mcu_3v3_12t_2r2w_sram_1024x8_array_control_core_0/a_19800_200#
+ VSUBS VSUBS gf180mcu_3v3_12t_2r2w_sram_1024x8_array_control_core_0/u_t017_004/c2_w1_bl
+ VSUBS gf180mcu_3v3_12t_2r2w_sram_1024x8_array_control_core_0/u_t011_012/c2_w0_bl
+ VSUBS VSUBS VSUBS gf180mcu_3v3_12t_2r2w_sram_1024x8_array_control_core_0/u_t009_012/c2_w0_bl
+ VSUBS gf180mcu_3v3_12t_2r2w_sram_1024x8_array_control_core_0/u_t014_006/c2_w1_bl
+ VSUBS VSUBS VSUBS VSUBS gf180mcu_3v3_12t_2r2w_sram_1024x8_array_control_core_0/a_14200_73000#
+ VSUBS VSUBS VSUBS VSUBS VSUBS VSUBS gf180mcu_3v3_12t_2r2w_sram_1024x8_array_control_core_0/u_t009_014/c2_w0_bl
+ VSUBS VSUBS VSUBS VSUBS VSUBS VSUBS VSUBS VSUBS VSUBS gf180mcu_3v3_12t_2r2w_sram_1024x8_array_control_core_0/gf180mcu_as_sc_mcu7t3v3__inv_2_977/A
+ VSUBS VSUBS VSUBS gf180mcu_3v3_12t_2r2w_sram_1024x8_array_control_core_0/a_200_47800#
+ gf180mcu_3v3_12t_2r2w_sram_1024x8_array_control_core_0/u_t011_004/c2_w1_bl VSUBS
+ VSUBS VSUBS VSUBS VSUBS VSUBS VSUBS VSUBS VSUBS gf180mcu_3v3_12t_2r2w_sram_1024x8_array_control_core_0/u_t009_004/c2_w1_bl
+ VSUBS VSUBS VSUBS VSUBS VSUBS VSUBS gf180mcu_3v3_12t_2r2w_sram_1024x8_array_control_core_0/u_t009_006/c2_w1_bl
+ VSUBS VSUBS gf180mcu_3v3_12t_2r2w_sram_1024x8_array_control_core_0/m4_7400_9273#
+ VSUBS VSUBS VSUBS gf180mcu_3v3_12t_2r2w_sram_1024x8_array_control_core_0/u_t002_014/c2_w0_bl
+ VSUBS VSUBS VSUBS VSUBS VSUBS VSUBS VSUBS VSUBS gf180mcu_3v3_12t_2r2w_sram_1024x8_array_control_core_0/a_14200_53400#
+ VSUBS gf180mcu_3v3_12t_2r2w_sram_1024x8_array_control_core_0/a_200_112200# gf180mcu_3v3_12t_2r2w_sram_1024x8_array_control_core_0/a_22600_59000#
+ VSUBS VSUBS VSUBS VSUBS VSUBS VSUBS VSUBS VSUBS VSUBS VSUBS gf180mcu_3v3_12t_2r2w_sram_1024x8_array_control_core_0/u_t030_013/c2_w0_bl
+ VSUBS VSUBS VSUBS VSUBS VSUBS VSUBS VSUBS VSUBS VSUBS VSUBS VSUBS VSUBS VSUBS VSUBS
+ VSUBS VSUBS VSUBS VSUBS VSUBS VSUBS VSUBS VSUBS VSUBS VSUBS gf180mcu_3v3_12t_2r2w_sram_1024x8_array_control_core_0/u_t026_011/c2_w0_bl
+ VSUBS VSUBS VSUBS VSUBS gf180mcu_3v3_12t_2r2w_sram_1024x8_array_control_core_0/a_200_56200#
+ VSUBS gf180mcu_3v3_12t_2r2w_sram_1024x8_array_control_core_0/a_14200_33800# VSUBS
+ gf180mcu_3v3_12t_2r2w_sram_1024x8_array_control_core_0/a_22600_39400# gf180mcu_3v3_12t_2r2w_sram_1024x8_array_control_core_0/a_19800_3000#
+ gf180mcu_3v3_12t_2r2w_sram_1024x8_array_control_core_0/u_t030_005/c2_w1_bl VSUBS
+ VSUBS VSUBS VSUBS gf180mcu_3v3_12t_2r2w_sram_1024x8_array_control_core_0/u_t026_013/c2_w0_bl
+ VSUBS VSUBS VSUBS VSUBS VSUBS gf180mcu_3v3_12t_2r2w_sram_1024x8_array_control_core_0/u_t027_007/c2_w1_bl
+ VSUBS VSUBS VSUBS VSUBS VSUBS VSUBS VSUBS VSUBS VSUBS VSUBS VSUBS VSUBS gf180mcu_3v3_12t_2r2w_sram_1024x8_array_control_core_0/gf180mcu_as_sc_mcu7t3v3__inv_2_1340/Y
+ VSUBS VSUBS gf180mcu_3v3_12t_2r2w_sram_1024x8_array_control_core_0/u_t022_011/c2_w0_bl
+ VSUBS VSUBS VSUBS VSUBS gf180mcu_3v3_12t_2r2w_sram_1024x8_array_control_core_0/u_t019_011/c2_w0_bl
+ VSUBS VSUBS gf180mcu_3v3_12t_2r2w_sram_1024x8_array_control_core_0/u_t026_005/c2_w1_bl
+ VSUBS gf180mcu_3v3_12t_2r2w_sram_1024x8_array_control_core_0/gf180mcu_as_sc_mcu7t3v3__inv_2_66/Y
+ VSUBS VSUBS VSUBS VSUBS gf180mcu_3v3_12t_2r2w_sram_1024x8_array_control_core_0/u_t017_013/c2_w0_bl
+ VSUBS gf180mcu_3v3_12t_2r2w_sram_1024x8_array_control_core_0/a_25400_3000# VSUBS
+ VSUBS gf180mcu_3v3_12t_2r2w_sram_1024x8_array_control_core_0/u_t022_007/c2_w1_bl
+ gf180mcu_3v3_12t_2r2w_sram_1024x8_array_control_core_0/a_200_36600# VSUBS gf180mcu_3v3_12t_2r2w_sram_1024x8_array_control_core_0/a_22600_92600#
+ VSUBS gf180mcu_3v3_12t_2r2w_sram_1024x8_array_control_core_0/a_22600_19800# VSUBS
+ VSUBS VSUBS VSUBS VSUBS VSUBS VSUBS VSUBS VSUBS VSUBS VSUBS VSUBS VSUBS VSUBS VSUBS
+ VSUBS VSUBS gf180mcu_3v3_12t_2r2w_sram_1024x8_array_control_core_0/u_t014_011/c2_w0_bl
+ VSUBS VSUBS VSUBS gf180mcu_3v3_12t_2r2w_sram_1024x8_array_control_core_0/u_t017_005/c2_w1_bl
+ VSUBS gf180mcu_3v3_12t_2r2w_sram_1024x8_array_control_core_0/a_14200_42200# gf180mcu_3v3_12t_2r2w_sram_1024x8_array_control_core_0/a_200_101000#
+ gf180mcu_3v3_12t_2r2w_sram_1024x8_array_control_core_0/u_t013_013/c2_w0_bl VSUBS
+ VSUBS VSUBS VSUBS VSUBS gf180mcu_3v3_12t_2r2w_sram_1024x8_array_control_core_0/u_t015_007/c2_w1_bl
+ VSUBS VSUBS VSUBS VSUBS VSUBS VSUBS VSUBS VSUBS VSUBS VSUBS VSUBS VSUBS VSUBS VSUBS
+ VSUBS VSUBS VSUBS gf180mcu_3v3_12t_2r2w_sram_1024x8_array_control_core_0/m4_18600_9273#
+ gf180mcu_3v3_12t_2r2w_sram_1024x8_array_control_core_0/a_28200_200# VSUBS gf180mcu_3v3_12t_2r2w_sram_1024x8_array_control_core_0/u_t009_011/c2_w0_bl
+ VSUBS VSUBS gf180mcu_3v3_12t_2r2w_sram_1024x8_array_control_core_0/u_t013_005/c2_w1_bl
+ VSUBS VSUBS VSUBS VSUBS VSUBS VSUBS gf180mcu_3v3_12t_2r2w_sram_1024x8_array_control_core_0/a_14200_106600#
+ VSUBS VSUBS gf180mcu_3v3_12t_2r2w_sram_1024x8_array_control_core_0/u_t010_007/c2_w1_bl
+ VSUBS VSUBS gf180mcu_3v3_12t_2r2w_sram_1024x8_array_control_core_0/a_200_45000#
+ VSUBS gf180mcu_3v3_12t_2r2w_sram_1024x8_array_control_core_0/a_14200_22600# VSUBS
+ gf180mcu_3v3_12t_2r2w_sram_1024x8_array_control_core_0/u_t009_007/c2_w1_bl VSUBS
+ VSUBS gf180mcu_3v3_12t_2r2w_sram_1024x8_array_control_core_0/a_22600_28200# VSUBS
+ VSUBS VSUBS VSUBS VSUBS VSUBS VSUBS VSUBS VSUBS VSUBS VSUBS VSUBS VSUBS gf180mcu_3v3_12t_2r2w_sram_1024x8_array_control_core_0/u_t002_011/c2_w0_bl
+ VSUBS VSUBS VSUBS VSUBS VSUBS gf180mcu_3v3_12t_2r2w_sram_1024x8_array_control_core_0/m4_24200_9273#
+ gf180mcu_3v3_12t_2r2w_sram_1024x8_array_control_core_0/u_t001_013/c2_w0_bl VSUBS
+ VSUBS VSUBS VSUBS VSUBS VSUBS VSUBS VSUBS VSUBS VSUBS VSUBS VSUBS detronyx_12t_precharge_sense_rc1_0/dout
+ VSUBS VSUBS VSUBS VSUBS gf180mcu_3v3_12t_2r2w_sram_1024x8_array_control_core_0/a_200_25400#
+ VSUBS VSUBS VSUBS gf180mcu_3v3_12t_2r2w_sram_1024x8_array_control_core_0/a_22600_81400#
+ VSUBS VSUBS VSUBS VSUBS gf180mcu_3v3_12t_2r2w_sram_1024x8_array_control_core_0/u_t027_012/c2_w0_bl
+ VSUBS VSUBS gf180mcu_3v3_12t_2r2w_sram_1024x8_array_control_core_0/u_t000_005/c2_w1_bl
+ VSUBS VSUBS VSUBS VSUBS gf180mcu_3v3_12t_2r2w_sram_1024x8_array_control_core_0/a_14200_115000#
+ VSUBS gf180mcu_3v3_12t_2r2w_sram_1024x8_array_control_core_0/u_t026_014/c2_w0_bl
+ VSUBS VSUBS VSUBS VSUBS VSUBS VSUBS VSUBS VSUBS VSUBS VSUBS VSUBS VSUBS gf180mcu_3v3_12t_2r2w_sram_1024x8_array_control_core_0/a_14200_31000#
+ VSUBS VSUBS VSUBS VSUBS VSUBS VSUBS VSUBS VSUBS VSUBS gf180mcu_3v3_12t_2r2w_sram_1024x8_array_control_core_0/m4_29800_9273#
+ VSUBS VSUBS gf180mcu_3v3_12t_2r2w_sram_1024x8_array_control_core_0/u_t027_004/c2_w1_bl
+ VSUBS VSUBS VSUBS gf180mcu_3v3_12t_2r2w_sram_1024x8_array_control_core_0/u_t022_012/c2_w0_bl
+ VSUBS VSUBS gf180mcu_3v3_12t_2r2w_sram_1024x8_array_control_core_0/a_22600_61800#
+ gf180mcu_3v3_12t_2r2w_sram_1024x8_array_control_core_0/u_t026_006/c2_w1_bl gf180mcu_3v3_12t_2r2w_sram_1024x8_array_control_core_0/u_t022_014/c2_w0_bl
+ VSUBS VSUBS VSUBS gf180mcu_3v3_12t_2r2w_sram_1024x8_array_control_core_0/u_t018_014/c2_w0_bl
+ VSUBS VSUBS VSUBS VSUBS VSUBS VSUBS VSUBS VSUBS VSUBS VSUBS VSUBS VSUBS VSUBS VSUBS
+ VSUBS VSUBS VSUBS gf180mcu_3v3_12t_2r2w_sram_1024x8_array_control_core_0/u_t022_004/c2_w1_bl
+ gf180mcu_3v3_12t_2r2w_sram_1024x8_array_control_core_0/a_14200_11400# VSUBS VSUBS
+ gf180mcu_3v3_12t_2r2w_sram_1024x8_array_control_core_0/a_22600_17000# VSUBS VSUBS
+ VSUBS gf180mcu_3v3_12t_2r2w_sram_1024x8_array_control_core_0/u_t015_012/c2_w0_bl
+ VSUBS VSUBS gf180mcu_3v3_12t_2r2w_sram_1024x8_array_control_core_0/u_t021_006/c2_w1_bl
+ VSUBS VSUBS VSUBS gf180mcu_3v3_12t_2r2w_sram_1024x8_array_control_core_0/u_t018_006/c2_w1_bl
+ VSUBS detronyx_12t_precharge_sense_rc1_0/dout gf180mcu_3v3_12t_2r2w_sram_1024x8_array_control_core_0/a_22600_8600#
+ VSUBS gf180mcu_3v3_12t_2r2w_sram_1024x8_array_control_core_0/a_200_109400# gf180mcu_3v3_12t_2r2w_sram_1024x8_array_control_core_0/u_t013_014/c2_w0_bl
+ VSUBS VSUBS VSUBS VSUBS VSUBS VSUBS VSUBS VSUBS VSUBS VSUBS gf180mcu_3v3_12t_2r2w_sram_1024x8_array_control_core_0/u_t015_004/c2_w1_bl
+ VSUBS gf180mcu_3v3_12t_2r2w_sram_1024x8_array_control_core_0/u_t010_012/c2_w0_bl
+ VSUBS VSUBS VSUBS gf180mcu_3v3_12t_2r2w_sram_1024x8_array_control_core_0/u_t009_012/c2_w0_bl
+ gf180mcu_3v3_12t_2r2w_sram_1024x8_array_control_core_0/a_200_14200# VSUBS gf180mcu_3v3_12t_2r2w_sram_1024x8_array_control_core_0/u_t013_006/c2_w1_bl
+ gf180mcu_3v3_12t_2r2w_sram_1024x8_array_control_core_0/a_22600_70200# VSUBS VSUBS
+ VSUBS VSUBS VSUBS VSUBS VSUBS VSUBS VSUBS VSUBS gf180mcu_3v3_12t_2r2w_sram_1024x8_array_control_core_0/u_t006_014/c2_w0_bl
+ VSUBS VSUBS VSUBS VSUBS VSUBS VSUBS VSUBS VSUBS VSUBS VSUBS VSUBS VSUBS VSUBS VSUBS
+ VSUBS VSUBS VSUBS gf180mcu_3v3_12t_2r2w_sram_1024x8_array_control_core_0/u_t010_004/c2_w1_bl
+ VSUBS VSUBS VSUBS VSUBS VSUBS gf180mcu_3v3_12t_2r2w_sram_1024x8_array_control_core_0/u_t009_004/c2_w1_bl
+ VSUBS VSUBS VSUBS VSUBS VSUBS VSUBS VSUBS gf180mcu_3v3_12t_2r2w_sram_1024x8_array_control_core_0/u_t006_006/c2_w1_bl
+ VSUBS VSUBS gf180mcu_3v3_12t_2r2w_sram_1024x8_array_control_core_0/gf180mcu_as_sc_mcu7t3v3__inv_2_1684/Y
+ VSUBS VSUBS VSUBS gf180mcu_3v3_12t_2r2w_sram_1024x8_array_control_core_0/u_t001_014/c2_w0_bl
+ gf180mcu_3v3_12t_2r2w_sram_1024x8_array_control_core_0/a_14200_59000# VSUBS VSUBS
+ VSUBS VSUBS VSUBS gf180mcu_3v3_12t_2r2w_sram_1024x8_array_control_core_0/a_22600_50600#
+ VSUBS VSUBS VSUBS VSUBS VSUBS gf180mcu_3v3_12t_2r2w_sram_1024x8_array_control_core_0/a_200_8600#
+ VSUBS VSUBS VSUBS VSUBS gf180mcu_3v3_12t_2r2w_sram_1024x8_array_control_core_0/a_22600_89800#
+ VSUBS VSUBS gf180mcu_3v3_12t_2r2w_sram_1024x8_array_control_core_0/u_t030_013/c2_w0_bl
+ VSUBS VSUBS gf180mcu_3v3_12t_2r2w_sram_1024x8_array_control_core_0/u_t028_013/c2_w0_bl
+ VSUBS gf180mcu_3v3_12t_2r2w_sram_1024x8_array_control_core_0/u_t001_006/c2_w1_bl
+ VSUBS gf180mcu_3v3_12t_2r2w_sram_1024x8_array_control_core_0/gf180mcu_as_sc_mcu7t3v3__inv_2_8/Y
+ VSUBS VSUBS VSUBS VSUBS VSUBS VSUBS VSUBS VSUBS VSUBS VSUBS VSUBS VSUBS VSUBS VSUBS
+ VSUBS VSUBS VSUBS VSUBS VSUBS VSUBS gf180mcu_3v3_12t_2r2w_sram_1024x8_array_control_core_0/a_14200_39400#
+ VSUBS gf180mcu_3v3_12t_2r2w_sram_1024x8_array_control_core_0/u_t026_011/c2_w0_bl
+ VSUBS gf180mcu_3v3_12t_2r2w_sram_1024x8_array_control_core_0/u_t030_005/c2_w1_bl
+ VSUBS VSUBS gf180mcu_3v3_12t_2r2w_sram_1024x8_array_control_core_0/u_t028_005/c2_w1_bl
+ VSUBS VSUBS gf180mcu_3v3_12t_2r2w_sram_1024x8_array_control_core_0/u_t023_013/c2_w0_bl
+ detronyx_12t_precharge_sense_rc1_0/dout VSUBS VSUBS VSUBS gf180mcu_3v3_12t_2r2w_sram_1024x8_array_control_core_0/u_t026_007/c2_w1_bl
+ VSUBS VSUBS VSUBS VSUBS VSUBS VSUBS VSUBS VSUBS VSUBS VSUBS VSUBS VSUBS VSUBS gf180mcu_3v3_12t_2r2w_sram_1024x8_array_control_core_0/u_t022_011/c2_w0_bl
+ VSUBS VSUBS VSUBS VSUBS VSUBS VSUBS VSUBS gf180mcu_3v3_12t_2r2w_sram_1024x8_array_control_core_0/u_t018_011/c2_w0_bl
+ VSUBS gf180mcu_3v3_12t_2r2w_sram_1024x8_array_control_core_0/a_28200_120600# gf180mcu_3v3_12t_2r2w_sram_1024x8_array_control_core_0/u_t023_005/c2_w1_bl
+ VSUBS VSUBS gf180mcu_3v3_12t_2r2w_sram_1024x8_array_control_core_0/a_14200_92600#
+ gf180mcu_3v3_12t_2r2w_sram_1024x8_array_control_core_0/a_14200_19800# gf180mcu_3v3_12t_2r2w_sram_1024x8_array_control_core_0/a_22600_98200#
+ VSUBS VSUBS VSUBS VSUBS VSUBS VSUBS gf180mcu_3v3_12t_2r2w_sram_1024x8_array_control_core_0/u_t017_013/c2_w0_bl
+ VSUBS VSUBS gf180mcu_3v3_12t_2r2w_sram_1024x8_array_control_core_0/u_t021_007/c2_w1_bl
+ VSUBS VSUBS gf180mcu_3v3_12t_2r2w_sram_1024x8_array_control_core_0/u_t019_007/c2_w1_bl
+ VSUBS VSUBS VSUBS VSUBS VSUBS VSUBS VSUBS VSUBS VSUBS VSUBS VSUBS VSUBS VSUBS VSUBS
+ VSUBS VSUBS VSUBS VSUBS gf180mcu_3v3_12t_2r2w_sram_1024x8_array_control_core_0/u_t013_011/c2_w0_bl
+ VSUBS VSUBS gf180mcu_3v3_12t_2r2w_sram_1024x8_array_control_core_0/u_t017_005/c2_w1_bl
+ VSUBS VSUBS gf180mcu_3v3_12t_2r2w_sram_1024x8_array_control_core_0/u_t011_013/c2_w0_bl
+ VSUBS VSUBS gf180mcu_3v3_12t_2r2w_sram_1024x8_array_control_core_0/u_t009_013/c2_w0_bl
+ VSUBS VSUBS VSUBS gf180mcu_3v3_12t_2r2w_sram_1024x8_array_control_core_0/gf180mcu_as_sc_mcu7t3v3__inv_2_1122/A
+ gf180mcu_3v3_12t_2r2w_sram_1024x8_array_control_core_0/u_t014_007/c2_w1_bl gf180mcu_3v3_12t_2r2w_sram_1024x8_array_control_core_0/a_200_95400#
+ VSUBS gf180mcu_3v3_12t_2r2w_sram_1024x8_array_control_core_0/a_22600_78600# VSUBS
+ VSUBS VSUBS VSUBS VSUBS VSUBS VSUBS VSUBS VSUBS VSUBS VSUBS VSUBS VSUBS VSUBS VSUBS
+ VSUBS VSUBS VSUBS VSUBS gf180mcu_3v3_12t_2r2w_sram_1024x8_array_control_core_0/u_t006_011/c2_w0_bl
+ VSUBS gf180mcu_3v3_12t_2r2w_sram_1024x8_array_control_core_0/u_t011_005/c2_w1_bl
+ VSUBS VSUBS VSUBS VSUBS VSUBS VSUBS VSUBS VSUBS gf180mcu_3v3_12t_2r2w_sram_1024x8_array_control_core_0/u_t009_005/c2_w1_bl
+ gf180mcu_3v3_12t_2r2w_sram_1024x8_array_control_core_0/a_14200_28200# VSUBS VSUBS
+ VSUBS VSUBS VSUBS VSUBS VSUBS gf180mcu_3v3_12t_2r2w_sram_1024x8_array_control_core_0/u_t009_007/c2_w1_bl
+ VSUBS VSUBS VSUBS VSUBS VSUBS VSUBS gf180mcu_3v3_12t_2r2w_sram_1024x8_array_control_core_0/a_22600_103800#
+ gf180mcu_3v3_12t_2r2w_sram_1024x8_array_control_core_0/a_200_75800# VSUBS VSUBS
+ VSUBS VSUBS gf180mcu_3v3_12t_2r2w_sram_1024x8_array_control_core_0/u_t001_011/c2_w0_bl
+ VSUBS VSUBS VSUBS VSUBS VSUBS gf180mcu_3v3_12t_2r2w_sram_1024x8_array_control_core_0/u_t030_014/c2_w0_bl
+ VSUBS VSUBS VSUBS VSUBS VSUBS VSUBS VSUBS VSUBS VSUBS gf180mcu_3v3_12t_2r2w_sram_1024x8_array_control_core_0/a_14200_81400#
+ VSUBS VSUBS gf180mcu_3v3_12t_2r2w_sram_1024x8_array_control_core_0/a_22600_87000#
+ VSUBS VSUBS VSUBS VSUBS VSUBS VSUBS VSUBS VSUBS VSUBS VSUBS VSUBS VSUBS VSUBS VSUBS
+ VSUBS VSUBS gf180mcu_3v3_12t_2r2w_sram_1024x8_array_control_core_0/u_t026_012/c2_w0_bl
+ VSUBS VSUBS VSUBS VSUBS gf180mcu_3v3_12t_2r2w_sram_1024x8_array_control_core_0/u_t030_006/c2_w1_bl
+ VSUBS gf180mcu_3v3_12t_2r2w_sram_1024x8_array_control_core_0/u_t026_014/c2_w0_bl
+ VSUBS VSUBS VSUBS VSUBS VSUBS VSUBS VSUBS VSUBS VSUBS VSUBS VSUBS VSUBS VSUBS VSUBS
+ VSUBS VSUBS VSUBS VSUBS gf180mcu_3v3_12t_2r2w_sram_1024x8_array_control_core_0/a_22600_112200#
+ gf180mcu_3v3_12t_2r2w_sram_1024x8_array_control_core_0/a_200_84200# VSUBS VSUBS
+ gf180mcu_3v3_12t_2r2w_sram_1024x8_array_control_core_0/a_14200_61800# VSUBS gf180mcu_3v3_12t_2r2w_sram_1024x8_array_control_core_0/u_t026_004/c2_w1_bl
+ gf180mcu_3v3_12t_2r2w_sram_1024x8_array_control_core_0/a_22600_67400# VSUBS VSUBS
+ gf180mcu_3v3_12t_2r2w_sram_1024x8_array_control_core_0/u_t022_012/c2_w0_bl VSUBS
+ gf180mcu_3v3_12t_2r2w_sram_1024x8_array_control_core_0/u_t019_012/c2_w0_bl VSUBS
+ gf180mcu_3v3_12t_2r2w_sram_1024x8_array_control_core_0/gf180mcu_as_sc_mcu7t3v3__inv_2_365/Y
+ VSUBS gf180mcu_3v3_12t_2r2w_sram_1024x8_array_control_core_0/u_t026_006/c2_w1_bl
+ gf180mcu_3v3_12t_2r2w_sram_1024x8_array_control_core_0/gf180mcu_as_sc_mcu7t3v3__inv_2_1724/A
+ VSUBS VSUBS VSUBS gf180mcu_3v3_12t_2r2w_sram_1024x8_array_control_core_0/u_t017_014/c2_w0_bl
+ VSUBS gf180mcu_3v3_12t_2r2w_sram_1024x8_array_control_core_0/gf180mcu_as_sc_mcu7t3v3__inv_2_73/Y
+ VSUBS VSUBS VSUBS VSUBS VSUBS VSUBS VSUBS VSUBS VSUBS VSUBS VSUBS gf180mcu_3v3_12t_2r2w_sram_1024x8_array_control_core_0/a_14200_17000#
+ VSUBS VSUBS VSUBS VSUBS VSUBS VSUBS gf180mcu_3v3_12t_2r2w_sram_1024x8_array_control_core_0/u_t021_004/c2_w1_bl
+ VSUBS VSUBS VSUBS VSUBS gf180mcu_3v3_12t_2r2w_sram_1024x8_array_control_core_0/u_t019_004/c2_w1_bl
+ VSUBS VSUBS gf180mcu_3v3_12t_2r2w_sram_1024x8_array_control_core_0/u_t014_012/c2_w0_bl
+ gf180mcu_3v3_12t_2r2w_sram_1024x8_array_control_core_0/a_200_64600# VSUBS VSUBS
+ gf180mcu_3v3_12t_2r2w_sram_1024x8_array_control_core_0/a_22600_47800# VSUBS gf180mcu_3v3_12t_2r2w_sram_1024x8_array_control_core_0/u_t017_006/c2_w1_bl
+ VSUBS VSUBS VSUBS gf180mcu_3v3_12t_2r2w_sram_1024x8_array_control_core_0/u_t013_014/c2_w0_bl
+ VSUBS VSUBS VSUBS VSUBS VSUBS VSUBS VSUBS gf180mcu_3v3_12t_2r2w_sram_1024x8_array_control_core_0/gf180mcu_as_sc_mcu7t3v3__inv_2_853/Y
+ VSUBS VSUBS VSUBS VSUBS VSUBS VSUBS VSUBS gf180mcu_3v3_12t_2r2w_sram_1024x8_array_control_core_0/gf180mcu_as_sc_mcu7t3v3__inv_2_590/Y
+ gf180mcu_3v3_12t_2r2w_sram_1024x8_array_control_core_0/u_t014_004/c2_w1_bl VSUBS
+ VSUBS gf180mcu_3v3_12t_2r2w_sram_1024x8_array_control_core_0/a_14200_70200# VSUBS
+ VSUBS VSUBS VSUBS VSUBS gf180mcu_3v3_12t_2r2w_sram_1024x8_array_control_core_0/u_t009_012/c2_w0_bl
+ VSUBS gf180mcu_3v3_12t_2r2w_sram_1024x8_array_control_core_0/u_t013_006/c2_w1_bl
+ VSUBS VSUBS VSUBS VSUBS VSUBS VSUBS VSUBS VSUBS VSUBS VSUBS VSUBS VSUBS VSUBS VSUBS
+ VSUBS VSUBS VSUBS VSUBS VSUBS VSUBS VSUBS VSUBS VSUBS VSUBS VSUBS VSUBS VSUBS VSUBS
+ VSUBS VSUBS VSUBS VSUBS VSUBS VSUBS gf180mcu_3v3_12t_2r2w_sram_1024x8_array_control_core_0/u_t009_004/c2_w1_bl
+ VSUBS gf180mcu_3v3_12t_2r2w_sram_1024x8_array_control_core_0/u_t002_012/c2_w0_bl
+ VSUBS VSUBS VSUBS VSUBS gf180mcu_3v3_12t_2r2w_sram_1024x8_array_control_core_0/gf180mcu_as_sc_mcu7t3v3__inv_2_1717/Y
+ gf180mcu_3v3_12t_2r2w_sram_1024x8_array_control_core_0/a_22600_101000# gf180mcu_3v3_12t_2r2w_sram_1024x8_array_control_core_0/a_200_73000#
+ VSUBS gf180mcu_3v3_12t_2r2w_sram_1024x8_array_control_core_0/a_14200_50600# VSUBS
+ VSUBS VSUBS gf180mcu_3v3_12t_2r2w_sram_1024x8_array_control_core_0/a_22600_56200#
+ VSUBS VSUBS gf180mcu_3v3_12t_2r2w_sram_1024x8_array_control_core_0/u_t001_014/c2_w0_bl
+ VSUBS VSUBS VSUBS VSUBS VSUBS VSUBS gf180mcu_3v3_12t_2r2w_sram_1024x8_array_control_core_0/gf180mcu_as_sc_mcu7t3v3__inv_2_733/Y
+ gf180mcu_3v3_12t_2r2w_sram_1024x8_array_control_core_0/a_14200_89800# VSUBS VSUBS
+ VSUBS gf180mcu_3v3_12t_2r2w_sram_1024x8_array_control_core_0/u_t030_011/c2_w0_bl
+ VSUBS VSUBS VSUBS VSUBS gf180mcu_3v3_12t_2r2w_sram_1024x8_array_control_core_0/gf180mcu_as_sc_mcu7t3v3__inv_2_1306/Y
+ VSUBS gf180mcu_3v3_12t_2r2w_sram_1024x8_array_control_core_0/gf180mcu_as_sc_mcu7t3v3__inv_2_1149/A
+ VSUBS gf180mcu_3v3_12t_2r2w_sram_1024x8_array_control_core_0/u_t027_013/c2_w0_bl
+ VSUBS VSUBS detronyx_12t_precharge_sense_rc1_0/dout VSUBS gf180mcu_3v3_12t_2r2w_sram_1024x8_array_control_core_0/u_t000_006/c2_w1_bl
+ VSUBS VSUBS VSUBS VSUBS VSUBS VSUBS VSUBS VSUBS VSUBS VSUBS VSUBS VSUBS VSUBS VSUBS
+ VSUBS VSUBS VSUBS gf180mcu_3v3_12t_2r2w_sram_1024x8_array_control_core_0/a_200_53400#
+ VSUBS VSUBS VSUBS gf180mcu_3v3_12t_2r2w_sram_1024x8_array_control_core_0/a_22600_36600#
+ VSUBS VSUBS VSUBS VSUBS VSUBS gf180mcu_3v3_12t_2r2w_sram_1024x8_array_control_core_0/u_t026_011/c2_w0_bl
+ VSUBS VSUBS VSUBS gf180mcu_3v3_12t_2r2w_sram_1024x8_array_control_core_0/u_t027_005/c2_w1_bl
+ VSUBS VSUBS gf180mcu_3v3_12t_2r2w_sram_1024x8_array_control_core_0/a_28200_3000#
+ gf180mcu_3v3_12t_2r2w_sram_1024x8_array_control_core_0/u_t022_013/c2_w0_bl VSUBS
+ VSUBS VSUBS VSUBS gf180mcu_3v3_12t_2r2w_sram_1024x8_array_control_core_0/u_t026_007/c2_w1_bl
+ VSUBS VSUBS VSUBS VSUBS VSUBS VSUBS VSUBS VSUBS VSUBS VSUBS VSUBS VSUBS VSUBS VSUBS
+ VSUBS gf180mcu_3v3_12t_2r2w_sram_1024x8_array_control_core_0/a_14200_98200# VSUBS
+ VSUBS VSUBS VSUBS VSUBS gf180mcu_3v3_12t_2r2w_sram_1024x8_array_control_core_0/u_t017_011/c2_w0_bl
+ gf180mcu_3v3_12t_2r2w_sram_1024x8_array_control_core_0/a_200_33800# VSUBS VSUBS
+ gf180mcu_3v3_12t_2r2w_sram_1024x8_array_control_core_0/u_t022_005/c2_w1_bl VSUBS
+ VSUBS VSUBS VSUBS VSUBS gf180mcu_3v3_12t_2r2w_sram_1024x8_array_control_core_0/gf180mcu_as_sc_mcu7t3v3__inv_2_1101/A
+ gf180mcu_3v3_12t_2r2w_sram_1024x8_array_control_core_0/u_t015_013/c2_w0_bl VSUBS
+ VSUBS VSUBS gf180mcu_3v3_12t_2r2w_sram_1024x8_array_control_core_0/u_t021_007/c2_w1_bl
+ VSUBS gf180mcu_3v3_12t_2r2w_sram_1024x8_array_control_core_0/u_t018_007/c2_w1_bl
+ VSUBS gf180mcu_3v3_12t_2r2w_sram_1024x8_array_control_core_0/a_25400_120600# VSUBS
+ VSUBS VSUBS VSUBS gf180mcu_3v3_12t_2r2w_sram_1024x8_array_control_core_0/gf180mcu_as_sc_mcu7t3v3__inv_2_350/Y
+ VSUBS VSUBS VSUBS VSUBS VSUBS gf180mcu_3v3_12t_2r2w_sram_1024x8_array_control_core_0/a_22600_45000#
+ VSUBS VSUBS VSUBS gf180mcu_3v3_12t_2r2w_sram_1024x8_array_control_core_0/u_t013_011/c2_w0_bl
+ VSUBS VSUBS VSUBS gf180mcu_3v3_12t_2r2w_sram_1024x8_array_control_core_0/u_t015_005/c2_w1_bl
+ gf180mcu_3v3_12t_2r2w_sram_1024x8_array_control_core_0/a_14200_78600# gf180mcu_3v3_12t_2r2w_sram_1024x8_array_control_core_0/u_t010_013/c2_w0_bl
+ VSUBS VSUBS VSUBS gf180mcu_3v3_12t_2r2w_sram_1024x8_array_control_core_0/u_t009_013/c2_w0_bl
+ VSUBS gf180mcu_3v3_12t_2r2w_sram_1024x8_array_control_core_0/u_t013_007/c2_w1_bl
+ VSUBS VSUBS VSUBS VSUBS VSUBS VSUBS VSUBS VSUBS VSUBS VSUBS VSUBS gf180mcu_3v3_12t_2r2w_sram_1024x8_array_control_core_0/m4_10808_9273#
+ VSUBS VSUBS VSUBS VSUBS VSUBS VSUBS VSUBS VSUBS VSUBS gf180mcu_3v3_12t_2r2w_sram_1024x8_array_control_core_0/a_14200_103800#
+ VSUBS VSUBS VSUBS VSUBS gf180mcu_3v3_12t_2r2w_sram_1024x8_array_control_core_0/m4_27000_9273#
+ VSUBS VSUBS gf180mcu_3v3_12t_2r2w_sram_1024x8_array_control_core_0/u_t010_005/c2_w1_bl
+ gf180mcu_3v3_12t_2r2w_sram_1024x8_array_control_core_0/a_200_42200# VSUBS VSUBS
+ VSUBS VSUBS gf180mcu_3v3_12t_2r2w_sram_1024x8_array_control_core_0/a_22600_25400#
+ VSUBS VSUBS gf180mcu_3v3_12t_2r2w_sram_1024x8_array_control_core_0/gf180mcu_as_sc_mcu7t3v3__inv_2_744/A
+ gf180mcu_3v3_12t_2r2w_sram_1024x8_array_control_core_0/u_t009_005/c2_w1_bl VSUBS
+ gf180mcu_3v3_12t_2r2w_sram_1024x8_array_control_core_0/a_14200_8600# VSUBS VSUBS
+ VSUBS VSUBS VSUBS VSUBS gf180mcu_3v3_12t_2r2w_sram_1024x8_array_control_core_0/u_t006_007/c2_w1_bl
+ VSUBS gf180mcu_3v3_12t_2r2w_sram_1024x8_array_control_core_0/a_22600_109400# VSUBS
+ VSUBS VSUBS detronyx_12t_precharge_sense_rc1_0/dout VSUBS VSUBS VSUBS VSUBS VSUBS
+ VSUBS VSUBS VSUBS VSUBS VSUBS gf180mcu_3v3_12t_2r2w_sram_1024x8_array_control_core_0/u_t001_011/c2_w0_bl
+ VSUBS VSUBS VSUBS VSUBS gf180mcu_3v3_12t_2r2w_sram_1024x8_array_control_core_0/gf180mcu_as_sc_mcu7t3v3__inv_2_1394/Y
+ gf180mcu_3v3_12t_2r2w_sram_1024x8_array_control_core_0/gf180mcu_as_sc_mcu7t3v3__inv_2_1689/A
+ VSUBS VSUBS gf180mcu_3v3_12t_2r2w_sram_1024x8_array_control_core_0/gf180mcu_as_sc_mcu7t3v3__inv_2_1672/Y
+ gf180mcu_3v3_12t_2r2w_sram_1024x8_array_control_core_0/u_t030_014/c2_w0_bl VSUBS
+ gf180mcu_3v3_12t_2r2w_sram_1024x8_array_control_core_0/a_14200_87000# VSUBS VSUBS
+ gf180mcu_3v3_12t_2r2w_sram_1024x8_array_control_core_0/u_t028_014/c2_w0_bl gf180mcu_3v3_12t_2r2w_sram_1024x8_array_control_core_0/a_200_22600#
+ VSUBS gf180mcu_3v3_12t_2r2w_sram_1024x8_array_control_core_0/u_t001_007/c2_w1_bl
+ VSUBS VSUBS VSUBS VSUBS VSUBS VSUBS VSUBS VSUBS VSUBS VSUBS VSUBS VSUBS VSUBS gf180mcu_3v3_12t_2r2w_sram_1024x8_array_control_core_0/gf180mcu_as_sc_mcu7t3v3__inv_2_1041/A
+ VSUBS VSUBS VSUBS VSUBS VSUBS VSUBS VSUBS VSUBS gf180mcu_3v3_12t_2r2w_sram_1024x8_array_control_core_0/gf180mcu_as_sc_mcu7t3v3__inv_2_634/A
+ VSUBS gf180mcu_3v3_12t_2r2w_sram_1024x8_array_control_core_0/a_14200_112200# VSUBS
+ VSUBS gf180mcu_3v3_12t_2r2w_sram_1024x8_array_control_core_0/u_t026_012/c2_w0_bl
+ VSUBS gf180mcu_3v3_12t_2r2w_sram_1024x8_array_control_core_0/u_t030_006/c2_w1_bl
+ VSUBS VSUBS VSUBS gf180mcu_3v3_12t_2r2w_sram_1024x8_array_control_core_0/u_t028_006/c2_w1_bl
+ gf180mcu_3v3_12t_2r2w_sram_1024x8_array_control_core_0/u_t023_014/c2_w0_bl VSUBS
+ VSUBS gf180mcu_3v3_12t_2r2w_sram_1024x8_array_control_core_0/gf180mcu_as_sc_mcu7t3v3__inv_2_675/Y
+ VSUBS VSUBS VSUBS gf180mcu_3v3_12t_2r2w_sram_1024x8_array_control_core_0/gf180mcu_as_sc_mcu7t3v3__inv_2_1409/A
+ VSUBS VSUBS VSUBS gf180mcu_3v3_12t_2r2w_sram_1024x8_array_control_core_0/a_14200_67400#
+ VSUBS VSUBS VSUBS VSUBS gf180mcu_3v3_12t_2r2w_sram_1024x8_array_control_core_0/u_t026_004/c2_w1_bl
+ VSUBS gf180mcu_3v3_12t_2r2w_sram_1024x8_array_control_core_0/u_t022_012/c2_w0_bl
+ VSUBS VSUBS VSUBS gf180mcu_3v3_12t_2r2w_sram_1024x8_array_control_core_0/u_t018_012/c2_w0_bl
+ VSUBS gf180mcu_3v3_12t_2r2w_sram_1024x8_array_control_core_0/u_t023_006/c2_w1_bl
+ VSUBS VSUBS VSUBS VSUBS VSUBS VSUBS VSUBS gf180mcu_3v3_12t_2r2w_sram_1024x8_array_control_core_0/u_t017_014/c2_w0_bl
+ VSUBS VSUBS VSUBS VSUBS VSUBS VSUBS gf180mcu_3v3_12t_2r2w_sram_1024x8_array_control_core_0/a_200_31000#
+ VSUBS VSUBS gf180mcu_3v3_12t_2r2w_sram_1024x8_array_control_core_0/a_22600_14200#
+ VSUBS VSUBS VSUBS VSUBS VSUBS VSUBS VSUBS VSUBS VSUBS VSUBS VSUBS VSUBS VSUBS VSUBS
+ gf180mcu_3v3_12t_2r2w_sram_1024x8_array_control_core_0/u_t021_004/c2_w1_bl VSUBS
+ VSUBS VSUBS gf180mcu_3v3_12t_2r2w_sram_1024x8_array_control_core_0/a_22600_5800#
+ VSUBS VSUBS VSUBS gf180mcu_3v3_12t_2r2w_sram_1024x8_array_control_core_0/a_14200_47800#
+ gf180mcu_3v3_12t_2r2w_sram_1024x8_array_control_core_0/u_t018_004/c2_w1_bl gf180mcu_3v3_12t_2r2w_sram_1024x8_array_control_core_0/a_200_106600#
+ VSUBS VSUBS gf180mcu_3v3_12t_2r2w_sram_1024x8_array_control_core_0/u_t013_012/c2_w0_bl
+ VSUBS VSUBS VSUBS VSUBS gf180mcu_3v3_12t_2r2w_sram_1024x8_array_control_core_0/u_t017_006/c2_w1_bl
+ VSUBS VSUBS VSUBS gf180mcu_3v3_12t_2r2w_sram_1024x8_array_control_core_0/gf180mcu_as_sc_mcu7t3v3__inv_2_722/A
+ gf180mcu_3v3_12t_2r2w_sram_1024x8_array_control_core_0/u_t011_014/c2_w0_bl VSUBS
+ VSUBS VSUBS gf180mcu_3v3_12t_2r2w_sram_1024x8_array_control_core_0/gf180mcu_as_sc_mcu7t3v3__inv_2_638/A
+ VSUBS gf180mcu_3v3_12t_2r2w_sram_1024x8_array_control_core_0/gf180mcu_as_sc_mcu7t3v3__inv_2_9/Y
+ gf180mcu_3v3_12t_2r2w_sram_1024x8_array_control_core_0/u_t009_014/c2_w0_bl gf180mcu_3v3_12t_2r2w_sram_1024x8_array_control_core_0/gf180mcu_as_sc_mcu7t3v3__inv_2_962/A
+ VSUBS VSUBS VSUBS VSUBS VSUBS gf180mcu_3v3_12t_2r2w_sram_1024x8_array_control_core_0/gf180mcu_as_sc_mcu7t3v3__inv_2_1382/Y
+ VSUBS gf180mcu_3v3_12t_2r2w_sram_1024x8_array_control_core_0/gf180mcu_as_sc_mcu7t3v3__inv_2_1669/A
+ gf180mcu_3v3_12t_2r2w_sram_1024x8_array_control_core_0/gf180mcu_as_sc_mcu7t3v3__inv_2_341/Y
+ VSUBS VSUBS VSUBS VSUBS gf180mcu_3v3_12t_2r2w_sram_1024x8_array_control_core_0/a_200_11400#
+ VSUBS VSUBS VSUBS gf180mcu_3v3_12t_2r2w_sram_1024x8_array_control_core_0/u_t013_004/c2_w1_bl
+ VSUBS VSUBS VSUBS VSUBS VSUBS VSUBS VSUBS VSUBS VSUBS gf180mcu_3v3_12t_2r2w_sram_1024x8_array_control_core_0/u_t006_012/c2_w0_bl
+ gf180mcu_3v3_12t_2r2w_sram_1024x8_array_control_core_0/gf180mcu_as_sc_mcu7t3v3__inv_2_998/A
+ VSUBS gf180mcu_3v3_12t_2r2w_sram_1024x8_array_control_core_0/u_t011_006/c2_w1_bl
+ VSUBS VSUBS VSUBS VSUBS VSUBS gf180mcu_3v3_12t_2r2w_sram_1024x8_array_control_core_0/u_t009_006/c2_w1_bl
+ VSUBS VSUBS VSUBS VSUBS VSUBS gf180mcu_3v3_12t_2r2w_sram_1024x8_array_control_core_0/a_14200_101000#
+ VSUBS VSUBS gf180mcu_3v3_12t_2r2w_sram_1024x8_array_control_core_0/gf180mcu_as_sc_mcu7t3v3__inv_2_24/Y
+ VSUBS VSUBS VSUBS VSUBS VSUBS VSUBS VSUBS VSUBS VSUBS VSUBS VSUBS VSUBS VSUBS gf180mcu_3v3_12t_2r2w_sram_1024x8_array_control_core_0/gf180mcu_as_sc_mcu7t3v3__inv_2_301/Y
+ VSUBS gf180mcu_3v3_12t_2r2w_sram_1024x8_array_control_core_0/gf180mcu_as_sc_mcu7t3v3__inv_2_61/Y
+ gf180mcu_3v3_12t_2r2w_sram_1024x8_array_control_core_0/gf180mcu_as_sc_mcu7t3v3__inv_2_1057/A
+ gf180mcu_3v3_12t_2r2w_sram_1024x8_array_control_core_0/u_t006_004/c2_w1_bl gf180mcu_3v3_12t_2r2w_sram_1024x8_array_control_core_0/gf180mcu_as_sc_mcu7t3v3__inv_2_1355/Y
+ gf180mcu_3v3_12t_2r2w_sram_1024x8_array_control_core_0/a_14200_56200# VSUBS gf180mcu_3v3_12t_2r2w_sram_1024x8_array_control_core_0/u_t001_012/c2_w0_bl
+ gf180mcu_3v3_12t_2r2w_sram_1024x8_array_control_core_0/a_200_115000# VSUBS VSUBS
+ VSUBS VSUBS VSUBS VSUBS VSUBS VSUBS VSUBS VSUBS gf180mcu_3v3_12t_2r2w_sram_1024x8_array_control_core_0/gf180mcu_as_sc_mcu7t3v3__inv_2_742/A
+ VSUBS gf180mcu_3v3_12t_2r2w_sram_1024x8_array_control_core_0/gf180mcu_as_sc_mcu7t3v3__inv_2_640/Y
+ VSUBS gf180mcu_3v3_12t_2r2w_sram_1024x8_array_control_core_0/gf180mcu_as_sc_mcu7t3v3__inv_2_1109/A
+ gf180mcu_3v3_12t_2r2w_sram_1024x8_array_control_core_0/m4_4600_9273# VSUBS VSUBS
+ VSUBS VSUBS VSUBS VSUBS VSUBS VSUBS gf180mcu_3v3_12t_2r2w_sram_1024x8_array_control_core_0/u_t030_011/c2_w0_bl
+ VSUBS VSUBS VSUBS VSUBS VSUBS VSUBS gf180mcu_3v3_12t_2r2w_sram_1024x8_array_control_core_0/u_t028_011/c2_w0_bl
+ gf180mcu_3v3_12t_2r2w_sram_1024x8_array_control_core_0/u_t001_004/c2_w1_bl VSUBS
+ gf180mcu_3v3_12t_2r2w_sram_1024x8_array_control_core_0/gf180mcu_as_sc_mcu7t3v3__inv_2_1685/A
+ gf180mcu_3v3_12t_2r2w_sram_1024x8_array_control_core_0/gf180mcu_as_sc_mcu7t3v3__inv_2_1694/Y
+ VSUBS VSUBS VSUBS VSUBS VSUBS gf180mcu_3v3_12t_2r2w_sram_1024x8_array_control_core_0/u_t026_013/c2_w0_bl
+ VSUBS VSUBS VSUBS VSUBS VSUBS VSUBS VSUBS gf180mcu_3v3_12t_2r2w_sram_1024x8_array_control_core_0/gf180mcu_as_sc_mcu7t3v3__inv_2_359/Y
+ gf180mcu_3v3_12t_2r2w_sram_1024x8_array_control_core_0/a_200_59000# VSUBS VSUBS
+ gf180mcu_3v3_12t_2r2w_sram_1024x8_array_control_core_0/a_14200_36600# gf180mcu_3v3_12t_2r2w_sram_1024x8_array_control_core_0/u_t030_007/c2_w1_bl
+ VSUBS VSUBS VSUBS gf180mcu_3v3_12t_2r2w_sram_1024x8_array_control_core_0/gf180mcu_as_sc_mcu7t3v3__inv_2_304/A
+ VSUBS VSUBS VSUBS VSUBS VSUBS VSUBS VSUBS VSUBS gf180mcu_3v3_12t_2r2w_sram_1024x8_array_control_core_0/gf180mcu_as_sc_mcu7t3v3__inv_2_662/A
+ gf180mcu_3v3_12t_2r2w_sram_1024x8_array_control_core
Xdetronyx_12t_precharge_sense_rc1_14 detronyx_12t_precharge_sense_rc1_14/VDD VSUBS
+ VSUBS VSUBS VSUBS VSUBS detronyx_12t_precharge_sense_rc1_14/a_672_2172# detronyx_12t_precharge_sense_rc1_14/a_240_2172#
+ detronyx_12t_precharge_sense_rc1
Xdetronyx_12t_precharge_sense_rc1_15 VSUBS VSUBS VSUBS VSUBS VSUBS VSUBS VSUBS VSUBS
+ detronyx_12t_precharge_sense_rc1
Xdetronyx_12t_write_driver_rc1_0 detronyx_12t_write_driver_rc1_0/VDD VSUBS detronyx_12t_write_driver_rc1_0/din
+ VSUBS detronyx_12t_write_driver_rc1_0/wbl0 detronyx_12t_write_driver_rc1_0/wbr0
+ detronyx_12t_write_driver_rc1_0/a_240_2348# detronyx_12t_write_driver_rc1
Xdetronyx_12t_write_driver_rc1_1 detronyx_12t_write_driver_rc1_1/VDD VSUBS detronyx_12t_write_driver_rc1_1/din
+ VSUBS detronyx_12t_write_driver_rc1_1/wbl0 VSUBS detronyx_12t_write_driver_rc1_1/a_240_2348#
+ detronyx_12t_write_driver_rc1
Xdetronyx_12t_write_driver_rc1_2 detronyx_12t_write_driver_rc1_2/VDD VSUBS detronyx_12t_write_driver_rc1_2/din
+ VSUBS detronyx_12t_write_driver_rc1_2/wbl0 VSUBS detronyx_12t_write_driver_rc1_2/a_240_2348#
+ detronyx_12t_write_driver_rc1
Xdetronyx_12t_write_driver_rc1_4 detronyx_12t_write_driver_rc1_4/VDD VSUBS detronyx_12t_write_driver_rc1_4/din
+ VSUBS detronyx_12t_write_driver_rc1_4/wbl0 VSUBS detronyx_12t_write_driver_rc1_4/a_240_2348#
+ detronyx_12t_write_driver_rc1
Xdetronyx_12t_write_driver_rc1_3 detronyx_12t_write_driver_rc1_3/VDD VSUBS detronyx_12t_write_driver_rc1_3/din
+ VSUBS detronyx_12t_write_driver_rc1_3/wbl0 VSUBS detronyx_12t_write_driver_rc1_3/a_240_2348#
+ detronyx_12t_write_driver_rc1
Xdetronyx_12t_precharge_sense_rc1_0 detronyx_12t_precharge_sense_rc1_0/VDD VSUBS detronyx_12t_precharge_sense_rc1_0/dout
+ VSUBS VSUBS detronyx_12t_precharge_sense_rc1_0/dout detronyx_12t_precharge_sense_rc1_0/a_672_2172#
+ detronyx_12t_precharge_sense_rc1_0/a_240_2172# detronyx_12t_precharge_sense_rc1
Xdetronyx_12t_write_driver_rc1_5 detronyx_12t_write_driver_rc1_5/VDD VSUBS detronyx_12t_write_driver_rc1_5/din
+ VSUBS detronyx_12t_write_driver_rc1_5/wbl0 VSUBS detronyx_12t_write_driver_rc1_5/a_240_2348#
+ detronyx_12t_write_driver_rc1
Xdetronyx_12t_precharge_sense_rc1_1 detronyx_12t_precharge_sense_rc1_1/VDD VSUBS VSUBS
+ detronyx_12t_precharge_sense_rc1_1/ren detronyx_12t_precharge_sense_rc1_1/ren VSUBS
+ detronyx_12t_precharge_sense_rc1_1/a_672_2172# detronyx_12t_precharge_sense_rc1_1/a_240_2172#
+ detronyx_12t_precharge_sense_rc1
Xdetronyx_12t_write_driver_rc1_6 detronyx_12t_write_driver_rc1_6/VDD VSUBS detronyx_12t_write_driver_rc1_6/din
+ VSUBS detronyx_12t_write_driver_rc1_6/wbl0 VSUBS detronyx_12t_write_driver_rc1_6/a_240_2348#
+ detronyx_12t_write_driver_rc1
Xdetronyx_12t_precharge_sense_rc1_2 detronyx_12t_precharge_sense_rc1_2/VDD VSUBS detronyx_12t_precharge_sense_rc1_2/dout
+ detronyx_12t_precharge_sense_rc1_2/ren detronyx_12t_precharge_sense_rc1_2/ren detronyx_12t_precharge_sense_rc1_2/dout
+ detronyx_12t_precharge_sense_rc1_2/a_672_2172# detronyx_12t_precharge_sense_rc1_2/a_240_2172#
+ detronyx_12t_precharge_sense_rc1
Xdetronyx_12t_write_driver_rc1_7 detronyx_12t_write_driver_rc1_7/VDD VSUBS detronyx_12t_write_driver_rc1_7/din
+ VSUBS detronyx_12t_write_driver_rc1_7/wbl0 VSUBS detronyx_12t_write_driver_rc1_7/a_240_2348#
+ detronyx_12t_write_driver_rc1
Xdetronyx_12t_precharge_sense_rc1_3 detronyx_12t_precharge_sense_rc1_3/VDD VSUBS detronyx_12t_precharge_sense_rc1_3/dout
+ detronyx_12t_precharge_sense_rc1_3/ren detronyx_12t_precharge_sense_rc1_3/ren detronyx_12t_precharge_sense_rc1_3/dout
+ detronyx_12t_precharge_sense_rc1_3/a_672_2172# detronyx_12t_precharge_sense_rc1_3/a_240_2172#
+ detronyx_12t_precharge_sense_rc1
Xdetronyx_12t_write_driver_rc1_8 detronyx_12t_write_driver_rc1_8/VDD VSUBS detronyx_12t_write_driver_rc1_8/din
+ VSUBS detronyx_12t_write_driver_rc1_8/wbl0 VSUBS detronyx_12t_write_driver_rc1_8/a_240_2348#
+ detronyx_12t_write_driver_rc1
Xdetronyx_12t_precharge_sense_rc1_4 detronyx_12t_precharge_sense_rc1_4/VDD VSUBS detronyx_12t_precharge_sense_rc1_4/dout
+ detronyx_12t_precharge_sense_rc1_4/ren detronyx_12t_precharge_sense_rc1_4/ren detronyx_12t_precharge_sense_rc1_4/dout
+ detronyx_12t_precharge_sense_rc1_4/a_672_2172# detronyx_12t_precharge_sense_rc1_4/a_240_2172#
+ detronyx_12t_precharge_sense_rc1
Xdetronyx_12t_write_driver_rc1_9 detronyx_12t_write_driver_rc1_9/VDD VSUBS detronyx_12t_write_driver_rc1_9/din
+ VSUBS detronyx_12t_write_driver_rc1_9/wbl0 VSUBS detronyx_12t_write_driver_rc1_9/a_240_2348#
+ detronyx_12t_write_driver_rc1
Xdetronyx_12t_precharge_sense_rc1_6 detronyx_12t_precharge_sense_rc1_6/VDD VSUBS VSUBS
+ VSUBS VSUBS VSUBS detronyx_12t_precharge_sense_rc1_6/a_672_2172# detronyx_12t_precharge_sense_rc1_6/a_240_2172#
+ detronyx_12t_precharge_sense_rc1
Xdetronyx_12t_precharge_sense_rc1_5 detronyx_12t_precharge_sense_rc1_5/VDD VSUBS detronyx_12t_precharge_sense_rc1_5/dout
+ VSUBS VSUBS detronyx_12t_precharge_sense_rc1_5/dout detronyx_12t_precharge_sense_rc1_5/a_672_2172#
+ detronyx_12t_precharge_sense_rc1_5/a_240_2172# detronyx_12t_precharge_sense_rc1
Xdetronyx_12t_precharge_sense_rc1_7 detronyx_12t_precharge_sense_rc1_7/VDD VSUBS VSUBS
+ VSUBS VSUBS VSUBS detronyx_12t_precharge_sense_rc1_7/a_672_2172# detronyx_12t_precharge_sense_rc1_7/a_240_2172#
+ detronyx_12t_precharge_sense_rc1
Xdetronyx_12t_precharge_sense_rc1_8 detronyx_12t_precharge_sense_rc1_8/VDD VSUBS VSUBS
+ detronyx_12t_precharge_sense_rc1_8/ren detronyx_12t_precharge_sense_rc1_8/ren VSUBS
+ detronyx_12t_precharge_sense_rc1_8/a_672_2172# detronyx_12t_precharge_sense_rc1_8/a_240_2172#
+ detronyx_12t_precharge_sense_rc1
Xdetronyx_12t_precharge_sense_rc1_9 detronyx_12t_precharge_sense_rc1_9/VDD VSUBS detronyx_12t_precharge_sense_rc1_9/dout
+ detronyx_12t_precharge_sense_rc1_9/ren detronyx_12t_precharge_sense_rc1_9/ren detronyx_12t_precharge_sense_rc1_9/dout
+ detronyx_12t_precharge_sense_rc1_9/a_672_2172# detronyx_12t_precharge_sense_rc1_9/a_240_2172#
+ detronyx_12t_precharge_sense_rc1
Xdetronyx_12t_write_driver_rc1_10 detronyx_12t_write_driver_rc1_10/VDD VSUBS detronyx_12t_write_driver_rc1_10/din
+ VSUBS detronyx_12t_write_driver_rc1_10/wbl0 VSUBS detronyx_12t_write_driver_rc1_10/a_240_2348#
+ detronyx_12t_write_driver_rc1
.ends
