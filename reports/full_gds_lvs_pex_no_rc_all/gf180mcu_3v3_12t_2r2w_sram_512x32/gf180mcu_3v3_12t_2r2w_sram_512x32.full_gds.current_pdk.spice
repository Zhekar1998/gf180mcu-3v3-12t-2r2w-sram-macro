* NGSPICE file created from gf180mcu_3v3_12t_2r2w_sram_512x32.ext - technology: gf180mcuD

.subckt detronyx_12t_write_driver_rc1 VDD VSS din wen wbl0 wbr0
X0 VDD a_240_2348# a_326_9670# VDD pfet_03v3 ad=0.1232p pd=1u as=0.1232p ps=1u w=0.56u l=0.28u
X1 VSS wen a_988_2348# VSS nfet_03v3 ad=0.4642p pd=2.99u as=0.4642p ps=2.99u w=1.055u l=0.28u
X2 VDD wen a_326_9670# VDD pfet_03v3 ad=0.1232p pd=1u as=0.1232p ps=1u w=0.56u l=0.28u
X3 VSS a_844_5266# a_328_6681# VSS nfet_03v3 ad=0.4642p pd=2.99u as=0.4642p ps=2.99u w=1.055u l=0.28u
X4 VSS wen a_240_3807# VSS nfet_03v3 ad=0.4642p pd=2.99u as=0.4642p ps=2.99u w=1.055u l=0.28u
X5 VDD wen a_326_11114# VDD pfet_03v3 ad=0.1232p pd=1u as=0.1232p ps=1u w=0.56u l=0.28u
X6 VDD wen a_844_2348# VDD pfet_03v3 ad=0.1232p pd=1u as=0.1232p ps=1u w=0.56u l=0.28u
X7 a_240_3807# a_240_2348# a_326_9670# VSS nfet_03v3 ad=0.4642p pd=2.99u as=0.4642p ps=2.99u w=1.055u l=0.28u
X8 VDD din a_844_5266# VDD pfet_03v3 ad=0.1232p pd=1u as=0.1232p ps=1u w=0.56u l=0.28u
X9 VDD wen a_844_5266# VDD pfet_03v3 ad=0.1232p pd=1u as=0.1232p ps=1u w=0.56u l=0.28u
X10 VDD a_240_2348# a_326_11114# VDD pfet_03v3 ad=0.1232p pd=1u as=0.1232p ps=1u w=0.56u l=0.28u
X11 VDD a_844_2348# wbl0 VDD pfet_03v3 ad=0.1232p pd=1u as=0.1232p ps=1u w=0.56u l=0.28u
X12 VDD a_844_5266# a_328_6681# VDD pfet_03v3 ad=0.1232p pd=1u as=0.1232p ps=1u w=0.56u l=0.28u
X13 VSS a_844_3807# wbl0 VSS nfet_03v3 ad=0.4642p pd=2.99u as=0.4642p ps=2.99u w=1.055u l=0.28u
X14 VDD din a_844_2348# VDD pfet_03v3 ad=0.1232p pd=1u as=0.1232p ps=1u w=0.56u l=0.28u
X15 a_988_5266# din a_844_5266# VSS nfet_03v3 ad=0.4642p pd=2.99u as=0.4642p ps=2.99u w=1.055u l=0.28u
X16 a_240_5266# a_240_2348# a_326_11114# VSS nfet_03v3 ad=0.4642p pd=2.99u as=0.4642p ps=2.99u w=1.055u l=0.28u
X17 VDD a_326_9670# a_844_3807# VDD pfet_03v3 ad=0.1232p pd=1u as=0.1232p ps=1u w=0.56u l=0.28u
X18 a_988_2348# din a_844_2348# VSS nfet_03v3 ad=0.4642p pd=2.99u as=0.4642p ps=2.99u w=1.055u l=0.28u
X19 VSS wen a_240_5266# VSS nfet_03v3 ad=0.4642p pd=2.99u as=0.4642p ps=2.99u w=1.055u l=0.28u
X20 VSS din a_240_2348# VSS nfet_03v3 ad=0.4642p pd=2.99u as=0.4642p ps=2.99u w=1.055u l=0.28u
X21 VSS a_326_9670# a_844_3807# VSS nfet_03v3 ad=0.4642p pd=2.99u as=0.4642p ps=2.99u w=1.055u l=0.28u
X22 VDD din a_240_2348# VDD pfet_03v3 ad=0.1232p pd=1u as=0.1232p ps=1u w=0.56u l=0.28u
X23 VSS wen a_988_5266# VSS nfet_03v3 ad=0.4642p pd=2.99u as=0.4642p ps=2.99u w=1.055u l=0.28u
X24 VDD a_326_11114# wbr0 VDD pfet_03v3 ad=0.1232p pd=1u as=0.1232p ps=1u w=0.56u l=0.28u
X25 VSS a_328_6681# wbr0 VSS nfet_03v3 ad=0.4642p pd=2.99u as=0.4642p ps=2.99u w=1.055u l=0.28u
.ends

.subckt detronyx_12t_precharge_sense_rc1 VDD VSS pchgb ren rbl0 dout
X0 VDD rbl0 a_240_2172# VDD pfet_03v3 ad=0.1232p pd=1u as=0.1232p ps=1u w=0.56u l=0.28u
X1 VSS a_240_2172# a_672_2172# VSS nfet_03v3 ad=0.4642p pd=2.99u as=0.4642p ps=2.99u w=1.055u l=0.28u
X2 VSS rbl0 a_240_2172# VSS nfet_03v3 ad=0.4642p pd=2.99u as=0.4642p ps=2.99u w=1.055u l=0.28u
X3 VDD pchgb rbl0 VDD pfet_03v3 ad=0.1232p pd=1u as=0.1232p ps=1u w=0.56u l=0.28u
X4 VDD a_672_2172# dout VDD pfet_03v3 ad=0.1232p pd=1u as=0.1232p ps=1u w=0.56u l=0.28u
X5 VSS a_672_2172# dout VSS nfet_03v3 ad=0.4642p pd=2.99u as=0.4642p ps=2.99u w=1.055u l=0.28u
X6 VDD a_240_2172# a_672_2172# VDD pfet_03v3 ad=0.1232p pd=1u as=0.1232p ps=1u w=0.56u l=0.28u
.ends

.subckt gf180mcu_as_sc_mcu7t3v3__inv_2 VDD VSS Y A VNW VPW
X0 VDD A Y VNW pfet_03v3 ad=0.6072p pd=3.64u as=0.3588p ps=1.9u w=1.38u l=0.28u
X1 Y A VSS VPW nfet_03v3 ad=0.26p pd=1.52u as=0.44p ps=2.88u w=1u l=0.28u
X2 Y A VDD VNW pfet_03v3 ad=0.3588p pd=1.9u as=0.6072p ps=3.64u w=1.38u l=0.28u
X3 VSS A Y VPW nfet_03v3 ad=0.44p pd=2.88u as=0.26p ps=1.52u w=1u l=0.28u
.ends

.subckt gf180mcu_as_sc_mcu7t3v3__nand4_2 VDD VSS A B C D Y VNW VPW
X0 VDD A Y VNW pfet_03v3 ad=0.3588p pd=1.9u as=0.3588p ps=1.9u w=1.38u l=0.28u
X1 Y D a_796_68# VPW nfet_03v3 ad=0.26p pd=1.52u as=0.26p ps=1.52u w=1u l=0.28u
X2 VSS A a_28_68# VPW nfet_03v3 ad=0.26p pd=1.52u as=0.44p ps=2.88u w=1u l=0.28u
X3 VDD C Y VNW pfet_03v3 ad=0.3588p pd=1.9u as=0.3588p ps=1.9u w=1.38u l=0.28u
X4 a_796_68# C a_492_68# VPW nfet_03v3 ad=0.26p pd=1.52u as=0.26p ps=1.52u w=1u l=0.28u
X5 Y B VDD VNW pfet_03v3 ad=0.3588p pd=1.9u as=0.3588p ps=1.9u w=1.38u l=0.28u
X6 a_28_68# B a_492_68# VPW nfet_03v3 ad=0.44p pd=2.88u as=0.26p ps=1.52u w=1u l=0.28u
X7 Y D VDD VNW pfet_03v3 ad=0.3588p pd=1.9u as=0.3588p ps=1.9u w=1.38u l=0.28u
X8 VDD B Y VNW pfet_03v3 ad=0.8004p pd=2.54u as=0.3588p ps=1.9u w=1.38u l=0.28u
X9 Y C VDD VNW pfet_03v3 ad=0.3588p pd=1.9u as=0.8004p ps=2.54u w=1.38u l=0.28u
X10 a_492_68# C a_796_68# VPW nfet_03v3 ad=0.26p pd=1.52u as=0.44p ps=2.88u w=1u l=0.28u
X11 a_492_68# B a_28_68# VPW nfet_03v3 ad=0.26p pd=1.52u as=0.26p ps=1.52u w=1u l=0.28u
X12 VDD D Y VNW pfet_03v3 ad=0.6348p pd=3.68u as=0.3588p ps=1.9u w=1.38u l=0.28u
X13 Y A VDD VNW pfet_03v3 ad=0.3588p pd=1.9u as=0.6072p ps=3.64u w=1.38u l=0.28u
X14 a_796_68# D Y VPW nfet_03v3 ad=0.46p pd=2.92u as=0.26p ps=1.52u w=1u l=0.28u
X15 a_28_68# A VSS VPW nfet_03v3 ad=0.26p pd=1.52u as=0.26p ps=1.52u w=1u l=0.28u
.ends

.subckt detronyx_12t_2w2r_rc4_4x4_routed_5layer_direct c0_w0_bl c0_w0_br c0_w1_bl
+ c0_w1_br c0_r0_rbl c0_r1_rbl c1_w0_bl c1_w0_br c1_w1_bl c1_w1_br c1_r0_rbl c1_r1_rbl
+ c2_w0_bl c2_w0_br c2_w1_bl c2_w1_br c2_r0_rbl c2_r1_rbl c3_w0_bl c3_w0_br c3_w1_bl
+ c3_w1_br c3_r0_rbl c3_r1_rbl r0_w0_wl r0_w1_wl r0_r0_rwl r0_r1_rwl r1_w0_wl r1_w1_wl
+ r1_r0_rwl r1_r1_rwl r2_w0_wl r2_w1_wl r2_r0_rwl r2_r1_rwl r3_w0_wl r3_w1_wl r3_r0_rwl
+ r3_r1_rwl VDD VSS VSUBS
X0 a_684_1814# a_484_1742# a_680_1660# VSUBS nfet_03v3 ad=0.1288p pd=1.48u as=0.1208p ps=1.42u w=0.28u l=0.36u
X1 a_1365_936# a_1283_888# a_1421_1243# w_1283_1162# pfet_03v3 ad=0.1238p pd=1.44u as=0.3061p ps=2.445u w=0.28u l=0.28u
X2 a_2215_1938# a_2159_1894# a_2071_1938# VSUBS nfet_03v3 ad=0.1378p pd=1.05u as=0.2332p ps=1.94u w=0.53u l=0.28u
X3 a_82_1708# a_484_2028# a_532_1946# VSUBS nfet_03v3 ad=0.1288p pd=1.48u as=0.1208p ps=1.42u w=0.28u l=0.36u
X4 a_2648_1708# a_2566_1660# a_2704_1752# VSUBS nfet_03v3 ad=0.3133p pd=2.64u as=0.342p ps=2.21u w=0.45u l=0.28u
X5 a_3658_932# a_3602_888# a_3498_932# VSUBS nfet_03v3 ad=0.23585p pd=1.95u as=0.1378p ps=1.05u w=0.53u l=0.28u
X6 a_932_1938# a_876_1894# a_788_1938# VSUBS nfet_03v3 ad=0.1378p pd=1.05u as=0.2332p ps=1.94u w=0.53u l=0.28u
X7 a_3250_2100# a_3050_2028# a_3246_1946# VSUBS nfet_03v3 ad=0.1288p pd=1.48u as=0.1208p ps=1.42u w=0.28u l=0.36u
X8 a_2375_160# a_2319_116# a_2215_160# VSUBS nfet_03v3 ad=0.23585p pd=1.95u as=0.1378p ps=1.05u w=0.53u l=0.28u
X9 a_1365_936# a_1283_888# a_1421_980# VSUBS nfet_03v3 ad=0.3133p pd=2.64u as=0.342p ps=2.21u w=0.45u l=0.28u
X10 a_4533_2100# a_4333_2028# a_4529_1946# VSUBS nfet_03v3 ad=0.1288p pd=1.48u as=0.1208p ps=1.42u w=0.28u l=0.36u
X11 a_82_164# a_0_116# a_138_471# w_0_390# pfet_03v3 ad=0.1238p pd=1.44u as=0.3061p ps=2.445u w=0.28u l=0.28u
X12 a_82_936# a_484_970# a_532_888# VSUBS nfet_03v3 ad=0.1288p pd=1.48u as=0.1208p ps=1.42u w=0.28u l=0.36u
X13 a_3931_1708# a_3849_1660# a_3987_2015# w_3849_1934# pfet_03v3 ad=0.1238p pd=1.44u as=0.3061p ps=2.445u w=0.28u l=0.28u
X14 a_1967_1042# a_1767_970# a_1963_888# VSUBS nfet_03v3 ad=0.1288p pd=1.48u as=0.1208p ps=1.42u w=0.28u l=0.36u
X15 a_1421_2787# a_1365_2480# a_1283_2432# w_1283_2706# pfet_03v3 ad=0.3061p pd=2.445u as=0.1238p ps=1.44u w=0.28u l=0.28u
X16 a_1365_2480# a_1767_2514# a_1815_2432# VSUBS nfet_03v3 ad=0.1288p pd=1.48u as=0.1208p ps=1.42u w=0.28u l=0.36u
X17 a_2704_2787# a_2648_2480# a_2566_2432# w_2566_2706# pfet_03v3 ad=0.3061p pd=2.445u as=0.1238p ps=1.44u w=0.28u l=0.28u
X18 a_138_2787# a_82_2480# a_0_2432# w_0_2706# pfet_03v3 ad=0.3061p pd=2.445u as=0.1238p ps=1.44u w=0.28u l=0.28u
X19 a_2648_936# a_3050_1256# a_3098_1174# VSUBS nfet_03v3 ad=0.1288p pd=1.48u as=0.1208p ps=1.42u w=0.28u l=0.36u
X20 a_1365_2480# a_1767_2800# a_1815_2718# VSUBS nfet_03v3 ad=0.1288p pd=1.48u as=0.1208p ps=1.42u w=0.28u l=0.36u
X21 a_2704_980# a_2648_936# a_2566_888# VSUBS nfet_03v3 ad=0.342p pd=2.21u as=0.3133p ps=2.64u w=0.45u l=0.28u
X22 a_82_1708# a_0_1660# a_138_1752# VSUBS nfet_03v3 ad=0.3133p pd=2.64u as=0.342p ps=2.21u w=0.45u l=0.28u
X23 a_3931_164# a_4333_198# a_4381_116# VSUBS nfet_03v3 ad=0.1288p pd=1.48u as=0.1208p ps=1.42u w=0.28u l=0.36u
X24 a_1092_160# a_1036_116# a_932_160# VSUBS nfet_03v3 ad=0.23585p pd=1.95u as=0.1378p ps=1.05u w=0.53u l=0.28u
X25 a_82_164# a_0_116# a_138_208# VSUBS nfet_03v3 ad=0.3133p pd=2.64u as=0.342p ps=2.21u w=0.45u l=0.28u
X26 a_4941_932# a_4885_1122# a_4781_1166# VSUBS nfet_03v3 ad=0.23585p pd=1.95u as=0.1378p ps=1.05u w=0.53u l=0.28u
X27 a_3931_164# a_4333_484# a_4381_402# VSUBS nfet_03v3 ad=0.1288p pd=1.48u as=0.1208p ps=1.42u w=0.28u l=0.36u
X28 a_2648_164# a_2566_116# a_2704_471# w_2566_390# pfet_03v3 ad=0.1238p pd=1.44u as=0.3061p ps=2.445u w=0.28u l=0.28u
X29 a_3498_1166# a_3442_1122# a_3354_1166# VSUBS nfet_03v3 ad=0.1378p pd=1.05u as=0.2332p ps=1.94u w=0.53u l=0.28u
X30 a_4533_270# a_4333_198# a_4529_116# VSUBS nfet_03v3 ad=0.1288p pd=1.48u as=0.1208p ps=1.42u w=0.28u l=0.36u
X31 a_2375_932# a_2319_888# a_2215_932# VSUBS nfet_03v3 ad=0.23585p pd=1.95u as=0.1378p ps=1.05u w=0.53u l=0.28u
X32 a_4781_1166# a_4725_1122# a_4637_1166# VSUBS nfet_03v3 ad=0.1378p pd=1.05u as=0.2332p ps=1.94u w=0.53u l=0.28u
X33 a_3658_1704# a_3602_1660# a_3498_1704# VSUBS nfet_03v3 ad=0.23585p pd=1.95u as=0.1378p ps=1.05u w=0.53u l=0.28u
X34 a_684_2586# a_484_2514# a_680_2432# VSUBS nfet_03v3 ad=0.1288p pd=1.48u as=0.1208p ps=1.42u w=0.28u l=0.36u
X35 a_1365_1708# a_1283_1660# a_1421_2015# w_1283_1934# pfet_03v3 ad=0.1238p pd=1.44u as=0.3061p ps=2.445u w=0.28u l=0.28u
X36 a_4533_556# a_4333_484# a_4529_402# VSUBS nfet_03v3 ad=0.1288p pd=1.48u as=0.1208p ps=1.42u w=0.28u l=0.36u
X37 a_1092_2476# a_1036_2666# a_932_2710# VSUBS nfet_03v3 ad=0.23585p pd=1.95u as=0.1378p ps=1.05u w=0.53u l=0.28u
X38 a_2215_1704# a_2159_1660# a_2071_1704# VSUBS nfet_03v3 ad=0.1378p pd=1.05u as=0.2332p ps=1.94u w=0.53u l=0.28u
X39 a_3987_471# a_3931_164# a_3849_116# w_3849_390# pfet_03v3 ad=0.3061p pd=2.445u as=0.1238p ps=1.44u w=0.28u l=0.28u
X40 a_4781_394# a_4725_350# a_4637_394# VSUBS nfet_03v3 ad=0.1378p pd=1.05u as=0.2332p ps=1.94u w=0.53u l=0.28u
X41 a_1421_980# a_1365_936# a_1283_888# VSUBS nfet_03v3 ad=0.342p pd=2.21u as=0.3133p ps=2.64u w=0.45u l=0.28u
X42 a_684_2872# a_484_2800# a_680_2718# VSUBS nfet_03v3 ad=0.1288p pd=1.48u as=0.1208p ps=1.42u w=0.28u l=0.36u
X43 a_2375_2476# a_2319_2666# a_2215_2710# VSUBS nfet_03v3 ad=0.23585p pd=1.95u as=0.1378p ps=1.05u w=0.53u l=0.28u
X44 a_2648_2480# a_2566_2432# a_2704_2524# VSUBS nfet_03v3 ad=0.3133p pd=2.64u as=0.342p ps=2.21u w=0.45u l=0.28u
X45 a_932_1704# a_876_1660# a_788_1704# VSUBS nfet_03v3 ad=0.1378p pd=1.05u as=0.2332p ps=1.94u w=0.53u l=0.28u
X46 a_2648_164# a_2566_116# a_2704_208# VSUBS nfet_03v3 ad=0.3133p pd=2.64u as=0.342p ps=2.21u w=0.45u l=0.28u
X47 a_1967_1328# a_1767_1256# a_1963_1174# VSUBS nfet_03v3 ad=0.1288p pd=1.48u as=0.1208p ps=1.42u w=0.28u l=0.36u
X48 a_82_1708# a_484_1742# a_532_1660# VSUBS nfet_03v3 ad=0.1288p pd=1.48u as=0.1208p ps=1.42u w=0.28u l=0.36u
X49 a_3250_1814# a_3050_1742# a_3246_1660# VSUBS nfet_03v3 ad=0.1288p pd=1.48u as=0.1208p ps=1.42u w=0.28u l=0.36u
X50 a_3250_270# a_3050_198# a_3246_116# VSUBS nfet_03v3 ad=0.1288p pd=1.48u as=0.1208p ps=1.42u w=0.28u l=0.36u
X51 a_2648_164# a_3050_198# a_3098_116# VSUBS nfet_03v3 ad=0.1288p pd=1.48u as=0.1208p ps=1.42u w=0.28u l=0.36u
X52 a_1092_932# a_1036_888# a_932_932# VSUBS nfet_03v3 ad=0.23585p pd=1.95u as=0.1378p ps=1.05u w=0.53u l=0.28u
X53 a_4941_1704# a_4885_1894# a_4781_1938# VSUBS nfet_03v3 ad=0.23585p pd=1.95u as=0.1378p ps=1.05u w=0.53u l=0.28u
X54 a_4533_1814# a_4333_1742# a_4529_1660# VSUBS nfet_03v3 ad=0.1288p pd=1.48u as=0.1208p ps=1.42u w=0.28u l=0.36u
X55 a_2648_1708# a_3050_2028# a_3098_1946# VSUBS nfet_03v3 ad=0.1288p pd=1.48u as=0.1208p ps=1.42u w=0.28u l=0.36u
X56 a_3250_556# a_3050_484# a_3246_402# VSUBS nfet_03v3 ad=0.1288p pd=1.48u as=0.1208p ps=1.42u w=0.28u l=0.36u
X57 a_2648_164# a_3050_484# a_3098_402# VSUBS nfet_03v3 ad=0.1288p pd=1.48u as=0.1208p ps=1.42u w=0.28u l=0.36u
X58 a_2648_936# a_2566_888# a_2704_1243# w_2566_1162# pfet_03v3 ad=0.1238p pd=1.44u as=0.3061p ps=2.445u w=0.28u l=0.28u
X59 a_3498_1938# a_3442_1894# a_3354_1938# VSUBS nfet_03v3 ad=0.1378p pd=1.05u as=0.2332p ps=1.94u w=0.53u l=0.28u
X60 a_1365_164# a_1283_116# a_1421_471# w_1283_390# pfet_03v3 ad=0.1238p pd=1.44u as=0.3061p ps=2.445u w=0.28u l=0.28u
X61 a_82_2480# a_0_2432# a_138_2524# VSUBS nfet_03v3 ad=0.3133p pd=2.64u as=0.342p ps=2.21u w=0.45u l=0.28u
X62 a_4781_1938# a_4725_1894# a_4637_1938# VSUBS nfet_03v3 ad=0.1378p pd=1.05u as=0.2332p ps=1.94u w=0.53u l=0.28u
X63 a_3498_394# a_3442_350# a_3354_394# VSUBS nfet_03v3 ad=0.1378p pd=1.05u as=0.2332p ps=1.94u w=0.53u l=0.28u
X64 a_1365_936# a_1767_970# a_1815_888# VSUBS nfet_03v3 ad=0.1288p pd=1.48u as=0.1208p ps=1.42u w=0.28u l=0.36u
X65 a_3987_208# a_3931_164# a_3849_116# VSUBS nfet_03v3 ad=0.342p pd=2.21u as=0.3133p ps=2.64u w=0.45u l=0.28u
X66 a_3931_936# a_3849_888# a_3987_980# VSUBS nfet_03v3 ad=0.3133p pd=2.64u as=0.342p ps=2.21u w=0.45u l=0.28u
X67 a_1421_1752# a_1365_1708# a_1283_1660# VSUBS nfet_03v3 ad=0.342p pd=2.21u as=0.3133p ps=2.64u w=0.45u l=0.28u
X68 a_1092_2476# a_1036_2432# a_932_2476# VSUBS nfet_03v3 ad=0.23585p pd=1.95u as=0.1378p ps=1.05u w=0.53u l=0.28u
X69 a_138_980# a_82_936# a_0_888# VSUBS nfet_03v3 ad=0.342p pd=2.21u as=0.3133p ps=2.64u w=0.45u l=0.28u
X70 a_2375_2476# a_2319_2432# a_2215_2476# VSUBS nfet_03v3 ad=0.23585p pd=1.95u as=0.1378p ps=1.05u w=0.53u l=0.28u
X71 a_2704_1752# a_2648_1708# a_2566_1660# VSUBS nfet_03v3 ad=0.342p pd=2.21u as=0.3133p ps=2.64u w=0.45u l=0.28u
X72 a_2704_471# a_2648_164# a_2566_116# w_2566_390# pfet_03v3 ad=0.3061p pd=2.445u as=0.1238p ps=1.44u w=0.28u l=0.28u
X73 a_138_1752# a_82_1708# a_0_1660# VSUBS nfet_03v3 ad=0.342p pd=2.21u as=0.3133p ps=2.64u w=0.45u l=0.28u
X74 a_3987_2787# a_3931_2480# a_3849_2432# w_3849_2706# pfet_03v3 ad=0.3061p pd=2.445u as=0.1238p ps=1.44u w=0.28u l=0.28u
X75 a_4941_160# a_4885_350# a_4781_394# VSUBS nfet_03v3 ad=0.23585p pd=1.95u as=0.1378p ps=1.05u w=0.53u l=0.28u
X76 a_3931_936# a_4333_1256# a_4381_1174# VSUBS nfet_03v3 ad=0.1288p pd=1.48u as=0.1208p ps=1.42u w=0.28u l=0.36u
X77 a_82_936# a_0_888# a_138_1243# w_0_1162# pfet_03v3 ad=0.1238p pd=1.44u as=0.3061p ps=2.445u w=0.28u l=0.28u
X78 a_1365_164# a_1283_116# a_1421_208# VSUBS nfet_03v3 ad=0.3133p pd=2.64u as=0.342p ps=2.21u w=0.45u l=0.28u
X79 a_4781_160# a_4725_116# a_4637_160# VSUBS nfet_03v3 ad=0.1378p pd=1.05u as=0.2332p ps=1.94u w=0.53u l=0.28u
X80 a_684_270# a_484_198# a_680_116# VSUBS nfet_03v3 ad=0.1288p pd=1.48u as=0.1208p ps=1.42u w=0.28u l=0.36u
X81 a_1421_471# a_1365_164# a_1283_116# w_1283_390# pfet_03v3 ad=0.3061p pd=2.445u as=0.1238p ps=1.44u w=0.28u l=0.28u
X82 a_684_556# a_484_484# a_680_402# VSUBS nfet_03v3 ad=0.1288p pd=1.48u as=0.1208p ps=1.42u w=0.28u l=0.36u
X83 a_3931_2480# a_3849_2432# a_3987_2787# w_3849_2706# pfet_03v3 ad=0.1238p pd=1.44u as=0.3061p ps=2.445u w=0.28u l=0.28u
X84 a_1967_2100# a_1767_2028# a_1963_1946# VSUBS nfet_03v3 ad=0.1288p pd=1.48u as=0.1208p ps=1.42u w=0.28u l=0.36u
X85 a_2215_394# a_2159_350# a_2071_394# VSUBS nfet_03v3 ad=0.1378p pd=1.05u as=0.2332p ps=1.94u w=0.53u l=0.28u
X86 a_82_2480# a_484_2514# a_532_2432# VSUBS nfet_03v3 ad=0.1288p pd=1.48u as=0.1208p ps=1.42u w=0.28u l=0.36u
X87 a_2704_208# a_2648_164# a_2566_116# VSUBS nfet_03v3 ad=0.342p pd=2.21u as=0.3133p ps=2.64u w=0.45u l=0.28u
X88 a_932_394# a_876_350# a_788_394# VSUBS nfet_03v3 ad=0.1378p pd=1.05u as=0.2332p ps=1.94u w=0.53u l=0.28u
X89 a_3250_2586# a_3050_2514# a_3246_2432# VSUBS nfet_03v3 ad=0.1288p pd=1.48u as=0.1208p ps=1.42u w=0.28u l=0.36u
X90 a_4941_1704# a_4885_1660# a_4781_1704# VSUBS nfet_03v3 ad=0.23585p pd=1.95u as=0.1378p ps=1.05u w=0.53u l=0.28u
X91 a_4533_2586# a_4333_2514# a_4529_2432# VSUBS nfet_03v3 ad=0.1288p pd=1.48u as=0.1208p ps=1.42u w=0.28u l=0.36u
X92 a_82_2480# a_484_2800# a_532_2718# VSUBS nfet_03v3 ad=0.1288p pd=1.48u as=0.1208p ps=1.42u w=0.28u l=0.36u
X93 a_2648_1708# a_2566_1660# a_2704_2015# w_2566_1934# pfet_03v3 ad=0.1238p pd=1.44u as=0.3061p ps=2.445u w=0.28u l=0.28u
X94 a_3250_2872# a_3050_2800# a_3246_2718# VSUBS nfet_03v3 ad=0.1288p pd=1.48u as=0.1208p ps=1.42u w=0.28u l=0.36u
X95 a_3498_1704# a_3442_1660# a_3354_1704# VSUBS nfet_03v3 ad=0.1378p pd=1.05u as=0.2332p ps=1.94u w=0.53u l=0.28u
X96 a_3658_2476# a_3602_2666# a_3498_2710# VSUBS nfet_03v3 ad=0.23585p pd=1.95u as=0.1378p ps=1.05u w=0.53u l=0.28u
X97 a_4533_2872# a_4333_2800# a_4529_2718# VSUBS nfet_03v3 ad=0.1288p pd=1.48u as=0.1208p ps=1.42u w=0.28u l=0.36u
X98 a_4781_1704# a_4725_1660# a_4637_1704# VSUBS nfet_03v3 ad=0.1378p pd=1.05u as=0.2332p ps=1.94u w=0.53u l=0.28u
X99 a_3498_160# a_3442_116# a_3354_160# VSUBS nfet_03v3 ad=0.1378p pd=1.05u as=0.2332p ps=1.94u w=0.53u l=0.28u
X100 a_1421_2524# a_1365_2480# a_1283_2432# VSUBS nfet_03v3 ad=0.342p pd=2.21u as=0.3133p ps=2.64u w=0.45u l=0.28u
X101 a_2215_2710# a_2159_2666# a_2071_2710# VSUBS nfet_03v3 ad=0.1378p pd=1.05u as=0.2332p ps=1.94u w=0.53u l=0.28u
X102 a_2648_1708# a_3050_1742# a_3098_1660# VSUBS nfet_03v3 ad=0.1288p pd=1.48u as=0.1208p ps=1.42u w=0.28u l=0.36u
X103 a_1365_936# a_1767_1256# a_1815_1174# VSUBS nfet_03v3 ad=0.1288p pd=1.48u as=0.1208p ps=1.42u w=0.28u l=0.36u
X104 a_2704_2524# a_2648_2480# a_2566_2432# VSUBS nfet_03v3 ad=0.342p pd=2.21u as=0.3133p ps=2.64u w=0.45u l=0.28u
X105 a_932_2710# a_876_2666# a_788_2710# VSUBS nfet_03v3 ad=0.1378p pd=1.05u as=0.2332p ps=1.94u w=0.53u l=0.28u
X106 a_138_2524# a_82_2480# a_0_2432# VSUBS nfet_03v3 ad=0.342p pd=2.21u as=0.3133p ps=2.64u w=0.45u l=0.28u
X107 a_4781_932# a_4725_888# a_4637_932# VSUBS nfet_03v3 ad=0.1378p pd=1.05u as=0.2332p ps=1.94u w=0.53u l=0.28u
X108 a_1421_208# a_1365_164# a_1283_116# VSUBS nfet_03v3 ad=0.342p pd=2.21u as=0.3133p ps=2.64u w=0.45u l=0.28u
X109 a_1421_1243# a_1365_936# a_1283_888# w_1283_1162# pfet_03v3 ad=0.3061p pd=2.445u as=0.1238p ps=1.44u w=0.28u l=0.28u
X110 a_138_471# a_82_164# a_0_116# w_0_390# pfet_03v3 ad=0.3061p pd=2.445u as=0.1238p ps=1.44u w=0.28u l=0.28u
X111 a_2704_1243# a_2648_936# a_2566_888# w_2566_1162# pfet_03v3 ad=0.3061p pd=2.445u as=0.1238p ps=1.44u w=0.28u l=0.28u
X112 a_82_1708# a_0_1660# a_138_2015# w_0_1934# pfet_03v3 ad=0.1238p pd=1.44u as=0.3061p ps=2.445u w=0.28u l=0.28u
X113 a_3931_1708# a_4333_2028# a_4381_1946# VSUBS nfet_03v3 ad=0.1288p pd=1.48u as=0.1208p ps=1.42u w=0.28u l=0.36u
X114 a_4941_160# a_4885_116# a_4781_160# VSUBS nfet_03v3 ad=0.23585p pd=1.95u as=0.1378p ps=1.05u w=0.53u l=0.28u
X115 a_138_1243# a_82_936# a_0_888# w_0_1162# pfet_03v3 ad=0.3061p pd=2.445u as=0.1238p ps=1.44u w=0.28u l=0.28u
X116 a_3931_164# a_3849_116# a_3987_471# w_3849_390# pfet_03v3 ad=0.1238p pd=1.44u as=0.3061p ps=2.445u w=0.28u l=0.28u
X117 a_3931_936# a_4333_970# a_4381_888# VSUBS nfet_03v3 ad=0.1288p pd=1.48u as=0.1208p ps=1.42u w=0.28u l=0.36u
X118 a_1365_2480# a_1283_2432# a_1421_2787# w_1283_2706# pfet_03v3 ad=0.1238p pd=1.44u as=0.3061p ps=2.445u w=0.28u l=0.28u
X119 a_1092_932# a_1036_1122# a_932_1166# VSUBS nfet_03v3 ad=0.23585p pd=1.95u as=0.1378p ps=1.05u w=0.53u l=0.28u
X120 a_3987_1752# a_3931_1708# a_3849_1660# VSUBS nfet_03v3 ad=0.342p pd=2.21u as=0.3133p ps=2.64u w=0.45u l=0.28u
X121 a_4533_1042# a_4333_970# a_4529_888# VSUBS nfet_03v3 ad=0.1288p pd=1.48u as=0.1208p ps=1.42u w=0.28u l=0.36u
X122 a_3658_2476# a_3602_2432# a_3498_2476# VSUBS nfet_03v3 ad=0.23585p pd=1.95u as=0.1378p ps=1.05u w=0.53u l=0.28u
X123 a_2375_932# a_2319_1122# a_2215_1166# VSUBS nfet_03v3 ad=0.23585p pd=1.95u as=0.1378p ps=1.05u w=0.53u l=0.28u
X124 a_684_1328# a_484_1256# a_680_1174# VSUBS nfet_03v3 ad=0.1288p pd=1.48u as=0.1208p ps=1.42u w=0.28u l=0.36u
X125 a_2215_160# a_2159_116# a_2071_160# VSUBS nfet_03v3 ad=0.1378p pd=1.05u as=0.2332p ps=1.94u w=0.53u l=0.28u
X126 a_3498_932# a_3442_888# a_3354_932# VSUBS nfet_03v3 ad=0.1378p pd=1.05u as=0.2332p ps=1.94u w=0.53u l=0.28u
X127 a_2215_2476# a_2159_2432# a_2071_2476# VSUBS nfet_03v3 ad=0.1378p pd=1.05u as=0.2332p ps=1.94u w=0.53u l=0.28u
X128 a_932_160# a_876_116# a_788_160# VSUBS nfet_03v3 ad=0.1378p pd=1.05u as=0.2332p ps=1.94u w=0.53u l=0.28u
X129 a_82_164# a_484_198# a_532_116# VSUBS nfet_03v3 ad=0.1288p pd=1.48u as=0.1208p ps=1.42u w=0.28u l=0.36u
X130 a_932_2476# a_876_2432# a_788_2476# VSUBS nfet_03v3 ad=0.1378p pd=1.05u as=0.2332p ps=1.94u w=0.53u l=0.28u
X131 a_3931_1708# a_3849_1660# a_3987_1752# VSUBS nfet_03v3 ad=0.3133p pd=2.64u as=0.342p ps=2.21u w=0.45u l=0.28u
X132 a_3931_164# a_3849_116# a_3987_208# VSUBS nfet_03v3 ad=0.3133p pd=2.64u as=0.342p ps=2.21u w=0.45u l=0.28u
X133 a_1967_270# a_1767_198# a_1963_116# VSUBS nfet_03v3 ad=0.1288p pd=1.48u as=0.1208p ps=1.42u w=0.28u l=0.36u
X134 a_1967_1814# a_1767_1742# a_1963_1660# VSUBS nfet_03v3 ad=0.1288p pd=1.48u as=0.1208p ps=1.42u w=0.28u l=0.36u
X135 a_82_164# a_484_484# a_532_402# VSUBS nfet_03v3 ad=0.1288p pd=1.48u as=0.1208p ps=1.42u w=0.28u l=0.36u
X136 a_138_208# a_82_164# a_0_116# VSUBS nfet_03v3 ad=0.342p pd=2.21u as=0.3133p ps=2.64u w=0.45u l=0.28u
X137 a_1967_556# a_1767_484# a_1963_402# VSUBS nfet_03v3 ad=0.1288p pd=1.48u as=0.1208p ps=1.42u w=0.28u l=0.36u
X138 a_1365_1708# a_1767_2028# a_1815_1946# VSUBS nfet_03v3 ad=0.1288p pd=1.48u as=0.1208p ps=1.42u w=0.28u l=0.36u
X139 a_4941_932# a_4885_888# a_4781_932# VSUBS nfet_03v3 ad=0.23585p pd=1.95u as=0.1378p ps=1.05u w=0.53u l=0.28u
X140 a_2648_2480# a_3050_2514# a_3098_2432# VSUBS nfet_03v3 ad=0.1288p pd=1.48u as=0.1208p ps=1.42u w=0.28u l=0.36u
X141 a_3250_1042# a_3050_970# a_3246_888# VSUBS nfet_03v3 ad=0.1288p pd=1.48u as=0.1208p ps=1.42u w=0.28u l=0.36u
X142 a_2648_936# a_3050_970# a_3098_888# VSUBS nfet_03v3 ad=0.1288p pd=1.48u as=0.1208p ps=1.42u w=0.28u l=0.36u
X143 a_2648_2480# a_3050_2800# a_3098_2718# VSUBS nfet_03v3 ad=0.1288p pd=1.48u as=0.1208p ps=1.42u w=0.28u l=0.36u
X144 a_1421_2015# a_1365_1708# a_1283_1660# w_1283_1934# pfet_03v3 ad=0.3061p pd=2.445u as=0.1238p ps=1.44u w=0.28u l=0.28u
X145 a_1092_1704# a_1036_1894# a_932_1938# VSUBS nfet_03v3 ad=0.23585p pd=1.95u as=0.1378p ps=1.05u w=0.53u l=0.28u
X146 a_3658_160# a_3602_350# a_3498_394# VSUBS nfet_03v3 ad=0.23585p pd=1.95u as=0.1378p ps=1.05u w=0.53u l=0.28u
X147 a_2375_1704# a_2319_1894# a_2215_1938# VSUBS nfet_03v3 ad=0.23585p pd=1.95u as=0.1378p ps=1.05u w=0.53u l=0.28u
X148 a_2704_2015# a_2648_1708# a_2566_1660# w_2566_1934# pfet_03v3 ad=0.3061p pd=2.445u as=0.1238p ps=1.44u w=0.28u l=0.28u
X149 a_138_2015# a_82_1708# a_0_1660# w_0_1934# pfet_03v3 ad=0.3061p pd=2.445u as=0.1238p ps=1.44u w=0.28u l=0.28u
X150 a_4941_2476# a_4885_2666# a_4781_2710# VSUBS nfet_03v3 ad=0.23585p pd=1.95u as=0.1378p ps=1.05u w=0.53u l=0.28u
X151 a_2215_932# a_2159_888# a_2071_932# VSUBS nfet_03v3 ad=0.1378p pd=1.05u as=0.2332p ps=1.94u w=0.53u l=0.28u
X152 a_932_932# a_876_888# a_788_932# VSUBS nfet_03v3 ad=0.1378p pd=1.05u as=0.2332p ps=1.94u w=0.53u l=0.28u
X153 a_1365_1708# a_1283_1660# a_1421_1752# VSUBS nfet_03v3 ad=0.3133p pd=2.64u as=0.342p ps=2.21u w=0.45u l=0.28u
X154 a_3498_2710# a_3442_2666# a_3354_2710# VSUBS nfet_03v3 ad=0.1378p pd=1.05u as=0.2332p ps=1.94u w=0.53u l=0.28u
X155 a_3987_2524# a_3931_2480# a_3849_2432# VSUBS nfet_03v3 ad=0.342p pd=2.21u as=0.3133p ps=2.64u w=0.45u l=0.28u
X156 a_3931_1708# a_4333_1742# a_4381_1660# VSUBS nfet_03v3 ad=0.1288p pd=1.48u as=0.1208p ps=1.42u w=0.28u l=0.36u
X157 a_4781_2710# a_4725_2666# a_4637_2710# VSUBS nfet_03v3 ad=0.1378p pd=1.05u as=0.2332p ps=1.94u w=0.53u l=0.28u
X158 a_684_2100# a_484_2028# a_680_1946# VSUBS nfet_03v3 ad=0.1288p pd=1.48u as=0.1208p ps=1.42u w=0.28u l=0.36u
X159 a_82_936# a_0_888# a_138_980# VSUBS nfet_03v3 ad=0.3133p pd=2.64u as=0.342p ps=2.21u w=0.45u l=0.28u
X160 a_3931_2480# a_3849_2432# a_3987_2524# VSUBS nfet_03v3 ad=0.3133p pd=2.64u as=0.342p ps=2.21u w=0.45u l=0.28u
X161 a_3987_1243# a_3931_936# a_3849_888# w_3849_1162# pfet_03v3 ad=0.3061p pd=2.445u as=0.1238p ps=1.44u w=0.28u l=0.28u
X162 a_2648_2480# a_2566_2432# a_2704_2787# w_2566_2706# pfet_03v3 ad=0.1238p pd=1.44u as=0.3061p ps=2.445u w=0.28u l=0.28u
X163 a_684_1042# a_484_970# a_680_888# VSUBS nfet_03v3 ad=0.1288p pd=1.48u as=0.1208p ps=1.42u w=0.28u l=0.36u
X164 a_1967_2586# a_1767_2514# a_1963_2432# VSUBS nfet_03v3 ad=0.1288p pd=1.48u as=0.1208p ps=1.42u w=0.28u l=0.36u
X165 a_3250_1328# a_3050_1256# a_3246_1174# VSUBS nfet_03v3 ad=0.1288p pd=1.48u as=0.1208p ps=1.42u w=0.28u l=0.36u
X166 a_82_936# a_484_1256# a_532_1174# VSUBS nfet_03v3 ad=0.1288p pd=1.48u as=0.1208p ps=1.42u w=0.28u l=0.36u
X167 a_1967_2872# a_1767_2800# a_1963_2718# VSUBS nfet_03v3 ad=0.1288p pd=1.48u as=0.1208p ps=1.42u w=0.28u l=0.36u
X168 a_4941_2476# a_4885_2432# a_4781_2476# VSUBS nfet_03v3 ad=0.23585p pd=1.95u as=0.1378p ps=1.05u w=0.53u l=0.28u
X169 a_2375_160# a_2319_350# a_2215_394# VSUBS nfet_03v3 ad=0.23585p pd=1.95u as=0.1378p ps=1.05u w=0.53u l=0.28u
X170 a_1365_164# a_1767_198# a_1815_116# VSUBS nfet_03v3 ad=0.1288p pd=1.48u as=0.1208p ps=1.42u w=0.28u l=0.36u
X171 a_4533_1328# a_4333_1256# a_4529_1174# VSUBS nfet_03v3 ad=0.1288p pd=1.48u as=0.1208p ps=1.42u w=0.28u l=0.36u
X172 a_3658_932# a_3602_1122# a_3498_1166# VSUBS nfet_03v3 ad=0.23585p pd=1.95u as=0.1378p ps=1.05u w=0.53u l=0.28u
X173 a_3931_936# a_3849_888# a_3987_1243# w_3849_1162# pfet_03v3 ad=0.1238p pd=1.44u as=0.3061p ps=2.445u w=0.28u l=0.28u
X174 a_3498_2476# a_3442_2432# a_3354_2476# VSUBS nfet_03v3 ad=0.1378p pd=1.05u as=0.2332p ps=1.94u w=0.53u l=0.28u
X175 a_1365_164# a_1767_484# a_1815_402# VSUBS nfet_03v3 ad=0.1288p pd=1.48u as=0.1208p ps=1.42u w=0.28u l=0.36u
X176 a_2215_1166# a_2159_1122# a_2071_1166# VSUBS nfet_03v3 ad=0.1378p pd=1.05u as=0.2332p ps=1.94u w=0.53u l=0.28u
X177 a_4781_2476# a_4725_2432# a_4637_2476# VSUBS nfet_03v3 ad=0.1378p pd=1.05u as=0.2332p ps=1.94u w=0.53u l=0.28u
X178 a_1092_1704# a_1036_1660# a_932_1704# VSUBS nfet_03v3 ad=0.23585p pd=1.95u as=0.1378p ps=1.05u w=0.53u l=0.28u
X179 a_3658_160# a_3602_116# a_3498_160# VSUBS nfet_03v3 ad=0.23585p pd=1.95u as=0.1378p ps=1.05u w=0.53u l=0.28u
X180 a_1365_1708# a_1767_1742# a_1815_1660# VSUBS nfet_03v3 ad=0.1288p pd=1.48u as=0.1208p ps=1.42u w=0.28u l=0.36u
X181 a_2375_1704# a_2319_1660# a_2215_1704# VSUBS nfet_03v3 ad=0.23585p pd=1.95u as=0.1378p ps=1.05u w=0.53u l=0.28u
X182 a_2648_936# a_2566_888# a_2704_980# VSUBS nfet_03v3 ad=0.3133p pd=2.64u as=0.342p ps=2.21u w=0.45u l=0.28u
X183 a_932_1166# a_876_1122# a_788_1166# VSUBS nfet_03v3 ad=0.1378p pd=1.05u as=0.2332p ps=1.94u w=0.53u l=0.28u
X184 a_82_2480# a_0_2432# a_138_2787# w_0_2706# pfet_03v3 ad=0.1238p pd=1.44u as=0.3061p ps=2.445u w=0.28u l=0.28u
X185 a_1365_2480# a_1283_2432# a_1421_2524# VSUBS nfet_03v3 ad=0.3133p pd=2.64u as=0.342p ps=2.21u w=0.45u l=0.28u
X186 a_3931_2480# a_4333_2514# a_4381_2432# VSUBS nfet_03v3 ad=0.1288p pd=1.48u as=0.1208p ps=1.42u w=0.28u l=0.36u
X187 a_1092_160# a_1036_350# a_932_394# VSUBS nfet_03v3 ad=0.23585p pd=1.95u as=0.1378p ps=1.05u w=0.53u l=0.28u
X188 a_3931_2480# a_4333_2800# a_4381_2718# VSUBS nfet_03v3 ad=0.1288p pd=1.48u as=0.1208p ps=1.42u w=0.28u l=0.36u
X189 a_3987_980# a_3931_936# a_3849_888# VSUBS nfet_03v3 ad=0.342p pd=2.21u as=0.3133p ps=2.64u w=0.45u l=0.28u
X190 a_3987_2015# a_3931_1708# a_3849_1660# w_3849_1934# pfet_03v3 ad=0.3061p pd=2.445u as=0.1238p ps=1.44u w=0.28u l=0.28u
X191 a_3658_1704# a_3602_1894# a_3498_1938# VSUBS nfet_03v3 ad=0.23585p pd=1.95u as=0.1378p ps=1.05u w=0.53u l=0.28u
.ends

.subckt gf180mcu_as_sc_mcu7t3v3__nand2_2 VDD VSS Y B A VNW VPW
X0 VDD A Y VNW pfet_03v3 ad=0.3588p pd=1.9u as=0.3588p ps=1.9u w=1.38u l=0.28u
X1 VSS A a_28_68# VPW nfet_03v3 ad=0.26p pd=1.52u as=0.44p ps=2.88u w=1u l=0.28u
X2 Y B VDD VNW pfet_03v3 ad=0.3588p pd=1.9u as=0.3588p ps=1.9u w=1.38u l=0.28u
X3 a_28_68# B Y VPW nfet_03v3 ad=0.515p pd=3.03u as=0.26p ps=1.52u w=1u l=0.28u
X4 VDD B Y VNW pfet_03v3 ad=0.7176p pd=3.8u as=0.3588p ps=1.9u w=1.38u l=0.28u
X5 Y B a_28_68# VPW nfet_03v3 ad=0.26p pd=1.52u as=0.26p ps=1.52u w=1u l=0.28u
X6 Y A VDD VNW pfet_03v3 ad=0.3588p pd=1.9u as=0.6072p ps=3.64u w=1.38u l=0.28u
X7 a_28_68# A VSS VPW nfet_03v3 ad=0.26p pd=1.52u as=0.26p ps=1.52u w=1u l=0.28u
.ends

.subckt gf180mcu_as_sc_mcu7t3v3__nor2_2 VDD VSS Y B A VNW VPW
X0 a_28_440# A VDD VNW pfet_03v3 ad=0.3588p pd=1.9u as=0.3588p ps=1.9u w=1.38u l=0.28u
X1 Y A VSS VPW nfet_03v3 ad=0.26p pd=1.52u as=0.44p ps=2.88u w=1u l=0.28u
X2 Y B a_28_440# VNW pfet_03v3 ad=0.3588p pd=1.9u as=0.3588p ps=1.9u w=1.38u l=0.28u
X3 VSS B Y VPW nfet_03v3 ad=0.515p pd=3.03u as=0.26p ps=1.52u w=1u l=0.28u
X4 a_28_440# B Y VNW pfet_03v3 ad=0.7176p pd=3.8u as=0.3588p ps=1.9u w=1.38u l=0.28u
X5 Y B VSS VPW nfet_03v3 ad=0.26p pd=1.52u as=0.26p ps=1.52u w=1u l=0.28u
X6 VDD A a_28_440# VNW pfet_03v3 ad=0.3588p pd=1.9u as=0.6072p ps=3.64u w=1.38u l=0.28u
X7 VSS A Y VPW nfet_03v3 ad=0.26p pd=1.52u as=0.26p ps=1.52u w=1u l=0.28u
.ends

.subckt gf180mcu_as_sc_mcu7t3v3__nand3_2 VDD VSS A B C Y VNW VPW
X0 VDD A Y VNW pfet_03v3 ad=0.3588p pd=1.9u as=0.3588p ps=1.9u w=1.38u l=0.28u
X1 VSS A a_28_68# VPW nfet_03v3 ad=0.26p pd=1.52u as=0.44p ps=2.88u w=1u l=0.28u
X2 VDD C Y VNW pfet_03v3 ad=0.621p pd=3.66u as=0.3588p ps=1.9u w=1.38u l=0.28u
X3 a_492_68# C Y VPW nfet_03v3 ad=0.45p pd=2.9u as=0.26p ps=1.52u w=1u l=0.28u
X4 Y B VDD VNW pfet_03v3 ad=0.3588p pd=1.9u as=0.3588p ps=1.9u w=1.38u l=0.28u
X5 a_28_68# B a_492_68# VPW nfet_03v3 ad=0.44p pd=2.88u as=0.26p ps=1.52u w=1u l=0.28u
X6 VDD B Y VNW pfet_03v3 ad=0.8004p pd=2.54u as=0.3588p ps=1.9u w=1.38u l=0.28u
X7 Y C VDD VNW pfet_03v3 ad=0.3588p pd=1.9u as=0.8004p ps=2.54u w=1.38u l=0.28u
X8 Y C a_492_68# VPW nfet_03v3 ad=0.26p pd=1.52u as=0.44p ps=2.88u w=1u l=0.28u
X9 a_492_68# B a_28_68# VPW nfet_03v3 ad=0.26p pd=1.52u as=0.26p ps=1.52u w=1u l=0.28u
X10 Y A VDD VNW pfet_03v3 ad=0.3588p pd=1.9u as=0.6072p ps=3.64u w=1.38u l=0.28u
X11 a_28_68# A VSS VPW nfet_03v3 ad=0.26p pd=1.52u as=0.26p ps=1.52u w=1u l=0.28u
.ends

.subckt gf180mcu_3v3_12t_2r2w_sram_512x32_array_control_core clk w1_data[0] w1_data[1]
+ w1_data[2] w1_data[3] w1_data[4] w1_data[5] w1_data[6] w1_data[7] w1_data[8] w1_data[9]
+ w1_data[10] w1_data[11] w1_data[12] w1_data[13] w1_data[14] w1_data[15] w1_data[16]
+ w1_data[17] w1_data[18] w1_data[19] w1_data[20] w1_data[21] w1_data[22] w1_data[23]
+ w1_data[24] w1_data[25] w1_data[26] w1_data[27] w1_data[28] w1_data[29] w1_data[30]
+ w1_data[31] w0_data[0] w0_data[1] w0_data[2] w0_data[3] w0_data[4] w0_data[5] w0_data[6]
+ w0_data[7] w0_data[8] w0_data[9] w0_data[10] w0_data[11] w0_data[12] w0_data[13]
+ w0_data[14] w0_data[15] w0_data[16] w0_data[17] w0_data[18] w0_data[19] w0_data[20]
+ w0_data[21] w0_data[22] w0_data[23] w0_data[24] w0_data[25] w0_data[26] w0_data[27]
+ w0_data[28] w0_data[29] w0_data[30] w0_data[31] r0_data[1] r0_data[2] r0_data[3]
+ r0_data[4] r0_data[5] r0_data[6] r0_data[7] r0_data[8] r0_data[9] r0_data[10] r0_data[11]
+ r0_data[12] r0_data[13] r0_data[14] r0_data[15] r0_data[16] r0_data[17] r0_data[18]
+ r0_data[19] r0_data[20] r0_data[21] r0_data[22] r0_data[23] r0_data[24] r0_data[25]
+ r0_data[26] r0_data[27] r0_data[28] r0_data[29] r0_data[30] r0_data[31] r0_data[0]
+ r1_data[2] r1_data[3] r1_data[4] r1_data[5] r1_data[6] r1_data[7] r1_data[8] r1_data[9]
+ r1_data[10] r1_data[11] r1_data[12] r1_data[13] r1_data[14] r1_data[15] r1_data[16]
+ r1_data[17] r1_data[18] r1_data[19] r1_data[20] r1_data[21] r1_data[22] r1_data[23]
+ r1_data[24] r1_data[25] r1_data[26] r1_data[27] r1_data[28] r1_data[29] r1_data[30]
+ r1_data[31] r1_data[0] r1_data[1] u_t001_006/c1_r0_rbl u_t016_020/c3_w0_bl u_t016_027/r3_w0_wl
+ u_t000_030/r3_w0_wl u_t000_013/c3_w1_br u_t029_004/r2_w1_wl u_t031_013/c1_w1_bl
+ u_t016_003/c1_w1_bl u_t010_017/c1_w0_bl u_t021_014/c3_w1_bl u_t003_009/c0_w1_bl
+ u_t030_030/r0_w0_wl u_t004_027/r2_w0_wl u_t029_030/c3_w0_bl u_t000_018/c3_w0_bl
+ u_t017_004/r1_w1_wl u_t002_023/c3_w1_bl u_t029_013/c1_w1_bl u_t007_005/r3_w1_wl
+ u_t023_027/c1_w0_bl u_t001_012/c3_w0_bl u_t003_020/c1_w0_br u_t008_017/c1_w0_bl
+ u_t019_014/c3_w1_bl u_t005_004/r0_w1_wl u_t013_028/c3_w0_bl u_t028_030/r0_w0_wl
+ u_t003_003/VSS u_t001_011/c2_r1_rbl u_t030_000/r2_w1_wl u_t024_028/r1_w0_wl u_t002_013/r3_w0_wl
+ u_t024_021/c1_w0_bl u_t004_003/VDD u_t001_013/c3_r0_rbl u_t018_031/r2_w0_wl u_t014_029/r3_w0_wl
+ u_t014_022/c3_w0_bl u_t005_030/c1_w0_bl u_t003_012/VSS u_t014_005/c1_w1_bl u_t012_028/r0_w0_wl
+ u_t004_012/VDD u_t006_031/r1_w0_wl u_t004_006/c3_w1_bl u_t002_029/r2_w0_wl u_t000_028/c1_w0_br
+ u_t003_002/r2_r0_rwl u_t020_010/c3_w1_bl u_t027_015/c1_w1_bl u_t004_021/VDD u_t003_023/r2_w0_wl
+ u_t021_029/c1_w0_bl u_t017_016/c3_w1_bl u_t006_019/c1_w0_bl u_t022_023/c1_w0_bl
+ u_t018_010/c3_w1_bl u_t004_000/r0_w1_wl u_t012_024/c3_w0_bl u_t002_019/c2_r0_rbl
+ u_t019_029/c1_w0_bl u_t012_007/c1_w1_bl u_t002_004/c2_r1_rbl u_t026_002/r2_w1_wl
+ u_t002_008/c3_w1_bl u_t000_024/c2_w0_bl u_t002_006/c3_r0_rbl u_t003_021/c1_r1_rbl
+ u_t013_001/c1_w1_bl u_t003_005/c1_w0_br u_t025_017/c1_w1_bl u_t014_002/r1_w1_wl
+ u_t003_030/r2_w1_wl u_t015_018/c3_w1_bl u_t001_001/c0_w1_bl u_t026_011/c1_w1_bl
+ u_t004_003/r3_w1_wl a_17000_120600# u_t020_025/c1_w0_bl u_t002_002/c2_w1_br u_t031_022/c3_w1_bl
+ u_t005_015/c1_w0_bl u_t016_012/c3_w1_bl u_t010_026/c3_w0_bl a_200_39400# u_t003_018/c2_w1_bl
+ u_t010_009/c1_w1_bl u_t002_007/c2_w0_bl a_22600_95400# u_t011_027/r3_w0_wl u_t011_020/c3_w0_bl
+ u_t018_025/c1_w0_bl u_t024_004/r2_w1_wl u_t029_022/c3_w1_bl u_t011_003/c1_w1_bl
+ u_t000_031/c2_w1_bl u_t003_008/r2_w0_wl u_t003_001/c2_w0_bl u_t008_026/c3_w0_bl
+ u_t001_007/c1_w0_br u_t001_004/c3_w1_bl u_t024_030/c3_w0_bl u_t008_009/c1_w1_bl
+ u_t012_004/r1_w1_wl u_t009_020/c3_w0_bl u_t009_027/r3_w0_wl u_t031_028/r2_w0_wl
+ u_t002_005/r3_w1_wl u_t024_013/c1_w1_bl u_t009_003/c1_w1_bl u_t025_031/r3_w0_wl
+ u_t000_004/c2_w1_br u_t003_017/c1_w0_bl u_t014_014/c3_w1_bl u_t000_004/r0_w1_wl
+ u_t029_028/r2_w0_wl u_t013_031/r2_w0_wl u_t002_017/c0_w0_br u_t000_009/c2_w0_bl
+ u_t025_019/c3_w0_bl u_t000_030/c1_w0_bl u_t016_027/c1_w0_bl u_t003_011/c0_w0_br
+ u_t006_028/c3_w0_bl u_t003_015/r2_w1_wl u_t023_000/r2_w1_wl u_t017_021/c1_w0_bl
+ u_t017_028/r1_w0_wl u_t001_014/c1_w1_br u_t007_022/c3_w0_bl u_t007_029/r3_w0_wl
+ u_t031_007/c3_w1_bl u_t022_015/c1_w1_bl u_t007_005/c1_w1_bl u_t011_000/r1_w1_wl
+ u_t005_028/r0_w0_wl u_t000_029/c0_r1_rbl u_t001_019/c1_w0_bl u_t012_016/c3_w1_bl
+ u_t029_007/c3_w1_bl u_t002_013/c1_w0_bl u_t013_010/c3_w1_bl u_t000_016/c1_r1_rbl
+ u_t000_019/c0_w0_br u_t003_014/c3_w0_br u_t000_016/c2_w1_bl u_t014_029/c1_w0_bl
+ u_t000_018/c2_r0_rbl u_t015_023/c1_w0_bl u_t021_002/r2_w1_wl u_t000_003/c2_r1_rbl
+ u_t001_010/c2_w1_bl u_t026_020/c3_w1_bl a_22600_3000# u_t000_005/c3_r0_rbl u_t005_024/c3_w0_bl
+ a_14200_45000# u_t020_017/c1_w1_bl u_t029_001/r0_w1_wl u_t005_007/c1_w1_bl u_t003_023/c0_w0_bl
+ u_t010_018/c3_w1_bl u_t021_011/c1_w1_bl u_t006_001/c1_w1_bl u_t027_009/c3_w1_bl
+ u_t000_015/c1_w0_bl u_t000_023/c3_r1_rbl u_t011_012/c3_w1_bl u_t031_004/r3_w1_wl
+ u_t018_017/c1_w1_bl u_t000_026/c0_w1_br u_t007_002/r1_w1_wl u_t003_021/c3_w1_br
+ u_t008_018/c3_w1_bl u_t019_011/c1_w1_bl u_t024_022/c3_w1_bl u_t013_025/c1_w0_bl
+ u_t001_009/c1_r1_rbl u_t009_012/c3_w1_bl u_t029_004/r3_w1_wl u_t003_026/c3_w0_bl
+ u_t003_012/c0_r0_rbl u_t002_014/r3_r0_rwl u_t003_009/c1_w1_bl u_t004_020/c3_w0_bl
+ u_t004_027/r3_w0_wl u_t002_026/c2_w0_br u_t003_031/r2_r0_rwl u_t017_004/r2_w1_wl
+ u_t004_003/c1_w1_bl u_t000_029/c3_w1_br u_t002_009/c0_w1_br u_t000_022/c1_w1_bl
+ u_t017_030/c3_w0_bl u_t030_018/c1_w0_bl u_t005_004/r1_w1_wl u_t028_030/r1_w0_wl
+ u_t003_003/c0_w1_br u_t030_000/r3_w1_wl u_t024_028/r2_w0_wl u_t017_013/c1_w1_bl
+ u_t020_019/c3_w0_bl u_t000_012/c3_w0_br a_200_92600# a_22600_120600# u_t018_031/r3_w0_wl
+ u_t011_027/c1_w0_bl a_200_19800# u_t007_014/c3_w1_bl u_t001_028/c3_w0_bl u_t016_030/r0_w0_wl
+ u_t003_008/c0_w0_bl u_t028_018/c1_w0_bl u_t012_028/r1_w0_wl u_t012_021/c1_w0_bl
+ a_22600_75800# u_t025_005/r0_w1_wl u_t006_031/r2_w0_wl u_t002_029/r3_w0_wl u_t018_019/c3_w0_bl
+ u_t002_022/c3_w0_bl u_t009_027/c1_w0_bl u_t002_005/c1_w1_bl u_t000_028/r0_w0_wl
+ u_t025_031/c1_w0_bl u_t003_019/c0_r1_rbl u_t003_006/c3_w1_br u_t024_007/c3_w1_bl
+ u_t015_015/c1_w1_bl u_t003_006/c1_r1_rbl u_t005_016/c3_w1_bl u_t010_023/c1_w0_bl
+ u_t021_020/c3_w1_bl u_t006_010/c3_w1_bl u_t026_002/r3_w1_wl u_t000_024/c3_w0_bl
+ u_t007_029/c1_w0_bl u_t027_014/c1_w0_bl u_t024_001/r0_w1_wl u_t000_007/c1_w1_bl
+ u_t003_026/c2_r1_rbl u_t014_002/r2_w1_wl u_t008_023/c1_w0_bl u_t003_028/c3_r0_rbl
+ u_t019_020/c3_w1_bl u_t001_001/c1_w1_bl u_t022_009/c3_w1_bl u_t003_013/c3_r1_rbl
+ u_t013_017/c1_w1_bl u_t002_002/r1_w1_wl a_14200_109400# u_t003_018/c3_w1_bl u_t014_011/c1_w1_bl
+ u_t004_012/c3_w1_bl u_t024_004/r3_w1_wl u_t025_016/c1_w0_bl u_t001_011/c0_r0_rbl
+ u_t002_011/c0_w1_bl u_t000_025/c0_r1_rbl u_t030_027/c3_w0_bl u_t006_025/c1_w0_bl
+ u_t001_000/c0_w0_bl u_t012_004/r2_w1_wl u_t017_022/c3_w1_bl u_t002_004/VSS a_14200_25400#
+ u_t002_001/c2_w0_br u_t031_021/c3_w0_bl u_t031_028/r3_w0_wl u_t002_004/VDD u_t031_004/c1_w1_bl
+ u_t003_017/c2_w0_bl u_t012_030/c3_w0_bl u_t028_027/c3_w0_bl u_t000_004/r1_w1_wl
+ u_t002_013/VSS u_t023_030/r1_w0_wl u_t003_028/c1_w1_br u_t002_013/VDD u_t012_013/c1_w1_bl
+ u_t029_021/c3_w0_bl u_t029_028/r3_w0_wl u_t013_031/r3_w0_wl u_t002_014/c3_w1_bl
+ u_t000_030/c2_w0_bl u_t029_004/c1_w1_bl u_t027_027/r0_w0_wl u_t011_030/r0_w0_wl
+ u_t023_018/c1_w0_bl u_t001_003/c3_w0_bl u_t020_005/r0_w1_wl u_t017_028/r2_w0_wl
+ u_t001_031/r2_w0_wl u_t013_019/c3_w0_bl u_t004_027/c1_w0_bl u_t002_004/r3_w0_wl
+ u_t000_003/c2_w0_br u_t020_031/c1_w0_bl u_t009_030/r0_w0_wl u_t000_003/r0_w0_wl
+ u_t002_004/c0_r0_rbl u_t005_021/c1_w0_bl u_t005_028/r1_w0_wl u_t003_027/c0_w0_br
+ u_t018_005/r0_w1_wl u_t026_029/c3_w0_bl u_t003_024/c2_w1_bl u_t010_015/c1_w1_bl
+ u_t027_023/c3_w0_bl u_t018_031/c1_w0_bl u_t000_016/c3_w1_bl u_t009_000/r2_w1_wl
+ u_t027_006/c1_w1_bl u_t025_029/r0_w0_wl u_t031_001/r1_w1_wl u_t003_014/r2_w0_wl
+ u_t002_010/r3_r0_rwl u_t001_013/c1_w0_br u_t002_024/c1_r0_rbl u_t017_007/c3_w1_bl
+ u_t001_010/c3_w1_bl u_t021_002/r3_w1_wl u_t008_015/c1_w1_bl u_t002_029/c1_w0_bl
+ u_t022_014/c1_w0_bl u_t000_008/c3_r1_rbl u_t002_011/r3_w1_wl u_t000_010/c2_w1_br
+ u_t002_011/c2_r0_rbl u_t003_023/c1_w0_bl u_t014_020/c3_w1_bl u_t017_001/r0_w1_wl
+ u_t000_015/c2_w0_bl u_t025_025/c3_w0_bl u_t025_008/c1_w1_bl u_t030_019/c3_w1_bl
+ u_t003_021/r2_w1_wl u_t015_009/c3_w1_bl u_t003_016/r2_r0_rwl u_t006_017/c1_w1_bl
+ u_t026_002/c1_w1_bl u_t020_016/c1_w0_bl u_t031_013/c3_w1_bl u_t027_003/r1_w1_wl
+ u_t007_011/c1_w1_bl u_t003_009/c2_w1_bl u_t001_025/c1_w0_bl u_t012_022/c3_w1_bl
+ u_t028_019/c3_w1_bl u_t030_030/r2_w0_wl u_t017_004/r3_w1_wl u_t018_016/c1_w0_bl
+ u_t029_013/c3_w1_bl u_t015_003/r0_w1_wl u_t000_025/c0_w0_br u_t023_027/c3_w0_bl
+ u_t003_004/c2_r0_rbl u_t003_020/c3_w0_br u_t005_004/r2_w1_wl u_t024_028/r3_w0_wl
+ u_t024_021/c3_w0_bl u_t024_004/c1_w1_bl u_t022_027/r0_w0_wl u_t005_030/c3_w0_bl
+ u_t016_030/r1_w0_wl u_t012_028/r2_w0_wl u_t005_013/c1_w1_bl u_t025_005/r1_w1_wl
+ u_t003_019/c0_w1_br u_t000_028/c3_w0_br u_t031_028/c1_w0_bl u_t004_030/r0_w0_wl
+ u_t027_015/c3_w1_bl u_t016_018/c1_w0_bl u_t000_028/r1_w0_wl u_t000_021/c1_w0_bl
+ u_t021_029/c3_w0_bl u_t000_003/c0_r0_rbl u_t013_005/r0_w1_wl a_200_28200# u_t016_000/r3_w1_wl
+ u_t000_018/VDD u_t003_002/c0_w0_br u_t006_019/c3_w0_bl u_t003_006/r2_w1_wl u_t001_005/c1_w1_br
+ a_22600_84200# u_t022_023/c3_w0_bl u_t029_028/c1_w0_bl u_t013_031/c1_w0_bl u_t000_027/VDD
+ u_t022_006/c1_w1_bl u_t020_029/r0_w0_wl u_t019_029/c3_w0_bl u_t000_021/c0_r1_rbl
+ u_t012_007/c3_w1_bl u_t003_015/c1_w1_bl u_t000_023/c1_r0_rbl u_t002_004/c1_w0_bl
+ u_t024_001/r1_w1_wl u_t018_029/r0_w0_wl u_t003_005/c3_w0_br u_t025_017/c3_w1_bl
+ u_t000_010/c2_r0_rbl u_t030_024/c1_w0_bl u_t001_004/c0_w0_br u_t001_001/c2_w1_bl
+ u_t015_014/c1_w0_bl u_t026_011/c3_w1_bl u_t012_001/r0_w1_wl u_t020_025/c3_w0_bl
+ u_t002_002/r2_w1_wl u_t020_008/c1_w1_bl u_t007_020/c3_w1_bl u_t028_024/c1_w0_bl
+ u_t010_009/c3_w1_bl u_t000_030/c3_r0_rbl u_t001_017/c1_w1_bl u_t021_002/c1_w1_bl
+ u_t018_025/c3_w0_bl u_t000_006/c1_w0_bl u_t018_008/c1_w1_bl u_t002_011/c1_w1_bl
+ u_t001_007/c3_w0_br u_t000_017/c0_w1_br u_t023_019/c3_w1_bl u_t003_012/c3_w1_br
+ u_t008_009/c3_w1_bl u_t012_004/r3_w1_wl u_t019_002/c1_w1_bl u_t013_016/c1_w0_bl
+ u_t001_011/c0_w1_br u_t024_013/c3_w1_bl u_t001_001/c1_r1_rbl u_t001_003/c2_r0_rbl
+ u_t000_017/c2_r1_rbl u_t000_004/r2_w1_wl u_t005_022/c3_w1_bl u_t023_030/r2_w0_wl
+ u_t026_026/c1_w0_bl u_t002_017/c2_w0_br u_t008_003/r0_w1_wl u_t000_030/c3_w0_bl
+ u_t016_027/c3_w0_bl u_t002_010/c0_w0_bl u_t027_020/c1_w0_bl u_t027_027/r1_w0_wl
+ u_t011_030/r1_w0_wl u_t003_011/c2_w0_br u_t000_013/c1_w1_bl u_t020_005/r1_w1_wl
+ u_t017_021/c3_w0_bl u_t017_028/r3_w0_wl u_t001_031/r3_w0_wl u_t001_014/c3_w1_br
+ u_t015_027/r0_w0_wl u_t017_004/c1_w1_bl u_t022_015/c3_w1_bl u_t011_018/c1_w0_bl
+ u_t000_003/r1_w0_wl u_t005_028/r2_w0_wl u_t001_019/c3_w0_bl u_t018_005/r1_w1_wl
+ u_t003_012/r2_r0_rwl u_t024_028/c1_w0_bl u_t002_013/c3_w0_bl u_t003_026/c0_r0_rbl
+ u_t009_018/c1_w0_bl u_t006_005/r0_w1_wl u_t014_029/c3_w0_bl u_t009_000/r3_w1_wl
+ u_t029_031/r0_w0_wl u_t003_011/c0_r1_rbl u_t025_029/r1_w0_wl u_t031_001/r2_w1_wl
+ u_t025_022/c1_w0_bl u_t015_023/c3_w0_bl u_t006_031/c1_w0_bl u_t030_016/c1_w1_bl
+ u_t015_006/c1_w1_bl u_t013_029/r0_w0_wl u_t020_017/c3_w1_bl u_t005_007/c3_w1_bl
+ u_t031_010/c1_w1_bl u_t003_023/c2_w0_bl u_t010_014/c1_w0_bl u_t003_031/c1_r1_rbl
+ u_t021_011/c3_w1_bl u_t028_016/c1_w1_bl a_200_81400# u_t002_023/c1_w0_br u_t018_017/c3_w1_bl
+ u_t002_020/c3_w1_bl u_t000_026/c2_w1_br u_t029_010/c1_w1_bl u_t023_024/c1_w0_bl
+ a_22600_64600# u_t008_014/c1_w0_bl u_t003_020/c3_r0_rbl u_t019_011/c3_w1_bl u_t013_025/c3_w0_bl
+ u_t001_005/VDD u_t002_010/r3_w0_wl u_t013_008/c1_w1_bl u_t027_003/r2_w1_wl u_t003_009/c3_w1_bl
+ u_t030_030/r3_w0_wl u_t001_014/VDD u_t014_002/c1_w1_bl u_t003_030/c2_w1_bl u_t001_008/c0_w1_bl
+ u_t026_018/c1_w1_bl u_t002_009/c2_w1_br u_t015_003/r1_w1_wl u_t000_022/c3_w1_bl
+ u_t016_019/c3_w1_bl u_t002_002/c0_w1_bl u_t027_012/c1_w1_bl u_t005_004/r3_w1_wl
+ u_t003_020/r2_w0_wl u_t021_026/c1_w0_bl u_t003_003/c2_w1_br u_t006_016/c1_w0_bl
+ u_t017_013/c3_w1_bl u_t003_003/r0_w1_wl u_t011_027/c3_w0_bl u_t022_027/r1_w0_wl
+ u_t022_020/c1_w0_bl u_t003_008/c2_w0_bl u_t012_028/r3_w0_wl u_t012_021/c3_w0_bl
+ u_t019_026/c1_w0_bl u_t025_005/r2_w1_wl u_t012_004/c1_w1_bl u_t010_027/r0_w0_wl
+ u_t009_027/c3_w0_bl u_t002_005/c3_w1_bl u_t000_028/r2_w0_wl u_t025_031/c3_w0_bl
+ u_t013_005/r1_w1_wl u_t025_014/c1_w1_bl u_t000_008/c1_r0_rbl u_t008_027/r0_w0_wl
+ u_t004_018/c1_w0_bl u_t015_015/c3_w1_bl u_t001_005/r0_w1_wl u_t004_000/r3_w1_wl
+ u_t024_031/r0_w0_wl u_t020_022/c1_w0_bl u_t020_029/r1_w0_wl u_t001_010/c0_r1_rbl
+ u_t003_018/c0_w0_br u_t010_023/c3_w0_bl u_t003_015/c2_w1_bl u_t001_031/c1_w0_bl
+ u_t017_028/c1_w0_bl a_14200_14200# u_t010_006/c1_w1_bl u_t007_029/c3_w0_bl u_t018_022/c1_w0_bl
+ u_t018_029/r1_w0_wl u_t000_007/c3_w1_bl u_t002_015/c1_w1_br u_t003_005/r2_w0_wl
+ u_t008_023/c3_w0_bl u_t023_016/c1_w1_bl u_t000_015/c3_r0_rbl u_t008_006/c1_w1_bl
+ u_t006_029/r0_w0_wl u_t013_017/c3_w1_bl u_t000_000/c3_r1_rbl u_t024_010/c1_w1_bl
+ u_t002_002/r3_w1_wl u_t000_001/c2_w1_br u_t003_014/c1_w0_bl u_t014_011/c3_w1_bl
+ u_t000_001/r0_w1_wl u_t003_025/c0_w1_br u_t002_018/c0_r0_rbl u_t022_003/r2_w1_wl
+ u_t016_024/c1_w0_bl u_t002_003/c0_r1_rbl u_t027_021/c3_w1_bl u_t006_025/c3_w0_bl
+ u_t001_000/c2_w0_bl u_t003_012/r2_w1_wl u_t021_018/c1_w1_bl u_t006_008/c1_w1_bl
+ u_t010_003/r1_w1_wl u_t011_019/c3_w1_bl u_t000_000/c1_w0_br u_t022_012/c1_w1_bl
+ u_t000_004/r3_w1_wl u_t007_002/c1_w1_bl u_t003_028/c3_w1_br u_t001_016/c1_w0_bl
+ u_t001_008/c3_r0_rbl u_t012_013/c3_w1_bl a_200_61800# u_t019_018/c1_w1_bl u_t003_021/c1_w1_bl
+ u_t002_025/c2_r0_rbl u_t030_004/r0_w1_wl u_t009_019/c3_w1_bl u_t027_027/r2_w0_wl
+ u_t002_010/c2_r1_rbl u_t020_005/r2_w1_wl u_t014_026/c1_w0_bl u_t025_023/c3_w1_bl
+ u_t030_030/c1_w0_bl u_t001_010/c0_w0_br u_t004_027/c3_w0_bl u_t015_020/c1_w0_bl
+ u_t015_027/r1_w0_wl u_t028_004/r0_w1_wl u_t020_031/c3_w0_bl u_t009_030/r2_w0_wl
+ u_t002_026/c0_w0_bl u_t005_021/c3_w0_bl u_t005_028/r3_w0_wl u_t031_031/r1_w0_wl
+ u_t018_005/r2_w1_wl u_t000_029/c1_w1_bl u_t020_014/c1_w1_bl u_t003_027/r0_w0_wl
+ u_t005_004/c1_w1_bl u_t028_030/c1_w0_bl u_t010_015/c3_w1_bl u_t018_031/c3_w0_bl
+ u_t031_019/c1_w0_bl u_t006_005/r1_w1_wl u_t000_012/c1_w0_bl u_t027_006/c3_w1_bl
+ u_t025_029/r2_w0_wl u_t031_001/r3_w1_wl u_t018_014/c1_w1_bl u_t001_013/c3_w0_br
+ u_t012_028/c1_w0_bl u_t002_010/VSS u_t003_016/c1_r1_rbl u_t008_015/c3_w1_bl u_t002_029/c3_w0_bl
+ u_t017_031/r0_w0_wl u_t003_018/c2_r0_rbl u_t013_029/r1_w0_wl u_t029_019/c1_w0_bl
+ u_t013_022/c1_w0_bl u_t029_001/r3_w1_wl u_t003_003/c2_r1_rbl u_t003_023/c3_w0_bl
+ u_t003_005/c3_r0_rbl u_t003_006/c1_w1_bl u_t001_029/r0_w0_wl u_t017_001/r2_w1_wl
+ a_19800_120600# u_t025_008/c3_w1_bl u_t016_016/c1_w1_bl u_t030_015/c1_w0_bl u_t003_023/c3_r1_rbl
+ u_t006_017/c3_w1_bl u_t017_010/c1_w1_bl u_t011_024/c1_w0_bl u_t022_021/c3_w1_bl
+ u_t007_011/c3_w1_bl a_200_17000# u_t001_025/c3_w0_bl u_t028_015/c1_w0_bl u_t025_002/r0_w1_wl
+ a_22600_73000# u_t001_008/c1_w1_bl u_t009_024/c1_w0_bl u_t000_025/c2_w0_br u_t002_002/c1_w1_bl
+ u_t014_018/c1_w1_bl u_t000_022/c1_r1_rbl u_t003_003/r1_w1_wl u_t001_002/c0_w1_br
+ u_t004_019/c3_w1_bl u_t022_027/r2_w0_wl u_t015_012/c1_w1_bl u_t016_030/r3_w0_wl
+ u_t020_023/c3_w1_bl u_t005_013/c3_w1_bl u_t025_005/r3_w1_wl u_t003_019/c2_w1_br
+ u_t026_017/c1_w0_bl u_t010_027/r1_w0_wl u_t010_020/c1_w0_bl u_t002_008/c2_w0_br
+ u_t023_004/r0_w1_wl u_t031_028/c3_w0_bl u_t000_021/c3_w0_bl u_t000_028/r3_w0_wl
+ u_t007_026/c1_w0_bl u_t002_001/c0_w0_bl u_t013_005/r2_w1_wl u_t018_023/c3_w1_bl
+ u_t003_002/c2_w0_br u_t000_004/c1_w1_bl u_t023_030/c1_w0_bl u_t001_005/c3_w1_br
+ u_t008_020/c1_w0_bl u_t008_027/r1_w0_wl u_t030_028/r0_w0_wl u_t013_031/c3_w0_bl
+ u_t029_028/c3_w0_bl u_t001_005/r1_w1_wl u_t024_031/r1_w0_wl u_t022_006/c3_w1_bl
+ u_t020_029/r2_w0_wl u_t013_014/c1_w1_bl u_t003_019/VSS u_t003_015/c3_w1_bl u_t002_001/c1_r0_rbl
+ u_t004_019/VDD u_t001_015/c1_r1_rbl u_t028_028/r0_w0_wl u_t012_031/r0_w0_wl u_t024_019/c1_w0_bl
+ u_t002_004/c3_w0_bl u_t003_028/VSS u_t024_001/r3_w1_wl u_t018_029/r2_w0_wl u_t004_028/VDD
+ u_t000_003/c0_w0_bl u_t001_002/c2_r1_rbl u_t005_028/c1_w0_bl u_t030_024/c3_w0_bl
+ u_t006_022/c1_w0_bl u_t006_029/r1_w0_wl u_t030_007/c1_w1_bl u_t000_006/VDD u_t020_008/c3_w1_bl
+ u_t011_016/c1_w1_bl u_t031_001/c1_w1_bl u_t028_024/c3_w0_bl u_t001_017/c3_w1_bl
+ u_t012_010/c1_w1_bl u_t028_007/c1_w1_bl u_t000_006/c3_w0_bl u_t002_014/c1_w0_br
+ u_t002_009/r3_r0_rwl u_t018_008/c3_w1_bl u_t022_003/r3_w1_wl u_t002_011/c3_w1_bl
+ u_t009_016/c1_w1_bl u_t029_001/c1_w1_bl u_t000_017/c2_w1_br u_t003_026/r2_r0_rwl
+ u_t023_015/c1_w0_bl u_t020_002/r0_w1_wl u_t000_010/c0_w1_bl u_t002_008/c1_r1_rbl
+ u_t001_011/c2_w1_br u_t010_003/r2_w1_wl u_t004_024/c1_w0_bl u_t003_025/c0_r1_rbl
+ u_t015_021/c3_w1_bl u_t002_001/r3_w0_wl u_t000_000/r0_w0_wl u_t003_024/c0_w0_br
+ u_t026_026/c3_w0_bl u_t003_028/r2_w1_wl u_t026_009/c1_w1_bl u_t010_012/c1_w1_bl
+ u_t030_004/r1_w1_wl u_t002_010/c2_w0_bl u_t027_020/c3_w0_bl u_t027_027/r3_w0_wl
+ u_t000_013/c3_w1_bl u_t020_005/r3_w1_wl u_t007_018/c1_w1_bl u_t027_003/c1_w1_bl
+ u_t003_011/r2_w0_wl u_t021_017/c1_w0_bl u_t015_027/r2_w0_wl a_200_70200# u_t008_012/c1_w1_bl
+ u_t028_004/r1_w1_wl u_t013_023/c3_w1_bl u_t002_026/c1_w0_bl u_t009_030/r3_w0_wl
+ u_t031_031/r2_w0_wl u_t003_027/c3_w0_br u_t018_005/r3_w1_wl a_22600_53400# u_t019_017/c1_w0_bl
+ u_t003_020/c1_w0_bl u_t003_027/r1_w0_wl u_t016_004/r0_w1_wl u_t024_028/c3_w0_bl
+ u_t006_005/r2_w1_wl u_t025_029/r3_w0_wl u_t025_022/c3_w0_bl u_t016_030/c1_w0_bl
+ u_t000_023/c1_w1_br u_t025_005/c1_w1_bl u_t000_000/c1_r0_rbl u_t023_028/r0_w0_wl
+ u_t006_031/c3_w0_bl u_t030_016/c3_w1_bl u_t015_006/c3_w1_bl u_t013_029/r2_w0_wl
+ u_t000_031/c0_r1_rbl u_t006_014/c1_w1_bl u_t000_028/c1_w0_bl u_t031_010/c3_w1_bl
+ u_t003_009/c0_w0_br u_t027_000/r1_w1_wl u_t003_008/c3_r1_rbl u_t028_016/c3_w1_bl
+ u_t001_029/r1_w0_wl u_t017_019/c1_w0_bl u_t001_022/c1_w0_bl u_t017_001/r3_w1_wl
+ u_t029_010/c3_w1_bl u_t002_006/c1_w1_br u_t015_000/r0_w1_wl u_t023_024/c3_w0_bl
+ u_t005_001/r2_w1_wl u_t023_007/c1_w1_bl u_t003_000/c1_w1_br u_t013_008/c3_w1_bl
+ u_t004_016/c1_w1_bl u_t024_001/c1_w1_bl u_t003_005/c1_w0_bl u_t005_010/c1_w1_bl
+ u_t000_007/c1_r1_rbl u_t001_008/c2_w1_bl u_t026_018/c3_w1_bl u_t010_021/c3_w1_bl
+ u_t002_010/c0_r0_rbl u_t000_009/c2_r0_rbl u_t031_025/c1_w0_bl u_t002_002/c2_w1_bl
+ u_t016_015/c1_w0_bl u_t027_012/c3_w1_bl u_t000_008/c1_w1_br u_t021_026/c3_w0_bl
+ u_t003_003/r2_w1_wl u_t021_009/c1_w1_bl u_t008_021/c3_w1_bl u_t022_020/c3_w0_bl
+ u_t022_027/r3_w0_wl u_t029_025/c1_w0_bl u_t000_027/c2_r1_rbl u_t002_030/c1_r0_rbl
+ u_t002_018/c1_w1_bl u_t022_003/c1_w1_bl u_t000_029/c3_r0_rbl u_t019_026/c3_w0_bl
+ u_t001_000/c3_r0_rbl u_t000_014/c3_r1_rbl u_t010_027/r2_w0_wl u_t019_009/c1_w1_bl
+ u_t003_012/c1_w1_bl u_t023_004/r1_w1_wl u_t004_030/r3_w0_wl u_t013_005/r3_w1_wl
+ u_t014_017/c1_w0_bl u_t002_012/c0_w1_br u_t025_014/c3_w1_bl u_t011_004/r0_w1_wl
+ u_t008_027/r2_w0_wl u_t001_011/VDD u_t030_021/c1_w0_bl u_t030_028/r1_w0_wl u_t003_003/c0_r0_rbl
+ u_t001_005/r2_w1_wl u_t006_023/c3_w1_bl u_t020_022/c3_w0_bl u_t002_005/r3_r0_rwl
+ u_t020_029/r3_w0_wl u_t002_017/c0_w0_bl u_t011_030/c1_w0_bl u_t027_027/c1_w0_bl
+ u_t003_018/c2_w0_br u_t003_022/r2_r0_rwl u_t020_005/c1_w1_bl u_t009_004/r0_w1_wl
+ u_t001_031/c3_w0_bl u_t017_028/c3_w0_bl u_t028_021/c1_w0_bl u_t028_028/r1_w0_wl
+ u_t012_031/r1_w0_wl u_t010_006/c3_w1_bl u_t001_014/c1_w1_bl u_t018_022/c3_w0_bl
+ u_t018_029/r3_w0_wl u_t009_030/c1_w0_bl u_t000_031/c2_w0_br u_t003_023/c1_r0_rbl
+ u_t016_028/r0_w0_wl u_t018_005/c1_w1_bl u_t000_031/r0_w0_wl u_t001_004/c3_w0_br
+ u_t012_019/c1_w0_bl u_t023_016/c3_w1_bl a_200_50600# u_t001_007/c3_r1_rbl u_t012_001/r3_w1_wl
+ u_t006_029/r2_w0_wl u_t008_006/c3_w1_bl u_t003_010/c2_r0_rbl u_t024_010/c3_w1_bl
+ a_22600_33800# u_t025_029/c1_w0_bl u_t000_001/r2_w1_wl u_t003_025/c2_w1_br u_t026_023/c1_w0_bl
+ u_t008_000/r0_w1_wl u_t016_024/c3_w0_bl u_t003_030/c3_r0_rbl u_t031_017/c1_w1_bl
+ u_t016_007/c1_w1_bl u_t020_002/r1_w1_wl u_t000_010/c1_w1_bl u_t021_018/c3_w1_bl
+ a_22600_200# u_t006_008/c3_w1_bl u_t017_001/c1_w1_bl u_t011_015/c1_w0_bl u_t022_012/c3_w1_bl
+ u_t029_017/c1_w1_bl u_t018_002/r1_w1_wl u_t000_026/c0_w1_bl u_t019_018/c3_w1_bl
+ u_t003_021/c3_w1_bl a_200_89800# a_22600_117800# u_t008_003/r3_w1_wl u_t030_004/r2_w1_wl
+ u_t024_025/c1_w0_bl u_t003_017/c2_r1_rbl u_t009_015/c1_w0_bl u_t000_016/c2_w0_br
+ u_t014_026/c3_w0_bl u_t014_009/c1_w1_bl u_t030_030/c3_w0_bl u_t001_010/c2_w0_br
+ u_t015_020/c3_w0_bl u_t015_027/r3_w0_wl u_t028_004/r2_w1_wl u_t030_013/c1_w1_bl
+ u_t031_031/r3_w0_wl u_t015_003/c1_w1_bl u_t000_029/c3_w1_bl u_t020_014/c3_w1_bl
+ u_t002_009/c0_w1_bl u_t003_027/r2_w0_wl u_t028_030/c3_w0_bl u_t016_004/r1_w1_wl
+ u_t001_023/c3_w1_bl u_t003_003/c0_w1_bl u_t028_013/c1_w1_bl u_t031_019/c3_w0_bl
+ u_t006_005/r3_w1_wl u_t029_031/r3_w0_wl u_t022_027/c1_w0_bl u_t000_012/c3_w0_bl
+ u_t002_020/c1_w0_br u_t007_017/c1_w0_bl u_t018_014/c3_w1_bl u_t004_004/r0_w1_wl
+ u_t012_028/c3_w0_bl u_t023_028/r1_w0_wl u_t023_021/c1_w0_bl u_t013_029/r3_w0_wl
+ u_t029_019/c3_w0_bl u_t013_022/c3_w0_bl u_t004_030/c1_w0_bl u_t013_005/c1_w1_bl
+ u_t011_028/r0_w0_wl u_t027_000/r2_w1_wl u_t003_006/c3_w1_bl u_t001_029/r2_w0_wl
+ u_t026_015/c1_w1_bl u_t020_029/c1_w0_bl u_t015_000/r1_w1_wl u_t000_022/c1_w0_br
+ u_t009_028/r0_w0_wl u_t005_019/c1_w0_bl u_t016_016/c3_w1_bl u_t005_001/r3_w1_wl
+ u_t021_023/c1_w0_bl u_t017_010/c3_w1_bl u_t003_000/r0_w1_wl u_t011_024/c3_w0_bl
+ u_t018_029/c1_w0_bl u_t011_007/c1_w1_bl a_14200_95400# u_t002_028/c0_r0_rbl u_t019_023/c1_w0_bl
+ u_t001_008/c3_w1_bl u_t012_001/c1_w1_bl u_t002_013/c0_r1_rbl u_t009_024/c3_w0_bl
+ u_t002_001/r3_r0_rwl u_t002_005/c1_w0_br u_t024_017/c1_w1_bl u_t002_009/r3_w1_wl
+ u_t002_015/c1_r0_rbl u_t009_007/c1_w1_bl u_t014_018/c3_w1_bl u_t000_001/c0_w1_bl
+ u_t002_000/c1_r1_rbl u_t025_011/c1_w1_bl u_t003_003/r3_w1_wl u_t030_022/c3_w1_bl
+ u_t001_002/c2_w1_br u_t002_002/c2_r0_rbl u_t004_015/c1_w0_bl u_t015_012/c3_w1_bl
+ u_t001_007/c2_w0_bl u_t010_020/c3_w0_bl u_t010_027/r3_w0_wl u_t017_025/c1_w0_bl
+ u_t003_019/r2_w1_wl u_t023_004/r2_w1_wl u_t028_022/c3_w1_bl u_t010_003/c1_w1_bl
+ u_t002_001/c2_w0_bl u_t007_026/c3_w0_bl u_t000_007/c1_w0_br u_t002_022/c3_r0_rbl
+ u_t000_004/c3_w1_bl u_t003_007/r2_r0_rwl u_t023_030/c3_w0_bl u_t007_009/c1_w1_bl
+ u_t011_004/r1_w1_wl u_t003_002/r2_w0_wl u_t008_020/c3_w0_bl u_t008_027/r3_w0_wl
+ u_t030_028/r2_w0_wl u_t003_028/c1_w1_bl u_t023_013/c1_w1_bl u_t001_005/r3_w1_wl
+ u_t008_003/c1_w1_bl u_t002_017/c1_w0_bl u_t013_014/c3_w1_bl u_t003_008/c1_r0_rbl
+ u_t009_004/r1_w1_wl u_t031_005/r0_w1_wl u_t003_011/c1_w0_bl u_t028_028/r2_w0_wl
+ u_t024_019/c3_w0_bl u_t015_027/c1_w0_bl u_t002_011/c0_w0_br u_t005_028/c3_w0_bl
+ u_t031_031/c1_w0_bl u_t022_000/r2_w1_wl u_t016_021/c1_w0_bl u_t016_028/r1_w0_wl
+ u_t000_014/c1_w1_br u_t029_005/r0_w1_wl u_t006_022/c3_w0_bl u_t006_029/r3_w0_wl
+ u_t030_007/c3_w1_bl u_t021_015/c1_w1_bl u_t010_000/r1_w1_wl u_t004_028/r0_w0_wl
+ u_t006_005/c1_w1_bl u_t029_031/c1_w0_bl u_t011_016/c3_w1_bl u_t000_019/c1_w0_bl
+ u_t003_015/c3_r0_rbl u_t000_001/r3_w1_wl u_t003_000/c3_r1_rbl u_t028_007/c3_w1_bl
+ u_t001_013/c1_w0_bl u_t012_010/c3_w1_bl u_t019_015/c1_w1_bl u_t002_014/c3_w0_br
+ u_t013_029/c1_w0_bl u_t009_016/c3_w1_bl a_22600_42200# u_t000_010/c2_w1_bl u_t014_023/c1_w0_bl
+ u_t025_020/c3_w1_bl u_t000_027/c0_r0_rbl u_t004_024/c3_w0_bl u_t000_012/c0_r1_rbl
+ u_t028_001/r0_w1_wl u_t003_025/VSS u_t004_007/c1_w1_bl u_t002_023/c0_w0_bl u_t000_014/c1_r0_rbl
+ u_t018_002/r2_w1_wl u_t003_024/c2_w0_br u_t020_011/c1_w1_bl u_t005_001/c1_w1_bl
+ u_t026_009/c3_w1_bl u_t010_012/c3_w1_bl u_t030_004/r3_w1_wl u_t017_017/c1_w1_bl
+ u_t000_003/VDD u_t031_016/c1_w0_bl u_t006_002/r1_w1_wl u_t007_018/c3_w1_bl u_t018_011/c1_w1_bl
+ u_t023_022/c3_w1_bl u_t012_025/c1_w0_bl u_t000_012/VDD u_t008_012/c3_w1_bl u_t028_004/r3_w1_wl
+ u_t002_026/c3_w0_bl a_200_98200# u_t029_016/c1_w0_bl a_14200_75800# u_t002_009/c1_w1_bl
+ u_t000_021/c3_r0_rbl u_t000_025/c0_w0_bl u_t000_021/VDD u_t003_027/r3_w0_wl u_t003_020/c3_w0_bl
+ u_t016_004/r2_w1_wl u_t003_031/c2_w1_br u_t003_003/c1_w1_bl u_t001_005/c0_r1_rbl
+ u_t001_009/c0_w1_br u_t001_007/c1_r0_rbl u_t016_030/c3_w0_bl u_t004_004/r1_w1_wl
+ u_t002_003/c0_w1_br u_t027_030/r1_w0_wl u_t023_028/r2_w0_wl u_t016_013/c1_w1_bl
+ u_t017_031/r3_w0_wl u_t010_027/c1_w0_bl u_t006_014/c3_w1_bl u_t000_028/c3_w0_bl
+ u_t002_008/c0_w0_bl u_t027_018/c1_w0_bl u_t011_028/r1_w0_wl u_t011_021/c1_w0_bl
+ u_t003_009/c2_w0_br u_t024_005/r0_w1_wl u_t005_031/r2_w0_wl u_t001_029/r3_w0_wl
+ u_t017_019/c3_w0_bl u_t001_022/c3_w0_bl u_t003_030/c1_w0_br u_t003_002/c0_w0_bl
+ u_t008_027/c1_w0_bl u_t001_005/c1_w1_bl u_t001_012/c2_r1_rbl u_t024_031/c1_w0_bl
+ u_t002_006/c3_w1_br u_t009_028/r1_w0_wl u_t009_021/c1_w0_bl u_t001_014/c3_r0_rbl
+ u_t031_029/r0_w0_wl u_t000_028/c3_r1_rbl a_17000_200# u_t023_007/c3_w1_bl u_t003_000/c3_w1_br
+ u_t014_015/c1_w1_bl u_t003_000/r1_w1_wl u_t004_016/c3_w1_bl u_t029_029/r0_w0_wl
+ u_t003_003/r2_r0_rwl u_t003_005/c3_w0_bl u_t020_020/c3_w1_bl u_t005_010/c3_w1_bl
+ u_t025_002/r3_w1_wl u_t003_016/c2_w1_br u_t006_029/c1_w0_bl u_t026_014/c1_w0_bl
+ u_t031_025/c3_w0_bl u_t007_023/c1_w0_bl u_t013_002/r2_w1_wl u_t018_020/c3_w1_bl
+ u_t031_008/c1_w1_bl u_t000_001/c1_w1_bl u_t021_009/c3_w1_bl u_t012_017/c1_w1_bl
+ u_t002_005/c2_r1_rbl u_t029_025/c3_w0_bl u_t002_018/c3_w1_bl u_t002_007/c3_r0_rbl
+ u_t003_022/c1_r1_rbl u_t013_011/c1_w1_bl u_t029_008/c1_w1_bl u_t003_015/c1_w0_br
+ u_t000_017/c0_w1_bl u_t019_009/c3_w1_bl u_t003_012/c3_w1_bl u_t023_004/r3_w1_wl
+ u_t024_016/c1_w0_bl u_t002_008/r3_w0_wl a_22600_22600# u_t021_003/r0_w1_wl u_t001_011/c0_w1_bl
+ u_t005_025/c1_w0_bl u_t000_000/c0_w0_bl u_t011_004/r2_w1_wl u_t016_022/c3_w1_bl
+ u_t001_001/c2_w0_br u_t030_021/c3_w0_bl u_t030_028/r3_w0_wl u_t030_004/c1_w1_bl
+ u_t002_017/c2_w0_bl u_t011_030/c3_w0_bl u_t027_027/c3_w0_bl u_t009_004/r2_w1_wl
+ u_t011_013/c1_w1_bl u_t031_005/r1_w1_wl u_t003_018/r2_w0_wl u_t028_021/c3_w0_bl
+ u_t028_028/r3_w0_wl u_t012_031/r3_w0_wl u_t001_014/c3_w1_bl u_t003_022/c1_w1_br
+ u_t026_027/r0_w0_wl u_t028_004/c1_w1_bl u_t009_030/c3_w0_bl u_t022_018/c1_w0_bl
+ u_t000_003/c3_w0_bl u_t022_000/r3_w1_wl u_t002_015/r3_w1_wl u_t016_028/r2_w0_wl
+ u_t009_013/c1_w1_bl u_t012_019/c3_w0_bl u_t029_005/r1_w1_wl u_t003_027/c1_w0_bl
+ a_22600_106600# a_200_78600# u_t008_030/r0_w0_wl u_t010_000/r2_w1_wl u_t004_021/c1_w0_bl
+ u_t004_028/r1_w0_wl u_t002_027/c0_w0_br u_t017_005/r0_w1_wl u_t025_029/c3_w0_bl
+ u_t026_023/c3_w0_bl u_t003_025/r2_w1_wl u_t017_031/c1_w0_bl u_t026_006/c1_w1_bl
+ u_t024_029/r0_w0_wl u_t031_017/c3_w1_bl u_t000_013/c1_w0_br u_t016_007/c3_w1_bl
+ u_t000_010/c3_w1_bl u_t020_002/r3_w1_wl u_t007_015/c1_w1_bl u_t001_029/c1_w0_bl
+ u_t021_014/c1_w0_bl u_t028_001/r1_w1_wl u_t029_017/c3_w1_bl u_t002_023/c1_w0_bl
+ u_t013_020/c3_w1_bl u_t002_020/c0_r0_rbl u_t000_019/c2_r0_rbl u_t019_014/c1_w0_bl
+ u_t003_007/c1_w1_br u_t016_001/r0_w1_wl u_t024_025/c3_w0_bl u_t000_004/c2_r1_rbl
+ u_t006_002/r2_w1_wl u_t024_008/c1_w1_bl u_t000_006/c3_r0_rbl u_t014_009/c3_w1_bl
+ u_t000_020/c1_w1_br u_t005_017/c1_w1_bl u_t025_002/c1_w1_bl u_t030_013/c3_w1_bl
+ u_t006_011/c1_w1_bl u_t002_009/c2_w1_bl u_t011_022/c3_w1_bl u_t000_025/c1_w0_bl
+ u_t027_019/c3_w1_bl u_t016_004/r3_w1_wl u_t003_003/c2_w1_bl u_t017_016/c1_w0_bl
+ u_t028_013/c3_w1_bl u_t022_027/c3_w0_bl u_t002_020/c3_w0_br u_t009_022/c3_w1_bl
+ u_t004_004/r2_w1_wl u_t027_030/r2_w0_wl u_t023_028/r3_w0_wl u_t023_021/c3_w0_bl
+ a_14200_84200# u_t002_015/r3_r0_rwl u_t003_019/c1_w1_bl u_t023_004/c1_w1_bl u_t021_027/r0_w0_wl
+ u_t002_029/c1_r0_rbl u_t004_030/c3_w0_bl u_t015_030/r1_w0_wl u_t003_000/c1_r0_rbl
+ u_t011_028/r2_w0_wl u_t002_014/c1_r1_rbl u_t004_013/c1_w1_bl u_t024_005/r1_w1_wl
+ u_t005_031/r3_w0_wl u_t030_028/c1_w0_bl u_t019_027/r0_w0_wl u_t003_030/r0_w0_wl
+ u_t015_018/c1_w0_bl u_t026_015/c3_w1_bl u_t012_005/r0_w1_wl u_t020_029/c3_w0_bl
+ u_t000_022/c3_w0_br u_t009_028/r2_w0_wl u_t002_002/c0_w0_br u_t005_019/c3_w0_bl
+ u_t031_029/r1_w0_wl u_t031_022/c1_w0_bl u_t000_005/c1_w1_br u_t021_023/c3_w0_bl
+ u_t003_018/c0_w0_bl u_t012_031/c1_w0_bl u_t028_028/c1_w0_bl u_t003_000/r2_w1_wl
+ u_t021_006/c1_w1_bl u_t018_029/c3_w0_bl u_t002_026/VSS u_t029_022/c1_w0_bl u_t029_029/r1_w0_wl
+ u_t011_007/c3_w1_bl gf180mcu_as_sc_mcu7t3v3__inv_2_1043/A u_t002_015/c1_w1_bl u_t000_031/c0_w0_bl
+ u_t019_023/c3_w0_bl u_t001_004/c1_w0_bl u_t019_006/c1_w1_bl u_t023_001/r1_w1_wl
+ u_t017_029/r0_w0_wl m4_185148_119400# u_t002_005/c3_w0_br u_t024_017/c3_w1_bl u_t003_007/c1_r1_rbl
+ u_t009_007/c3_w1_bl u_t013_002/r3_w1_wl u_t000_004/c0_w0_br u_t003_009/c2_r0_rbl
+ u_t000_001/c2_w1_bl u_t014_014/c1_w0_bl u_t025_011/c3_w1_bl u_t011_001/r0_w1_wl
+ u_t003_025/c0_w1_bl u_t001_002/r2_w1_wl u_t006_020/c3_w1_bl u_t027_024/c1_w0_bl
+ u_t020_002/c1_w1_bl u_t000_017/c1_w1_bl u_t003_027/c2_r1_rbl u_t017_025/c3_w0_bl
+ u_t003_029/c3_r0_rbl u_t017_008/c1_w1_bl u_t001_011/c1_w1_bl u_t000_007/c3_w0_br
+ u_t022_019/c3_w1_bl u_t002_012/c3_w1_br u_t003_014/c3_r1_rbl u_t007_009/c3_w1_bl
+ u_t011_004/r3_w1_wl u_t018_002/c1_w1_bl u_t012_016/c1_w0_bl u_t000_011/c0_w1_br
+ u_t003_028/c3_w1_bl u_t023_013/c3_w1_bl u_t019_003/r1_w1_wl u_t004_022/c3_w1_bl
+ u_t022_030/r2_w0_wl u_t009_004/r3_w1_wl a_22600_31000# u_t000_016/c0_w0_bl u_t031_005/r2_w1_wl
+ u_t025_026/c1_w0_bl u_t003_011/c3_w0_bl u_t001_012/c0_r0_rbl u_t000_026/c0_r1_rbl
+ u_t007_003/r0_w1_wl u_t015_027/c3_w0_bl u_t001_010/c0_w0_bl u_t026_020/c1_w0_bl
+ u_t026_027/r1_w0_wl u_t010_030/r1_w0_wl u_t002_011/c2_w0_br u_t031_031/c3_w0_bl
+ u_t016_021/c3_w0_bl u_t016_028/r3_w0_wl u_t000_031/r3_w0_wl u_t000_014/c3_w1_br
+ u_t029_005/r2_w1_wl u_t031_014/c1_w1_bl u_t014_027/r0_w0_wl u_t016_004/c1_w1_bl
+ u_t010_018/c1_w0_bl u_t021_015/c3_w1_bl u_t030_031/r0_w0_wl u_t004_028/r2_w0_wl
+ u_t029_031/c3_w0_bl u_t000_019/c3_w0_bl u_t017_005/r1_w1_wl u_t029_014/c1_w1_bl
+ u_t023_028/c1_w0_bl u_t001_013/c3_w0_bl u_t003_021/c1_w0_br u_t000_023/c0_w1_bl
+ u_t019_015/c3_w1_bl u_t008_018/c1_w0_bl u_t005_005/r0_w1_wl u_t013_029/c3_w0_bl
+ u_t028_031/r0_w0_wl u_t008_000/r3_w1_wl a_200_87000# a_22600_115000# u_t030_001/r2_w1_wl
+ u_t024_029/r1_w0_wl u_t024_022/c1_w0_bl u_t002_014/r3_w0_wl a_14200_64600# u_t014_023/c3_w0_bl
+ u_t002_005/c0_r0_rbl u_t005_031/c1_w0_bl u_t014_006/c1_w1_bl u_t012_029/r0_w0_wl
+ u_t004_007/c3_w1_bl u_t030_010/c1_w1_bl u_t002_023/c2_w0_bl u_t000_029/c1_w0_br
+ u_t001_006/c1_r1_rbl u_t000_026/c3_w1_bl u_t020_011/c3_w1_bl u_t027_016/c1_w1_bl
+ u_t003_024/r2_w0_wl u_t002_011/r3_r0_rwl u_t017_017/c3_w1_bl u_t001_020/c3_w1_bl
+ u_t028_010/c1_w1_bl u_t022_024/c1_w0_bl u_t007_014/c1_w0_bl u_t018_011/c3_w1_bl
+ u_t004_001/r0_w1_wl u_t012_025/c3_w0_bl u_t002_012/c2_r0_rbl u_t012_008/c1_w1_bl
+ u_t003_004/VSS u_t026_003/r2_w1_wl u_t002_009/c3_w1_bl u_t004_004/VDD u_t000_025/c2_w0_bl
+ u_t001_013/c3_r1_rbl u_t013_002/c1_w1_bl gf180mcu_as_sc_mcu7t3v3__inv_2_2/A u_t003_006/c1_w0_br
+ u_t000_008/c0_w1_bl u_t025_018/c1_w1_bl u_t003_013/VSS u_t001_009/c2_w1_br u_t014_003/r1_w1_wl
+ u_t004_013/VDD u_t003_031/r2_w1_wl u_t003_017/r2_r0_rwl u_t015_019/c3_w1_bl u_t001_002/c0_w1_bl
+ u_t026_012/c1_w1_bl u_t004_004/r3_w1_wl u_t020_026/c1_w0_bl u_t002_003/c2_w1_br
+ u_t031_023/c3_w1_bl u_t005_016/c1_w0_bl u_t016_013/c3_w1_bl u_t010_027/c3_w0_bl
+ u_t021_027/r1_w0_wl u_t021_020/c1_w0_bl u_t015_030/r2_w0_wl u_t002_008/c2_w0_bl
+ u_t011_021/c3_w0_bl u_t011_028/r3_w0_wl u_t018_026/c1_w0_bl u_t024_005/r2_w1_wl
+ u_t029_023/c3_w1_bl u_t011_004/c1_w1_bl u_t003_009/r2_w0_wl u_t003_002/c2_w0_bl
+ u_t008_027/c3_w0_bl u_t003_030/r1_w0_wl u_t019_020/c1_w0_bl u_t019_027/r1_w0_wl
+ u_t001_005/c3_w1_bl u_t003_013/c1_w1_br u_t024_031/c3_w0_bl u_t012_005/r1_w1_wl
+ u_t009_021/c3_w0_bl u_t009_028/r3_w0_wl u_t031_029/r2_w0_wl u_t002_006/c3_r1_rbl
+ u_t002_006/r3_w1_wl u_t024_014/c1_w1_bl u_t009_004/c1_w1_bl u_t007_027/r0_w0_wl
+ u_t003_018/c1_w0_bl u_t014_015/c3_w1_bl u_t000_005/r0_w1_wl u_t003_000/r3_w1_wl
+ a_22600_11400# u_t029_029/r2_w0_wl u_t002_018/c0_w0_br u_t002_015/c2_w1_bl a_25400_200#
+ u_t000_031/c1_w0_bl u_t016_028/c1_w0_bl u_t000_004/c0_r0_rbl u_t003_012/c0_w0_br
+ u_t006_029/c3_w0_bl u_t003_016/r2_w1_wl u_t017_022/c1_w0_bl u_t023_001/r2_w1_wl
+ u_t017_029/r1_w0_wl u_t001_015/c1_w1_br u_t007_023/c3_w0_bl u_t031_008/c3_w1_bl
+ u_t022_016/c1_w1_bl u_t011_001/r1_w1_wl u_t000_022/c0_r1_rbl u_t005_029/r0_w0_wl
+ u_t007_006/c1_w1_bl u_t012_017/c3_w1_bl u_t023_010/c1_w1_bl u_t000_024/c1_r0_rbl
+ u_t029_008/c3_w1_bl u_t002_014/c1_w0_bl u_t013_011/c3_w1_bl u_t000_017/c2_w1_bl
+ u_t000_011/c2_r0_rbl a_200_67400# u_t021_003/r2_w1_wl u_t015_024/c1_w0_bl u_t026_021/c3_w1_bl
+ a_200_103800# u_t000_000/c2_w0_bl u_t005_025/c3_w0_bl u_t020_018/c1_w1_bl u_t029_002/r0_w1_wl
+ u_t005_008/c1_w1_bl u_t003_024/c0_w0_bl u_t010_019/c3_w1_bl u_t021_012/c1_w1_bl
+ u_t006_002/c1_w1_bl u_t022_030/r3_w0_wl u_t000_016/c1_w0_bl u_t011_013/c3_w1_bl
+ u_t031_005/r3_w1_wl u_t018_018/c1_w1_bl a_19800_200# u_t000_027/c0_w1_br u_t007_003/r1_w1_wl
+ u_t003_022/c3_w1_br u_t008_019/c3_w1_bl u_t010_030/r2_w0_wl u_t026_027/r2_w0_wl
+ u_t019_012/c1_w1_bl u_t013_026/c1_w0_bl u_t024_023/c3_w1_bl u_t009_013/c3_w1_bl
+ u_t029_005/r3_w1_wl u_t000_010/c0_w0_br u_t003_027/c3_w0_bl u_t001_004/c2_r0_rbl
+ u_t000_018/c2_r1_rbl u_t014_020/c1_w0_bl u_t014_027/r1_w0_wl u_t027_004/r0_w1_wl
+ u_t002_021/c1_r0_rbl u_t004_021/c3_w0_bl u_t004_028/r3_w0_wl u_t003_031/c0_w1_bl
+ u_t017_005/r2_w1_wl u_t004_004/c1_w1_bl u_t002_027/r0_w0_wl u_t027_030/c1_w0_bl
+ u_t017_031/c3_w0_bl u_t030_019/c1_w0_bl u_t005_005/r1_w1_wl u_t028_031/r1_w0_wl
+ u_t003_004/c0_w1_br u_t026_006/c3_w1_bl u_t030_001/r3_w1_wl u_t024_029/r2_w0_wl
+ u_t017_014/c1_w1_bl u_t000_013/c3_w0_br u_t011_028/c1_w0_bl u_t007_015/c3_w1_bl
+ u_t001_029/c3_w0_bl u_t016_031/r0_w0_wl u_t003_009/c0_w0_bl u_t012_029/r1_w0_wl
+ u_t028_019/c1_w0_bl u_t012_022/c1_w0_bl u_t003_013/r2_r0_rwl u_t002_023/c3_w0_bl
+ u_t003_027/c0_r0_rbl u_t009_028/c1_w0_bl u_t002_006/c1_w1_bl a_14200_73000# u_t000_029/r0_w0_wl
+ u_t003_012/c0_r1_rbl u_t003_007/c3_w1_br u_t003_014/c1_r0_rbl u_t024_008/c3_w1_bl
+ u_t015_016/c1_w1_bl u_t000_020/c3_w1_br u_t005_017/c3_w1_bl u_t016_010/c1_w1_bl
+ u_t010_024/c1_w0_bl u_t021_021/c3_w1_bl u_t003_016/c0_w1_bl u_t026_003/r3_w1_wl
+ u_t006_011/c3_w1_bl u_t000_025/c3_w0_bl u_t027_015/c1_w0_bl u_t024_002/r0_w1_wl
+ u_t000_008/c1_w1_bl u_t014_003/r2_w1_wl u_t008_024/c1_w0_bl u_t003_021/c3_r0_rbl
+ u_t019_021/c3_w1_bl u_t001_002/c1_w1_bl u_t013_018/c1_w1_bl u_t002_003/r1_w1_wl
+ gf180mcu_as_sc_mcu7t3v3__inv_2_1660/Y u_t000_002/c0_w1_br u_t003_019/c3_w1_bl u_t021_027/r2_w0_wl
+ u_t014_012/c1_w1_bl u_t004_013/c3_w1_bl u_t024_005/r3_w1_wl a_200_47800# u_t025_017/c1_w0_bl
+ u_t001_008/c2_w0_br u_t022_004/r0_w1_wl u_t030_028/c3_w0_bl u_t019_027/r2_w0_wl
+ u_t003_030/r2_w0_wl u_t006_026/c1_w0_bl u_t001_001/c0_w0_bl u_t012_005/r2_w1_wl
+ u_t017_023/c3_w1_bl u_t002_002/c2_w0_br u_t031_029/r3_w0_wl u_t031_022/c3_w0_bl
+ u_t022_030/c1_w0_bl u_t000_005/c3_w1_br u_t007_020/c1_w0_bl u_t007_027/r1_w0_wl
+ u_t031_005/c1_w1_bl u_t012_031/c3_w0_bl u_t028_028/c3_w0_bl u_t000_005/r1_w1_wl
+ u_t023_031/r1_w0_wl u_t003_029/c1_w1_br u_t021_006/c3_w1_bl u_t003_028/c3_r1_rbl
+ u_t012_014/c1_w1_bl u_t029_022/c3_w0_bl u_t029_029/r3_w0_wl u_t002_015/c3_w1_bl
+ u_t000_031/c2_w0_bl u_t027_028/r0_w0_wl u_t029_005/c1_w1_bl u_t011_031/r0_w0_wl
+ u_t023_019/c1_w0_bl u_t001_004/c3_w0_bl u_t017_029/r2_w0_wl u_t019_006/c3_w1_bl
+ u_t004_028/c1_w0_bl u_t002_005/r3_w0_wl u_t021_000/r0_w1_wl u_t009_031/r0_w0_wl
+ u_t000_004/r0_w0_wl u_t005_022/c1_w0_bl u_t001_011/c0_r1_rbl u_t005_029/r1_w0_wl
+ u_t003_025/c2_w1_bl u_t002_005/VSS u_t010_016/c1_w1_bl u_t030_001/c1_w1_bl u_t002_005/VDD
+ u_t027_024/c3_w0_bl u_t000_017/c3_w1_bl u_t009_001/r2_w1_wl u_t027_007/c1_w1_bl
+ u_t011_010/c1_w1_bl u_t031_002/r1_w1_wl u_t003_015/r2_w0_wl u_t001_014/c1_w0_br
+ u_t002_014/VDD u_t017_008/c3_w1_bl u_t021_003/r3_w1_wl u_t001_011/c3_w1_bl u_t028_001/c1_w1_bl
+ u_t008_016/c1_w1_bl u_t022_015/c1_w0_bl u_t002_012/r3_w1_wl u_t000_011/c2_w1_br
+ u_t009_010/c1_w1_bl u_t003_024/c1_w0_bl u_t014_021/c3_w1_bl a_14200_53400# u_t002_019/c0_r0_rbl
+ u_t017_002/r0_w1_wl u_t002_024/c0_w0_br u_t000_016/c2_w0_bl u_t025_026/c3_w0_bl
+ a_200_112200# a_22600_59000# u_t002_004/c0_r1_rbl u_t025_009/c1_w1_bl u_t002_006/c1_r0_rbl
+ u_t001_010/c2_w0_bl u_t026_020/c3_w0_bl u_t026_027/r3_w0_wl u_t003_022/r2_w1_wl
+ u_t006_018/c1_w1_bl u_t026_003/c1_w1_bl u_t020_017/c1_w0_bl u_t031_014/c3_w1_bl
+ u_t014_027/r2_w0_wl u_t007_012/c1_w1_bl u_t027_004/r1_w1_wl u_t001_026/c1_w0_bl
+ u_t012_023/c3_w1_bl u_t008_030/r3_w0_wl u_t030_031/r2_w0_wl u_t002_027/c3_w0_br
+ u_t017_005/r3_w1_wl u_t002_026/c2_r0_rbl u_t018_017/c1_w0_bl u_t002_020/c1_w0_bl
+ u_t002_027/r1_w0_wl u_t029_014/c3_w1_bl u_t000_026/c0_w0_br u_t015_004/r0_w1_wl
+ u_t023_028/c3_w0_bl u_t002_011/c2_r1_rbl u_t003_021/c3_w0_br u_t000_023/c2_w1_bl
+ u_t005_005/r2_w1_wl u_t002_013/c3_r0_rbl u_t024_029/r3_w0_wl u_t024_022/c3_w0_bl
+ u_t015_030/c1_w0_bl u_t024_005/c1_w1_bl u_t022_028/r0_w0_wl u_t005_031/c3_w0_bl
+ u_t016_031/r1_w0_wl u_t014_006/c3_w1_bl u_t012_029/r2_w0_wl u_t005_014/c1_w1_bl
+ u_t030_010/c3_w1_bl u_t000_029/c3_w0_br u_t002_009/c0_w0_br u_t031_029/c1_w0_bl
+ u_t004_031/r0_w0_wl u_t000_029/r1_w0_wl u_t016_019/c1_w0_bl u_t027_016/c3_w1_bl
+ u_t000_022/c1_w0_bl u_t016_001/r3_w1_wl u_t003_003/c0_w0_br u_t003_000/c2_w1_bl
+ u_t003_007/r2_w1_wl u_t028_010/c3_w1_bl u_t001_006/c1_w1_br u_t022_024/c3_w0_bl
+ u_t003_019/c2_r0_rbl u_t029_029/c1_w0_bl u_t022_007/c1_w1_bl u_t002_000/c1_w1_br
+ u_t003_004/c2_r1_rbl u_t012_008/c3_w1_bl u_t003_006/c3_r0_rbl u_t023_001/c1_w1_bl
+ u_t003_016/c1_w1_bl u_t002_005/c1_w0_bl u_t024_002/r1_w1_wl u_t004_010/c1_w1_bl
+ u_t003_006/c3_w0_br u_t000_008/c2_w1_bl u_t025_018/c3_w1_bl u_t030_025/c1_w0_bl
+ u_t015_015/c1_w0_bl u_t001_002/c2_w1_bl u_t003_010/c0_w1_br u_t026_012/c3_w1_bl
+ u_t012_002/r0_w1_wl u_t000_018/c0_r0_rbl u_t020_026/c3_w0_bl u_t002_003/r2_w1_wl
+ u_t020_009/c1_w1_bl u_t000_003/c0_r1_rbl u_t007_021/c3_w1_bl u_t000_019/VDD u_t021_020/c3_w0_bl
+ u_t021_027/r3_w0_wl u_t028_025/c1_w0_bl u_t001_018/c1_w1_bl u_t021_003/c1_w1_bl
+ u_t018_026/c3_w0_bl u_t000_028/VDD u_t018_009/c1_w1_bl u_t002_012/c1_w1_bl u_t022_004/r1_w1_wl
+ u_t000_018/c0_w1_br u_t019_020/c3_w0_bl u_t019_027/r3_w0_wl u_t003_013/c3_w1_br
+ u_t012_005/r3_w1_wl u_t000_023/c1_r1_rbl u_t019_003/c1_w1_bl u_t013_017/c1_w0_bl
+ u_t001_012/c0_w1_br u_t024_014/c3_w1_bl u_t000_025/c2_r0_rbl u_t010_004/r0_w1_wl
+ u_t007_027/r2_w0_wl u_t003_018/c3_w0_bl u_t000_010/c2_r1_rbl u_t000_005/r2_w1_wl
+ a_200_56200# u_t005_023/c3_w1_bl u_t023_031/r2_w0_wl a_14200_33800# u_t003_010/VSS
+ u_t010_030/c1_w0_bl u_t026_027/c1_w0_bl u_t002_018/c2_w0_br a_22600_39400# u_t008_004/r0_w1_wl
+ a_19800_3000# u_t000_031/c3_w0_bl u_t016_028/c3_w0_bl u_t027_021/c1_w0_bl u_t027_028/r1_w0_wl
+ u_t011_031/r1_w0_wl u_t000_014/c1_w1_bl u_t017_022/c3_w0_bl u_t017_029/r3_w0_wl
+ u_t008_030/c1_w0_bl u_t000_030/c3_r1_rbl u_t015_028/r0_w0_wl u_t017_005/c1_w1_bl
+ u_t000_004/c3_w0_br u_t022_016/c3_w1_bl u_t011_019/c1_w0_bl u_t000_004/r1_w0_wl
+ u_t005_029/r2_w0_wl u_t007_006/c3_w1_bl u_t003_028/c1_w0_br u_t023_010/c3_w1_bl
+ u_t024_029/c1_w0_bl u_t019_000/r1_w1_wl u_t009_019/c1_w0_bl u_t009_001/r3_w1_wl
+ u_t001_003/c2_r1_rbl u_t031_002/r2_w1_wl u_t025_023/c1_w0_bl u_t001_005/c3_r0_rbl
+ u_t007_000/r0_w1_wl u_t015_024/c3_w0_bl u_t030_017/c1_w1_bl u_t015_007/c1_w1_bl
+ u_t020_018/c3_w1_bl u_t005_008/c3_w1_bl u_t031_011/c1_w1_bl u_t003_024/c2_w0_bl
+ u_t016_001/c1_w1_bl u_t010_015/c1_w0_bl u_t021_012/c3_w1_bl u_t028_017/c1_w1_bl
+ u_t018_018/c3_w1_bl u_t002_021/c3_w1_bl u_t029_011/c1_w1_bl u_t003_027/r2_r0_rwl
+ u_t023_025/c1_w0_bl u_t002_009/c1_r1_rbl u_t008_015/c1_w0_bl u_t019_012/c3_w1_bl
+ u_t013_026/c3_w0_bl gf180mcu_as_sc_mcu7t3v3__inv_2_1369/Y u_t003_026/c0_r1_rbl u_t002_011/r3_w0_wl
+ u_t013_009/c1_w1_bl u_t000_010/c2_w0_br u_t014_027/r3_w0_wl u_t014_020/c3_w0_bl
+ u_t027_004/r2_w1_wl u_t030_031/r3_w0_wl u_t014_003/c1_w1_bl u_t003_031/c2_w1_bl
+ u_t001_009/c0_w1_bl u_t002_027/r2_w0_wl u_t027_030/c3_w0_bl u_t015_004/r1_w1_wl
+ u_t000_023/c3_w1_bl u_t002_003/c0_w1_bl u_t027_013/c1_w1_bl u_t030_019/c3_w0_bl
+ u_t005_005/r3_w1_wl u_t003_021/r2_w0_wl u_t021_027/c1_w0_bl u_t003_004/c2_w1_br
+ u_t006_017/c1_w0_bl u_t017_014/c3_w1_bl u_t003_004/r0_w1_wl u_t011_028/c3_w0_bl
+ u_t022_028/r1_w0_wl u_t022_021/c1_w0_bl u_t003_009/c2_w0_bl u_t012_029/r3_w0_wl
+ u_t028_019/c3_w0_bl u_t012_022/c3_w0_bl u_t019_027/c1_w0_bl u_t003_030/c1_w0_bl
+ u_t012_005/c1_w1_bl u_t010_028/r0_w0_wl u_t009_028/c3_w0_bl u_t001_006/VDD u_t026_000/r2_w1_wl
+ u_t002_006/c3_w1_bl u_t000_029/r2_w0_wl u_t025_015/c1_w1_bl u_t000_001/c1_r0_rbl
+ u_t014_000/r1_w1_wl u_t008_028/r0_w0_wl u_t004_019/c1_w0_bl u_t015_016/c3_w1_bl
+ a_25400_3000# u_t004_001/r3_w1_wl a_200_36600# u_t020_023/c1_w0_bl u_t031_020/c3_w1_bl
+ u_t016_010/c3_w1_bl u_t003_019/c0_w0_br a_22600_92600# u_t010_024/c3_w0_bl u_t003_016/c2_w1_bl
+ a_22600_19800# u_t017_029/c1_w0_bl u_t010_007/c1_w1_bl u_t018_023/c1_w0_bl u_t000_008/c3_w1_bl
+ u_t029_020/c3_w1_bl u_t011_001/c1_w1_bl u_t003_006/r2_w0_wl u_t008_024/c3_w0_bl
+ u_t001_005/c1_w0_br u_t023_017/c1_w1_bl u_t008_007/c1_w1_bl u_t013_018/c3_w1_bl
+ u_t024_011/c1_w1_bl u_t002_003/r3_w1_wl u_t009_001/c1_w1_bl u_t000_002/c2_w1_br
+ u_t003_015/c1_w0_bl u_t014_012/c3_w1_bl u_t000_002/r0_w1_wl u_t000_008/c1_r1_rbl
+ u_t003_026/c0_w1_br u_t002_011/c0_r0_rbl u_t000_007/c2_w0_bl u_t016_025/c1_w0_bl
+ u_t022_004/r2_w1_wl u_t027_022/c3_w1_bl u_t001_001/c2_w0_bl u_t006_026/c3_w0_bl
+ u_t003_013/r2_w1_wl u_t022_030/c3_w0_bl u_t006_009/c1_w1_bl u_t000_028/c2_r1_rbl
+ u_t010_004/r1_w1_wl u_t007_020/c3_w0_bl u_t007_027/r3_w0_wl u_t002_031/c1_r0_rbl
+ u_t022_013/c1_w1_bl u_t000_005/r3_w1_wl u_t007_003/c1_w1_bl u_t003_029/c3_w1_br
+ u_t001_017/c1_w0_bl u_t012_014/c3_w1_bl u_t000_015/c3_r1_rbl u_t003_022/c1_w1_bl
+ u_t021_030/r0_w0_wl u_t008_004/r1_w1_wl u_t030_005/r0_w1_wl u_t002_011/c1_w0_bl
+ u_t027_028/r2_w0_wl u_t000_017/c0_w0_br u_t023_019/c3_w0_bl u_t003_012/c3_w0_br
+ u_t014_027/c1_w0_bl u_t030_031/c1_w0_bl u_t001_011/c0_w0_br u_t004_028/c3_w0_bl
+ u_t003_004/c0_r0_rbl a_14200_42200# u_t021_000/r2_w1_wl u_t015_021/c1_w0_bl u_t015_028/r1_w0_wl
+ u_t028_005/r0_w1_wl u_t002_006/r3_r0_rwl a_200_101000# u_t009_031/r2_w0_wl u_t005_022/c3_w0_bl
+ u_t005_029/r3_w0_wl u_t003_023/r2_r0_rwl u_t020_015/c1_w1_bl u_t003_028/r0_w0_wl
+ u_t005_005/c1_w1_bl u_t028_031/c1_w0_bl u_t010_016/c3_w1_bl u_t027_007/c3_w1_bl
+ u_t000_013/c1_w0_bl u_t003_024/c1_r0_rbl u_t011_010/c3_w1_bl u_t031_002/r3_w1_wl
+ u_t018_015/c1_w1_bl u_t001_014/c3_w0_br u_t012_029/c1_w0_bl u_t007_000/r1_w1_wl
+ u_t001_008/c3_r1_rbl u_t008_016/c3_w1_bl u_t003_011/c2_r0_rbl u_t013_023/c1_w0_bl
+ u_t024_020/c3_w1_bl u_t009_010/c3_w1_bl u_t029_002/r3_w1_wl u_t003_024/c3_w0_bl
+ u_t003_007/c1_w1_bl u_t017_002/r2_w1_wl u_t002_024/c2_w0_br u_t004_001/c1_w1_bl
+ u_t000_027/c3_w1_br u_t025_009/c3_w1_bl u_t016_017/c1_w1_bl u_t000_020/c1_w1_bl
+ u_t030_016/c1_w0_bl u_t006_018/c3_w1_bl u_t000_010/c0_r0_rbl u_t017_011/c1_w1_bl
+ u_t022_022/c3_w1_bl u_t011_025/c1_w0_bl u_t007_012/c3_w1_bl u_t027_004/r3_w1_wl
+ u_t001_026/c3_w0_bl u_t002_011/VSS u_t028_016/c1_w0_bl u_t025_003/r0_w1_wl u_t002_011/VDD
+ u_t001_009/c1_w1_bl u_t003_018/c2_r1_rbl u_t002_027/r3_w0_wl u_t002_020/c3_w0_bl
+ u_t009_025/c1_w0_bl u_t000_026/c2_w0_br u_t015_004/r2_w1_wl u_t002_020/VSS u_t000_030/c1_r0_rbl
+ u_t002_003/c1_w1_bl u_t000_009/c0_w1_br u_t015_030/c3_w0_bl u_t003_004/r1_w1_wl
+ a_28200_200# u_t001_003/c0_w1_br u_t022_028/r2_w0_wl u_t015_013/c1_w1_bl u_t016_031/r3_w0_wl
+ u_t005_014/c3_w1_bl u_t003_030/c2_w0_bl u_t001_008/c0_w0_bl u_t026_018/c1_w0_bl
+ u_t010_028/r1_w0_wl u_t010_021/c1_w0_bl u_t001_003/c0_r0_rbl u_t002_009/c2_w0_br
+ u_t023_005/r0_w1_wl u_t031_029/c3_w0_bl u_t026_000/r3_w1_wl u_t016_019/c3_w0_bl
+ u_t002_030/c1_w0_br u_t000_022/c3_w0_bl u_t000_029/r3_w0_wl u_t002_002/c0_w0_bl
+ u_t007_027/c1_w0_bl u_t003_003/c2_w0_br u_t000_005/c1_w1_bl u_t023_031/c1_w0_bl
+ u_t001_006/c3_w1_br u_t014_000/r2_w1_wl u_t008_021/c1_w0_bl u_t008_028/r1_w0_wl
+ u_t030_029/r0_w0_wl u_t029_029/c3_w0_bl a_14200_106600# u_t022_007/c3_w1_bl u_t002_000/c3_w1_br
+ u_t013_015/c1_w1_bl u_t002_000/r1_w1_wl u_t003_016/c3_w1_bl u_t028_029/r0_w0_wl
+ u_t002_005/c3_w0_bl u_t001_010/c2_r0_rbl u_t000_024/c2_r1_rbl u_t004_010/c3_w1_bl
+ u_t024_002/r3_w1_wl u_t005_029/c1_w0_bl u_t025_014/c1_w0_bl a_200_45000# u_t030_025/c3_w0_bl
+ a_14200_22600# u_t003_010/c2_w1_br u_t006_023/c1_w0_bl u_t030_008/c1_w1_bl u_t017_020/c3_w1_bl
+ a_22600_28200# u_t020_009/c3_w1_bl u_t011_017/c1_w1_bl u_t031_002/c1_w1_bl u_t003_015/c2_w0_bl
+ u_t028_025/c3_w0_bl u_t001_018/c3_w1_bl u_t028_008/c1_w1_bl u_t012_011/c1_w1_bl
+ u_t002_002/r3_r0_rwl u_t002_015/c1_w0_br u_t018_009/c3_w1_bl u_t002_016/c1_r0_rbl
+ u_t002_012/c3_w1_bl u_t022_004/r3_w1_wl u_t029_002/c1_w1_bl u_t009_017/c1_w1_bl
+ u_t000_018/c2_w1_br u_t023_016/c1_w0_bl u_t002_001/c1_r1_rbl u_t020_003/r0_w1_wl
+ u_t000_011/c0_w1_bl u_t002_003/c2_r0_rbl u_t010_004/r2_w1_wl u_t004_025/c1_w0_bl
+ u_t015_022/c3_w1_bl u_t002_002/r3_w0_wl u_t003_031/VSS u_t000_001/c2_w0_br u_t004_029/VDD
+ u_t000_001/r0_w0_wl u_t003_025/c0_w0_br u_t026_027/c3_w0_bl u_t010_030/c3_w0_bl
+ u_t003_029/r2_w1_wl u_t008_004/r2_w1_wl u_t010_013/c1_w1_bl u_t030_005/r1_w1_wl
+ u_t027_021/c3_w0_bl u_t027_028/r3_w0_wl u_t002_023/c3_r0_rbl u_t000_014/c3_w1_bl
+ u_t003_008/r2_r0_rwl u_t025_027/r0_w0_wl u_t027_004/c1_w1_bl u_t003_012/r2_w0_wl
+ u_t021_018/c1_w0_bl u_t008_030/c3_w0_bl u_t019_030/r1_w0_wl u_t021_000/r3_w1_wl
+ u_t015_028/r2_w0_wl u_t008_013/c1_w1_bl u_t011_019/c3_w0_bl u_t028_005/r1_w1_wl
+ u_t009_031/r3_w0_wl u_t002_027/c1_w0_bl u_t003_028/c3_w0_br u_t007_030/r0_w0_wl
+ u_t019_018/c1_w0_bl u_t003_021/c1_w0_bl u_t003_028/r1_w0_wl u_t016_005/r0_w1_wl
+ u_t024_029/c3_w0_bl u_t009_019/c3_w0_bl u_t025_023/c3_w0_bl u_t016_031/c1_w0_bl
+ u_t025_006/c1_w1_bl u_t023_029/r0_w0_wl u_t030_017/c3_w1_bl u_t015_007/c3_w1_bl
+ u_t006_015/c1_w1_bl u_t000_029/c1_w0_bl u_t020_014/c1_w0_bl u_t031_011/c3_w1_bl
+ u_t027_001/r1_w1_wl u_t028_017/c3_w1_bl u_t001_023/c1_w0_bl u_t012_020/c3_w1_bl
+ u_t017_002/r3_w1_wl u_t018_014/c1_w0_bl u_t029_011/c3_w1_bl u_t002_007/c1_w1_br
+ u_t015_001/r0_w1_wl u_t023_025/c3_w0_bl u_t000_028/c0_r0_rbl u_t005_002/r2_w1_wl
+ u_t023_008/c1_w1_bl u_t000_013/c0_r1_rbl u_t013_009/c3_w1_bl u_t004_017/c1_w1_bl
+ u_t024_002/c1_w1_bl u_t000_015/c1_r0_rbl u_t003_006/c1_w0_bl u_t000_000/c1_r1_rbl
+ u_t005_011/c1_w1_bl u_t001_009/c2_w1_bl u_t003_017/c0_w1_br u_t026_019/c3_w1_bl
+ u_t010_022/c3_w1_bl u_t000_002/c2_r0_rbl u_t015_004/r3_w1_wl a_200_25400# u_t031_026/c1_w0_bl
+ u_t002_003/c2_w1_bl u_t016_016/c1_w0_bl u_t027_013/c3_w1_bl u_t021_027/c3_w0_bl
+ a_22600_81400# u_t003_004/r2_w1_wl u_t008_022/c3_w1_bl u_t026_030/r2_w0_wl u_t000_020/c2_r1_rbl
+ u_t022_021/c3_w0_bl u_t022_028/r3_w0_wl u_t029_026/c1_w0_bl u_t000_022/c3_r0_rbl
+ u_t022_004/c1_w1_bl u_t020_027/r0_w0_wl u_t019_027/c3_w0_bl u_t003_030/c3_w0_bl
+ u_t010_028/r2_w0_wl u_t003_013/c1_w1_bl u_t023_005/r1_w1_wl u_t004_031/r3_w0_wl
+ u_t001_008/c1_r0_rbl u_t018_027/r0_w0_wl u_t014_018/c1_w0_bl u_t025_015/c3_w1_bl
+ u_t002_025/c0_r0_rbl u_t011_005/r0_w1_wl u_t008_028/r2_w0_wl u_t030_022/c1_w0_bl
+ u_t001_002/c0_w0_br u_t004_019/c3_w0_bl u_t030_029/r1_w0_wl u_t002_010/c0_r1_rbl
+ u_t020_023/c3_w0_bl u_t002_018/c0_w0_bl u_t011_031/c1_w0_bl u_t027_028/c1_w0_bl
+ u_t002_000/r2_w1_wl u_t020_006/c1_w1_bl u_t009_005/r0_w1_wl u_t017_029/c3_w0_bl
+ u_t028_022/c1_w0_bl u_t028_029/r1_w0_wl u_t010_007/c3_w1_bl u_t001_015/c1_w1_bl
+ u_t018_023/c3_w0_bl u_t009_031/c1_w0_bl a_14200_115000# u_t000_004/c1_w0_bl u_t000_029/c3_r1_rbl
+ u_t016_029/r0_w0_wl u_t018_006/c1_w1_bl u_t001_005/c3_w0_br u_t023_017/c3_w1_bl
+ u_t001_000/c3_r1_rbl u_t012_002/r3_w1_wl u_t008_007/c3_w1_bl u_t013_014/c1_w0_bl
+ u_t001_003/VDD u_t024_011/c3_w1_bl u_t003_004/r2_r0_rwl u_t000_002/r2_w1_wl u_t003_018/c0_r0_rbl
+ u_t005_020/c3_w1_bl u_t003_026/c2_w1_br u_t001_012/VDD a_14200_31000# u_t026_024/c1_w0_bl
+ u_t003_003/c0_r1_rbl u_t008_001/r0_w1_wl u_t016_025/c3_w0_bl gf180mcu_as_sc_mcu7t3v3__inv_2_1106/A
+ u_t031_018/c1_w1_bl u_t016_008/c1_w1_bl u_t020_003/r1_w1_wl u_t000_011/c1_w1_bl
+ u_t021_019/c3_w1_bl u_t001_012/c3_w1_br u_t006_009/c3_w1_bl u_t010_004/r3_w1_wl
+ u_t017_002/c1_w1_bl u_t011_016/c1_w0_bl u_t002_008/c3_r0_rbl u_t022_013/c3_w1_bl
+ u_t003_023/c1_r1_rbl u_t029_018/c1_w1_bl u_t018_003/r1_w1_wl u_t003_025/c2_r0_rbl
+ u_t019_019/c3_w1_bl u_t003_022/c3_w1_bl u_t008_004/r3_w1_wl u_t003_010/c2_r1_rbl
+ u_t030_005/r2_w1_wl u_t024_026/c1_w0_bl u_t002_011/c3_w0_bl u_t009_016/c1_w0_bl
+ u_t000_017/c2_w0_br u_t014_027/c3_w0_bl u_t000_010/c0_w0_bl u_t025_020/c1_w0_bl
+ u_t025_027/r1_w0_wl u_t030_031/c3_w0_bl u_t001_011/c2_w0_br u_t019_030/r2_w0_wl
+ u_t015_028/r3_w0_wl u_t015_021/c3_w0_bl u_t028_005/r2_w1_wl u_t030_014/c1_w1_bl
+ u_t015_004/c1_w1_bl u_t013_027/r0_w0_wl u_t003_030/c3_r1_rbl u_t020_015/c3_w1_bl
+ u_t007_030/r1_w0_wl u_t003_028/r2_w0_wl u_t028_031/c3_w0_bl u_t016_005/r1_w1_wl
+ u_t028_014/c1_w1_bl u_t022_028/c1_w0_bl u_t000_013/c3_w0_bl a_22600_61800# u_t002_021/c1_w0_br
+ u_t018_015/c3_w1_bl u_t007_018/c1_w0_bl u_t012_029/c3_w0_bl u_t000_024/c2_w1_br
+ u_t004_005/r0_w1_wl u_t023_029/r1_w0_wl u_t023_022/c1_w0_bl u_t013_023/c3_w0_bl
+ u_t004_031/c1_w0_bl u_t013_006/c1_w1_bl u_t011_029/r0_w0_wl u_t027_001/r2_w1_wl
+ u_t003_007/c3_w1_bl u_t026_016/c1_w1_bl u_t015_001/r1_w1_wl u_t000_023/c1_w0_br
+ u_t009_029/r0_w0_wl u_t016_017/c3_w1_bl u_t000_020/c3_w1_bl u_t027_010/c1_w1_bl
+ u_t005_002/r3_w1_wl u_t021_024/c1_w0_bl u_t003_001/c2_w1_br u_t006_014/c1_w0_bl
+ u_t017_011/c3_w1_bl u_t003_001/r0_w1_wl u_t011_025/c3_w0_bl u_t011_008/c1_w1_bl
+ u_t019_024/c1_w0_bl u_t001_009/c3_w1_bl u_t012_002/c1_w1_bl u_t000_005/c2_r1_rbl
+ u_t009_025/c3_w0_bl u_t002_006/c1_w0_br u_t024_018/c1_w1_bl u_t000_007/c3_r0_rbl
+ u_t009_008/c1_w1_bl u_t000_009/c2_w1_br u_t014_019/c3_w1_bl u_t000_030/c1_w1_br
+ u_t003_000/c1_w0_br u_t000_002/c0_w1_bl u_t025_012/c1_w1_bl u_t003_004/r3_w1_wl
+ u_t026_030/r3_w0_wl u_t001_003/c2_w1_br u_t030_023/c3_w1_bl u_t004_016/c1_w0_bl
+ u_t015_013/c3_w1_bl u_t020_020/c1_w0_bl u_t020_027/r1_w0_wl a_14200_11400# u_t014_030/r2_w0_wl
+ u_t001_008/c2_w0_bl u_t010_021/c3_w0_bl u_t010_028/r3_w0_wl u_t017_026/c1_w0_bl
+ u_t023_005/r2_w1_wl u_t028_023/c3_w1_bl a_22600_17000# u_t010_004/c1_w1_bl u_t002_002/c2_w0_bl
+ u_t007_027/c3_w0_bl u_t002_030/r1_w0_wl u_t003_000/r2_r0_rwl u_t018_020/c1_w0_bl
+ u_t018_027/r1_w0_wl u_t000_005/c3_w1_bl u_t002_013/c1_w1_br u_t023_031/c3_w0_bl
+ u_t011_005/r1_w1_wl u_t003_003/r2_w0_wl u_t008_021/c3_w0_bl u_t008_028/r3_w0_wl
+ u_t030_029/r2_w0_wl u_t003_029/c1_w1_bl u_t023_014/c1_w1_bl u_t008_004/c1_w1_bl
+ u_t006_027/r0_w0_wl u_t002_018/c1_w0_bl u_t013_015/c3_w1_bl u_t003_001/c1_r0_rbl
+ u_t002_015/c1_r1_rbl u_t002_000/r3_w1_wl u_t009_005/r1_w1_wl u_t002_017/c2_r0_rbl
+ u_t003_012/c1_w0_bl u_t028_029/r2_w0_wl u_t001_015/c2_w1_bl u_t002_002/c2_r1_rbl
+ u_t015_028/c1_w0_bl u_t002_012/c0_w0_br u_t005_029/c3_w0_bl gf180mcu_as_sc_mcu7t3v3__inv_2_574/A
+ u_t022_001/r2_w1_wl u_t016_022/c1_w0_bl u_t016_029/r1_w0_wl a_22600_8600# u_t000_015/c1_w1_br
+ u_t006_023/c3_w0_bl u_t030_008/c3_w1_bl u_t003_010/r2_w1_wl u_t021_016/c1_w1_bl
+ a_200_109400# u_t010_001/r1_w1_wl u_t004_029/r0_w0_wl u_t006_006/c1_w1_bl u_t011_017/c3_w1_bl
+ u_t022_010/c1_w1_bl u_t000_002/r3_w1_wl u_t028_008/c3_w1_bl u_t001_014/c1_w0_bl
+ u_t012_011/c3_w1_bl u_t019_016/c1_w1_bl u_t009_017/c3_w1_bl u_t003_008/c1_r1_rbl
+ u_t014_024/c1_w0_bl u_t025_021/c3_w1_bl u_t000_020/c0_r0_rbl u_t004_025/c3_w0_bl
+ u_t028_002/r0_w1_wl u_t004_008/c1_w1_bl u_t002_024/c0_w0_bl u_t018_003/r2_w1_wl
+ u_t003_025/c2_w0_br u_t000_027/c1_w1_bl u_t020_012/c1_w1_bl u_t021_030/r3_w0_wl
+ u_t005_002/c1_w1_bl u_t010_013/c3_w1_bl u_t030_005/r3_w1_wl u_t017_018/c1_w1_bl
+ u_t031_017/c1_w0_bl u_t006_003/r1_w1_wl u_t003_015/c3_r1_rbl u_t007_019/c3_w1_bl
+ u_t025_027/r2_w0_wl u_t018_012/c1_w1_bl u_t023_023/c3_w1_bl u_t012_026/c1_w0_bl
+ u_t008_013/c3_w1_bl u_t028_005/r3_w1_wl u_t002_027/c3_w0_bl u_t029_017/c1_w0_bl
+ u_t013_027/r1_w0_wl u_t013_020/c1_w0_bl u_t026_004/r0_w1_wl u_t000_026/c0_w0_bl
+ u_t003_028/r3_w0_wl u_t003_021/c3_w0_bl u_t000_027/c0_r1_rbl u_t016_005/r2_w1_wl
+ u_t003_004/c1_w1_bl u_t001_027/r0_w0_wl u_t026_030/c1_w0_bl u_t000_029/c1_r0_rbl
+ u_t001_000/c1_r0_rbl u_t003_026/VSS u_t016_031/c3_w0_bl u_t000_014/c1_r1_rbl u_t004_005/r1_w1_wl
+ u_t027_031/r1_w0_wl u_t002_004/c0_w1_br u_t004_026/VDD u_t025_006/c3_w1_bl u_t023_029/r2_w0_wl
+ u_t016_014/c1_w1_bl u_t010_028/c1_w0_bl u_t006_015/c3_w1_bl a_200_14200# u_t000_004/VDD
+ u_t000_029/c3_w0_bl u_t002_009/c0_w0_bl u_t011_029/r1_w0_wl u_t027_019/c1_w0_bl
+ u_t011_022/c1_w0_bl a_22600_70200# u_t001_023/c3_w0_bl u_t003_003/c0_w0_bl u_t000_013/VDD
+ u_t008_028/c1_w0_bl u_t025_000/r0_w1_wl u_t001_006/c1_w1_bl u_t002_007/c3_w1_br
+ u_t009_022/c1_w0_bl u_t009_029/r1_w0_wl u_t000_021/c3_r1_rbl u_t023_008/c3_w1_bl
+ u_t014_016/c1_w1_bl u_t003_001/r1_w1_wl u_t004_017/c3_w1_bl u_t015_010/c1_w1_bl
+ u_t001_007/c1_r1_rbl u_t003_006/c3_w0_bl u_t020_021/c3_w1_bl u_t003_010/c0_r0_rbl
+ u_t001_009/c2_r0_rbl u_t025_003/r3_w1_wl u_t005_011/c3_w1_bl u_t002_012/r3_r0_rwl
+ u_t003_017/c2_w1_br u_t026_015/c1_w0_bl u_t003_010/c0_w1_bl u_t031_026/c3_w0_bl
+ u_t013_003/r2_w1_wl u_t007_024/c1_w0_bl u_t018_021/c3_w1_bl u_t031_009/c1_w1_bl
+ u_t000_002/c1_w1_bl u_t012_018/c1_w1_bl u_t003_030/c1_r0_rbl u_t029_026/c3_w0_bl
+ u_t002_000/c3_r0_rbl u_t002_019/c3_w1_bl u_t001_014/c3_r1_rbl u_t020_027/r2_w0_wl
+ u_t029_009/c1_w1_bl u_t013_012/c1_w1_bl u_t000_018/c0_w1_bl u_t003_013/c3_w1_bl
+ u_t023_005/r3_w1_wl u_t024_017/c1_w0_bl u_t003_018/r2_r0_rwl u_t002_009/r3_w0_wl
+ u_t021_004/r0_w1_wl u_t000_008/c2_w0_br u_t018_027/r2_w0_wl u_t002_030/r2_w0_wl
+ u_t005_026/c1_w0_bl u_t000_001/c0_w0_bl u_t011_005/r2_w1_wl u_t016_023/c3_w1_bl
+ u_t030_022/c3_w0_bl u_t001_002/c2_w0_br u_t030_029/r3_w0_wl u_t021_030/c1_w0_bl
+ u_t006_020/c1_w0_bl u_t006_027/r1_w0_wl u_t030_005/c1_w1_bl u_t019_004/r0_w1_wl
+ u_t027_028/c3_w0_bl u_t011_031/c3_w0_bl u_t020_006/c3_w1_bl u_t009_005/r2_w1_wl
+ u_t011_014/c1_w1_bl u_t003_019/r2_w0_wl u_t028_022/c3_w0_bl u_t028_029/r3_w0_wl
+ u_t019_030/c1_w0_bl u_t001_015/c3_w1_bl u_t003_023/c1_w1_br u_t026_028/r0_w0_wl
+ u_t028_005/c1_w1_bl u_t009_031/c3_w0_bl u_t022_019/c1_w0_bl u_t000_004/c3_w0_bl
+ u_t002_007/c3_r1_rbl u_t022_001/r3_w1_wl u_t018_006/c3_w1_bl u_t016_029/r2_w0_wl
+ u_t009_014/c1_w1_bl u_t003_028/c1_w0_bl u_t020_000/r0_w1_wl u_t008_031/r0_w0_wl
+ u_t010_001/r2_w1_wl u_t004_022/c1_w0_bl u_t004_029/r1_w0_wl u_t000_005/c0_r0_rbl
+ u_t026_024/c3_w0_bl u_t003_026/r2_w1_wl a_14200_59000# u_t026_007/c1_w1_bl u_t010_010/c1_w1_bl
+ u_t031_018/c3_w1_bl u_t000_014/c1_w0_br u_t016_008/c3_w1_bl u_t020_003/r3_w1_wl
+ u_t000_011/c3_w1_bl u_t007_016/c1_w1_bl u_t027_001/c1_w1_bl u_t000_023/c0_r1_rbl
+ u_t021_015/c1_w0_bl u_t008_010/c1_w1_bl u_t028_002/r1_w1_wl a_22600_50600# u_t029_018/c3_w1_bl
+ u_t002_024/c1_w0_bl u_t013_021/c3_w1_bl u_t000_012/c2_r0_rbl u_t019_015/c1_w0_bl
+ u_t003_008/c1_w1_br u_t016_002/r0_w1_wl u_t024_026/c3_w0_bl a_200_8600# u_t006_003/r2_w1_wl
+ u_t024_009/c1_w1_bl u_t000_010/c2_w0_bl u_t025_027/r3_w0_wl u_t025_020/c3_w0_bl
+ u_t000_021/c1_w1_br u_t005_018/c1_w1_bl u_t000_030/c2_r1_rbl u_t025_003/c1_w1_bl
+ u_t030_014/c3_w1_bl u_t013_027/r2_w0_wl u_t006_012/c1_w1_bl u_t026_004/r1_w1_wl
+ u_t011_023/c3_w1_bl u_t000_026/c1_w0_bl u_t016_005/r3_w1_wl u_t017_017/c1_w0_bl
+ u_t001_027/r1_w0_wl u_t028_014/c3_w1_bl u_t001_020/c1_w0_bl u_t014_004/r0_w1_wl
+ u_t022_028/c3_w0_bl u_t002_021/c3_w0_br u_t004_005/r2_w1_wl a_22600_89800# u_t009_023/c3_w1_bl
+ u_t027_031/r2_w0_wl u_t023_029/r3_w0_wl u_t023_022/c3_w0_bl u_t014_030/c1_w0_bl
+ u_t000_019/c2_r1_rbl u_t023_005/c1_w1_bl u_t002_022/c1_r0_rbl u_t021_028/r0_w0_wl
+ u_t004_031/c3_w0_bl u_t015_031/r1_w0_wl u_t013_006/c3_w1_bl u_t011_029/r2_w0_wl
+ u_t000_006/c3_r1_rbl u_t004_014/c1_w1_bl u_t003_031/c2_w0_br u_t001_009/c0_w0_br
+ u_t030_029/c1_w0_bl u_t019_028/r0_w0_wl u_t003_031/r0_w0_wl u_t015_019/c1_w0_bl
+ u_t026_016/c3_w1_bl u_t009_029/r2_w0_wl u_t002_003/c0_w0_br u_t031_023/c1_w0_bl
+ u_t002_000/c2_w1_bl u_t027_010/c3_w1_bl u_t000_006/c1_w1_br u_t021_024/c3_w0_bl
+ gf180mcu_as_sc_mcu7t3v3__inv_2_1678/Y u_t028_029/c1_w0_bl u_t003_001/r2_w1_wl u_t021_007/c1_w1_bl
+ u_t003_014/r2_r0_rwl u_t001_000/c1_w1_br u_t003_028/c0_r0_rbl u_t029_023/c1_w0_bl
+ u_t011_008/c3_w1_bl u_t022_001/c1_w1_bl u_t002_016/c1_w1_bl u_t003_013/c0_r1_rbl
+ u_t019_024/c3_w0_bl m4_174688_119400# u_t001_005/c1_w0_bl u_t003_015/c1_r0_rbl u_t023_002/r1_w1_wl
+ u_t003_010/c1_w1_bl u_t019_007/c1_w1_bl u_t002_006/c3_w0_br u_t024_018/c3_w1_bl
+ u_t003_000/c1_r1_rbl u_t013_003/r3_w1_wl u_t009_008/c3_w1_bl u_t000_030/c3_w1_br
+ u_t003_002/c2_r0_rbl u_t014_015/c1_w0_bl u_t000_002/c2_w1_bl u_t002_010/c0_w1_br
+ u_t025_012/c3_w1_bl u_t011_002/r0_w1_wl u_t003_026/c0_w1_bl u_t001_003/r2_w1_wl
+ u_t006_021/c3_w1_bl u_t020_020/c3_w0_bl u_t020_027/r3_w0_wl u_t027_025/c1_w0_bl
+ u_t002_018/VSS u_t003_016/c2_w0_br u_t020_003/c1_w1_bl u_t000_018/c1_w1_bl u_t003_020/c2_r1_rbl
+ a_14200_39400# u_t017_026/c3_w0_bl u_t003_022/c3_r0_rbl u_t017_009/c1_w1_bl u_t001_012/c1_w1_bl
+ u_t021_004/r1_w1_wl u_t002_027/VSS u_t018_020/c3_w0_bl u_t018_027/r3_w0_wl u_t002_013/c3_w1_br
+ u_t011_005/r3_w1_wl u_t018_003/c1_w1_bl u_t012_017/c1_w0_bl u_t000_012/c0_w1_br
+ u_t003_029/c3_w1_bl u_t023_014/c3_w1_bl u_t006_027/r2_w0_wl u_t002_018/c3_w0_bl
+ u_t019_004/r1_w1_wl u_t004_023/c3_w1_bl u_t022_031/r2_w0_wl u_t009_005/r3_w1_wl
+ u_t000_017/c0_w0_bl u_t025_027/c1_w0_bl u_t003_012/c3_w0_bl u_t007_004/r0_w1_wl
+ u_t015_028/c3_w0_bl u_t000_021/c1_r0_rbl u_t026_021/c1_w0_bl u_t026_028/r1_w0_wl
+ u_t010_031/r1_w0_wl u_t016_022/c3_w0_bl u_t016_029/r3_w0_wl u_t000_015/c3_w1_br
+ u_t007_030/c1_w0_bl u_t031_015/c1_w1_bl u_t020_000/r1_w1_wl u_t016_005/c1_w1_bl
+ u_t014_028/r0_w0_wl u_t021_016/c3_w1_bl u_t010_019/c1_w0_bl u_t003_029/c3_r1_rbl
+ u_t006_006/c3_w1_bl u_t004_029/r2_w0_wl u_t002_028/c1_w0_br u_t022_010/c3_w1_bl
+ u_t029_015/c1_w1_bl u_t023_029/c1_w0_bl u_t018_000/r1_w1_wl u_t003_022/c1_w0_br
+ u_t000_024/c0_w1_bl u_t019_016/c3_w1_bl u_t008_019/c1_w0_bl u_t008_001/r3_w1_wl
+ u_t030_002/r2_w1_wl u_t024_023/c1_w0_bl u_t002_015/r3_w0_wl u_t014_024/c3_w0_bl
+ u_t001_012/c0_r1_rbl u_t014_007/c1_w1_bl u_t001_014/c1_r0_rbl u_t004_008/c3_w1_bl
+ u_t030_011/c1_w1_bl u_t002_024/c2_w0_bl u_t015_001/c1_w1_bl u_t000_027/c3_w1_bl
+ u_t020_012/c3_w1_bl u_t027_017/c1_w1_bl u_t003_025/r2_w0_wl u_t017_018/c3_w1_bl
+ u_t001_021/c3_w1_bl u_t003_001/c0_w1_bl u_t028_011/c1_w1_bl u_t022_025/c1_w0_bl
+ u_t007_015/c1_w0_bl u_t018_012/c3_w1_bl u_t004_002/r0_w1_wl u_t012_026/c3_w0_bl
+ u_t012_009/c1_w1_bl u_t013_027/r3_w0_wl u_t013_020/c3_w0_bl u_t026_004/r2_w1_wl
+ u_t013_003/c1_w1_bl u_t002_005/c0_r1_rbl u_t003_007/c1_w0_br u_t000_009/c0_w1_bl
+ u_t003_004/c3_w1_bl u_t001_027/r2_w0_wl u_t002_007/c1_r0_rbl u_t026_030/c3_w0_bl
+ u_t014_004/r1_w1_wl u_t003_010/r2_r0_rwl u_t001_003/c0_w1_bl u_t026_013/c1_w1_bl
+ u_t004_005/r3_w1_wl u_t020_027/c1_w0_bl u_t002_004/c2_w1_br u_t000_020/c1_w0_br
+ u_t005_017/c1_w0_bl u_t016_014/c3_w1_bl a_28200_120600# u_t002_004/r0_w1_wl u_t010_028/c3_w0_bl
+ u_t025_030/r0_w0_wl u_t021_021/c1_w0_bl u_t021_028/r1_w0_wl u_t015_031/r2_w0_wl
+ u_t002_009/c2_w0_bl u_t027_019/c3_w0_bl u_t011_022/c3_w0_bl u_t002_027/c2_r0_rbl
+ u_t011_029/r3_w0_wl a_14200_92600# u_t018_027/c1_w0_bl u_t002_030/c1_w0_bl a_14200_19800#
+ u_t011_005/c1_w1_bl u_t002_012/c2_r1_rbl a_22600_98200# u_t008_028/c3_w0_bl u_t003_031/r1_w0_wl
+ u_t019_021/c1_w0_bl u_t019_028/r1_w0_wl u_t001_006/c3_w1_bl u_t002_014/c3_r0_rbl
+ u_t003_014/c1_w1_br u_t003_005/VSS u_t009_022/c3_w0_bl u_t009_029/r3_w0_wl u_t004_005/VDD
+ u_t024_015/c1_w1_bl u_t002_007/r3_w1_wl u_t009_005/c1_w1_bl u_t007_028/r0_w0_wl
+ u_t003_019/c1_w0_bl u_t014_016/c3_w1_bl u_t003_001/r3_w1_wl u_t004_014/VDD u_t030_020/c3_w1_bl
+ u_t015_010/c3_w1_bl u_t002_019/c0_w0_br u_t016_029/c1_w0_bl u_t003_017/r2_w1_wl
+ u_t023_002/r2_w1_wl u_t017_023/c1_w0_bl u_t003_010/c2_w1_bl u_t028_020/c3_w1_bl
+ u_t010_001/c1_w1_bl u_t007_024/c3_w0_bl u_t000_030/c0_r0_rbl u_t031_009/c3_w1_bl
+ u_t000_005/c1_w0_br u_t022_017/c1_w1_bl u_t003_005/c2_r1_rbl u_t011_002/r1_w1_wl
+ u_t007_007/c1_w1_bl u_t003_000/r2_w0_wl u_t012_018/c3_w1_bl u_t003_007/c3_r0_rbl
+ u_t023_011/c1_w1_bl u_t008_001/c1_w1_bl gf180mcu_as_sc_mcu7t3v3__inv_2_635/Y u_t029_009/c3_w1_bl
+ u_t002_015/c1_w0_bl u_t013_012/c3_w1_bl u_t000_018/c2_w1_bl u_t021_004/r2_w1_wl
+ u_t015_025/c1_w0_bl u_t026_022/c3_w1_bl u_t000_019/c0_r0_rbl u_t000_001/c2_w0_bl
+ u_t005_026/c3_w0_bl u_t000_004/c0_r1_rbl u_t029_003/r0_w1_wl u_t021_030/c3_w0_bl
+ u_t005_009/c1_w1_bl u_t003_025/c0_w0_bl u_t000_006/c1_r0_rbl u_t006_020/c3_w0_bl
+ u_t006_027/r3_w0_wl u_t019_004/r2_w1_wl u_t021_013/c1_w1_bl u_t006_003/c1_w1_bl
+ u_t022_031/r3_w0_wl u_t000_017/c1_w0_bl u_t011_014/c3_w1_bl u_t020_030/r0_w0_wl
+ u_t019_030/c3_w0_bl u_t007_004/r1_w1_wl u_t001_011/c1_w0_bl u_t010_031/r2_w0_wl
+ u_t000_024/c1_r1_rbl u_t026_028/r2_w0_wl u_t019_013/c1_w1_bl u_t022_019/c3_w0_bl
+ u_t002_012/c3_w0_br u_t013_027/c1_w0_bl u_t000_026/c2_r0_rbl u_t009_014/c3_w1_bl
+ u_t000_011/c0_w0_br u_t003_028/c3_w0_bl u_t000_011/c2_r1_rbl u_t014_021/c1_w0_bl
+ u_t014_028/r1_w0_wl u_t027_005/r0_w1_wl m4_169458_119400# u_t000_013/c3_r0_rbl u_t004_029/r3_w0_wl
+ u_t004_022/c3_w0_bl u_t004_005/c1_w1_bl u_t002_028/r0_w0_wl u_t027_031/c1_w0_bl
+ u_t018_000/r2_w1_wl u_t026_007/c3_w1_bl u_t030_002/r3_w1_wl u_t010_010/c3_w1_bl
+ u_t017_015/c1_w1_bl u_t000_014/c3_w0_br u_t011_029/c1_w0_bl u_t031_014/c1_w0_bl
+ u_t006_000/r1_w1_wl u_t007_016/c3_w1_bl a_200_95400# u_t012_023/c1_w0_bl u_t023_020/c3_w1_bl
+ u_t008_010/c3_w1_bl u_t002_024/c3_w0_bl u_t003_020/c0_r0_rbl u_t009_029/c1_w0_bl
+ u_t029_014/c1_w0_bl a_22600_78600# u_t002_007/c1_w1_bl u_t000_023/c0_w0_bl u_t001_004/c2_r1_rbl
+ u_t001_006/c3_r0_rbl u_t003_001/c1_w1_bl u_t024_009/c3_w1_bl u_t015_017/c1_w1_bl
+ u_t000_021/c3_w1_br u_t005_018/c3_w1_bl u_t016_011/c1_w1_bl u_t010_025/c1_w0_bl
+ u_t021_022/c3_w1_bl u_t003_017/c0_w1_bl u_t006_012/c3_w1_bl u_t026_004/r3_w1_wl
+ u_t000_026/c3_w0_bl u_t027_016/c1_w0_bl u_t024_003/r0_w1_wl u_t000_009/c1_w1_bl
+ u_t003_028/r2_r0_rwl u_t001_027/r3_w0_wl u_t001_020/c3_w0_bl u_t008_025/c1_w0_bl
+ u_t003_000/c0_w0_bl u_t014_004/r2_w1_wl u_t019_022/c3_w1_bl u_t001_003/c1_w1_bl
+ u_t003_027/c0_r1_rbl u_t031_027/r0_w0_wl u_t003_029/c1_r0_rbl u_t014_030/c3_w0_bl
+ u_t002_004/r1_w1_wl u_t000_003/c0_w1_br u_t021_028/r2_w0_wl u_t003_014/c1_r1_rbl
+ u_t014_013/c1_w1_bl u_t004_014/c3_w1_bl u_t002_030/c2_w0_bl u_t029_027/r0_w0_wl
+ u_t013_030/r0_w0_wl u_t000_008/c0_w0_bl u_t025_018/c1_w0_bl u_t003_003/c3_w0_bl
+ u_t001_009/c2_w0_br u_t022_005/r0_w1_wl u_t030_029/c3_w0_bl u_t025_000/r3_w1_wl
+ u_t019_028/r2_w0_wl u_t003_031/r2_w0_wl u_t015_019/c3_w0_bl u_t001_002/c0_w0_bl
+ u_t006_027/c1_w0_bl u_t002_003/c2_w0_br u_t031_023/c3_w0_bl u_t022_031/c1_w0_bl
+ gf180mcu_as_sc_mcu7t3v3__inv_2_361/Y u_t000_006/c3_w1_br u_t013_000/r2_w1_wl u_t007_021/c1_w0_bl
+ u_t007_028/r1_w0_wl u_t031_006/c1_w1_bl a_14200_28200# u_t028_029/c3_w0_bl u_t021_007/c3_w1_bl
+ u_t003_021/c3_r1_rbl u_t001_000/c3_w1_br u_t012_015/c1_w1_bl u_t029_023/c3_w0_bl
+ u_t002_016/c3_w1_bl u_t027_029/r0_w0_wl u_t029_006/c1_w1_bl u_t001_005/c3_w0_bl
+ u_t003_013/c1_w0_br u_t019_007/c3_w1_bl u_t003_010/c3_w1_bl u_t004_029/c1_w0_bl
+ u_t024_014/c1_w0_bl u_t002_006/r3_w0_wl u_t021_001/r0_w1_wl u_t002_010/c2_w1_br
+ u_t000_005/r0_w0_wl u_t005_023/c1_w0_bl u_t016_020/c3_w1_bl u_t010_017/c1_w1_bl
+ u_t030_002/c1_w1_bl u_t002_015/c2_w0_bl u_t027_025/c3_w0_bl u_t000_018/c3_w1_bl
+ u_t009_002/r2_w1_wl u_t027_008/c1_w1_bl u_t011_011/c1_w1_bl u_t031_003/r1_w1_wl
+ u_t003_016/r2_w0_wl u_t001_015/c1_w0_br u_t017_009/c3_w1_bl u_t001_012/c3_w1_bl
+ u_t003_020/c1_w1_br u_t021_004/r3_w1_wl u_t028_002/c1_w1_bl u_t008_017/c1_w1_bl
+ u_t022_016/c1_w0_bl a_200_75800# a_22600_103800# u_t002_013/r3_w1_wl u_t009_011/c1_w1_bl
+ u_t014_022/c3_w1_bl u_t003_025/c1_w0_bl u_t000_009/c1_r1_rbl u_t019_004/r3_w1_wl
+ u_t002_012/c0_r0_rbl u_t002_025/c0_w0_br u_t017_003/r0_w1_wl u_t000_017/c2_w0_bl
+ u_t025_027/c3_w0_bl u_t020_030/r1_w0_wl u_t000_028/c1_w1_br u_t007_004/r2_w1_wl
+ u_t026_028/r3_w0_wl u_t026_021/c3_w0_bl u_t003_023/r2_w1_wl u_t002_006/VDD u_t026_004/c1_w1_bl
+ u_t000_029/c2_r1_rbl u_t024_027/r0_w0_wl u_t020_018/c1_w0_bl u_t007_030/c3_w0_bl
+ u_t031_015/c3_w1_bl u_t020_000/r3_w1_wl u_t014_028/r2_w0_wl u_t007_013/c1_w1_bl
+ u_t010_019/c3_w0_bl u_t027_005/r1_w1_wl u_t008_031/r3_w0_wl u_t001_027/c1_w0_bl
+ u_t000_016/c3_r1_rbl u_t002_028/c3_w0_br u_t018_018/c1_w0_bl u_t029_015/c3_w1_bl
+ u_t002_028/r1_w0_wl u_t002_021/c1_w0_bl u_t023_029/c3_w0_bl u_t000_027/c0_w0_br
+ u_t015_005/r0_w1_wl u_t003_022/c3_w0_br u_t000_024/c2_w1_bl u_t008_019/c3_w0_bl
+ u_t003_005/c1_w1_br u_t024_023/c3_w0_bl u_t003_005/c0_r0_rbl u_t015_031/c1_w0_bl
+ u_t006_000/r2_w1_wl u_t002_007/r3_r0_rwl u_t024_006/c1_w1_bl u_t022_029/r0_w0_wl
+ u_t003_024/r2_r0_rwl u_t014_007/c3_w1_bl m4_179918_119400# u_t005_015/c1_w1_bl u_t002_006/c1_r1_rbl
+ u_t003_031/c0_w0_bl u_t030_011/c3_w1_bl u_t027_017/c3_w1_bl u_t000_023/c1_w0_bl
+ u_t011_020/c3_w1_bl u_t016_002/r3_w1_wl u_t003_004/c0_w0_br u_t003_001/c2_w1_bl
+ u_t003_008/r2_w1_wl u_t017_014/c1_w0_bl u_t028_011/c3_w1_bl u_t001_007/c1_w1_br
+ u_t003_012/c2_r0_rbl u_t022_025/c3_w0_bl a_14200_81400# u_t022_008/c1_w1_bl u_t009_020/c3_w1_bl
+ u_t002_028/c3_r0_rbl a_22600_87000# u_t012_009/c3_w1_bl u_t002_013/c3_r1_rbl u_t023_002/c1_w1_bl
+ u_t003_017/c1_w1_bl u_t002_006/c1_w0_bl u_t024_003/r1_w1_wl u_t004_011/c1_w1_bl
+ u_t003_007/c3_w0_br u_t000_009/c2_w1_bl u_t025_019/c3_w1_bl u_t014_004/r3_w1_wl
+ u_t030_026/c1_w0_bl u_t015_016/c1_w0_bl u_t001_003/c2_w1_bl u_t003_011/c0_w1_br
+ u_t026_013/c3_w1_bl u_t000_011/c0_r0_rbl u_t012_003/r0_w1_wl u_t020_027/c3_w0_bl
+ u_t000_020/c3_w0_br u_t031_020/c1_w0_bl u_t031_027/r1_w0_wl u_t002_004/r2_w1_wl
+ u_t007_022/c3_w1_bl u_t021_021/c3_w0_bl u_t021_028/r3_w0_wl u_t028_026/c1_w0_bl
+ u_t003_016/c0_w0_bl u_t021_004/c1_w1_bl u_t003_019/c2_r1_rbl u_t018_027/c3_w0_bl
+ u_t002_030/c3_w0_bl u_t029_020/c1_w0_bl u_t029_027/r1_w0_wl u_t000_031/c1_r0_rbl
+ u_t002_013/c1_w1_bl u_t022_005/r1_w1_wl u_t000_019/c0_w1_br u_t019_021/c3_w0_bl
+ u_t019_028/r3_w0_wl u_t003_014/c3_w1_br u_t003_006/c3_r1_rbl u_t019_004/c1_w1_bl
+ u_t017_027/r0_w0_wl u_t013_018/c1_w0_bl u_t024_015/c3_w1_bl u_t010_005/r0_w1_wl
+ u_t013_000/r3_w1_wl u_t007_028/r2_w0_wl u_t000_002/c0_w0_br u_t003_019/c3_w0_bl
+ u_t010_031/c1_w0_bl u_t026_028/c1_w0_bl u_t003_023/c0_w1_bl u_t001_004/c0_r0_rbl
+ u_t001_000/r2_w1_wl u_t000_018/c0_r1_rbl u_t008_005/r0_w1_wl u_t016_029/c3_w0_bl
+ u_t027_022/c1_w0_bl u_t027_029/r1_w0_wl u_t000_015/c1_w1_bl u_t017_023/c3_w0_bl
+ u_t008_031/c1_w0_bl u_t015_029/r0_w0_wl u_t017_006/c1_w1_bl u_t000_005/c3_w0_br
+ u_t022_017/c3_w1_bl u_t000_029/VDD u_t007_007/c3_w1_bl u_t000_005/r1_w0_wl u_t003_029/c1_w0_br
+ u_t003_026/c3_w1_bl u_t012_014/c1_w0_bl u_t023_011/c3_w1_bl u_t019_001/r1_w1_wl
+ u_t001_011/c2_r0_rbl u_t003_002/VSS u_t000_025/c2_r1_rbl u_t004_020/c3_w1_bl u_t009_002/r3_w1_wl
+ u_t031_003/r2_w1_wl u_t025_024/c1_w0_bl u_t003_011/VSS u_t007_001/r0_w1_wl u_t015_025/c3_w0_bl
+ u_t004_011/VDD u_t030_018/c1_w1_bl u_t015_008/c1_w1_bl u_t020_019/c3_w1_bl u_t003_020/VSS
+ u_t000_012/c3_w1_br u_t005_009/c3_w1_bl u_t031_012/c1_w1_bl u_t003_025/c2_w0_bl
+ u_t004_020/VDD u_t016_002/c1_w1_bl u_t010_016/c1_w0_bl u_t021_013/c3_w1_bl u_t003_008/c0_w1_bl
+ u_t028_018/c1_w1_bl u_t002_003/r3_r0_rwl u_t018_019/c3_w1_bl u_t002_022/c3_w1_bl
+ u_t003_020/r2_r0_rwl u_t029_012/c1_w1_bl u_t007_004/r3_w1_wl a_200_84200# a_22600_112200#
+ u_t023_026/c1_w0_bl u_t001_011/c3_w0_bl a_14200_61800# u_t008_016/c1_w0_bl u_t019_013/c3_w1_bl
+ u_t013_027/c3_w0_bl u_t002_004/c2_r0_rbl u_t024_027/r1_w0_wl a_22600_67400# u_t002_012/r3_w0_wl
+ u_t024_020/c1_w0_bl u_t000_011/c2_w0_br u_t018_030/r2_w0_wl u_t003_021/c1_r0_rbl
+ u_t014_028/r3_w0_wl u_t014_021/c3_w0_bl u_t027_005/r2_w1_wl u_t014_004/c1_w1_bl
+ u_t012_027/r0_w0_wl u_t006_030/r1_w0_wl u_t002_028/r2_w0_wl u_t027_031/c3_w0_bl
+ u_t015_005/r1_w1_wl u_t003_009/r2_r0_rwl u_t027_014/c1_w1_bl u_t003_022/r2_w0_wl
+ u_t021_028/c1_w0_bl u_t006_018/c1_w0_bl u_t017_015/c3_w1_bl u_t011_029/c3_w0_bl
+ u_t003_005/r0_w1_wl u_t022_029/r1_w0_wl u_t022_022/c1_w0_bl gf180mcu_as_sc_mcu7t3v3__inv_2_988/A
+ u_t012_023/c3_w0_bl u_t019_028/c1_w0_bl u_t003_031/c1_w0_bl u_t012_006/c1_w1_bl
+ u_t010_029/r0_w0_wl u_t009_029/c3_w0_bl u_t026_001/r2_w1_wl u_t002_007/c3_w1_bl
+ u_t000_023/c2_w0_bl u_t025_016/c1_w1_bl u_t014_001/r1_w1_wl u_t008_029/r0_w0_wl
+ u_t015_017/c3_w1_bl u_t026_010/c1_w1_bl u_t004_002/r3_w1_wl u_t020_024/c1_w0_bl
+ u_t002_001/c2_w1_br u_t031_021/c3_w1_bl u_t005_014/c1_w0_bl u_t016_011/c3_w1_bl
+ u_t010_025/c3_w0_bl u_t003_017/c2_w1_bl u_t010_008/c1_w1_bl u_t018_024/c1_w0_bl
+ u_t029_021/c3_w1_bl u_t000_009/c3_w1_bl a_14200_17000# u_t011_002/c1_w1_bl u_t000_030/c2_w1_bl
+ u_t003_007/r2_w0_wl u_t008_025/c3_w0_bl u_t003_000/c2_w0_bl u_t000_029/c0_r0_rbl
+ u_t001_006/c1_w0_br u_t023_018/c1_w1_bl u_t008_008/c1_w1_bl u_t013_019/c3_w1_bl
+ u_t002_000/c1_w0_br u_t031_027/r2_w0_wl u_t024_012/c1_w1_bl u_t002_004/r3_w1_wl
+ u_t000_016/c1_r0_rbl u_t025_030/r3_w0_wl u_t009_002/c1_w1_bl u_t000_003/c2_w1_br
+ u_t003_016/c1_w0_bl u_t014_013/c3_w1_bl u_t000_001/c1_r1_rbl u_t000_003/r0_w1_wl
+ u_t003_027/c0_w1_br u_t000_003/c2_r0_rbl u_t029_027/r2_w0_wl u_t013_030/r2_w0_wl
+ u_t000_008/c2_w0_bl u_t022_005/r2_w1_wl u_t027_023/c3_w1_bl u_t016_026/c1_w0_bl
+ u_t001_002/c2_w0_bl u_t003_010/c0_w0_br u_t006_027/c3_w0_bl u_t003_014/r2_w1_wl
+ u_t017_020/c1_w0_bl u_t017_027/r1_w0_wl u_t001_013/c1_w1_br u_t022_031/c3_w0_bl
+ u_t010_005/r1_w1_wl u_t007_021/c3_w0_bl u_t007_028/r3_w0_wl u_t031_006/c3_w1_bl
+ u_t000_023/c3_r0_rbl u_t022_014/c1_w1_bl u_t007_004/c1_w1_bl u_t005_027/r0_w0_wl
+ u_t001_018/c1_w0_bl u_t012_015/c3_w1_bl u_t021_031/r0_w0_wl u_t008_005/r1_w1_wl
+ u_t002_012/c1_w0_bl u_t029_006/c3_w1_bl a_200_64600# u_t027_029/r2_w0_wl u_t000_018/c0_w0_br
+ u_t003_013/c3_w0_br u_t000_015/c2_w1_bl u_t014_028/c1_w0_bl u_t002_026/c0_r0_rbl
+ a_22600_47800# u_t004_029/c3_w0_bl u_t001_012/c0_w0_br u_t015_022/c1_w0_bl u_t021_001/r2_w1_wl
+ u_t002_011/c0_r1_rbl u_t015_029/r1_w0_wl u_t005_023/c3_w0_bl u_t020_016/c1_w1_bl
+ u_t029_000/r0_w1_wl u_t005_006/c1_w1_bl u_t003_029/r0_w0_wl u_t010_017/c3_w1_bl
+ u_t021_010/c1_w1_bl u_t027_008/c3_w1_bl u_t000_014/c1_w0_bl u_t011_011/c3_w1_bl
+ u_t031_003/r3_w1_wl u_t018_016/c1_w1_bl u_t000_025/c0_w1_br u_t007_001/r1_w1_wl
+ u_t003_020/c3_w1_br u_t008_017/c3_w1_bl u_t019_010/c1_w1_bl u_t013_024/c1_w0_bl
+ u_t024_021/c3_w1_bl u_t029_003/r3_w1_wl u_t002_020/c3_r0_rbl u_t009_011/c3_w1_bl
+ u_t003_005/r2_r0_rwl u_t003_025/c3_w0_bl u_t003_019/c0_r0_rbl u_t003_008/c1_w1_bl
+ u_t003_004/c0_r1_rbl u_t017_003/r2_w1_wl u_t002_025/c2_w0_br u_t003_006/c1_r0_rbl
+ u_t004_002/c1_w1_bl u_t000_028/c3_w1_br u_t016_018/c1_w1_bl u_t000_021/c1_w1_bl
+ u_t030_017/c1_w0_bl u_t003_002/c0_w1_br u_t006_019/c3_w1_bl u_t024_027/r2_w0_wl
+ u_t017_012/c1_w1_bl u_t018_030/r3_w0_wl u_t011_026/c1_w0_bl u_t022_023/c3_w1_bl
+ u_t003_024/c1_r1_rbl u_t007_013/c3_w1_bl u_t027_005/r3_w1_wl u_t001_027/c3_w0_bl
+ u_t003_026/c2_r0_rbl u_t028_017/c1_w0_bl u_t012_027/r1_w0_wl u_t012_020/c1_w0_bl
+ u_t025_004/r0_w1_wl u_t003_011/c2_r1_rbl a_14200_70200# u_t006_030/r2_w0_wl u_t002_028/r3_w0_wl
+ u_t002_021/c3_w0_bl u_t009_026/c1_w0_bl u_t015_005/r2_w1_wl u_t003_013/c3_r0_rbl
+ u_t002_004/c1_w1_bl u_t000_027/r0_w0_wl u_t025_030/c1_w0_bl u_t003_005/c3_w1_br
+ u_t015_031/c3_w0_bl u_t003_005/r1_w1_wl u_t001_004/c0_w1_br u_t024_006/c3_w1_bl
+ u_t022_029/r2_w0_wl u_t015_014/c1_w1_bl gf180mcu_as_sc_mcu7t3v3__inv_2_618/A u_t005_015/c3_w1_bl
+ u_t003_031/c2_w0_bl u_t000_025/c0_r0_rbl u_t001_009/c0_w0_bl u_t026_019/c1_w0_bl
+ u_t010_022/c1_w0_bl u_t010_029/r1_w0_wl a_17000_3000# u_t002_003/VSS u_t000_010/c0_r1_rbl
+ u_t026_001/r3_w1_wl u_t002_003/VDD u_t000_023/c3_w0_bl u_t002_003/c0_w0_bl u_t007_028/c1_w0_bl
+ u_t024_000/r0_w1_wl u_t000_006/c1_w1_bl u_t002_012/VSS u_t001_007/c3_w1_br u_t014_001/r2_w1_wl
+ u_t008_022/c1_w0_bl u_t008_029/r1_w0_wl u_t002_012/VDD u_t022_008/c3_w1_bl u_t002_024/VSS
+ u_t013_016/c1_w1_bl u_t000_030/c1_r1_rbl u_t002_001/r1_w1_wl u_t003_017/c3_w1_bl
+ u_t014_010/c1_w1_bl u_t002_031/VSS u_t002_006/c3_w0_bl u_t024_003/r3_w1_wl u_t004_011/c3_w1_bl
+ u_t025_015/c1_w0_bl u_t002_010/c0_w1_bl u_t030_026/c3_w0_bl u_t003_011/c2_w1_br
+ u_t006_024/c1_w0_bl u_t030_009/c1_w1_bl u_t001_003/c0_r1_rbl u_t017_021/c3_w1_bl
+ u_t031_020/c3_w0_bl u_t031_027/r3_w0_wl u_t011_018/c1_w1_bl u_t031_003/c1_w1_bl
+ u_t003_016/c2_w0_bl u_t028_026/c3_w0_bl u_t001_019/c3_w1_bl u_t028_009/c1_w1_bl
+ u_t012_012/c1_w1_bl u_t029_020/c3_w0_bl u_t029_027/r3_w0_wl u_t013_030/r3_w0_wl
+ u_t000_008/c3_r0_rbl u_t002_013/c3_w1_bl u_t022_005/r3_w1_wl u_t029_003/c1_w1_bl
+ u_t009_018/c1_w1_bl u_t000_019/c2_w1_br u_t023_017/c1_w0_bl u_t020_004/r0_w1_wl
+ u_t017_027/r2_w0_wl u_t001_030/r2_w0_wl u_t001_010/c2_r1_rbl u_t010_005/r2_w1_wl
+ u_t015_023/c3_w1_bl u_t004_026/c1_w0_bl u_t002_003/r3_w0_wl u_t000_002/c2_w0_br
+ u_t020_030/c1_w0_bl u_t000_002/r0_w0_wl u_t005_020/c1_w0_bl u_t005_027/r1_w0_wl
+ u_t003_026/c0_w0_br u_t018_004/r0_w1_wl u_t026_028/c3_w0_bl u_t010_031/c3_w0_bl
+ u_t003_023/c2_w1_bl u_t008_005/r2_w1_wl u_t010_014/c1_w1_bl u_t027_022/c3_w0_bl
+ u_t027_029/r3_w0_wl u_t018_030/c1_w0_bl u_t003_001/r2_r0_rwl u_t000_015/c3_w1_bl
+ u_t027_005/c1_w1_bl u_t025_028/r0_w0_wl u_t031_000/r1_w1_wl u_t003_013/r2_w0_wl
+ u_t008_031/c3_w0_bl u_t021_019/c1_w0_bl u_t019_031/r1_w0_wl u_t017_006/c3_w1_bl
+ u_t021_001/r3_w1_wl u_t015_029/r2_w0_wl u_t008_014/c1_w1_bl u_t002_028/c1_w0_bl
+ gf180mcu_as_sc_mcu7t3v3__inv_2_1691/Y u_t003_029/c3_w0_br u_t002_010/r3_w1_wl a_200_73000#
+ a_22600_101000# u_t007_031/r0_w0_wl u_t002_018/c2_r0_rbl a_14200_50600# u_t003_022/c1_w0_bl
+ u_t003_029/r1_w0_wl u_t019_019/c1_w0_bl u_t002_003/c2_r1_rbl a_22600_56200# u_t002_005/c3_r0_rbl
+ u_t017_000/r0_w1_wl u_t025_024/c3_w0_bl u_t025_007/c1_w1_bl u_t030_018/c3_w1_bl
+ u_t003_020/r2_w1_wl u_t015_008/c3_w1_bl u_t006_016/c1_w1_bl u_t026_001/c1_w1_bl
+ u_t020_015/c1_w0_bl u_t031_012/c3_w1_bl u_t027_002/r1_w1_wl u_t007_010/c1_w1_bl
+ u_t003_008/c2_w1_bl u_t001_024/c1_w0_bl u_t028_018/c3_w1_bl u_t012_021/c3_w1_bl
+ u_t017_003/r3_w1_wl u_t003_009/c1_r1_rbl u_t018_015/c1_w0_bl u_t029_012/c3_w1_bl
+ u_t000_026/VDD u_t002_008/c1_w1_br u_t015_002/r0_w1_wl u_t000_024/c0_w0_br u_t023_026/c3_w0_bl
+ u_t005_003/r2_w1_wl u_t023_009/c1_w1_bl a_14200_89800# u_t024_027/r3_w0_wl u_t024_020/c3_w0_bl
+ u_t024_003/c1_w1_bl u_t004_018/c1_w1_bl u_t012_027/r2_w0_wl u_t005_012/c1_w1_bl
+ u_t025_004/r1_w1_wl u_t003_018/c0_w1_br u_t010_023/c3_w1_bl u_t000_027/c3_w0_br
+ u_t015_005/r3_w1_wl u_t031_027/c1_w0_bl u_t003_016/c3_r1_rbl u_t016_017/c1_w0_bl
+ u_t000_027/r1_w0_wl u_t027_014/c3_w1_bl u_t000_020/c1_w0_bl u_t013_004/r0_w1_wl
+ u_t021_028/c3_w0_bl u_t003_005/r2_w1_wl u_t008_023/c3_w1_bl u_t026_031/r2_w0_wl
+ gf180mcu_as_sc_mcu7t3v3__inv_2_1144/A u_t022_022/c3_w0_bl u_t022_029/r3_w0_wl u_t029_027/c1_w0_bl
+ u_t013_030/c1_w0_bl u_t022_005/c1_w1_bl u_t020_028/r0_w0_wl u_t019_028/c3_w0_bl
+ u_t003_031/c3_w0_bl gf180mcu_as_sc_mcu7t3v3__inv_2_1294/Y u_t000_028/c0_r1_rbl u_t012_006/c3_w1_bl
+ u_t010_029/r2_w0_wl u_t003_014/c1_w1_bl u_t002_031/c2_w0_br u_t001_001/c1_r0_rbl
+ u_t000_009/c0_w0_br u_t000_015/c1_r1_rbl u_t024_000/r1_w1_wl u_t018_028/r0_w0_wl
+ u_t003_004/c3_w0_br u_t014_019/c1_w0_bl u_t025_016/c3_w1_bl u_t000_017/c2_r0_rbl
+ u_t008_029/r2_w0_wl u_t001_003/c0_w0_br u_t030_023/c1_w0_bl u_t000_002/c2_r1_rbl
+ u_t001_000/c2_w1_bl u_t026_010/c3_w1_bl u_t020_024/c3_w0_bl u_t012_000/r0_w1_wl
+ u_t027_029/c1_w0_bl u_t002_001/r2_w1_wl u_t020_007/c1_w1_bl u_t000_000/c1_w1_br
+ u_t028_023/c1_w0_bl u_t010_008/c3_w1_bl u_t021_001/c1_w1_bl u_t001_016/c1_w1_bl
+ u_t018_024/c3_w0_bl u_t000_005/c1_w0_bl u_t000_022/c3_r1_rbl u_t002_010/c1_w1_bl
+ u_t018_007/c1_w1_bl u_t001_006/c3_w0_br u_t023_018/c3_w1_bl u_t012_003/r3_w1_wl
+ u_t008_008/c3_w1_bl u_t019_001/c1_w1_bl u_t013_015/c1_w0_bl u_t001_010/c0_w1_br
+ a_200_53400# u_t024_012/c3_w1_bl u_t001_008/c1_r1_rbl u_t003_011/c0_r0_rbl u_t000_003/r2_w1_wl
+ u_t005_021/c3_w1_bl a_22600_36600# u_t002_013/r3_r0_rwl u_t026_025/c1_w0_bl u_t002_016/c2_w0_br
+ u_t003_030/r2_r0_rwl u_t008_002/r0_w1_wl u_t016_026/c3_w0_bl u_t003_010/c2_w0_br
+ u_t016_009/c1_w1_bl u_t000_012/c1_w1_bl u_t020_004/r1_w1_wl u_t017_020/c3_w0_bl
+ u_t017_027/r3_w0_wl u_t001_030/r3_w0_wl u_t001_013/c3_w1_br u_t003_031/c1_r0_rbl
+ u_t010_005/r3_w1_wl u_t017_003/c1_w1_bl u_t011_017/c1_w0_bl u_t022_014/c3_w1_bl
+ u_t005_027/r2_w0_wl u_t018_004/r1_w1_wl u_t003_023/c3_w1_bl u_t008_005/r3_w1_wl
+ u_t003_019/r2_r0_rwl u_t024_027/c1_w0_bl u_t002_012/c3_w0_bl u_t001_004/VDD u_t000_018/c2_w0_br
+ u_t009_017/c1_w0_bl u_t006_004/r0_w1_wl u_t014_028/c3_w0_bl u_t029_030/r0_w0_wl
+ u_t025_021/c1_w0_bl u_t025_028/r1_w0_wl u_t031_000/r2_w1_wl u_t003_018/c0_r1_rbl
+ u_t019_031/r2_w0_wl u_t001_013/VDD u_t015_029/r3_w0_wl u_t015_022/c3_w0_bl a_28200_3000#
+ u_t006_030/c1_w0_bl u_t030_015/c1_w1_bl u_t015_005/c1_w1_bl u_t013_028/r0_w0_wl
+ u_t020_016/c3_w1_bl u_t007_031/r1_w0_wl u_t005_006/c3_w1_bl u_t003_029/r2_w0_wl
+ u_t021_010/c3_w1_bl u_t028_015/c1_w1_bl u_t022_029/c1_w0_bl u_t002_022/c1_w0_br
+ u_t002_008/c3_r1_rbl u_t018_016/c3_w1_bl u_t007_019/c1_w0_bl u_t000_025/c2_w1_br
+ u_t003_025/c2_r1_rbl u_t023_023/c1_w0_bl u_t019_010/c3_w1_bl u_t013_024/c3_w0_bl
+ u_t013_007/c1_w1_bl u_t027_002/r2_w1_wl u_t003_008/c3_w1_bl u_t014_001/c1_w1_bl
+ u_t026_017/c1_w1_bl u_t015_002/r1_w1_wl u_t016_018/c3_w1_bl u_t000_021/c3_w1_bl
+ u_t001_010/c0_r0_rbl u_t002_001/c0_w1_bl u_t027_011/c1_w1_bl u_t005_003/r3_w1_wl
+ u_t000_024/c0_r1_rbl u_t021_025/c1_w0_bl u_t003_002/c2_w1_br u_t006_015/c1_w0_bl
+ u_t017_012/c3_w1_bl u_t003_002/r0_w1_wl u_t011_026/c3_w0_bl u_t011_009/c1_w1_bl
+ u_t003_007/c2_w0_bl u_t012_027/r3_w0_wl u_t012_020/c3_w0_bl u_t019_025/c1_w0_bl
+ u_t025_004/r2_w1_wl u_t012_003/c1_w1_bl u_t009_026/c3_w0_bl a_14200_98200# u_t002_007/c1_w0_br
+ u_t000_000/c3_r0_rbl u_t002_004/c3_w1_bl u_t000_027/r2_w0_wl u_t009_009/c1_w1_bl
+ u_t025_030/c3_w0_bl u_t013_004/r1_w1_wl u_t000_031/c2_r1_rbl u_t000_003/c0_w1_bl
+ u_t025_013/c1_w1_bl u_t003_005/r3_w1_wl a_200_33800# u_t026_031/r3_w0_wl u_t001_004/c2_w1_br
+ u_t004_017/c1_w0_bl u_t015_014/c3_w1_bl u_t001_004/r0_w1_wl u_t024_030/r0_w0_wl
+ u_t020_021/c1_w0_bl u_t020_028/r1_w0_wl u_t002_003/c0_r0_rbl u_t014_031/r2_w0_wl
+ u_t001_009/c2_w0_bl u_t003_017/c0_w0_br u_t026_019/c3_w0_bl u_t010_022/c3_w0_bl
+ u_t010_029/r3_w0_wl u_t017_027/c1_w0_bl u_t001_030/c1_w0_bl u_t010_005/c1_w1_bl
+ u_t007_028/c3_w0_bl u_t002_031/r1_w0_wl u_t018_021/c1_w0_bl u_t018_028/r1_w0_wl
+ u_t000_006/c3_w1_bl u_t002_014/c1_w1_br u_t003_004/r2_w0_wl u_t008_022/c3_w0_bl
+ u_t008_029/r3_w0_wl u_t002_023/c1_r0_rbl u_t023_015/c1_w1_bl u_t008_005/c1_w1_bl
+ u_t006_028/r0_w0_wl u_t002_019/c1_w0_bl u_t013_016/c3_w1_bl u_t000_007/c3_r1_rbl
+ u_t002_001/r3_w1_wl u_t002_010/c2_r0_rbl u_t014_010/c3_w1_bl u_t003_013/c1_w0_bl
+ u_t000_000/r0_w1_wl u_t015_029/c1_w0_bl u_t022_002/r2_w1_wl u_t016_023/c1_w0_bl
+ u_t002_010/c2_w1_bl u_t027_020/c3_w1_bl u_t006_024/c3_w0_bl u_t030_009/c3_w1_bl
+ a_25400_120600# u_t002_030/c3_r0_rbl u_t003_011/r2_w1_wl u_t021_017/c1_w1_bl u_t003_015/r2_r0_rwl
+ u_t002_002/VSS u_t010_002/r1_w1_wl u_t006_007/c1_w1_bl u_t011_018/c3_w1_bl u_t022_011/c1_w1_bl
+ u_t000_003/r3_w1_wl u_t007_001/c1_w1_bl u_t003_027/c3_w1_br u_t001_015/c1_w0_bl
+ u_t028_009/c3_w1_bl u_t003_016/c1_r0_rbl u_t012_012/c3_w1_bl u_t019_017/c1_w1_bl
+ u_t003_020/c1_w1_bl u_t003_001/c1_r1_rbl u_t009_018/c3_w1_bl gf180mcu_as_sc_mcu7t3v3__inv_2_341/Y
+ u_t003_003/c2_r0_rbl u_t020_004/r2_w1_wl u_t014_025/c1_w0_bl u_t025_022/c3_w1_bl
+ u_t004_026/c3_w0_bl a_22600_45000# u_t028_003/r0_w1_wl u_t020_030/c3_w0_bl u_t004_009/c1_w1_bl
+ u_t002_025/c0_w0_bl u_t005_020/c3_w0_bl u_t005_027/r3_w0_wl u_t031_030/r1_w0_wl
+ u_t003_026/c2_w0_br u_t018_004/r2_w1_wl u_t000_028/c1_w1_bl u_t020_013/c1_w1_bl
+ u_t021_031/r3_w0_wl u_t005_003/c1_w1_bl u_t003_023/c3_r0_rbl u_t003_009/c0_w1_br
+ u_t010_014/c3_w1_bl u_t018_030/c3_w0_bl u_t031_018/c1_w0_bl u_t006_004/r1_w1_wl
+ u_t000_011/c1_w0_bl u_t025_028/r2_w0_wl u_t031_000/r3_w1_wl u_t018_013/c1_w1_bl
+ u_t021_019/c3_w0_bl u_t001_012/c3_w0_br u_t012_027/c1_w0_bl u_t008_014/c3_w1_bl
+ u_t002_028/c3_w0_bl u_t017_030/r0_w0_wl u_t029_018/c1_w0_bl u_t013_028/r1_w0_wl
+ u_t013_021/c1_w0_bl u_t026_005/r0_w1_wl u_t029_000/r3_w1_wl gf180mcu_as_sc_mcu7t3v3__inv_2_1685/Y
+ u_t003_029/r3_w0_wl u_t019_019/c3_w0_bl u_t003_022/c3_w0_bl u_t000_020/c0_r1_rbl
+ a_14200_78600# u_t000_022/c1_r0_rbl u_t003_005/c1_w1_bl u_t001_028/r0_w0_wl u_t026_031/c1_w0_bl
+ u_t017_000/r2_w1_wl u_t025_007/c3_w1_bl u_t016_015/c1_w1_bl u_t010_029/c1_w0_bl
+ u_t030_014/c1_w0_bl u_t006_016/c3_w1_bl u_t011_023/c1_w0_bl u_t022_020/c3_w1_bl
+ u_t007_010/c3_w1_bl gf180mcu_as_sc_mcu7t3v3__inv_2_661/A u_t001_024/c3_w0_bl u_t008_029/c1_w0_bl
+ u_t028_014/c1_w0_bl u_t025_001/r0_w1_wl u_t001_007/c1_w1_bl u_t009_023/c1_w0_bl
+ u_t000_024/c2_w0_br u_t002_001/c1_w1_bl u_t003_018/VSS u_t001_013/c0_r1_rbl u_t023_009/c3_w1_bl
+ u_t004_018/VDD u_t014_017/c1_w1_bl u_t001_015/c1_r0_rbl u_t000_029/c1_r1_rbl u_t003_002/r1_w1_wl
+ u_t004_018/c3_w1_bl u_t001_000/c1_r1_rbl u_t003_027/VSS u_t015_011/c1_w1_bl u_t004_027/VDD
+ u_t020_022/c3_w1_bl u_t001_002/c2_r0_rbl u_t005_012/c3_w1_bl u_t025_004/r3_w1_wl
+ u_t003_018/c2_w1_br u_t026_016/c1_w0_bl u_t003_011/c0_w1_bl u_t031_027/c3_w0_bl
+ u_t000_005/VDD u_t000_027/r3_w0_wl u_t000_020/c3_w0_bl u_t007_025/c1_w0_bl u_t002_000/c0_w0_bl
+ u_t013_004/r2_w1_wl u_t018_022/c3_w1_bl u_t000_031/c2_w1_br u_t003_001/c2_w0_br
+ u_t000_003/c1_w1_bl a_14200_103800# u_t000_014/VDD u_t030_027/r0_w0_wl u_t013_030/c3_w0_bl
+ u_t029_027/c3_w0_bl u_t001_004/r1_w1_wl u_t024_030/r1_w0_wl u_t020_028/r2_w0_wl
+ u_t013_013/c1_w1_bl u_t003_014/c3_w1_bl u_t002_008/c1_r0_rbl u_t028_027/r0_w0_wl
+ u_t012_030/r0_w0_wl u_t003_011/r2_r0_rwl u_t024_018/c1_w0_bl a_200_42200# u_t002_003/c3_w0_bl
+ u_t003_025/c0_r0_rbl u_t021_005/r0_w1_wl u_t000_009/c2_w0_br u_t024_000/r3_w1_wl
+ u_t018_028/r2_w0_wl u_t002_031/r2_w0_wl u_t014_019/c3_w0_bl u_t000_030/c1_w0_br
+ u_t000_002/c0_w0_bl u_t003_010/c0_r1_rbl u_t005_027/c1_w0_bl a_22600_25400# u_t001_003/c2_w0_br
+ u_t030_023/c3_w0_bl u_t021_031/c1_w0_bl u_t006_021/c1_w0_bl u_t006_028/r1_w0_wl
+ u_t030_006/c1_w1_bl u_t019_005/r0_w1_wl u_t027_029/c3_w0_bl a_14200_8600# u_t020_007/c3_w1_bl
+ u_t000_000/c3_w1_br u_t011_015/c1_w1_bl u_t028_023/c3_w0_bl u_t019_031/c1_w0_bl
+ u_t002_015/c3_r0_rbl u_t001_016/c3_w1_bl u_t003_030/c1_r1_rbl u_t026_029/r0_w0_wl
+ u_t028_006/c1_w1_bl u_t000_005/c3_w0_bl u_t002_013/c1_w0_br u_t002_000/c3_r1_rbl
+ u_t002_010/c3_w1_bl u_t018_007/c3_w1_bl u_t022_002/r3_w1_wl u_t009_015/c1_w1_bl
+ u_t000_016/c2_w1_br u_t003_029/c1_w0_bl u_t023_014/c1_w0_bl u_t020_001/r0_w1_wl
+ u_t001_010/c2_w1_br u_t010_002/r2_w1_wl u_t004_023/c1_w0_bl u_t015_020/c3_w1_bl
+ u_t002_000/r3_w0_wl a_22600_109400# u_t001_015/c2_w0_bl u_t026_025/c3_w0_bl u_t003_027/r2_w1_wl
+ u_t026_008/c1_w1_bl u_t010_011/c1_w1_bl u_t000_031/c0_r0_rbl u_t031_019/c3_w1_bl
+ u_t000_015/c1_w0_br u_t016_009/c3_w1_bl u_t000_012/c3_w1_bl u_t020_004/r3_w1_wl
+ u_t007_017/c1_w1_bl u_t027_002/c1_w1_bl u_t003_010/r2_w0_wl u_t021_016/c1_w0_bl
+ u_t003_008/c3_r0_rbl gf180mcu_as_sc_mcu7t3v3__inv_2_1094/A u_t008_011/c1_w1_bl u_t028_003/r1_w1_wl
+ u_t029_019/c3_w1_bl u_t002_025/c1_w0_bl u_t013_022/c3_w1_bl u_t031_030/r2_w0_wl
+ u_t018_004/r3_w1_wl u_t019_016/c1_w0_bl u_t016_003/r0_w1_wl u_t024_027/c3_w0_bl
+ u_t006_004/r2_w1_wl u_t025_028/r3_w0_wl u_t025_021/c3_w0_bl u_t000_005/c0_r1_rbl
+ u_t000_022/c1_w1_br u_t025_004/c1_w1_bl u_t023_027/r0_w0_wl u_t000_007/c1_r0_rbl
+ u_t006_030/c3_w0_bl u_t030_015/c3_w1_bl u_t013_028/r2_w0_wl u_t006_013/c1_w1_bl
+ u_t026_005/r1_w1_wl u_t000_027/c1_w0_bl u_t017_018/c1_w0_bl u_t028_015/c3_w1_bl
+ u_t001_028/r1_w0_wl u_t001_021/c1_w0_bl u_t022_029/c3_w0_bl u_t014_005/r0_w1_wl
+ u_t017_000/r3_w1_wl u_t002_022/c3_w0_br u_t007_019/c3_w0_bl u_t000_027/c2_r0_rbl
+ u_t002_005/c1_w1_br u_t023_023/c3_w0_bl u_t000_012/c2_r1_rbl u_t014_031/c1_w0_bl
+ gf180mcu_as_sc_mcu7t3v3__inv_2_1657/Y u_t005_000/r2_w1_wl u_t023_006/c1_w1_bl u_t000_014/c3_r0_rbl
+ u_t021_029/r0_w0_wl a_14200_87000# u_t013_007/c3_w1_bl u_t004_015/c1_w1_bl u_t002_031/c0_w0_bl
+ u_t003_004/c1_w0_bl u_t001_031/VSS a_200_22600# u_t019_029/r0_w0_wl u_t026_017/c3_w1_bl
+ u_t010_020/c3_w1_bl u_t002_004/c0_w0_br u_t031_024/c1_w0_bl u_t002_001/c2_w1_bl
+ u_t016_014/c1_w0_bl u_t027_011/c3_w1_bl u_t000_007/c1_w1_br u_t021_025/c3_w0_bl
+ u_t021_008/c1_w1_bl u_t003_002/r2_w1_wl u_t008_020/c3_w1_bl u_t029_024/c1_w0_bl
+ u_t011_009/c3_w1_bl u_t022_002/c1_w1_bl u_t002_017/c1_w1_bl u_t001_005/c2_r1_rbl
+ u_t019_025/c3_w0_bl gf180mcu_as_sc_mcu7t3v3__inv_2_1052/A u_t001_006/c1_w0_bl u_t001_007/c3_r0_rbl
+ u_t019_008/c1_w1_bl u_t023_003/r1_w1_wl u_t003_011/c1_w1_bl u_t002_007/c3_w0_br
+ u_t024_019/c3_w1_bl u_t009_009/c3_w1_bl u_t013_004/r3_w1_wl u_t014_016/c1_w0_bl
+ u_t000_003/c2_w1_bl u_t002_011/c0_w1_br u_t025_013/c3_w1_bl u_t011_003/r0_w1_wl
+ u_t030_020/c1_w0_bl u_t030_027/r1_w0_wl u_t001_004/r2_w1_wl u_t006_022/c3_w1_bl
+ u_t020_021/c3_w0_bl u_t020_028/r3_w0_wl u_t002_016/c0_w0_bl u_t027_026/c1_w0_bl
+ gf180mcu_as_sc_mcu7t3v3__inv_2_1675/Y u_t003_017/c2_w0_br u_t000_019/c1_w1_bl u_t020_004/c1_w1_bl
+ u_t003_029/r2_r0_rwl u_t001_030/c3_w0_bl u_t017_027/c3_w0_bl u_t003_010/c0_w0_bl
+ u_t012_030/r1_w0_wl u_t028_020/c1_w0_bl u_t028_027/r1_w0_wl a_14200_112200# u_t001_013/c1_w1_bl
+ u_t021_005/r1_w1_wl u_t003_028/c0_r1_rbl u_t018_021/c3_w0_bl u_t018_028/r3_w0_wl
+ u_t002_014/c3_w1_br u_t018_004/c1_w1_bl u_t016_027/r0_w0_wl u_t000_030/r0_w0_wl
+ u_t012_018/c1_w0_bl u_t023_015/c3_w1_bl u_t003_015/c1_r1_rbl u_t012_000/r3_w1_wl
+ u_t006_028/r2_w0_wl u_t002_019/c3_w0_bl u_t019_005/r1_w1_wl u_t003_017/c2_r0_rbl
+ u_t000_018/c0_w0_bl u_t003_002/c2_r1_rbl u_t025_028/c1_w0_bl u_t003_013/c3_w0_bl
+ u_t000_000/r2_w1_wl u_t007_005/r0_w1_wl u_t015_029/c3_w0_bl u_t003_024/c2_w1_br
+ u_t026_022/c1_w0_bl u_t026_029/r1_w0_wl u_t016_023/c3_w0_bl u_t007_031/c1_w0_bl
+ u_t002_019/VSS u_t031_016/c1_w1_bl u_t016_006/c1_w1_bl u_t020_001/r1_w1_wl u_t014_029/r0_w0_wl
+ u_t021_017/c3_w1_bl u_t003_022/c3_r1_rbl u_t006_007/c3_w1_bl u_t002_028/VSS u_t002_029/c1_w0_br
+ u_t011_014/c1_w0_bl u_t022_011/c3_w1_bl u_t029_016/c1_w1_bl u_t018_001/r1_w1_wl
+ u_t003_023/c1_w0_br u_t000_025/c0_w1_bl u_t019_017/c3_w1_bl u_t003_020/c3_w1_bl
+ u_t008_002/r3_w1_wl u_t030_003/r2_w1_wl u_t024_024/c1_w0_bl u_t009_014/c1_w0_bl
+ u_t014_025/c3_w0_bl a_14200_67400# u_t014_008/c1_w1_bl u_t000_021/c1_r1_rbl u_t004_009/c3_w1_bl
+ u_t030_012/c1_w1_bl u_t002_025/c2_w0_bl u_t031_030/r3_w0_wl u_t015_002/c1_w1_bl
+ u_t000_028/c3_w1_bl u_t020_013/c3_w1_bl u_t027_018/c1_w1_bl u_t002_008/c0_w1_bl
+ u_t003_026/r2_w0_wl u_t003_009/c2_w1_br u_t001_022/c3_w1_bl u_t017_019/c3_w1_bl
+ u_t003_030/c1_w1_br u_t003_002/c0_w1_bl u_t028_012/c1_w1_bl u_t006_004/r3_w1_wl
+ u_t022_026/c1_w0_bl u_t029_030/r3_w0_wl u_t000_011/c3_w0_bl u_t007_016/c1_w0_bl
+ u_t018_013/c3_w1_bl u_t004_003/r0_w1_wl u_t012_027/c3_w0_bl u_t023_027/r1_w0_wl
+ u_t023_020/c1_w0_bl u_t013_028/r3_w0_wl u_t013_021/c3_w0_bl u_t026_005/r2_w1_wl
+ u_t013_004/c1_w1_bl u_t011_027/r0_w0_wl u_t002_000/c1_r0_rbl u_t003_005/c3_w1_bl
+ u_t001_028/r2_w0_wl u_t026_031/c3_w0_bl u_t001_014/c1_r1_rbl u_t014_005/r1_w1_wl
+ u_t026_014/c1_w1_bl u_t020_028/c1_w0_bl u_t000_021/c1_w0_br u_t009_027/r0_w0_wl
+ u_t016_015/c3_w1_bl u_t005_018/c1_w0_bl u_t010_029/c3_w0_bl u_t002_005/r0_w1_wl
+ u_t005_000/r3_w1_wl u_t025_031/r0_w0_wl u_t021_022/c1_w0_bl u_t021_029/r1_w0_wl
+ gf180mcu_as_sc_mcu7t3v3__inv_2_1387/Y u_t011_023/c3_w0_bl u_t018_028/c1_w0_bl u_t002_031/c1_w0_bl
+ u_t011_006/c1_w1_bl u_t008_029/c3_w0_bl u_t019_022/c1_w0_bl u_t019_029/r1_w0_wl
+ u_t001_007/c3_w1_bl u_t003_015/c1_w1_br u_t009_023/c3_w0_bl u_t002_008/r3_r0_rwl
+ u_t024_016/c1_w1_bl u_t002_008/r3_w1_wl u_t009_006/c1_w1_bl u_t007_029/r0_w0_wl
+ u_t003_025/r2_r0_rwl gf180mcu_as_sc_mcu7t3v3__inv_2_739/A u_t014_017/c3_w1_bl u_t025_010/c1_w1_bl
+ u_t002_007/c1_r1_rbl u_t003_002/r3_w1_wl u_t001_001/c2_w1_br u_t030_021/c3_w1_bl
+ a_200_31000# u_t002_009/c2_r0_rbl u_t004_014/c1_w0_bl u_t015_011/c3_w1_bl a_22600_14200#
+ u_t003_018/r2_w1_wl u_t023_003/r2_w1_wl u_t017_024/c1_w0_bl u_t028_021/c3_w1_bl
+ u_t010_002/c1_w1_bl u_t007_025/c3_w0_bl u_t002_000/c2_w0_bl u_t000_006/c1_w0_br
+ u_t022_018/c1_w1_bl u_t002_029/c3_r0_rbl u_t007_008/c1_w1_bl u_t011_003/r1_w1_wl
+ gf180mcu_as_sc_mcu7t3v3__inv_2_997/Y u_t003_001/r2_w0_wl u_t003_000/c3_r0_rbl u_t012_019/c3_w1_bl
+ u_t001_000/c1_w0_br u_t002_014/c3_r1_rbl u_t030_027/r2_w0_wl u_t003_027/c1_w1_bl
+ u_t001_004/r3_w1_wl u_t023_012/c1_w1_bl u_t003_009/VSS u_t008_002/c1_w1_bl u_t004_006/VDD
+ u_t002_016/c1_w0_bl u_t013_013/c3_w1_bl u_t003_017/VSS u_t031_004/r0_w1_wl u_t028_027/r2_w0_wl
+ u_t021_005/r2_w1_wl u_t015_026/c1_w0_bl u_t026_023/c3_w1_bl a_22600_5800# u_t000_012/c0_r0_rbl
+ u_t000_002/c2_w0_bl u_t002_010/c0_w0_br u_t003_024/VSS a_14200_47800# u_t005_027/c3_w0_bl
+ u_t031_030/c1_w0_bl u_t016_020/c1_w0_bl u_t016_027/r1_w0_wl a_200_106600# u_t000_013/c1_w1_br
+ u_t029_004/r0_w1_wl u_t021_031/c3_w0_bl u_t003_026/c0_w0_bl u_t006_021/c3_w0_bl
+ u_t006_028/r3_w0_wl u_t030_006/c3_w1_bl u_t019_005/r2_w1_wl u_t021_014/c1_w1_bl
+ u_t000_030/c0_r1_rbl u_t004_027/r0_w0_wl u_t006_004/c1_w1_bl u_t029_030/c1_w0_bl
+ u_t000_018/c1_w0_bl u_t011_015/c3_w1_bl u_t000_000/r3_w1_wl u_t020_031/r0_w0_wl
+ u_t019_031/c3_w0_bl u_t007_005/r1_w1_wl u_t003_007/c3_r1_rbl u_t000_011/VDD u_t001_012/c1_w0_bl
+ u_t028_006/c3_w1_bl u_t026_029/r2_w0_wl u_t019_014/c1_w1_bl u_t002_013/c3_w0_br
+ u_t013_028/c1_w0_bl u_t009_015/c3_w1_bl u_t000_031/VSS u_t003_029/c3_w0_bl u_t000_012/c0_w0_br
+ u_t000_020/VDD u_t014_029/r1_w0_wl u_t014_022/c1_w0_bl u_t004_023/c3_w0_bl u_t001_005/c0_r0_rbl
+ gf180mcu_as_sc_mcu7t3v3__inv_2_716/Y u_t000_019/c0_r1_rbl u_t028_000/r0_w1_wl u_t004_006/c1_w1_bl
+ u_t002_029/r0_w0_wl u_t018_001/r2_w1_wl u_t020_010/c1_w1_bl u_t000_006/c1_r1_rbl
+ u_t026_008/c3_w1_bl u_t030_003/r3_w1_wl u_t010_011/c3_w1_bl u_t017_016/c1_w1_bl
+ gf180mcu_as_sc_mcu7t3v3__inv_2_71/Y u_t031_015/c1_w0_bl u_t006_001/r1_w1_wl u_t007_017/c3_w1_bl
+ u_t018_010/c1_w1_bl u_t012_024/c1_w0_bl u_t023_021/c3_w1_bl u_t008_011/c3_w1_bl
+ u_t002_025/c3_w0_bl u_t001_012/c2_r0_rbl u_t000_026/c2_r1_rbl u_t029_015/c1_w0_bl
+ u_t002_008/c1_w1_bl u_t000_024/c0_w0_bl u_t000_028/c3_r0_rbl gf180mcu_as_sc_mcu7t3v3__inv_2_737/A
+ u_t000_013/c3_r1_rbl u_t003_002/c1_w1_bl u_t015_018/c1_w1_bl u_t000_022/c3_w1_br
+ u_t002_002/c0_w1_br u_t005_019/c3_w1_bl u_t023_027/r2_w0_wl a_200_11400# u_t016_012/c1_w1_bl
+ u_t010_026/c1_w0_bl u_t017_030/r3_w0_wl gf180mcu_as_sc_mcu7t3v3__inv_2_8/A u_t021_023/c3_w1_bl
+ u_t003_018/c0_w1_bl u_t006_013/c3_w1_bl u_t026_005/r3_w1_wl u_t000_027/c3_w0_bl
+ u_t002_004/r3_r0_rwl u_t027_017/c1_w0_bl u_t011_027/r1_w0_wl u_t011_020/c1_w0_bl
+ u_t003_008/c2_w0_br u_t024_004/r0_w1_wl u_t003_021/r2_r0_rwl u_t005_030/r2_w0_wl
+ u_t001_028/r3_w0_wl u_t001_021/c3_w0_bl u_t000_031/c0_w1_bl u_t008_026/c1_w0_bl
+ u_t003_001/c0_w0_bl u_t014_005/r2_w1_wl u_t019_023/c3_w1_bl u_t001_004/c1_w1_bl
+ u_t003_020/c0_r1_rbl u_t024_030/c1_w0_bl u_t002_005/c3_w1_br u_t009_027/r1_w0_wl
+ u_t009_020/c1_w0_bl u_t003_022/c1_r0_rbl u_t031_028/r0_w0_wl u_t014_031/c3_w0_bl
+ u_t002_005/r1_w1_wl u_t000_004/c0_w1_br u_t023_006/c3_w1_bl u_t021_029/r2_w0_wl
+ u_t001_006/c3_r1_rbl u_t014_014/c1_w1_bl u_t004_015/c3_w1_bl u_t002_031/c2_w0_bl
+ u_t029_028/r0_w0_wl u_t013_031/r0_w0_wl u_t000_009/c0_w0_bl u_t025_019/c1_w0_bl
+ u_t003_004/c3_w0_bl u_t025_001/r3_w1_wl u_t019_029/r2_w0_wl u_t001_003/c0_w0_bl
+ u_t006_028/c1_w0_bl u_t031_024/c3_w0_bl u_t000_007/c3_w1_br u_t013_001/r2_w1_wl
+ u_t007_022/c1_w0_bl u_t007_029/r1_w0_wl u_t031_007/c1_w1_bl u_t021_008/c3_w1_bl
+ a_14200_101000# u_t012_016/c1_w1_bl u_t029_024/c3_w0_bl u_t002_017/c3_w1_bl gf180mcu_as_sc_mcu7t3v3__inv_2_1384/Y
+ u_t013_010/c1_w1_bl gf180mcu_as_sc_mcu7t3v3__inv_2_9/A u_t003_029/c1_r1_rbl u_t029_007/c1_w1_bl
+ u_t001_006/c3_w0_bl u_t003_014/c1_w0_br u_t000_016/c0_w1_bl u_t019_008/c3_w1_bl
+ u_t003_011/c3_w1_bl u_t024_015/c1_w0_bl u_t002_007/r3_w0_wl u_t021_002/r0_w1_wl
+ u_t001_010/c0_w1_bl u_t002_011/c2_w1_br u_t000_006/r0_w0_wl u_t005_024/c1_w0_bl
+ u_t016_021/c3_w1_bl u_t030_020/c3_w0_bl u_t030_027/r3_w0_wl gf180mcu_as_sc_mcu7t3v3__inv_2_358/Y
+ u_t030_003/c1_w1_bl u_t010_018/c1_w1_bl u_t002_016/c2_w0_bl u_t027_026/c3_w0_bl
+ u_t000_019/c3_w1_bl u_t009_003/r2_w1_wl u_t027_009/c1_w1_bl u_t011_012/c1_w1_bl
+ u_t031_004/r1_w1_wl u_t003_010/c2_w0_bl u_t003_017/r2_w0_wl u_t028_020/c3_w0_bl
+ u_t028_027/r3_w0_wl u_t012_030/r3_w0_wl u_t001_013/c3_w1_bl u_t003_021/c1_w1_br
+ u_t021_005/r3_w1_wl u_t008_018/c1_w1_bl u_t028_003/c1_w1_bl u_t022_017/c1_w0_bl
+ u_t002_014/r3_w1_wl u_t016_027/r2_w0_wl u_t009_012/c1_w1_bl u_t029_004/r1_w1_wl
+ u_t014_023/c3_w1_bl u_t003_026/c1_w0_bl u_t019_005/r3_w1_wl gf180mcu_as_sc_mcu7t3v3__inv_2_364/Y
+ u_t000_004/c2_r0_rbl u_t004_020/c1_w0_bl u_t004_027/r1_w0_wl u_t002_026/c0_w0_br
+ u_t017_004/r0_w1_wl u_t025_028/c3_w0_bl u_t020_031/r1_w0_wl u_t000_029/c1_w1_br
+ a_14200_56200# u_t007_005/r2_w1_wl u_t026_029/r3_w0_wl a_200_115000# u_t026_022/c3_w0_bl
+ u_t003_024/r2_w1_wl u_t017_030/c1_w0_bl u_t026_005/c1_w1_bl u_t024_028/r0_w0_wl
+ u_t007_031/c3_w0_bl u_t020_019/c1_w0_bl u_t031_016/c3_w1_bl u_t016_006/c3_w1_bl
+ u_t020_001/r3_w1_wl u_t014_029/r2_w0_wl u_t007_014/c1_w1_bl u_t001_028/c1_w0_bl
+ u_t002_029/c3_w0_br u_t028_000/r1_w1_wl u_t029_016/c3_w1_bl u_t002_029/r1_w0_wl
+ u_t018_019/c1_w0_bl u_t002_022/c1_w0_bl u_t000_025/c2_w1_bl u_t002_027/c0_r0_rbl
+ u_t003_006/c1_w1_br u_t016_000/r0_w1_wl u_t024_024/c3_w0_bl u_t002_012/c0_r1_rbl
+ u_t002_000/r3_r0_rwl u_t006_001/r2_w1_wl u_t024_007/c1_w1_bl gf180mcu_as_sc_mcu7t3v3__inv_2_732/Y
+ u_t002_014/c1_r0_rbl gf180mcu_as_sc_mcu7t3v3__inv_2_631/A u_t014_008/c3_w1_bl u_t005_016/c1_w1_bl
+ u_t025_001/c1_w1_bl u_t002_009/VSS u_t030_012/c3_w1_bl u_t006_010/c1_w1_bl u_t002_008/c2_w1_bl
+ u_t027_018/c3_w1_bl u_t000_024/c1_w0_bl u_t011_021/c3_w1_bl u_t002_017/VSS u_t016_003/r3_w1_wl
+ u_t003_030/c3_w1_br u_t003_002/c2_w1_bl u_t003_009/r2_w1_wl u_t017_015/c1_w0_bl
+ u_t028_012/c3_w1_bl u_t001_008/c1_w1_br u_t022_026/c3_w0_bl u_t002_025/VSS u_t022_009/c1_w1_bl
+ u_t002_021/c3_r0_rbl u_t009_021/c3_w1_bl gf180mcu_as_sc_mcu7t3v3__inv_2_1115/A u_t003_006/r2_r0_rwl
+ u_t023_027/r3_w0_wl u_t023_020/c3_w0_bl u_t023_003/c1_w1_bl u_t003_018/c1_w1_bl
+ u_t003_005/c0_r1_rbl u_t003_007/c1_r0_rbl u_t011_027/r2_w0_wl u_t004_012/c1_w1_bl
+ u_t024_004/r1_w1_wl u_t005_030/r3_w0_wl u_t014_005/r3_w1_wl u_t030_027/c1_w0_bl
+ u_t015_017/c1_w0_bl u_t003_012/c0_w1_br gf180mcu_as_sc_mcu7t3v3__inv_2_1682/Y u_t026_014/c3_w1_bl
+ gf180mcu_as_sc_mcu7t3v3__inv_2_338/Y u_t012_004/r0_w1_wl u_t020_028/c3_w0_bl u_t000_021/c3_w0_br
+ u_t009_027/r2_w0_wl u_t031_021/c1_w0_bl u_t031_028/r1_w0_wl gf180mcu_as_sc_mcu7t3v3__inv_2_66/Y
+ u_t002_005/r2_w1_wl u_t007_023/c3_w1_bl u_t021_022/c3_w0_bl u_t003_027/c2_r0_rbl
+ u_t021_029/r3_w0_wl u_t003_017/c0_w0_bl u_t028_027/c1_w0_bl u_t012_030/c1_w0_bl
+ u_t021_005/c1_w1_bl u_t003_012/c2_r1_rbl u_t002_031/c3_w0_bl u_t018_028/c3_w0_bl
+ u_t029_021/c1_w0_bl u_t029_028/r1_w0_wl u_t003_014/c3_r0_rbl u_t011_006/c3_w1_bl
+ u_t002_014/c1_w1_bl u_t019_022/c3_w0_bl u_t019_029/r3_w0_wl u_t003_015/c3_w1_br
+ gf180mcu_as_sc_mcu7t3v3__inv_2_1379/Y VSUBS u_t019_005/c1_w1_bl u_t023_000/r1_w1_wl
+ u_t017_028/r0_w0_wl u_t002_004/c3_w0_br u_t013_019/c1_w0_bl u_t024_016/c3_w1_bl
+ u_t009_006/c3_w1_bl u_t013_001/r3_w1_wl u_t007_029/r2_w0_wl u_t000_003/c0_w0_br
+ u_t025_010/c3_w1_bl u_t000_000/c2_w1_bl u_t000_026/c0_r0_rbl u_t011_000/r0_w1_wl
+ u_t026_029/c1_w0_bl gf180mcu_as_sc_mcu7t3v3__inv_2_344/Y u_t003_024/c0_w1_bl a_200_59000#
+ u_t001_001/r2_w1_wl u_t000_011/c0_r1_rbl a_14200_36600# u_t027_023/c1_w0_bl u_t020_001/c1_w1_bl
+ u_t000_016/c1_w1_bl u_t017_024/c3_w0_bl gf180mcu_as_sc_mcu7t3v3__inv_2_992/A u_t001_010/c1_w1_bl
+ u_t017_007/c1_w1_bl u_t000_006/c3_w0_br u_t022_018/c3_w1_bl u_t007_008/c3_w1_bl
+ u_t000_031/c1_r1_rbl u_t018_001/c1_w1_bl u_t012_015/c1_w0_bl u_t000_010/c0_w1_br
+ u_t003_027/c3_w1_bl u_t023_012/c3_w1_bl u_t019_002/r1_w1_wl u_t004_021/c3_w1_bl
+ gf180mcu_as_sc_mcu7t3v3__inv_2_991/A u_t000_020/c3_r0_rbl u_t009_003/r3_w1_wl gf180mcu_as_sc_mcu7t3v3__inv_2_1398/Y
+ u_t031_004/r2_w1_wl gf180mcu_as_sc_mcu7t3v3__inv_2_848/Y u_t025_025/c1_w0_bl VSS
+ u_t007_002/r0_w1_wl gf180mcu_as_sc_mcu7t3v3__inv_2_77/Y u_t015_026/c3_w0_bl u_t001_004/c0_r1_rbl
+ gf180mcu_as_sc_mcu7t3v3__inv_2_684/A u_t015_009/c1_w1_bl u_t002_010/c2_w0_br u_t031_030/c3_w0_bl
Xgf180mcu_as_sc_mcu7t3v3__inv_2_1577 gf180mcu_as_sc_mcu7t3v3__inv_2_1577/VDD gf180mcu_as_sc_mcu7t3v3__inv_2_1581/VDD
+ gf180mcu_as_sc_mcu7t3v3__inv_2_1577/Y VSS gf180mcu_as_sc_mcu7t3v3__inv_2_1577/VNW
+ VSUBS gf180mcu_as_sc_mcu7t3v3__inv_2
Xgf180mcu_as_sc_mcu7t3v3__inv_2_1588 gf180mcu_as_sc_mcu7t3v3__inv_2_1589/VDD gf180mcu_as_sc_mcu7t3v3__inv_2_1589/VSS
+ gf180mcu_as_sc_mcu7t3v3__inv_2_1588/Y VSS gf180mcu_as_sc_mcu7t3v3__inv_2_1589/VNW
+ VSUBS gf180mcu_as_sc_mcu7t3v3__inv_2
Xgf180mcu_as_sc_mcu7t3v3__inv_2_1555 gf180mcu_as_sc_mcu7t3v3__inv_2_1589/VSS VSS VSS
+ VSS gf180mcu_as_sc_mcu7t3v3__inv_2_1557/VNW VSUBS gf180mcu_as_sc_mcu7t3v3__inv_2
Xgf180mcu_as_sc_mcu7t3v3__inv_2_1566 VSS VSS VSS VSS gf180mcu_as_sc_mcu7t3v3__inv_2_1570/VNW
+ VSUBS gf180mcu_as_sc_mcu7t3v3__inv_2
Xgf180mcu_as_sc_mcu7t3v3__inv_2_1599 VSS gf180mcu_as_sc_mcu7t3v3__inv_2_1653/VDD gf180mcu_as_sc_mcu7t3v3__inv_2_1682/Y
+ gf180mcu_as_sc_mcu7t3v3__inv_2_1682/Y gf180mcu_as_sc_mcu7t3v3__inv_2_1652/VNW VSUBS
+ gf180mcu_as_sc_mcu7t3v3__inv_2
Xgf180mcu_as_sc_mcu7t3v3__nand4_2_338 gf180mcu_as_sc_mcu7t3v3__inv_2_1132/VDD gf180mcu_as_sc_mcu7t3v3__inv_2_1135/VDD
+ VSS VSS VSS VSS VSS gf180mcu_as_sc_mcu7t3v3__inv_2_1132/VNW VSUBS gf180mcu_as_sc_mcu7t3v3__nand4_2
Xgf180mcu_as_sc_mcu7t3v3__nand4_2_349 VSS VSS VSS VSS VSS VSS VSS gf180mcu_as_sc_mcu7t3v3__inv_2_1195/VNW
+ VSUBS gf180mcu_as_sc_mcu7t3v3__nand4_2
Xgf180mcu_as_sc_mcu7t3v3__nand4_2_327 gf180mcu_as_sc_mcu7t3v3__inv_2_1096/VDD VSS
+ VSS VSS VSS VSS VSS gf180mcu_as_sc_mcu7t3v3__inv_2_1096/VNW VSUBS gf180mcu_as_sc_mcu7t3v3__nand4_2
Xgf180mcu_as_sc_mcu7t3v3__nand4_2_316 gf180mcu_as_sc_mcu7t3v3__inv_2_1016/VDD VSS
+ VSS VSS VSS VSS VSS gf180mcu_as_sc_mcu7t3v3__inv_2_1016/VNW VSUBS gf180mcu_as_sc_mcu7t3v3__nand4_2
Xgf180mcu_as_sc_mcu7t3v3__nand4_2_305 VSS gf180mcu_as_sc_mcu7t3v3__inv_2_1042/VDD
+ VSS VSS VSS VSS VSS gf180mcu_as_sc_mcu7t3v3__inv_2_1038/VNW VSUBS gf180mcu_as_sc_mcu7t3v3__nand4_2
Xu_t029_026 u_t029_026/c0_w0_bl u_t029_026/c0_w0_br u_t029_026/c0_w1_bl u_t029_026/c0_w1_br
+ u_t029_026/c0_r0_rbl u_t029_026/c0_r1_rbl u_t029_026/c1_w0_bl u_t029_026/c1_w0_br
+ u_t029_026/c1_w1_bl u_t029_026/c1_w1_br u_t029_026/c1_r0_rbl u_t029_026/c1_r1_rbl
+ u_t029_026/c2_w0_bl u_t029_026/c2_w0_br u_t029_026/c2_w1_bl u_t029_026/c2_w1_br
+ u_t029_026/c2_r0_rbl u_t029_026/c2_r1_rbl u_t029_026/c3_w0_bl u_t029_026/c3_w0_br
+ u_t029_026/c3_w1_bl u_t029_026/c3_w1_br u_t029_026/c3_r0_rbl u_t029_026/c3_r1_rbl
+ u_t029_026/r0_w0_wl u_t029_026/r0_w1_wl u_t029_026/r0_r0_rwl u_t029_026/r0_r1_rwl
+ u_t029_026/r1_w0_wl u_t029_026/r1_w1_wl u_t029_026/r1_r0_rwl u_t029_026/r1_r1_rwl
+ u_t029_026/r2_w0_wl u_t029_026/r2_w1_wl u_t029_026/r2_r0_rwl u_t029_026/r2_r1_rwl
+ u_t029_026/r3_w0_wl u_t029_026/r3_w1_wl u_t029_026/r3_r0_rwl u_t029_026/r3_r1_rwl
+ u_t029_026/VDD u_t029_031/VSS VSUBS detronyx_12t_2w2r_rc4_4x4_routed_5layer_direct
Xu_t029_015 u_t029_015/c0_w0_bl u_t029_015/c0_w0_br u_t029_015/c0_w1_bl u_t029_015/c0_w1_br
+ u_t029_015/c0_r0_rbl u_t029_015/c0_r1_rbl u_t029_015/c1_w0_bl u_t029_015/c1_w0_br
+ u_t029_015/c1_w1_bl u_t029_015/c1_w1_br u_t029_015/c1_r0_rbl u_t029_015/c1_r1_rbl
+ u_t029_015/c2_w0_bl u_t029_015/c2_w0_br u_t029_015/c2_w1_bl u_t029_015/c2_w1_br
+ u_t029_015/c2_r0_rbl u_t029_015/c2_r1_rbl u_t029_015/c3_w0_bl u_t029_015/c3_w0_br
+ u_t029_015/c3_w1_bl u_t029_015/c3_w1_br u_t029_015/c3_r0_rbl u_t029_015/c3_r1_rbl
+ u_t029_015/r0_w0_wl u_t029_015/r0_w1_wl u_t029_015/r0_r0_rwl u_t029_015/r0_r1_rwl
+ u_t029_015/r1_w0_wl u_t029_015/r1_w1_wl u_t029_015/r1_r0_rwl u_t029_015/r1_r1_rwl
+ u_t029_015/r2_w0_wl u_t029_015/r2_w1_wl u_t029_015/r2_r0_rwl u_t029_015/r2_r1_rwl
+ u_t029_015/r3_w0_wl u_t029_015/r3_w1_wl u_t029_015/r3_r0_rwl u_t029_015/r3_r1_rwl
+ VSS u_t029_031/VSS VSUBS detronyx_12t_2w2r_rc4_4x4_routed_5layer_direct
Xu_t029_004 u_t029_004/c0_w0_bl u_t029_004/c0_w0_br u_t029_004/c0_w1_bl u_t029_004/c0_w1_br
+ u_t029_004/c0_r0_rbl u_t029_004/c0_r1_rbl u_t029_004/c1_w0_bl u_t029_004/c1_w0_br
+ u_t029_004/c1_w1_bl u_t029_004/c1_w1_br u_t029_004/c1_r0_rbl u_t029_004/c1_r1_rbl
+ u_t029_004/c2_w0_bl u_t029_004/c2_w0_br u_t029_004/c2_w1_bl u_t029_004/c2_w1_br
+ u_t029_004/c2_r0_rbl u_t029_004/c2_r1_rbl u_t029_004/c3_w0_bl u_t029_004/c3_w0_br
+ u_t029_004/c3_w1_bl u_t029_004/c3_w1_br u_t029_004/c3_r0_rbl u_t029_004/c3_r1_rbl
+ u_t029_004/r0_w0_wl u_t029_004/r0_w1_wl u_t029_004/r0_r0_rwl u_t029_004/r0_r1_rwl
+ u_t029_004/r1_w0_wl u_t029_004/r1_w1_wl u_t029_004/r1_r0_rwl u_t029_004/r1_r1_rwl
+ u_t029_004/r2_w0_wl u_t029_004/r2_w1_wl u_t029_004/r2_r0_rwl u_t029_004/r2_r1_rwl
+ u_t029_004/r3_w0_wl u_t029_004/r3_w1_wl u_t029_004/r3_r0_rwl u_t029_004/r3_r1_rwl
+ u_t029_004/VDD u_t029_031/VSS VSUBS detronyx_12t_2w2r_rc4_4x4_routed_5layer_direct
Xgf180mcu_as_sc_mcu7t3v3__inv_2_1352 gf180mcu_as_sc_mcu7t3v3__inv_2_1400/VDD gf180mcu_as_sc_mcu7t3v3__inv_2_1400/VSS
+ gf180mcu_as_sc_mcu7t3v3__inv_2_1352/Y gf180mcu_as_sc_mcu7t3v3__inv_2_1685/Y gf180mcu_as_sc_mcu7t3v3__inv_2_1400/VNW
+ VSUBS gf180mcu_as_sc_mcu7t3v3__inv_2
Xgf180mcu_as_sc_mcu7t3v3__inv_2_1385 VSS VSS gf180mcu_as_sc_mcu7t3v3__inv_2_1387/Y
+ VSS gf180mcu_as_sc_mcu7t3v3__inv_2_1385/VNW VSUBS gf180mcu_as_sc_mcu7t3v3__inv_2
Xgf180mcu_as_sc_mcu7t3v3__inv_2_1363 VSS gf180mcu_as_sc_mcu7t3v3__inv_2_1387/VDD gf180mcu_as_sc_mcu7t3v3__inv_2_1363/Y
+ gf180mcu_as_sc_mcu7t3v3__inv_2_1387/Y gf180mcu_as_sc_mcu7t3v3__inv_2_1386/VNW VSUBS
+ gf180mcu_as_sc_mcu7t3v3__inv_2
Xgf180mcu_as_sc_mcu7t3v3__inv_2_1341 gf180mcu_as_sc_mcu7t3v3__inv_2_1390/VDD gf180mcu_as_sc_mcu7t3v3__inv_2_1391/VDD
+ gf180mcu_as_sc_mcu7t3v3__inv_2_1341/Y gf180mcu_as_sc_mcu7t3v3__inv_2_1398/Y gf180mcu_as_sc_mcu7t3v3__inv_2_1390/VNW
+ VSUBS gf180mcu_as_sc_mcu7t3v3__inv_2
Xgf180mcu_as_sc_mcu7t3v3__inv_2_1330 VSS VSS VSS gf180mcu_as_sc_mcu7t3v3__inv_2_1691/Y
+ gf180mcu_as_sc_mcu7t3v3__inv_2_1380/VNW VSUBS gf180mcu_as_sc_mcu7t3v3__inv_2
Xgf180mcu_as_sc_mcu7t3v3__inv_2_1374 VSS gf180mcu_as_sc_mcu7t3v3__inv_2_1375/VDD gf180mcu_as_sc_mcu7t3v3__inv_2_1379/Y
+ VSS gf180mcu_as_sc_mcu7t3v3__inv_2_1374/VNW VSUBS gf180mcu_as_sc_mcu7t3v3__inv_2
Xgf180mcu_as_sc_mcu7t3v3__inv_2_1396 gf180mcu_as_sc_mcu7t3v3__inv_2_1398/VSS gf180mcu_as_sc_mcu7t3v3__inv_2_1397/VSS
+ gf180mcu_as_sc_mcu7t3v3__inv_2_1396/Y gf180mcu_as_sc_mcu7t3v3__inv_2_1398/Y gf180mcu_as_sc_mcu7t3v3__inv_2_1397/VNW
+ VSUBS gf180mcu_as_sc_mcu7t3v3__inv_2
Xgf180mcu_as_sc_mcu7t3v3__inv_2_825 VSS VSS VSS VSS gf180mcu_as_sc_mcu7t3v3__inv_2_829/VNW
+ VSUBS gf180mcu_as_sc_mcu7t3v3__inv_2
Xgf180mcu_as_sc_mcu7t3v3__inv_2_814 VSS VSS VSS VSS gf180mcu_as_sc_mcu7t3v3__inv_2_816/VNW
+ VSUBS gf180mcu_as_sc_mcu7t3v3__inv_2
Xgf180mcu_as_sc_mcu7t3v3__inv_2_803 VSS VSS VSS VSS gf180mcu_as_sc_mcu7t3v3__inv_2_804/VNW
+ VSUBS gf180mcu_as_sc_mcu7t3v3__inv_2
Xgf180mcu_as_sc_mcu7t3v3__inv_2_836 VSS VSS VSS VSS gf180mcu_as_sc_mcu7t3v3__inv_2_836/VNW
+ VSUBS gf180mcu_as_sc_mcu7t3v3__inv_2
Xgf180mcu_as_sc_mcu7t3v3__inv_2_847 gf180mcu_as_sc_mcu7t3v3__inv_2_849/VDD gf180mcu_as_sc_mcu7t3v3__inv_2_849/VSS
+ gf180mcu_as_sc_mcu7t3v3__inv_2_847/Y gf180mcu_as_sc_mcu7t3v3__inv_2_848/Y gf180mcu_as_sc_mcu7t3v3__inv_2_849/VNW
+ VSUBS gf180mcu_as_sc_mcu7t3v3__inv_2
Xgf180mcu_as_sc_mcu7t3v3__inv_2_858 VSS VSS VSS VSS gf180mcu_as_sc_mcu7t3v3__inv_2_860/VNW
+ VSUBS gf180mcu_as_sc_mcu7t3v3__inv_2
Xgf180mcu_as_sc_mcu7t3v3__inv_2_869 VSS VSS VSS VSS gf180mcu_as_sc_mcu7t3v3__inv_2_885/VNW
+ VSUBS gf180mcu_as_sc_mcu7t3v3__inv_2
Xgf180mcu_as_sc_mcu7t3v3__nand4_2_146 VSS VSS VSS VSS VSS VSS gf180mcu_as_sc_mcu7t3v3__nand4_2_146/Y
+ gf180mcu_as_sc_mcu7t3v3__inv_2_531/VNW VSUBS gf180mcu_as_sc_mcu7t3v3__nand4_2
Xgf180mcu_as_sc_mcu7t3v3__nand4_2_124 VSS VSS VSS VSS VSS VSS VSS gf180mcu_as_sc_mcu7t3v3__inv_2_558/VNW
+ VSUBS gf180mcu_as_sc_mcu7t3v3__nand4_2
Xgf180mcu_as_sc_mcu7t3v3__nand4_2_157 gf180mcu_as_sc_mcu7t3v3__inv_2_584/VDD gf180mcu_as_sc_mcu7t3v3__inv_2_584/VDD
+ VSS VSS VSS VSS VSS gf180mcu_as_sc_mcu7t3v3__inv_2_580/VNW VSUBS gf180mcu_as_sc_mcu7t3v3__nand4_2
Xgf180mcu_as_sc_mcu7t3v3__nand4_2_168 gf180mcu_as_sc_mcu7t3v3__inv_2_629/VDD gf180mcu_as_sc_mcu7t3v3__inv_2_633/VDD
+ VSS VSS VSS VSS VSS gf180mcu_as_sc_mcu7t3v3__inv_2_629/VNW VSUBS gf180mcu_as_sc_mcu7t3v3__nand4_2
Xgf180mcu_as_sc_mcu7t3v3__nand4_2_135 VSS VSS VSS VSS VSS VSS VSS gf180mcu_as_sc_mcu7t3v3__inv_2_526/VNW
+ VSUBS gf180mcu_as_sc_mcu7t3v3__nand4_2
Xgf180mcu_as_sc_mcu7t3v3__nand4_2_102 gf180mcu_as_sc_mcu7t3v3__inv_2_354/VDD gf180mcu_as_sc_mcu7t3v3__inv_2_355/VDD
+ VSS VSS VSS VSS VSS gf180mcu_as_sc_mcu7t3v3__inv_2_354/VNW VSUBS gf180mcu_as_sc_mcu7t3v3__nand4_2
Xgf180mcu_as_sc_mcu7t3v3__nand4_2_179 VSS gf180mcu_as_sc_mcu7t3v3__inv_2_695/VDD VSS
+ VSS VSS VSS VSS gf180mcu_as_sc_mcu7t3v3__inv_2_691/VNW VSUBS gf180mcu_as_sc_mcu7t3v3__nand4_2
Xgf180mcu_as_sc_mcu7t3v3__nand4_2_113 gf180mcu_as_sc_mcu7t3v3__inv_2_337/VDD gf180mcu_as_sc_mcu7t3v3__inv_2_338/VDD
+ VSS VSS VSS VSS VSS gf180mcu_as_sc_mcu7t3v3__inv_2_337/VNW VSUBS gf180mcu_as_sc_mcu7t3v3__nand4_2
Xu_t026_029 u_t026_029/c0_w0_bl u_t026_029/c0_w0_br u_t026_029/c0_w1_bl u_t026_029/c0_w1_br
+ u_t026_029/c0_r0_rbl u_t026_029/c0_r1_rbl u_t026_029/c1_w0_bl u_t026_029/c1_w0_br
+ u_t026_029/c1_w1_bl u_t026_029/c1_w1_br u_t026_029/c1_r0_rbl u_t026_029/c1_r1_rbl
+ u_t026_029/c2_w0_bl u_t026_029/c2_w0_br u_t026_029/c2_w1_bl u_t026_029/c2_w1_br
+ u_t026_029/c2_r0_rbl u_t026_029/c2_r1_rbl u_t026_029/c3_w0_bl u_t026_029/c3_w0_br
+ u_t026_029/c3_w1_bl u_t026_029/c3_w1_br u_t026_029/c3_r0_rbl u_t026_029/c3_r1_rbl
+ u_t026_029/r0_w0_wl u_t026_029/r0_w1_wl u_t026_029/r0_r0_rwl u_t026_029/r0_r1_rwl
+ u_t026_029/r1_w0_wl u_t026_029/r1_w1_wl u_t026_029/r1_r0_rwl u_t026_029/r1_r1_rwl
+ u_t026_029/r2_w0_wl u_t026_029/r2_w1_wl u_t026_029/r2_r0_rwl u_t026_029/r2_r1_rwl
+ u_t026_029/r3_w0_wl u_t026_029/r3_w1_wl u_t026_029/r3_r0_rwl u_t026_029/r3_r1_rwl
+ u_t026_029/VDD u_t026_031/VSS VSUBS detronyx_12t_2w2r_rc4_4x4_routed_5layer_direct
Xu_t026_018 u_t026_018/c0_w0_bl u_t026_018/c0_w0_br u_t026_018/c0_w1_bl u_t026_018/c0_w1_br
+ u_t026_018/c0_r0_rbl u_t026_018/c0_r1_rbl u_t026_018/c1_w0_bl u_t026_018/c1_w0_br
+ u_t026_018/c1_w1_bl u_t026_018/c1_w1_br u_t026_018/c1_r0_rbl u_t026_018/c1_r1_rbl
+ u_t026_018/c2_w0_bl u_t026_018/c2_w0_br u_t026_018/c2_w1_bl u_t026_018/c2_w1_br
+ u_t026_018/c2_r0_rbl u_t026_018/c2_r1_rbl u_t026_018/c3_w0_bl u_t026_018/c3_w0_br
+ u_t026_018/c3_w1_bl u_t026_018/c3_w1_br u_t026_018/c3_r0_rbl u_t026_018/c3_r1_rbl
+ u_t026_018/r0_w0_wl u_t026_018/r0_w1_wl u_t026_018/r0_r0_rwl u_t026_018/r0_r1_rwl
+ u_t026_018/r1_w0_wl u_t026_018/r1_w1_wl u_t026_018/r1_r0_rwl u_t026_018/r1_r1_rwl
+ u_t026_018/r2_w0_wl u_t026_018/r2_w1_wl u_t026_018/r2_r0_rwl u_t026_018/r2_r1_rwl
+ u_t026_018/r3_w0_wl u_t026_018/r3_w1_wl u_t026_018/r3_r0_rwl u_t026_018/r3_r1_rwl
+ u_t026_018/VDD u_t026_031/VSS VSUBS detronyx_12t_2w2r_rc4_4x4_routed_5layer_direct
Xu_t026_007 u_t026_007/c0_w0_bl u_t026_007/c0_w0_br u_t026_007/c0_w1_bl u_t026_007/c0_w1_br
+ u_t026_007/c0_r0_rbl u_t026_007/c0_r1_rbl u_t026_007/c1_w0_bl u_t026_007/c1_w0_br
+ u_t026_007/c1_w1_bl u_t026_007/c1_w1_br u_t026_007/c1_r0_rbl u_t026_007/c1_r1_rbl
+ u_t026_007/c2_w0_bl u_t026_007/c2_w0_br u_t026_007/c2_w1_bl u_t026_007/c2_w1_br
+ u_t026_007/c2_r0_rbl u_t026_007/c2_r1_rbl u_t026_007/c3_w0_bl u_t026_007/c3_w0_br
+ u_t026_007/c3_w1_bl u_t026_007/c3_w1_br u_t026_007/c3_r0_rbl u_t026_007/c3_r1_rbl
+ u_t026_007/r0_w0_wl u_t026_007/r0_w1_wl u_t026_007/r0_r0_rwl u_t026_007/r0_r1_rwl
+ u_t026_007/r1_w0_wl u_t026_007/r1_w1_wl u_t026_007/r1_r0_rwl u_t026_007/r1_r1_rwl
+ u_t026_007/r2_w0_wl u_t026_007/r2_w1_wl u_t026_007/r2_r0_rwl u_t026_007/r2_r1_rwl
+ u_t026_007/r3_w0_wl u_t026_007/r3_w1_wl u_t026_007/r3_r0_rwl u_t026_007/r3_r1_rwl
+ VSS u_t026_031/VSS VSUBS detronyx_12t_2w2r_rc4_4x4_routed_5layer_direct
Xgf180mcu_as_sc_mcu7t3v3__nand4_2_30 gf180mcu_as_sc_mcu7t3v3__inv_2_95/VDD VSS VSS
+ VSS VSS VSS VSS gf180mcu_as_sc_mcu7t3v3__inv_2_95/VNW VSUBS gf180mcu_as_sc_mcu7t3v3__nand4_2
Xgf180mcu_as_sc_mcu7t3v3__nand4_2_41 gf180mcu_as_sc_mcu7t3v3__inv_2_138/VDD VSS VSS
+ VSS VSS VSS VSS gf180mcu_as_sc_mcu7t3v3__inv_2_138/VNW VSUBS gf180mcu_as_sc_mcu7t3v3__nand4_2
Xgf180mcu_as_sc_mcu7t3v3__nand4_2_63 gf180mcu_as_sc_mcu7t3v3__inv_2_200/VDD VSS VSS
+ VSS VSS VSS VSS gf180mcu_as_sc_mcu7t3v3__inv_2_200/VNW VSUBS gf180mcu_as_sc_mcu7t3v3__nand4_2
Xgf180mcu_as_sc_mcu7t3v3__nand4_2_96 gf180mcu_as_sc_mcu7t3v3__inv_2_351/VDD VSS VSS
+ VSS VSS VSS VSS gf180mcu_as_sc_mcu7t3v3__inv_2_351/VNW VSUBS gf180mcu_as_sc_mcu7t3v3__nand4_2
Xgf180mcu_as_sc_mcu7t3v3__nand4_2_74 gf180mcu_as_sc_mcu7t3v3__inv_2_205/VDD VSS VSS
+ VSS VSS VSS VSS gf180mcu_as_sc_mcu7t3v3__inv_2_205/VNW VSUBS gf180mcu_as_sc_mcu7t3v3__nand4_2
Xgf180mcu_as_sc_mcu7t3v3__nand4_2_52 VSS gf180mcu_as_sc_mcu7t3v3__inv_2_228/VSS VSS
+ VSS VSS VSS gf180mcu_as_sc_mcu7t3v3__nand4_2_52/Y gf180mcu_as_sc_mcu7t3v3__inv_2_228/VNW
+ VSUBS gf180mcu_as_sc_mcu7t3v3__nand4_2
Xgf180mcu_as_sc_mcu7t3v3__nand4_2_85 gf180mcu_as_sc_mcu7t3v3__inv_2_257/VDD gf180mcu_as_sc_mcu7t3v3__inv_2_257/VSS
+ VSS VSS VSS VSS gf180mcu_as_sc_mcu7t3v3__nand4_2_85/Y gf180mcu_as_sc_mcu7t3v3__inv_2_257/VNW
+ VSUBS gf180mcu_as_sc_mcu7t3v3__nand4_2
Xu_t017_029 u_t017_029/c0_w0_bl u_t017_029/c0_w0_br u_t017_029/c0_w1_bl u_t017_029/c0_w1_br
+ u_t017_029/c0_r0_rbl u_t017_029/c0_r1_rbl u_t017_029/c1_w0_bl u_t017_029/c1_w0_br
+ u_t017_029/c1_w1_bl u_t017_029/c1_w1_br u_t017_029/c1_r0_rbl u_t017_029/c1_r1_rbl
+ u_t017_029/c2_w0_bl u_t017_029/c2_w0_br u_t017_029/c2_w1_bl u_t017_029/c2_w1_br
+ u_t017_029/c2_r0_rbl u_t017_029/c2_r1_rbl u_t017_029/c3_w0_bl u_t017_029/c3_w0_br
+ u_t017_029/c3_w1_bl u_t017_029/c3_w1_br u_t017_029/c3_r0_rbl u_t017_029/c3_r1_rbl
+ u_t017_029/r0_w0_wl u_t017_029/r0_w1_wl u_t017_029/r0_r0_rwl u_t017_029/r0_r1_rwl
+ u_t017_029/r1_w0_wl u_t017_029/r1_w1_wl u_t017_029/r1_r0_rwl u_t017_029/r1_r1_rwl
+ u_t017_029/r2_w0_wl u_t017_029/r2_w1_wl u_t017_029/r2_r0_rwl u_t017_029/r2_r1_rwl
+ u_t017_029/r3_w0_wl u_t017_029/r3_w1_wl u_t017_029/r3_r0_rwl u_t017_029/r3_r1_rwl
+ u_t017_029/VDD u_t017_031/VSS VSUBS detronyx_12t_2w2r_rc4_4x4_routed_5layer_direct
Xu_t017_018 u_t017_018/c0_w0_bl u_t017_018/c0_w0_br u_t017_018/c0_w1_bl u_t017_018/c0_w1_br
+ u_t017_018/c0_r0_rbl u_t017_018/c0_r1_rbl u_t017_018/c1_w0_bl u_t017_018/c1_w0_br
+ u_t017_018/c1_w1_bl u_t017_018/c1_w1_br u_t017_018/c1_r0_rbl u_t017_018/c1_r1_rbl
+ u_t017_018/c2_w0_bl u_t017_018/c2_w0_br u_t017_018/c2_w1_bl u_t017_018/c2_w1_br
+ u_t017_018/c2_r0_rbl u_t017_018/c2_r1_rbl u_t017_018/c3_w0_bl u_t017_018/c3_w0_br
+ u_t017_018/c3_w1_bl u_t017_018/c3_w1_br u_t017_018/c3_r0_rbl u_t017_018/c3_r1_rbl
+ u_t017_018/r0_w0_wl u_t017_018/r0_w1_wl u_t017_018/r0_r0_rwl u_t017_018/r0_r1_rwl
+ u_t017_018/r1_w0_wl u_t017_018/r1_w1_wl u_t017_018/r1_r0_rwl u_t017_018/r1_r1_rwl
+ u_t017_018/r2_w0_wl u_t017_018/r2_w1_wl u_t017_018/r2_r0_rwl u_t017_018/r2_r1_rwl
+ u_t017_018/r3_w0_wl u_t017_018/r3_w1_wl u_t017_018/r3_r0_rwl u_t017_018/r3_r1_rwl
+ u_t017_018/VDD u_t017_031/VSS VSUBS detronyx_12t_2w2r_rc4_4x4_routed_5layer_direct
Xu_t017_007 u_t017_007/c0_w0_bl u_t017_007/c0_w0_br u_t017_007/c0_w1_bl u_t017_007/c0_w1_br
+ u_t017_007/c0_r0_rbl u_t017_007/c0_r1_rbl u_t017_007/c1_w0_bl u_t017_007/c1_w0_br
+ u_t017_007/c1_w1_bl u_t017_007/c1_w1_br u_t017_007/c1_r0_rbl u_t017_007/c1_r1_rbl
+ u_t017_007/c2_w0_bl u_t017_007/c2_w0_br u_t017_007/c2_w1_bl u_t017_007/c2_w1_br
+ u_t017_007/c2_r0_rbl u_t017_007/c2_r1_rbl u_t017_007/c3_w0_bl u_t017_007/c3_w0_br
+ u_t017_007/c3_w1_bl u_t017_007/c3_w1_br u_t017_007/c3_r0_rbl u_t017_007/c3_r1_rbl
+ u_t017_007/r0_w0_wl u_t017_007/r0_w1_wl u_t017_007/r0_r0_rwl u_t017_007/r0_r1_rwl
+ u_t017_007/r1_w0_wl u_t017_007/r1_w1_wl u_t017_007/r1_r0_rwl u_t017_007/r1_r1_rwl
+ u_t017_007/r2_w0_wl u_t017_007/r2_w1_wl u_t017_007/r2_r0_rwl u_t017_007/r2_r1_rwl
+ u_t017_007/r3_w0_wl u_t017_007/r3_w1_wl u_t017_007/r3_r0_rwl u_t017_007/r3_r1_rwl
+ VSS u_t017_031/VSS VSUBS detronyx_12t_2w2r_rc4_4x4_routed_5layer_direct
Xgf180mcu_as_sc_mcu7t3v3__inv_2_1160 VSS VSS gf180mcu_as_sc_mcu7t3v3__inv_2_1160/Y
+ VSS gf180mcu_as_sc_mcu7t3v3__inv_2_1160/VNW VSUBS gf180mcu_as_sc_mcu7t3v3__inv_2
Xgf180mcu_as_sc_mcu7t3v3__inv_2_1171 VSS VSS VSS VSS gf180mcu_as_sc_mcu7t3v3__inv_2_1171/VNW
+ VSUBS gf180mcu_as_sc_mcu7t3v3__inv_2
Xgf180mcu_as_sc_mcu7t3v3__inv_2_1182 VSS VSS gf180mcu_as_sc_mcu7t3v3__inv_2_1182/Y
+ VSS gf180mcu_as_sc_mcu7t3v3__inv_2_1182/VNW VSUBS gf180mcu_as_sc_mcu7t3v3__inv_2
Xgf180mcu_as_sc_mcu7t3v3__inv_2_1193 VSS VSS VSS VSS gf180mcu_as_sc_mcu7t3v3__inv_2_1194/VNW
+ VSUBS gf180mcu_as_sc_mcu7t3v3__inv_2
Xu_t008_029 u_t008_029/c0_w0_bl u_t008_029/c0_w0_br u_t008_029/c0_w1_bl u_t008_029/c0_w1_br
+ u_t008_029/c0_r0_rbl u_t008_029/c0_r1_rbl u_t008_029/c1_w0_bl u_t008_029/c1_w0_br
+ u_t008_029/c1_w1_bl u_t008_029/c1_w1_br u_t008_029/c1_r0_rbl u_t008_029/c1_r1_rbl
+ u_t008_029/c2_w0_bl u_t008_029/c2_w0_br u_t008_029/c2_w1_bl u_t008_029/c2_w1_br
+ u_t008_029/c2_r0_rbl u_t008_029/c2_r1_rbl u_t008_029/c3_w0_bl u_t008_029/c3_w0_br
+ u_t008_029/c3_w1_bl u_t008_029/c3_w1_br u_t008_029/c3_r0_rbl u_t008_029/c3_r1_rbl
+ u_t008_029/r0_w0_wl u_t008_029/r0_w1_wl u_t008_029/r0_r0_rwl u_t008_029/r0_r1_rwl
+ u_t008_029/r1_w0_wl u_t008_029/r1_w1_wl u_t008_029/r1_r0_rwl u_t008_029/r1_r1_rwl
+ u_t008_029/r2_w0_wl u_t008_029/r2_w1_wl u_t008_029/r2_r0_rwl u_t008_029/r2_r1_rwl
+ u_t008_029/r3_w0_wl u_t008_029/r3_w1_wl u_t008_029/r3_r0_rwl u_t008_029/r3_r1_rwl
+ u_t008_029/VDD u_t008_031/VSS VSUBS detronyx_12t_2w2r_rc4_4x4_routed_5layer_direct
Xu_t008_018 u_t008_018/c0_w0_bl u_t008_018/c0_w0_br u_t008_018/c0_w1_bl u_t008_018/c0_w1_br
+ u_t008_018/c0_r0_rbl u_t008_018/c0_r1_rbl u_t008_018/c1_w0_bl u_t008_018/c1_w0_br
+ u_t008_018/c1_w1_bl u_t008_018/c1_w1_br u_t008_018/c1_r0_rbl u_t008_018/c1_r1_rbl
+ u_t008_018/c2_w0_bl u_t008_018/c2_w0_br u_t008_018/c2_w1_bl u_t008_018/c2_w1_br
+ u_t008_018/c2_r0_rbl u_t008_018/c2_r1_rbl u_t008_018/c3_w0_bl u_t008_018/c3_w0_br
+ u_t008_018/c3_w1_bl u_t008_018/c3_w1_br u_t008_018/c3_r0_rbl u_t008_018/c3_r1_rbl
+ u_t008_018/r0_w0_wl u_t008_018/r0_w1_wl u_t008_018/r0_r0_rwl u_t008_018/r0_r1_rwl
+ u_t008_018/r1_w0_wl u_t008_018/r1_w1_wl u_t008_018/r1_r0_rwl u_t008_018/r1_r1_rwl
+ u_t008_018/r2_w0_wl u_t008_018/r2_w1_wl u_t008_018/r2_r0_rwl u_t008_018/r2_r1_rwl
+ u_t008_018/r3_w0_wl u_t008_018/r3_w1_wl u_t008_018/r3_r0_rwl u_t008_018/r3_r1_rwl
+ u_t008_018/VDD u_t008_031/VSS VSUBS detronyx_12t_2w2r_rc4_4x4_routed_5layer_direct
Xu_t031_010 u_t031_010/c0_w0_bl u_t031_010/c0_w0_br u_t031_010/c0_w1_bl u_t031_010/c0_w1_br
+ u_t031_010/c0_r0_rbl u_t031_010/c0_r1_rbl u_t031_010/c1_w0_bl u_t031_010/c1_w0_br
+ u_t031_010/c1_w1_bl u_t031_010/c1_w1_br u_t031_010/c1_r0_rbl u_t031_010/c1_r1_rbl
+ u_t031_010/c2_w0_bl u_t031_010/c2_w0_br u_t031_010/c2_w1_bl u_t031_010/c2_w1_br
+ u_t031_010/c2_r0_rbl u_t031_010/c2_r1_rbl u_t031_010/c3_w0_bl u_t031_010/c3_w0_br
+ u_t031_010/c3_w1_bl u_t031_010/c3_w1_br u_t031_010/c3_r0_rbl u_t031_010/c3_r1_rbl
+ u_t031_010/r0_w0_wl u_t031_010/r0_w1_wl u_t031_010/r0_r0_rwl u_t031_010/r0_r1_rwl
+ u_t031_010/r1_w0_wl u_t031_010/r1_w1_wl u_t031_010/r1_r0_rwl u_t031_010/r1_r1_rwl
+ u_t031_010/r2_w0_wl u_t031_010/r2_w1_wl u_t031_010/r2_r0_rwl u_t031_010/r2_r1_rwl
+ u_t031_010/r3_w0_wl u_t031_010/r3_w1_wl u_t031_010/r3_r0_rwl u_t031_010/r3_r1_rwl
+ VSS u_t031_010/VSS VSUBS detronyx_12t_2w2r_rc4_4x4_routed_5layer_direct
Xu_t008_007 u_t008_007/c0_w0_bl u_t008_007/c0_w0_br u_t008_007/c0_w1_bl u_t008_007/c0_w1_br
+ u_t008_007/c0_r0_rbl u_t008_007/c0_r1_rbl u_t008_007/c1_w0_bl u_t008_007/c1_w0_br
+ u_t008_007/c1_w1_bl u_t008_007/c1_w1_br u_t008_007/c1_r0_rbl u_t008_007/c1_r1_rbl
+ u_t008_007/c2_w0_bl u_t008_007/c2_w0_br u_t008_007/c2_w1_bl u_t008_007/c2_w1_br
+ u_t008_007/c2_r0_rbl u_t008_007/c2_r1_rbl u_t008_007/c3_w0_bl u_t008_007/c3_w0_br
+ u_t008_007/c3_w1_bl u_t008_007/c3_w1_br u_t008_007/c3_r0_rbl u_t008_007/c3_r1_rbl
+ u_t008_007/r0_w0_wl u_t008_007/r0_w1_wl u_t008_007/r0_r0_rwl u_t008_007/r0_r1_rwl
+ u_t008_007/r1_w0_wl u_t008_007/r1_w1_wl u_t008_007/r1_r0_rwl u_t008_007/r1_r1_rwl
+ u_t008_007/r2_w0_wl u_t008_007/r2_w1_wl u_t008_007/r2_r0_rwl u_t008_007/r2_r1_rwl
+ u_t008_007/r3_w0_wl u_t008_007/r3_w1_wl u_t008_007/r3_r0_rwl u_t008_007/r3_r1_rwl
+ VSS u_t008_031/VSS VSUBS detronyx_12t_2w2r_rc4_4x4_routed_5layer_direct
Xgf180mcu_as_sc_mcu7t3v3__inv_2_622 gf180mcu_as_sc_mcu7t3v3__inv_2_626/VDD VSS gf180mcu_as_sc_mcu7t3v3__inv_2_622/Y
+ gf180mcu_as_sc_mcu7t3v3__inv_2_626/Y gf180mcu_as_sc_mcu7t3v3__inv_2_626/VNW VSUBS
+ gf180mcu_as_sc_mcu7t3v3__inv_2
Xgf180mcu_as_sc_mcu7t3v3__inv_2_600 gf180mcu_as_sc_mcu7t3v3__inv_2_601/VDD VSS gf180mcu_as_sc_mcu7t3v3__inv_2_631/A
+ gf180mcu_as_sc_mcu7t3v3__inv_2_601/Y gf180mcu_as_sc_mcu7t3v3__inv_2_601/VNW VSUBS
+ gf180mcu_as_sc_mcu7t3v3__inv_2
Xgf180mcu_as_sc_mcu7t3v3__inv_2_633 gf180mcu_as_sc_mcu7t3v3__inv_2_633/VDD gf180mcu_as_sc_mcu7t3v3__inv_2_633/VSS
+ gf180mcu_as_sc_mcu7t3v3__inv_2_633/Y VSS gf180mcu_as_sc_mcu7t3v3__inv_2_633/VNW
+ VSUBS gf180mcu_as_sc_mcu7t3v3__inv_2
Xgf180mcu_as_sc_mcu7t3v3__inv_2_611 gf180mcu_as_sc_mcu7t3v3__inv_2_616/VDD gf180mcu_as_sc_mcu7t3v3__inv_2_616/VDD
+ gf180mcu_as_sc_mcu7t3v3__inv_2_618/A gf180mcu_as_sc_mcu7t3v3__inv_2_612/Y gf180mcu_as_sc_mcu7t3v3__inv_2_612/VNW
+ VSUBS gf180mcu_as_sc_mcu7t3v3__inv_2
Xgf180mcu_as_sc_mcu7t3v3__inv_2_677 gf180mcu_as_sc_mcu7t3v3__inv_2_679/VDD gf180mcu_as_sc_mcu7t3v3__inv_2_849/VDD
+ gf180mcu_as_sc_mcu7t3v3__inv_2_677/Y gf180mcu_as_sc_mcu7t3v3__inv_2_848/Y gf180mcu_as_sc_mcu7t3v3__inv_2_679/VNW
+ VSUBS gf180mcu_as_sc_mcu7t3v3__inv_2
Xgf180mcu_as_sc_mcu7t3v3__inv_2_666 gf180mcu_as_sc_mcu7t3v3__inv_2_667/VDD gf180mcu_as_sc_mcu7t3v3__inv_2_671/VDD
+ gf180mcu_as_sc_mcu7t3v3__inv_2_666/Y gf180mcu_as_sc_mcu7t3v3__inv_2_667/Y gf180mcu_as_sc_mcu7t3v3__inv_2_667/VNW
+ VSUBS gf180mcu_as_sc_mcu7t3v3__inv_2
Xgf180mcu_as_sc_mcu7t3v3__inv_2_644 VSS gf180mcu_as_sc_mcu7t3v3__inv_2_684/VSS gf180mcu_as_sc_mcu7t3v3__inv_2_644/Y
+ VSS gf180mcu_as_sc_mcu7t3v3__inv_2_684/VNW VSUBS gf180mcu_as_sc_mcu7t3v3__inv_2
Xgf180mcu_as_sc_mcu7t3v3__inv_2_655 VSS gf180mcu_as_sc_mcu7t3v3__inv_2_659/VDD gf180mcu_as_sc_mcu7t3v3__inv_2_655/Y
+ VSS gf180mcu_as_sc_mcu7t3v3__inv_2_655/VNW VSUBS gf180mcu_as_sc_mcu7t3v3__inv_2
Xgf180mcu_as_sc_mcu7t3v3__inv_2_688 VSS gf180mcu_as_sc_mcu7t3v3__inv_2_738/VSS gf180mcu_as_sc_mcu7t3v3__inv_2_738/A
+ VSS gf180mcu_as_sc_mcu7t3v3__inv_2_738/VNW VSUBS gf180mcu_as_sc_mcu7t3v3__inv_2
Xu_t031_021 u_t031_021/c0_w0_bl u_t031_021/c0_w0_br u_t031_021/c0_w1_bl u_t031_021/c0_w1_br
+ u_t031_021/c0_r0_rbl u_t031_021/c0_r1_rbl u_t031_021/c1_w0_bl u_t031_021/c1_w0_br
+ u_t031_021/c1_w1_bl u_t031_021/c1_w1_br u_t031_021/c1_r0_rbl u_t031_021/c1_r1_rbl
+ u_t031_021/c2_w0_bl u_t031_021/c2_w0_br u_t031_021/c2_w1_bl u_t031_021/c2_w1_br
+ u_t031_021/c2_r0_rbl u_t031_021/c2_r1_rbl u_t031_021/c3_w0_bl u_t031_021/c3_w0_br
+ u_t031_021/c3_w1_bl u_t031_021/c3_w1_br u_t031_021/c3_r0_rbl u_t031_021/c3_r1_rbl
+ u_t031_021/r0_w0_wl u_t031_021/r0_w1_wl u_t031_021/r0_r0_rwl u_t031_021/r0_r1_rwl
+ u_t031_021/r1_w0_wl u_t031_021/r1_w1_wl u_t031_021/r1_r0_rwl u_t031_021/r1_r1_rwl
+ u_t031_021/r2_w0_wl u_t031_021/r2_w1_wl u_t031_021/r2_r0_rwl u_t031_021/r2_r1_rwl
+ u_t031_021/r3_w0_wl u_t031_021/r3_w1_wl u_t031_021/r3_r0_rwl u_t031_021/r3_r1_rwl
+ u_t031_021/VDD u_t031_024/VSS VSUBS detronyx_12t_2w2r_rc4_4x4_routed_5layer_direct
Xgf180mcu_as_sc_mcu7t3v3__inv_2_699 VSS VSS gf180mcu_as_sc_mcu7t3v3__inv_2_699/Y VSS
+ gf180mcu_as_sc_mcu7t3v3__inv_2_699/VNW VSUBS gf180mcu_as_sc_mcu7t3v3__inv_2
Xu_t022_021 u_t022_021/c0_w0_bl u_t022_021/c0_w0_br u_t022_021/c0_w1_bl u_t022_021/c0_w1_br
+ u_t022_021/c0_r0_rbl u_t022_021/c0_r1_rbl u_t022_021/c1_w0_bl u_t022_021/c1_w0_br
+ u_t022_021/c1_w1_bl u_t022_021/c1_w1_br u_t022_021/c1_r0_rbl u_t022_021/c1_r1_rbl
+ u_t022_021/c2_w0_bl u_t022_021/c2_w0_br u_t022_021/c2_w1_bl u_t022_021/c2_w1_br
+ u_t022_021/c2_r0_rbl u_t022_021/c2_r1_rbl u_t022_021/c3_w0_bl u_t022_021/c3_w0_br
+ u_t022_021/c3_w1_bl u_t022_021/c3_w1_br u_t022_021/c3_r0_rbl u_t022_021/c3_r1_rbl
+ u_t022_021/r0_w0_wl u_t022_021/r0_w1_wl u_t022_021/r0_r0_rwl u_t022_021/r0_r1_rwl
+ u_t022_021/r1_w0_wl u_t022_021/r1_w1_wl u_t022_021/r1_r0_rwl u_t022_021/r1_r1_rwl
+ u_t022_021/r2_w0_wl u_t022_021/r2_w1_wl u_t022_021/r2_r0_rwl u_t022_021/r2_r1_rwl
+ u_t022_021/r3_w0_wl u_t022_021/r3_w1_wl u_t022_021/r3_r0_rwl u_t022_021/r3_r1_rwl
+ u_t022_021/VDD u_t022_031/VSS VSUBS detronyx_12t_2w2r_rc4_4x4_routed_5layer_direct
Xu_t022_010 u_t022_010/c0_w0_bl u_t022_010/c0_w0_br u_t022_010/c0_w1_bl u_t022_010/c0_w1_br
+ u_t022_010/c0_r0_rbl u_t022_010/c0_r1_rbl u_t022_010/c1_w0_bl u_t022_010/c1_w0_br
+ u_t022_010/c1_w1_bl u_t022_010/c1_w1_br u_t022_010/c1_r0_rbl u_t022_010/c1_r1_rbl
+ u_t022_010/c2_w0_bl u_t022_010/c2_w0_br u_t022_010/c2_w1_bl u_t022_010/c2_w1_br
+ u_t022_010/c2_r0_rbl u_t022_010/c2_r1_rbl u_t022_010/c3_w0_bl u_t022_010/c3_w0_br
+ u_t022_010/c3_w1_bl u_t022_010/c3_w1_br u_t022_010/c3_r0_rbl u_t022_010/c3_r1_rbl
+ u_t022_010/r0_w0_wl u_t022_010/r0_w1_wl u_t022_010/r0_r0_rwl u_t022_010/r0_r1_rwl
+ u_t022_010/r1_w0_wl u_t022_010/r1_w1_wl u_t022_010/r1_r0_rwl u_t022_010/r1_r1_rwl
+ u_t022_010/r2_w0_wl u_t022_010/r2_w1_wl u_t022_010/r2_r0_rwl u_t022_010/r2_r1_rwl
+ u_t022_010/r3_w0_wl u_t022_010/r3_w1_wl u_t022_010/r3_r0_rwl u_t022_010/r3_r1_rwl
+ VSS u_t022_031/VSS VSUBS detronyx_12t_2w2r_rc4_4x4_routed_5layer_direct
Xu_t013_010 u_t013_010/c0_w0_bl u_t013_010/c0_w0_br u_t013_010/c0_w1_bl u_t013_010/c0_w1_br
+ u_t013_010/c0_r0_rbl u_t013_010/c0_r1_rbl u_t013_010/c1_w0_bl u_t013_010/c1_w0_br
+ u_t013_010/c1_w1_bl u_t013_010/c1_w1_br u_t013_010/c1_r0_rbl u_t013_010/c1_r1_rbl
+ u_t013_010/c2_w0_bl u_t013_010/c2_w0_br u_t013_010/c2_w1_bl u_t013_010/c2_w1_br
+ u_t013_010/c2_r0_rbl u_t013_010/c2_r1_rbl u_t013_010/c3_w0_bl u_t013_010/c3_w0_br
+ u_t013_010/c3_w1_bl u_t013_010/c3_w1_br u_t013_010/c3_r0_rbl u_t013_010/c3_r1_rbl
+ u_t013_010/r0_w0_wl u_t013_010/r0_w1_wl u_t013_010/r0_r0_rwl u_t013_010/r0_r1_rwl
+ u_t013_010/r1_w0_wl u_t013_010/r1_w1_wl u_t013_010/r1_r0_rwl u_t013_010/r1_r1_rwl
+ u_t013_010/r2_w0_wl u_t013_010/r2_w1_wl u_t013_010/r2_r0_rwl u_t013_010/r2_r1_rwl
+ u_t013_010/r3_w0_wl u_t013_010/r3_w1_wl u_t013_010/r3_r0_rwl u_t013_010/r3_r1_rwl
+ VSS u_t013_031/VSS VSUBS detronyx_12t_2w2r_rc4_4x4_routed_5layer_direct
Xu_t013_021 u_t013_021/c0_w0_bl u_t013_021/c0_w0_br u_t013_021/c0_w1_bl u_t013_021/c0_w1_br
+ u_t013_021/c0_r0_rbl u_t013_021/c0_r1_rbl u_t013_021/c1_w0_bl u_t013_021/c1_w0_br
+ u_t013_021/c1_w1_bl u_t013_021/c1_w1_br u_t013_021/c1_r0_rbl u_t013_021/c1_r1_rbl
+ u_t013_021/c2_w0_bl u_t013_021/c2_w0_br u_t013_021/c2_w1_bl u_t013_021/c2_w1_br
+ u_t013_021/c2_r0_rbl u_t013_021/c2_r1_rbl u_t013_021/c3_w0_bl u_t013_021/c3_w0_br
+ u_t013_021/c3_w1_bl u_t013_021/c3_w1_br u_t013_021/c3_r0_rbl u_t013_021/c3_r1_rbl
+ u_t013_021/r0_w0_wl u_t013_021/r0_w1_wl u_t013_021/r0_r0_rwl u_t013_021/r0_r1_rwl
+ u_t013_021/r1_w0_wl u_t013_021/r1_w1_wl u_t013_021/r1_r0_rwl u_t013_021/r1_r1_rwl
+ u_t013_021/r2_w0_wl u_t013_021/r2_w1_wl u_t013_021/r2_r0_rwl u_t013_021/r2_r1_rwl
+ u_t013_021/r3_w0_wl u_t013_021/r3_w1_wl u_t013_021/r3_r0_rwl u_t013_021/r3_r1_rwl
+ u_t013_021/VDD u_t013_031/VSS VSUBS detronyx_12t_2w2r_rc4_4x4_routed_5layer_direct
Xu_t004_021 u_t004_021/c0_w0_bl u_t004_021/c0_w0_br u_t004_021/c0_w1_bl u_t004_021/c0_w1_br
+ u_t004_021/c0_r0_rbl u_t004_021/c0_r1_rbl u_t004_021/c1_w0_bl u_t004_021/c1_w0_br
+ u_t004_021/c1_w1_bl u_t004_021/c1_w1_br u_t004_021/c1_r0_rbl u_t004_021/c1_r1_rbl
+ u_t004_021/c2_w0_bl u_t004_021/c2_w0_br u_t004_021/c2_w1_bl u_t004_021/c2_w1_br
+ u_t004_021/c2_r0_rbl u_t004_021/c2_r1_rbl u_t004_021/c3_w0_bl u_t004_021/c3_w0_br
+ u_t004_021/c3_w1_bl u_t004_021/c3_w1_br u_t004_021/c3_r0_rbl u_t004_021/c3_r1_rbl
+ u_t004_021/r0_w0_wl u_t004_021/r0_w1_wl u_t004_021/r0_r0_rwl u_t004_021/r0_r1_rwl
+ u_t004_021/r1_w0_wl u_t004_021/r1_w1_wl u_t004_021/r1_r0_rwl u_t004_021/r1_r1_rwl
+ u_t004_021/r2_w0_wl u_t004_021/r2_w1_wl u_t004_021/r2_r0_rwl u_t004_021/r2_r1_rwl
+ u_t004_021/r3_w0_wl u_t004_021/r3_w1_wl u_t004_021/r3_r0_rwl u_t004_021/r3_r1_rwl
+ u_t004_021/VDD u_t004_031/VSS VSUBS detronyx_12t_2w2r_rc4_4x4_routed_5layer_direct
Xu_t004_010 u_t004_010/c0_w0_bl u_t004_010/c0_w0_br u_t004_010/c0_w1_bl u_t004_010/c0_w1_br
+ u_t004_010/c0_r0_rbl u_t004_010/c0_r1_rbl u_t004_010/c1_w0_bl u_t004_010/c1_w0_br
+ u_t004_010/c1_w1_bl u_t004_010/c1_w1_br u_t004_010/c1_r0_rbl u_t004_010/c1_r1_rbl
+ u_t004_010/c2_w0_bl u_t004_010/c2_w0_br u_t004_010/c2_w1_bl u_t004_010/c2_w1_br
+ u_t004_010/c2_r0_rbl u_t004_010/c2_r1_rbl u_t004_010/c3_w0_bl u_t004_010/c3_w0_br
+ u_t004_010/c3_w1_bl u_t004_010/c3_w1_br u_t004_010/c3_r0_rbl u_t004_010/c3_r1_rbl
+ u_t004_010/r0_w0_wl u_t004_010/r0_w1_wl u_t004_010/r0_r0_rwl u_t004_010/r0_r1_rwl
+ u_t004_010/r1_w0_wl u_t004_010/r1_w1_wl u_t004_010/r1_r0_rwl u_t004_010/r1_r1_rwl
+ u_t004_010/r2_w0_wl u_t004_010/r2_w1_wl u_t004_010/r2_r0_rwl u_t004_010/r2_r1_rwl
+ u_t004_010/r3_w0_wl u_t004_010/r3_w1_wl u_t004_010/r3_r0_rwl u_t004_010/r3_r1_rwl
+ VSS u_t004_031/VSS VSUBS detronyx_12t_2w2r_rc4_4x4_routed_5layer_direct
Xgf180mcu_as_sc_mcu7t3v3__inv_2_452 gf180mcu_as_sc_mcu7t3v3__nor2_2_5/VDD gf180mcu_as_sc_mcu7t3v3__nor2_2_5/VSS
+ VSS VSS gf180mcu_as_sc_mcu7t3v3__nor2_2_5/VNW VSUBS gf180mcu_as_sc_mcu7t3v3__inv_2
Xgf180mcu_as_sc_mcu7t3v3__inv_2_463 gf180mcu_as_sc_mcu7t3v3__nor2_2_5/VDD gf180mcu_as_sc_mcu7t3v3__nor2_2_5/VSS
+ VSS VSS gf180mcu_as_sc_mcu7t3v3__nor2_2_5/VNW VSUBS gf180mcu_as_sc_mcu7t3v3__inv_2
Xgf180mcu_as_sc_mcu7t3v3__inv_2_474 gf180mcu_as_sc_mcu7t3v3__nor2_2_5/VDD gf180mcu_as_sc_mcu7t3v3__nand3_2_8/VSS
+ VSS VSS gf180mcu_as_sc_mcu7t3v3__nor2_2_5/VNW VSUBS gf180mcu_as_sc_mcu7t3v3__inv_2
Xgf180mcu_as_sc_mcu7t3v3__inv_2_441 gf180mcu_as_sc_mcu7t3v3__nor2_2_4/VDD gf180mcu_as_sc_mcu7t3v3__nand3_2_8/VSS
+ VSS VSS gf180mcu_as_sc_mcu7t3v3__nor2_2_4/VNW VSUBS gf180mcu_as_sc_mcu7t3v3__inv_2
Xgf180mcu_as_sc_mcu7t3v3__inv_2_430 gf180mcu_as_sc_mcu7t3v3__nor2_2_6/VDD gf180mcu_as_sc_mcu7t3v3__nor2_2_6/VSS
+ VSS VSS gf180mcu_as_sc_mcu7t3v3__nor2_2_6/VNW VSUBS gf180mcu_as_sc_mcu7t3v3__inv_2
Xgf180mcu_as_sc_mcu7t3v3__inv_2_496 gf180mcu_as_sc_mcu7t3v3__nand3_2_5/VDD gf180mcu_as_sc_mcu7t3v3__nor2_2_4/VSS
+ VSS VSS gf180mcu_as_sc_mcu7t3v3__nand3_2_5/VNW VSUBS gf180mcu_as_sc_mcu7t3v3__inv_2
Xgf180mcu_as_sc_mcu7t3v3__inv_2_485 gf180mcu_as_sc_mcu7t3v3__nand3_2_5/VDD gf180mcu_as_sc_mcu7t3v3__nor2_2_4/VSS
+ VSS VSS gf180mcu_as_sc_mcu7t3v3__nand3_2_5/VNW VSUBS gf180mcu_as_sc_mcu7t3v3__inv_2
Xu_t010_024 u_t010_024/c0_w0_bl u_t010_024/c0_w0_br u_t010_024/c0_w1_bl u_t010_024/c0_w1_br
+ u_t010_024/c0_r0_rbl u_t010_024/c0_r1_rbl u_t010_024/c1_w0_bl u_t010_024/c1_w0_br
+ u_t010_024/c1_w1_bl u_t010_024/c1_w1_br u_t010_024/c1_r0_rbl u_t010_024/c1_r1_rbl
+ u_t010_024/c2_w0_bl u_t010_024/c2_w0_br u_t010_024/c2_w1_bl u_t010_024/c2_w1_br
+ u_t010_024/c2_r0_rbl u_t010_024/c2_r1_rbl u_t010_024/c3_w0_bl u_t010_024/c3_w0_br
+ u_t010_024/c3_w1_bl u_t010_024/c3_w1_br u_t010_024/c3_r0_rbl u_t010_024/c3_r1_rbl
+ u_t010_024/r0_w0_wl u_t010_024/r0_w1_wl u_t010_024/r0_r0_rwl u_t010_024/r0_r1_rwl
+ u_t010_024/r1_w0_wl u_t010_024/r1_w1_wl u_t010_024/r1_r0_rwl u_t010_024/r1_r1_rwl
+ u_t010_024/r2_w0_wl u_t010_024/r2_w1_wl u_t010_024/r2_r0_rwl u_t010_024/r2_r1_rwl
+ u_t010_024/r3_w0_wl u_t010_024/r3_w1_wl u_t010_024/r3_r0_rwl u_t010_024/r3_r1_rwl
+ VSS u_t010_024/VSS VSUBS detronyx_12t_2w2r_rc4_4x4_routed_5layer_direct
Xu_t010_013 u_t010_013/c0_w0_bl u_t010_013/c0_w0_br u_t010_013/c0_w1_bl u_t010_013/c0_w1_br
+ u_t010_013/c0_r0_rbl u_t010_013/c0_r1_rbl u_t010_013/c1_w0_bl u_t010_013/c1_w0_br
+ u_t010_013/c1_w1_bl u_t010_013/c1_w1_br u_t010_013/c1_r0_rbl u_t010_013/c1_r1_rbl
+ u_t010_013/c2_w0_bl u_t010_013/c2_w0_br u_t010_013/c2_w1_bl u_t010_013/c2_w1_br
+ u_t010_013/c2_r0_rbl u_t010_013/c2_r1_rbl u_t010_013/c3_w0_bl u_t010_013/c3_w0_br
+ u_t010_013/c3_w1_bl u_t010_013/c3_w1_br u_t010_013/c3_r0_rbl u_t010_013/c3_r1_rbl
+ u_t010_013/r0_w0_wl u_t010_013/r0_w1_wl u_t010_013/r0_r0_rwl u_t010_013/r0_r1_rwl
+ u_t010_013/r1_w0_wl u_t010_013/r1_w1_wl u_t010_013/r1_r0_rwl u_t010_013/r1_r1_rwl
+ u_t010_013/r2_w0_wl u_t010_013/r2_w1_wl u_t010_013/r2_r0_rwl u_t010_013/r2_r1_rwl
+ u_t010_013/r3_w0_wl u_t010_013/r3_w1_wl u_t010_013/r3_r0_rwl u_t010_013/r3_r1_rwl
+ u_t010_013/VDD u_t010_013/VSS VSUBS detronyx_12t_2w2r_rc4_4x4_routed_5layer_direct
Xu_t010_002 u_t010_002/c0_w0_bl u_t010_002/c0_w0_br u_t010_002/c0_w1_bl u_t010_002/c0_w1_br
+ u_t010_002/c0_r0_rbl u_t010_002/c0_r1_rbl u_t010_002/c1_w0_bl u_t010_002/c1_w0_br
+ u_t010_002/c1_w1_bl u_t010_002/c1_w1_br u_t010_002/c1_r0_rbl u_t010_002/c1_r1_rbl
+ u_t010_002/c2_w0_bl u_t010_002/c2_w0_br u_t010_002/c2_w1_bl u_t010_002/c2_w1_br
+ u_t010_002/c2_r0_rbl u_t010_002/c2_r1_rbl u_t010_002/c3_w0_bl u_t010_002/c3_w0_br
+ u_t010_002/c3_w1_bl u_t010_002/c3_w1_br u_t010_002/c3_r0_rbl u_t010_002/c3_r1_rbl
+ u_t010_002/r0_w0_wl u_t010_002/r0_w1_wl u_t010_002/r0_r0_rwl u_t010_002/r0_r1_rwl
+ u_t010_002/r1_w0_wl u_t010_002/r1_w1_wl u_t010_002/r1_r0_rwl u_t010_002/r1_r1_rwl
+ u_t010_002/r2_w0_wl u_t010_002/r2_w1_wl u_t010_002/r2_r0_rwl u_t010_002/r2_r1_rwl
+ u_t010_002/r3_w0_wl u_t010_002/r3_w1_wl u_t010_002/r3_r0_rwl u_t010_002/r3_r1_rwl
+ VSS u_t010_002/VSS VSUBS detronyx_12t_2w2r_rc4_4x4_routed_5layer_direct
Xu_t001_024 u_t001_024/c0_w0_bl u_t001_024/c0_w0_br u_t001_024/c0_w1_bl u_t001_024/c0_w1_br
+ u_t001_024/c0_r0_rbl u_t001_024/c0_r1_rbl u_t001_024/c1_w0_bl u_t001_024/c1_w0_br
+ u_t001_024/c1_w1_bl u_t001_024/c1_w1_br u_t001_024/c1_r0_rbl u_t001_024/c1_r1_rbl
+ u_t001_024/c2_w0_bl u_t001_024/c2_w0_br u_t001_024/c2_w1_bl u_t001_024/c2_w1_br
+ u_t001_024/c2_r0_rbl u_t001_024/c2_r1_rbl u_t001_024/c3_w0_bl u_t001_024/c3_w0_br
+ u_t001_024/c3_w1_bl u_t001_024/c3_w1_br u_t001_024/c3_r0_rbl u_t001_024/c3_r1_rbl
+ u_t001_024/r0_w0_wl u_t001_024/r0_w1_wl u_t001_024/r0_r0_rwl u_t001_024/r0_r1_rwl
+ u_t001_024/r1_w0_wl u_t001_024/r1_w1_wl u_t001_024/r1_r0_rwl u_t001_024/r1_r1_rwl
+ u_t001_024/r2_w0_wl u_t001_024/r2_w1_wl u_t001_024/r2_r0_rwl u_t001_024/r2_r1_rwl
+ u_t001_024/r3_w0_wl u_t001_024/r3_w1_wl u_t001_024/r3_r0_rwl u_t001_024/r3_r1_rwl
+ VSS u_t001_031/VSS VSUBS detronyx_12t_2w2r_rc4_4x4_routed_5layer_direct
Xu_t001_013 u_t001_013/c0_w0_bl u_t001_013/c0_w0_br u_t001_013/c0_w1_bl u_t001_013/c0_w1_br
+ u_t001_013/c0_r0_rbl u_t001_013/c0_r1_rbl u_t001_013/c1_w0_bl u_t001_013/c1_w0_br
+ u_t001_013/c1_w1_bl u_t001_013/c1_w1_br u_t001_013/c1_r0_rbl u_t001_013/c1_r1_rbl
+ u_t001_013/c2_w0_bl u_t001_013/c2_w0_br u_t001_013/c2_w1_bl u_t001_013/c2_w1_br
+ u_t001_013/c2_r0_rbl u_t001_013/c2_r1_rbl u_t001_013/c3_w0_bl u_t001_013/c3_w0_br
+ u_t001_013/c3_w1_bl u_t001_013/c3_w1_br u_t001_013/c3_r0_rbl u_t001_013/c3_r1_rbl
+ u_t001_013/r0_w0_wl u_t001_013/r0_w1_wl u_t001_013/r0_r0_rwl u_t001_013/r0_r1_rwl
+ u_t001_013/r1_w0_wl u_t001_013/r1_w1_wl u_t001_013/r1_r0_rwl u_t001_013/r1_r1_rwl
+ u_t001_013/r2_w0_wl u_t001_013/r2_w1_wl u_t001_013/r2_r0_rwl u_t001_013/r2_r1_rwl
+ u_t001_013/r3_w0_wl u_t001_013/r3_w1_wl u_t001_013/r3_r0_rwl u_t001_013/r3_r1_rwl
+ u_t001_013/VDD u_t001_031/VSS VSUBS detronyx_12t_2w2r_rc4_4x4_routed_5layer_direct
Xu_t001_002 u_t001_002/c0_w0_bl u_t001_002/c0_w0_br u_t001_002/c0_w1_bl u_t001_002/c0_w1_br
+ u_t001_002/c0_r0_rbl u_t001_002/c0_r1_rbl u_t001_002/c1_w0_bl u_t001_002/c1_w0_br
+ u_t001_002/c1_w1_bl u_t001_002/c1_w1_br u_t001_002/c1_r0_rbl u_t001_002/c1_r1_rbl
+ u_t001_002/c2_w0_bl u_t001_002/c2_w0_br u_t001_002/c2_w1_bl u_t001_002/c2_w1_br
+ u_t001_002/c2_r0_rbl u_t001_002/c2_r1_rbl u_t001_002/c3_w0_bl u_t001_002/c3_w0_br
+ u_t001_002/c3_w1_bl u_t001_002/c3_w1_br u_t001_002/c3_r0_rbl u_t001_002/c3_r1_rbl
+ u_t001_002/r0_w0_wl u_t001_002/r0_w1_wl u_t001_002/r0_r0_rwl u_t001_002/r0_r1_rwl
+ u_t001_002/r1_w0_wl u_t001_002/r1_w1_wl u_t001_002/r1_r0_rwl u_t001_002/r1_r1_rwl
+ u_t001_002/r2_w0_wl u_t001_002/r2_w1_wl u_t001_002/r2_r0_rwl u_t001_002/r2_r1_rwl
+ u_t001_002/r3_w0_wl u_t001_002/r3_w1_wl u_t001_002/r3_r0_rwl u_t001_002/r3_r1_rwl
+ VSS u_t001_031/VSS VSUBS detronyx_12t_2w2r_rc4_4x4_routed_5layer_direct
Xgf180mcu_as_sc_mcu7t3v3__inv_2_282 gf180mcu_as_sc_mcu7t3v3__inv_2_353/VDD gf180mcu_as_sc_mcu7t3v3__inv_2_368/VDD
+ gf180mcu_as_sc_mcu7t3v3__inv_2_282/Y gf180mcu_as_sc_mcu7t3v3__inv_2_66/Y gf180mcu_as_sc_mcu7t3v3__inv_2_353/VNW
+ VSUBS gf180mcu_as_sc_mcu7t3v3__inv_2
Xgf180mcu_as_sc_mcu7t3v3__inv_2_271 gf180mcu_as_sc_mcu7t3v3__inv_2_358/VDD gf180mcu_as_sc_mcu7t3v3__inv_2_359/VDD
+ VSS gf180mcu_as_sc_mcu7t3v3__inv_2_358/Y gf180mcu_as_sc_mcu7t3v3__inv_2_358/VNW
+ VSUBS gf180mcu_as_sc_mcu7t3v3__inv_2
Xgf180mcu_as_sc_mcu7t3v3__inv_2_293 gf180mcu_as_sc_mcu7t3v3__inv_2_356/VDD gf180mcu_as_sc_mcu7t3v3__inv_2_357/VDD
+ VSS gf180mcu_as_sc_mcu7t3v3__inv_2_358/Y gf180mcu_as_sc_mcu7t3v3__inv_2_356/VNW
+ VSUBS gf180mcu_as_sc_mcu7t3v3__inv_2
Xgf180mcu_as_sc_mcu7t3v3__inv_2_260 VSS gf180mcu_as_sc_mcu7t3v3__inv_2_260/VSS gf180mcu_as_sc_mcu7t3v3__inv_2_260/Y
+ VSS gf180mcu_as_sc_mcu7t3v3__inv_2_260/VNW VSUBS gf180mcu_as_sc_mcu7t3v3__inv_2
Xgf180mcu_as_sc_mcu7t3v3__nand4_2_509 gf180mcu_as_sc_mcu7t3v3__inv_2_1685/VDD VSS
+ VSS VSS VSS VSS VSS gf180mcu_as_sc_mcu7t3v3__inv_2_1685/VNW VSUBS gf180mcu_as_sc_mcu7t3v3__nand4_2
Xgf180mcu_as_sc_mcu7t3v3__inv_2_19 VSS gf180mcu_as_sc_mcu7t3v3__inv_2_77/VDD gf180mcu_as_sc_mcu7t3v3__inv_2_77/Y
+ gf180mcu_as_sc_mcu7t3v3__inv_2_77/Y gf180mcu_as_sc_mcu7t3v3__inv_2_76/VNW VSUBS
+ gf180mcu_as_sc_mcu7t3v3__inv_2
Xgf180mcu_as_sc_mcu7t3v3__inv_2_1567 gf180mcu_as_sc_mcu7t3v3__inv_2_1569/VDD VSS VSS
+ VSS gf180mcu_as_sc_mcu7t3v3__inv_2_1569/VNW VSUBS gf180mcu_as_sc_mcu7t3v3__inv_2
Xgf180mcu_as_sc_mcu7t3v3__inv_2_1556 gf180mcu_as_sc_mcu7t3v3__inv_2_1589/VSS VSS gf180mcu_as_sc_mcu7t3v3__inv_2_1556/Y
+ VSS gf180mcu_as_sc_mcu7t3v3__inv_2_1557/VNW VSUBS gf180mcu_as_sc_mcu7t3v3__inv_2
Xgf180mcu_as_sc_mcu7t3v3__inv_2_1578 VSS gf180mcu_as_sc_mcu7t3v3__inv_2_1586/VSS VSS
+ VSS gf180mcu_as_sc_mcu7t3v3__inv_2_1586/VNW VSUBS gf180mcu_as_sc_mcu7t3v3__inv_2
Xgf180mcu_as_sc_mcu7t3v3__inv_2_1512 gf180mcu_as_sc_mcu7t3v3__inv_2_1514/VDD VSS VSS
+ VSS gf180mcu_as_sc_mcu7t3v3__inv_2_1514/VNW VSUBS gf180mcu_as_sc_mcu7t3v3__inv_2
Xgf180mcu_as_sc_mcu7t3v3__inv_2_1534 gf180mcu_as_sc_mcu7t3v3__inv_2_1535/VDD gf180mcu_as_sc_mcu7t3v3__inv_2_1539/VDD
+ gf180mcu_as_sc_mcu7t3v3__inv_2_1534/Y VSS gf180mcu_as_sc_mcu7t3v3__inv_2_1535/VNW
+ VSUBS gf180mcu_as_sc_mcu7t3v3__inv_2
Xgf180mcu_as_sc_mcu7t3v3__inv_2_1545 VSS gf180mcu_as_sc_mcu7t3v3__inv_2_1551/VDD VSS
+ VSS gf180mcu_as_sc_mcu7t3v3__inv_2_1547/VNW VSUBS gf180mcu_as_sc_mcu7t3v3__inv_2
Xgf180mcu_as_sc_mcu7t3v3__inv_2_1523 gf180mcu_as_sc_mcu7t3v3__inv_2_1524/VDD VSS gf180mcu_as_sc_mcu7t3v3__inv_2_1523/Y
+ VSS gf180mcu_as_sc_mcu7t3v3__inv_2_1524/VNW VSUBS gf180mcu_as_sc_mcu7t3v3__inv_2
Xgf180mcu_as_sc_mcu7t3v3__inv_2_1501 gf180mcu_as_sc_mcu7t3v3__inv_2_1502/VDD gf180mcu_as_sc_mcu7t3v3__inv_2_1502/VSS
+ gf180mcu_as_sc_mcu7t3v3__inv_2_1501/Y VSS gf180mcu_as_sc_mcu7t3v3__inv_2_1502/VNW
+ VSUBS gf180mcu_as_sc_mcu7t3v3__inv_2
Xgf180mcu_as_sc_mcu7t3v3__inv_2_1589 gf180mcu_as_sc_mcu7t3v3__inv_2_1589/VDD gf180mcu_as_sc_mcu7t3v3__inv_2_1589/VSS
+ gf180mcu_as_sc_mcu7t3v3__inv_2_1589/Y VSS gf180mcu_as_sc_mcu7t3v3__inv_2_1589/VNW
+ VSUBS gf180mcu_as_sc_mcu7t3v3__inv_2
Xgf180mcu_as_sc_mcu7t3v3__nand4_2_339 gf180mcu_as_sc_mcu7t3v3__inv_2_1135/VDD VSS
+ VSS VSS VSS VSS VSS gf180mcu_as_sc_mcu7t3v3__inv_2_1135/VNW VSUBS gf180mcu_as_sc_mcu7t3v3__nand4_2
Xgf180mcu_as_sc_mcu7t3v3__nand4_2_328 VSS VSS VSS VSS VSS VSS VSS gf180mcu_as_sc_mcu7t3v3__inv_2_1100/VNW
+ VSUBS gf180mcu_as_sc_mcu7t3v3__nand4_2
Xgf180mcu_as_sc_mcu7t3v3__nand4_2_317 VSS gf180mcu_as_sc_mcu7t3v3__inv_2_1053/VDD
+ VSS VSS VSS VSS VSS gf180mcu_as_sc_mcu7t3v3__inv_2_1039/VNW VSUBS gf180mcu_as_sc_mcu7t3v3__nand4_2
Xgf180mcu_as_sc_mcu7t3v3__nand2_2_0 gf180mcu_as_sc_mcu7t3v3__nand3_2_5/VDD gf180mcu_as_sc_mcu7t3v3__nor2_2_4/VSS
+ VSS VSS VSS gf180mcu_as_sc_mcu7t3v3__nand3_2_5/VNW VSUBS gf180mcu_as_sc_mcu7t3v3__nand2_2
Xgf180mcu_as_sc_mcu7t3v3__nand4_2_306 gf180mcu_as_sc_mcu7t3v3__inv_2_1042/VDD gf180mcu_as_sc_mcu7t3v3__inv_2_1046/VDD
+ VSS VSS VSS VSS VSS gf180mcu_as_sc_mcu7t3v3__inv_2_1042/VNW VSUBS gf180mcu_as_sc_mcu7t3v3__nand4_2
Xu_t029_027 u_t029_027/c0_w0_bl u_t029_027/c0_w0_br u_t029_027/c0_w1_bl u_t029_027/c0_w1_br
+ u_t029_027/c0_r0_rbl u_t029_027/c0_r1_rbl u_t029_027/c1_w0_bl u_t029_027/c1_w0_br
+ u_t029_027/c1_w1_bl u_t029_027/c1_w1_br u_t029_027/c1_r0_rbl u_t029_027/c1_r1_rbl
+ u_t029_027/c2_w0_bl u_t029_027/c2_w0_br u_t029_027/c2_w1_bl u_t029_027/c2_w1_br
+ u_t029_027/c2_r0_rbl u_t029_027/c2_r1_rbl u_t029_027/c3_w0_bl u_t029_027/c3_w0_br
+ u_t029_027/c3_w1_bl u_t029_027/c3_w1_br u_t029_027/c3_r0_rbl u_t029_027/c3_r1_rbl
+ u_t029_027/r0_w0_wl u_t029_027/r0_w1_wl u_t029_027/r0_r0_rwl u_t029_027/r0_r1_rwl
+ u_t029_027/r1_w0_wl u_t029_027/r1_w1_wl u_t029_027/r1_r0_rwl u_t029_027/r1_r1_rwl
+ u_t029_027/r2_w0_wl u_t029_027/r2_w1_wl u_t029_027/r2_r0_rwl u_t029_027/r2_r1_rwl
+ u_t029_027/r3_w0_wl u_t029_027/r3_w1_wl u_t029_027/r3_r0_rwl u_t029_027/r3_r1_rwl
+ u_t029_027/VDD u_t029_031/VSS VSUBS detronyx_12t_2w2r_rc4_4x4_routed_5layer_direct
Xu_t029_016 u_t029_016/c0_w0_bl u_t029_016/c0_w0_br u_t029_016/c0_w1_bl u_t029_016/c0_w1_br
+ u_t029_016/c0_r0_rbl u_t029_016/c0_r1_rbl u_t029_016/c1_w0_bl u_t029_016/c1_w0_br
+ u_t029_016/c1_w1_bl u_t029_016/c1_w1_br u_t029_016/c1_r0_rbl u_t029_016/c1_r1_rbl
+ u_t029_016/c2_w0_bl u_t029_016/c2_w0_br u_t029_016/c2_w1_bl u_t029_016/c2_w1_br
+ u_t029_016/c2_r0_rbl u_t029_016/c2_r1_rbl u_t029_016/c3_w0_bl u_t029_016/c3_w0_br
+ u_t029_016/c3_w1_bl u_t029_016/c3_w1_br u_t029_016/c3_r0_rbl u_t029_016/c3_r1_rbl
+ u_t029_016/r0_w0_wl u_t029_016/r0_w1_wl u_t029_016/r0_r0_rwl u_t029_016/r0_r1_rwl
+ u_t029_016/r1_w0_wl u_t029_016/r1_w1_wl u_t029_016/r1_r0_rwl u_t029_016/r1_r1_rwl
+ u_t029_016/r2_w0_wl u_t029_016/r2_w1_wl u_t029_016/r2_r0_rwl u_t029_016/r2_r1_rwl
+ u_t029_016/r3_w0_wl u_t029_016/r3_w1_wl u_t029_016/r3_r0_rwl u_t029_016/r3_r1_rwl
+ VSS u_t029_031/VSS VSUBS detronyx_12t_2w2r_rc4_4x4_routed_5layer_direct
Xu_t029_005 u_t029_005/c0_w0_bl u_t029_005/c0_w0_br u_t029_005/c0_w1_bl u_t029_005/c0_w1_br
+ u_t029_005/c0_r0_rbl u_t029_005/c0_r1_rbl u_t029_005/c1_w0_bl u_t029_005/c1_w0_br
+ u_t029_005/c1_w1_bl u_t029_005/c1_w1_br u_t029_005/c1_r0_rbl u_t029_005/c1_r1_rbl
+ u_t029_005/c2_w0_bl u_t029_005/c2_w0_br u_t029_005/c2_w1_bl u_t029_005/c2_w1_br
+ u_t029_005/c2_r0_rbl u_t029_005/c2_r1_rbl u_t029_005/c3_w0_bl u_t029_005/c3_w0_br
+ u_t029_005/c3_w1_bl u_t029_005/c3_w1_br u_t029_005/c3_r0_rbl u_t029_005/c3_r1_rbl
+ u_t029_005/r0_w0_wl u_t029_005/r0_w1_wl u_t029_005/r0_r0_rwl u_t029_005/r0_r1_rwl
+ u_t029_005/r1_w0_wl u_t029_005/r1_w1_wl u_t029_005/r1_r0_rwl u_t029_005/r1_r1_rwl
+ u_t029_005/r2_w0_wl u_t029_005/r2_w1_wl u_t029_005/r2_r0_rwl u_t029_005/r2_r1_rwl
+ u_t029_005/r3_w0_wl u_t029_005/r3_w1_wl u_t029_005/r3_r0_rwl u_t029_005/r3_r1_rwl
+ u_t029_005/VDD u_t029_031/VSS VSUBS detronyx_12t_2w2r_rc4_4x4_routed_5layer_direct
Xgf180mcu_as_sc_mcu7t3v3__inv_2_1342 VSS gf180mcu_as_sc_mcu7t3v3__inv_2_1400/VDD VSS
+ gf180mcu_as_sc_mcu7t3v3__inv_2_1685/Y gf180mcu_as_sc_mcu7t3v3__inv_2_1399/VNW VSUBS
+ gf180mcu_as_sc_mcu7t3v3__inv_2
Xgf180mcu_as_sc_mcu7t3v3__inv_2_1353 gf180mcu_as_sc_mcu7t3v3__inv_2_1383/VDD gf180mcu_as_sc_mcu7t3v3__inv_2_1384/VDD
+ VSS gf180mcu_as_sc_mcu7t3v3__inv_2_1384/Y gf180mcu_as_sc_mcu7t3v3__inv_2_1383/VNW
+ VSUBS gf180mcu_as_sc_mcu7t3v3__inv_2
Xgf180mcu_as_sc_mcu7t3v3__inv_2_1386 VSS gf180mcu_as_sc_mcu7t3v3__inv_2_1387/VDD gf180mcu_as_sc_mcu7t3v3__inv_2_1387/Y
+ VSS gf180mcu_as_sc_mcu7t3v3__inv_2_1386/VNW VSUBS gf180mcu_as_sc_mcu7t3v3__inv_2
Xgf180mcu_as_sc_mcu7t3v3__inv_2_1331 gf180mcu_as_sc_mcu7t3v3__inv_2_1387/VDD VSS VSS
+ gf180mcu_as_sc_mcu7t3v3__inv_2_1387/Y gf180mcu_as_sc_mcu7t3v3__inv_2_1387/VNW VSUBS
+ gf180mcu_as_sc_mcu7t3v3__inv_2
Xgf180mcu_as_sc_mcu7t3v3__inv_2_1375 gf180mcu_as_sc_mcu7t3v3__inv_2_1375/VDD gf180mcu_as_sc_mcu7t3v3__inv_2_1376/VDD
+ gf180mcu_as_sc_mcu7t3v3__inv_2_1379/Y VSS gf180mcu_as_sc_mcu7t3v3__inv_2_1375/VNW
+ VSUBS gf180mcu_as_sc_mcu7t3v3__inv_2
Xgf180mcu_as_sc_mcu7t3v3__inv_2_1320 VSS VSS VSS gf180mcu_as_sc_mcu7t3v3__inv_2_1379/Y
+ gf180mcu_as_sc_mcu7t3v3__inv_2_1370/VNW VSUBS gf180mcu_as_sc_mcu7t3v3__inv_2
Xgf180mcu_as_sc_mcu7t3v3__inv_2_1397 gf180mcu_as_sc_mcu7t3v3__inv_2_1398/VSS gf180mcu_as_sc_mcu7t3v3__inv_2_1397/VSS
+ gf180mcu_as_sc_mcu7t3v3__inv_2_1398/Y VSS gf180mcu_as_sc_mcu7t3v3__inv_2_1397/VNW
+ VSUBS gf180mcu_as_sc_mcu7t3v3__inv_2
Xgf180mcu_as_sc_mcu7t3v3__inv_2_1364 gf180mcu_as_sc_mcu7t3v3__inv_2_1394/VDD VSS VSS
+ gf180mcu_as_sc_mcu7t3v3__inv_2_1398/Y gf180mcu_as_sc_mcu7t3v3__inv_2_1394/VNW VSUBS
+ gf180mcu_as_sc_mcu7t3v3__inv_2
Xgf180mcu_as_sc_mcu7t3v3__inv_2_848 gf180mcu_as_sc_mcu7t3v3__inv_2_849/VDD gf180mcu_as_sc_mcu7t3v3__inv_2_849/VSS
+ gf180mcu_as_sc_mcu7t3v3__inv_2_848/Y gf180mcu_as_sc_mcu7t3v3__inv_2_849/Y gf180mcu_as_sc_mcu7t3v3__inv_2_849/VNW
+ VSUBS gf180mcu_as_sc_mcu7t3v3__inv_2
Xgf180mcu_as_sc_mcu7t3v3__inv_2_837 VSS VSS gf180mcu_as_sc_mcu7t3v3__inv_2_837/Y VSS
+ gf180mcu_as_sc_mcu7t3v3__inv_2_841/VNW VSUBS gf180mcu_as_sc_mcu7t3v3__inv_2
Xgf180mcu_as_sc_mcu7t3v3__inv_2_815 VSS VSS VSS VSS gf180mcu_as_sc_mcu7t3v3__inv_2_816/VNW
+ VSUBS gf180mcu_as_sc_mcu7t3v3__inv_2
Xgf180mcu_as_sc_mcu7t3v3__inv_2_804 VSS VSS VSS VSS gf180mcu_as_sc_mcu7t3v3__inv_2_804/VNW
+ VSUBS gf180mcu_as_sc_mcu7t3v3__inv_2
Xgf180mcu_as_sc_mcu7t3v3__inv_2_826 VSS VSS gf180mcu_as_sc_mcu7t3v3__inv_2_826/Y VSS
+ gf180mcu_as_sc_mcu7t3v3__inv_2_828/VNW VSUBS gf180mcu_as_sc_mcu7t3v3__inv_2
Xgf180mcu_as_sc_mcu7t3v3__inv_2_859 VSS VSS VSS VSS gf180mcu_as_sc_mcu7t3v3__inv_2_860/VNW
+ VSUBS gf180mcu_as_sc_mcu7t3v3__inv_2
Xu_t026_019 u_t026_019/c0_w0_bl u_t026_019/c0_w0_br u_t026_019/c0_w1_bl u_t026_019/c0_w1_br
+ u_t026_019/c0_r0_rbl u_t026_019/c0_r1_rbl u_t026_019/c1_w0_bl u_t026_019/c1_w0_br
+ u_t026_019/c1_w1_bl u_t026_019/c1_w1_br u_t026_019/c1_r0_rbl u_t026_019/c1_r1_rbl
+ u_t026_019/c2_w0_bl u_t026_019/c2_w0_br u_t026_019/c2_w1_bl u_t026_019/c2_w1_br
+ u_t026_019/c2_r0_rbl u_t026_019/c2_r1_rbl u_t026_019/c3_w0_bl u_t026_019/c3_w0_br
+ u_t026_019/c3_w1_bl u_t026_019/c3_w1_br u_t026_019/c3_r0_rbl u_t026_019/c3_r1_rbl
+ u_t026_019/r0_w0_wl u_t026_019/r0_w1_wl u_t026_019/r0_r0_rwl u_t026_019/r0_r1_rwl
+ u_t026_019/r1_w0_wl u_t026_019/r1_w1_wl u_t026_019/r1_r0_rwl u_t026_019/r1_r1_rwl
+ u_t026_019/r2_w0_wl u_t026_019/r2_w1_wl u_t026_019/r2_r0_rwl u_t026_019/r2_r1_rwl
+ u_t026_019/r3_w0_wl u_t026_019/r3_w1_wl u_t026_019/r3_r0_rwl u_t026_019/r3_r1_rwl
+ u_t026_019/VDD u_t026_031/VSS VSUBS detronyx_12t_2w2r_rc4_4x4_routed_5layer_direct
Xu_t026_008 u_t026_008/c0_w0_bl u_t026_008/c0_w0_br u_t026_008/c0_w1_bl u_t026_008/c0_w1_br
+ u_t026_008/c0_r0_rbl u_t026_008/c0_r1_rbl u_t026_008/c1_w0_bl u_t026_008/c1_w0_br
+ u_t026_008/c1_w1_bl u_t026_008/c1_w1_br u_t026_008/c1_r0_rbl u_t026_008/c1_r1_rbl
+ u_t026_008/c2_w0_bl u_t026_008/c2_w0_br u_t026_008/c2_w1_bl u_t026_008/c2_w1_br
+ u_t026_008/c2_r0_rbl u_t026_008/c2_r1_rbl u_t026_008/c3_w0_bl u_t026_008/c3_w0_br
+ u_t026_008/c3_w1_bl u_t026_008/c3_w1_br u_t026_008/c3_r0_rbl u_t026_008/c3_r1_rbl
+ u_t026_008/r0_w0_wl u_t026_008/r0_w1_wl u_t026_008/r0_r0_rwl u_t026_008/r0_r1_rwl
+ u_t026_008/r1_w0_wl u_t026_008/r1_w1_wl u_t026_008/r1_r0_rwl u_t026_008/r1_r1_rwl
+ u_t026_008/r2_w0_wl u_t026_008/r2_w1_wl u_t026_008/r2_r0_rwl u_t026_008/r2_r1_rwl
+ u_t026_008/r3_w0_wl u_t026_008/r3_w1_wl u_t026_008/r3_r0_rwl u_t026_008/r3_r1_rwl
+ VSS u_t026_031/VSS VSUBS detronyx_12t_2w2r_rc4_4x4_routed_5layer_direct
Xgf180mcu_as_sc_mcu7t3v3__nand4_2_42 VSS gf180mcu_as_sc_mcu7t3v3__inv_2_146/VDD VSS
+ VSS VSS VSS VSS gf180mcu_as_sc_mcu7t3v3__inv_2_142/VNW VSUBS gf180mcu_as_sc_mcu7t3v3__nand4_2
Xgf180mcu_as_sc_mcu7t3v3__nand4_2_147 VSS VSS VSS VSS VSS VSS gf180mcu_as_sc_mcu7t3v3__nand4_2_147/Y
+ gf180mcu_as_sc_mcu7t3v3__inv_2_547/VNW VSUBS gf180mcu_as_sc_mcu7t3v3__nand4_2
Xgf180mcu_as_sc_mcu7t3v3__nand4_2_31 gf180mcu_as_sc_mcu7t3v3__inv_2_99/VDD gf180mcu_as_sc_mcu7t3v3__inv_2_99/VSS
+ VSS VSS VSS VSS gf180mcu_as_sc_mcu7t3v3__nand4_2_31/Y gf180mcu_as_sc_mcu7t3v3__inv_2_99/VNW
+ VSUBS gf180mcu_as_sc_mcu7t3v3__nand4_2
Xgf180mcu_as_sc_mcu7t3v3__nand4_2_158 gf180mcu_as_sc_mcu7t3v3__inv_2_584/VDD gf180mcu_as_sc_mcu7t3v3__inv_2_585/VDD
+ VSS VSS VSS VSS VSS gf180mcu_as_sc_mcu7t3v3__inv_2_584/VNW VSUBS gf180mcu_as_sc_mcu7t3v3__nand4_2
Xgf180mcu_as_sc_mcu7t3v3__nand4_2_125 VSS VSS VSS VSS VSS VSS gf180mcu_as_sc_mcu7t3v3__nand4_2_125/Y
+ gf180mcu_as_sc_mcu7t3v3__inv_2_450/VNW VSUBS gf180mcu_as_sc_mcu7t3v3__nand4_2
Xgf180mcu_as_sc_mcu7t3v3__nand4_2_20 gf180mcu_as_sc_mcu7t3v3__inv_2_75/VDD VSS VSS
+ VSS VSS VSS VSS gf180mcu_as_sc_mcu7t3v3__inv_2_75/VNW VSUBS gf180mcu_as_sc_mcu7t3v3__nand4_2
Xgf180mcu_as_sc_mcu7t3v3__nand4_2_169 gf180mcu_as_sc_mcu7t3v3__inv_2_633/VDD gf180mcu_as_sc_mcu7t3v3__inv_2_633/VSS
+ VSS VSS VSS VSS VSS gf180mcu_as_sc_mcu7t3v3__inv_2_633/VNW VSUBS gf180mcu_as_sc_mcu7t3v3__nand4_2
Xgf180mcu_as_sc_mcu7t3v3__nand4_2_136 VSS VSS VSS VSS VSS VSS gf180mcu_as_sc_mcu7t3v3__nand4_2_136/Y
+ gf180mcu_as_sc_mcu7t3v3__inv_2_530/VNW VSUBS gf180mcu_as_sc_mcu7t3v3__nand4_2
Xgf180mcu_as_sc_mcu7t3v3__nand4_2_103 gf180mcu_as_sc_mcu7t3v3__inv_2_360/VDD gf180mcu_as_sc_mcu7t3v3__inv_2_361/VDD
+ VSS VSS VSS VSS VSS gf180mcu_as_sc_mcu7t3v3__inv_2_360/VNW VSUBS gf180mcu_as_sc_mcu7t3v3__nand4_2
Xgf180mcu_as_sc_mcu7t3v3__nand4_2_53 gf180mcu_as_sc_mcu7t3v3__inv_2_228/VSS VSS VSS
+ VSS VSS VSS gf180mcu_as_sc_mcu7t3v3__nand4_2_53/Y gf180mcu_as_sc_mcu7t3v3__inv_2_210/VNW
+ VSUBS gf180mcu_as_sc_mcu7t3v3__nand4_2
Xgf180mcu_as_sc_mcu7t3v3__nand4_2_114 VSS VSS VSS VSS VSS VSS VSS gf180mcu_as_sc_mcu7t3v3__inv_2_342/VNW
+ VSUBS gf180mcu_as_sc_mcu7t3v3__nand4_2
Xgf180mcu_as_sc_mcu7t3v3__nand4_2_64 VSS gf180mcu_as_sc_mcu7t3v3__inv_2_206/VDD VSS
+ VSS VSS VSS VSS gf180mcu_as_sc_mcu7t3v3__inv_2_204/VNW VSUBS gf180mcu_as_sc_mcu7t3v3__nand4_2
Xgf180mcu_as_sc_mcu7t3v3__nand4_2_97 gf180mcu_as_sc_mcu7t3v3__inv_2_363/VDD gf180mcu_as_sc_mcu7t3v3__inv_2_363/VDD
+ VSS VSS VSS VSS VSS gf180mcu_as_sc_mcu7t3v3__inv_2_362/VNW VSUBS gf180mcu_as_sc_mcu7t3v3__nand4_2
Xgf180mcu_as_sc_mcu7t3v3__nand4_2_75 VSS gf180mcu_as_sc_mcu7t3v3__inv_2_188/VDD VSS
+ VSS VSS VSS VSS gf180mcu_as_sc_mcu7t3v3__inv_2_181/VNW VSUBS gf180mcu_as_sc_mcu7t3v3__nand4_2
Xgf180mcu_as_sc_mcu7t3v3__nand4_2_86 gf180mcu_as_sc_mcu7t3v3__inv_2_257/VSS VSS VSS
+ VSS VSS VSS gf180mcu_as_sc_mcu7t3v3__nand4_2_86/Y gf180mcu_as_sc_mcu7t3v3__inv_2_246/VNW
+ VSUBS gf180mcu_as_sc_mcu7t3v3__nand4_2
Xu_t025_030 u_t025_030/c0_w0_bl u_t025_030/c0_w0_br u_t025_030/c0_w1_bl u_t025_030/c0_w1_br
+ u_t025_030/c0_r0_rbl u_t025_030/c0_r1_rbl u_t025_030/c1_w0_bl u_t025_030/c1_w0_br
+ u_t025_030/c1_w1_bl u_t025_030/c1_w1_br u_t025_030/c1_r0_rbl u_t025_030/c1_r1_rbl
+ u_t025_030/c2_w0_bl u_t025_030/c2_w0_br u_t025_030/c2_w1_bl u_t025_030/c2_w1_br
+ u_t025_030/c2_r0_rbl u_t025_030/c2_r1_rbl u_t025_030/c3_w0_bl u_t025_030/c3_w0_br
+ u_t025_030/c3_w1_bl u_t025_030/c3_w1_br u_t025_030/c3_r0_rbl u_t025_030/c3_r1_rbl
+ u_t025_030/r0_w0_wl u_t025_030/r0_w1_wl u_t025_030/r0_r0_rwl u_t025_030/r0_r1_rwl
+ u_t025_030/r1_w0_wl u_t025_030/r1_w1_wl u_t025_030/r1_r0_rwl u_t025_030/r1_r1_rwl
+ u_t025_030/r2_w0_wl u_t025_030/r2_w1_wl u_t025_030/r2_r0_rwl u_t025_030/r2_r1_rwl
+ u_t025_030/r3_w0_wl u_t025_030/r3_w1_wl u_t025_030/r3_r0_rwl u_t025_030/r3_r1_rwl
+ VSS u_t025_031/VSS VSUBS detronyx_12t_2w2r_rc4_4x4_routed_5layer_direct
Xu_t017_019 u_t017_019/c0_w0_bl u_t017_019/c0_w0_br u_t017_019/c0_w1_bl u_t017_019/c0_w1_br
+ u_t017_019/c0_r0_rbl u_t017_019/c0_r1_rbl u_t017_019/c1_w0_bl u_t017_019/c1_w0_br
+ u_t017_019/c1_w1_bl u_t017_019/c1_w1_br u_t017_019/c1_r0_rbl u_t017_019/c1_r1_rbl
+ u_t017_019/c2_w0_bl u_t017_019/c2_w0_br u_t017_019/c2_w1_bl u_t017_019/c2_w1_br
+ u_t017_019/c2_r0_rbl u_t017_019/c2_r1_rbl u_t017_019/c3_w0_bl u_t017_019/c3_w0_br
+ u_t017_019/c3_w1_bl u_t017_019/c3_w1_br u_t017_019/c3_r0_rbl u_t017_019/c3_r1_rbl
+ u_t017_019/r0_w0_wl u_t017_019/r0_w1_wl u_t017_019/r0_r0_rwl u_t017_019/r0_r1_rwl
+ u_t017_019/r1_w0_wl u_t017_019/r1_w1_wl u_t017_019/r1_r0_rwl u_t017_019/r1_r1_rwl
+ u_t017_019/r2_w0_wl u_t017_019/r2_w1_wl u_t017_019/r2_r0_rwl u_t017_019/r2_r1_rwl
+ u_t017_019/r3_w0_wl u_t017_019/r3_w1_wl u_t017_019/r3_r0_rwl u_t017_019/r3_r1_rwl
+ u_t017_019/VDD u_t017_031/VSS VSUBS detronyx_12t_2w2r_rc4_4x4_routed_5layer_direct
Xu_t017_008 u_t017_008/c0_w0_bl u_t017_008/c0_w0_br u_t017_008/c0_w1_bl u_t017_008/c0_w1_br
+ u_t017_008/c0_r0_rbl u_t017_008/c0_r1_rbl u_t017_008/c1_w0_bl u_t017_008/c1_w0_br
+ u_t017_008/c1_w1_bl u_t017_008/c1_w1_br u_t017_008/c1_r0_rbl u_t017_008/c1_r1_rbl
+ u_t017_008/c2_w0_bl u_t017_008/c2_w0_br u_t017_008/c2_w1_bl u_t017_008/c2_w1_br
+ u_t017_008/c2_r0_rbl u_t017_008/c2_r1_rbl u_t017_008/c3_w0_bl u_t017_008/c3_w0_br
+ u_t017_008/c3_w1_bl u_t017_008/c3_w1_br u_t017_008/c3_r0_rbl u_t017_008/c3_r1_rbl
+ u_t017_008/r0_w0_wl u_t017_008/r0_w1_wl u_t017_008/r0_r0_rwl u_t017_008/r0_r1_rwl
+ u_t017_008/r1_w0_wl u_t017_008/r1_w1_wl u_t017_008/r1_r0_rwl u_t017_008/r1_r1_rwl
+ u_t017_008/r2_w0_wl u_t017_008/r2_w1_wl u_t017_008/r2_r0_rwl u_t017_008/r2_r1_rwl
+ u_t017_008/r3_w0_wl u_t017_008/r3_w1_wl u_t017_008/r3_r0_rwl u_t017_008/r3_r1_rwl
+ VSS u_t017_031/VSS VSUBS detronyx_12t_2w2r_rc4_4x4_routed_5layer_direct
Xgf180mcu_as_sc_mcu7t3v3__inv_2_1194 VSS VSS gf180mcu_as_sc_mcu7t3v3__inv_2_1194/Y
+ VSS gf180mcu_as_sc_mcu7t3v3__inv_2_1194/VNW VSUBS gf180mcu_as_sc_mcu7t3v3__inv_2
Xgf180mcu_as_sc_mcu7t3v3__inv_2_1150 VSS VSS VSS VSS gf180mcu_as_sc_mcu7t3v3__inv_2_1151/VNW
+ VSUBS gf180mcu_as_sc_mcu7t3v3__inv_2
Xgf180mcu_as_sc_mcu7t3v3__inv_2_1161 VSS VSS VSS VSS gf180mcu_as_sc_mcu7t3v3__inv_2_1162/VNW
+ VSUBS gf180mcu_as_sc_mcu7t3v3__inv_2
Xgf180mcu_as_sc_mcu7t3v3__inv_2_1172 VSS VSS gf180mcu_as_sc_mcu7t3v3__inv_2_1172/Y
+ VSS gf180mcu_as_sc_mcu7t3v3__inv_2_1172/VNW VSUBS gf180mcu_as_sc_mcu7t3v3__inv_2
Xgf180mcu_as_sc_mcu7t3v3__inv_2_1183 VSS VSS VSS VSS gf180mcu_as_sc_mcu7t3v3__inv_2_1191/VNW
+ VSUBS gf180mcu_as_sc_mcu7t3v3__inv_2
Xu_t008_019 u_t008_019/c0_w0_bl u_t008_019/c0_w0_br u_t008_019/c0_w1_bl u_t008_019/c0_w1_br
+ u_t008_019/c0_r0_rbl u_t008_019/c0_r1_rbl u_t008_019/c1_w0_bl u_t008_019/c1_w0_br
+ u_t008_019/c1_w1_bl u_t008_019/c1_w1_br u_t008_019/c1_r0_rbl u_t008_019/c1_r1_rbl
+ u_t008_019/c2_w0_bl u_t008_019/c2_w0_br u_t008_019/c2_w1_bl u_t008_019/c2_w1_br
+ u_t008_019/c2_r0_rbl u_t008_019/c2_r1_rbl u_t008_019/c3_w0_bl u_t008_019/c3_w0_br
+ u_t008_019/c3_w1_bl u_t008_019/c3_w1_br u_t008_019/c3_r0_rbl u_t008_019/c3_r1_rbl
+ u_t008_019/r0_w0_wl u_t008_019/r0_w1_wl u_t008_019/r0_r0_rwl u_t008_019/r0_r1_rwl
+ u_t008_019/r1_w0_wl u_t008_019/r1_w1_wl u_t008_019/r1_r0_rwl u_t008_019/r1_r1_rwl
+ u_t008_019/r2_w0_wl u_t008_019/r2_w1_wl u_t008_019/r2_r0_rwl u_t008_019/r2_r1_rwl
+ u_t008_019/r3_w0_wl u_t008_019/r3_w1_wl u_t008_019/r3_r0_rwl u_t008_019/r3_r1_rwl
+ u_t008_019/VDD u_t008_031/VSS VSUBS detronyx_12t_2w2r_rc4_4x4_routed_5layer_direct
Xu_t008_008 u_t008_008/c0_w0_bl u_t008_008/c0_w0_br u_t008_008/c0_w1_bl u_t008_008/c0_w1_br
+ u_t008_008/c0_r0_rbl u_t008_008/c0_r1_rbl u_t008_008/c1_w0_bl u_t008_008/c1_w0_br
+ u_t008_008/c1_w1_bl u_t008_008/c1_w1_br u_t008_008/c1_r0_rbl u_t008_008/c1_r1_rbl
+ u_t008_008/c2_w0_bl u_t008_008/c2_w0_br u_t008_008/c2_w1_bl u_t008_008/c2_w1_br
+ u_t008_008/c2_r0_rbl u_t008_008/c2_r1_rbl u_t008_008/c3_w0_bl u_t008_008/c3_w0_br
+ u_t008_008/c3_w1_bl u_t008_008/c3_w1_br u_t008_008/c3_r0_rbl u_t008_008/c3_r1_rbl
+ u_t008_008/r0_w0_wl u_t008_008/r0_w1_wl u_t008_008/r0_r0_rwl u_t008_008/r0_r1_rwl
+ u_t008_008/r1_w0_wl u_t008_008/r1_w1_wl u_t008_008/r1_r0_rwl u_t008_008/r1_r1_rwl
+ u_t008_008/r2_w0_wl u_t008_008/r2_w1_wl u_t008_008/r2_r0_rwl u_t008_008/r2_r1_rwl
+ u_t008_008/r3_w0_wl u_t008_008/r3_w1_wl u_t008_008/r3_r0_rwl u_t008_008/r3_r1_rwl
+ VSS u_t008_031/VSS VSUBS detronyx_12t_2w2r_rc4_4x4_routed_5layer_direct
Xu_t016_030 u_t016_030/c0_w0_bl u_t016_030/c0_w0_br u_t016_030/c0_w1_bl u_t016_030/c0_w1_br
+ u_t016_030/c0_r0_rbl u_t016_030/c0_r1_rbl u_t016_030/c1_w0_bl u_t016_030/c1_w0_br
+ u_t016_030/c1_w1_bl u_t016_030/c1_w1_br u_t016_030/c1_r0_rbl u_t016_030/c1_r1_rbl
+ u_t016_030/c2_w0_bl u_t016_030/c2_w0_br u_t016_030/c2_w1_bl u_t016_030/c2_w1_br
+ u_t016_030/c2_r0_rbl u_t016_030/c2_r1_rbl u_t016_030/c3_w0_bl u_t016_030/c3_w0_br
+ u_t016_030/c3_w1_bl u_t016_030/c3_w1_br u_t016_030/c3_r0_rbl u_t016_030/c3_r1_rbl
+ u_t016_030/r0_w0_wl u_t016_030/r0_w1_wl u_t016_030/r0_r0_rwl u_t016_030/r0_r1_rwl
+ u_t016_030/r1_w0_wl u_t016_030/r1_w1_wl u_t016_030/r1_r0_rwl u_t016_030/r1_r1_rwl
+ u_t016_030/r2_w0_wl u_t016_030/r2_w1_wl u_t016_030/r2_r0_rwl u_t016_030/r2_r1_rwl
+ u_t016_030/r3_w0_wl u_t016_030/r3_w1_wl u_t016_030/r3_r0_rwl u_t016_030/r3_r1_rwl
+ VSS u_t016_031/VSS VSUBS detronyx_12t_2w2r_rc4_4x4_routed_5layer_direct
Xu_t031_022 u_t031_022/c0_w0_bl u_t031_022/c0_w0_br u_t031_022/c0_w1_bl u_t031_022/c0_w1_br
+ u_t031_022/c0_r0_rbl u_t031_022/c0_r1_rbl u_t031_022/c1_w0_bl u_t031_022/c1_w0_br
+ u_t031_022/c1_w1_bl u_t031_022/c1_w1_br u_t031_022/c1_r0_rbl u_t031_022/c1_r1_rbl
+ u_t031_022/c2_w0_bl u_t031_022/c2_w0_br u_t031_022/c2_w1_bl u_t031_022/c2_w1_br
+ u_t031_022/c2_r0_rbl u_t031_022/c2_r1_rbl u_t031_022/c3_w0_bl u_t031_022/c3_w0_br
+ u_t031_022/c3_w1_bl u_t031_022/c3_w1_br u_t031_022/c3_r0_rbl u_t031_022/c3_r1_rbl
+ u_t031_022/r0_w0_wl u_t031_022/r0_w1_wl u_t031_022/r0_r0_rwl u_t031_022/r0_r1_rwl
+ u_t031_022/r1_w0_wl u_t031_022/r1_w1_wl u_t031_022/r1_r0_rwl u_t031_022/r1_r1_rwl
+ u_t031_022/r2_w0_wl u_t031_022/r2_w1_wl u_t031_022/r2_r0_rwl u_t031_022/r2_r1_rwl
+ u_t031_022/r3_w0_wl u_t031_022/r3_w1_wl u_t031_022/r3_r0_rwl u_t031_022/r3_r1_rwl
+ VSS u_t031_024/VSS VSUBS detronyx_12t_2w2r_rc4_4x4_routed_5layer_direct
Xu_t031_011 u_t031_011/c0_w0_bl u_t031_011/c0_w0_br u_t031_011/c0_w1_bl u_t031_011/c0_w1_br
+ u_t031_011/c0_r0_rbl u_t031_011/c0_r1_rbl u_t031_011/c1_w0_bl u_t031_011/c1_w0_br
+ u_t031_011/c1_w1_bl u_t031_011/c1_w1_br u_t031_011/c1_r0_rbl u_t031_011/c1_r1_rbl
+ u_t031_011/c2_w0_bl u_t031_011/c2_w0_br u_t031_011/c2_w1_bl u_t031_011/c2_w1_br
+ u_t031_011/c2_r0_rbl u_t031_011/c2_r1_rbl u_t031_011/c3_w0_bl u_t031_011/c3_w0_br
+ u_t031_011/c3_w1_bl u_t031_011/c3_w1_br u_t031_011/c3_r0_rbl u_t031_011/c3_r1_rbl
+ u_t031_011/r0_w0_wl u_t031_011/r0_w1_wl u_t031_011/r0_r0_rwl u_t031_011/r0_r1_rwl
+ u_t031_011/r1_w0_wl u_t031_011/r1_w1_wl u_t031_011/r1_r0_rwl u_t031_011/r1_r1_rwl
+ u_t031_011/r2_w0_wl u_t031_011/r2_w1_wl u_t031_011/r2_r0_rwl u_t031_011/r2_r1_rwl
+ u_t031_011/r3_w0_wl u_t031_011/r3_w1_wl u_t031_011/r3_r0_rwl u_t031_011/r3_r1_rwl
+ u_t031_011/VDD u_t031_011/VSS VSUBS detronyx_12t_2w2r_rc4_4x4_routed_5layer_direct
Xu_t031_000 u_t031_000/c0_w0_bl u_t031_000/c0_w0_br u_t031_000/c0_w1_bl u_t031_000/c0_w1_br
+ u_t031_000/c0_r0_rbl u_t031_000/c0_r1_rbl u_t031_000/c1_w0_bl u_t031_000/c1_w0_br
+ u_t031_000/c1_w1_bl u_t031_000/c1_w1_br u_t031_000/c1_r0_rbl u_t031_000/c1_r1_rbl
+ u_t031_000/c2_w0_bl u_t031_000/c2_w0_br u_t031_000/c2_w1_bl u_t031_000/c2_w1_br
+ u_t031_000/c2_r0_rbl u_t031_000/c2_r1_rbl u_t031_000/c3_w0_bl u_t031_000/c3_w0_br
+ u_t031_000/c3_w1_bl u_t031_000/c3_w1_br u_t031_000/c3_r0_rbl u_t031_000/c3_r1_rbl
+ u_t031_000/r0_w0_wl u_t031_000/r0_w1_wl u_t031_000/r0_r0_rwl u_t031_000/r0_r1_rwl
+ u_t031_000/r1_w0_wl u_t031_000/r1_w1_wl u_t031_000/r1_r0_rwl u_t031_000/r1_r1_rwl
+ u_t031_000/r2_w0_wl u_t031_000/r2_w1_wl u_t031_000/r2_r0_rwl u_t031_000/r2_r1_rwl
+ u_t031_000/r3_w0_wl u_t031_000/r3_w1_wl u_t031_000/r3_r0_rwl u_t031_000/r3_r1_rwl
+ VSS u_t031_002/VSS VSUBS detronyx_12t_2w2r_rc4_4x4_routed_5layer_direct
Xgf180mcu_as_sc_mcu7t3v3__inv_2_634 gf180mcu_as_sc_mcu7t3v3__inv_2_636/VSS gf180mcu_as_sc_mcu7t3v3__inv_2_636/VSS
+ gf180mcu_as_sc_mcu7t3v3__inv_2_634/Y gf180mcu_as_sc_mcu7t3v3__inv_2_635/Y gf180mcu_as_sc_mcu7t3v3__inv_2_636/VNW
+ VSUBS gf180mcu_as_sc_mcu7t3v3__inv_2
Xgf180mcu_as_sc_mcu7t3v3__inv_2_601 gf180mcu_as_sc_mcu7t3v3__inv_2_601/VDD VSS gf180mcu_as_sc_mcu7t3v3__inv_2_601/Y
+ VSS gf180mcu_as_sc_mcu7t3v3__inv_2_601/VNW VSUBS gf180mcu_as_sc_mcu7t3v3__inv_2
Xgf180mcu_as_sc_mcu7t3v3__inv_2_623 gf180mcu_as_sc_mcu7t3v3__inv_2_629/VDD gf180mcu_as_sc_mcu7t3v3__inv_2_629/VDD
+ gf180mcu_as_sc_mcu7t3v3__inv_2_623/Y gf180mcu_as_sc_mcu7t3v3__inv_2_631/A gf180mcu_as_sc_mcu7t3v3__inv_2_625/VNW
+ VSUBS gf180mcu_as_sc_mcu7t3v3__inv_2
Xgf180mcu_as_sc_mcu7t3v3__inv_2_612 gf180mcu_as_sc_mcu7t3v3__inv_2_616/VDD gf180mcu_as_sc_mcu7t3v3__inv_2_616/VDD
+ gf180mcu_as_sc_mcu7t3v3__inv_2_612/Y VSS gf180mcu_as_sc_mcu7t3v3__inv_2_612/VNW
+ VSUBS gf180mcu_as_sc_mcu7t3v3__inv_2
Xgf180mcu_as_sc_mcu7t3v3__inv_2_678 gf180mcu_as_sc_mcu7t3v3__inv_2_679/VDD gf180mcu_as_sc_mcu7t3v3__inv_2_849/VDD
+ gf180mcu_as_sc_mcu7t3v3__inv_2_678/Y gf180mcu_as_sc_mcu7t3v3__inv_2_679/Y gf180mcu_as_sc_mcu7t3v3__inv_2_679/VNW
+ VSUBS gf180mcu_as_sc_mcu7t3v3__inv_2
Xgf180mcu_as_sc_mcu7t3v3__inv_2_667 gf180mcu_as_sc_mcu7t3v3__inv_2_667/VDD gf180mcu_as_sc_mcu7t3v3__inv_2_671/VDD
+ gf180mcu_as_sc_mcu7t3v3__inv_2_667/Y VSS gf180mcu_as_sc_mcu7t3v3__inv_2_667/VNW
+ VSUBS gf180mcu_as_sc_mcu7t3v3__inv_2
Xgf180mcu_as_sc_mcu7t3v3__inv_2_656 gf180mcu_as_sc_mcu7t3v3__inv_2_684/VSS VSS gf180mcu_as_sc_mcu7t3v3__inv_2_656/Y
+ gf180mcu_as_sc_mcu7t3v3__inv_2_660/Y gf180mcu_as_sc_mcu7t3v3__inv_2_660/VNW VSUBS
+ gf180mcu_as_sc_mcu7t3v3__inv_2
Xgf180mcu_as_sc_mcu7t3v3__inv_2_645 gf180mcu_as_sc_mcu7t3v3__inv_2_647/VDD gf180mcu_as_sc_mcu7t3v3__inv_2_651/VDD
+ gf180mcu_as_sc_mcu7t3v3__inv_2_645/Y gf180mcu_as_sc_mcu7t3v3__inv_2_739/A gf180mcu_as_sc_mcu7t3v3__inv_2_647/VNW
+ VSUBS gf180mcu_as_sc_mcu7t3v3__inv_2
Xgf180mcu_as_sc_mcu7t3v3__inv_2_689 VSS gf180mcu_as_sc_mcu7t3v3__inv_2_695/VDD gf180mcu_as_sc_mcu7t3v3__inv_2_689/Y
+ gf180mcu_as_sc_mcu7t3v3__inv_2_716/Y gf180mcu_as_sc_mcu7t3v3__inv_2_691/VNW VSUBS
+ gf180mcu_as_sc_mcu7t3v3__inv_2
Xu_t007_030 u_t007_030/c0_w0_bl u_t007_030/c0_w0_br u_t007_030/c0_w1_bl u_t007_030/c0_w1_br
+ u_t007_030/c0_r0_rbl u_t007_030/c0_r1_rbl u_t007_030/c1_w0_bl u_t007_030/c1_w0_br
+ u_t007_030/c1_w1_bl u_t007_030/c1_w1_br u_t007_030/c1_r0_rbl u_t007_030/c1_r1_rbl
+ u_t007_030/c2_w0_bl u_t007_030/c2_w0_br u_t007_030/c2_w1_bl u_t007_030/c2_w1_br
+ u_t007_030/c2_r0_rbl u_t007_030/c2_r1_rbl u_t007_030/c3_w0_bl u_t007_030/c3_w0_br
+ u_t007_030/c3_w1_bl u_t007_030/c3_w1_br u_t007_030/c3_r0_rbl u_t007_030/c3_r1_rbl
+ u_t007_030/r0_w0_wl u_t007_030/r0_w1_wl u_t007_030/r0_r0_rwl u_t007_030/r0_r1_rwl
+ u_t007_030/r1_w0_wl u_t007_030/r1_w1_wl u_t007_030/r1_r0_rwl u_t007_030/r1_r1_rwl
+ u_t007_030/r2_w0_wl u_t007_030/r2_w1_wl u_t007_030/r2_r0_rwl u_t007_030/r2_r1_rwl
+ u_t007_030/r3_w0_wl u_t007_030/r3_w1_wl u_t007_030/r3_r0_rwl u_t007_030/r3_r1_rwl
+ VSS u_t007_031/VSS VSUBS detronyx_12t_2w2r_rc4_4x4_routed_5layer_direct
Xu_t022_022 u_t022_022/c0_w0_bl u_t022_022/c0_w0_br u_t022_022/c0_w1_bl u_t022_022/c0_w1_br
+ u_t022_022/c0_r0_rbl u_t022_022/c0_r1_rbl u_t022_022/c1_w0_bl u_t022_022/c1_w0_br
+ u_t022_022/c1_w1_bl u_t022_022/c1_w1_br u_t022_022/c1_r0_rbl u_t022_022/c1_r1_rbl
+ u_t022_022/c2_w0_bl u_t022_022/c2_w0_br u_t022_022/c2_w1_bl u_t022_022/c2_w1_br
+ u_t022_022/c2_r0_rbl u_t022_022/c2_r1_rbl u_t022_022/c3_w0_bl u_t022_022/c3_w0_br
+ u_t022_022/c3_w1_bl u_t022_022/c3_w1_br u_t022_022/c3_r0_rbl u_t022_022/c3_r1_rbl
+ u_t022_022/r0_w0_wl u_t022_022/r0_w1_wl u_t022_022/r0_r0_rwl u_t022_022/r0_r1_rwl
+ u_t022_022/r1_w0_wl u_t022_022/r1_w1_wl u_t022_022/r1_r0_rwl u_t022_022/r1_r1_rwl
+ u_t022_022/r2_w0_wl u_t022_022/r2_w1_wl u_t022_022/r2_r0_rwl u_t022_022/r2_r1_rwl
+ u_t022_022/r3_w0_wl u_t022_022/r3_w1_wl u_t022_022/r3_r0_rwl u_t022_022/r3_r1_rwl
+ VSS u_t022_031/VSS VSUBS detronyx_12t_2w2r_rc4_4x4_routed_5layer_direct
Xu_t022_011 u_t022_011/c0_w0_bl u_t022_011/c0_w0_br u_t022_011/c0_w1_bl u_t022_011/c0_w1_br
+ u_t022_011/c0_r0_rbl u_t022_011/c0_r1_rbl u_t022_011/c1_w0_bl u_t022_011/c1_w0_br
+ u_t022_011/c1_w1_bl u_t022_011/c1_w1_br u_t022_011/c1_r0_rbl u_t022_011/c1_r1_rbl
+ u_t022_011/c2_w0_bl u_t022_011/c2_w0_br u_t022_011/c2_w1_bl u_t022_011/c2_w1_br
+ u_t022_011/c2_r0_rbl u_t022_011/c2_r1_rbl u_t022_011/c3_w0_bl u_t022_011/c3_w0_br
+ u_t022_011/c3_w1_bl u_t022_011/c3_w1_br u_t022_011/c3_r0_rbl u_t022_011/c3_r1_rbl
+ u_t022_011/r0_w0_wl u_t022_011/r0_w1_wl u_t022_011/r0_r0_rwl u_t022_011/r0_r1_rwl
+ u_t022_011/r1_w0_wl u_t022_011/r1_w1_wl u_t022_011/r1_r0_rwl u_t022_011/r1_r1_rwl
+ u_t022_011/r2_w0_wl u_t022_011/r2_w1_wl u_t022_011/r2_r0_rwl u_t022_011/r2_r1_rwl
+ u_t022_011/r3_w0_wl u_t022_011/r3_w1_wl u_t022_011/r3_r0_rwl u_t022_011/r3_r1_rwl
+ u_t022_011/VDD u_t022_031/VSS VSUBS detronyx_12t_2w2r_rc4_4x4_routed_5layer_direct
Xu_t022_000 u_t022_000/c0_w0_bl u_t022_000/c0_w0_br u_t022_000/c0_w1_bl u_t022_000/c0_w1_br
+ u_t022_000/c0_r0_rbl u_t022_000/c0_r1_rbl u_t022_000/c1_w0_bl u_t022_000/c1_w0_br
+ u_t022_000/c1_w1_bl u_t022_000/c1_w1_br u_t022_000/c1_r0_rbl u_t022_000/c1_r1_rbl
+ u_t022_000/c2_w0_bl u_t022_000/c2_w0_br u_t022_000/c2_w1_bl u_t022_000/c2_w1_br
+ u_t022_000/c2_r0_rbl u_t022_000/c2_r1_rbl u_t022_000/c3_w0_bl u_t022_000/c3_w0_br
+ u_t022_000/c3_w1_bl u_t022_000/c3_w1_br u_t022_000/c3_r0_rbl u_t022_000/c3_r1_rbl
+ u_t022_000/r0_w0_wl u_t022_000/r0_w1_wl u_t022_000/r0_r0_rwl u_t022_000/r0_r1_rwl
+ u_t022_000/r1_w0_wl u_t022_000/r1_w1_wl u_t022_000/r1_r0_rwl u_t022_000/r1_r1_rwl
+ u_t022_000/r2_w0_wl u_t022_000/r2_w1_wl u_t022_000/r2_r0_rwl u_t022_000/r2_r1_rwl
+ u_t022_000/r3_w0_wl u_t022_000/r3_w1_wl u_t022_000/r3_r0_rwl u_t022_000/r3_r1_rwl
+ VSS u_t022_031/VSS VSUBS detronyx_12t_2w2r_rc4_4x4_routed_5layer_direct
Xu_t013_022 u_t013_022/c0_w0_bl u_t013_022/c0_w0_br u_t013_022/c0_w1_bl u_t013_022/c0_w1_br
+ u_t013_022/c0_r0_rbl u_t013_022/c0_r1_rbl u_t013_022/c1_w0_bl u_t013_022/c1_w0_br
+ u_t013_022/c1_w1_bl u_t013_022/c1_w1_br u_t013_022/c1_r0_rbl u_t013_022/c1_r1_rbl
+ u_t013_022/c2_w0_bl u_t013_022/c2_w0_br u_t013_022/c2_w1_bl u_t013_022/c2_w1_br
+ u_t013_022/c2_r0_rbl u_t013_022/c2_r1_rbl u_t013_022/c3_w0_bl u_t013_022/c3_w0_br
+ u_t013_022/c3_w1_bl u_t013_022/c3_w1_br u_t013_022/c3_r0_rbl u_t013_022/c3_r1_rbl
+ u_t013_022/r0_w0_wl u_t013_022/r0_w1_wl u_t013_022/r0_r0_rwl u_t013_022/r0_r1_rwl
+ u_t013_022/r1_w0_wl u_t013_022/r1_w1_wl u_t013_022/r1_r0_rwl u_t013_022/r1_r1_rwl
+ u_t013_022/r2_w0_wl u_t013_022/r2_w1_wl u_t013_022/r2_r0_rwl u_t013_022/r2_r1_rwl
+ u_t013_022/r3_w0_wl u_t013_022/r3_w1_wl u_t013_022/r3_r0_rwl u_t013_022/r3_r1_rwl
+ VSS u_t013_031/VSS VSUBS detronyx_12t_2w2r_rc4_4x4_routed_5layer_direct
Xu_t013_011 u_t013_011/c0_w0_bl u_t013_011/c0_w0_br u_t013_011/c0_w1_bl u_t013_011/c0_w1_br
+ u_t013_011/c0_r0_rbl u_t013_011/c0_r1_rbl u_t013_011/c1_w0_bl u_t013_011/c1_w0_br
+ u_t013_011/c1_w1_bl u_t013_011/c1_w1_br u_t013_011/c1_r0_rbl u_t013_011/c1_r1_rbl
+ u_t013_011/c2_w0_bl u_t013_011/c2_w0_br u_t013_011/c2_w1_bl u_t013_011/c2_w1_br
+ u_t013_011/c2_r0_rbl u_t013_011/c2_r1_rbl u_t013_011/c3_w0_bl u_t013_011/c3_w0_br
+ u_t013_011/c3_w1_bl u_t013_011/c3_w1_br u_t013_011/c3_r0_rbl u_t013_011/c3_r1_rbl
+ u_t013_011/r0_w0_wl u_t013_011/r0_w1_wl u_t013_011/r0_r0_rwl u_t013_011/r0_r1_rwl
+ u_t013_011/r1_w0_wl u_t013_011/r1_w1_wl u_t013_011/r1_r0_rwl u_t013_011/r1_r1_rwl
+ u_t013_011/r2_w0_wl u_t013_011/r2_w1_wl u_t013_011/r2_r0_rwl u_t013_011/r2_r1_rwl
+ u_t013_011/r3_w0_wl u_t013_011/r3_w1_wl u_t013_011/r3_r0_rwl u_t013_011/r3_r1_rwl
+ u_t013_011/VDD u_t013_031/VSS VSUBS detronyx_12t_2w2r_rc4_4x4_routed_5layer_direct
Xu_t013_000 u_t013_000/c0_w0_bl u_t013_000/c0_w0_br u_t013_000/c0_w1_bl u_t013_000/c0_w1_br
+ u_t013_000/c0_r0_rbl u_t013_000/c0_r1_rbl u_t013_000/c1_w0_bl u_t013_000/c1_w0_br
+ u_t013_000/c1_w1_bl u_t013_000/c1_w1_br u_t013_000/c1_r0_rbl u_t013_000/c1_r1_rbl
+ u_t013_000/c2_w0_bl u_t013_000/c2_w0_br u_t013_000/c2_w1_bl u_t013_000/c2_w1_br
+ u_t013_000/c2_r0_rbl u_t013_000/c2_r1_rbl u_t013_000/c3_w0_bl u_t013_000/c3_w0_br
+ u_t013_000/c3_w1_bl u_t013_000/c3_w1_br u_t013_000/c3_r0_rbl u_t013_000/c3_r1_rbl
+ u_t013_000/r0_w0_wl u_t013_000/r0_w1_wl u_t013_000/r0_r0_rwl u_t013_000/r0_r1_rwl
+ u_t013_000/r1_w0_wl u_t013_000/r1_w1_wl u_t013_000/r1_r0_rwl u_t013_000/r1_r1_rwl
+ u_t013_000/r2_w0_wl u_t013_000/r2_w1_wl u_t013_000/r2_r0_rwl u_t013_000/r2_r1_rwl
+ u_t013_000/r3_w0_wl u_t013_000/r3_w1_wl u_t013_000/r3_r0_rwl u_t013_000/r3_r1_rwl
+ VSS u_t013_031/VSS VSUBS detronyx_12t_2w2r_rc4_4x4_routed_5layer_direct
Xgf180mcu_as_sc_mcu7t3v3__inv_2_420 gf180mcu_as_sc_mcu7t3v3__nand3_2_5/VDD gf180mcu_as_sc_mcu7t3v3__nor2_2_6/VSS
+ VSS VSS gf180mcu_as_sc_mcu7t3v3__nand3_2_5/VNW VSUBS gf180mcu_as_sc_mcu7t3v3__inv_2
Xu_t004_022 u_t004_022/c0_w0_bl u_t004_022/c0_w0_br u_t004_022/c0_w1_bl u_t004_022/c0_w1_br
+ u_t004_022/c0_r0_rbl u_t004_022/c0_r1_rbl u_t004_022/c1_w0_bl u_t004_022/c1_w0_br
+ u_t004_022/c1_w1_bl u_t004_022/c1_w1_br u_t004_022/c1_r0_rbl u_t004_022/c1_r1_rbl
+ u_t004_022/c2_w0_bl u_t004_022/c2_w0_br u_t004_022/c2_w1_bl u_t004_022/c2_w1_br
+ u_t004_022/c2_r0_rbl u_t004_022/c2_r1_rbl u_t004_022/c3_w0_bl u_t004_022/c3_w0_br
+ u_t004_022/c3_w1_bl u_t004_022/c3_w1_br u_t004_022/c3_r0_rbl u_t004_022/c3_r1_rbl
+ u_t004_022/r0_w0_wl u_t004_022/r0_w1_wl u_t004_022/r0_r0_rwl u_t004_022/r0_r1_rwl
+ u_t004_022/r1_w0_wl u_t004_022/r1_w1_wl u_t004_022/r1_r0_rwl u_t004_022/r1_r1_rwl
+ u_t004_022/r2_w0_wl u_t004_022/r2_w1_wl u_t004_022/r2_r0_rwl u_t004_022/r2_r1_rwl
+ u_t004_022/r3_w0_wl u_t004_022/r3_w1_wl u_t004_022/r3_r0_rwl u_t004_022/r3_r1_rwl
+ VSS u_t004_031/VSS VSUBS detronyx_12t_2w2r_rc4_4x4_routed_5layer_direct
Xu_t004_011 u_t004_011/c0_w0_bl u_t004_011/c0_w0_br u_t004_011/c0_w1_bl u_t004_011/c0_w1_br
+ u_t004_011/c0_r0_rbl u_t004_011/c0_r1_rbl u_t004_011/c1_w0_bl u_t004_011/c1_w0_br
+ u_t004_011/c1_w1_bl u_t004_011/c1_w1_br u_t004_011/c1_r0_rbl u_t004_011/c1_r1_rbl
+ u_t004_011/c2_w0_bl u_t004_011/c2_w0_br u_t004_011/c2_w1_bl u_t004_011/c2_w1_br
+ u_t004_011/c2_r0_rbl u_t004_011/c2_r1_rbl u_t004_011/c3_w0_bl u_t004_011/c3_w0_br
+ u_t004_011/c3_w1_bl u_t004_011/c3_w1_br u_t004_011/c3_r0_rbl u_t004_011/c3_r1_rbl
+ u_t004_011/r0_w0_wl u_t004_011/r0_w1_wl u_t004_011/r0_r0_rwl u_t004_011/r0_r1_rwl
+ u_t004_011/r1_w0_wl u_t004_011/r1_w1_wl u_t004_011/r1_r0_rwl u_t004_011/r1_r1_rwl
+ u_t004_011/r2_w0_wl u_t004_011/r2_w1_wl u_t004_011/r2_r0_rwl u_t004_011/r2_r1_rwl
+ u_t004_011/r3_w0_wl u_t004_011/r3_w1_wl u_t004_011/r3_r0_rwl u_t004_011/r3_r1_rwl
+ u_t004_011/VDD u_t004_031/VSS VSUBS detronyx_12t_2w2r_rc4_4x4_routed_5layer_direct
Xu_t004_000 u_t004_000/c0_w0_bl u_t004_000/c0_w0_br u_t004_000/c0_w1_bl u_t004_000/c0_w1_br
+ u_t004_000/c0_r0_rbl u_t004_000/c0_r1_rbl u_t004_000/c1_w0_bl u_t004_000/c1_w0_br
+ u_t004_000/c1_w1_bl u_t004_000/c1_w1_br u_t004_000/c1_r0_rbl u_t004_000/c1_r1_rbl
+ u_t004_000/c2_w0_bl u_t004_000/c2_w0_br u_t004_000/c2_w1_bl u_t004_000/c2_w1_br
+ u_t004_000/c2_r0_rbl u_t004_000/c2_r1_rbl u_t004_000/c3_w0_bl u_t004_000/c3_w0_br
+ u_t004_000/c3_w1_bl u_t004_000/c3_w1_br u_t004_000/c3_r0_rbl u_t004_000/c3_r1_rbl
+ u_t004_000/r0_w0_wl u_t004_000/r0_w1_wl u_t004_000/r0_r0_rwl u_t004_000/r0_r1_rwl
+ u_t004_000/r1_w0_wl u_t004_000/r1_w1_wl u_t004_000/r1_r0_rwl u_t004_000/r1_r1_rwl
+ u_t004_000/r2_w0_wl u_t004_000/r2_w1_wl u_t004_000/r2_r0_rwl u_t004_000/r2_r1_rwl
+ u_t004_000/r3_w0_wl u_t004_000/r3_w1_wl u_t004_000/r3_r0_rwl u_t004_000/r3_r1_rwl
+ VSS u_t004_031/VSS VSUBS detronyx_12t_2w2r_rc4_4x4_routed_5layer_direct
Xgf180mcu_as_sc_mcu7t3v3__inv_2_453 gf180mcu_as_sc_mcu7t3v3__nor2_2_5/VDD gf180mcu_as_sc_mcu7t3v3__nand3_2_8/VSS
+ gf180mcu_as_sc_mcu7t3v3__inv_2_453/Y VSS gf180mcu_as_sc_mcu7t3v3__nor2_2_5/VNW VSUBS
+ gf180mcu_as_sc_mcu7t3v3__inv_2
Xgf180mcu_as_sc_mcu7t3v3__inv_2_464 gf180mcu_as_sc_mcu7t3v3__nor2_2_5/VDD gf180mcu_as_sc_mcu7t3v3__nand3_2_8/VSS
+ VSS VSS gf180mcu_as_sc_mcu7t3v3__nor2_2_5/VNW VSUBS gf180mcu_as_sc_mcu7t3v3__inv_2
Xgf180mcu_as_sc_mcu7t3v3__inv_2_442 gf180mcu_as_sc_mcu7t3v3__nor2_2_4/VDD gf180mcu_as_sc_mcu7t3v3__nor2_2_4/VSS
+ VSS VSS gf180mcu_as_sc_mcu7t3v3__nor2_2_4/VNW VSUBS gf180mcu_as_sc_mcu7t3v3__inv_2
Xgf180mcu_as_sc_mcu7t3v3__inv_2_475 gf180mcu_as_sc_mcu7t3v3__nor2_2_4/VDD gf180mcu_as_sc_mcu7t3v3__nand3_2_8/VSS
+ VSS VSS gf180mcu_as_sc_mcu7t3v3__nor2_2_4/VNW VSUBS gf180mcu_as_sc_mcu7t3v3__inv_2
Xgf180mcu_as_sc_mcu7t3v3__inv_2_431 gf180mcu_as_sc_mcu7t3v3__nor2_2_6/VDD gf180mcu_as_sc_mcu7t3v3__nand3_2_3/VSS
+ VSS VSS gf180mcu_as_sc_mcu7t3v3__nor2_2_6/VNW VSUBS gf180mcu_as_sc_mcu7t3v3__inv_2
Xgf180mcu_as_sc_mcu7t3v3__inv_2_497 gf180mcu_as_sc_mcu7t3v3__nand3_2_5/VDD gf180mcu_as_sc_mcu7t3v3__nor2_2_6/VSS
+ VSS VSS gf180mcu_as_sc_mcu7t3v3__nand3_2_5/VNW VSUBS gf180mcu_as_sc_mcu7t3v3__inv_2
Xgf180mcu_as_sc_mcu7t3v3__inv_2_486 gf180mcu_as_sc_mcu7t3v3__nand3_2_5/VDD gf180mcu_as_sc_mcu7t3v3__nor2_2_6/VSS
+ VSS VSS gf180mcu_as_sc_mcu7t3v3__nand3_2_5/VNW VSUBS gf180mcu_as_sc_mcu7t3v3__inv_2
Xu_t010_025 u_t010_025/c0_w0_bl u_t010_025/c0_w0_br u_t010_025/c0_w1_bl u_t010_025/c0_w1_br
+ u_t010_025/c0_r0_rbl u_t010_025/c0_r1_rbl u_t010_025/c1_w0_bl u_t010_025/c1_w0_br
+ u_t010_025/c1_w1_bl u_t010_025/c1_w1_br u_t010_025/c1_r0_rbl u_t010_025/c1_r1_rbl
+ u_t010_025/c2_w0_bl u_t010_025/c2_w0_br u_t010_025/c2_w1_bl u_t010_025/c2_w1_br
+ u_t010_025/c2_r0_rbl u_t010_025/c2_r1_rbl u_t010_025/c3_w0_bl u_t010_025/c3_w0_br
+ u_t010_025/c3_w1_bl u_t010_025/c3_w1_br u_t010_025/c3_r0_rbl u_t010_025/c3_r1_rbl
+ u_t010_025/r0_w0_wl u_t010_025/r0_w1_wl u_t010_025/r0_r0_rwl u_t010_025/r0_r1_rwl
+ u_t010_025/r1_w0_wl u_t010_025/r1_w1_wl u_t010_025/r1_r0_rwl u_t010_025/r1_r1_rwl
+ u_t010_025/r2_w0_wl u_t010_025/r2_w1_wl u_t010_025/r2_r0_rwl u_t010_025/r2_r1_rwl
+ u_t010_025/r3_w0_wl u_t010_025/r3_w1_wl u_t010_025/r3_r0_rwl u_t010_025/r3_r1_rwl
+ VSS u_t010_025/VSS VSUBS detronyx_12t_2w2r_rc4_4x4_routed_5layer_direct
Xu_t010_014 u_t010_014/c0_w0_bl u_t010_014/c0_w0_br u_t010_014/c0_w1_bl u_t010_014/c0_w1_br
+ u_t010_014/c0_r0_rbl u_t010_014/c0_r1_rbl u_t010_014/c1_w0_bl u_t010_014/c1_w0_br
+ u_t010_014/c1_w1_bl u_t010_014/c1_w1_br u_t010_014/c1_r0_rbl u_t010_014/c1_r1_rbl
+ u_t010_014/c2_w0_bl u_t010_014/c2_w0_br u_t010_014/c2_w1_bl u_t010_014/c2_w1_br
+ u_t010_014/c2_r0_rbl u_t010_014/c2_r1_rbl u_t010_014/c3_w0_bl u_t010_014/c3_w0_br
+ u_t010_014/c3_w1_bl u_t010_014/c3_w1_br u_t010_014/c3_r0_rbl u_t010_014/c3_r1_rbl
+ u_t010_014/r0_w0_wl u_t010_014/r0_w1_wl u_t010_014/r0_r0_rwl u_t010_014/r0_r1_rwl
+ u_t010_014/r1_w0_wl u_t010_014/r1_w1_wl u_t010_014/r1_r0_rwl u_t010_014/r1_r1_rwl
+ u_t010_014/r2_w0_wl u_t010_014/r2_w1_wl u_t010_014/r2_r0_rwl u_t010_014/r2_r1_rwl
+ u_t010_014/r3_w0_wl u_t010_014/r3_w1_wl u_t010_014/r3_r0_rwl u_t010_014/r3_r1_rwl
+ u_t010_014/VDD u_t010_017/VSS VSUBS detronyx_12t_2w2r_rc4_4x4_routed_5layer_direct
Xu_t010_003 u_t010_003/c0_w0_bl u_t010_003/c0_w0_br u_t010_003/c0_w1_bl u_t010_003/c0_w1_br
+ u_t010_003/c0_r0_rbl u_t010_003/c0_r1_rbl u_t010_003/c1_w0_bl u_t010_003/c1_w0_br
+ u_t010_003/c1_w1_bl u_t010_003/c1_w1_br u_t010_003/c1_r0_rbl u_t010_003/c1_r1_rbl
+ u_t010_003/c2_w0_bl u_t010_003/c2_w0_br u_t010_003/c2_w1_bl u_t010_003/c2_w1_br
+ u_t010_003/c2_r0_rbl u_t010_003/c2_r1_rbl u_t010_003/c3_w0_bl u_t010_003/c3_w0_br
+ u_t010_003/c3_w1_bl u_t010_003/c3_w1_br u_t010_003/c3_r0_rbl u_t010_003/c3_r1_rbl
+ u_t010_003/r0_w0_wl u_t010_003/r0_w1_wl u_t010_003/r0_r0_rwl u_t010_003/r0_r1_rwl
+ u_t010_003/r1_w0_wl u_t010_003/r1_w1_wl u_t010_003/r1_r0_rwl u_t010_003/r1_r1_rwl
+ u_t010_003/r2_w0_wl u_t010_003/r2_w1_wl u_t010_003/r2_r0_rwl u_t010_003/r2_r1_rwl
+ u_t010_003/r3_w0_wl u_t010_003/r3_w1_wl u_t010_003/r3_r0_rwl u_t010_003/r3_r1_rwl
+ u_t010_003/VDD u_t010_003/VSS VSUBS detronyx_12t_2w2r_rc4_4x4_routed_5layer_direct
Xu_t001_025 u_t001_025/c0_w0_bl u_t001_025/c0_w0_br u_t001_025/c0_w1_bl u_t001_025/c0_w1_br
+ u_t001_025/c0_r0_rbl u_t001_025/c0_r1_rbl u_t001_025/c1_w0_bl u_t001_025/c1_w0_br
+ u_t001_025/c1_w1_bl u_t001_025/c1_w1_br u_t001_025/c1_r0_rbl u_t001_025/c1_r1_rbl
+ u_t001_025/c2_w0_bl u_t001_025/c2_w0_br u_t001_025/c2_w1_bl u_t001_025/c2_w1_br
+ u_t001_025/c2_r0_rbl u_t001_025/c2_r1_rbl u_t001_025/c3_w0_bl u_t001_025/c3_w0_br
+ u_t001_025/c3_w1_bl u_t001_025/c3_w1_br u_t001_025/c3_r0_rbl u_t001_025/c3_r1_rbl
+ u_t001_025/r0_w0_wl u_t001_025/r0_w1_wl u_t001_025/r0_r0_rwl u_t001_025/r0_r1_rwl
+ u_t001_025/r1_w0_wl u_t001_025/r1_w1_wl u_t001_025/r1_r0_rwl u_t001_025/r1_r1_rwl
+ u_t001_025/r2_w0_wl u_t001_025/r2_w1_wl u_t001_025/r2_r0_rwl u_t001_025/r2_r1_rwl
+ u_t001_025/r3_w0_wl u_t001_025/r3_w1_wl u_t001_025/r3_r0_rwl u_t001_025/r3_r1_rwl
+ VSS u_t001_031/VSS VSUBS detronyx_12t_2w2r_rc4_4x4_routed_5layer_direct
Xu_t001_014 u_t001_014/c0_w0_bl u_t001_014/c0_w0_br u_t001_014/c0_w1_bl u_t001_014/c0_w1_br
+ u_t001_014/c0_r0_rbl u_t001_014/c0_r1_rbl u_t001_014/c1_w0_bl u_t001_014/c1_w0_br
+ u_t001_014/c1_w1_bl u_t001_014/c1_w1_br u_t001_014/c1_r0_rbl u_t001_014/c1_r1_rbl
+ u_t001_014/c2_w0_bl u_t001_014/c2_w0_br u_t001_014/c2_w1_bl u_t001_014/c2_w1_br
+ u_t001_014/c2_r0_rbl u_t001_014/c2_r1_rbl u_t001_014/c3_w0_bl u_t001_014/c3_w0_br
+ u_t001_014/c3_w1_bl u_t001_014/c3_w1_br u_t001_014/c3_r0_rbl u_t001_014/c3_r1_rbl
+ u_t001_014/r0_w0_wl u_t001_014/r0_w1_wl u_t001_014/r0_r0_rwl u_t001_014/r0_r1_rwl
+ u_t001_014/r1_w0_wl u_t001_014/r1_w1_wl u_t001_014/r1_r0_rwl u_t001_014/r1_r1_rwl
+ u_t001_014/r2_w0_wl u_t001_014/r2_w1_wl u_t001_014/r2_r0_rwl u_t001_014/r2_r1_rwl
+ u_t001_014/r3_w0_wl u_t001_014/r3_w1_wl u_t001_014/r3_r0_rwl u_t001_014/r3_r1_rwl
+ u_t001_014/VDD u_t001_031/VSS VSUBS detronyx_12t_2w2r_rc4_4x4_routed_5layer_direct
Xu_t001_003 u_t001_003/c0_w0_bl u_t001_003/c0_w0_br u_t001_003/c0_w1_bl u_t001_003/c0_w1_br
+ u_t001_003/c0_r0_rbl u_t001_003/c0_r1_rbl u_t001_003/c1_w0_bl u_t001_003/c1_w0_br
+ u_t001_003/c1_w1_bl u_t001_003/c1_w1_br u_t001_003/c1_r0_rbl u_t001_003/c1_r1_rbl
+ u_t001_003/c2_w0_bl u_t001_003/c2_w0_br u_t001_003/c2_w1_bl u_t001_003/c2_w1_br
+ u_t001_003/c2_r0_rbl u_t001_003/c2_r1_rbl u_t001_003/c3_w0_bl u_t001_003/c3_w0_br
+ u_t001_003/c3_w1_bl u_t001_003/c3_w1_br u_t001_003/c3_r0_rbl u_t001_003/c3_r1_rbl
+ u_t001_003/r0_w0_wl u_t001_003/r0_w1_wl u_t001_003/r0_r0_rwl u_t001_003/r0_r1_rwl
+ u_t001_003/r1_w0_wl u_t001_003/r1_w1_wl u_t001_003/r1_r0_rwl u_t001_003/r1_r1_rwl
+ u_t001_003/r2_w0_wl u_t001_003/r2_w1_wl u_t001_003/r2_r0_rwl u_t001_003/r2_r1_rwl
+ u_t001_003/r3_w0_wl u_t001_003/r3_w1_wl u_t001_003/r3_r0_rwl u_t001_003/r3_r1_rwl
+ u_t001_003/VDD u_t001_031/VSS VSUBS detronyx_12t_2w2r_rc4_4x4_routed_5layer_direct
Xgf180mcu_as_sc_mcu7t3v3__inv_2_261 gf180mcu_as_sc_mcu7t3v3__inv_2_361/VDD gf180mcu_as_sc_mcu7t3v3__inv_2_363/VDD
+ VSS gf180mcu_as_sc_mcu7t3v3__inv_2_361/Y gf180mcu_as_sc_mcu7t3v3__inv_2_361/VNW
+ VSUBS gf180mcu_as_sc_mcu7t3v3__inv_2
Xgf180mcu_as_sc_mcu7t3v3__inv_2_250 VSS VSS VSS VSS gf180mcu_as_sc_mcu7t3v3__inv_2_252/VNW
+ VSUBS gf180mcu_as_sc_mcu7t3v3__inv_2
Xgf180mcu_as_sc_mcu7t3v3__inv_2_283 gf180mcu_as_sc_mcu7t3v3__inv_2_364/VDD VSS VSS
+ gf180mcu_as_sc_mcu7t3v3__inv_2_364/Y gf180mcu_as_sc_mcu7t3v3__inv_2_364/VNW VSUBS
+ gf180mcu_as_sc_mcu7t3v3__inv_2
Xgf180mcu_as_sc_mcu7t3v3__inv_2_272 gf180mcu_as_sc_mcu7t3v3__inv_2_358/VDD gf180mcu_as_sc_mcu7t3v3__inv_2_359/VDD
+ gf180mcu_as_sc_mcu7t3v3__inv_2_358/Y gf180mcu_as_sc_mcu7t3v3__inv_2_358/Y gf180mcu_as_sc_mcu7t3v3__inv_2_358/VNW
+ VSUBS gf180mcu_as_sc_mcu7t3v3__inv_2
Xgf180mcu_as_sc_mcu7t3v3__inv_2_294 gf180mcu_as_sc_mcu7t3v3__inv_2_356/VDD gf180mcu_as_sc_mcu7t3v3__inv_2_357/VDD
+ gf180mcu_as_sc_mcu7t3v3__inv_2_358/Y gf180mcu_as_sc_mcu7t3v3__inv_2_358/Y gf180mcu_as_sc_mcu7t3v3__inv_2_356/VNW
+ VSUBS gf180mcu_as_sc_mcu7t3v3__inv_2
Xgf180mcu_as_sc_mcu7t3v3__inv_2_1568 gf180mcu_as_sc_mcu7t3v3__inv_2_1569/VDD VSS VSS
+ VSS gf180mcu_as_sc_mcu7t3v3__inv_2_1569/VNW VSUBS gf180mcu_as_sc_mcu7t3v3__inv_2
Xgf180mcu_as_sc_mcu7t3v3__inv_2_1579 gf180mcu_as_sc_mcu7t3v3__inv_2_1581/VDD VSS VSS
+ VSS gf180mcu_as_sc_mcu7t3v3__inv_2_1581/VNW VSUBS gf180mcu_as_sc_mcu7t3v3__inv_2
Xgf180mcu_as_sc_mcu7t3v3__inv_2_1557 gf180mcu_as_sc_mcu7t3v3__inv_2_1589/VSS VSS gf180mcu_as_sc_mcu7t3v3__inv_2_1557/Y
+ VSS gf180mcu_as_sc_mcu7t3v3__inv_2_1557/VNW VSUBS gf180mcu_as_sc_mcu7t3v3__inv_2
Xgf180mcu_as_sc_mcu7t3v3__inv_2_1513 gf180mcu_as_sc_mcu7t3v3__inv_2_1514/VDD VSS VSS
+ VSS gf180mcu_as_sc_mcu7t3v3__inv_2_1514/VNW VSUBS gf180mcu_as_sc_mcu7t3v3__inv_2
Xgf180mcu_as_sc_mcu7t3v3__inv_2_1535 gf180mcu_as_sc_mcu7t3v3__inv_2_1535/VDD gf180mcu_as_sc_mcu7t3v3__inv_2_1539/VDD
+ gf180mcu_as_sc_mcu7t3v3__inv_2_1535/Y VSS gf180mcu_as_sc_mcu7t3v3__inv_2_1535/VNW
+ VSUBS gf180mcu_as_sc_mcu7t3v3__inv_2
Xgf180mcu_as_sc_mcu7t3v3__inv_2_1546 VSS gf180mcu_as_sc_mcu7t3v3__inv_2_1551/VDD gf180mcu_as_sc_mcu7t3v3__inv_2_1546/Y
+ VSS gf180mcu_as_sc_mcu7t3v3__inv_2_1547/VNW VSUBS gf180mcu_as_sc_mcu7t3v3__inv_2
Xgf180mcu_as_sc_mcu7t3v3__inv_2_1524 gf180mcu_as_sc_mcu7t3v3__inv_2_1524/VDD VSS gf180mcu_as_sc_mcu7t3v3__inv_2_1524/Y
+ VSS gf180mcu_as_sc_mcu7t3v3__inv_2_1524/VNW VSUBS gf180mcu_as_sc_mcu7t3v3__inv_2
Xgf180mcu_as_sc_mcu7t3v3__inv_2_1502 gf180mcu_as_sc_mcu7t3v3__inv_2_1502/VDD gf180mcu_as_sc_mcu7t3v3__inv_2_1502/VSS
+ gf180mcu_as_sc_mcu7t3v3__inv_2_1502/Y VSS gf180mcu_as_sc_mcu7t3v3__inv_2_1502/VNW
+ VSUBS gf180mcu_as_sc_mcu7t3v3__inv_2
Xgf180mcu_as_sc_mcu7t3v3__nand4_2_318 VSS gf180mcu_as_sc_mcu7t3v3__inv_2_1064/VDD
+ VSS VSS VSS VSS VSS gf180mcu_as_sc_mcu7t3v3__inv_2_1060/VNW VSUBS gf180mcu_as_sc_mcu7t3v3__nand4_2
Xgf180mcu_as_sc_mcu7t3v3__nand4_2_329 VSS gf180mcu_as_sc_mcu7t3v3__inv_2_1107/VDD
+ VSS VSS VSS VSS VSS gf180mcu_as_sc_mcu7t3v3__inv_2_1104/VNW VSUBS gf180mcu_as_sc_mcu7t3v3__nand4_2
Xgf180mcu_as_sc_mcu7t3v3__nand2_2_1 gf180mcu_as_sc_mcu7t3v3__nand3_2_5/VDD gf180mcu_as_sc_mcu7t3v3__nor2_2_6/VSS
+ VSS VSS VSS gf180mcu_as_sc_mcu7t3v3__nand3_2_5/VNW VSUBS gf180mcu_as_sc_mcu7t3v3__nand2_2
Xgf180mcu_as_sc_mcu7t3v3__nand4_2_307 gf180mcu_as_sc_mcu7t3v3__inv_2_1046/VDD VSS
+ VSS VSS VSS VSS VSS gf180mcu_as_sc_mcu7t3v3__inv_2_1046/VNW VSUBS gf180mcu_as_sc_mcu7t3v3__nand4_2
Xu_t029_028 u_t029_028/c0_w0_bl u_t029_028/c0_w0_br u_t029_028/c0_w1_bl u_t029_028/c0_w1_br
+ u_t029_028/c0_r0_rbl u_t029_028/c0_r1_rbl u_t029_028/c1_w0_bl u_t029_028/c1_w0_br
+ u_t029_028/c1_w1_bl u_t029_028/c1_w1_br u_t029_028/c1_r0_rbl u_t029_028/c1_r1_rbl
+ u_t029_028/c2_w0_bl u_t029_028/c2_w0_br u_t029_028/c2_w1_bl u_t029_028/c2_w1_br
+ u_t029_028/c2_r0_rbl u_t029_028/c2_r1_rbl u_t029_028/c3_w0_bl u_t029_028/c3_w0_br
+ u_t029_028/c3_w1_bl u_t029_028/c3_w1_br u_t029_028/c3_r0_rbl u_t029_028/c3_r1_rbl
+ u_t029_028/r0_w0_wl u_t029_028/r0_w1_wl u_t029_028/r0_r0_rwl u_t029_028/r0_r1_rwl
+ u_t029_028/r1_w0_wl u_t029_028/r1_w1_wl u_t029_028/r1_r0_rwl u_t029_028/r1_r1_rwl
+ u_t029_028/r2_w0_wl u_t029_028/r2_w1_wl u_t029_028/r2_r0_rwl u_t029_028/r2_r1_rwl
+ u_t029_028/r3_w0_wl u_t029_028/r3_w1_wl u_t029_028/r3_r0_rwl u_t029_028/r3_r1_rwl
+ u_t029_028/VDD u_t029_031/VSS VSUBS detronyx_12t_2w2r_rc4_4x4_routed_5layer_direct
Xu_t029_017 u_t029_017/c0_w0_bl u_t029_017/c0_w0_br u_t029_017/c0_w1_bl u_t029_017/c0_w1_br
+ u_t029_017/c0_r0_rbl u_t029_017/c0_r1_rbl u_t029_017/c1_w0_bl u_t029_017/c1_w0_br
+ u_t029_017/c1_w1_bl u_t029_017/c1_w1_br u_t029_017/c1_r0_rbl u_t029_017/c1_r1_rbl
+ u_t029_017/c2_w0_bl u_t029_017/c2_w0_br u_t029_017/c2_w1_bl u_t029_017/c2_w1_br
+ u_t029_017/c2_r0_rbl u_t029_017/c2_r1_rbl u_t029_017/c3_w0_bl u_t029_017/c3_w0_br
+ u_t029_017/c3_w1_bl u_t029_017/c3_w1_br u_t029_017/c3_r0_rbl u_t029_017/c3_r1_rbl
+ u_t029_017/r0_w0_wl u_t029_017/r0_w1_wl u_t029_017/r0_r0_rwl u_t029_017/r0_r1_rwl
+ u_t029_017/r1_w0_wl u_t029_017/r1_w1_wl u_t029_017/r1_r0_rwl u_t029_017/r1_r1_rwl
+ u_t029_017/r2_w0_wl u_t029_017/r2_w1_wl u_t029_017/r2_r0_rwl u_t029_017/r2_r1_rwl
+ u_t029_017/r3_w0_wl u_t029_017/r3_w1_wl u_t029_017/r3_r0_rwl u_t029_017/r3_r1_rwl
+ VSS u_t029_031/VSS VSUBS detronyx_12t_2w2r_rc4_4x4_routed_5layer_direct
Xu_t029_006 u_t029_006/c0_w0_bl u_t029_006/c0_w0_br u_t029_006/c0_w1_bl u_t029_006/c0_w1_br
+ u_t029_006/c0_r0_rbl u_t029_006/c0_r1_rbl u_t029_006/c1_w0_bl u_t029_006/c1_w0_br
+ u_t029_006/c1_w1_bl u_t029_006/c1_w1_br u_t029_006/c1_r0_rbl u_t029_006/c1_r1_rbl
+ u_t029_006/c2_w0_bl u_t029_006/c2_w0_br u_t029_006/c2_w1_bl u_t029_006/c2_w1_br
+ u_t029_006/c2_r0_rbl u_t029_006/c2_r1_rbl u_t029_006/c3_w0_bl u_t029_006/c3_w0_br
+ u_t029_006/c3_w1_bl u_t029_006/c3_w1_br u_t029_006/c3_r0_rbl u_t029_006/c3_r1_rbl
+ u_t029_006/r0_w0_wl u_t029_006/r0_w1_wl u_t029_006/r0_r0_rwl u_t029_006/r0_r1_rwl
+ u_t029_006/r1_w0_wl u_t029_006/r1_w1_wl u_t029_006/r1_r0_rwl u_t029_006/r1_r1_rwl
+ u_t029_006/r2_w0_wl u_t029_006/r2_w1_wl u_t029_006/r2_r0_rwl u_t029_006/r2_r1_rwl
+ u_t029_006/r3_w0_wl u_t029_006/r3_w1_wl u_t029_006/r3_r0_rwl u_t029_006/r3_r1_rwl
+ u_t029_006/VDD u_t029_031/VSS VSUBS detronyx_12t_2w2r_rc4_4x4_routed_5layer_direct
Xgf180mcu_as_sc_mcu7t3v3__inv_2_1310 VSS gf180mcu_as_sc_mcu7t3v3__inv_2_1375/VDD VSS
+ gf180mcu_as_sc_mcu7t3v3__inv_2_1379/Y gf180mcu_as_sc_mcu7t3v3__inv_2_1374/VNW VSUBS
+ gf180mcu_as_sc_mcu7t3v3__inv_2
Xgf180mcu_as_sc_mcu7t3v3__inv_2_1354 gf180mcu_as_sc_mcu7t3v3__inv_2_1383/VDD gf180mcu_as_sc_mcu7t3v3__inv_2_1384/VDD
+ gf180mcu_as_sc_mcu7t3v3__inv_2_1354/Y gf180mcu_as_sc_mcu7t3v3__inv_2_1384/Y gf180mcu_as_sc_mcu7t3v3__inv_2_1383/VNW
+ VSUBS gf180mcu_as_sc_mcu7t3v3__inv_2
Xgf180mcu_as_sc_mcu7t3v3__inv_2_1332 gf180mcu_as_sc_mcu7t3v3__inv_2_1387/VDD VSS gf180mcu_as_sc_mcu7t3v3__inv_2_1332/Y
+ gf180mcu_as_sc_mcu7t3v3__inv_2_1387/Y gf180mcu_as_sc_mcu7t3v3__inv_2_1387/VNW VSUBS
+ gf180mcu_as_sc_mcu7t3v3__inv_2
Xgf180mcu_as_sc_mcu7t3v3__inv_2_1387 gf180mcu_as_sc_mcu7t3v3__inv_2_1387/VDD VSS gf180mcu_as_sc_mcu7t3v3__inv_2_1387/Y
+ VSS gf180mcu_as_sc_mcu7t3v3__inv_2_1387/VNW VSUBS gf180mcu_as_sc_mcu7t3v3__inv_2
Xgf180mcu_as_sc_mcu7t3v3__inv_2_1343 gf180mcu_as_sc_mcu7t3v3__inv_2_1391/VDD VSS VSS
+ gf180mcu_as_sc_mcu7t3v3__inv_2_1398/Y gf180mcu_as_sc_mcu7t3v3__inv_2_1391/VNW VSUBS
+ gf180mcu_as_sc_mcu7t3v3__inv_2
Xgf180mcu_as_sc_mcu7t3v3__inv_2_1365 VSS gf180mcu_as_sc_mcu7t3v3__inv_2_1691/VDD gf180mcu_as_sc_mcu7t3v3__inv_2_1691/Y
+ VSS gf180mcu_as_sc_mcu7t3v3__inv_2_1365/VNW VSUBS gf180mcu_as_sc_mcu7t3v3__inv_2
Xgf180mcu_as_sc_mcu7t3v3__inv_2_1376 gf180mcu_as_sc_mcu7t3v3__inv_2_1376/VDD VSS gf180mcu_as_sc_mcu7t3v3__inv_2_1379/Y
+ VSS gf180mcu_as_sc_mcu7t3v3__inv_2_1376/VNW VSUBS gf180mcu_as_sc_mcu7t3v3__inv_2
Xgf180mcu_as_sc_mcu7t3v3__inv_2_1321 VSS VSS gf180mcu_as_sc_mcu7t3v3__inv_2_1379/Y
+ gf180mcu_as_sc_mcu7t3v3__inv_2_1379/Y gf180mcu_as_sc_mcu7t3v3__inv_2_1370/VNW VSUBS
+ gf180mcu_as_sc_mcu7t3v3__inv_2
Xgf180mcu_as_sc_mcu7t3v3__inv_2_1398 VSS gf180mcu_as_sc_mcu7t3v3__inv_2_1398/VSS gf180mcu_as_sc_mcu7t3v3__inv_2_1398/Y
+ VSS gf180mcu_as_sc_mcu7t3v3__inv_2_1398/VNW VSUBS gf180mcu_as_sc_mcu7t3v3__inv_2
Xgf180mcu_as_sc_mcu7t3v3__inv_2_849 gf180mcu_as_sc_mcu7t3v3__inv_2_849/VDD gf180mcu_as_sc_mcu7t3v3__inv_2_849/VSS
+ gf180mcu_as_sc_mcu7t3v3__inv_2_849/Y VSS gf180mcu_as_sc_mcu7t3v3__inv_2_849/VNW
+ VSUBS gf180mcu_as_sc_mcu7t3v3__inv_2
Xgf180mcu_as_sc_mcu7t3v3__inv_2_805 VSS VSS VSS VSS gf180mcu_as_sc_mcu7t3v3__inv_2_813/VNW
+ VSUBS gf180mcu_as_sc_mcu7t3v3__inv_2
Xgf180mcu_as_sc_mcu7t3v3__inv_2_816 VSS VSS VSS VSS gf180mcu_as_sc_mcu7t3v3__inv_2_816/VNW
+ VSUBS gf180mcu_as_sc_mcu7t3v3__inv_2
Xgf180mcu_as_sc_mcu7t3v3__inv_2_838 VSS VSS gf180mcu_as_sc_mcu7t3v3__inv_2_838/Y VSS
+ gf180mcu_as_sc_mcu7t3v3__inv_2_840/VNW VSUBS gf180mcu_as_sc_mcu7t3v3__inv_2
Xgf180mcu_as_sc_mcu7t3v3__inv_2_827 VSS VSS VSS VSS gf180mcu_as_sc_mcu7t3v3__inv_2_828/VNW
+ VSUBS gf180mcu_as_sc_mcu7t3v3__inv_2
Xgf180mcu_as_sc_mcu7t3v3__nand4_2_126 VSS VSS VSS VSS VSS VSS VSS gf180mcu_as_sc_mcu7t3v3__inv_2_437/VNW
+ VSUBS gf180mcu_as_sc_mcu7t3v3__nand4_2
Xgf180mcu_as_sc_mcu7t3v3__nand4_2_104 VSS gf180mcu_as_sc_mcu7t3v3__inv_2_341/VDD VSS
+ VSS VSS VSS VSS gf180mcu_as_sc_mcu7t3v3__inv_2_340/VNW VSUBS gf180mcu_as_sc_mcu7t3v3__nand4_2
Xgf180mcu_as_sc_mcu7t3v3__nand4_2_115 gf180mcu_as_sc_mcu7t3v3__inv_2_331/VDD gf180mcu_as_sc_mcu7t3v3__inv_2_332/VDD
+ VSS VSS VSS VSS VSS gf180mcu_as_sc_mcu7t3v3__inv_2_331/VNW VSUBS gf180mcu_as_sc_mcu7t3v3__nand4_2
Xu_t026_009 u_t026_009/c0_w0_bl u_t026_009/c0_w0_br u_t026_009/c0_w1_bl u_t026_009/c0_w1_br
+ u_t026_009/c0_r0_rbl u_t026_009/c0_r1_rbl u_t026_009/c1_w0_bl u_t026_009/c1_w0_br
+ u_t026_009/c1_w1_bl u_t026_009/c1_w1_br u_t026_009/c1_r0_rbl u_t026_009/c1_r1_rbl
+ u_t026_009/c2_w0_bl u_t026_009/c2_w0_br u_t026_009/c2_w1_bl u_t026_009/c2_w1_br
+ u_t026_009/c2_r0_rbl u_t026_009/c2_r1_rbl u_t026_009/c3_w0_bl u_t026_009/c3_w0_br
+ u_t026_009/c3_w1_bl u_t026_009/c3_w1_br u_t026_009/c3_r0_rbl u_t026_009/c3_r1_rbl
+ u_t026_009/r0_w0_wl u_t026_009/r0_w1_wl u_t026_009/r0_r0_rwl u_t026_009/r0_r1_rwl
+ u_t026_009/r1_w0_wl u_t026_009/r1_w1_wl u_t026_009/r1_r0_rwl u_t026_009/r1_r1_rwl
+ u_t026_009/r2_w0_wl u_t026_009/r2_w1_wl u_t026_009/r2_r0_rwl u_t026_009/r2_r1_rwl
+ u_t026_009/r3_w0_wl u_t026_009/r3_w1_wl u_t026_009/r3_r0_rwl u_t026_009/r3_r1_rwl
+ VSS u_t026_031/VSS VSUBS detronyx_12t_2w2r_rc4_4x4_routed_5layer_direct
Xgf180mcu_as_sc_mcu7t3v3__nand4_2_43 gf180mcu_as_sc_mcu7t3v3__inv_2_146/VDD VSS VSS
+ VSS VSS VSS gf180mcu_as_sc_mcu7t3v3__nand4_2_43/Y gf180mcu_as_sc_mcu7t3v3__inv_2_146/VNW
+ VSUBS gf180mcu_as_sc_mcu7t3v3__nand4_2
Xgf180mcu_as_sc_mcu7t3v3__nand4_2_32 gf180mcu_as_sc_mcu7t3v3__inv_2_99/VSS gf180mcu_as_sc_mcu7t3v3__inv_2_96/VDD
+ VSS VSS VSS VSS gf180mcu_as_sc_mcu7t3v3__nand4_2_32/Y gf180mcu_as_sc_mcu7t3v3__inv_2_103/VNW
+ VSUBS gf180mcu_as_sc_mcu7t3v3__nand4_2
Xgf180mcu_as_sc_mcu7t3v3__nand4_2_159 gf180mcu_as_sc_mcu7t3v3__inv_2_585/VDD gf180mcu_as_sc_mcu7t3v3__inv_2_585/VSS
+ VSS VSS VSS VSS VSS gf180mcu_as_sc_mcu7t3v3__inv_2_585/VNW VSUBS gf180mcu_as_sc_mcu7t3v3__nand4_2
Xgf180mcu_as_sc_mcu7t3v3__nand4_2_21 gf180mcu_as_sc_mcu7t3v3__inv_2_77/VSS VSS VSS
+ VSS VSS VSS VSS gf180mcu_as_sc_mcu7t3v3__inv_2_59/VNW VSUBS gf180mcu_as_sc_mcu7t3v3__nand4_2
Xgf180mcu_as_sc_mcu7t3v3__nand4_2_137 VSS VSS VSS VSS VSS VSS gf180mcu_as_sc_mcu7t3v3__nand4_2_137/Y
+ gf180mcu_as_sc_mcu7t3v3__inv_2_534/VNW VSUBS gf180mcu_as_sc_mcu7t3v3__nand4_2
Xgf180mcu_as_sc_mcu7t3v3__nand4_2_10 gf180mcu_as_sc_mcu7t3v3__inv_2_73/VDD gf180mcu_as_sc_mcu7t3v3__inv_2_73/VDD
+ VSS VSS VSS VSS VSS gf180mcu_as_sc_mcu7t3v3__inv_2_72/VNW VSUBS gf180mcu_as_sc_mcu7t3v3__nand4_2
Xgf180mcu_as_sc_mcu7t3v3__nand4_2_148 VSS VSS VSS VSS VSS VSS gf180mcu_as_sc_mcu7t3v3__nand4_2_148/Y
+ gf180mcu_as_sc_mcu7t3v3__inv_2_511/VNW VSUBS gf180mcu_as_sc_mcu7t3v3__nand4_2
Xgf180mcu_as_sc_mcu7t3v3__nand4_2_65 gf180mcu_as_sc_mcu7t3v3__inv_2_206/VDD gf180mcu_as_sc_mcu7t3v3__inv_2_371/VDD
+ VSS VSS VSS VSS gf180mcu_as_sc_mcu7t3v3__nand4_2_65/Y gf180mcu_as_sc_mcu7t3v3__inv_2_206/VNW
+ VSUBS gf180mcu_as_sc_mcu7t3v3__nand4_2
Xgf180mcu_as_sc_mcu7t3v3__nand4_2_76 VSS VSS VSS VSS VSS VSS VSS gf180mcu_as_sc_mcu7t3v3__inv_2_252/VNW
+ VSUBS gf180mcu_as_sc_mcu7t3v3__nand4_2
Xgf180mcu_as_sc_mcu7t3v3__nand4_2_54 VSS VSS VSS VSS VSS VSS VSS gf180mcu_as_sc_mcu7t3v3__inv_2_253/VNW
+ VSUBS gf180mcu_as_sc_mcu7t3v3__nand4_2
Xgf180mcu_as_sc_mcu7t3v3__nand4_2_98 VSS gf180mcu_as_sc_mcu7t3v3__inv_2_353/VDD VSS
+ VSS VSS VSS VSS gf180mcu_as_sc_mcu7t3v3__inv_2_352/VNW VSUBS gf180mcu_as_sc_mcu7t3v3__nand4_2
Xgf180mcu_as_sc_mcu7t3v3__nand4_2_87 gf180mcu_as_sc_mcu7t3v3__inv_2_355/VDD gf180mcu_as_sc_mcu7t3v3__inv_2_356/VDD
+ VSS VSS VSS VSS VSS gf180mcu_as_sc_mcu7t3v3__inv_2_355/VNW VSUBS gf180mcu_as_sc_mcu7t3v3__nand4_2
Xu_t025_031 u_t025_031/c0_w0_bl u_t025_031/c0_w0_br u_t025_031/c0_w1_bl u_t025_031/c0_w1_br
+ u_t025_031/c0_r0_rbl u_t025_031/c0_r1_rbl u_t025_031/c1_w0_bl u_t025_031/c1_w0_br
+ u_t025_031/c1_w1_bl u_t025_031/c1_w1_br u_t025_031/c1_r0_rbl u_t025_031/c1_r1_rbl
+ u_t025_031/c2_w0_bl u_t025_031/c2_w0_br u_t025_031/c2_w1_bl u_t025_031/c2_w1_br
+ u_t025_031/c2_r0_rbl u_t025_031/c2_r1_rbl u_t025_031/c3_w0_bl u_t025_031/c3_w0_br
+ u_t025_031/c3_w1_bl u_t025_031/c3_w1_br u_t025_031/c3_r0_rbl u_t025_031/c3_r1_rbl
+ u_t025_031/r0_w0_wl u_t025_031/r0_w1_wl u_t025_031/r0_r0_rwl u_t025_031/r0_r1_rwl
+ u_t025_031/r1_w0_wl u_t025_031/r1_w1_wl u_t025_031/r1_r0_rwl u_t025_031/r1_r1_rwl
+ u_t025_031/r2_w0_wl u_t025_031/r2_w1_wl u_t025_031/r2_r0_rwl u_t025_031/r2_r1_rwl
+ u_t025_031/r3_w0_wl u_t025_031/r3_w1_wl u_t025_031/r3_r0_rwl u_t025_031/r3_r1_rwl
+ VSS u_t025_031/VSS VSUBS detronyx_12t_2w2r_rc4_4x4_routed_5layer_direct
Xu_t025_020 u_t025_020/c0_w0_bl u_t025_020/c0_w0_br u_t025_020/c0_w1_bl u_t025_020/c0_w1_br
+ u_t025_020/c0_r0_rbl u_t025_020/c0_r1_rbl u_t025_020/c1_w0_bl u_t025_020/c1_w0_br
+ u_t025_020/c1_w1_bl u_t025_020/c1_w1_br u_t025_020/c1_r0_rbl u_t025_020/c1_r1_rbl
+ u_t025_020/c2_w0_bl u_t025_020/c2_w0_br u_t025_020/c2_w1_bl u_t025_020/c2_w1_br
+ u_t025_020/c2_r0_rbl u_t025_020/c2_r1_rbl u_t025_020/c3_w0_bl u_t025_020/c3_w0_br
+ u_t025_020/c3_w1_bl u_t025_020/c3_w1_br u_t025_020/c3_r0_rbl u_t025_020/c3_r1_rbl
+ u_t025_020/r0_w0_wl u_t025_020/r0_w1_wl u_t025_020/r0_r0_rwl u_t025_020/r0_r1_rwl
+ u_t025_020/r1_w0_wl u_t025_020/r1_w1_wl u_t025_020/r1_r0_rwl u_t025_020/r1_r1_rwl
+ u_t025_020/r2_w0_wl u_t025_020/r2_w1_wl u_t025_020/r2_r0_rwl u_t025_020/r2_r1_rwl
+ u_t025_020/r3_w0_wl u_t025_020/r3_w1_wl u_t025_020/r3_r0_rwl u_t025_020/r3_r1_rwl
+ u_t025_020/VDD u_t025_031/VSS VSUBS detronyx_12t_2w2r_rc4_4x4_routed_5layer_direct
Xu_t017_009 u_t017_009/c0_w0_bl u_t017_009/c0_w0_br u_t017_009/c0_w1_bl u_t017_009/c0_w1_br
+ u_t017_009/c0_r0_rbl u_t017_009/c0_r1_rbl u_t017_009/c1_w0_bl u_t017_009/c1_w0_br
+ u_t017_009/c1_w1_bl u_t017_009/c1_w1_br u_t017_009/c1_r0_rbl u_t017_009/c1_r1_rbl
+ u_t017_009/c2_w0_bl u_t017_009/c2_w0_br u_t017_009/c2_w1_bl u_t017_009/c2_w1_br
+ u_t017_009/c2_r0_rbl u_t017_009/c2_r1_rbl u_t017_009/c3_w0_bl u_t017_009/c3_w0_br
+ u_t017_009/c3_w1_bl u_t017_009/c3_w1_br u_t017_009/c3_r0_rbl u_t017_009/c3_r1_rbl
+ u_t017_009/r0_w0_wl u_t017_009/r0_w1_wl u_t017_009/r0_r0_rwl u_t017_009/r0_r1_rwl
+ u_t017_009/r1_w0_wl u_t017_009/r1_w1_wl u_t017_009/r1_r0_rwl u_t017_009/r1_r1_rwl
+ u_t017_009/r2_w0_wl u_t017_009/r2_w1_wl u_t017_009/r2_r0_rwl u_t017_009/r2_r1_rwl
+ u_t017_009/r3_w0_wl u_t017_009/r3_w1_wl u_t017_009/r3_r0_rwl u_t017_009/r3_r1_rwl
+ VSS u_t017_031/VSS VSUBS detronyx_12t_2w2r_rc4_4x4_routed_5layer_direct
Xgf180mcu_as_sc_mcu7t3v3__inv_2_1140 gf180mcu_as_sc_mcu7t3v3__inv_2_1141/VDD gf180mcu_as_sc_mcu7t3v3__inv_2_1143/VDD
+ gf180mcu_as_sc_mcu7t3v3__inv_2_1140/Y gf180mcu_as_sc_mcu7t3v3__inv_2_1141/Y gf180mcu_as_sc_mcu7t3v3__inv_2_1141/VNW
+ VSUBS gf180mcu_as_sc_mcu7t3v3__inv_2
Xgf180mcu_as_sc_mcu7t3v3__inv_2_1151 VSS VSS gf180mcu_as_sc_mcu7t3v3__inv_2_1151/Y
+ VSS gf180mcu_as_sc_mcu7t3v3__inv_2_1151/VNW VSUBS gf180mcu_as_sc_mcu7t3v3__inv_2
Xgf180mcu_as_sc_mcu7t3v3__inv_2_1162 VSS VSS VSS VSS gf180mcu_as_sc_mcu7t3v3__inv_2_1162/VNW
+ VSUBS gf180mcu_as_sc_mcu7t3v3__inv_2
Xgf180mcu_as_sc_mcu7t3v3__inv_2_1195 VSS VSS VSS VSS gf180mcu_as_sc_mcu7t3v3__inv_2_1195/VNW
+ VSUBS gf180mcu_as_sc_mcu7t3v3__inv_2
Xgf180mcu_as_sc_mcu7t3v3__inv_2_1173 VSS VSS VSS VSS gf180mcu_as_sc_mcu7t3v3__inv_2_1178/VNW
+ VSUBS gf180mcu_as_sc_mcu7t3v3__inv_2
Xgf180mcu_as_sc_mcu7t3v3__inv_2_1184 VSS VSS VSS VSS gf180mcu_as_sc_mcu7t3v3__inv_2_1186/VNW
+ VSUBS gf180mcu_as_sc_mcu7t3v3__inv_2
Xu_t008_009 u_t008_009/c0_w0_bl u_t008_009/c0_w0_br u_t008_009/c0_w1_bl u_t008_009/c0_w1_br
+ u_t008_009/c0_r0_rbl u_t008_009/c0_r1_rbl u_t008_009/c1_w0_bl u_t008_009/c1_w0_br
+ u_t008_009/c1_w1_bl u_t008_009/c1_w1_br u_t008_009/c1_r0_rbl u_t008_009/c1_r1_rbl
+ u_t008_009/c2_w0_bl u_t008_009/c2_w0_br u_t008_009/c2_w1_bl u_t008_009/c2_w1_br
+ u_t008_009/c2_r0_rbl u_t008_009/c2_r1_rbl u_t008_009/c3_w0_bl u_t008_009/c3_w0_br
+ u_t008_009/c3_w1_bl u_t008_009/c3_w1_br u_t008_009/c3_r0_rbl u_t008_009/c3_r1_rbl
+ u_t008_009/r0_w0_wl u_t008_009/r0_w1_wl u_t008_009/r0_r0_rwl u_t008_009/r0_r1_rwl
+ u_t008_009/r1_w0_wl u_t008_009/r1_w1_wl u_t008_009/r1_r0_rwl u_t008_009/r1_r1_rwl
+ u_t008_009/r2_w0_wl u_t008_009/r2_w1_wl u_t008_009/r2_r0_rwl u_t008_009/r2_r1_rwl
+ u_t008_009/r3_w0_wl u_t008_009/r3_w1_wl u_t008_009/r3_r0_rwl u_t008_009/r3_r1_rwl
+ VSS u_t008_031/VSS VSUBS detronyx_12t_2w2r_rc4_4x4_routed_5layer_direct
Xgf180mcu_as_sc_mcu7t3v3__inv_2_602 gf180mcu_as_sc_mcu7t3v3__inv_2_849/VSS gf180mcu_as_sc_mcu7t3v3__inv_2_630/VDD
+ gf180mcu_as_sc_mcu7t3v3__inv_2_848/Y gf180mcu_as_sc_mcu7t3v3__inv_2_617/Y gf180mcu_as_sc_mcu7t3v3__inv_2_617/VNW
+ VSUBS gf180mcu_as_sc_mcu7t3v3__inv_2
Xu_t016_031 u_t016_031/c0_w0_bl u_t016_031/c0_w0_br u_t016_031/c0_w1_bl u_t016_031/c0_w1_br
+ u_t016_031/c0_r0_rbl u_t016_031/c0_r1_rbl u_t016_031/c1_w0_bl u_t016_031/c1_w0_br
+ u_t016_031/c1_w1_bl u_t016_031/c1_w1_br u_t016_031/c1_r0_rbl u_t016_031/c1_r1_rbl
+ u_t016_031/c2_w0_bl u_t016_031/c2_w0_br u_t016_031/c2_w1_bl u_t016_031/c2_w1_br
+ u_t016_031/c2_r0_rbl u_t016_031/c2_r1_rbl u_t016_031/c3_w0_bl u_t016_031/c3_w0_br
+ u_t016_031/c3_w1_bl u_t016_031/c3_w1_br u_t016_031/c3_r0_rbl u_t016_031/c3_r1_rbl
+ u_t016_031/r0_w0_wl u_t016_031/r0_w1_wl u_t016_031/r0_r0_rwl u_t016_031/r0_r1_rwl
+ u_t016_031/r1_w0_wl u_t016_031/r1_w1_wl u_t016_031/r1_r0_rwl u_t016_031/r1_r1_rwl
+ u_t016_031/r2_w0_wl u_t016_031/r2_w1_wl u_t016_031/r2_r0_rwl u_t016_031/r2_r1_rwl
+ u_t016_031/r3_w0_wl u_t016_031/r3_w1_wl u_t016_031/r3_r0_rwl u_t016_031/r3_r1_rwl
+ VSS u_t016_031/VSS VSUBS detronyx_12t_2w2r_rc4_4x4_routed_5layer_direct
Xu_t031_023 u_t031_023/c0_w0_bl u_t031_023/c0_w0_br u_t031_023/c0_w1_bl u_t031_023/c0_w1_br
+ u_t031_023/c0_r0_rbl u_t031_023/c0_r1_rbl u_t031_023/c1_w0_bl u_t031_023/c1_w0_br
+ u_t031_023/c1_w1_bl u_t031_023/c1_w1_br u_t031_023/c1_r0_rbl u_t031_023/c1_r1_rbl
+ u_t031_023/c2_w0_bl u_t031_023/c2_w0_br u_t031_023/c2_w1_bl u_t031_023/c2_w1_br
+ u_t031_023/c2_r0_rbl u_t031_023/c2_r1_rbl u_t031_023/c3_w0_bl u_t031_023/c3_w0_br
+ u_t031_023/c3_w1_bl u_t031_023/c3_w1_br u_t031_023/c3_r0_rbl u_t031_023/c3_r1_rbl
+ u_t031_023/r0_w0_wl u_t031_023/r0_w1_wl u_t031_023/r0_r0_rwl u_t031_023/r0_r1_rwl
+ u_t031_023/r1_w0_wl u_t031_023/r1_w1_wl u_t031_023/r1_r0_rwl u_t031_023/r1_r1_rwl
+ u_t031_023/r2_w0_wl u_t031_023/r2_w1_wl u_t031_023/r2_r0_rwl u_t031_023/r2_r1_rwl
+ u_t031_023/r3_w0_wl u_t031_023/r3_w1_wl u_t031_023/r3_r0_rwl u_t031_023/r3_r1_rwl
+ VSS u_t031_024/VSS VSUBS detronyx_12t_2w2r_rc4_4x4_routed_5layer_direct
Xu_t016_020 u_t016_020/c0_w0_bl u_t016_020/c0_w0_br u_t016_020/c0_w1_bl u_t016_020/c0_w1_br
+ u_t016_020/c0_r0_rbl u_t016_020/c0_r1_rbl u_t016_020/c1_w0_bl u_t016_020/c1_w0_br
+ u_t016_020/c1_w1_bl u_t016_020/c1_w1_br u_t016_020/c1_r0_rbl u_t016_020/c1_r1_rbl
+ u_t016_020/c2_w0_bl u_t016_020/c2_w0_br u_t016_020/c2_w1_bl u_t016_020/c2_w1_br
+ u_t016_020/c2_r0_rbl u_t016_020/c2_r1_rbl u_t016_020/c3_w0_bl u_t016_020/c3_w0_br
+ u_t016_020/c3_w1_bl u_t016_020/c3_w1_br u_t016_020/c3_r0_rbl u_t016_020/c3_r1_rbl
+ u_t016_020/r0_w0_wl u_t016_020/r0_w1_wl u_t016_020/r0_r0_rwl u_t016_020/r0_r1_rwl
+ u_t016_020/r1_w0_wl u_t016_020/r1_w1_wl u_t016_020/r1_r0_rwl u_t016_020/r1_r1_rwl
+ u_t016_020/r2_w0_wl u_t016_020/r2_w1_wl u_t016_020/r2_r0_rwl u_t016_020/r2_r1_rwl
+ u_t016_020/r3_w0_wl u_t016_020/r3_w1_wl u_t016_020/r3_r0_rwl u_t016_020/r3_r1_rwl
+ u_t016_020/VDD u_t016_020/VSS VSUBS detronyx_12t_2w2r_rc4_4x4_routed_5layer_direct
Xu_t031_012 u_t031_012/c0_w0_bl u_t031_012/c0_w0_br u_t031_012/c0_w1_bl u_t031_012/c0_w1_br
+ u_t031_012/c0_r0_rbl u_t031_012/c0_r1_rbl u_t031_012/c1_w0_bl u_t031_012/c1_w0_br
+ u_t031_012/c1_w1_bl u_t031_012/c1_w1_br u_t031_012/c1_r0_rbl u_t031_012/c1_r1_rbl
+ u_t031_012/c2_w0_bl u_t031_012/c2_w0_br u_t031_012/c2_w1_bl u_t031_012/c2_w1_br
+ u_t031_012/c2_r0_rbl u_t031_012/c2_r1_rbl u_t031_012/c3_w0_bl u_t031_012/c3_w0_br
+ u_t031_012/c3_w1_bl u_t031_012/c3_w1_br u_t031_012/c3_r0_rbl u_t031_012/c3_r1_rbl
+ u_t031_012/r0_w0_wl u_t031_012/r0_w1_wl u_t031_012/r0_r0_rwl u_t031_012/r0_r1_rwl
+ u_t031_012/r1_w0_wl u_t031_012/r1_w1_wl u_t031_012/r1_r0_rwl u_t031_012/r1_r1_rwl
+ u_t031_012/r2_w0_wl u_t031_012/r2_w1_wl u_t031_012/r2_r0_rwl u_t031_012/r2_r1_rwl
+ u_t031_012/r3_w0_wl u_t031_012/r3_w1_wl u_t031_012/r3_r0_rwl u_t031_012/r3_r1_rwl
+ u_t031_012/VDD u_t031_012/VSS VSUBS detronyx_12t_2w2r_rc4_4x4_routed_5layer_direct
Xu_t031_001 u_t031_001/c0_w0_bl u_t031_001/c0_w0_br u_t031_001/c0_w1_bl u_t031_001/c0_w1_br
+ u_t031_001/c0_r0_rbl u_t031_001/c0_r1_rbl u_t031_001/c1_w0_bl u_t031_001/c1_w0_br
+ u_t031_001/c1_w1_bl u_t031_001/c1_w1_br u_t031_001/c1_r0_rbl u_t031_001/c1_r1_rbl
+ u_t031_001/c2_w0_bl u_t031_001/c2_w0_br u_t031_001/c2_w1_bl u_t031_001/c2_w1_br
+ u_t031_001/c2_r0_rbl u_t031_001/c2_r1_rbl u_t031_001/c3_w0_bl u_t031_001/c3_w0_br
+ u_t031_001/c3_w1_bl u_t031_001/c3_w1_br u_t031_001/c3_r0_rbl u_t031_001/c3_r1_rbl
+ u_t031_001/r0_w0_wl u_t031_001/r0_w1_wl u_t031_001/r0_r0_rwl u_t031_001/r0_r1_rwl
+ u_t031_001/r1_w0_wl u_t031_001/r1_w1_wl u_t031_001/r1_r0_rwl u_t031_001/r1_r1_rwl
+ u_t031_001/r2_w0_wl u_t031_001/r2_w1_wl u_t031_001/r2_r0_rwl u_t031_001/r2_r1_rwl
+ u_t031_001/r3_w0_wl u_t031_001/r3_w1_wl u_t031_001/r3_r0_rwl u_t031_001/r3_r1_rwl
+ VSS u_t031_002/VSS VSUBS detronyx_12t_2w2r_rc4_4x4_routed_5layer_direct
Xgf180mcu_as_sc_mcu7t3v3__inv_2_613 VSS gf180mcu_as_sc_mcu7t3v3__inv_2_626/VDD gf180mcu_as_sc_mcu7t3v3__inv_2_613/Y
+ VSS gf180mcu_as_sc_mcu7t3v3__inv_2_613/VNW VSUBS gf180mcu_as_sc_mcu7t3v3__inv_2
Xgf180mcu_as_sc_mcu7t3v3__inv_2_635 gf180mcu_as_sc_mcu7t3v3__inv_2_636/VSS gf180mcu_as_sc_mcu7t3v3__inv_2_636/VSS
+ gf180mcu_as_sc_mcu7t3v3__inv_2_635/Y gf180mcu_as_sc_mcu7t3v3__inv_2_636/Y gf180mcu_as_sc_mcu7t3v3__inv_2_636/VNW
+ VSUBS gf180mcu_as_sc_mcu7t3v3__inv_2
Xgf180mcu_as_sc_mcu7t3v3__inv_2_624 gf180mcu_as_sc_mcu7t3v3__inv_2_629/VDD gf180mcu_as_sc_mcu7t3v3__inv_2_629/VDD
+ gf180mcu_as_sc_mcu7t3v3__inv_2_631/A gf180mcu_as_sc_mcu7t3v3__inv_2_625/Y gf180mcu_as_sc_mcu7t3v3__inv_2_625/VNW
+ VSUBS gf180mcu_as_sc_mcu7t3v3__inv_2
Xgf180mcu_as_sc_mcu7t3v3__inv_2_679 gf180mcu_as_sc_mcu7t3v3__inv_2_679/VDD gf180mcu_as_sc_mcu7t3v3__inv_2_849/VDD
+ gf180mcu_as_sc_mcu7t3v3__inv_2_679/Y VSS gf180mcu_as_sc_mcu7t3v3__inv_2_679/VNW
+ VSUBS gf180mcu_as_sc_mcu7t3v3__inv_2
Xgf180mcu_as_sc_mcu7t3v3__inv_2_668 VSS VSS gf180mcu_as_sc_mcu7t3v3__inv_2_668/Y gf180mcu_as_sc_mcu7t3v3__inv_2_684/A
+ gf180mcu_as_sc_mcu7t3v3__inv_2_676/VNW VSUBS gf180mcu_as_sc_mcu7t3v3__inv_2
Xgf180mcu_as_sc_mcu7t3v3__inv_2_657 gf180mcu_as_sc_mcu7t3v3__inv_2_659/VDD gf180mcu_as_sc_mcu7t3v3__inv_2_663/VDD
+ gf180mcu_as_sc_mcu7t3v3__inv_2_657/Y gf180mcu_as_sc_mcu7t3v3__inv_2_661/A gf180mcu_as_sc_mcu7t3v3__inv_2_659/VNW
+ VSUBS gf180mcu_as_sc_mcu7t3v3__inv_2
Xgf180mcu_as_sc_mcu7t3v3__inv_2_646 gf180mcu_as_sc_mcu7t3v3__inv_2_647/VDD gf180mcu_as_sc_mcu7t3v3__inv_2_651/VDD
+ gf180mcu_as_sc_mcu7t3v3__inv_2_646/Y gf180mcu_as_sc_mcu7t3v3__inv_2_647/Y gf180mcu_as_sc_mcu7t3v3__inv_2_647/VNW
+ VSUBS gf180mcu_as_sc_mcu7t3v3__inv_2
Xu_t007_031 u_t007_031/c0_w0_bl u_t007_031/c0_w0_br u_t007_031/c0_w1_bl u_t007_031/c0_w1_br
+ u_t007_031/c0_r0_rbl u_t007_031/c0_r1_rbl u_t007_031/c1_w0_bl u_t007_031/c1_w0_br
+ u_t007_031/c1_w1_bl u_t007_031/c1_w1_br u_t007_031/c1_r0_rbl u_t007_031/c1_r1_rbl
+ u_t007_031/c2_w0_bl u_t007_031/c2_w0_br u_t007_031/c2_w1_bl u_t007_031/c2_w1_br
+ u_t007_031/c2_r0_rbl u_t007_031/c2_r1_rbl u_t007_031/c3_w0_bl u_t007_031/c3_w0_br
+ u_t007_031/c3_w1_bl u_t007_031/c3_w1_br u_t007_031/c3_r0_rbl u_t007_031/c3_r1_rbl
+ u_t007_031/r0_w0_wl u_t007_031/r0_w1_wl u_t007_031/r0_r0_rwl u_t007_031/r0_r1_rwl
+ u_t007_031/r1_w0_wl u_t007_031/r1_w1_wl u_t007_031/r1_r0_rwl u_t007_031/r1_r1_rwl
+ u_t007_031/r2_w0_wl u_t007_031/r2_w1_wl u_t007_031/r2_r0_rwl u_t007_031/r2_r1_rwl
+ u_t007_031/r3_w0_wl u_t007_031/r3_w1_wl u_t007_031/r3_r0_rwl u_t007_031/r3_r1_rwl
+ VSS u_t007_031/VSS VSUBS detronyx_12t_2w2r_rc4_4x4_routed_5layer_direct
Xu_t007_020 u_t007_020/c0_w0_bl u_t007_020/c0_w0_br u_t007_020/c0_w1_bl u_t007_020/c0_w1_br
+ u_t007_020/c0_r0_rbl u_t007_020/c0_r1_rbl u_t007_020/c1_w0_bl u_t007_020/c1_w0_br
+ u_t007_020/c1_w1_bl u_t007_020/c1_w1_br u_t007_020/c1_r0_rbl u_t007_020/c1_r1_rbl
+ u_t007_020/c2_w0_bl u_t007_020/c2_w0_br u_t007_020/c2_w1_bl u_t007_020/c2_w1_br
+ u_t007_020/c2_r0_rbl u_t007_020/c2_r1_rbl u_t007_020/c3_w0_bl u_t007_020/c3_w0_br
+ u_t007_020/c3_w1_bl u_t007_020/c3_w1_br u_t007_020/c3_r0_rbl u_t007_020/c3_r1_rbl
+ u_t007_020/r0_w0_wl u_t007_020/r0_w1_wl u_t007_020/r0_r0_rwl u_t007_020/r0_r1_rwl
+ u_t007_020/r1_w0_wl u_t007_020/r1_w1_wl u_t007_020/r1_r0_rwl u_t007_020/r1_r1_rwl
+ u_t007_020/r2_w0_wl u_t007_020/r2_w1_wl u_t007_020/r2_r0_rwl u_t007_020/r2_r1_rwl
+ u_t007_020/r3_w0_wl u_t007_020/r3_w1_wl u_t007_020/r3_r0_rwl u_t007_020/r3_r1_rwl
+ u_t008_020/VDD u_t007_020/VSS VSUBS detronyx_12t_2w2r_rc4_4x4_routed_5layer_direct
Xu_t022_001 u_t022_001/c0_w0_bl u_t022_001/c0_w0_br u_t022_001/c0_w1_bl u_t022_001/c0_w1_br
+ u_t022_001/c0_r0_rbl u_t022_001/c0_r1_rbl u_t022_001/c1_w0_bl u_t022_001/c1_w0_br
+ u_t022_001/c1_w1_bl u_t022_001/c1_w1_br u_t022_001/c1_r0_rbl u_t022_001/c1_r1_rbl
+ u_t022_001/c2_w0_bl u_t022_001/c2_w0_br u_t022_001/c2_w1_bl u_t022_001/c2_w1_br
+ u_t022_001/c2_r0_rbl u_t022_001/c2_r1_rbl u_t022_001/c3_w0_bl u_t022_001/c3_w0_br
+ u_t022_001/c3_w1_bl u_t022_001/c3_w1_br u_t022_001/c3_r0_rbl u_t022_001/c3_r1_rbl
+ u_t022_001/r0_w0_wl u_t022_001/r0_w1_wl u_t022_001/r0_r0_rwl u_t022_001/r0_r1_rwl
+ u_t022_001/r1_w0_wl u_t022_001/r1_w1_wl u_t022_001/r1_r0_rwl u_t022_001/r1_r1_rwl
+ u_t022_001/r2_w0_wl u_t022_001/r2_w1_wl u_t022_001/r2_r0_rwl u_t022_001/r2_r1_rwl
+ u_t022_001/r3_w0_wl u_t022_001/r3_w1_wl u_t022_001/r3_r0_rwl u_t022_001/r3_r1_rwl
+ VSS u_t022_031/VSS VSUBS detronyx_12t_2w2r_rc4_4x4_routed_5layer_direct
Xu_t022_023 u_t022_023/c0_w0_bl u_t022_023/c0_w0_br u_t022_023/c0_w1_bl u_t022_023/c0_w1_br
+ u_t022_023/c0_r0_rbl u_t022_023/c0_r1_rbl u_t022_023/c1_w0_bl u_t022_023/c1_w0_br
+ u_t022_023/c1_w1_bl u_t022_023/c1_w1_br u_t022_023/c1_r0_rbl u_t022_023/c1_r1_rbl
+ u_t022_023/c2_w0_bl u_t022_023/c2_w0_br u_t022_023/c2_w1_bl u_t022_023/c2_w1_br
+ u_t022_023/c2_r0_rbl u_t022_023/c2_r1_rbl u_t022_023/c3_w0_bl u_t022_023/c3_w0_br
+ u_t022_023/c3_w1_bl u_t022_023/c3_w1_br u_t022_023/c3_r0_rbl u_t022_023/c3_r1_rbl
+ u_t022_023/r0_w0_wl u_t022_023/r0_w1_wl u_t022_023/r0_r0_rwl u_t022_023/r0_r1_rwl
+ u_t022_023/r1_w0_wl u_t022_023/r1_w1_wl u_t022_023/r1_r0_rwl u_t022_023/r1_r1_rwl
+ u_t022_023/r2_w0_wl u_t022_023/r2_w1_wl u_t022_023/r2_r0_rwl u_t022_023/r2_r1_rwl
+ u_t022_023/r3_w0_wl u_t022_023/r3_w1_wl u_t022_023/r3_r0_rwl u_t022_023/r3_r1_rwl
+ VSS u_t022_031/VSS VSUBS detronyx_12t_2w2r_rc4_4x4_routed_5layer_direct
Xu_t022_012 u_t022_012/c0_w0_bl u_t022_012/c0_w0_br u_t022_012/c0_w1_bl u_t022_012/c0_w1_br
+ u_t022_012/c0_r0_rbl u_t022_012/c0_r1_rbl u_t022_012/c1_w0_bl u_t022_012/c1_w0_br
+ u_t022_012/c1_w1_bl u_t022_012/c1_w1_br u_t022_012/c1_r0_rbl u_t022_012/c1_r1_rbl
+ u_t022_012/c2_w0_bl u_t022_012/c2_w0_br u_t022_012/c2_w1_bl u_t022_012/c2_w1_br
+ u_t022_012/c2_r0_rbl u_t022_012/c2_r1_rbl u_t022_012/c3_w0_bl u_t022_012/c3_w0_br
+ u_t022_012/c3_w1_bl u_t022_012/c3_w1_br u_t022_012/c3_r0_rbl u_t022_012/c3_r1_rbl
+ u_t022_012/r0_w0_wl u_t022_012/r0_w1_wl u_t022_012/r0_r0_rwl u_t022_012/r0_r1_rwl
+ u_t022_012/r1_w0_wl u_t022_012/r1_w1_wl u_t022_012/r1_r0_rwl u_t022_012/r1_r1_rwl
+ u_t022_012/r2_w0_wl u_t022_012/r2_w1_wl u_t022_012/r2_r0_rwl u_t022_012/r2_r1_rwl
+ u_t022_012/r3_w0_wl u_t022_012/r3_w1_wl u_t022_012/r3_r0_rwl u_t022_012/r3_r1_rwl
+ u_t022_012/VDD u_t022_031/VSS VSUBS detronyx_12t_2w2r_rc4_4x4_routed_5layer_direct
Xgf180mcu_as_sc_mcu7t3v3__nand4_2_490 VSS gf180mcu_as_sc_mcu7t3v3__inv_2_1657/VDD
+ VSS VSS VSS VSS VSS gf180mcu_as_sc_mcu7t3v3__inv_2_1656/VNW VSUBS gf180mcu_as_sc_mcu7t3v3__nand4_2
Xu_t013_023 u_t013_023/c0_w0_bl u_t013_023/c0_w0_br u_t013_023/c0_w1_bl u_t013_023/c0_w1_br
+ u_t013_023/c0_r0_rbl u_t013_023/c0_r1_rbl u_t013_023/c1_w0_bl u_t013_023/c1_w0_br
+ u_t013_023/c1_w1_bl u_t013_023/c1_w1_br u_t013_023/c1_r0_rbl u_t013_023/c1_r1_rbl
+ u_t013_023/c2_w0_bl u_t013_023/c2_w0_br u_t013_023/c2_w1_bl u_t013_023/c2_w1_br
+ u_t013_023/c2_r0_rbl u_t013_023/c2_r1_rbl u_t013_023/c3_w0_bl u_t013_023/c3_w0_br
+ u_t013_023/c3_w1_bl u_t013_023/c3_w1_br u_t013_023/c3_r0_rbl u_t013_023/c3_r1_rbl
+ u_t013_023/r0_w0_wl u_t013_023/r0_w1_wl u_t013_023/r0_r0_rwl u_t013_023/r0_r1_rwl
+ u_t013_023/r1_w0_wl u_t013_023/r1_w1_wl u_t013_023/r1_r0_rwl u_t013_023/r1_r1_rwl
+ u_t013_023/r2_w0_wl u_t013_023/r2_w1_wl u_t013_023/r2_r0_rwl u_t013_023/r2_r1_rwl
+ u_t013_023/r3_w0_wl u_t013_023/r3_w1_wl u_t013_023/r3_r0_rwl u_t013_023/r3_r1_rwl
+ VSS u_t013_031/VSS VSUBS detronyx_12t_2w2r_rc4_4x4_routed_5layer_direct
Xu_t013_012 u_t013_012/c0_w0_bl u_t013_012/c0_w0_br u_t013_012/c0_w1_bl u_t013_012/c0_w1_br
+ u_t013_012/c0_r0_rbl u_t013_012/c0_r1_rbl u_t013_012/c1_w0_bl u_t013_012/c1_w0_br
+ u_t013_012/c1_w1_bl u_t013_012/c1_w1_br u_t013_012/c1_r0_rbl u_t013_012/c1_r1_rbl
+ u_t013_012/c2_w0_bl u_t013_012/c2_w0_br u_t013_012/c2_w1_bl u_t013_012/c2_w1_br
+ u_t013_012/c2_r0_rbl u_t013_012/c2_r1_rbl u_t013_012/c3_w0_bl u_t013_012/c3_w0_br
+ u_t013_012/c3_w1_bl u_t013_012/c3_w1_br u_t013_012/c3_r0_rbl u_t013_012/c3_r1_rbl
+ u_t013_012/r0_w0_wl u_t013_012/r0_w1_wl u_t013_012/r0_r0_rwl u_t013_012/r0_r1_rwl
+ u_t013_012/r1_w0_wl u_t013_012/r1_w1_wl u_t013_012/r1_r0_rwl u_t013_012/r1_r1_rwl
+ u_t013_012/r2_w0_wl u_t013_012/r2_w1_wl u_t013_012/r2_r0_rwl u_t013_012/r2_r1_rwl
+ u_t013_012/r3_w0_wl u_t013_012/r3_w1_wl u_t013_012/r3_r0_rwl u_t013_012/r3_r1_rwl
+ u_t013_012/VDD u_t013_031/VSS VSUBS detronyx_12t_2w2r_rc4_4x4_routed_5layer_direct
Xu_t013_001 u_t013_001/c0_w0_bl u_t013_001/c0_w0_br u_t013_001/c0_w1_bl u_t013_001/c0_w1_br
+ u_t013_001/c0_r0_rbl u_t013_001/c0_r1_rbl u_t013_001/c1_w0_bl u_t013_001/c1_w0_br
+ u_t013_001/c1_w1_bl u_t013_001/c1_w1_br u_t013_001/c1_r0_rbl u_t013_001/c1_r1_rbl
+ u_t013_001/c2_w0_bl u_t013_001/c2_w0_br u_t013_001/c2_w1_bl u_t013_001/c2_w1_br
+ u_t013_001/c2_r0_rbl u_t013_001/c2_r1_rbl u_t013_001/c3_w0_bl u_t013_001/c3_w0_br
+ u_t013_001/c3_w1_bl u_t013_001/c3_w1_br u_t013_001/c3_r0_rbl u_t013_001/c3_r1_rbl
+ u_t013_001/r0_w0_wl u_t013_001/r0_w1_wl u_t013_001/r0_r0_rwl u_t013_001/r0_r1_rwl
+ u_t013_001/r1_w0_wl u_t013_001/r1_w1_wl u_t013_001/r1_r0_rwl u_t013_001/r1_r1_rwl
+ u_t013_001/r2_w0_wl u_t013_001/r2_w1_wl u_t013_001/r2_r0_rwl u_t013_001/r2_r1_rwl
+ u_t013_001/r3_w0_wl u_t013_001/r3_w1_wl u_t013_001/r3_r0_rwl u_t013_001/r3_r1_rwl
+ VSS u_t013_031/VSS VSUBS detronyx_12t_2w2r_rc4_4x4_routed_5layer_direct
Xgf180mcu_as_sc_mcu7t3v3__inv_2_410 VSS VSS gf180mcu_as_sc_mcu7t3v3__inv_2_410/Y VSS
+ gf180mcu_as_sc_mcu7t3v3__inv_2_410/VNW VSUBS gf180mcu_as_sc_mcu7t3v3__inv_2
Xgf180mcu_as_sc_mcu7t3v3__inv_2_443 VSS VSS VSS VSS gf180mcu_as_sc_mcu7t3v3__inv_2_443/VNW
+ VSUBS gf180mcu_as_sc_mcu7t3v3__inv_2
Xgf180mcu_as_sc_mcu7t3v3__inv_2_454 gf180mcu_as_sc_mcu7t3v3__nor2_2_4/VDD gf180mcu_as_sc_mcu7t3v3__nand3_2_8/VSS
+ gf180mcu_as_sc_mcu7t3v3__inv_2_454/Y VSS gf180mcu_as_sc_mcu7t3v3__nor2_2_4/VNW VSUBS
+ gf180mcu_as_sc_mcu7t3v3__inv_2
Xgf180mcu_as_sc_mcu7t3v3__inv_2_421 gf180mcu_as_sc_mcu7t3v3__nor2_2_6/VDD gf180mcu_as_sc_mcu7t3v3__nor2_2_6/VSS
+ VSS VSS gf180mcu_as_sc_mcu7t3v3__nor2_2_6/VNW VSUBS gf180mcu_as_sc_mcu7t3v3__inv_2
Xgf180mcu_as_sc_mcu7t3v3__inv_2_432 gf180mcu_as_sc_mcu7t3v3__nand3_2_5/VDD gf180mcu_as_sc_mcu7t3v3__nor2_2_4/VSS
+ VSS VSS gf180mcu_as_sc_mcu7t3v3__nand3_2_5/VNW VSUBS gf180mcu_as_sc_mcu7t3v3__inv_2
Xu_t004_023 u_t004_023/c0_w0_bl u_t004_023/c0_w0_br u_t004_023/c0_w1_bl u_t004_023/c0_w1_br
+ u_t004_023/c0_r0_rbl u_t004_023/c0_r1_rbl u_t004_023/c1_w0_bl u_t004_023/c1_w0_br
+ u_t004_023/c1_w1_bl u_t004_023/c1_w1_br u_t004_023/c1_r0_rbl u_t004_023/c1_r1_rbl
+ u_t004_023/c2_w0_bl u_t004_023/c2_w0_br u_t004_023/c2_w1_bl u_t004_023/c2_w1_br
+ u_t004_023/c2_r0_rbl u_t004_023/c2_r1_rbl u_t004_023/c3_w0_bl u_t004_023/c3_w0_br
+ u_t004_023/c3_w1_bl u_t004_023/c3_w1_br u_t004_023/c3_r0_rbl u_t004_023/c3_r1_rbl
+ u_t004_023/r0_w0_wl u_t004_023/r0_w1_wl u_t004_023/r0_r0_rwl u_t004_023/r0_r1_rwl
+ u_t004_023/r1_w0_wl u_t004_023/r1_w1_wl u_t004_023/r1_r0_rwl u_t004_023/r1_r1_rwl
+ u_t004_023/r2_w0_wl u_t004_023/r2_w1_wl u_t004_023/r2_r0_rwl u_t004_023/r2_r1_rwl
+ u_t004_023/r3_w0_wl u_t004_023/r3_w1_wl u_t004_023/r3_r0_rwl u_t004_023/r3_r1_rwl
+ VSS u_t004_031/VSS VSUBS detronyx_12t_2w2r_rc4_4x4_routed_5layer_direct
Xu_t004_012 u_t004_012/c0_w0_bl u_t004_012/c0_w0_br u_t004_012/c0_w1_bl u_t004_012/c0_w1_br
+ u_t004_012/c0_r0_rbl u_t004_012/c0_r1_rbl u_t004_012/c1_w0_bl u_t004_012/c1_w0_br
+ u_t004_012/c1_w1_bl u_t004_012/c1_w1_br u_t004_012/c1_r0_rbl u_t004_012/c1_r1_rbl
+ u_t004_012/c2_w0_bl u_t004_012/c2_w0_br u_t004_012/c2_w1_bl u_t004_012/c2_w1_br
+ u_t004_012/c2_r0_rbl u_t004_012/c2_r1_rbl u_t004_012/c3_w0_bl u_t004_012/c3_w0_br
+ u_t004_012/c3_w1_bl u_t004_012/c3_w1_br u_t004_012/c3_r0_rbl u_t004_012/c3_r1_rbl
+ u_t004_012/r0_w0_wl u_t004_012/r0_w1_wl u_t004_012/r0_r0_rwl u_t004_012/r0_r1_rwl
+ u_t004_012/r1_w0_wl u_t004_012/r1_w1_wl u_t004_012/r1_r0_rwl u_t004_012/r1_r1_rwl
+ u_t004_012/r2_w0_wl u_t004_012/r2_w1_wl u_t004_012/r2_r0_rwl u_t004_012/r2_r1_rwl
+ u_t004_012/r3_w0_wl u_t004_012/r3_w1_wl u_t004_012/r3_r0_rwl u_t004_012/r3_r1_rwl
+ u_t004_012/VDD u_t004_031/VSS VSUBS detronyx_12t_2w2r_rc4_4x4_routed_5layer_direct
Xu_t004_001 u_t004_001/c0_w0_bl u_t004_001/c0_w0_br u_t004_001/c0_w1_bl u_t004_001/c0_w1_br
+ u_t004_001/c0_r0_rbl u_t004_001/c0_r1_rbl u_t004_001/c1_w0_bl u_t004_001/c1_w0_br
+ u_t004_001/c1_w1_bl u_t004_001/c1_w1_br u_t004_001/c1_r0_rbl u_t004_001/c1_r1_rbl
+ u_t004_001/c2_w0_bl u_t004_001/c2_w0_br u_t004_001/c2_w1_bl u_t004_001/c2_w1_br
+ u_t004_001/c2_r0_rbl u_t004_001/c2_r1_rbl u_t004_001/c3_w0_bl u_t004_001/c3_w0_br
+ u_t004_001/c3_w1_bl u_t004_001/c3_w1_br u_t004_001/c3_r0_rbl u_t004_001/c3_r1_rbl
+ u_t004_001/r0_w0_wl u_t004_001/r0_w1_wl u_t004_001/r0_r0_rwl u_t004_001/r0_r1_rwl
+ u_t004_001/r1_w0_wl u_t004_001/r1_w1_wl u_t004_001/r1_r0_rwl u_t004_001/r1_r1_rwl
+ u_t004_001/r2_w0_wl u_t004_001/r2_w1_wl u_t004_001/r2_r0_rwl u_t004_001/r2_r1_rwl
+ u_t004_001/r3_w0_wl u_t004_001/r3_w1_wl u_t004_001/r3_r0_rwl u_t004_001/r3_r1_rwl
+ VSS u_t004_031/VSS VSUBS detronyx_12t_2w2r_rc4_4x4_routed_5layer_direct
Xgf180mcu_as_sc_mcu7t3v3__inv_2_465 gf180mcu_as_sc_mcu7t3v3__nor2_2_4/VDD gf180mcu_as_sc_mcu7t3v3__nand3_2_8/VSS
+ VSS VSS gf180mcu_as_sc_mcu7t3v3__nor2_2_4/VNW VSUBS gf180mcu_as_sc_mcu7t3v3__inv_2
Xgf180mcu_as_sc_mcu7t3v3__inv_2_476 gf180mcu_as_sc_mcu7t3v3__nor2_2_4/VDD gf180mcu_as_sc_mcu7t3v3__nor2_2_4/VSS
+ VSS VSS gf180mcu_as_sc_mcu7t3v3__nor2_2_4/VNW VSUBS gf180mcu_as_sc_mcu7t3v3__inv_2
Xgf180mcu_as_sc_mcu7t3v3__inv_2_498 gf180mcu_as_sc_mcu7t3v3__nor2_2_6/VDD gf180mcu_as_sc_mcu7t3v3__nor2_2_6/VSS
+ gf180mcu_as_sc_mcu7t3v3__inv_2_498/Y VSS gf180mcu_as_sc_mcu7t3v3__nor2_2_6/VNW VSUBS
+ gf180mcu_as_sc_mcu7t3v3__inv_2
Xgf180mcu_as_sc_mcu7t3v3__inv_2_487 gf180mcu_as_sc_mcu7t3v3__nor2_2_6/VDD gf180mcu_as_sc_mcu7t3v3__nand3_2_3/VSS
+ VSS VSS gf180mcu_as_sc_mcu7t3v3__nor2_2_6/VNW VSUBS gf180mcu_as_sc_mcu7t3v3__inv_2
Xu_t010_026 u_t010_026/c0_w0_bl u_t010_026/c0_w0_br u_t010_026/c0_w1_bl u_t010_026/c0_w1_br
+ u_t010_026/c0_r0_rbl u_t010_026/c0_r1_rbl u_t010_026/c1_w0_bl u_t010_026/c1_w0_br
+ u_t010_026/c1_w1_bl u_t010_026/c1_w1_br u_t010_026/c1_r0_rbl u_t010_026/c1_r1_rbl
+ u_t010_026/c2_w0_bl u_t010_026/c2_w0_br u_t010_026/c2_w1_bl u_t010_026/c2_w1_br
+ u_t010_026/c2_r0_rbl u_t010_026/c2_r1_rbl u_t010_026/c3_w0_bl u_t010_026/c3_w0_br
+ u_t010_026/c3_w1_bl u_t010_026/c3_w1_br u_t010_026/c3_r0_rbl u_t010_026/c3_r1_rbl
+ u_t010_026/r0_w0_wl u_t010_026/r0_w1_wl u_t010_026/r0_r0_rwl u_t010_026/r0_r1_rwl
+ u_t010_026/r1_w0_wl u_t010_026/r1_w1_wl u_t010_026/r1_r0_rwl u_t010_026/r1_r1_rwl
+ u_t010_026/r2_w0_wl u_t010_026/r2_w1_wl u_t010_026/r2_r0_rwl u_t010_026/r2_r1_rwl
+ u_t010_026/r3_w0_wl u_t010_026/r3_w1_wl u_t010_026/r3_r0_rwl u_t010_026/r3_r1_rwl
+ u_t010_026/VDD u_t010_026/VSS VSUBS detronyx_12t_2w2r_rc4_4x4_routed_5layer_direct
Xu_t010_015 u_t010_015/c0_w0_bl u_t010_015/c0_w0_br u_t010_015/c0_w1_bl u_t010_015/c0_w1_br
+ u_t010_015/c0_r0_rbl u_t010_015/c0_r1_rbl u_t010_015/c1_w0_bl u_t010_015/c1_w0_br
+ u_t010_015/c1_w1_bl u_t010_015/c1_w1_br u_t010_015/c1_r0_rbl u_t010_015/c1_r1_rbl
+ u_t010_015/c2_w0_bl u_t010_015/c2_w0_br u_t010_015/c2_w1_bl u_t010_015/c2_w1_br
+ u_t010_015/c2_r0_rbl u_t010_015/c2_r1_rbl u_t010_015/c3_w0_bl u_t010_015/c3_w0_br
+ u_t010_015/c3_w1_bl u_t010_015/c3_w1_br u_t010_015/c3_r0_rbl u_t010_015/c3_r1_rbl
+ u_t010_015/r0_w0_wl u_t010_015/r0_w1_wl u_t010_015/r0_r0_rwl u_t010_015/r0_r1_rwl
+ u_t010_015/r1_w0_wl u_t010_015/r1_w1_wl u_t010_015/r1_r0_rwl u_t010_015/r1_r1_rwl
+ u_t010_015/r2_w0_wl u_t010_015/r2_w1_wl u_t010_015/r2_r0_rwl u_t010_015/r2_r1_rwl
+ u_t010_015/r3_w0_wl u_t010_015/r3_w1_wl u_t010_015/r3_r0_rwl u_t010_015/r3_r1_rwl
+ VSS u_t010_017/VSS VSUBS detronyx_12t_2w2r_rc4_4x4_routed_5layer_direct
Xu_t010_004 u_t010_004/c0_w0_bl u_t010_004/c0_w0_br u_t010_004/c0_w1_bl u_t010_004/c0_w1_br
+ u_t010_004/c0_r0_rbl u_t010_004/c0_r1_rbl u_t010_004/c1_w0_bl u_t010_004/c1_w0_br
+ u_t010_004/c1_w1_bl u_t010_004/c1_w1_br u_t010_004/c1_r0_rbl u_t010_004/c1_r1_rbl
+ u_t010_004/c2_w0_bl u_t010_004/c2_w0_br u_t010_004/c2_w1_bl u_t010_004/c2_w1_br
+ u_t010_004/c2_r0_rbl u_t010_004/c2_r1_rbl u_t010_004/c3_w0_bl u_t010_004/c3_w0_br
+ u_t010_004/c3_w1_bl u_t010_004/c3_w1_br u_t010_004/c3_r0_rbl u_t010_004/c3_r1_rbl
+ u_t010_004/r0_w0_wl u_t010_004/r0_w1_wl u_t010_004/r0_r0_rwl u_t010_004/r0_r1_rwl
+ u_t010_004/r1_w0_wl u_t010_004/r1_w1_wl u_t010_004/r1_r0_rwl u_t010_004/r1_r1_rwl
+ u_t010_004/r2_w0_wl u_t010_004/r2_w1_wl u_t010_004/r2_r0_rwl u_t010_004/r2_r1_rwl
+ u_t010_004/r3_w0_wl u_t010_004/r3_w1_wl u_t010_004/r3_r0_rwl u_t010_004/r3_r1_rwl
+ u_t010_004/VDD u_t010_004/VSS VSUBS detronyx_12t_2w2r_rc4_4x4_routed_5layer_direct
Xu_t001_026 u_t001_026/c0_w0_bl u_t001_026/c0_w0_br u_t001_026/c0_w1_bl u_t001_026/c0_w1_br
+ u_t001_026/c0_r0_rbl u_t001_026/c0_r1_rbl u_t001_026/c1_w0_bl u_t001_026/c1_w0_br
+ u_t001_026/c1_w1_bl u_t001_026/c1_w1_br u_t001_026/c1_r0_rbl u_t001_026/c1_r1_rbl
+ u_t001_026/c2_w0_bl u_t001_026/c2_w0_br u_t001_026/c2_w1_bl u_t001_026/c2_w1_br
+ u_t001_026/c2_r0_rbl u_t001_026/c2_r1_rbl u_t001_026/c3_w0_bl u_t001_026/c3_w0_br
+ u_t001_026/c3_w1_bl u_t001_026/c3_w1_br u_t001_026/c3_r0_rbl u_t001_026/c3_r1_rbl
+ u_t001_026/r0_w0_wl u_t001_026/r0_w1_wl u_t001_026/r0_r0_rwl u_t001_026/r0_r1_rwl
+ u_t001_026/r1_w0_wl u_t001_026/r1_w1_wl u_t001_026/r1_r0_rwl u_t001_026/r1_r1_rwl
+ u_t001_026/r2_w0_wl u_t001_026/r2_w1_wl u_t001_026/r2_r0_rwl u_t001_026/r2_r1_rwl
+ u_t001_026/r3_w0_wl u_t001_026/r3_w1_wl u_t001_026/r3_r0_rwl u_t001_026/r3_r1_rwl
+ u_t001_026/VDD u_t001_031/VSS VSUBS detronyx_12t_2w2r_rc4_4x4_routed_5layer_direct
Xu_t001_015 u_t001_015/c0_w0_bl u_t001_015/c0_w0_br u_t001_015/c0_w1_bl u_t001_015/c0_w1_br
+ u_t001_015/c0_r0_rbl u_t001_015/c0_r1_rbl u_t001_015/c1_w0_bl u_t001_015/c1_w0_br
+ u_t001_015/c1_w1_bl u_t001_015/c1_w1_br u_t001_015/c1_r0_rbl u_t001_015/c1_r1_rbl
+ u_t001_015/c2_w0_bl u_t001_015/c2_w0_br u_t001_015/c2_w1_bl u_t001_015/c2_w1_br
+ u_t001_015/c2_r0_rbl u_t001_015/c2_r1_rbl u_t001_015/c3_w0_bl u_t001_015/c3_w0_br
+ u_t001_015/c3_w1_bl u_t001_015/c3_w1_br u_t001_015/c3_r0_rbl u_t001_015/c3_r1_rbl
+ u_t001_015/r0_w0_wl u_t001_015/r0_w1_wl u_t001_015/r0_r0_rwl u_t001_015/r0_r1_rwl
+ u_t001_015/r1_w0_wl u_t001_015/r1_w1_wl u_t001_015/r1_r0_rwl u_t001_015/r1_r1_rwl
+ u_t001_015/r2_w0_wl u_t001_015/r2_w1_wl u_t001_015/r2_r0_rwl u_t001_015/r2_r1_rwl
+ u_t001_015/r3_w0_wl u_t001_015/r3_w1_wl u_t001_015/r3_r0_rwl u_t001_015/r3_r1_rwl
+ VSS u_t001_031/VSS VSUBS detronyx_12t_2w2r_rc4_4x4_routed_5layer_direct
Xu_t001_004 u_t001_004/c0_w0_bl u_t001_004/c0_w0_br u_t001_004/c0_w1_bl u_t001_004/c0_w1_br
+ u_t001_004/c0_r0_rbl u_t001_004/c0_r1_rbl u_t001_004/c1_w0_bl u_t001_004/c1_w0_br
+ u_t001_004/c1_w1_bl u_t001_004/c1_w1_br u_t001_004/c1_r0_rbl u_t001_004/c1_r1_rbl
+ u_t001_004/c2_w0_bl u_t001_004/c2_w0_br u_t001_004/c2_w1_bl u_t001_004/c2_w1_br
+ u_t001_004/c2_r0_rbl u_t001_004/c2_r1_rbl u_t001_004/c3_w0_bl u_t001_004/c3_w0_br
+ u_t001_004/c3_w1_bl u_t001_004/c3_w1_br u_t001_004/c3_r0_rbl u_t001_004/c3_r1_rbl
+ u_t001_004/r0_w0_wl u_t001_004/r0_w1_wl u_t001_004/r0_r0_rwl u_t001_004/r0_r1_rwl
+ u_t001_004/r1_w0_wl u_t001_004/r1_w1_wl u_t001_004/r1_r0_rwl u_t001_004/r1_r1_rwl
+ u_t001_004/r2_w0_wl u_t001_004/r2_w1_wl u_t001_004/r2_r0_rwl u_t001_004/r2_r1_rwl
+ u_t001_004/r3_w0_wl u_t001_004/r3_w1_wl u_t001_004/r3_r0_rwl u_t001_004/r3_r1_rwl
+ u_t001_004/VDD u_t001_031/VSS VSUBS detronyx_12t_2w2r_rc4_4x4_routed_5layer_direct
Xgf180mcu_as_sc_mcu7t3v3__inv_2_273 gf180mcu_as_sc_mcu7t3v3__inv_2_351/VDD VSS VSS
+ gf180mcu_as_sc_mcu7t3v3__inv_2_66/Y gf180mcu_as_sc_mcu7t3v3__inv_2_351/VNW VSUBS
+ gf180mcu_as_sc_mcu7t3v3__inv_2
Xgf180mcu_as_sc_mcu7t3v3__inv_2_284 gf180mcu_as_sc_mcu7t3v3__inv_2_364/VDD VSS gf180mcu_as_sc_mcu7t3v3__inv_2_284/Y
+ gf180mcu_as_sc_mcu7t3v3__inv_2_364/Y gf180mcu_as_sc_mcu7t3v3__inv_2_364/VNW VSUBS
+ gf180mcu_as_sc_mcu7t3v3__inv_2
Xgf180mcu_as_sc_mcu7t3v3__inv_2_262 gf180mcu_as_sc_mcu7t3v3__inv_2_361/VDD gf180mcu_as_sc_mcu7t3v3__inv_2_363/VDD
+ gf180mcu_as_sc_mcu7t3v3__inv_2_262/Y gf180mcu_as_sc_mcu7t3v3__inv_2_361/Y gf180mcu_as_sc_mcu7t3v3__inv_2_361/VNW
+ VSUBS gf180mcu_as_sc_mcu7t3v3__inv_2
Xgf180mcu_as_sc_mcu7t3v3__inv_2_251 VSS VSS VSS VSS gf180mcu_as_sc_mcu7t3v3__inv_2_252/VNW
+ VSUBS gf180mcu_as_sc_mcu7t3v3__inv_2
Xgf180mcu_as_sc_mcu7t3v3__inv_2_240 gf180mcu_as_sc_mcu7t3v3__inv_2_241/VDD gf180mcu_as_sc_mcu7t3v3__inv_2_245/VDD
+ gf180mcu_as_sc_mcu7t3v3__inv_2_240/Y VSS gf180mcu_as_sc_mcu7t3v3__inv_2_241/VNW
+ VSUBS gf180mcu_as_sc_mcu7t3v3__inv_2
Xgf180mcu_as_sc_mcu7t3v3__inv_2_295 VSS VSS VSS gf180mcu_as_sc_mcu7t3v3__inv_2_338/Y
+ gf180mcu_as_sc_mcu7t3v3__inv_2_329/VNW VSUBS gf180mcu_as_sc_mcu7t3v3__inv_2
Xgf180mcu_as_sc_mcu7t3v3__inv_2_1569 gf180mcu_as_sc_mcu7t3v3__inv_2_1569/VDD VSS VSS
+ VSS gf180mcu_as_sc_mcu7t3v3__inv_2_1569/VNW VSUBS gf180mcu_as_sc_mcu7t3v3__inv_2
Xgf180mcu_as_sc_mcu7t3v3__inv_2_1558 gf180mcu_as_sc_mcu7t3v3__inv_2_1586/VSS VSS VSS
+ VSS gf180mcu_as_sc_mcu7t3v3__inv_2_1574/VNW VSUBS gf180mcu_as_sc_mcu7t3v3__inv_2
Xgf180mcu_as_sc_mcu7t3v3__inv_2_1525 gf180mcu_as_sc_mcu7t3v3__inv_2_1548/VSS VSS VSS
+ VSS gf180mcu_as_sc_mcu7t3v3__inv_2_1525/VNW VSUBS gf180mcu_as_sc_mcu7t3v3__inv_2
Xgf180mcu_as_sc_mcu7t3v3__inv_2_1536 VSS gf180mcu_as_sc_mcu7t3v3__inv_2_1552/VSS VSS
+ VSS gf180mcu_as_sc_mcu7t3v3__inv_2_1552/VNW VSUBS gf180mcu_as_sc_mcu7t3v3__inv_2
Xgf180mcu_as_sc_mcu7t3v3__inv_2_1514 gf180mcu_as_sc_mcu7t3v3__inv_2_1514/VDD VSS VSS
+ VSS gf180mcu_as_sc_mcu7t3v3__inv_2_1514/VNW VSUBS gf180mcu_as_sc_mcu7t3v3__inv_2
Xgf180mcu_as_sc_mcu7t3v3__inv_2_1547 VSS gf180mcu_as_sc_mcu7t3v3__inv_2_1551/VDD gf180mcu_as_sc_mcu7t3v3__inv_2_1547/Y
+ VSS gf180mcu_as_sc_mcu7t3v3__inv_2_1547/VNW VSUBS gf180mcu_as_sc_mcu7t3v3__inv_2
Xgf180mcu_as_sc_mcu7t3v3__inv_2_1503 VSS VSS VSS VSS gf180mcu_as_sc_mcu7t3v3__inv_2_1553/VNW
+ VSUBS gf180mcu_as_sc_mcu7t3v3__inv_2
Xgf180mcu_as_sc_mcu7t3v3__nand4_2_308 VSS gf180mcu_as_sc_mcu7t3v3__inv_2_1056/VDD
+ VSS VSS VSS VSS VSS gf180mcu_as_sc_mcu7t3v3__inv_2_1050/VNW VSUBS gf180mcu_as_sc_mcu7t3v3__nand4_2
Xgf180mcu_as_sc_mcu7t3v3__nand4_2_319 gf180mcu_as_sc_mcu7t3v3__inv_2_1064/VDD gf180mcu_as_sc_mcu7t3v3__inv_2_1072/VDD
+ VSS VSS VSS VSS VSS gf180mcu_as_sc_mcu7t3v3__inv_2_1064/VNW VSUBS gf180mcu_as_sc_mcu7t3v3__nand4_2
Xgf180mcu_as_sc_mcu7t3v3__nand2_2_2 gf180mcu_as_sc_mcu7t3v3__nor2_2_6/VDD gf180mcu_as_sc_mcu7t3v3__nand3_2_3/VSS
+ VSS VSS VSS gf180mcu_as_sc_mcu7t3v3__nor2_2_6/VNW VSUBS gf180mcu_as_sc_mcu7t3v3__nand2_2
Xu_t029_018 u_t029_018/c0_w0_bl u_t029_018/c0_w0_br u_t029_018/c0_w1_bl u_t029_018/c0_w1_br
+ u_t029_018/c0_r0_rbl u_t029_018/c0_r1_rbl u_t029_018/c1_w0_bl u_t029_018/c1_w0_br
+ u_t029_018/c1_w1_bl u_t029_018/c1_w1_br u_t029_018/c1_r0_rbl u_t029_018/c1_r1_rbl
+ u_t029_018/c2_w0_bl u_t029_018/c2_w0_br u_t029_018/c2_w1_bl u_t029_018/c2_w1_br
+ u_t029_018/c2_r0_rbl u_t029_018/c2_r1_rbl u_t029_018/c3_w0_bl u_t029_018/c3_w0_br
+ u_t029_018/c3_w1_bl u_t029_018/c3_w1_br u_t029_018/c3_r0_rbl u_t029_018/c3_r1_rbl
+ u_t029_018/r0_w0_wl u_t029_018/r0_w1_wl u_t029_018/r0_r0_rwl u_t029_018/r0_r1_rwl
+ u_t029_018/r1_w0_wl u_t029_018/r1_w1_wl u_t029_018/r1_r0_rwl u_t029_018/r1_r1_rwl
+ u_t029_018/r2_w0_wl u_t029_018/r2_w1_wl u_t029_018/r2_r0_rwl u_t029_018/r2_r1_rwl
+ u_t029_018/r3_w0_wl u_t029_018/r3_w1_wl u_t029_018/r3_r0_rwl u_t029_018/r3_r1_rwl
+ u_t029_018/VDD u_t029_031/VSS VSUBS detronyx_12t_2w2r_rc4_4x4_routed_5layer_direct
Xu_t029_007 u_t029_007/c0_w0_bl u_t029_007/c0_w0_br u_t029_007/c0_w1_bl u_t029_007/c0_w1_br
+ u_t029_007/c0_r0_rbl u_t029_007/c0_r1_rbl u_t029_007/c1_w0_bl u_t029_007/c1_w0_br
+ u_t029_007/c1_w1_bl u_t029_007/c1_w1_br u_t029_007/c1_r0_rbl u_t029_007/c1_r1_rbl
+ u_t029_007/c2_w0_bl u_t029_007/c2_w0_br u_t029_007/c2_w1_bl u_t029_007/c2_w1_br
+ u_t029_007/c2_r0_rbl u_t029_007/c2_r1_rbl u_t029_007/c3_w0_bl u_t029_007/c3_w0_br
+ u_t029_007/c3_w1_bl u_t029_007/c3_w1_br u_t029_007/c3_r0_rbl u_t029_007/c3_r1_rbl
+ u_t029_007/r0_w0_wl u_t029_007/r0_w1_wl u_t029_007/r0_r0_rwl u_t029_007/r0_r1_rwl
+ u_t029_007/r1_w0_wl u_t029_007/r1_w1_wl u_t029_007/r1_r0_rwl u_t029_007/r1_r1_rwl
+ u_t029_007/r2_w0_wl u_t029_007/r2_w1_wl u_t029_007/r2_r0_rwl u_t029_007/r2_r1_rwl
+ u_t029_007/r3_w0_wl u_t029_007/r3_w1_wl u_t029_007/r3_r0_rwl u_t029_007/r3_r1_rwl
+ VSS u_t029_031/VSS VSUBS detronyx_12t_2w2r_rc4_4x4_routed_5layer_direct
Xu_t029_029 u_t029_029/c0_w0_bl u_t029_029/c0_w0_br u_t029_029/c0_w1_bl u_t029_029/c0_w1_br
+ u_t029_029/c0_r0_rbl u_t029_029/c0_r1_rbl u_t029_029/c1_w0_bl u_t029_029/c1_w0_br
+ u_t029_029/c1_w1_bl u_t029_029/c1_w1_br u_t029_029/c1_r0_rbl u_t029_029/c1_r1_rbl
+ u_t029_029/c2_w0_bl u_t029_029/c2_w0_br u_t029_029/c2_w1_bl u_t029_029/c2_w1_br
+ u_t029_029/c2_r0_rbl u_t029_029/c2_r1_rbl u_t029_029/c3_w0_bl u_t029_029/c3_w0_br
+ u_t029_029/c3_w1_bl u_t029_029/c3_w1_br u_t029_029/c3_r0_rbl u_t029_029/c3_r1_rbl
+ u_t029_029/r0_w0_wl u_t029_029/r0_w1_wl u_t029_029/r0_r0_rwl u_t029_029/r0_r1_rwl
+ u_t029_029/r1_w0_wl u_t029_029/r1_w1_wl u_t029_029/r1_r0_rwl u_t029_029/r1_r1_rwl
+ u_t029_029/r2_w0_wl u_t029_029/r2_w1_wl u_t029_029/r2_r0_rwl u_t029_029/r2_r1_rwl
+ u_t029_029/r3_w0_wl u_t029_029/r3_w1_wl u_t029_029/r3_r0_rwl u_t029_029/r3_r1_rwl
+ u_t029_029/VDD u_t029_031/VSS VSUBS detronyx_12t_2w2r_rc4_4x4_routed_5layer_direct
Xgf180mcu_as_sc_mcu7t3v3__inv_2_1344 gf180mcu_as_sc_mcu7t3v3__inv_2_1391/VDD VSS gf180mcu_as_sc_mcu7t3v3__inv_2_1398/Y
+ gf180mcu_as_sc_mcu7t3v3__inv_2_1398/Y gf180mcu_as_sc_mcu7t3v3__inv_2_1391/VNW VSUBS
+ gf180mcu_as_sc_mcu7t3v3__inv_2
Xgf180mcu_as_sc_mcu7t3v3__inv_2_1300 VSS gf180mcu_as_sc_mcu7t3v3__inv_2_1691/VDD VSS
+ gf180mcu_as_sc_mcu7t3v3__inv_2_1691/Y gf180mcu_as_sc_mcu7t3v3__inv_2_1365/VNW VSUBS
+ gf180mcu_as_sc_mcu7t3v3__inv_2
Xgf180mcu_as_sc_mcu7t3v3__inv_2_1322 gf180mcu_as_sc_mcu7t3v3__inv_2_1378/VDD gf180mcu_as_sc_mcu7t3v3__inv_2_1379/VDD
+ VSS gf180mcu_as_sc_mcu7t3v3__inv_2_1379/Y gf180mcu_as_sc_mcu7t3v3__inv_2_1378/VNW
+ VSUBS gf180mcu_as_sc_mcu7t3v3__inv_2
Xgf180mcu_as_sc_mcu7t3v3__inv_2_1311 VSS gf180mcu_as_sc_mcu7t3v3__inv_2_1375/VDD gf180mcu_as_sc_mcu7t3v3__inv_2_1379/Y
+ gf180mcu_as_sc_mcu7t3v3__inv_2_1379/Y gf180mcu_as_sc_mcu7t3v3__inv_2_1374/VNW VSUBS
+ gf180mcu_as_sc_mcu7t3v3__inv_2
Xgf180mcu_as_sc_mcu7t3v3__inv_2_1333 gf180mcu_as_sc_mcu7t3v3__inv_2_1394/VDD VSS gf180mcu_as_sc_mcu7t3v3__inv_2_1398/Y
+ gf180mcu_as_sc_mcu7t3v3__inv_2_1398/Y gf180mcu_as_sc_mcu7t3v3__inv_2_1394/VNW VSUBS
+ gf180mcu_as_sc_mcu7t3v3__inv_2
Xgf180mcu_as_sc_mcu7t3v3__inv_2_1399 VSS gf180mcu_as_sc_mcu7t3v3__inv_2_1400/VDD gf180mcu_as_sc_mcu7t3v3__inv_2_1685/Y
+ VSS gf180mcu_as_sc_mcu7t3v3__inv_2_1399/VNW VSUBS gf180mcu_as_sc_mcu7t3v3__inv_2
Xgf180mcu_as_sc_mcu7t3v3__inv_2_1388 VSS VSS gf180mcu_as_sc_mcu7t3v3__inv_2_1398/Y
+ VSS gf180mcu_as_sc_mcu7t3v3__inv_2_1388/VNW VSUBS gf180mcu_as_sc_mcu7t3v3__inv_2
Xgf180mcu_as_sc_mcu7t3v3__inv_2_1377 VSS gf180mcu_as_sc_mcu7t3v3__inv_2_1378/VDD gf180mcu_as_sc_mcu7t3v3__inv_2_1379/Y
+ VSS gf180mcu_as_sc_mcu7t3v3__inv_2_1377/VNW VSUBS gf180mcu_as_sc_mcu7t3v3__inv_2
Xgf180mcu_as_sc_mcu7t3v3__inv_2_1366 gf180mcu_as_sc_mcu7t3v3__inv_2_1397/VSS VSS gf180mcu_as_sc_mcu7t3v3__inv_2_1398/Y
+ VSS gf180mcu_as_sc_mcu7t3v3__inv_2_1366/VNW VSUBS gf180mcu_as_sc_mcu7t3v3__inv_2
Xgf180mcu_as_sc_mcu7t3v3__inv_2_1355 gf180mcu_as_sc_mcu7t3v3__inv_2_1393/VDD gf180mcu_as_sc_mcu7t3v3__inv_2_1394/VDD
+ VSS gf180mcu_as_sc_mcu7t3v3__inv_2_1398/Y gf180mcu_as_sc_mcu7t3v3__inv_2_1393/VNW
+ VSUBS gf180mcu_as_sc_mcu7t3v3__inv_2
Xgf180mcu_as_sc_mcu7t3v3__inv_2_817 VSS VSS gf180mcu_as_sc_mcu7t3v3__inv_2_817/Y VSS
+ gf180mcu_as_sc_mcu7t3v3__inv_2_833/VNW VSUBS gf180mcu_as_sc_mcu7t3v3__inv_2
Xgf180mcu_as_sc_mcu7t3v3__inv_2_806 VSS VSS gf180mcu_as_sc_mcu7t3v3__inv_2_806/Y VSS
+ gf180mcu_as_sc_mcu7t3v3__inv_2_808/VNW VSUBS gf180mcu_as_sc_mcu7t3v3__inv_2
Xgf180mcu_as_sc_mcu7t3v3__inv_2_839 VSS VSS VSS VSS gf180mcu_as_sc_mcu7t3v3__inv_2_840/VNW
+ VSUBS gf180mcu_as_sc_mcu7t3v3__inv_2
Xgf180mcu_as_sc_mcu7t3v3__inv_2_828 VSS VSS gf180mcu_as_sc_mcu7t3v3__inv_2_828/Y VSS
+ gf180mcu_as_sc_mcu7t3v3__inv_2_828/VNW VSUBS gf180mcu_as_sc_mcu7t3v3__inv_2
Xgf180mcu_as_sc_mcu7t3v3__nand4_2_127 VSS VSS VSS VSS VSS VSS gf180mcu_as_sc_mcu7t3v3__nand4_2_127/Y
+ gf180mcu_as_sc_mcu7t3v3__inv_2_398/VNW VSUBS gf180mcu_as_sc_mcu7t3v3__nand4_2
Xgf180mcu_as_sc_mcu7t3v3__nand4_2_138 VSS VSS VSS VSS VSS VSS VSS gf180mcu_as_sc_mcu7t3v3__inv_2_538/VNW
+ VSUBS gf180mcu_as_sc_mcu7t3v3__nand4_2
Xgf180mcu_as_sc_mcu7t3v3__nand4_2_149 VSS VSS VSS VSS VSS VSS VSS gf180mcu_as_sc_mcu7t3v3__inv_2_535/VNW
+ VSUBS gf180mcu_as_sc_mcu7t3v3__nand4_2
Xgf180mcu_as_sc_mcu7t3v3__nand4_2_116 gf180mcu_as_sc_mcu7t3v3__inv_2_341/VDD VSS VSS
+ VSS VSS VSS VSS gf180mcu_as_sc_mcu7t3v3__inv_2_341/VNW VSUBS gf180mcu_as_sc_mcu7t3v3__nand4_2
Xgf180mcu_as_sc_mcu7t3v3__nand4_2_105 VSS gf180mcu_as_sc_mcu7t3v3__inv_2_337/VDD VSS
+ VSS VSS VSS VSS gf180mcu_as_sc_mcu7t3v3__inv_2_336/VNW VSUBS gf180mcu_as_sc_mcu7t3v3__nand4_2
Xgf180mcu_as_sc_mcu7t3v3__nand4_2_44 VSS gf180mcu_as_sc_mcu7t3v3__inv_2_99/VDD VSS
+ VSS VSS VSS gf180mcu_as_sc_mcu7t3v3__nand4_2_44/Y gf180mcu_as_sc_mcu7t3v3__inv_2_150/VNW
+ VSUBS gf180mcu_as_sc_mcu7t3v3__nand4_2
Xgf180mcu_as_sc_mcu7t3v3__nand4_2_33 gf180mcu_as_sc_mcu7t3v3__inv_2_96/VDD gf180mcu_as_sc_mcu7t3v3__inv_2_96/VDD
+ VSS VSS VSS VSS VSS gf180mcu_as_sc_mcu7t3v3__inv_2_84/VNW VSUBS gf180mcu_as_sc_mcu7t3v3__nand4_2
Xgf180mcu_as_sc_mcu7t3v3__nand4_2_11 gf180mcu_as_sc_mcu7t3v3__inv_2_77/VDD gf180mcu_as_sc_mcu7t3v3__inv_2_77/VSS
+ VSS VSS VSS VSS VSS gf180mcu_as_sc_mcu7t3v3__inv_2_77/VNW VSUBS gf180mcu_as_sc_mcu7t3v3__nand4_2
Xgf180mcu_as_sc_mcu7t3v3__nand4_2_22 gf180mcu_as_sc_mcu7t3v3__inv_2_70/VDD gf180mcu_as_sc_mcu7t3v3__inv_2_71/VDD
+ VSS VSS VSS VSS VSS gf180mcu_as_sc_mcu7t3v3__inv_2_70/VNW VSUBS gf180mcu_as_sc_mcu7t3v3__nand4_2
Xgf180mcu_as_sc_mcu7t3v3__nand4_2_88 gf180mcu_as_sc_mcu7t3v3__inv_2_363/VDD gf180mcu_as_sc_mcu7t3v3__inv_2_364/VDD
+ VSS VSS VSS VSS VSS gf180mcu_as_sc_mcu7t3v3__inv_2_363/VNW VSUBS gf180mcu_as_sc_mcu7t3v3__nand4_2
Xgf180mcu_as_sc_mcu7t3v3__nand4_2_66 gf180mcu_as_sc_mcu7t3v3__inv_2_196/VSS gf180mcu_as_sc_mcu7t3v3__inv_2_165/VDD
+ VSS VSS VSS VSS gf180mcu_as_sc_mcu7t3v3__nand4_2_66/Y gf180mcu_as_sc_mcu7t3v3__inv_2_161/VNW
+ VSUBS gf180mcu_as_sc_mcu7t3v3__nand4_2
Xgf180mcu_as_sc_mcu7t3v3__nand4_2_99 gf180mcu_as_sc_mcu7t3v3__inv_2_359/VDD gf180mcu_as_sc_mcu7t3v3__inv_2_360/VDD
+ VSS VSS VSS VSS VSS gf180mcu_as_sc_mcu7t3v3__inv_2_359/VNW VSUBS gf180mcu_as_sc_mcu7t3v3__nand4_2
Xgf180mcu_as_sc_mcu7t3v3__nand4_2_55 VSS gf180mcu_as_sc_mcu7t3v3__inv_2_220/VDD VSS
+ VSS VSS VSS gf180mcu_as_sc_mcu7t3v3__nand4_2_55/Y gf180mcu_as_sc_mcu7t3v3__inv_2_216/VNW
+ VSUBS gf180mcu_as_sc_mcu7t3v3__nand4_2
Xgf180mcu_as_sc_mcu7t3v3__nand4_2_77 VSS VSS VSS VSS VSS VSS VSS gf180mcu_as_sc_mcu7t3v3__inv_2_256/VNW
+ VSUBS gf180mcu_as_sc_mcu7t3v3__nand4_2
Xu_t025_021 u_t025_021/c0_w0_bl u_t025_021/c0_w0_br u_t025_021/c0_w1_bl u_t025_021/c0_w1_br
+ u_t025_021/c0_r0_rbl u_t025_021/c0_r1_rbl u_t025_021/c1_w0_bl u_t025_021/c1_w0_br
+ u_t025_021/c1_w1_bl u_t025_021/c1_w1_br u_t025_021/c1_r0_rbl u_t025_021/c1_r1_rbl
+ u_t025_021/c2_w0_bl u_t025_021/c2_w0_br u_t025_021/c2_w1_bl u_t025_021/c2_w1_br
+ u_t025_021/c2_r0_rbl u_t025_021/c2_r1_rbl u_t025_021/c3_w0_bl u_t025_021/c3_w0_br
+ u_t025_021/c3_w1_bl u_t025_021/c3_w1_br u_t025_021/c3_r0_rbl u_t025_021/c3_r1_rbl
+ u_t025_021/r0_w0_wl u_t025_021/r0_w1_wl u_t025_021/r0_r0_rwl u_t025_021/r0_r1_rwl
+ u_t025_021/r1_w0_wl u_t025_021/r1_w1_wl u_t025_021/r1_r0_rwl u_t025_021/r1_r1_rwl
+ u_t025_021/r2_w0_wl u_t025_021/r2_w1_wl u_t025_021/r2_r0_rwl u_t025_021/r2_r1_rwl
+ u_t025_021/r3_w0_wl u_t025_021/r3_w1_wl u_t025_021/r3_r0_rwl u_t025_021/r3_r1_rwl
+ u_t025_021/VDD u_t025_031/VSS VSUBS detronyx_12t_2w2r_rc4_4x4_routed_5layer_direct
Xu_t025_010 u_t025_010/c0_w0_bl u_t025_010/c0_w0_br u_t025_010/c0_w1_bl u_t025_010/c0_w1_br
+ u_t025_010/c0_r0_rbl u_t025_010/c0_r1_rbl u_t025_010/c1_w0_bl u_t025_010/c1_w0_br
+ u_t025_010/c1_w1_bl u_t025_010/c1_w1_br u_t025_010/c1_r0_rbl u_t025_010/c1_r1_rbl
+ u_t025_010/c2_w0_bl u_t025_010/c2_w0_br u_t025_010/c2_w1_bl u_t025_010/c2_w1_br
+ u_t025_010/c2_r0_rbl u_t025_010/c2_r1_rbl u_t025_010/c3_w0_bl u_t025_010/c3_w0_br
+ u_t025_010/c3_w1_bl u_t025_010/c3_w1_br u_t025_010/c3_r0_rbl u_t025_010/c3_r1_rbl
+ u_t025_010/r0_w0_wl u_t025_010/r0_w1_wl u_t025_010/r0_r0_rwl u_t025_010/r0_r1_rwl
+ u_t025_010/r1_w0_wl u_t025_010/r1_w1_wl u_t025_010/r1_r0_rwl u_t025_010/r1_r1_rwl
+ u_t025_010/r2_w0_wl u_t025_010/r2_w1_wl u_t025_010/r2_r0_rwl u_t025_010/r2_r1_rwl
+ u_t025_010/r3_w0_wl u_t025_010/r3_w1_wl u_t025_010/r3_r0_rwl u_t025_010/r3_r1_rwl
+ VSS u_t025_031/VSS VSUBS detronyx_12t_2w2r_rc4_4x4_routed_5layer_direct
Xgf180mcu_as_sc_mcu7t3v3__inv_2_1130 gf180mcu_as_sc_mcu7t3v3__inv_2_1132/VDD gf180mcu_as_sc_mcu7t3v3__inv_2_1135/VDD
+ VSS VSS gf180mcu_as_sc_mcu7t3v3__inv_2_1132/VNW VSUBS gf180mcu_as_sc_mcu7t3v3__inv_2
Xgf180mcu_as_sc_mcu7t3v3__inv_2_1141 gf180mcu_as_sc_mcu7t3v3__inv_2_1141/VDD gf180mcu_as_sc_mcu7t3v3__inv_2_1143/VDD
+ gf180mcu_as_sc_mcu7t3v3__inv_2_1141/Y VSS gf180mcu_as_sc_mcu7t3v3__inv_2_1141/VNW
+ VSUBS gf180mcu_as_sc_mcu7t3v3__inv_2
Xgf180mcu_as_sc_mcu7t3v3__inv_2_1152 VSS VSS VSS VSS gf180mcu_as_sc_mcu7t3v3__inv_2_1156/VNW
+ VSUBS gf180mcu_as_sc_mcu7t3v3__inv_2
Xgf180mcu_as_sc_mcu7t3v3__inv_2_1163 VSS VSS VSS VSS gf180mcu_as_sc_mcu7t3v3__inv_2_1195/VNW
+ VSUBS gf180mcu_as_sc_mcu7t3v3__inv_2
Xgf180mcu_as_sc_mcu7t3v3__inv_2_1174 VSS VSS VSS VSS gf180mcu_as_sc_mcu7t3v3__inv_2_1178/VNW
+ VSUBS gf180mcu_as_sc_mcu7t3v3__inv_2
Xgf180mcu_as_sc_mcu7t3v3__inv_2_1185 VSS VSS VSS VSS gf180mcu_as_sc_mcu7t3v3__inv_2_1186/VNW
+ VSUBS gf180mcu_as_sc_mcu7t3v3__inv_2
Xgf180mcu_as_sc_mcu7t3v3__inv_2_1196 VSS VSS VSS VSS gf180mcu_as_sc_mcu7t3v3__inv_2_1197/VNW
+ VSUBS gf180mcu_as_sc_mcu7t3v3__inv_2
Xu_t016_021 u_t016_021/c0_w0_bl u_t016_021/c0_w0_br u_t016_021/c0_w1_bl u_t016_021/c0_w1_br
+ u_t016_021/c0_r0_rbl u_t016_021/c0_r1_rbl u_t016_021/c1_w0_bl u_t016_021/c1_w0_br
+ u_t016_021/c1_w1_bl u_t016_021/c1_w1_br u_t016_021/c1_r0_rbl u_t016_021/c1_r1_rbl
+ u_t016_021/c2_w0_bl u_t016_021/c2_w0_br u_t016_021/c2_w1_bl u_t016_021/c2_w1_br
+ u_t016_021/c2_r0_rbl u_t016_021/c2_r1_rbl u_t016_021/c3_w0_bl u_t016_021/c3_w0_br
+ u_t016_021/c3_w1_bl u_t016_021/c3_w1_br u_t016_021/c3_r0_rbl u_t016_021/c3_r1_rbl
+ u_t016_021/r0_w0_wl u_t016_021/r0_w1_wl u_t016_021/r0_r0_rwl u_t016_021/r0_r1_rwl
+ u_t016_021/r1_w0_wl u_t016_021/r1_w1_wl u_t016_021/r1_r0_rwl u_t016_021/r1_r1_rwl
+ u_t016_021/r2_w0_wl u_t016_021/r2_w1_wl u_t016_021/r2_r0_rwl u_t016_021/r2_r1_rwl
+ u_t016_021/r3_w0_wl u_t016_021/r3_w1_wl u_t016_021/r3_r0_rwl u_t016_021/r3_r1_rwl
+ u_t016_021/VDD u_t016_024/VSS VSUBS detronyx_12t_2w2r_rc4_4x4_routed_5layer_direct
Xu_t016_010 u_t016_010/c0_w0_bl u_t016_010/c0_w0_br u_t016_010/c0_w1_bl u_t016_010/c0_w1_br
+ u_t016_010/c0_r0_rbl u_t016_010/c0_r1_rbl u_t016_010/c1_w0_bl u_t016_010/c1_w0_br
+ u_t016_010/c1_w1_bl u_t016_010/c1_w1_br u_t016_010/c1_r0_rbl u_t016_010/c1_r1_rbl
+ u_t016_010/c2_w0_bl u_t016_010/c2_w0_br u_t016_010/c2_w1_bl u_t016_010/c2_w1_br
+ u_t016_010/c2_r0_rbl u_t016_010/c2_r1_rbl u_t016_010/c3_w0_bl u_t016_010/c3_w0_br
+ u_t016_010/c3_w1_bl u_t016_010/c3_w1_br u_t016_010/c3_r0_rbl u_t016_010/c3_r1_rbl
+ u_t016_010/r0_w0_wl u_t016_010/r0_w1_wl u_t016_010/r0_r0_rwl u_t016_010/r0_r1_rwl
+ u_t016_010/r1_w0_wl u_t016_010/r1_w1_wl u_t016_010/r1_r0_rwl u_t016_010/r1_r1_rwl
+ u_t016_010/r2_w0_wl u_t016_010/r2_w1_wl u_t016_010/r2_r0_rwl u_t016_010/r2_r1_rwl
+ u_t016_010/r3_w0_wl u_t016_010/r3_w1_wl u_t016_010/r3_r0_rwl u_t016_010/r3_r1_rwl
+ VSS u_t016_010/VSS VSUBS detronyx_12t_2w2r_rc4_4x4_routed_5layer_direct
Xgf180mcu_as_sc_mcu7t3v3__inv_2_636 gf180mcu_as_sc_mcu7t3v3__inv_2_636/VSS gf180mcu_as_sc_mcu7t3v3__inv_2_636/VSS
+ gf180mcu_as_sc_mcu7t3v3__inv_2_636/Y VSS gf180mcu_as_sc_mcu7t3v3__inv_2_636/VNW
+ VSUBS gf180mcu_as_sc_mcu7t3v3__inv_2
Xgf180mcu_as_sc_mcu7t3v3__inv_2_625 gf180mcu_as_sc_mcu7t3v3__inv_2_629/VDD gf180mcu_as_sc_mcu7t3v3__inv_2_629/VDD
+ gf180mcu_as_sc_mcu7t3v3__inv_2_625/Y VSS gf180mcu_as_sc_mcu7t3v3__inv_2_625/VNW
+ VSUBS gf180mcu_as_sc_mcu7t3v3__inv_2
Xgf180mcu_as_sc_mcu7t3v3__inv_2_614 gf180mcu_as_sc_mcu7t3v3__inv_2_616/VDD gf180mcu_as_sc_mcu7t3v3__inv_2_620/VDD
+ gf180mcu_as_sc_mcu7t3v3__inv_2_614/Y gf180mcu_as_sc_mcu7t3v3__inv_2_618/A gf180mcu_as_sc_mcu7t3v3__inv_2_616/VNW
+ VSUBS gf180mcu_as_sc_mcu7t3v3__inv_2
Xgf180mcu_as_sc_mcu7t3v3__inv_2_603 gf180mcu_as_sc_mcu7t3v3__inv_2_630/VDD gf180mcu_as_sc_mcu7t3v3__inv_2_630/VSS
+ gf180mcu_as_sc_mcu7t3v3__inv_2_603/Y gf180mcu_as_sc_mcu7t3v3__inv_2_604/Y gf180mcu_as_sc_mcu7t3v3__inv_2_630/VNW
+ VSUBS gf180mcu_as_sc_mcu7t3v3__inv_2
Xu_t031_024 u_t031_024/c0_w0_bl u_t031_024/c0_w0_br u_t031_024/c0_w1_bl u_t031_024/c0_w1_br
+ u_t031_024/c0_r0_rbl u_t031_024/c0_r1_rbl u_t031_024/c1_w0_bl u_t031_024/c1_w0_br
+ u_t031_024/c1_w1_bl u_t031_024/c1_w1_br u_t031_024/c1_r0_rbl u_t031_024/c1_r1_rbl
+ u_t031_024/c2_w0_bl u_t031_024/c2_w0_br u_t031_024/c2_w1_bl u_t031_024/c2_w1_br
+ u_t031_024/c2_r0_rbl u_t031_024/c2_r1_rbl u_t031_024/c3_w0_bl u_t031_024/c3_w0_br
+ u_t031_024/c3_w1_bl u_t031_024/c3_w1_br u_t031_024/c3_r0_rbl u_t031_024/c3_r1_rbl
+ u_t031_024/r0_w0_wl u_t031_024/r0_w1_wl u_t031_024/r0_r0_rwl u_t031_024/r0_r1_rwl
+ u_t031_024/r1_w0_wl u_t031_024/r1_w1_wl u_t031_024/r1_r0_rwl u_t031_024/r1_r1_rwl
+ u_t031_024/r2_w0_wl u_t031_024/r2_w1_wl u_t031_024/r2_r0_rwl u_t031_024/r2_r1_rwl
+ u_t031_024/r3_w0_wl u_t031_024/r3_w1_wl u_t031_024/r3_r0_rwl u_t031_024/r3_r1_rwl
+ VSS u_t031_024/VSS VSUBS detronyx_12t_2w2r_rc4_4x4_routed_5layer_direct
Xu_t031_013 u_t031_013/c0_w0_bl u_t031_013/c0_w0_br u_t031_013/c0_w1_bl u_t031_013/c0_w1_br
+ u_t031_013/c0_r0_rbl u_t031_013/c0_r1_rbl u_t031_013/c1_w0_bl u_t031_013/c1_w0_br
+ u_t031_013/c1_w1_bl u_t031_013/c1_w1_br u_t031_013/c1_r0_rbl u_t031_013/c1_r1_rbl
+ u_t031_013/c2_w0_bl u_t031_013/c2_w0_br u_t031_013/c2_w1_bl u_t031_013/c2_w1_br
+ u_t031_013/c2_r0_rbl u_t031_013/c2_r1_rbl u_t031_013/c3_w0_bl u_t031_013/c3_w0_br
+ u_t031_013/c3_w1_bl u_t031_013/c3_w1_br u_t031_013/c3_r0_rbl u_t031_013/c3_r1_rbl
+ u_t031_013/r0_w0_wl u_t031_013/r0_w1_wl u_t031_013/r0_r0_rwl u_t031_013/r0_r1_rwl
+ u_t031_013/r1_w0_wl u_t031_013/r1_w1_wl u_t031_013/r1_r0_rwl u_t031_013/r1_r1_rwl
+ u_t031_013/r2_w0_wl u_t031_013/r2_w1_wl u_t031_013/r2_r0_rwl u_t031_013/r2_r1_rwl
+ u_t031_013/r3_w0_wl u_t031_013/r3_w1_wl u_t031_013/r3_r0_rwl u_t031_013/r3_r1_rwl
+ u_t031_013/VDD u_t031_013/VSS VSUBS detronyx_12t_2w2r_rc4_4x4_routed_5layer_direct
Xu_t031_002 u_t031_002/c0_w0_bl u_t031_002/c0_w0_br u_t031_002/c0_w1_bl u_t031_002/c0_w1_br
+ u_t031_002/c0_r0_rbl u_t031_002/c0_r1_rbl u_t031_002/c1_w0_bl u_t031_002/c1_w0_br
+ u_t031_002/c1_w1_bl u_t031_002/c1_w1_br u_t031_002/c1_r0_rbl u_t031_002/c1_r1_rbl
+ u_t031_002/c2_w0_bl u_t031_002/c2_w0_br u_t031_002/c2_w1_bl u_t031_002/c2_w1_br
+ u_t031_002/c2_r0_rbl u_t031_002/c2_r1_rbl u_t031_002/c3_w0_bl u_t031_002/c3_w0_br
+ u_t031_002/c3_w1_bl u_t031_002/c3_w1_br u_t031_002/c3_r0_rbl u_t031_002/c3_r1_rbl
+ u_t031_002/r0_w0_wl u_t031_002/r0_w1_wl u_t031_002/r0_r0_rwl u_t031_002/r0_r1_rwl
+ u_t031_002/r1_w0_wl u_t031_002/r1_w1_wl u_t031_002/r1_r0_rwl u_t031_002/r1_r1_rwl
+ u_t031_002/r2_w0_wl u_t031_002/r2_w1_wl u_t031_002/r2_r0_rwl u_t031_002/r2_r1_rwl
+ u_t031_002/r3_w0_wl u_t031_002/r3_w1_wl u_t031_002/r3_r0_rwl u_t031_002/r3_r1_rwl
+ VSS u_t031_002/VSS VSUBS detronyx_12t_2w2r_rc4_4x4_routed_5layer_direct
Xgf180mcu_as_sc_mcu7t3v3__inv_2_669 gf180mcu_as_sc_mcu7t3v3__inv_2_671/VDD VSS gf180mcu_as_sc_mcu7t3v3__inv_2_669/Y
+ gf180mcu_as_sc_mcu7t3v3__inv_2_848/Y gf180mcu_as_sc_mcu7t3v3__inv_2_671/VNW VSUBS
+ gf180mcu_as_sc_mcu7t3v3__inv_2
Xgf180mcu_as_sc_mcu7t3v3__inv_2_658 gf180mcu_as_sc_mcu7t3v3__inv_2_659/VDD gf180mcu_as_sc_mcu7t3v3__inv_2_663/VDD
+ gf180mcu_as_sc_mcu7t3v3__inv_2_658/Y gf180mcu_as_sc_mcu7t3v3__inv_2_659/Y gf180mcu_as_sc_mcu7t3v3__inv_2_659/VNW
+ VSUBS gf180mcu_as_sc_mcu7t3v3__inv_2
Xgf180mcu_as_sc_mcu7t3v3__inv_2_647 gf180mcu_as_sc_mcu7t3v3__inv_2_647/VDD gf180mcu_as_sc_mcu7t3v3__inv_2_651/VDD
+ gf180mcu_as_sc_mcu7t3v3__inv_2_647/Y VSS gf180mcu_as_sc_mcu7t3v3__inv_2_647/VNW
+ VSUBS gf180mcu_as_sc_mcu7t3v3__inv_2
Xu_t022_024 u_t022_024/c0_w0_bl u_t022_024/c0_w0_br u_t022_024/c0_w1_bl u_t022_024/c0_w1_br
+ u_t022_024/c0_r0_rbl u_t022_024/c0_r1_rbl u_t022_024/c1_w0_bl u_t022_024/c1_w0_br
+ u_t022_024/c1_w1_bl u_t022_024/c1_w1_br u_t022_024/c1_r0_rbl u_t022_024/c1_r1_rbl
+ u_t022_024/c2_w0_bl u_t022_024/c2_w0_br u_t022_024/c2_w1_bl u_t022_024/c2_w1_br
+ u_t022_024/c2_r0_rbl u_t022_024/c2_r1_rbl u_t022_024/c3_w0_bl u_t022_024/c3_w0_br
+ u_t022_024/c3_w1_bl u_t022_024/c3_w1_br u_t022_024/c3_r0_rbl u_t022_024/c3_r1_rbl
+ u_t022_024/r0_w0_wl u_t022_024/r0_w1_wl u_t022_024/r0_r0_rwl u_t022_024/r0_r1_rwl
+ u_t022_024/r1_w0_wl u_t022_024/r1_w1_wl u_t022_024/r1_r0_rwl u_t022_024/r1_r1_rwl
+ u_t022_024/r2_w0_wl u_t022_024/r2_w1_wl u_t022_024/r2_r0_rwl u_t022_024/r2_r1_rwl
+ u_t022_024/r3_w0_wl u_t022_024/r3_w1_wl u_t022_024/r3_r0_rwl u_t022_024/r3_r1_rwl
+ VSS u_t022_031/VSS VSUBS detronyx_12t_2w2r_rc4_4x4_routed_5layer_direct
Xu_t007_021 u_t007_021/c0_w0_bl u_t007_021/c0_w0_br u_t007_021/c0_w1_bl u_t007_021/c0_w1_br
+ u_t007_021/c0_r0_rbl u_t007_021/c0_r1_rbl u_t007_021/c1_w0_bl u_t007_021/c1_w0_br
+ u_t007_021/c1_w1_bl u_t007_021/c1_w1_br u_t007_021/c1_r0_rbl u_t007_021/c1_r1_rbl
+ u_t007_021/c2_w0_bl u_t007_021/c2_w0_br u_t007_021/c2_w1_bl u_t007_021/c2_w1_br
+ u_t007_021/c2_r0_rbl u_t007_021/c2_r1_rbl u_t007_021/c3_w0_bl u_t007_021/c3_w0_br
+ u_t007_021/c3_w1_bl u_t007_021/c3_w1_br u_t007_021/c3_r0_rbl u_t007_021/c3_r1_rbl
+ u_t007_021/r0_w0_wl u_t007_021/r0_w1_wl u_t007_021/r0_r0_rwl u_t007_021/r0_r1_rwl
+ u_t007_021/r1_w0_wl u_t007_021/r1_w1_wl u_t007_021/r1_r0_rwl u_t007_021/r1_r1_rwl
+ u_t007_021/r2_w0_wl u_t007_021/r2_w1_wl u_t007_021/r2_r0_rwl u_t007_021/r2_r1_rwl
+ u_t007_021/r3_w0_wl u_t007_021/r3_w1_wl u_t007_021/r3_r0_rwl u_t007_021/r3_r1_rwl
+ u_t008_021/VDD u_t007_024/VSS VSUBS detronyx_12t_2w2r_rc4_4x4_routed_5layer_direct
Xu_t022_013 u_t022_013/c0_w0_bl u_t022_013/c0_w0_br u_t022_013/c0_w1_bl u_t022_013/c0_w1_br
+ u_t022_013/c0_r0_rbl u_t022_013/c0_r1_rbl u_t022_013/c1_w0_bl u_t022_013/c1_w0_br
+ u_t022_013/c1_w1_bl u_t022_013/c1_w1_br u_t022_013/c1_r0_rbl u_t022_013/c1_r1_rbl
+ u_t022_013/c2_w0_bl u_t022_013/c2_w0_br u_t022_013/c2_w1_bl u_t022_013/c2_w1_br
+ u_t022_013/c2_r0_rbl u_t022_013/c2_r1_rbl u_t022_013/c3_w0_bl u_t022_013/c3_w0_br
+ u_t022_013/c3_w1_bl u_t022_013/c3_w1_br u_t022_013/c3_r0_rbl u_t022_013/c3_r1_rbl
+ u_t022_013/r0_w0_wl u_t022_013/r0_w1_wl u_t022_013/r0_r0_rwl u_t022_013/r0_r1_rwl
+ u_t022_013/r1_w0_wl u_t022_013/r1_w1_wl u_t022_013/r1_r0_rwl u_t022_013/r1_r1_rwl
+ u_t022_013/r2_w0_wl u_t022_013/r2_w1_wl u_t022_013/r2_r0_rwl u_t022_013/r2_r1_rwl
+ u_t022_013/r3_w0_wl u_t022_013/r3_w1_wl u_t022_013/r3_r0_rwl u_t022_013/r3_r1_rwl
+ u_t022_013/VDD u_t022_031/VSS VSUBS detronyx_12t_2w2r_rc4_4x4_routed_5layer_direct
Xu_t007_010 u_t007_010/c0_w0_bl u_t007_010/c0_w0_br u_t007_010/c0_w1_bl u_t007_010/c0_w1_br
+ u_t007_010/c0_r0_rbl u_t007_010/c0_r1_rbl u_t007_010/c1_w0_bl u_t007_010/c1_w0_br
+ u_t007_010/c1_w1_bl u_t007_010/c1_w1_br u_t007_010/c1_r0_rbl u_t007_010/c1_r1_rbl
+ u_t007_010/c2_w0_bl u_t007_010/c2_w0_br u_t007_010/c2_w1_bl u_t007_010/c2_w1_br
+ u_t007_010/c2_r0_rbl u_t007_010/c2_r1_rbl u_t007_010/c3_w0_bl u_t007_010/c3_w0_br
+ u_t007_010/c3_w1_bl u_t007_010/c3_w1_br u_t007_010/c3_r0_rbl u_t007_010/c3_r1_rbl
+ u_t007_010/r0_w0_wl u_t007_010/r0_w1_wl u_t007_010/r0_r0_rwl u_t007_010/r0_r1_rwl
+ u_t007_010/r1_w0_wl u_t007_010/r1_w1_wl u_t007_010/r1_r0_rwl u_t007_010/r1_r1_rwl
+ u_t007_010/r2_w0_wl u_t007_010/r2_w1_wl u_t007_010/r2_r0_rwl u_t007_010/r2_r1_rwl
+ u_t007_010/r3_w0_wl u_t007_010/r3_w1_wl u_t007_010/r3_r0_rwl u_t007_010/r3_r1_rwl
+ VSS u_t007_010/VSS VSUBS detronyx_12t_2w2r_rc4_4x4_routed_5layer_direct
Xu_t022_002 u_t022_002/c0_w0_bl u_t022_002/c0_w0_br u_t022_002/c0_w1_bl u_t022_002/c0_w1_br
+ u_t022_002/c0_r0_rbl u_t022_002/c0_r1_rbl u_t022_002/c1_w0_bl u_t022_002/c1_w0_br
+ u_t022_002/c1_w1_bl u_t022_002/c1_w1_br u_t022_002/c1_r0_rbl u_t022_002/c1_r1_rbl
+ u_t022_002/c2_w0_bl u_t022_002/c2_w0_br u_t022_002/c2_w1_bl u_t022_002/c2_w1_br
+ u_t022_002/c2_r0_rbl u_t022_002/c2_r1_rbl u_t022_002/c3_w0_bl u_t022_002/c3_w0_br
+ u_t022_002/c3_w1_bl u_t022_002/c3_w1_br u_t022_002/c3_r0_rbl u_t022_002/c3_r1_rbl
+ u_t022_002/r0_w0_wl u_t022_002/r0_w1_wl u_t022_002/r0_r0_rwl u_t022_002/r0_r1_rwl
+ u_t022_002/r1_w0_wl u_t022_002/r1_w1_wl u_t022_002/r1_r0_rwl u_t022_002/r1_r1_rwl
+ u_t022_002/r2_w0_wl u_t022_002/r2_w1_wl u_t022_002/r2_r0_rwl u_t022_002/r2_r1_rwl
+ u_t022_002/r3_w0_wl u_t022_002/r3_w1_wl u_t022_002/r3_r0_rwl u_t022_002/r3_r1_rwl
+ VSS u_t022_031/VSS VSUBS detronyx_12t_2w2r_rc4_4x4_routed_5layer_direct
Xgf180mcu_as_sc_mcu7t3v3__nand4_2_480 gf180mcu_as_sc_mcu7t3v3__inv_2_1667/VSS VSS
+ VSS VSS VSS VSS VSS gf180mcu_as_sc_mcu7t3v3__inv_2_1651/VNW VSUBS gf180mcu_as_sc_mcu7t3v3__nand4_2
Xgf180mcu_as_sc_mcu7t3v3__nand4_2_491 VSS gf180mcu_as_sc_mcu7t3v3__inv_2_1663/VDD
+ VSS VSS VSS VSS VSS gf180mcu_as_sc_mcu7t3v3__inv_2_1662/VNW VSUBS gf180mcu_as_sc_mcu7t3v3__nand4_2
Xu_t013_024 u_t013_024/c0_w0_bl u_t013_024/c0_w0_br u_t013_024/c0_w1_bl u_t013_024/c0_w1_br
+ u_t013_024/c0_r0_rbl u_t013_024/c0_r1_rbl u_t013_024/c1_w0_bl u_t013_024/c1_w0_br
+ u_t013_024/c1_w1_bl u_t013_024/c1_w1_br u_t013_024/c1_r0_rbl u_t013_024/c1_r1_rbl
+ u_t013_024/c2_w0_bl u_t013_024/c2_w0_br u_t013_024/c2_w1_bl u_t013_024/c2_w1_br
+ u_t013_024/c2_r0_rbl u_t013_024/c2_r1_rbl u_t013_024/c3_w0_bl u_t013_024/c3_w0_br
+ u_t013_024/c3_w1_bl u_t013_024/c3_w1_br u_t013_024/c3_r0_rbl u_t013_024/c3_r1_rbl
+ u_t013_024/r0_w0_wl u_t013_024/r0_w1_wl u_t013_024/r0_r0_rwl u_t013_024/r0_r1_rwl
+ u_t013_024/r1_w0_wl u_t013_024/r1_w1_wl u_t013_024/r1_r0_rwl u_t013_024/r1_r1_rwl
+ u_t013_024/r2_w0_wl u_t013_024/r2_w1_wl u_t013_024/r2_r0_rwl u_t013_024/r2_r1_rwl
+ u_t013_024/r3_w0_wl u_t013_024/r3_w1_wl u_t013_024/r3_r0_rwl u_t013_024/r3_r1_rwl
+ VSS u_t013_031/VSS VSUBS detronyx_12t_2w2r_rc4_4x4_routed_5layer_direct
Xu_t013_013 u_t013_013/c0_w0_bl u_t013_013/c0_w0_br u_t013_013/c0_w1_bl u_t013_013/c0_w1_br
+ u_t013_013/c0_r0_rbl u_t013_013/c0_r1_rbl u_t013_013/c1_w0_bl u_t013_013/c1_w0_br
+ u_t013_013/c1_w1_bl u_t013_013/c1_w1_br u_t013_013/c1_r0_rbl u_t013_013/c1_r1_rbl
+ u_t013_013/c2_w0_bl u_t013_013/c2_w0_br u_t013_013/c2_w1_bl u_t013_013/c2_w1_br
+ u_t013_013/c2_r0_rbl u_t013_013/c2_r1_rbl u_t013_013/c3_w0_bl u_t013_013/c3_w0_br
+ u_t013_013/c3_w1_bl u_t013_013/c3_w1_br u_t013_013/c3_r0_rbl u_t013_013/c3_r1_rbl
+ u_t013_013/r0_w0_wl u_t013_013/r0_w1_wl u_t013_013/r0_r0_rwl u_t013_013/r0_r1_rwl
+ u_t013_013/r1_w0_wl u_t013_013/r1_w1_wl u_t013_013/r1_r0_rwl u_t013_013/r1_r1_rwl
+ u_t013_013/r2_w0_wl u_t013_013/r2_w1_wl u_t013_013/r2_r0_rwl u_t013_013/r2_r1_rwl
+ u_t013_013/r3_w0_wl u_t013_013/r3_w1_wl u_t013_013/r3_r0_rwl u_t013_013/r3_r1_rwl
+ u_t013_013/VDD u_t013_031/VSS VSUBS detronyx_12t_2w2r_rc4_4x4_routed_5layer_direct
Xu_t013_002 u_t013_002/c0_w0_bl u_t013_002/c0_w0_br u_t013_002/c0_w1_bl u_t013_002/c0_w1_br
+ u_t013_002/c0_r0_rbl u_t013_002/c0_r1_rbl u_t013_002/c1_w0_bl u_t013_002/c1_w0_br
+ u_t013_002/c1_w1_bl u_t013_002/c1_w1_br u_t013_002/c1_r0_rbl u_t013_002/c1_r1_rbl
+ u_t013_002/c2_w0_bl u_t013_002/c2_w0_br u_t013_002/c2_w1_bl u_t013_002/c2_w1_br
+ u_t013_002/c2_r0_rbl u_t013_002/c2_r1_rbl u_t013_002/c3_w0_bl u_t013_002/c3_w0_br
+ u_t013_002/c3_w1_bl u_t013_002/c3_w1_br u_t013_002/c3_r0_rbl u_t013_002/c3_r1_rbl
+ u_t013_002/r0_w0_wl u_t013_002/r0_w1_wl u_t013_002/r0_r0_rwl u_t013_002/r0_r1_rwl
+ u_t013_002/r1_w0_wl u_t013_002/r1_w1_wl u_t013_002/r1_r0_rwl u_t013_002/r1_r1_rwl
+ u_t013_002/r2_w0_wl u_t013_002/r2_w1_wl u_t013_002/r2_r0_rwl u_t013_002/r2_r1_rwl
+ u_t013_002/r3_w0_wl u_t013_002/r3_w1_wl u_t013_002/r3_r0_rwl u_t013_002/r3_r1_rwl
+ VSS u_t013_031/VSS VSUBS detronyx_12t_2w2r_rc4_4x4_routed_5layer_direct
Xu_t004_024 u_t004_024/c0_w0_bl u_t004_024/c0_w0_br u_t004_024/c0_w1_bl u_t004_024/c0_w1_br
+ u_t004_024/c0_r0_rbl u_t004_024/c0_r1_rbl u_t004_024/c1_w0_bl u_t004_024/c1_w0_br
+ u_t004_024/c1_w1_bl u_t004_024/c1_w1_br u_t004_024/c1_r0_rbl u_t004_024/c1_r1_rbl
+ u_t004_024/c2_w0_bl u_t004_024/c2_w0_br u_t004_024/c2_w1_bl u_t004_024/c2_w1_br
+ u_t004_024/c2_r0_rbl u_t004_024/c2_r1_rbl u_t004_024/c3_w0_bl u_t004_024/c3_w0_br
+ u_t004_024/c3_w1_bl u_t004_024/c3_w1_br u_t004_024/c3_r0_rbl u_t004_024/c3_r1_rbl
+ u_t004_024/r0_w0_wl u_t004_024/r0_w1_wl u_t004_024/r0_r0_rwl u_t004_024/r0_r1_rwl
+ u_t004_024/r1_w0_wl u_t004_024/r1_w1_wl u_t004_024/r1_r0_rwl u_t004_024/r1_r1_rwl
+ u_t004_024/r2_w0_wl u_t004_024/r2_w1_wl u_t004_024/r2_r0_rwl u_t004_024/r2_r1_rwl
+ u_t004_024/r3_w0_wl u_t004_024/r3_w1_wl u_t004_024/r3_r0_rwl u_t004_024/r3_r1_rwl
+ VSS u_t004_031/VSS VSUBS detronyx_12t_2w2r_rc4_4x4_routed_5layer_direct
Xu_t004_013 u_t004_013/c0_w0_bl u_t004_013/c0_w0_br u_t004_013/c0_w1_bl u_t004_013/c0_w1_br
+ u_t004_013/c0_r0_rbl u_t004_013/c0_r1_rbl u_t004_013/c1_w0_bl u_t004_013/c1_w0_br
+ u_t004_013/c1_w1_bl u_t004_013/c1_w1_br u_t004_013/c1_r0_rbl u_t004_013/c1_r1_rbl
+ u_t004_013/c2_w0_bl u_t004_013/c2_w0_br u_t004_013/c2_w1_bl u_t004_013/c2_w1_br
+ u_t004_013/c2_r0_rbl u_t004_013/c2_r1_rbl u_t004_013/c3_w0_bl u_t004_013/c3_w0_br
+ u_t004_013/c3_w1_bl u_t004_013/c3_w1_br u_t004_013/c3_r0_rbl u_t004_013/c3_r1_rbl
+ u_t004_013/r0_w0_wl u_t004_013/r0_w1_wl u_t004_013/r0_r0_rwl u_t004_013/r0_r1_rwl
+ u_t004_013/r1_w0_wl u_t004_013/r1_w1_wl u_t004_013/r1_r0_rwl u_t004_013/r1_r1_rwl
+ u_t004_013/r2_w0_wl u_t004_013/r2_w1_wl u_t004_013/r2_r0_rwl u_t004_013/r2_r1_rwl
+ u_t004_013/r3_w0_wl u_t004_013/r3_w1_wl u_t004_013/r3_r0_rwl u_t004_013/r3_r1_rwl
+ u_t004_013/VDD u_t004_031/VSS VSUBS detronyx_12t_2w2r_rc4_4x4_routed_5layer_direct
Xu_t004_002 u_t004_002/c0_w0_bl u_t004_002/c0_w0_br u_t004_002/c0_w1_bl u_t004_002/c0_w1_br
+ u_t004_002/c0_r0_rbl u_t004_002/c0_r1_rbl u_t004_002/c1_w0_bl u_t004_002/c1_w0_br
+ u_t004_002/c1_w1_bl u_t004_002/c1_w1_br u_t004_002/c1_r0_rbl u_t004_002/c1_r1_rbl
+ u_t004_002/c2_w0_bl u_t004_002/c2_w0_br u_t004_002/c2_w1_bl u_t004_002/c2_w1_br
+ u_t004_002/c2_r0_rbl u_t004_002/c2_r1_rbl u_t004_002/c3_w0_bl u_t004_002/c3_w0_br
+ u_t004_002/c3_w1_bl u_t004_002/c3_w1_br u_t004_002/c3_r0_rbl u_t004_002/c3_r1_rbl
+ u_t004_002/r0_w0_wl u_t004_002/r0_w1_wl u_t004_002/r0_r0_rwl u_t004_002/r0_r1_rwl
+ u_t004_002/r1_w0_wl u_t004_002/r1_w1_wl u_t004_002/r1_r0_rwl u_t004_002/r1_r1_rwl
+ u_t004_002/r2_w0_wl u_t004_002/r2_w1_wl u_t004_002/r2_r0_rwl u_t004_002/r2_r1_rwl
+ u_t004_002/r3_w0_wl u_t004_002/r3_w1_wl u_t004_002/r3_r0_rwl u_t004_002/r3_r1_rwl
+ VSS u_t004_031/VSS VSUBS detronyx_12t_2w2r_rc4_4x4_routed_5layer_direct
Xgf180mcu_as_sc_mcu7t3v3__inv_2_444 VSS VSS VSS VSS gf180mcu_as_sc_mcu7t3v3__inv_2_448/VNW
+ VSUBS gf180mcu_as_sc_mcu7t3v3__inv_2
Xgf180mcu_as_sc_mcu7t3v3__inv_2_400 gf180mcu_as_sc_mcu7t3v3__nor2_2_5/VDD gf180mcu_as_sc_mcu7t3v3__nand3_2_8/VSS
+ VSS VSS gf180mcu_as_sc_mcu7t3v3__nor2_2_5/VNW VSUBS gf180mcu_as_sc_mcu7t3v3__inv_2
Xgf180mcu_as_sc_mcu7t3v3__inv_2_455 gf180mcu_as_sc_mcu7t3v3__nor2_2_4/VDD gf180mcu_as_sc_mcu7t3v3__nor2_2_4/VSS
+ gf180mcu_as_sc_mcu7t3v3__inv_2_455/Y VSS gf180mcu_as_sc_mcu7t3v3__nor2_2_4/VNW VSUBS
+ gf180mcu_as_sc_mcu7t3v3__inv_2
Xgf180mcu_as_sc_mcu7t3v3__inv_2_466 gf180mcu_as_sc_mcu7t3v3__nor2_2_4/VDD gf180mcu_as_sc_mcu7t3v3__nor2_2_4/VSS
+ VSS VSS gf180mcu_as_sc_mcu7t3v3__nor2_2_4/VNW VSUBS gf180mcu_as_sc_mcu7t3v3__inv_2
Xgf180mcu_as_sc_mcu7t3v3__inv_2_422 gf180mcu_as_sc_mcu7t3v3__nor2_2_6/VDD gf180mcu_as_sc_mcu7t3v3__nand3_2_3/VSS
+ VSS VSS gf180mcu_as_sc_mcu7t3v3__nor2_2_6/VNW VSUBS gf180mcu_as_sc_mcu7t3v3__inv_2
Xgf180mcu_as_sc_mcu7t3v3__inv_2_411 gf180mcu_as_sc_mcu7t3v3__nor2_2_6/VDD gf180mcu_as_sc_mcu7t3v3__nor2_2_6/VSS
+ VSS VSS gf180mcu_as_sc_mcu7t3v3__nor2_2_6/VNW VSUBS gf180mcu_as_sc_mcu7t3v3__inv_2
Xgf180mcu_as_sc_mcu7t3v3__inv_2_433 gf180mcu_as_sc_mcu7t3v3__nand3_2_5/VDD gf180mcu_as_sc_mcu7t3v3__nor2_2_6/VSS
+ VSS VSS gf180mcu_as_sc_mcu7t3v3__nand3_2_5/VNW VSUBS gf180mcu_as_sc_mcu7t3v3__inv_2
Xgf180mcu_as_sc_mcu7t3v3__inv_2_477 gf180mcu_as_sc_mcu7t3v3__nand3_2_5/VDD gf180mcu_as_sc_mcu7t3v3__nor2_2_4/VSS
+ VSS VSS gf180mcu_as_sc_mcu7t3v3__nand3_2_5/VNW VSUBS gf180mcu_as_sc_mcu7t3v3__inv_2
Xgf180mcu_as_sc_mcu7t3v3__inv_2_499 gf180mcu_as_sc_mcu7t3v3__nor2_2_6/VDD gf180mcu_as_sc_mcu7t3v3__nand3_2_3/VSS
+ gf180mcu_as_sc_mcu7t3v3__inv_2_499/Y VSS gf180mcu_as_sc_mcu7t3v3__nor2_2_6/VNW VSUBS
+ gf180mcu_as_sc_mcu7t3v3__inv_2
Xgf180mcu_as_sc_mcu7t3v3__inv_2_488 gf180mcu_as_sc_mcu7t3v3__nor2_2_6/VDD gf180mcu_as_sc_mcu7t3v3__nor2_2_6/VSS
+ VSS VSS gf180mcu_as_sc_mcu7t3v3__nor2_2_6/VNW VSUBS gf180mcu_as_sc_mcu7t3v3__inv_2
Xu_t010_016 u_t010_016/c0_w0_bl u_t010_016/c0_w0_br u_t010_016/c0_w1_bl u_t010_016/c0_w1_br
+ u_t010_016/c0_r0_rbl u_t010_016/c0_r1_rbl u_t010_016/c1_w0_bl u_t010_016/c1_w0_br
+ u_t010_016/c1_w1_bl u_t010_016/c1_w1_br u_t010_016/c1_r0_rbl u_t010_016/c1_r1_rbl
+ u_t010_016/c2_w0_bl u_t010_016/c2_w0_br u_t010_016/c2_w1_bl u_t010_016/c2_w1_br
+ u_t010_016/c2_r0_rbl u_t010_016/c2_r1_rbl u_t010_016/c3_w0_bl u_t010_016/c3_w0_br
+ u_t010_016/c3_w1_bl u_t010_016/c3_w1_br u_t010_016/c3_r0_rbl u_t010_016/c3_r1_rbl
+ u_t010_016/r0_w0_wl u_t010_016/r0_w1_wl u_t010_016/r0_r0_rwl u_t010_016/r0_r1_rwl
+ u_t010_016/r1_w0_wl u_t010_016/r1_w1_wl u_t010_016/r1_r0_rwl u_t010_016/r1_r1_rwl
+ u_t010_016/r2_w0_wl u_t010_016/r2_w1_wl u_t010_016/r2_r0_rwl u_t010_016/r2_r1_rwl
+ u_t010_016/r3_w0_wl u_t010_016/r3_w1_wl u_t010_016/r3_r0_rwl u_t010_016/r3_r1_rwl
+ VSS u_t010_017/VSS VSUBS detronyx_12t_2w2r_rc4_4x4_routed_5layer_direct
Xu_t010_005 u_t010_005/c0_w0_bl u_t010_005/c0_w0_br u_t010_005/c0_w1_bl u_t010_005/c0_w1_br
+ u_t010_005/c0_r0_rbl u_t010_005/c0_r1_rbl u_t010_005/c1_w0_bl u_t010_005/c1_w0_br
+ u_t010_005/c1_w1_bl u_t010_005/c1_w1_br u_t010_005/c1_r0_rbl u_t010_005/c1_r1_rbl
+ u_t010_005/c2_w0_bl u_t010_005/c2_w0_br u_t010_005/c2_w1_bl u_t010_005/c2_w1_br
+ u_t010_005/c2_r0_rbl u_t010_005/c2_r1_rbl u_t010_005/c3_w0_bl u_t010_005/c3_w0_br
+ u_t010_005/c3_w1_bl u_t010_005/c3_w1_br u_t010_005/c3_r0_rbl u_t010_005/c3_r1_rbl
+ u_t010_005/r0_w0_wl u_t010_005/r0_w1_wl u_t010_005/r0_r0_rwl u_t010_005/r0_r1_rwl
+ u_t010_005/r1_w0_wl u_t010_005/r1_w1_wl u_t010_005/r1_r0_rwl u_t010_005/r1_r1_rwl
+ u_t010_005/r2_w0_wl u_t010_005/r2_w1_wl u_t010_005/r2_r0_rwl u_t010_005/r2_r1_rwl
+ u_t010_005/r3_w0_wl u_t010_005/r3_w1_wl u_t010_005/r3_r0_rwl u_t010_005/r3_r1_rwl
+ u_t010_005/VDD u_t010_005/VSS VSUBS detronyx_12t_2w2r_rc4_4x4_routed_5layer_direct
Xu_t010_027 u_t010_027/c0_w0_bl u_t010_027/c0_w0_br u_t010_027/c0_w1_bl u_t010_027/c0_w1_br
+ u_t010_027/c0_r0_rbl u_t010_027/c0_r1_rbl u_t010_027/c1_w0_bl u_t010_027/c1_w0_br
+ u_t010_027/c1_w1_bl u_t010_027/c1_w1_br u_t010_027/c1_r0_rbl u_t010_027/c1_r1_rbl
+ u_t010_027/c2_w0_bl u_t010_027/c2_w0_br u_t010_027/c2_w1_bl u_t010_027/c2_w1_br
+ u_t010_027/c2_r0_rbl u_t010_027/c2_r1_rbl u_t010_027/c3_w0_bl u_t010_027/c3_w0_br
+ u_t010_027/c3_w1_bl u_t010_027/c3_w1_br u_t010_027/c3_r0_rbl u_t010_027/c3_r1_rbl
+ u_t010_027/r0_w0_wl u_t010_027/r0_w1_wl u_t010_027/r0_r0_rwl u_t010_027/r0_r1_rwl
+ u_t010_027/r1_w0_wl u_t010_027/r1_w1_wl u_t010_027/r1_r0_rwl u_t010_027/r1_r1_rwl
+ u_t010_027/r2_w0_wl u_t010_027/r2_w1_wl u_t010_027/r2_r0_rwl u_t010_027/r2_r1_rwl
+ u_t010_027/r3_w0_wl u_t010_027/r3_w1_wl u_t010_027/r3_r0_rwl u_t010_027/r3_r1_rwl
+ u_t010_027/VDD u_t010_027/VSS VSUBS detronyx_12t_2w2r_rc4_4x4_routed_5layer_direct
Xu_t001_027 u_t001_027/c0_w0_bl u_t001_027/c0_w0_br u_t001_027/c0_w1_bl u_t001_027/c0_w1_br
+ u_t001_027/c0_r0_rbl u_t001_027/c0_r1_rbl u_t001_027/c1_w0_bl u_t001_027/c1_w0_br
+ u_t001_027/c1_w1_bl u_t001_027/c1_w1_br u_t001_027/c1_r0_rbl u_t001_027/c1_r1_rbl
+ u_t001_027/c2_w0_bl u_t001_027/c2_w0_br u_t001_027/c2_w1_bl u_t001_027/c2_w1_br
+ u_t001_027/c2_r0_rbl u_t001_027/c2_r1_rbl u_t001_027/c3_w0_bl u_t001_027/c3_w0_br
+ u_t001_027/c3_w1_bl u_t001_027/c3_w1_br u_t001_027/c3_r0_rbl u_t001_027/c3_r1_rbl
+ u_t001_027/r0_w0_wl u_t001_027/r0_w1_wl u_t001_027/r0_r0_rwl u_t001_027/r0_r1_rwl
+ u_t001_027/r1_w0_wl u_t001_027/r1_w1_wl u_t001_027/r1_r0_rwl u_t001_027/r1_r1_rwl
+ u_t001_027/r2_w0_wl u_t001_027/r2_w1_wl u_t001_027/r2_r0_rwl u_t001_027/r2_r1_rwl
+ u_t001_027/r3_w0_wl u_t001_027/r3_w1_wl u_t001_027/r3_r0_rwl u_t001_027/r3_r1_rwl
+ u_t001_027/VDD u_t001_031/VSS VSUBS detronyx_12t_2w2r_rc4_4x4_routed_5layer_direct
Xu_t001_016 u_t001_016/c0_w0_bl u_t001_016/c0_w0_br u_t001_016/c0_w1_bl u_t001_016/c0_w1_br
+ u_t001_016/c0_r0_rbl u_t001_016/c0_r1_rbl u_t001_016/c1_w0_bl u_t001_016/c1_w0_br
+ u_t001_016/c1_w1_bl u_t001_016/c1_w1_br u_t001_016/c1_r0_rbl u_t001_016/c1_r1_rbl
+ u_t001_016/c2_w0_bl u_t001_016/c2_w0_br u_t001_016/c2_w1_bl u_t001_016/c2_w1_br
+ u_t001_016/c2_r0_rbl u_t001_016/c2_r1_rbl u_t001_016/c3_w0_bl u_t001_016/c3_w0_br
+ u_t001_016/c3_w1_bl u_t001_016/c3_w1_br u_t001_016/c3_r0_rbl u_t001_016/c3_r1_rbl
+ u_t001_016/r0_w0_wl u_t001_016/r0_w1_wl u_t001_016/r0_r0_rwl u_t001_016/r0_r1_rwl
+ u_t001_016/r1_w0_wl u_t001_016/r1_w1_wl u_t001_016/r1_r0_rwl u_t001_016/r1_r1_rwl
+ u_t001_016/r2_w0_wl u_t001_016/r2_w1_wl u_t001_016/r2_r0_rwl u_t001_016/r2_r1_rwl
+ u_t001_016/r3_w0_wl u_t001_016/r3_w1_wl u_t001_016/r3_r0_rwl u_t001_016/r3_r1_rwl
+ VSS u_t001_031/VSS VSUBS detronyx_12t_2w2r_rc4_4x4_routed_5layer_direct
Xu_t001_005 u_t001_005/c0_w0_bl u_t001_005/c0_w0_br u_t001_005/c0_w1_bl u_t001_005/c0_w1_br
+ u_t001_005/c0_r0_rbl u_t001_005/c0_r1_rbl u_t001_005/c1_w0_bl u_t001_005/c1_w0_br
+ u_t001_005/c1_w1_bl u_t001_005/c1_w1_br u_t001_005/c1_r0_rbl u_t001_005/c1_r1_rbl
+ u_t001_005/c2_w0_bl u_t001_005/c2_w0_br u_t001_005/c2_w1_bl u_t001_005/c2_w1_br
+ u_t001_005/c2_r0_rbl u_t001_005/c2_r1_rbl u_t001_005/c3_w0_bl u_t001_005/c3_w0_br
+ u_t001_005/c3_w1_bl u_t001_005/c3_w1_br u_t001_005/c3_r0_rbl u_t001_005/c3_r1_rbl
+ u_t001_005/r0_w0_wl u_t001_005/r0_w1_wl u_t001_005/r0_r0_rwl u_t001_005/r0_r1_rwl
+ u_t001_005/r1_w0_wl u_t001_005/r1_w1_wl u_t001_005/r1_r0_rwl u_t001_005/r1_r1_rwl
+ u_t001_005/r2_w0_wl u_t001_005/r2_w1_wl u_t001_005/r2_r0_rwl u_t001_005/r2_r1_rwl
+ u_t001_005/r3_w0_wl u_t001_005/r3_w1_wl u_t001_005/r3_r0_rwl u_t001_005/r3_r1_rwl
+ u_t001_005/VDD u_t001_031/VSS VSUBS detronyx_12t_2w2r_rc4_4x4_routed_5layer_direct
Xgf180mcu_as_sc_mcu7t3v3__inv_2_274 gf180mcu_as_sc_mcu7t3v3__inv_2_351/VDD VSS gf180mcu_as_sc_mcu7t3v3__inv_2_66/Y
+ gf180mcu_as_sc_mcu7t3v3__inv_2_66/Y gf180mcu_as_sc_mcu7t3v3__inv_2_351/VNW VSUBS
+ gf180mcu_as_sc_mcu7t3v3__inv_2
Xgf180mcu_as_sc_mcu7t3v3__inv_2_263 gf180mcu_as_sc_mcu7t3v3__inv_2_357/VDD gf180mcu_as_sc_mcu7t3v3__inv_2_358/VDD
+ VSS gf180mcu_as_sc_mcu7t3v3__inv_2_358/Y gf180mcu_as_sc_mcu7t3v3__inv_2_357/VNW
+ VSUBS gf180mcu_as_sc_mcu7t3v3__inv_2
Xgf180mcu_as_sc_mcu7t3v3__inv_2_285 gf180mcu_as_sc_mcu7t3v3__inv_2_354/VDD gf180mcu_as_sc_mcu7t3v3__inv_2_355/VDD
+ VSS gf180mcu_as_sc_mcu7t3v3__inv_2_358/Y gf180mcu_as_sc_mcu7t3v3__inv_2_354/VNW
+ VSUBS gf180mcu_as_sc_mcu7t3v3__inv_2
Xgf180mcu_as_sc_mcu7t3v3__inv_2_252 VSS VSS VSS VSS gf180mcu_as_sc_mcu7t3v3__inv_2_252/VNW
+ VSUBS gf180mcu_as_sc_mcu7t3v3__inv_2
Xgf180mcu_as_sc_mcu7t3v3__inv_2_230 gf180mcu_as_sc_mcu7t3v3__inv_2_257/VDD gf180mcu_as_sc_mcu7t3v3__inv_2_257/VSS
+ gf180mcu_as_sc_mcu7t3v3__inv_2_230/Y VSS gf180mcu_as_sc_mcu7t3v3__inv_2_257/VNW
+ VSUBS gf180mcu_as_sc_mcu7t3v3__inv_2
Xgf180mcu_as_sc_mcu7t3v3__inv_2_241 gf180mcu_as_sc_mcu7t3v3__inv_2_241/VDD gf180mcu_as_sc_mcu7t3v3__inv_2_245/VDD
+ gf180mcu_as_sc_mcu7t3v3__inv_2_241/Y VSS gf180mcu_as_sc_mcu7t3v3__inv_2_241/VNW
+ VSUBS gf180mcu_as_sc_mcu7t3v3__inv_2
Xgf180mcu_as_sc_mcu7t3v3__inv_2_296 VSS VSS gf180mcu_as_sc_mcu7t3v3__inv_2_338/Y gf180mcu_as_sc_mcu7t3v3__inv_2_338/Y
+ gf180mcu_as_sc_mcu7t3v3__inv_2_329/VNW VSUBS gf180mcu_as_sc_mcu7t3v3__inv_2
Xgf180mcu_as_sc_mcu7t3v3__inv_2_1515 VSS gf180mcu_as_sc_mcu7t3v3__inv_2_1524/VDD VSS
+ VSS gf180mcu_as_sc_mcu7t3v3__inv_2_1520/VNW VSUBS gf180mcu_as_sc_mcu7t3v3__inv_2
Xgf180mcu_as_sc_mcu7t3v3__inv_2_1526 VSS VSS VSS VSS gf180mcu_as_sc_mcu7t3v3__inv_2_1528/VNW
+ VSUBS gf180mcu_as_sc_mcu7t3v3__inv_2
Xgf180mcu_as_sc_mcu7t3v3__inv_2_1504 gf180mcu_as_sc_mcu7t3v3__inv_2_1532/VSS gf180mcu_as_sc_mcu7t3v3__inv_2_1688/VDD
+ VSS VSS gf180mcu_as_sc_mcu7t3v3__inv_2_1506/VNW VSUBS gf180mcu_as_sc_mcu7t3v3__inv_2
Xgf180mcu_as_sc_mcu7t3v3__inv_2_1559 VSS VSS VSS VSS gf180mcu_as_sc_mcu7t3v3__inv_2_1561/VNW
+ VSUBS gf180mcu_as_sc_mcu7t3v3__inv_2
Xgf180mcu_as_sc_mcu7t3v3__inv_2_1548 gf180mcu_as_sc_mcu7t3v3__inv_2_1592/VSS gf180mcu_as_sc_mcu7t3v3__inv_2_1548/VSS
+ gf180mcu_as_sc_mcu7t3v3__inv_2_1548/Y VSS gf180mcu_as_sc_mcu7t3v3__inv_2_1548/VNW
+ VSUBS gf180mcu_as_sc_mcu7t3v3__inv_2
Xgf180mcu_as_sc_mcu7t3v3__inv_2_1537 gf180mcu_as_sc_mcu7t3v3__inv_2_1539/VDD VSS VSS
+ VSS gf180mcu_as_sc_mcu7t3v3__inv_2_1539/VNW VSUBS gf180mcu_as_sc_mcu7t3v3__inv_2
Xgf180mcu_as_sc_mcu7t3v3__nand4_2_309 gf180mcu_as_sc_mcu7t3v3__inv_2_1053/VDD VSS
+ VSS VSS VSS VSS VSS gf180mcu_as_sc_mcu7t3v3__inv_2_1053/VNW VSUBS gf180mcu_as_sc_mcu7t3v3__nand4_2
Xgf180mcu_as_sc_mcu7t3v3__nand2_2_3 gf180mcu_as_sc_mcu7t3v3__nor2_2_5/VDD gf180mcu_as_sc_mcu7t3v3__nand3_2_8/VSS
+ VSS VSS VSS gf180mcu_as_sc_mcu7t3v3__nor2_2_5/VNW VSUBS gf180mcu_as_sc_mcu7t3v3__nand2_2
Xu_t029_019 u_t029_019/c0_w0_bl u_t029_019/c0_w0_br u_t029_019/c0_w1_bl u_t029_019/c0_w1_br
+ u_t029_019/c0_r0_rbl u_t029_019/c0_r1_rbl u_t029_019/c1_w0_bl u_t029_019/c1_w0_br
+ u_t029_019/c1_w1_bl u_t029_019/c1_w1_br u_t029_019/c1_r0_rbl u_t029_019/c1_r1_rbl
+ u_t029_019/c2_w0_bl u_t029_019/c2_w0_br u_t029_019/c2_w1_bl u_t029_019/c2_w1_br
+ u_t029_019/c2_r0_rbl u_t029_019/c2_r1_rbl u_t029_019/c3_w0_bl u_t029_019/c3_w0_br
+ u_t029_019/c3_w1_bl u_t029_019/c3_w1_br u_t029_019/c3_r0_rbl u_t029_019/c3_r1_rbl
+ u_t029_019/r0_w0_wl u_t029_019/r0_w1_wl u_t029_019/r0_r0_rwl u_t029_019/r0_r1_rwl
+ u_t029_019/r1_w0_wl u_t029_019/r1_w1_wl u_t029_019/r1_r0_rwl u_t029_019/r1_r1_rwl
+ u_t029_019/r2_w0_wl u_t029_019/r2_w1_wl u_t029_019/r2_r0_rwl u_t029_019/r2_r1_rwl
+ u_t029_019/r3_w0_wl u_t029_019/r3_w1_wl u_t029_019/r3_r0_rwl u_t029_019/r3_r1_rwl
+ u_t029_019/VDD u_t029_031/VSS VSUBS detronyx_12t_2w2r_rc4_4x4_routed_5layer_direct
Xu_t029_008 u_t029_008/c0_w0_bl u_t029_008/c0_w0_br u_t029_008/c0_w1_bl u_t029_008/c0_w1_br
+ u_t029_008/c0_r0_rbl u_t029_008/c0_r1_rbl u_t029_008/c1_w0_bl u_t029_008/c1_w0_br
+ u_t029_008/c1_w1_bl u_t029_008/c1_w1_br u_t029_008/c1_r0_rbl u_t029_008/c1_r1_rbl
+ u_t029_008/c2_w0_bl u_t029_008/c2_w0_br u_t029_008/c2_w1_bl u_t029_008/c2_w1_br
+ u_t029_008/c2_r0_rbl u_t029_008/c2_r1_rbl u_t029_008/c3_w0_bl u_t029_008/c3_w0_br
+ u_t029_008/c3_w1_bl u_t029_008/c3_w1_br u_t029_008/c3_r0_rbl u_t029_008/c3_r1_rbl
+ u_t029_008/r0_w0_wl u_t029_008/r0_w1_wl u_t029_008/r0_r0_rwl u_t029_008/r0_r1_rwl
+ u_t029_008/r1_w0_wl u_t029_008/r1_w1_wl u_t029_008/r1_r0_rwl u_t029_008/r1_r1_rwl
+ u_t029_008/r2_w0_wl u_t029_008/r2_w1_wl u_t029_008/r2_r0_rwl u_t029_008/r2_r1_rwl
+ u_t029_008/r3_w0_wl u_t029_008/r3_w1_wl u_t029_008/r3_r0_rwl u_t029_008/r3_r1_rwl
+ VSS u_t029_031/VSS VSUBS detronyx_12t_2w2r_rc4_4x4_routed_5layer_direct
Xgf180mcu_as_sc_mcu7t3v3__inv_2_1345 VSS gf180mcu_as_sc_mcu7t3v3__inv_2_1400/VDD gf180mcu_as_sc_mcu7t3v3__inv_2_1685/Y
+ gf180mcu_as_sc_mcu7t3v3__inv_2_1685/Y gf180mcu_as_sc_mcu7t3v3__inv_2_1399/VNW VSUBS
+ gf180mcu_as_sc_mcu7t3v3__inv_2
Xgf180mcu_as_sc_mcu7t3v3__inv_2_1356 gf180mcu_as_sc_mcu7t3v3__inv_2_1384/VDD VSS VSS
+ gf180mcu_as_sc_mcu7t3v3__inv_2_1384/Y gf180mcu_as_sc_mcu7t3v3__inv_2_1384/VNW VSUBS
+ gf180mcu_as_sc_mcu7t3v3__inv_2
Xgf180mcu_as_sc_mcu7t3v3__inv_2_1334 VSS VSS VSS gf180mcu_as_sc_mcu7t3v3__inv_2_1398/Y
+ gf180mcu_as_sc_mcu7t3v3__inv_2_1388/VNW VSUBS gf180mcu_as_sc_mcu7t3v3__inv_2
Xgf180mcu_as_sc_mcu7t3v3__inv_2_1301 VSS gf180mcu_as_sc_mcu7t3v3__inv_2_1691/VDD gf180mcu_as_sc_mcu7t3v3__inv_2_1301/Y
+ gf180mcu_as_sc_mcu7t3v3__inv_2_1691/Y gf180mcu_as_sc_mcu7t3v3__inv_2_1365/VNW VSUBS
+ gf180mcu_as_sc_mcu7t3v3__inv_2
Xgf180mcu_as_sc_mcu7t3v3__inv_2_1378 gf180mcu_as_sc_mcu7t3v3__inv_2_1378/VDD gf180mcu_as_sc_mcu7t3v3__inv_2_1379/VDD
+ gf180mcu_as_sc_mcu7t3v3__inv_2_1379/Y VSS gf180mcu_as_sc_mcu7t3v3__inv_2_1378/VNW
+ VSUBS gf180mcu_as_sc_mcu7t3v3__inv_2
Xgf180mcu_as_sc_mcu7t3v3__inv_2_1323 gf180mcu_as_sc_mcu7t3v3__inv_2_1378/VDD gf180mcu_as_sc_mcu7t3v3__inv_2_1379/VDD
+ gf180mcu_as_sc_mcu7t3v3__inv_2_1323/Y gf180mcu_as_sc_mcu7t3v3__inv_2_1379/Y gf180mcu_as_sc_mcu7t3v3__inv_2_1378/VNW
+ VSUBS gf180mcu_as_sc_mcu7t3v3__inv_2
Xgf180mcu_as_sc_mcu7t3v3__inv_2_1312 VSS gf180mcu_as_sc_mcu7t3v3__inv_2_1369/VDD VSS
+ gf180mcu_as_sc_mcu7t3v3__inv_2_1369/Y gf180mcu_as_sc_mcu7t3v3__inv_2_1368/VNW VSUBS
+ gf180mcu_as_sc_mcu7t3v3__inv_2
Xgf180mcu_as_sc_mcu7t3v3__inv_2_1367 VSS VSS gf180mcu_as_sc_mcu7t3v3__inv_2_1369/Y
+ VSS gf180mcu_as_sc_mcu7t3v3__inv_2_1367/VNW VSUBS gf180mcu_as_sc_mcu7t3v3__inv_2
Xgf180mcu_as_sc_mcu7t3v3__inv_2_1389 VSS gf180mcu_as_sc_mcu7t3v3__inv_2_1390/VDD gf180mcu_as_sc_mcu7t3v3__inv_2_1398/Y
+ VSS gf180mcu_as_sc_mcu7t3v3__inv_2_1389/VNW VSUBS gf180mcu_as_sc_mcu7t3v3__inv_2
Xu_t028_030 u_t028_030/c0_w0_bl u_t028_030/c0_w0_br u_t028_030/c0_w1_bl u_t028_030/c0_w1_br
+ u_t028_030/c0_r0_rbl u_t028_030/c0_r1_rbl u_t028_030/c1_w0_bl u_t028_030/c1_w0_br
+ u_t028_030/c1_w1_bl u_t028_030/c1_w1_br u_t028_030/c1_r0_rbl u_t028_030/c1_r1_rbl
+ u_t028_030/c2_w0_bl u_t028_030/c2_w0_br u_t028_030/c2_w1_bl u_t028_030/c2_w1_br
+ u_t028_030/c2_r0_rbl u_t028_030/c2_r1_rbl u_t028_030/c3_w0_bl u_t028_030/c3_w0_br
+ u_t028_030/c3_w1_bl u_t028_030/c3_w1_br u_t028_030/c3_r0_rbl u_t028_030/c3_r1_rbl
+ u_t028_030/r0_w0_wl u_t028_030/r0_w1_wl u_t028_030/r0_r0_rwl u_t028_030/r0_r1_rwl
+ u_t028_030/r1_w0_wl u_t028_030/r1_w1_wl u_t028_030/r1_r0_rwl u_t028_030/r1_r1_rwl
+ u_t028_030/r2_w0_wl u_t028_030/r2_w1_wl u_t028_030/r2_r0_rwl u_t028_030/r2_r1_rwl
+ u_t028_030/r3_w0_wl u_t028_030/r3_w1_wl u_t028_030/r3_r0_rwl u_t028_030/r3_r1_rwl
+ VSS u_t028_031/VSS VSUBS detronyx_12t_2w2r_rc4_4x4_routed_5layer_direct
Xgf180mcu_as_sc_mcu7t3v3__inv_2_818 VSS VSS gf180mcu_as_sc_mcu7t3v3__inv_2_818/Y VSS
+ gf180mcu_as_sc_mcu7t3v3__inv_2_820/VNW VSUBS gf180mcu_as_sc_mcu7t3v3__inv_2
Xgf180mcu_as_sc_mcu7t3v3__inv_2_807 VSS VSS VSS VSS gf180mcu_as_sc_mcu7t3v3__inv_2_808/VNW
+ VSUBS gf180mcu_as_sc_mcu7t3v3__inv_2
Xgf180mcu_as_sc_mcu7t3v3__inv_2_829 VSS VSS gf180mcu_as_sc_mcu7t3v3__inv_2_829/Y VSS
+ gf180mcu_as_sc_mcu7t3v3__inv_2_829/VNW VSUBS gf180mcu_as_sc_mcu7t3v3__inv_2
Xgf180mcu_as_sc_mcu7t3v3__nand4_2_128 VSS VSS VSS VSS VSS VSS gf180mcu_as_sc_mcu7t3v3__nand4_2_128/Y
+ gf180mcu_as_sc_mcu7t3v3__inv_2_410/VNW VSUBS gf180mcu_as_sc_mcu7t3v3__nand4_2
Xgf180mcu_as_sc_mcu7t3v3__nand4_2_139 VSS VSS VSS VSS VSS VSS gf180mcu_as_sc_mcu7t3v3__nand4_2_139/Y
+ gf180mcu_as_sc_mcu7t3v3__inv_2_542/VNW VSUBS gf180mcu_as_sc_mcu7t3v3__nand4_2
Xgf180mcu_as_sc_mcu7t3v3__nand4_2_117 gf180mcu_as_sc_mcu7t3v3__inv_2_335/VDD VSS VSS
+ VSS VSS VSS VSS gf180mcu_as_sc_mcu7t3v3__inv_2_335/VNW VSUBS gf180mcu_as_sc_mcu7t3v3__nand4_2
Xgf180mcu_as_sc_mcu7t3v3__nand4_2_106 VSS gf180mcu_as_sc_mcu7t3v3__inv_2_334/VDD VSS
+ VSS VSS VSS VSS gf180mcu_as_sc_mcu7t3v3__inv_2_333/VNW VSUBS gf180mcu_as_sc_mcu7t3v3__nand4_2
Xu_t019_030 u_t019_030/c0_w0_bl u_t019_030/c0_w0_br u_t019_030/c0_w1_bl u_t019_030/c0_w1_br
+ u_t019_030/c0_r0_rbl u_t019_030/c0_r1_rbl u_t019_030/c1_w0_bl u_t019_030/c1_w0_br
+ u_t019_030/c1_w1_bl u_t019_030/c1_w1_br u_t019_030/c1_r0_rbl u_t019_030/c1_r1_rbl
+ u_t019_030/c2_w0_bl u_t019_030/c2_w0_br u_t019_030/c2_w1_bl u_t019_030/c2_w1_br
+ u_t019_030/c2_r0_rbl u_t019_030/c2_r1_rbl u_t019_030/c3_w0_bl u_t019_030/c3_w0_br
+ u_t019_030/c3_w1_bl u_t019_030/c3_w1_br u_t019_030/c3_r0_rbl u_t019_030/c3_r1_rbl
+ u_t019_030/r0_w0_wl u_t019_030/r0_w1_wl u_t019_030/r0_r0_rwl u_t019_030/r0_r1_rwl
+ u_t019_030/r1_w0_wl u_t019_030/r1_w1_wl u_t019_030/r1_r0_rwl u_t019_030/r1_r1_rwl
+ u_t019_030/r2_w0_wl u_t019_030/r2_w1_wl u_t019_030/r2_r0_rwl u_t019_030/r2_r1_rwl
+ u_t019_030/r3_w0_wl u_t019_030/r3_w1_wl u_t019_030/r3_r0_rwl u_t019_030/r3_r1_rwl
+ VSS u_t019_031/VSS VSUBS detronyx_12t_2w2r_rc4_4x4_routed_5layer_direct
Xgf180mcu_as_sc_mcu7t3v3__nand4_2_34 gf180mcu_as_sc_mcu7t3v3__inv_2_96/VDD gf180mcu_as_sc_mcu7t3v3__inv_2_96/VSS
+ VSS VSS VSS VSS gf180mcu_as_sc_mcu7t3v3__nand4_2_34/Y gf180mcu_as_sc_mcu7t3v3__inv_2_96/VNW
+ VSUBS gf180mcu_as_sc_mcu7t3v3__nand4_2
Xgf180mcu_as_sc_mcu7t3v3__nand4_2_12 VSS gf180mcu_as_sc_mcu7t3v3__inv_2_77/VDD VSS
+ VSS VSS VSS VSS gf180mcu_as_sc_mcu7t3v3__inv_2_76/VNW VSUBS gf180mcu_as_sc_mcu7t3v3__nand4_2
Xgf180mcu_as_sc_mcu7t3v3__nand4_2_45 gf180mcu_as_sc_mcu7t3v3__inv_2_152/VSS gf180mcu_as_sc_mcu7t3v3__inv_2_152/VSS
+ VSS VSS VSS VSS VSS gf180mcu_as_sc_mcu7t3v3__inv_2_152/VNW VSUBS gf180mcu_as_sc_mcu7t3v3__nand4_2
Xgf180mcu_as_sc_mcu7t3v3__nand4_2_23 gf180mcu_as_sc_mcu7t3v3__inv_2_66/VDD gf180mcu_as_sc_mcu7t3v3__inv_2_66/VSS
+ VSS VSS VSS VSS VSS gf180mcu_as_sc_mcu7t3v3__inv_2_66/VNW VSUBS gf180mcu_as_sc_mcu7t3v3__nand4_2
Xgf180mcu_as_sc_mcu7t3v3__nand4_2_67 gf180mcu_as_sc_mcu7t3v3__inv_2_165/VDD VSS VSS
+ VSS VSS VSS gf180mcu_as_sc_mcu7t3v3__nand4_2_67/Y gf180mcu_as_sc_mcu7t3v3__inv_2_165/VNW
+ VSUBS gf180mcu_as_sc_mcu7t3v3__nand4_2
Xgf180mcu_as_sc_mcu7t3v3__nand4_2_89 gf180mcu_as_sc_mcu7t3v3__inv_2_356/VDD gf180mcu_as_sc_mcu7t3v3__inv_2_357/VDD
+ VSS VSS VSS VSS VSS gf180mcu_as_sc_mcu7t3v3__inv_2_356/VNW VSUBS gf180mcu_as_sc_mcu7t3v3__nand4_2
Xgf180mcu_as_sc_mcu7t3v3__nand4_2_56 gf180mcu_as_sc_mcu7t3v3__inv_2_220/VDD VSS VSS
+ VSS VSS VSS gf180mcu_as_sc_mcu7t3v3__nand4_2_56/Y gf180mcu_as_sc_mcu7t3v3__inv_2_220/VNW
+ VSUBS gf180mcu_as_sc_mcu7t3v3__nand4_2
Xgf180mcu_as_sc_mcu7t3v3__nand4_2_78 VSS gf180mcu_as_sc_mcu7t3v3__inv_2_229/VDD VSS
+ VSS VSS VSS gf180mcu_as_sc_mcu7t3v3__nand4_2_78/Y gf180mcu_as_sc_mcu7t3v3__inv_2_213/VNW
+ VSUBS gf180mcu_as_sc_mcu7t3v3__nand4_2
Xu_t025_000 u_t025_000/c0_w0_bl u_t025_000/c0_w0_br u_t025_000/c0_w1_bl u_t025_000/c0_w1_br
+ u_t025_000/c0_r0_rbl u_t025_000/c0_r1_rbl u_t025_000/c1_w0_bl u_t025_000/c1_w0_br
+ u_t025_000/c1_w1_bl u_t025_000/c1_w1_br u_t025_000/c1_r0_rbl u_t025_000/c1_r1_rbl
+ u_t025_000/c2_w0_bl u_t025_000/c2_w0_br u_t025_000/c2_w1_bl u_t025_000/c2_w1_br
+ u_t025_000/c2_r0_rbl u_t025_000/c2_r1_rbl u_t025_000/c3_w0_bl u_t025_000/c3_w0_br
+ u_t025_000/c3_w1_bl u_t025_000/c3_w1_br u_t025_000/c3_r0_rbl u_t025_000/c3_r1_rbl
+ u_t025_000/r0_w0_wl u_t025_000/r0_w1_wl u_t025_000/r0_r0_rwl u_t025_000/r0_r1_rwl
+ u_t025_000/r1_w0_wl u_t025_000/r1_w1_wl u_t025_000/r1_r0_rwl u_t025_000/r1_r1_rwl
+ u_t025_000/r2_w0_wl u_t025_000/r2_w1_wl u_t025_000/r2_r0_rwl u_t025_000/r2_r1_rwl
+ u_t025_000/r3_w0_wl u_t025_000/r3_w1_wl u_t025_000/r3_r0_rwl u_t025_000/r3_r1_rwl
+ VSS u_t025_031/VSS VSUBS detronyx_12t_2w2r_rc4_4x4_routed_5layer_direct
Xu_t025_022 u_t025_022/c0_w0_bl u_t025_022/c0_w0_br u_t025_022/c0_w1_bl u_t025_022/c0_w1_br
+ u_t025_022/c0_r0_rbl u_t025_022/c0_r1_rbl u_t025_022/c1_w0_bl u_t025_022/c1_w0_br
+ u_t025_022/c1_w1_bl u_t025_022/c1_w1_br u_t025_022/c1_r0_rbl u_t025_022/c1_r1_rbl
+ u_t025_022/c2_w0_bl u_t025_022/c2_w0_br u_t025_022/c2_w1_bl u_t025_022/c2_w1_br
+ u_t025_022/c2_r0_rbl u_t025_022/c2_r1_rbl u_t025_022/c3_w0_bl u_t025_022/c3_w0_br
+ u_t025_022/c3_w1_bl u_t025_022/c3_w1_br u_t025_022/c3_r0_rbl u_t025_022/c3_r1_rbl
+ u_t025_022/r0_w0_wl u_t025_022/r0_w1_wl u_t025_022/r0_r0_rwl u_t025_022/r0_r1_rwl
+ u_t025_022/r1_w0_wl u_t025_022/r1_w1_wl u_t025_022/r1_r0_rwl u_t025_022/r1_r1_rwl
+ u_t025_022/r2_w0_wl u_t025_022/r2_w1_wl u_t025_022/r2_r0_rwl u_t025_022/r2_r1_rwl
+ u_t025_022/r3_w0_wl u_t025_022/r3_w1_wl u_t025_022/r3_r0_rwl u_t025_022/r3_r1_rwl
+ VSS u_t025_031/VSS VSUBS detronyx_12t_2w2r_rc4_4x4_routed_5layer_direct
Xu_t025_011 u_t025_011/c0_w0_bl u_t025_011/c0_w0_br u_t025_011/c0_w1_bl u_t025_011/c0_w1_br
+ u_t025_011/c0_r0_rbl u_t025_011/c0_r1_rbl u_t025_011/c1_w0_bl u_t025_011/c1_w0_br
+ u_t025_011/c1_w1_bl u_t025_011/c1_w1_br u_t025_011/c1_r0_rbl u_t025_011/c1_r1_rbl
+ u_t025_011/c2_w0_bl u_t025_011/c2_w0_br u_t025_011/c2_w1_bl u_t025_011/c2_w1_br
+ u_t025_011/c2_r0_rbl u_t025_011/c2_r1_rbl u_t025_011/c3_w0_bl u_t025_011/c3_w0_br
+ u_t025_011/c3_w1_bl u_t025_011/c3_w1_br u_t025_011/c3_r0_rbl u_t025_011/c3_r1_rbl
+ u_t025_011/r0_w0_wl u_t025_011/r0_w1_wl u_t025_011/r0_r0_rwl u_t025_011/r0_r1_rwl
+ u_t025_011/r1_w0_wl u_t025_011/r1_w1_wl u_t025_011/r1_r0_rwl u_t025_011/r1_r1_rwl
+ u_t025_011/r2_w0_wl u_t025_011/r2_w1_wl u_t025_011/r2_r0_rwl u_t025_011/r2_r1_rwl
+ u_t025_011/r3_w0_wl u_t025_011/r3_w1_wl u_t025_011/r3_r0_rwl u_t025_011/r3_r1_rwl
+ u_t025_011/VDD u_t025_031/VSS VSUBS detronyx_12t_2w2r_rc4_4x4_routed_5layer_direct
Xgf180mcu_as_sc_mcu7t3v3__inv_2_1131 gf180mcu_as_sc_mcu7t3v3__inv_2_1132/VDD gf180mcu_as_sc_mcu7t3v3__inv_2_1135/VDD
+ gf180mcu_as_sc_mcu7t3v3__inv_2_1131/Y gf180mcu_as_sc_mcu7t3v3__inv_2_1132/Y gf180mcu_as_sc_mcu7t3v3__inv_2_1132/VNW
+ VSUBS gf180mcu_as_sc_mcu7t3v3__inv_2
Xgf180mcu_as_sc_mcu7t3v3__inv_2_1142 gf180mcu_as_sc_mcu7t3v3__inv_2_1143/VDD VSS VSS
+ VSS gf180mcu_as_sc_mcu7t3v3__inv_2_1143/VNW VSUBS gf180mcu_as_sc_mcu7t3v3__inv_2
Xgf180mcu_as_sc_mcu7t3v3__inv_2_1120 VSS VSS gf180mcu_as_sc_mcu7t3v3__inv_2_1120/Y
+ VSS gf180mcu_as_sc_mcu7t3v3__inv_2_1120/VNW VSUBS gf180mcu_as_sc_mcu7t3v3__inv_2
Xgf180mcu_as_sc_mcu7t3v3__inv_2_1175 VSS VSS VSS VSS gf180mcu_as_sc_mcu7t3v3__inv_2_1177/VNW
+ VSUBS gf180mcu_as_sc_mcu7t3v3__inv_2
Xgf180mcu_as_sc_mcu7t3v3__inv_2_1186 VSS VSS VSS VSS gf180mcu_as_sc_mcu7t3v3__inv_2_1186/VNW
+ VSUBS gf180mcu_as_sc_mcu7t3v3__inv_2
Xgf180mcu_as_sc_mcu7t3v3__inv_2_1197 VSS VSS VSS VSS gf180mcu_as_sc_mcu7t3v3__inv_2_1197/VNW
+ VSUBS gf180mcu_as_sc_mcu7t3v3__inv_2
Xgf180mcu_as_sc_mcu7t3v3__inv_2_1153 VSS VSS VSS VSS gf180mcu_as_sc_mcu7t3v3__inv_2_1155/VNW
+ VSUBS gf180mcu_as_sc_mcu7t3v3__inv_2
Xgf180mcu_as_sc_mcu7t3v3__inv_2_1164 VSS VSS VSS VSS gf180mcu_as_sc_mcu7t3v3__inv_2_1172/VNW
+ VSUBS gf180mcu_as_sc_mcu7t3v3__inv_2
Xu_t016_022 u_t016_022/c0_w0_bl u_t016_022/c0_w0_br u_t016_022/c0_w1_bl u_t016_022/c0_w1_br
+ u_t016_022/c0_r0_rbl u_t016_022/c0_r1_rbl u_t016_022/c1_w0_bl u_t016_022/c1_w0_br
+ u_t016_022/c1_w1_bl u_t016_022/c1_w1_br u_t016_022/c1_r0_rbl u_t016_022/c1_r1_rbl
+ u_t016_022/c2_w0_bl u_t016_022/c2_w0_br u_t016_022/c2_w1_bl u_t016_022/c2_w1_br
+ u_t016_022/c2_r0_rbl u_t016_022/c2_r1_rbl u_t016_022/c3_w0_bl u_t016_022/c3_w0_br
+ u_t016_022/c3_w1_bl u_t016_022/c3_w1_br u_t016_022/c3_r0_rbl u_t016_022/c3_r1_rbl
+ u_t016_022/r0_w0_wl u_t016_022/r0_w1_wl u_t016_022/r0_r0_rwl u_t016_022/r0_r1_rwl
+ u_t016_022/r1_w0_wl u_t016_022/r1_w1_wl u_t016_022/r1_r0_rwl u_t016_022/r1_r1_rwl
+ u_t016_022/r2_w0_wl u_t016_022/r2_w1_wl u_t016_022/r2_r0_rwl u_t016_022/r2_r1_rwl
+ u_t016_022/r3_w0_wl u_t016_022/r3_w1_wl u_t016_022/r3_r0_rwl u_t016_022/r3_r1_rwl
+ VSS u_t016_024/VSS VSUBS detronyx_12t_2w2r_rc4_4x4_routed_5layer_direct
Xu_t016_011 u_t016_011/c0_w0_bl u_t016_011/c0_w0_br u_t016_011/c0_w1_bl u_t016_011/c0_w1_br
+ u_t016_011/c0_r0_rbl u_t016_011/c0_r1_rbl u_t016_011/c1_w0_bl u_t016_011/c1_w0_br
+ u_t016_011/c1_w1_bl u_t016_011/c1_w1_br u_t016_011/c1_r0_rbl u_t016_011/c1_r1_rbl
+ u_t016_011/c2_w0_bl u_t016_011/c2_w0_br u_t016_011/c2_w1_bl u_t016_011/c2_w1_br
+ u_t016_011/c2_r0_rbl u_t016_011/c2_r1_rbl u_t016_011/c3_w0_bl u_t016_011/c3_w0_br
+ u_t016_011/c3_w1_bl u_t016_011/c3_w1_br u_t016_011/c3_r0_rbl u_t016_011/c3_r1_rbl
+ u_t016_011/r0_w0_wl u_t016_011/r0_w1_wl u_t016_011/r0_r0_rwl u_t016_011/r0_r1_rwl
+ u_t016_011/r1_w0_wl u_t016_011/r1_w1_wl u_t016_011/r1_r0_rwl u_t016_011/r1_r1_rwl
+ u_t016_011/r2_w0_wl u_t016_011/r2_w1_wl u_t016_011/r2_r0_rwl u_t016_011/r2_r1_rwl
+ u_t016_011/r3_w0_wl u_t016_011/r3_w1_wl u_t016_011/r3_r0_rwl u_t016_011/r3_r1_rwl
+ u_t016_011/VDD u_t016_011/VSS VSUBS detronyx_12t_2w2r_rc4_4x4_routed_5layer_direct
Xu_t016_000 u_t016_000/c0_w0_bl u_t016_000/c0_w0_br u_t016_000/c0_w1_bl u_t016_000/c0_w1_br
+ u_t016_000/c0_r0_rbl u_t016_000/c0_r1_rbl u_t016_000/c1_w0_bl u_t016_000/c1_w0_br
+ u_t016_000/c1_w1_bl u_t016_000/c1_w1_br u_t016_000/c1_r0_rbl u_t016_000/c1_r1_rbl
+ u_t016_000/c2_w0_bl u_t016_000/c2_w0_br u_t016_000/c2_w1_bl u_t016_000/c2_w1_br
+ u_t016_000/c2_r0_rbl u_t016_000/c2_r1_rbl u_t016_000/c3_w0_bl u_t016_000/c3_w0_br
+ u_t016_000/c3_w1_bl u_t016_000/c3_w1_br u_t016_000/c3_r0_rbl u_t016_000/c3_r1_rbl
+ u_t016_000/r0_w0_wl u_t016_000/r0_w1_wl u_t016_000/r0_r0_rwl u_t016_000/r0_r1_rwl
+ u_t016_000/r1_w0_wl u_t016_000/r1_w1_wl u_t016_000/r1_r0_rwl u_t016_000/r1_r1_rwl
+ u_t016_000/r2_w0_wl u_t016_000/r2_w1_wl u_t016_000/r2_r0_rwl u_t016_000/r2_r1_rwl
+ u_t016_000/r3_w0_wl u_t016_000/r3_w1_wl u_t016_000/r3_r0_rwl u_t016_000/r3_r1_rwl
+ VSS u_t016_002/VSS VSUBS detronyx_12t_2w2r_rc4_4x4_routed_5layer_direct
Xgf180mcu_as_sc_mcu7t3v3__inv_2_626 gf180mcu_as_sc_mcu7t3v3__inv_2_626/VDD VSS gf180mcu_as_sc_mcu7t3v3__inv_2_626/Y
+ VSS gf180mcu_as_sc_mcu7t3v3__inv_2_626/VNW VSUBS gf180mcu_as_sc_mcu7t3v3__inv_2
Xgf180mcu_as_sc_mcu7t3v3__inv_2_615 gf180mcu_as_sc_mcu7t3v3__inv_2_616/VDD gf180mcu_as_sc_mcu7t3v3__inv_2_620/VDD
+ gf180mcu_as_sc_mcu7t3v3__inv_2_615/Y gf180mcu_as_sc_mcu7t3v3__inv_2_616/Y gf180mcu_as_sc_mcu7t3v3__inv_2_616/VNW
+ VSUBS gf180mcu_as_sc_mcu7t3v3__inv_2
Xgf180mcu_as_sc_mcu7t3v3__inv_2_604 gf180mcu_as_sc_mcu7t3v3__inv_2_630/VDD gf180mcu_as_sc_mcu7t3v3__inv_2_630/VSS
+ gf180mcu_as_sc_mcu7t3v3__inv_2_604/Y VSS gf180mcu_as_sc_mcu7t3v3__inv_2_630/VNW
+ VSUBS gf180mcu_as_sc_mcu7t3v3__inv_2
Xgf180mcu_as_sc_mcu7t3v3__inv_2_637 VSS gf180mcu_as_sc_mcu7t3v3__inv_2_667/VDD gf180mcu_as_sc_mcu7t3v3__inv_2_637/Y
+ gf180mcu_as_sc_mcu7t3v3__inv_2_848/Y gf180mcu_as_sc_mcu7t3v3__inv_2_639/VNW VSUBS
+ gf180mcu_as_sc_mcu7t3v3__inv_2
Xgf180mcu_as_sc_mcu7t3v3__inv_2_648 VSS VSS gf180mcu_as_sc_mcu7t3v3__inv_2_848/Y gf180mcu_as_sc_mcu7t3v3__inv_2_664/Y
+ gf180mcu_as_sc_mcu7t3v3__inv_2_680/VNW VSUBS gf180mcu_as_sc_mcu7t3v3__inv_2
Xgf180mcu_as_sc_mcu7t3v3__inv_2_659 gf180mcu_as_sc_mcu7t3v3__inv_2_659/VDD gf180mcu_as_sc_mcu7t3v3__inv_2_663/VDD
+ gf180mcu_as_sc_mcu7t3v3__inv_2_659/Y VSS gf180mcu_as_sc_mcu7t3v3__inv_2_659/VNW
+ VSUBS gf180mcu_as_sc_mcu7t3v3__inv_2
Xu_t031_025 u_t031_025/c0_w0_bl u_t031_025/c0_w0_br u_t031_025/c0_w1_bl u_t031_025/c0_w1_br
+ u_t031_025/c0_r0_rbl u_t031_025/c0_r1_rbl u_t031_025/c1_w0_bl u_t031_025/c1_w0_br
+ u_t031_025/c1_w1_bl u_t031_025/c1_w1_br u_t031_025/c1_r0_rbl u_t031_025/c1_r1_rbl
+ u_t031_025/c2_w0_bl u_t031_025/c2_w0_br u_t031_025/c2_w1_bl u_t031_025/c2_w1_br
+ u_t031_025/c2_r0_rbl u_t031_025/c2_r1_rbl u_t031_025/c3_w0_bl u_t031_025/c3_w0_br
+ u_t031_025/c3_w1_bl u_t031_025/c3_w1_br u_t031_025/c3_r0_rbl u_t031_025/c3_r1_rbl
+ u_t031_025/r0_w0_wl u_t031_025/r0_w1_wl u_t031_025/r0_r0_rwl u_t031_025/r0_r1_rwl
+ u_t031_025/r1_w0_wl u_t031_025/r1_w1_wl u_t031_025/r1_r0_rwl u_t031_025/r1_r1_rwl
+ u_t031_025/r2_w0_wl u_t031_025/r2_w1_wl u_t031_025/r2_r0_rwl u_t031_025/r2_r1_rwl
+ u_t031_025/r3_w0_wl u_t031_025/r3_w1_wl u_t031_025/r3_r0_rwl u_t031_025/r3_r1_rwl
+ VSS u_t031_025/VSS VSUBS detronyx_12t_2w2r_rc4_4x4_routed_5layer_direct
Xu_t031_014 u_t031_014/c0_w0_bl u_t031_014/c0_w0_br u_t031_014/c0_w1_bl u_t031_014/c0_w1_br
+ u_t031_014/c0_r0_rbl u_t031_014/c0_r1_rbl u_t031_014/c1_w0_bl u_t031_014/c1_w0_br
+ u_t031_014/c1_w1_bl u_t031_014/c1_w1_br u_t031_014/c1_r0_rbl u_t031_014/c1_r1_rbl
+ u_t031_014/c2_w0_bl u_t031_014/c2_w0_br u_t031_014/c2_w1_bl u_t031_014/c2_w1_br
+ u_t031_014/c2_r0_rbl u_t031_014/c2_r1_rbl u_t031_014/c3_w0_bl u_t031_014/c3_w0_br
+ u_t031_014/c3_w1_bl u_t031_014/c3_w1_br u_t031_014/c3_r0_rbl u_t031_014/c3_r1_rbl
+ u_t031_014/r0_w0_wl u_t031_014/r0_w1_wl u_t031_014/r0_r0_rwl u_t031_014/r0_r1_rwl
+ u_t031_014/r1_w0_wl u_t031_014/r1_w1_wl u_t031_014/r1_r0_rwl u_t031_014/r1_r1_rwl
+ u_t031_014/r2_w0_wl u_t031_014/r2_w1_wl u_t031_014/r2_r0_rwl u_t031_014/r2_r1_rwl
+ u_t031_014/r3_w0_wl u_t031_014/r3_w1_wl u_t031_014/r3_r0_rwl u_t031_014/r3_r1_rwl
+ u_t031_014/VDD u_t031_017/VSS VSUBS detronyx_12t_2w2r_rc4_4x4_routed_5layer_direct
Xu_t031_003 u_t031_003/c0_w0_bl u_t031_003/c0_w0_br u_t031_003/c0_w1_bl u_t031_003/c0_w1_br
+ u_t031_003/c0_r0_rbl u_t031_003/c0_r1_rbl u_t031_003/c1_w0_bl u_t031_003/c1_w0_br
+ u_t031_003/c1_w1_bl u_t031_003/c1_w1_br u_t031_003/c1_r0_rbl u_t031_003/c1_r1_rbl
+ u_t031_003/c2_w0_bl u_t031_003/c2_w0_br u_t031_003/c2_w1_bl u_t031_003/c2_w1_br
+ u_t031_003/c2_r0_rbl u_t031_003/c2_r1_rbl u_t031_003/c3_w0_bl u_t031_003/c3_w0_br
+ u_t031_003/c3_w1_bl u_t031_003/c3_w1_br u_t031_003/c3_r0_rbl u_t031_003/c3_r1_rbl
+ u_t031_003/r0_w0_wl u_t031_003/r0_w1_wl u_t031_003/r0_r0_rwl u_t031_003/r0_r1_rwl
+ u_t031_003/r1_w0_wl u_t031_003/r1_w1_wl u_t031_003/r1_r0_rwl u_t031_003/r1_r1_rwl
+ u_t031_003/r2_w0_wl u_t031_003/r2_w1_wl u_t031_003/r2_r0_rwl u_t031_003/r2_r1_rwl
+ u_t031_003/r3_w0_wl u_t031_003/r3_w1_wl u_t031_003/r3_r0_rwl u_t031_003/r3_r1_rwl
+ u_t031_003/VDD u_t031_003/VSS VSUBS detronyx_12t_2w2r_rc4_4x4_routed_5layer_direct
Xu_t007_000 u_t007_000/c0_w0_bl u_t007_000/c0_w0_br u_t007_000/c0_w1_bl u_t007_000/c0_w1_br
+ u_t007_000/c0_r0_rbl u_t007_000/c0_r1_rbl u_t007_000/c1_w0_bl u_t007_000/c1_w0_br
+ u_t007_000/c1_w1_bl u_t007_000/c1_w1_br u_t007_000/c1_r0_rbl u_t007_000/c1_r1_rbl
+ u_t007_000/c2_w0_bl u_t007_000/c2_w0_br u_t007_000/c2_w1_bl u_t007_000/c2_w1_br
+ u_t007_000/c2_r0_rbl u_t007_000/c2_r1_rbl u_t007_000/c3_w0_bl u_t007_000/c3_w0_br
+ u_t007_000/c3_w1_bl u_t007_000/c3_w1_br u_t007_000/c3_r0_rbl u_t007_000/c3_r1_rbl
+ u_t007_000/r0_w0_wl u_t007_000/r0_w1_wl u_t007_000/r0_r0_rwl u_t007_000/r0_r1_rwl
+ u_t007_000/r1_w0_wl u_t007_000/r1_w1_wl u_t007_000/r1_r0_rwl u_t007_000/r1_r1_rwl
+ u_t007_000/r2_w0_wl u_t007_000/r2_w1_wl u_t007_000/r2_r0_rwl u_t007_000/r2_r1_rwl
+ u_t007_000/r3_w0_wl u_t007_000/r3_w1_wl u_t007_000/r3_r0_rwl u_t007_000/r3_r1_rwl
+ VSS u_t007_002/VSS VSUBS detronyx_12t_2w2r_rc4_4x4_routed_5layer_direct
Xu_t022_025 u_t022_025/c0_w0_bl u_t022_025/c0_w0_br u_t022_025/c0_w1_bl u_t022_025/c0_w1_br
+ u_t022_025/c0_r0_rbl u_t022_025/c0_r1_rbl u_t022_025/c1_w0_bl u_t022_025/c1_w0_br
+ u_t022_025/c1_w1_bl u_t022_025/c1_w1_br u_t022_025/c1_r0_rbl u_t022_025/c1_r1_rbl
+ u_t022_025/c2_w0_bl u_t022_025/c2_w0_br u_t022_025/c2_w1_bl u_t022_025/c2_w1_br
+ u_t022_025/c2_r0_rbl u_t022_025/c2_r1_rbl u_t022_025/c3_w0_bl u_t022_025/c3_w0_br
+ u_t022_025/c3_w1_bl u_t022_025/c3_w1_br u_t022_025/c3_r0_rbl u_t022_025/c3_r1_rbl
+ u_t022_025/r0_w0_wl u_t022_025/r0_w1_wl u_t022_025/r0_r0_rwl u_t022_025/r0_r1_rwl
+ u_t022_025/r1_w0_wl u_t022_025/r1_w1_wl u_t022_025/r1_r0_rwl u_t022_025/r1_r1_rwl
+ u_t022_025/r2_w0_wl u_t022_025/r2_w1_wl u_t022_025/r2_r0_rwl u_t022_025/r2_r1_rwl
+ u_t022_025/r3_w0_wl u_t022_025/r3_w1_wl u_t022_025/r3_r0_rwl u_t022_025/r3_r1_rwl
+ VSS u_t022_031/VSS VSUBS detronyx_12t_2w2r_rc4_4x4_routed_5layer_direct
Xu_t007_022 u_t007_022/c0_w0_bl u_t007_022/c0_w0_br u_t007_022/c0_w1_bl u_t007_022/c0_w1_br
+ u_t007_022/c0_r0_rbl u_t007_022/c0_r1_rbl u_t007_022/c1_w0_bl u_t007_022/c1_w0_br
+ u_t007_022/c1_w1_bl u_t007_022/c1_w1_br u_t007_022/c1_r0_rbl u_t007_022/c1_r1_rbl
+ u_t007_022/c2_w0_bl u_t007_022/c2_w0_br u_t007_022/c2_w1_bl u_t007_022/c2_w1_br
+ u_t007_022/c2_r0_rbl u_t007_022/c2_r1_rbl u_t007_022/c3_w0_bl u_t007_022/c3_w0_br
+ u_t007_022/c3_w1_bl u_t007_022/c3_w1_br u_t007_022/c3_r0_rbl u_t007_022/c3_r1_rbl
+ u_t007_022/r0_w0_wl u_t007_022/r0_w1_wl u_t007_022/r0_r0_rwl u_t007_022/r0_r1_rwl
+ u_t007_022/r1_w0_wl u_t007_022/r1_w1_wl u_t007_022/r1_r0_rwl u_t007_022/r1_r1_rwl
+ u_t007_022/r2_w0_wl u_t007_022/r2_w1_wl u_t007_022/r2_r0_rwl u_t007_022/r2_r1_rwl
+ u_t007_022/r3_w0_wl u_t007_022/r3_w1_wl u_t007_022/r3_r0_rwl u_t007_022/r3_r1_rwl
+ VSS u_t007_024/VSS VSUBS detronyx_12t_2w2r_rc4_4x4_routed_5layer_direct
Xu_t022_014 u_t022_014/c0_w0_bl u_t022_014/c0_w0_br u_t022_014/c0_w1_bl u_t022_014/c0_w1_br
+ u_t022_014/c0_r0_rbl u_t022_014/c0_r1_rbl u_t022_014/c1_w0_bl u_t022_014/c1_w0_br
+ u_t022_014/c1_w1_bl u_t022_014/c1_w1_br u_t022_014/c1_r0_rbl u_t022_014/c1_r1_rbl
+ u_t022_014/c2_w0_bl u_t022_014/c2_w0_br u_t022_014/c2_w1_bl u_t022_014/c2_w1_br
+ u_t022_014/c2_r0_rbl u_t022_014/c2_r1_rbl u_t022_014/c3_w0_bl u_t022_014/c3_w0_br
+ u_t022_014/c3_w1_bl u_t022_014/c3_w1_br u_t022_014/c3_r0_rbl u_t022_014/c3_r1_rbl
+ u_t022_014/r0_w0_wl u_t022_014/r0_w1_wl u_t022_014/r0_r0_rwl u_t022_014/r0_r1_rwl
+ u_t022_014/r1_w0_wl u_t022_014/r1_w1_wl u_t022_014/r1_r0_rwl u_t022_014/r1_r1_rwl
+ u_t022_014/r2_w0_wl u_t022_014/r2_w1_wl u_t022_014/r2_r0_rwl u_t022_014/r2_r1_rwl
+ u_t022_014/r3_w0_wl u_t022_014/r3_w1_wl u_t022_014/r3_r0_rwl u_t022_014/r3_r1_rwl
+ u_t022_014/VDD u_t022_031/VSS VSUBS detronyx_12t_2w2r_rc4_4x4_routed_5layer_direct
Xu_t007_011 u_t007_011/c0_w0_bl u_t007_011/c0_w0_br u_t007_011/c0_w1_bl u_t007_011/c0_w1_br
+ u_t007_011/c0_r0_rbl u_t007_011/c0_r1_rbl u_t007_011/c1_w0_bl u_t007_011/c1_w0_br
+ u_t007_011/c1_w1_bl u_t007_011/c1_w1_br u_t007_011/c1_r0_rbl u_t007_011/c1_r1_rbl
+ u_t007_011/c2_w0_bl u_t007_011/c2_w0_br u_t007_011/c2_w1_bl u_t007_011/c2_w1_br
+ u_t007_011/c2_r0_rbl u_t007_011/c2_r1_rbl u_t007_011/c3_w0_bl u_t007_011/c3_w0_br
+ u_t007_011/c3_w1_bl u_t007_011/c3_w1_br u_t007_011/c3_r0_rbl u_t007_011/c3_r1_rbl
+ u_t007_011/r0_w0_wl u_t007_011/r0_w1_wl u_t007_011/r0_r0_rwl u_t007_011/r0_r1_rwl
+ u_t007_011/r1_w0_wl u_t007_011/r1_w1_wl u_t007_011/r1_r0_rwl u_t007_011/r1_r1_rwl
+ u_t007_011/r2_w0_wl u_t007_011/r2_w1_wl u_t007_011/r2_r0_rwl u_t007_011/r2_r1_rwl
+ u_t007_011/r3_w0_wl u_t007_011/r3_w1_wl u_t007_011/r3_r0_rwl u_t007_011/r3_r1_rwl
+ u_t008_011/VDD u_t007_011/VSS VSUBS detronyx_12t_2w2r_rc4_4x4_routed_5layer_direct
Xu_t022_003 u_t022_003/c0_w0_bl u_t022_003/c0_w0_br u_t022_003/c0_w1_bl u_t022_003/c0_w1_br
+ u_t022_003/c0_r0_rbl u_t022_003/c0_r1_rbl u_t022_003/c1_w0_bl u_t022_003/c1_w0_br
+ u_t022_003/c1_w1_bl u_t022_003/c1_w1_br u_t022_003/c1_r0_rbl u_t022_003/c1_r1_rbl
+ u_t022_003/c2_w0_bl u_t022_003/c2_w0_br u_t022_003/c2_w1_bl u_t022_003/c2_w1_br
+ u_t022_003/c2_r0_rbl u_t022_003/c2_r1_rbl u_t022_003/c3_w0_bl u_t022_003/c3_w0_br
+ u_t022_003/c3_w1_bl u_t022_003/c3_w1_br u_t022_003/c3_r0_rbl u_t022_003/c3_r1_rbl
+ u_t022_003/r0_w0_wl u_t022_003/r0_w1_wl u_t022_003/r0_r0_rwl u_t022_003/r0_r1_rwl
+ u_t022_003/r1_w0_wl u_t022_003/r1_w1_wl u_t022_003/r1_r0_rwl u_t022_003/r1_r1_rwl
+ u_t022_003/r2_w0_wl u_t022_003/r2_w1_wl u_t022_003/r2_r0_rwl u_t022_003/r2_r1_rwl
+ u_t022_003/r3_w0_wl u_t022_003/r3_w1_wl u_t022_003/r3_r0_rwl u_t022_003/r3_r1_rwl
+ u_t022_003/VDD u_t022_031/VSS VSUBS detronyx_12t_2w2r_rc4_4x4_routed_5layer_direct
Xgf180mcu_as_sc_mcu7t3v3__nand4_2_481 gf180mcu_as_sc_mcu7t3v3__inv_2_1667/VDD gf180mcu_as_sc_mcu7t3v3__inv_2_1667/VSS
+ VSS VSS VSS VSS VSS gf180mcu_as_sc_mcu7t3v3__inv_2_1667/VNW VSUBS gf180mcu_as_sc_mcu7t3v3__nand4_2
Xgf180mcu_as_sc_mcu7t3v3__nand4_2_492 gf180mcu_as_sc_mcu7t3v3__inv_2_1657/VDD VSS
+ VSS VSS VSS VSS VSS gf180mcu_as_sc_mcu7t3v3__inv_2_1657/VNW VSUBS gf180mcu_as_sc_mcu7t3v3__nand4_2
Xgf180mcu_as_sc_mcu7t3v3__nand4_2_470 gf180mcu_as_sc_mcu7t3v3__inv_2_1551/VDD VSS
+ VSS VSS VSS VSS gf180mcu_as_sc_mcu7t3v3__nand4_2_470/Y gf180mcu_as_sc_mcu7t3v3__inv_2_1551/VNW
+ VSUBS gf180mcu_as_sc_mcu7t3v3__nand4_2
Xu_t013_025 u_t013_025/c0_w0_bl u_t013_025/c0_w0_br u_t013_025/c0_w1_bl u_t013_025/c0_w1_br
+ u_t013_025/c0_r0_rbl u_t013_025/c0_r1_rbl u_t013_025/c1_w0_bl u_t013_025/c1_w0_br
+ u_t013_025/c1_w1_bl u_t013_025/c1_w1_br u_t013_025/c1_r0_rbl u_t013_025/c1_r1_rbl
+ u_t013_025/c2_w0_bl u_t013_025/c2_w0_br u_t013_025/c2_w1_bl u_t013_025/c2_w1_br
+ u_t013_025/c2_r0_rbl u_t013_025/c2_r1_rbl u_t013_025/c3_w0_bl u_t013_025/c3_w0_br
+ u_t013_025/c3_w1_bl u_t013_025/c3_w1_br u_t013_025/c3_r0_rbl u_t013_025/c3_r1_rbl
+ u_t013_025/r0_w0_wl u_t013_025/r0_w1_wl u_t013_025/r0_r0_rwl u_t013_025/r0_r1_rwl
+ u_t013_025/r1_w0_wl u_t013_025/r1_w1_wl u_t013_025/r1_r0_rwl u_t013_025/r1_r1_rwl
+ u_t013_025/r2_w0_wl u_t013_025/r2_w1_wl u_t013_025/r2_r0_rwl u_t013_025/r2_r1_rwl
+ u_t013_025/r3_w0_wl u_t013_025/r3_w1_wl u_t013_025/r3_r0_rwl u_t013_025/r3_r1_rwl
+ VSS u_t013_031/VSS VSUBS detronyx_12t_2w2r_rc4_4x4_routed_5layer_direct
Xu_t013_014 u_t013_014/c0_w0_bl u_t013_014/c0_w0_br u_t013_014/c0_w1_bl u_t013_014/c0_w1_br
+ u_t013_014/c0_r0_rbl u_t013_014/c0_r1_rbl u_t013_014/c1_w0_bl u_t013_014/c1_w0_br
+ u_t013_014/c1_w1_bl u_t013_014/c1_w1_br u_t013_014/c1_r0_rbl u_t013_014/c1_r1_rbl
+ u_t013_014/c2_w0_bl u_t013_014/c2_w0_br u_t013_014/c2_w1_bl u_t013_014/c2_w1_br
+ u_t013_014/c2_r0_rbl u_t013_014/c2_r1_rbl u_t013_014/c3_w0_bl u_t013_014/c3_w0_br
+ u_t013_014/c3_w1_bl u_t013_014/c3_w1_br u_t013_014/c3_r0_rbl u_t013_014/c3_r1_rbl
+ u_t013_014/r0_w0_wl u_t013_014/r0_w1_wl u_t013_014/r0_r0_rwl u_t013_014/r0_r1_rwl
+ u_t013_014/r1_w0_wl u_t013_014/r1_w1_wl u_t013_014/r1_r0_rwl u_t013_014/r1_r1_rwl
+ u_t013_014/r2_w0_wl u_t013_014/r2_w1_wl u_t013_014/r2_r0_rwl u_t013_014/r2_r1_rwl
+ u_t013_014/r3_w0_wl u_t013_014/r3_w1_wl u_t013_014/r3_r0_rwl u_t013_014/r3_r1_rwl
+ u_t013_014/VDD u_t013_031/VSS VSUBS detronyx_12t_2w2r_rc4_4x4_routed_5layer_direct
Xu_t013_003 u_t013_003/c0_w0_bl u_t013_003/c0_w0_br u_t013_003/c0_w1_bl u_t013_003/c0_w1_br
+ u_t013_003/c0_r0_rbl u_t013_003/c0_r1_rbl u_t013_003/c1_w0_bl u_t013_003/c1_w0_br
+ u_t013_003/c1_w1_bl u_t013_003/c1_w1_br u_t013_003/c1_r0_rbl u_t013_003/c1_r1_rbl
+ u_t013_003/c2_w0_bl u_t013_003/c2_w0_br u_t013_003/c2_w1_bl u_t013_003/c2_w1_br
+ u_t013_003/c2_r0_rbl u_t013_003/c2_r1_rbl u_t013_003/c3_w0_bl u_t013_003/c3_w0_br
+ u_t013_003/c3_w1_bl u_t013_003/c3_w1_br u_t013_003/c3_r0_rbl u_t013_003/c3_r1_rbl
+ u_t013_003/r0_w0_wl u_t013_003/r0_w1_wl u_t013_003/r0_r0_rwl u_t013_003/r0_r1_rwl
+ u_t013_003/r1_w0_wl u_t013_003/r1_w1_wl u_t013_003/r1_r0_rwl u_t013_003/r1_r1_rwl
+ u_t013_003/r2_w0_wl u_t013_003/r2_w1_wl u_t013_003/r2_r0_rwl u_t013_003/r2_r1_rwl
+ u_t013_003/r3_w0_wl u_t013_003/r3_w1_wl u_t013_003/r3_r0_rwl u_t013_003/r3_r1_rwl
+ u_t013_003/VDD u_t013_031/VSS VSUBS detronyx_12t_2w2r_rc4_4x4_routed_5layer_direct
Xu_t004_025 u_t004_025/c0_w0_bl u_t004_025/c0_w0_br u_t004_025/c0_w1_bl u_t004_025/c0_w1_br
+ u_t004_025/c0_r0_rbl u_t004_025/c0_r1_rbl u_t004_025/c1_w0_bl u_t004_025/c1_w0_br
+ u_t004_025/c1_w1_bl u_t004_025/c1_w1_br u_t004_025/c1_r0_rbl u_t004_025/c1_r1_rbl
+ u_t004_025/c2_w0_bl u_t004_025/c2_w0_br u_t004_025/c2_w1_bl u_t004_025/c2_w1_br
+ u_t004_025/c2_r0_rbl u_t004_025/c2_r1_rbl u_t004_025/c3_w0_bl u_t004_025/c3_w0_br
+ u_t004_025/c3_w1_bl u_t004_025/c3_w1_br u_t004_025/c3_r0_rbl u_t004_025/c3_r1_rbl
+ u_t004_025/r0_w0_wl u_t004_025/r0_w1_wl u_t004_025/r0_r0_rwl u_t004_025/r0_r1_rwl
+ u_t004_025/r1_w0_wl u_t004_025/r1_w1_wl u_t004_025/r1_r0_rwl u_t004_025/r1_r1_rwl
+ u_t004_025/r2_w0_wl u_t004_025/r2_w1_wl u_t004_025/r2_r0_rwl u_t004_025/r2_r1_rwl
+ u_t004_025/r3_w0_wl u_t004_025/r3_w1_wl u_t004_025/r3_r0_rwl u_t004_025/r3_r1_rwl
+ VSS u_t004_031/VSS VSUBS detronyx_12t_2w2r_rc4_4x4_routed_5layer_direct
Xu_t004_014 u_t004_014/c0_w0_bl u_t004_014/c0_w0_br u_t004_014/c0_w1_bl u_t004_014/c0_w1_br
+ u_t004_014/c0_r0_rbl u_t004_014/c0_r1_rbl u_t004_014/c1_w0_bl u_t004_014/c1_w0_br
+ u_t004_014/c1_w1_bl u_t004_014/c1_w1_br u_t004_014/c1_r0_rbl u_t004_014/c1_r1_rbl
+ u_t004_014/c2_w0_bl u_t004_014/c2_w0_br u_t004_014/c2_w1_bl u_t004_014/c2_w1_br
+ u_t004_014/c2_r0_rbl u_t004_014/c2_r1_rbl u_t004_014/c3_w0_bl u_t004_014/c3_w0_br
+ u_t004_014/c3_w1_bl u_t004_014/c3_w1_br u_t004_014/c3_r0_rbl u_t004_014/c3_r1_rbl
+ u_t004_014/r0_w0_wl u_t004_014/r0_w1_wl u_t004_014/r0_r0_rwl u_t004_014/r0_r1_rwl
+ u_t004_014/r1_w0_wl u_t004_014/r1_w1_wl u_t004_014/r1_r0_rwl u_t004_014/r1_r1_rwl
+ u_t004_014/r2_w0_wl u_t004_014/r2_w1_wl u_t004_014/r2_r0_rwl u_t004_014/r2_r1_rwl
+ u_t004_014/r3_w0_wl u_t004_014/r3_w1_wl u_t004_014/r3_r0_rwl u_t004_014/r3_r1_rwl
+ u_t004_014/VDD u_t004_031/VSS VSUBS detronyx_12t_2w2r_rc4_4x4_routed_5layer_direct
Xu_t004_003 u_t004_003/c0_w0_bl u_t004_003/c0_w0_br u_t004_003/c0_w1_bl u_t004_003/c0_w1_br
+ u_t004_003/c0_r0_rbl u_t004_003/c0_r1_rbl u_t004_003/c1_w0_bl u_t004_003/c1_w0_br
+ u_t004_003/c1_w1_bl u_t004_003/c1_w1_br u_t004_003/c1_r0_rbl u_t004_003/c1_r1_rbl
+ u_t004_003/c2_w0_bl u_t004_003/c2_w0_br u_t004_003/c2_w1_bl u_t004_003/c2_w1_br
+ u_t004_003/c2_r0_rbl u_t004_003/c2_r1_rbl u_t004_003/c3_w0_bl u_t004_003/c3_w0_br
+ u_t004_003/c3_w1_bl u_t004_003/c3_w1_br u_t004_003/c3_r0_rbl u_t004_003/c3_r1_rbl
+ u_t004_003/r0_w0_wl u_t004_003/r0_w1_wl u_t004_003/r0_r0_rwl u_t004_003/r0_r1_rwl
+ u_t004_003/r1_w0_wl u_t004_003/r1_w1_wl u_t004_003/r1_r0_rwl u_t004_003/r1_r1_rwl
+ u_t004_003/r2_w0_wl u_t004_003/r2_w1_wl u_t004_003/r2_r0_rwl u_t004_003/r2_r1_rwl
+ u_t004_003/r3_w0_wl u_t004_003/r3_w1_wl u_t004_003/r3_r0_rwl u_t004_003/r3_r1_rwl
+ u_t004_003/VDD u_t004_031/VSS VSUBS detronyx_12t_2w2r_rc4_4x4_routed_5layer_direct
Xgf180mcu_as_sc_mcu7t3v3__inv_2_445 VSS VSS gf180mcu_as_sc_mcu7t3v3__inv_2_445/Y VSS
+ gf180mcu_as_sc_mcu7t3v3__inv_2_447/VNW VSUBS gf180mcu_as_sc_mcu7t3v3__inv_2
Xgf180mcu_as_sc_mcu7t3v3__inv_2_412 VSS VSS gf180mcu_as_sc_mcu7t3v3__inv_2_412/Y VSS
+ gf180mcu_as_sc_mcu7t3v3__inv_2_448/VNW VSUBS gf180mcu_as_sc_mcu7t3v3__inv_2
Xgf180mcu_as_sc_mcu7t3v3__inv_2_423 gf180mcu_as_sc_mcu7t3v3__nor2_2_5/VDD gf180mcu_as_sc_mcu7t3v3__nor2_2_5/VSS
+ VSS VSS gf180mcu_as_sc_mcu7t3v3__nor2_2_5/VNW VSUBS gf180mcu_as_sc_mcu7t3v3__inv_2
Xgf180mcu_as_sc_mcu7t3v3__inv_2_401 gf180mcu_as_sc_mcu7t3v3__nor2_2_4/VDD gf180mcu_as_sc_mcu7t3v3__nand3_2_8/VSS
+ VSS VSS gf180mcu_as_sc_mcu7t3v3__nor2_2_4/VNW VSUBS gf180mcu_as_sc_mcu7t3v3__inv_2
Xgf180mcu_as_sc_mcu7t3v3__inv_2_489 gf180mcu_as_sc_mcu7t3v3__nor2_2_6/VDD gf180mcu_as_sc_mcu7t3v3__nand3_2_3/VSS
+ VSS VSS gf180mcu_as_sc_mcu7t3v3__nor2_2_6/VNW VSUBS gf180mcu_as_sc_mcu7t3v3__inv_2
Xgf180mcu_as_sc_mcu7t3v3__inv_2_478 gf180mcu_as_sc_mcu7t3v3__nand3_2_5/VDD gf180mcu_as_sc_mcu7t3v3__nor2_2_6/VSS
+ VSS VSS gf180mcu_as_sc_mcu7t3v3__nand3_2_5/VNW VSUBS gf180mcu_as_sc_mcu7t3v3__inv_2
Xgf180mcu_as_sc_mcu7t3v3__inv_2_467 gf180mcu_as_sc_mcu7t3v3__nand3_2_5/VDD gf180mcu_as_sc_mcu7t3v3__nor2_2_4/VSS
+ VSS VSS gf180mcu_as_sc_mcu7t3v3__nand3_2_5/VNW VSUBS gf180mcu_as_sc_mcu7t3v3__inv_2
Xgf180mcu_as_sc_mcu7t3v3__inv_2_456 gf180mcu_as_sc_mcu7t3v3__nand3_2_5/VDD gf180mcu_as_sc_mcu7t3v3__nor2_2_4/VSS
+ gf180mcu_as_sc_mcu7t3v3__inv_2_456/Y VSS gf180mcu_as_sc_mcu7t3v3__nand3_2_5/VNW
+ VSUBS gf180mcu_as_sc_mcu7t3v3__inv_2
Xgf180mcu_as_sc_mcu7t3v3__inv_2_434 gf180mcu_as_sc_mcu7t3v3__nand3_2_5/VDD gf180mcu_as_sc_mcu7t3v3__nor2_2_4/VSS
+ VSS VSS gf180mcu_as_sc_mcu7t3v3__nand3_2_5/VNW VSUBS gf180mcu_as_sc_mcu7t3v3__inv_2
Xu_t010_028 u_t010_028/c0_w0_bl u_t010_028/c0_w0_br u_t010_028/c0_w1_bl u_t010_028/c0_w1_br
+ u_t010_028/c0_r0_rbl u_t010_028/c0_r1_rbl u_t010_028/c1_w0_bl u_t010_028/c1_w0_br
+ u_t010_028/c1_w1_bl u_t010_028/c1_w1_br u_t010_028/c1_r0_rbl u_t010_028/c1_r1_rbl
+ u_t010_028/c2_w0_bl u_t010_028/c2_w0_br u_t010_028/c2_w1_bl u_t010_028/c2_w1_br
+ u_t010_028/c2_r0_rbl u_t010_028/c2_r1_rbl u_t010_028/c3_w0_bl u_t010_028/c3_w0_br
+ u_t010_028/c3_w1_bl u_t010_028/c3_w1_br u_t010_028/c3_r0_rbl u_t010_028/c3_r1_rbl
+ u_t010_028/r0_w0_wl u_t010_028/r0_w1_wl u_t010_028/r0_r0_rwl u_t010_028/r0_r1_rwl
+ u_t010_028/r1_w0_wl u_t010_028/r1_w1_wl u_t010_028/r1_r0_rwl u_t010_028/r1_r1_rwl
+ u_t010_028/r2_w0_wl u_t010_028/r2_w1_wl u_t010_028/r2_r0_rwl u_t010_028/r2_r1_rwl
+ u_t010_028/r3_w0_wl u_t010_028/r3_w1_wl u_t010_028/r3_r0_rwl u_t010_028/r3_r1_rwl
+ u_t010_028/VDD u_t010_028/VSS VSUBS detronyx_12t_2w2r_rc4_4x4_routed_5layer_direct
Xu_t010_017 u_t010_017/c0_w0_bl u_t010_017/c0_w0_br u_t010_017/c0_w1_bl u_t010_017/c0_w1_br
+ u_t010_017/c0_r0_rbl u_t010_017/c0_r1_rbl u_t010_017/c1_w0_bl u_t010_017/c1_w0_br
+ u_t010_017/c1_w1_bl u_t010_017/c1_w1_br u_t010_017/c1_r0_rbl u_t010_017/c1_r1_rbl
+ u_t010_017/c2_w0_bl u_t010_017/c2_w0_br u_t010_017/c2_w1_bl u_t010_017/c2_w1_br
+ u_t010_017/c2_r0_rbl u_t010_017/c2_r1_rbl u_t010_017/c3_w0_bl u_t010_017/c3_w0_br
+ u_t010_017/c3_w1_bl u_t010_017/c3_w1_br u_t010_017/c3_r0_rbl u_t010_017/c3_r1_rbl
+ u_t010_017/r0_w0_wl u_t010_017/r0_w1_wl u_t010_017/r0_r0_rwl u_t010_017/r0_r1_rwl
+ u_t010_017/r1_w0_wl u_t010_017/r1_w1_wl u_t010_017/r1_r0_rwl u_t010_017/r1_r1_rwl
+ u_t010_017/r2_w0_wl u_t010_017/r2_w1_wl u_t010_017/r2_r0_rwl u_t010_017/r2_r1_rwl
+ u_t010_017/r3_w0_wl u_t010_017/r3_w1_wl u_t010_017/r3_r0_rwl u_t010_017/r3_r1_rwl
+ VSS u_t010_017/VSS VSUBS detronyx_12t_2w2r_rc4_4x4_routed_5layer_direct
Xu_t010_006 u_t010_006/c0_w0_bl u_t010_006/c0_w0_br u_t010_006/c0_w1_bl u_t010_006/c0_w1_br
+ u_t010_006/c0_r0_rbl u_t010_006/c0_r1_rbl u_t010_006/c1_w0_bl u_t010_006/c1_w0_br
+ u_t010_006/c1_w1_bl u_t010_006/c1_w1_br u_t010_006/c1_r0_rbl u_t010_006/c1_r1_rbl
+ u_t010_006/c2_w0_bl u_t010_006/c2_w0_br u_t010_006/c2_w1_bl u_t010_006/c2_w1_br
+ u_t010_006/c2_r0_rbl u_t010_006/c2_r1_rbl u_t010_006/c3_w0_bl u_t010_006/c3_w0_br
+ u_t010_006/c3_w1_bl u_t010_006/c3_w1_br u_t010_006/c3_r0_rbl u_t010_006/c3_r1_rbl
+ u_t010_006/r0_w0_wl u_t010_006/r0_w1_wl u_t010_006/r0_r0_rwl u_t010_006/r0_r1_rwl
+ u_t010_006/r1_w0_wl u_t010_006/r1_w1_wl u_t010_006/r1_r0_rwl u_t010_006/r1_r1_rwl
+ u_t010_006/r2_w0_wl u_t010_006/r2_w1_wl u_t010_006/r2_r0_rwl u_t010_006/r2_r1_rwl
+ u_t010_006/r3_w0_wl u_t010_006/r3_w1_wl u_t010_006/r3_r0_rwl u_t010_006/r3_r1_rwl
+ u_t010_006/VDD u_t010_009/VSS VSUBS detronyx_12t_2w2r_rc4_4x4_routed_5layer_direct
Xgf180mcu_as_sc_mcu7t3v3__inv_2_990 VSS gf180mcu_as_sc_mcu7t3v3__inv_2_990/VSS gf180mcu_as_sc_mcu7t3v3__inv_2_990/Y
+ VSS gf180mcu_as_sc_mcu7t3v3__inv_2_990/VNW VSUBS gf180mcu_as_sc_mcu7t3v3__inv_2
Xu_t001_028 u_t001_028/c0_w0_bl u_t001_028/c0_w0_br u_t001_028/c0_w1_bl u_t001_028/c0_w1_br
+ u_t001_028/c0_r0_rbl u_t001_028/c0_r1_rbl u_t001_028/c1_w0_bl u_t001_028/c1_w0_br
+ u_t001_028/c1_w1_bl u_t001_028/c1_w1_br u_t001_028/c1_r0_rbl u_t001_028/c1_r1_rbl
+ u_t001_028/c2_w0_bl u_t001_028/c2_w0_br u_t001_028/c2_w1_bl u_t001_028/c2_w1_br
+ u_t001_028/c2_r0_rbl u_t001_028/c2_r1_rbl u_t001_028/c3_w0_bl u_t001_028/c3_w0_br
+ u_t001_028/c3_w1_bl u_t001_028/c3_w1_br u_t001_028/c3_r0_rbl u_t001_028/c3_r1_rbl
+ u_t001_028/r0_w0_wl u_t001_028/r0_w1_wl u_t001_028/r0_r0_rwl u_t001_028/r0_r1_rwl
+ u_t001_028/r1_w0_wl u_t001_028/r1_w1_wl u_t001_028/r1_r0_rwl u_t001_028/r1_r1_rwl
+ u_t001_028/r2_w0_wl u_t001_028/r2_w1_wl u_t001_028/r2_r0_rwl u_t001_028/r2_r1_rwl
+ u_t001_028/r3_w0_wl u_t001_028/r3_w1_wl u_t001_028/r3_r0_rwl u_t001_028/r3_r1_rwl
+ u_t001_028/VDD u_t001_031/VSS VSUBS detronyx_12t_2w2r_rc4_4x4_routed_5layer_direct
Xu_t001_017 u_t001_017/c0_w0_bl u_t001_017/c0_w0_br u_t001_017/c0_w1_bl u_t001_017/c0_w1_br
+ u_t001_017/c0_r0_rbl u_t001_017/c0_r1_rbl u_t001_017/c1_w0_bl u_t001_017/c1_w0_br
+ u_t001_017/c1_w1_bl u_t001_017/c1_w1_br u_t001_017/c1_r0_rbl u_t001_017/c1_r1_rbl
+ u_t001_017/c2_w0_bl u_t001_017/c2_w0_br u_t001_017/c2_w1_bl u_t001_017/c2_w1_br
+ u_t001_017/c2_r0_rbl u_t001_017/c2_r1_rbl u_t001_017/c3_w0_bl u_t001_017/c3_w0_br
+ u_t001_017/c3_w1_bl u_t001_017/c3_w1_br u_t001_017/c3_r0_rbl u_t001_017/c3_r1_rbl
+ u_t001_017/r0_w0_wl u_t001_017/r0_w1_wl u_t001_017/r0_r0_rwl u_t001_017/r0_r1_rwl
+ u_t001_017/r1_w0_wl u_t001_017/r1_w1_wl u_t001_017/r1_r0_rwl u_t001_017/r1_r1_rwl
+ u_t001_017/r2_w0_wl u_t001_017/r2_w1_wl u_t001_017/r2_r0_rwl u_t001_017/r2_r1_rwl
+ u_t001_017/r3_w0_wl u_t001_017/r3_w1_wl u_t001_017/r3_r0_rwl u_t001_017/r3_r1_rwl
+ VSS u_t001_031/VSS VSUBS detronyx_12t_2w2r_rc4_4x4_routed_5layer_direct
Xu_t001_006 u_t001_006/c0_w0_bl u_t001_006/c0_w0_br u_t001_006/c0_w1_bl u_t001_006/c0_w1_br
+ u_t001_006/c0_r0_rbl u_t001_006/c0_r1_rbl u_t001_006/c1_w0_bl u_t001_006/c1_w0_br
+ u_t001_006/c1_w1_bl u_t001_006/c1_w1_br u_t001_006/c1_r0_rbl u_t001_006/c1_r1_rbl
+ u_t001_006/c2_w0_bl u_t001_006/c2_w0_br u_t001_006/c2_w1_bl u_t001_006/c2_w1_br
+ u_t001_006/c2_r0_rbl u_t001_006/c2_r1_rbl u_t001_006/c3_w0_bl u_t001_006/c3_w0_br
+ u_t001_006/c3_w1_bl u_t001_006/c3_w1_br u_t001_006/c3_r0_rbl u_t001_006/c3_r1_rbl
+ u_t001_006/r0_w0_wl u_t001_006/r0_w1_wl u_t001_006/r0_r0_rwl u_t001_006/r0_r1_rwl
+ u_t001_006/r1_w0_wl u_t001_006/r1_w1_wl u_t001_006/r1_r0_rwl u_t001_006/r1_r1_rwl
+ u_t001_006/r2_w0_wl u_t001_006/r2_w1_wl u_t001_006/r2_r0_rwl u_t001_006/r2_r1_rwl
+ u_t001_006/r3_w0_wl u_t001_006/r3_w1_wl u_t001_006/r3_r0_rwl u_t001_006/r3_r1_rwl
+ u_t001_006/VDD u_t001_031/VSS VSUBS detronyx_12t_2w2r_rc4_4x4_routed_5layer_direct
Xgf180mcu_as_sc_mcu7t3v3__inv_2_275 gf180mcu_as_sc_mcu7t3v3__inv_2_363/VDD gf180mcu_as_sc_mcu7t3v3__inv_2_363/VDD
+ VSS gf180mcu_as_sc_mcu7t3v3__inv_2_364/Y gf180mcu_as_sc_mcu7t3v3__inv_2_362/VNW
+ VSUBS gf180mcu_as_sc_mcu7t3v3__inv_2
Xgf180mcu_as_sc_mcu7t3v3__inv_2_264 gf180mcu_as_sc_mcu7t3v3__inv_2_357/VDD gf180mcu_as_sc_mcu7t3v3__inv_2_358/VDD
+ gf180mcu_as_sc_mcu7t3v3__inv_2_264/Y gf180mcu_as_sc_mcu7t3v3__inv_2_358/Y gf180mcu_as_sc_mcu7t3v3__inv_2_357/VNW
+ VSUBS gf180mcu_as_sc_mcu7t3v3__inv_2
Xgf180mcu_as_sc_mcu7t3v3__inv_2_286 gf180mcu_as_sc_mcu7t3v3__inv_2_354/VDD gf180mcu_as_sc_mcu7t3v3__inv_2_355/VDD
+ gf180mcu_as_sc_mcu7t3v3__inv_2_286/Y gf180mcu_as_sc_mcu7t3v3__inv_2_358/Y gf180mcu_as_sc_mcu7t3v3__inv_2_354/VNW
+ VSUBS gf180mcu_as_sc_mcu7t3v3__inv_2
Xgf180mcu_as_sc_mcu7t3v3__inv_2_220 gf180mcu_as_sc_mcu7t3v3__inv_2_220/VDD VSS gf180mcu_as_sc_mcu7t3v3__inv_2_220/Y
+ VSS gf180mcu_as_sc_mcu7t3v3__inv_2_220/VNW VSUBS gf180mcu_as_sc_mcu7t3v3__inv_2
Xgf180mcu_as_sc_mcu7t3v3__inv_2_297 VSS gf180mcu_as_sc_mcu7t3v3__inv_2_341/VDD gf180mcu_as_sc_mcu7t3v3__inv_2_297/Y
+ gf180mcu_as_sc_mcu7t3v3__inv_2_341/Y gf180mcu_as_sc_mcu7t3v3__inv_2_340/VNW VSUBS
+ gf180mcu_as_sc_mcu7t3v3__inv_2
Xgf180mcu_as_sc_mcu7t3v3__inv_2_253 VSS VSS VSS VSS gf180mcu_as_sc_mcu7t3v3__inv_2_253/VNW
+ VSUBS gf180mcu_as_sc_mcu7t3v3__inv_2
Xgf180mcu_as_sc_mcu7t3v3__inv_2_242 gf180mcu_as_sc_mcu7t3v3__inv_2_257/VSS VSS gf180mcu_as_sc_mcu7t3v3__inv_2_242/Y
+ VSS gf180mcu_as_sc_mcu7t3v3__inv_2_246/VNW VSUBS gf180mcu_as_sc_mcu7t3v3__inv_2
Xgf180mcu_as_sc_mcu7t3v3__inv_2_231 gf180mcu_as_sc_mcu7t3v3__inv_2_233/VDD VSS VSS
+ VSS gf180mcu_as_sc_mcu7t3v3__inv_2_233/VNW VSUBS gf180mcu_as_sc_mcu7t3v3__inv_2
Xgf180mcu_as_sc_mcu7t3v3__inv_2_1516 VSS gf180mcu_as_sc_mcu7t3v3__inv_2_1535/VDD VSS
+ VSS gf180mcu_as_sc_mcu7t3v3__inv_2_1518/VNW VSUBS gf180mcu_as_sc_mcu7t3v3__inv_2
Xgf180mcu_as_sc_mcu7t3v3__inv_2_1538 gf180mcu_as_sc_mcu7t3v3__inv_2_1539/VDD VSS gf180mcu_as_sc_mcu7t3v3__inv_2_1538/Y
+ VSS gf180mcu_as_sc_mcu7t3v3__inv_2_1539/VNW VSUBS gf180mcu_as_sc_mcu7t3v3__inv_2
Xgf180mcu_as_sc_mcu7t3v3__inv_2_1549 gf180mcu_as_sc_mcu7t3v3__inv_2_1551/VDD VSS VSS
+ VSS gf180mcu_as_sc_mcu7t3v3__inv_2_1551/VNW VSUBS gf180mcu_as_sc_mcu7t3v3__inv_2
Xgf180mcu_as_sc_mcu7t3v3__inv_2_1527 VSS VSS VSS VSS gf180mcu_as_sc_mcu7t3v3__inv_2_1528/VNW
+ VSUBS gf180mcu_as_sc_mcu7t3v3__inv_2
Xgf180mcu_as_sc_mcu7t3v3__inv_2_1505 gf180mcu_as_sc_mcu7t3v3__inv_2_1532/VSS gf180mcu_as_sc_mcu7t3v3__inv_2_1688/VDD
+ gf180mcu_as_sc_mcu7t3v3__inv_2_1505/Y VSS gf180mcu_as_sc_mcu7t3v3__inv_2_1506/VNW
+ VSUBS gf180mcu_as_sc_mcu7t3v3__inv_2
Xgf180mcu_as_sc_mcu7t3v3__nand2_2_4 gf180mcu_as_sc_mcu7t3v3__nor2_2_4/VDD gf180mcu_as_sc_mcu7t3v3__nand3_2_8/VSS
+ VSS VSS VSS gf180mcu_as_sc_mcu7t3v3__nor2_2_4/VNW VSUBS gf180mcu_as_sc_mcu7t3v3__nand2_2
Xu_t029_009 u_t029_009/c0_w0_bl u_t029_009/c0_w0_br u_t029_009/c0_w1_bl u_t029_009/c0_w1_br
+ u_t029_009/c0_r0_rbl u_t029_009/c0_r1_rbl u_t029_009/c1_w0_bl u_t029_009/c1_w0_br
+ u_t029_009/c1_w1_bl u_t029_009/c1_w1_br u_t029_009/c1_r0_rbl u_t029_009/c1_r1_rbl
+ u_t029_009/c2_w0_bl u_t029_009/c2_w0_br u_t029_009/c2_w1_bl u_t029_009/c2_w1_br
+ u_t029_009/c2_r0_rbl u_t029_009/c2_r1_rbl u_t029_009/c3_w0_bl u_t029_009/c3_w0_br
+ u_t029_009/c3_w1_bl u_t029_009/c3_w1_br u_t029_009/c3_r0_rbl u_t029_009/c3_r1_rbl
+ u_t029_009/r0_w0_wl u_t029_009/r0_w1_wl u_t029_009/r0_r0_rwl u_t029_009/r0_r1_rwl
+ u_t029_009/r1_w0_wl u_t029_009/r1_w1_wl u_t029_009/r1_r0_rwl u_t029_009/r1_r1_rwl
+ u_t029_009/r2_w0_wl u_t029_009/r2_w1_wl u_t029_009/r2_r0_rwl u_t029_009/r2_r1_rwl
+ u_t029_009/r3_w0_wl u_t029_009/r3_w1_wl u_t029_009/r3_r0_rwl u_t029_009/r3_r1_rwl
+ VSS u_t029_031/VSS VSUBS detronyx_12t_2w2r_rc4_4x4_routed_5layer_direct
Xgf180mcu_as_sc_mcu7t3v3__inv_2_1357 gf180mcu_as_sc_mcu7t3v3__inv_2_1384/VDD VSS gf180mcu_as_sc_mcu7t3v3__inv_2_1357/Y
+ gf180mcu_as_sc_mcu7t3v3__inv_2_1384/Y gf180mcu_as_sc_mcu7t3v3__inv_2_1384/VNW VSUBS
+ gf180mcu_as_sc_mcu7t3v3__inv_2
Xgf180mcu_as_sc_mcu7t3v3__inv_2_1335 VSS VSS gf180mcu_as_sc_mcu7t3v3__inv_2_1398/Y
+ gf180mcu_as_sc_mcu7t3v3__inv_2_1398/Y gf180mcu_as_sc_mcu7t3v3__inv_2_1388/VNW VSUBS
+ gf180mcu_as_sc_mcu7t3v3__inv_2
Xgf180mcu_as_sc_mcu7t3v3__inv_2_1379 gf180mcu_as_sc_mcu7t3v3__inv_2_1379/VDD VSS gf180mcu_as_sc_mcu7t3v3__inv_2_1379/Y
+ VSS gf180mcu_as_sc_mcu7t3v3__inv_2_1379/VNW VSUBS gf180mcu_as_sc_mcu7t3v3__inv_2
Xgf180mcu_as_sc_mcu7t3v3__inv_2_1302 gf180mcu_as_sc_mcu7t3v3__inv_2_1373/VDD VSS VSS
+ gf180mcu_as_sc_mcu7t3v3__inv_2_1379/Y gf180mcu_as_sc_mcu7t3v3__inv_2_1373/VNW VSUBS
+ gf180mcu_as_sc_mcu7t3v3__inv_2
Xgf180mcu_as_sc_mcu7t3v3__inv_2_1324 VSS gf180mcu_as_sc_mcu7t3v3__inv_2_1372/VDD VSS
+ gf180mcu_as_sc_mcu7t3v3__inv_2_1379/Y gf180mcu_as_sc_mcu7t3v3__inv_2_1371/VNW VSUBS
+ gf180mcu_as_sc_mcu7t3v3__inv_2
Xgf180mcu_as_sc_mcu7t3v3__inv_2_1368 VSS gf180mcu_as_sc_mcu7t3v3__inv_2_1369/VDD gf180mcu_as_sc_mcu7t3v3__inv_2_1369/Y
+ VSS gf180mcu_as_sc_mcu7t3v3__inv_2_1368/VNW VSUBS gf180mcu_as_sc_mcu7t3v3__inv_2
Xgf180mcu_as_sc_mcu7t3v3__inv_2_1313 VSS gf180mcu_as_sc_mcu7t3v3__inv_2_1369/VDD gf180mcu_as_sc_mcu7t3v3__inv_2_1313/Y
+ gf180mcu_as_sc_mcu7t3v3__inv_2_1369/Y gf180mcu_as_sc_mcu7t3v3__inv_2_1368/VNW VSUBS
+ gf180mcu_as_sc_mcu7t3v3__inv_2
Xgf180mcu_as_sc_mcu7t3v3__inv_2_1346 VSS gf180mcu_as_sc_mcu7t3v3__inv_2_1393/VDD VSS
+ gf180mcu_as_sc_mcu7t3v3__inv_2_1398/Y gf180mcu_as_sc_mcu7t3v3__inv_2_1392/VNW VSUBS
+ gf180mcu_as_sc_mcu7t3v3__inv_2
Xu_t028_031 u_t028_031/c0_w0_bl u_t028_031/c0_w0_br u_t028_031/c0_w1_bl u_t028_031/c0_w1_br
+ u_t028_031/c0_r0_rbl u_t028_031/c0_r1_rbl u_t028_031/c1_w0_bl u_t028_031/c1_w0_br
+ u_t028_031/c1_w1_bl u_t028_031/c1_w1_br u_t028_031/c1_r0_rbl u_t028_031/c1_r1_rbl
+ u_t028_031/c2_w0_bl u_t028_031/c2_w0_br u_t028_031/c2_w1_bl u_t028_031/c2_w1_br
+ u_t028_031/c2_r0_rbl u_t028_031/c2_r1_rbl u_t028_031/c3_w0_bl u_t028_031/c3_w0_br
+ u_t028_031/c3_w1_bl u_t028_031/c3_w1_br u_t028_031/c3_r0_rbl u_t028_031/c3_r1_rbl
+ u_t028_031/r0_w0_wl u_t028_031/r0_w1_wl u_t028_031/r0_r0_rwl u_t028_031/r0_r1_rwl
+ u_t028_031/r1_w0_wl u_t028_031/r1_w1_wl u_t028_031/r1_r0_rwl u_t028_031/r1_r1_rwl
+ u_t028_031/r2_w0_wl u_t028_031/r2_w1_wl u_t028_031/r2_r0_rwl u_t028_031/r2_r1_rwl
+ u_t028_031/r3_w0_wl u_t028_031/r3_w1_wl u_t028_031/r3_r0_rwl u_t028_031/r3_r1_rwl
+ VSS u_t028_031/VSS VSUBS detronyx_12t_2w2r_rc4_4x4_routed_5layer_direct
Xu_t028_020 u_t028_020/c0_w0_bl u_t028_020/c0_w0_br u_t028_020/c0_w1_bl u_t028_020/c0_w1_br
+ u_t028_020/c0_r0_rbl u_t028_020/c0_r1_rbl u_t028_020/c1_w0_bl u_t028_020/c1_w0_br
+ u_t028_020/c1_w1_bl u_t028_020/c1_w1_br u_t028_020/c1_r0_rbl u_t028_020/c1_r1_rbl
+ u_t028_020/c2_w0_bl u_t028_020/c2_w0_br u_t028_020/c2_w1_bl u_t028_020/c2_w1_br
+ u_t028_020/c2_r0_rbl u_t028_020/c2_r1_rbl u_t028_020/c3_w0_bl u_t028_020/c3_w0_br
+ u_t028_020/c3_w1_bl u_t028_020/c3_w1_br u_t028_020/c3_r0_rbl u_t028_020/c3_r1_rbl
+ u_t028_020/r0_w0_wl u_t028_020/r0_w1_wl u_t028_020/r0_r0_rwl u_t028_020/r0_r1_rwl
+ u_t028_020/r1_w0_wl u_t028_020/r1_w1_wl u_t028_020/r1_r0_rwl u_t028_020/r1_r1_rwl
+ u_t028_020/r2_w0_wl u_t028_020/r2_w1_wl u_t028_020/r2_r0_rwl u_t028_020/r2_r1_rwl
+ u_t028_020/r3_w0_wl u_t028_020/r3_w1_wl u_t028_020/r3_r0_rwl u_t028_020/r3_r1_rwl
+ u_t029_020/VDD u_t028_020/VSS VSUBS detronyx_12t_2w2r_rc4_4x4_routed_5layer_direct
Xgf180mcu_as_sc_mcu7t3v3__inv_2_819 VSS VSS VSS VSS gf180mcu_as_sc_mcu7t3v3__inv_2_820/VNW
+ VSUBS gf180mcu_as_sc_mcu7t3v3__inv_2
Xgf180mcu_as_sc_mcu7t3v3__inv_2_808 VSS VSS gf180mcu_as_sc_mcu7t3v3__inv_2_808/Y VSS
+ gf180mcu_as_sc_mcu7t3v3__inv_2_808/VNW VSUBS gf180mcu_as_sc_mcu7t3v3__inv_2
Xu_t019_031 u_t019_031/c0_w0_bl u_t019_031/c0_w0_br u_t019_031/c0_w1_bl u_t019_031/c0_w1_br
+ u_t019_031/c0_r0_rbl u_t019_031/c0_r1_rbl u_t019_031/c1_w0_bl u_t019_031/c1_w0_br
+ u_t019_031/c1_w1_bl u_t019_031/c1_w1_br u_t019_031/c1_r0_rbl u_t019_031/c1_r1_rbl
+ u_t019_031/c2_w0_bl u_t019_031/c2_w0_br u_t019_031/c2_w1_bl u_t019_031/c2_w1_br
+ u_t019_031/c2_r0_rbl u_t019_031/c2_r1_rbl u_t019_031/c3_w0_bl u_t019_031/c3_w0_br
+ u_t019_031/c3_w1_bl u_t019_031/c3_w1_br u_t019_031/c3_r0_rbl u_t019_031/c3_r1_rbl
+ u_t019_031/r0_w0_wl u_t019_031/r0_w1_wl u_t019_031/r0_r0_rwl u_t019_031/r0_r1_rwl
+ u_t019_031/r1_w0_wl u_t019_031/r1_w1_wl u_t019_031/r1_r0_rwl u_t019_031/r1_r1_rwl
+ u_t019_031/r2_w0_wl u_t019_031/r2_w1_wl u_t019_031/r2_r0_rwl u_t019_031/r2_r1_rwl
+ u_t019_031/r3_w0_wl u_t019_031/r3_w1_wl u_t019_031/r3_r0_rwl u_t019_031/r3_r1_rwl
+ VSS u_t019_031/VSS VSUBS detronyx_12t_2w2r_rc4_4x4_routed_5layer_direct
Xu_t019_020 u_t019_020/c0_w0_bl u_t019_020/c0_w0_br u_t019_020/c0_w1_bl u_t019_020/c0_w1_br
+ u_t019_020/c0_r0_rbl u_t019_020/c0_r1_rbl u_t019_020/c1_w0_bl u_t019_020/c1_w0_br
+ u_t019_020/c1_w1_bl u_t019_020/c1_w1_br u_t019_020/c1_r0_rbl u_t019_020/c1_r1_rbl
+ u_t019_020/c2_w0_bl u_t019_020/c2_w0_br u_t019_020/c2_w1_bl u_t019_020/c2_w1_br
+ u_t019_020/c2_r0_rbl u_t019_020/c2_r1_rbl u_t019_020/c3_w0_bl u_t019_020/c3_w0_br
+ u_t019_020/c3_w1_bl u_t019_020/c3_w1_br u_t019_020/c3_r0_rbl u_t019_020/c3_r1_rbl
+ u_t019_020/r0_w0_wl u_t019_020/r0_w1_wl u_t019_020/r0_r0_rwl u_t019_020/r0_r1_rwl
+ u_t019_020/r1_w0_wl u_t019_020/r1_w1_wl u_t019_020/r1_r0_rwl u_t019_020/r1_r1_rwl
+ u_t019_020/r2_w0_wl u_t019_020/r2_w1_wl u_t019_020/r2_r0_rwl u_t019_020/r2_r1_rwl
+ u_t019_020/r3_w0_wl u_t019_020/r3_w1_wl u_t019_020/r3_r0_rwl u_t019_020/r3_r1_rwl
+ u_t019_020/VDD u_t019_020/VSS VSUBS detronyx_12t_2w2r_rc4_4x4_routed_5layer_direct
Xgf180mcu_as_sc_mcu7t3v3__nand4_2_129 VSS VSS VSS VSS VSS VSS VSS gf180mcu_as_sc_mcu7t3v3__inv_2_443/VNW
+ VSUBS gf180mcu_as_sc_mcu7t3v3__nand4_2
Xgf180mcu_as_sc_mcu7t3v3__nand4_2_13 gf180mcu_as_sc_mcu7t3v3__inv_2_61/VDD gf180mcu_as_sc_mcu7t3v3__inv_2_62/VDD
+ VSS VSS VSS VSS VSS gf180mcu_as_sc_mcu7t3v3__inv_2_61/VNW VSUBS gf180mcu_as_sc_mcu7t3v3__nand4_2
Xgf180mcu_as_sc_mcu7t3v3__nand4_2_35 gf180mcu_as_sc_mcu7t3v3__inv_2_151/VSS gf180mcu_as_sc_mcu7t3v3__inv_2_139/VSS
+ VSS VSS VSS VSS gf180mcu_as_sc_mcu7t3v3__nand4_2_35/Y gf180mcu_as_sc_mcu7t3v3__inv_2_139/VNW
+ VSUBS gf180mcu_as_sc_mcu7t3v3__nand4_2
Xgf180mcu_as_sc_mcu7t3v3__nand4_2_24 gf180mcu_as_sc_mcu7t3v3__inv_2_70/VDD gf180mcu_as_sc_mcu7t3v3__inv_2_70/VDD
+ VSS VSS VSS VSS VSS gf180mcu_as_sc_mcu7t3v3__inv_2_64/VNW VSUBS gf180mcu_as_sc_mcu7t3v3__nand4_2
Xgf180mcu_as_sc_mcu7t3v3__nand4_2_118 VSS gf180mcu_as_sc_mcu7t3v3__inv_2_344/VDD VSS
+ VSS VSS VSS VSS gf180mcu_as_sc_mcu7t3v3__inv_2_343/VNW VSUBS gf180mcu_as_sc_mcu7t3v3__nand4_2
Xgf180mcu_as_sc_mcu7t3v3__nand4_2_107 VSS VSS VSS VSS VSS VSS VSS gf180mcu_as_sc_mcu7t3v3__inv_2_329/VNW
+ VSUBS gf180mcu_as_sc_mcu7t3v3__nand4_2
Xgf180mcu_as_sc_mcu7t3v3__nand4_2_46 gf180mcu_as_sc_mcu7t3v3__inv_2_371/VSS gf180mcu_as_sc_mcu7t3v3__inv_2_115/VDD
+ VSS VSS VSS VSS VSS gf180mcu_as_sc_mcu7t3v3__inv_2_111/VNW VSUBS gf180mcu_as_sc_mcu7t3v3__nand4_2
Xgf180mcu_as_sc_mcu7t3v3__nand4_2_68 VSS VSS VSS VSS VSS VSS VSS gf180mcu_as_sc_mcu7t3v3__inv_2_169/VNW
+ VSUBS gf180mcu_as_sc_mcu7t3v3__nand4_2
Xgf180mcu_as_sc_mcu7t3v3__nand4_2_57 VSS VSS VSS VSS VSS VSS VSS gf180mcu_as_sc_mcu7t3v3__inv_2_224/VNW
+ VSUBS gf180mcu_as_sc_mcu7t3v3__nand4_2
Xgf180mcu_as_sc_mcu7t3v3__nand4_2_79 gf180mcu_as_sc_mcu7t3v3__inv_2_229/VDD gf180mcu_as_sc_mcu7t3v3__inv_2_233/VDD
+ VSS VSS VSS VSS gf180mcu_as_sc_mcu7t3v3__nand4_2_79/Y gf180mcu_as_sc_mcu7t3v3__inv_2_229/VNW
+ VSUBS gf180mcu_as_sc_mcu7t3v3__nand4_2
Xu_t025_023 u_t025_023/c0_w0_bl u_t025_023/c0_w0_br u_t025_023/c0_w1_bl u_t025_023/c0_w1_br
+ u_t025_023/c0_r0_rbl u_t025_023/c0_r1_rbl u_t025_023/c1_w0_bl u_t025_023/c1_w0_br
+ u_t025_023/c1_w1_bl u_t025_023/c1_w1_br u_t025_023/c1_r0_rbl u_t025_023/c1_r1_rbl
+ u_t025_023/c2_w0_bl u_t025_023/c2_w0_br u_t025_023/c2_w1_bl u_t025_023/c2_w1_br
+ u_t025_023/c2_r0_rbl u_t025_023/c2_r1_rbl u_t025_023/c3_w0_bl u_t025_023/c3_w0_br
+ u_t025_023/c3_w1_bl u_t025_023/c3_w1_br u_t025_023/c3_r0_rbl u_t025_023/c3_r1_rbl
+ u_t025_023/r0_w0_wl u_t025_023/r0_w1_wl u_t025_023/r0_r0_rwl u_t025_023/r0_r1_rwl
+ u_t025_023/r1_w0_wl u_t025_023/r1_w1_wl u_t025_023/r1_r0_rwl u_t025_023/r1_r1_rwl
+ u_t025_023/r2_w0_wl u_t025_023/r2_w1_wl u_t025_023/r2_r0_rwl u_t025_023/r2_r1_rwl
+ u_t025_023/r3_w0_wl u_t025_023/r3_w1_wl u_t025_023/r3_r0_rwl u_t025_023/r3_r1_rwl
+ VSS u_t025_031/VSS VSUBS detronyx_12t_2w2r_rc4_4x4_routed_5layer_direct
Xu_t025_012 u_t025_012/c0_w0_bl u_t025_012/c0_w0_br u_t025_012/c0_w1_bl u_t025_012/c0_w1_br
+ u_t025_012/c0_r0_rbl u_t025_012/c0_r1_rbl u_t025_012/c1_w0_bl u_t025_012/c1_w0_br
+ u_t025_012/c1_w1_bl u_t025_012/c1_w1_br u_t025_012/c1_r0_rbl u_t025_012/c1_r1_rbl
+ u_t025_012/c2_w0_bl u_t025_012/c2_w0_br u_t025_012/c2_w1_bl u_t025_012/c2_w1_br
+ u_t025_012/c2_r0_rbl u_t025_012/c2_r1_rbl u_t025_012/c3_w0_bl u_t025_012/c3_w0_br
+ u_t025_012/c3_w1_bl u_t025_012/c3_w1_br u_t025_012/c3_r0_rbl u_t025_012/c3_r1_rbl
+ u_t025_012/r0_w0_wl u_t025_012/r0_w1_wl u_t025_012/r0_r0_rwl u_t025_012/r0_r1_rwl
+ u_t025_012/r1_w0_wl u_t025_012/r1_w1_wl u_t025_012/r1_r0_rwl u_t025_012/r1_r1_rwl
+ u_t025_012/r2_w0_wl u_t025_012/r2_w1_wl u_t025_012/r2_r0_rwl u_t025_012/r2_r1_rwl
+ u_t025_012/r3_w0_wl u_t025_012/r3_w1_wl u_t025_012/r3_r0_rwl u_t025_012/r3_r1_rwl
+ u_t025_012/VDD u_t025_031/VSS VSUBS detronyx_12t_2w2r_rc4_4x4_routed_5layer_direct
Xu_t025_001 u_t025_001/c0_w0_bl u_t025_001/c0_w0_br u_t025_001/c0_w1_bl u_t025_001/c0_w1_br
+ u_t025_001/c0_r0_rbl u_t025_001/c0_r1_rbl u_t025_001/c1_w0_bl u_t025_001/c1_w0_br
+ u_t025_001/c1_w1_bl u_t025_001/c1_w1_br u_t025_001/c1_r0_rbl u_t025_001/c1_r1_rbl
+ u_t025_001/c2_w0_bl u_t025_001/c2_w0_br u_t025_001/c2_w1_bl u_t025_001/c2_w1_br
+ u_t025_001/c2_r0_rbl u_t025_001/c2_r1_rbl u_t025_001/c3_w0_bl u_t025_001/c3_w0_br
+ u_t025_001/c3_w1_bl u_t025_001/c3_w1_br u_t025_001/c3_r0_rbl u_t025_001/c3_r1_rbl
+ u_t025_001/r0_w0_wl u_t025_001/r0_w1_wl u_t025_001/r0_r0_rwl u_t025_001/r0_r1_rwl
+ u_t025_001/r1_w0_wl u_t025_001/r1_w1_wl u_t025_001/r1_r0_rwl u_t025_001/r1_r1_rwl
+ u_t025_001/r2_w0_wl u_t025_001/r2_w1_wl u_t025_001/r2_r0_rwl u_t025_001/r2_r1_rwl
+ u_t025_001/r3_w0_wl u_t025_001/r3_w1_wl u_t025_001/r3_r0_rwl u_t025_001/r3_r1_rwl
+ VSS u_t025_031/VSS VSUBS detronyx_12t_2w2r_rc4_4x4_routed_5layer_direct
Xgf180mcu_as_sc_mcu7t3v3__inv_2_1110 VSS VSS gf180mcu_as_sc_mcu7t3v3__inv_2_1115/A
+ gf180mcu_as_sc_mcu7t3v3__inv_2_1111/Y gf180mcu_as_sc_mcu7t3v3__inv_2_1111/VNW VSUBS
+ gf180mcu_as_sc_mcu7t3v3__inv_2
Xgf180mcu_as_sc_mcu7t3v3__inv_2_1198 gf180mcu_as_sc_mcu7t3v3__nor2_2_8/VDD gf180mcu_as_sc_mcu7t3v3__nand3_2_32/VSS
+ VSS VSS gf180mcu_as_sc_mcu7t3v3__nor2_2_8/VNW VSUBS gf180mcu_as_sc_mcu7t3v3__inv_2
Xgf180mcu_as_sc_mcu7t3v3__inv_2_1121 gf180mcu_as_sc_mcu7t3v3__inv_2_1123/VDD gf180mcu_as_sc_mcu7t3v3__inv_2_1126/VDD
+ VSS VSS gf180mcu_as_sc_mcu7t3v3__inv_2_1123/VNW VSUBS gf180mcu_as_sc_mcu7t3v3__inv_2
Xgf180mcu_as_sc_mcu7t3v3__inv_2_1132 gf180mcu_as_sc_mcu7t3v3__inv_2_1132/VDD gf180mcu_as_sc_mcu7t3v3__inv_2_1135/VDD
+ gf180mcu_as_sc_mcu7t3v3__inv_2_1132/Y VSS gf180mcu_as_sc_mcu7t3v3__inv_2_1132/VNW
+ VSUBS gf180mcu_as_sc_mcu7t3v3__inv_2
Xgf180mcu_as_sc_mcu7t3v3__inv_2_1143 gf180mcu_as_sc_mcu7t3v3__inv_2_1143/VDD VSS gf180mcu_as_sc_mcu7t3v3__inv_2_1143/Y
+ gf180mcu_as_sc_mcu7t3v3__inv_2_1143/A gf180mcu_as_sc_mcu7t3v3__inv_2_1143/VNW VSUBS
+ gf180mcu_as_sc_mcu7t3v3__inv_2
Xgf180mcu_as_sc_mcu7t3v3__inv_2_1176 VSS VSS VSS VSS gf180mcu_as_sc_mcu7t3v3__inv_2_1177/VNW
+ VSUBS gf180mcu_as_sc_mcu7t3v3__inv_2
Xgf180mcu_as_sc_mcu7t3v3__inv_2_1154 VSS VSS VSS VSS gf180mcu_as_sc_mcu7t3v3__inv_2_1155/VNW
+ VSUBS gf180mcu_as_sc_mcu7t3v3__inv_2
Xgf180mcu_as_sc_mcu7t3v3__inv_2_1165 VSS VSS VSS VSS gf180mcu_as_sc_mcu7t3v3__inv_2_1172/VNW
+ VSUBS gf180mcu_as_sc_mcu7t3v3__inv_2
Xgf180mcu_as_sc_mcu7t3v3__inv_2_1187 VSS VSS VSS VSS gf180mcu_as_sc_mcu7t3v3__inv_2_1191/VNW
+ VSUBS gf180mcu_as_sc_mcu7t3v3__inv_2
Xu_t031_026 u_t031_026/c0_w0_bl u_t031_026/c0_w0_br u_t031_026/c0_w1_bl u_t031_026/c0_w1_br
+ u_t031_026/c0_r0_rbl u_t031_026/c0_r1_rbl u_t031_026/c1_w0_bl u_t031_026/c1_w0_br
+ u_t031_026/c1_w1_bl u_t031_026/c1_w1_br u_t031_026/c1_r0_rbl u_t031_026/c1_r1_rbl
+ u_t031_026/c2_w0_bl u_t031_026/c2_w0_br u_t031_026/c2_w1_bl u_t031_026/c2_w1_br
+ u_t031_026/c2_r0_rbl u_t031_026/c2_r1_rbl u_t031_026/c3_w0_bl u_t031_026/c3_w0_br
+ u_t031_026/c3_w1_bl u_t031_026/c3_w1_br u_t031_026/c3_r0_rbl u_t031_026/c3_r1_rbl
+ u_t031_026/r0_w0_wl u_t031_026/r0_w1_wl u_t031_026/r0_r0_rwl u_t031_026/r0_r1_rwl
+ u_t031_026/r1_w0_wl u_t031_026/r1_w1_wl u_t031_026/r1_r0_rwl u_t031_026/r1_r1_rwl
+ u_t031_026/r2_w0_wl u_t031_026/r2_w1_wl u_t031_026/r2_r0_rwl u_t031_026/r2_r1_rwl
+ u_t031_026/r3_w0_wl u_t031_026/r3_w1_wl u_t031_026/r3_r0_rwl u_t031_026/r3_r1_rwl
+ u_t031_026/VDD u_t031_026/VSS VSUBS detronyx_12t_2w2r_rc4_4x4_routed_5layer_direct
Xu_t016_023 u_t016_023/c0_w0_bl u_t016_023/c0_w0_br u_t016_023/c0_w1_bl u_t016_023/c0_w1_br
+ u_t016_023/c0_r0_rbl u_t016_023/c0_r1_rbl u_t016_023/c1_w0_bl u_t016_023/c1_w0_br
+ u_t016_023/c1_w1_bl u_t016_023/c1_w1_br u_t016_023/c1_r0_rbl u_t016_023/c1_r1_rbl
+ u_t016_023/c2_w0_bl u_t016_023/c2_w0_br u_t016_023/c2_w1_bl u_t016_023/c2_w1_br
+ u_t016_023/c2_r0_rbl u_t016_023/c2_r1_rbl u_t016_023/c3_w0_bl u_t016_023/c3_w0_br
+ u_t016_023/c3_w1_bl u_t016_023/c3_w1_br u_t016_023/c3_r0_rbl u_t016_023/c3_r1_rbl
+ u_t016_023/r0_w0_wl u_t016_023/r0_w1_wl u_t016_023/r0_r0_rwl u_t016_023/r0_r1_rwl
+ u_t016_023/r1_w0_wl u_t016_023/r1_w1_wl u_t016_023/r1_r0_rwl u_t016_023/r1_r1_rwl
+ u_t016_023/r2_w0_wl u_t016_023/r2_w1_wl u_t016_023/r2_r0_rwl u_t016_023/r2_r1_rwl
+ u_t016_023/r3_w0_wl u_t016_023/r3_w1_wl u_t016_023/r3_r0_rwl u_t016_023/r3_r1_rwl
+ VSS u_t016_024/VSS VSUBS detronyx_12t_2w2r_rc4_4x4_routed_5layer_direct
Xu_t031_015 u_t031_015/c0_w0_bl u_t031_015/c0_w0_br u_t031_015/c0_w1_bl u_t031_015/c0_w1_br
+ u_t031_015/c0_r0_rbl u_t031_015/c0_r1_rbl u_t031_015/c1_w0_bl u_t031_015/c1_w0_br
+ u_t031_015/c1_w1_bl u_t031_015/c1_w1_br u_t031_015/c1_r0_rbl u_t031_015/c1_r1_rbl
+ u_t031_015/c2_w0_bl u_t031_015/c2_w0_br u_t031_015/c2_w1_bl u_t031_015/c2_w1_br
+ u_t031_015/c2_r0_rbl u_t031_015/c2_r1_rbl u_t031_015/c3_w0_bl u_t031_015/c3_w0_br
+ u_t031_015/c3_w1_bl u_t031_015/c3_w1_br u_t031_015/c3_r0_rbl u_t031_015/c3_r1_rbl
+ u_t031_015/r0_w0_wl u_t031_015/r0_w1_wl u_t031_015/r0_r0_rwl u_t031_015/r0_r1_rwl
+ u_t031_015/r1_w0_wl u_t031_015/r1_w1_wl u_t031_015/r1_r0_rwl u_t031_015/r1_r1_rwl
+ u_t031_015/r2_w0_wl u_t031_015/r2_w1_wl u_t031_015/r2_r0_rwl u_t031_015/r2_r1_rwl
+ u_t031_015/r3_w0_wl u_t031_015/r3_w1_wl u_t031_015/r3_r0_rwl u_t031_015/r3_r1_rwl
+ VSS u_t031_017/VSS VSUBS detronyx_12t_2w2r_rc4_4x4_routed_5layer_direct
Xu_t016_012 u_t016_012/c0_w0_bl u_t016_012/c0_w0_br u_t016_012/c0_w1_bl u_t016_012/c0_w1_br
+ u_t016_012/c0_r0_rbl u_t016_012/c0_r1_rbl u_t016_012/c1_w0_bl u_t016_012/c1_w0_br
+ u_t016_012/c1_w1_bl u_t016_012/c1_w1_br u_t016_012/c1_r0_rbl u_t016_012/c1_r1_rbl
+ u_t016_012/c2_w0_bl u_t016_012/c2_w0_br u_t016_012/c2_w1_bl u_t016_012/c2_w1_br
+ u_t016_012/c2_r0_rbl u_t016_012/c2_r1_rbl u_t016_012/c3_w0_bl u_t016_012/c3_w0_br
+ u_t016_012/c3_w1_bl u_t016_012/c3_w1_br u_t016_012/c3_r0_rbl u_t016_012/c3_r1_rbl
+ u_t016_012/r0_w0_wl u_t016_012/r0_w1_wl u_t016_012/r0_r0_rwl u_t016_012/r0_r1_rwl
+ u_t016_012/r1_w0_wl u_t016_012/r1_w1_wl u_t016_012/r1_r0_rwl u_t016_012/r1_r1_rwl
+ u_t016_012/r2_w0_wl u_t016_012/r2_w1_wl u_t016_012/r2_r0_rwl u_t016_012/r2_r1_rwl
+ u_t016_012/r3_w0_wl u_t016_012/r3_w1_wl u_t016_012/r3_r0_rwl u_t016_012/r3_r1_rwl
+ u_t016_012/VDD u_t016_012/VSS VSUBS detronyx_12t_2w2r_rc4_4x4_routed_5layer_direct
Xu_t031_004 u_t031_004/c0_w0_bl u_t031_004/c0_w0_br u_t031_004/c0_w1_bl u_t031_004/c0_w1_br
+ u_t031_004/c0_r0_rbl u_t031_004/c0_r1_rbl u_t031_004/c1_w0_bl u_t031_004/c1_w0_br
+ u_t031_004/c1_w1_bl u_t031_004/c1_w1_br u_t031_004/c1_r0_rbl u_t031_004/c1_r1_rbl
+ u_t031_004/c2_w0_bl u_t031_004/c2_w0_br u_t031_004/c2_w1_bl u_t031_004/c2_w1_br
+ u_t031_004/c2_r0_rbl u_t031_004/c2_r1_rbl u_t031_004/c3_w0_bl u_t031_004/c3_w0_br
+ u_t031_004/c3_w1_bl u_t031_004/c3_w1_br u_t031_004/c3_r0_rbl u_t031_004/c3_r1_rbl
+ u_t031_004/r0_w0_wl u_t031_004/r0_w1_wl u_t031_004/r0_r0_rwl u_t031_004/r0_r1_rwl
+ u_t031_004/r1_w0_wl u_t031_004/r1_w1_wl u_t031_004/r1_r0_rwl u_t031_004/r1_r1_rwl
+ u_t031_004/r2_w0_wl u_t031_004/r2_w1_wl u_t031_004/r2_r0_rwl u_t031_004/r2_r1_rwl
+ u_t031_004/r3_w0_wl u_t031_004/r3_w1_wl u_t031_004/r3_r0_rwl u_t031_004/r3_r1_rwl
+ u_t031_004/VDD u_t031_004/VSS VSUBS detronyx_12t_2w2r_rc4_4x4_routed_5layer_direct
Xu_t016_001 u_t016_001/c0_w0_bl u_t016_001/c0_w0_br u_t016_001/c0_w1_bl u_t016_001/c0_w1_br
+ u_t016_001/c0_r0_rbl u_t016_001/c0_r1_rbl u_t016_001/c1_w0_bl u_t016_001/c1_w0_br
+ u_t016_001/c1_w1_bl u_t016_001/c1_w1_br u_t016_001/c1_r0_rbl u_t016_001/c1_r1_rbl
+ u_t016_001/c2_w0_bl u_t016_001/c2_w0_br u_t016_001/c2_w1_bl u_t016_001/c2_w1_br
+ u_t016_001/c2_r0_rbl u_t016_001/c2_r1_rbl u_t016_001/c3_w0_bl u_t016_001/c3_w0_br
+ u_t016_001/c3_w1_bl u_t016_001/c3_w1_br u_t016_001/c3_r0_rbl u_t016_001/c3_r1_rbl
+ u_t016_001/r0_w0_wl u_t016_001/r0_w1_wl u_t016_001/r0_r0_rwl u_t016_001/r0_r1_rwl
+ u_t016_001/r1_w0_wl u_t016_001/r1_w1_wl u_t016_001/r1_r0_rwl u_t016_001/r1_r1_rwl
+ u_t016_001/r2_w0_wl u_t016_001/r2_w1_wl u_t016_001/r2_r0_rwl u_t016_001/r2_r1_rwl
+ u_t016_001/r3_w0_wl u_t016_001/r3_w1_wl u_t016_001/r3_r0_rwl u_t016_001/r3_r1_rwl
+ VSS u_t016_002/VSS VSUBS detronyx_12t_2w2r_rc4_4x4_routed_5layer_direct
Xgf180mcu_as_sc_mcu7t3v3__inv_2_605 VSS gf180mcu_as_sc_mcu7t3v3__inv_2_626/VDD gf180mcu_as_sc_mcu7t3v3__inv_2_605/Y
+ gf180mcu_as_sc_mcu7t3v3__inv_2_631/A gf180mcu_as_sc_mcu7t3v3__inv_2_613/VNW VSUBS
+ gf180mcu_as_sc_mcu7t3v3__inv_2
Xgf180mcu_as_sc_mcu7t3v3__inv_2_627 gf180mcu_as_sc_mcu7t3v3__inv_2_629/VDD gf180mcu_as_sc_mcu7t3v3__inv_2_633/VDD
+ gf180mcu_as_sc_mcu7t3v3__inv_2_627/Y gf180mcu_as_sc_mcu7t3v3__inv_2_631/A gf180mcu_as_sc_mcu7t3v3__inv_2_629/VNW
+ VSUBS gf180mcu_as_sc_mcu7t3v3__inv_2
Xgf180mcu_as_sc_mcu7t3v3__inv_2_616 gf180mcu_as_sc_mcu7t3v3__inv_2_616/VDD gf180mcu_as_sc_mcu7t3v3__inv_2_620/VDD
+ gf180mcu_as_sc_mcu7t3v3__inv_2_616/Y VSS gf180mcu_as_sc_mcu7t3v3__inv_2_616/VNW
+ VSUBS gf180mcu_as_sc_mcu7t3v3__inv_2
Xgf180mcu_as_sc_mcu7t3v3__inv_2_638 VSS gf180mcu_as_sc_mcu7t3v3__inv_2_667/VDD gf180mcu_as_sc_mcu7t3v3__inv_2_638/Y
+ gf180mcu_as_sc_mcu7t3v3__inv_2_639/Y gf180mcu_as_sc_mcu7t3v3__inv_2_639/VNW VSUBS
+ gf180mcu_as_sc_mcu7t3v3__inv_2
Xgf180mcu_as_sc_mcu7t3v3__inv_2_649 gf180mcu_as_sc_mcu7t3v3__inv_2_651/VDD VSS gf180mcu_as_sc_mcu7t3v3__inv_2_649/Y
+ gf180mcu_as_sc_mcu7t3v3__inv_2_739/A gf180mcu_as_sc_mcu7t3v3__inv_2_651/VNW VSUBS
+ gf180mcu_as_sc_mcu7t3v3__inv_2
Xu_t007_023 u_t007_023/c0_w0_bl u_t007_023/c0_w0_br u_t007_023/c0_w1_bl u_t007_023/c0_w1_br
+ u_t007_023/c0_r0_rbl u_t007_023/c0_r1_rbl u_t007_023/c1_w0_bl u_t007_023/c1_w0_br
+ u_t007_023/c1_w1_bl u_t007_023/c1_w1_br u_t007_023/c1_r0_rbl u_t007_023/c1_r1_rbl
+ u_t007_023/c2_w0_bl u_t007_023/c2_w0_br u_t007_023/c2_w1_bl u_t007_023/c2_w1_br
+ u_t007_023/c2_r0_rbl u_t007_023/c2_r1_rbl u_t007_023/c3_w0_bl u_t007_023/c3_w0_br
+ u_t007_023/c3_w1_bl u_t007_023/c3_w1_br u_t007_023/c3_r0_rbl u_t007_023/c3_r1_rbl
+ u_t007_023/r0_w0_wl u_t007_023/r0_w1_wl u_t007_023/r0_r0_rwl u_t007_023/r0_r1_rwl
+ u_t007_023/r1_w0_wl u_t007_023/r1_w1_wl u_t007_023/r1_r0_rwl u_t007_023/r1_r1_rwl
+ u_t007_023/r2_w0_wl u_t007_023/r2_w1_wl u_t007_023/r2_r0_rwl u_t007_023/r2_r1_rwl
+ u_t007_023/r3_w0_wl u_t007_023/r3_w1_wl u_t007_023/r3_r0_rwl u_t007_023/r3_r1_rwl
+ VSS u_t007_024/VSS VSUBS detronyx_12t_2w2r_rc4_4x4_routed_5layer_direct
Xu_t007_012 u_t007_012/c0_w0_bl u_t007_012/c0_w0_br u_t007_012/c0_w1_bl u_t007_012/c0_w1_br
+ u_t007_012/c0_r0_rbl u_t007_012/c0_r1_rbl u_t007_012/c1_w0_bl u_t007_012/c1_w0_br
+ u_t007_012/c1_w1_bl u_t007_012/c1_w1_br u_t007_012/c1_r0_rbl u_t007_012/c1_r1_rbl
+ u_t007_012/c2_w0_bl u_t007_012/c2_w0_br u_t007_012/c2_w1_bl u_t007_012/c2_w1_br
+ u_t007_012/c2_r0_rbl u_t007_012/c2_r1_rbl u_t007_012/c3_w0_bl u_t007_012/c3_w0_br
+ u_t007_012/c3_w1_bl u_t007_012/c3_w1_br u_t007_012/c3_r0_rbl u_t007_012/c3_r1_rbl
+ u_t007_012/r0_w0_wl u_t007_012/r0_w1_wl u_t007_012/r0_r0_rwl u_t007_012/r0_r1_rwl
+ u_t007_012/r1_w0_wl u_t007_012/r1_w1_wl u_t007_012/r1_r0_rwl u_t007_012/r1_r1_rwl
+ u_t007_012/r2_w0_wl u_t007_012/r2_w1_wl u_t007_012/r2_r0_rwl u_t007_012/r2_r1_rwl
+ u_t007_012/r3_w0_wl u_t007_012/r3_w1_wl u_t007_012/r3_r0_rwl u_t007_012/r3_r1_rwl
+ u_t008_012/VDD u_t007_012/VSS VSUBS detronyx_12t_2w2r_rc4_4x4_routed_5layer_direct
Xu_t007_001 u_t007_001/c0_w0_bl u_t007_001/c0_w0_br u_t007_001/c0_w1_bl u_t007_001/c0_w1_br
+ u_t007_001/c0_r0_rbl u_t007_001/c0_r1_rbl u_t007_001/c1_w0_bl u_t007_001/c1_w0_br
+ u_t007_001/c1_w1_bl u_t007_001/c1_w1_br u_t007_001/c1_r0_rbl u_t007_001/c1_r1_rbl
+ u_t007_001/c2_w0_bl u_t007_001/c2_w0_br u_t007_001/c2_w1_bl u_t007_001/c2_w1_br
+ u_t007_001/c2_r0_rbl u_t007_001/c2_r1_rbl u_t007_001/c3_w0_bl u_t007_001/c3_w0_br
+ u_t007_001/c3_w1_bl u_t007_001/c3_w1_br u_t007_001/c3_r0_rbl u_t007_001/c3_r1_rbl
+ u_t007_001/r0_w0_wl u_t007_001/r0_w1_wl u_t007_001/r0_r0_rwl u_t007_001/r0_r1_rwl
+ u_t007_001/r1_w0_wl u_t007_001/r1_w1_wl u_t007_001/r1_r0_rwl u_t007_001/r1_r1_rwl
+ u_t007_001/r2_w0_wl u_t007_001/r2_w1_wl u_t007_001/r2_r0_rwl u_t007_001/r2_r1_rwl
+ u_t007_001/r3_w0_wl u_t007_001/r3_w1_wl u_t007_001/r3_r0_rwl u_t007_001/r3_r1_rwl
+ VSS u_t007_002/VSS VSUBS detronyx_12t_2w2r_rc4_4x4_routed_5layer_direct
Xu_t022_026 u_t022_026/c0_w0_bl u_t022_026/c0_w0_br u_t022_026/c0_w1_bl u_t022_026/c0_w1_br
+ u_t022_026/c0_r0_rbl u_t022_026/c0_r1_rbl u_t022_026/c1_w0_bl u_t022_026/c1_w0_br
+ u_t022_026/c1_w1_bl u_t022_026/c1_w1_br u_t022_026/c1_r0_rbl u_t022_026/c1_r1_rbl
+ u_t022_026/c2_w0_bl u_t022_026/c2_w0_br u_t022_026/c2_w1_bl u_t022_026/c2_w1_br
+ u_t022_026/c2_r0_rbl u_t022_026/c2_r1_rbl u_t022_026/c3_w0_bl u_t022_026/c3_w0_br
+ u_t022_026/c3_w1_bl u_t022_026/c3_w1_br u_t022_026/c3_r0_rbl u_t022_026/c3_r1_rbl
+ u_t022_026/r0_w0_wl u_t022_026/r0_w1_wl u_t022_026/r0_r0_rwl u_t022_026/r0_r1_rwl
+ u_t022_026/r1_w0_wl u_t022_026/r1_w1_wl u_t022_026/r1_r0_rwl u_t022_026/r1_r1_rwl
+ u_t022_026/r2_w0_wl u_t022_026/r2_w1_wl u_t022_026/r2_r0_rwl u_t022_026/r2_r1_rwl
+ u_t022_026/r3_w0_wl u_t022_026/r3_w1_wl u_t022_026/r3_r0_rwl u_t022_026/r3_r1_rwl
+ u_t022_026/VDD u_t022_031/VSS VSUBS detronyx_12t_2w2r_rc4_4x4_routed_5layer_direct
Xu_t022_015 u_t022_015/c0_w0_bl u_t022_015/c0_w0_br u_t022_015/c0_w1_bl u_t022_015/c0_w1_br
+ u_t022_015/c0_r0_rbl u_t022_015/c0_r1_rbl u_t022_015/c1_w0_bl u_t022_015/c1_w0_br
+ u_t022_015/c1_w1_bl u_t022_015/c1_w1_br u_t022_015/c1_r0_rbl u_t022_015/c1_r1_rbl
+ u_t022_015/c2_w0_bl u_t022_015/c2_w0_br u_t022_015/c2_w1_bl u_t022_015/c2_w1_br
+ u_t022_015/c2_r0_rbl u_t022_015/c2_r1_rbl u_t022_015/c3_w0_bl u_t022_015/c3_w0_br
+ u_t022_015/c3_w1_bl u_t022_015/c3_w1_br u_t022_015/c3_r0_rbl u_t022_015/c3_r1_rbl
+ u_t022_015/r0_w0_wl u_t022_015/r0_w1_wl u_t022_015/r0_r0_rwl u_t022_015/r0_r1_rwl
+ u_t022_015/r1_w0_wl u_t022_015/r1_w1_wl u_t022_015/r1_r0_rwl u_t022_015/r1_r1_rwl
+ u_t022_015/r2_w0_wl u_t022_015/r2_w1_wl u_t022_015/r2_r0_rwl u_t022_015/r2_r1_rwl
+ u_t022_015/r3_w0_wl u_t022_015/r3_w1_wl u_t022_015/r3_r0_rwl u_t022_015/r3_r1_rwl
+ VSS u_t022_031/VSS VSUBS detronyx_12t_2w2r_rc4_4x4_routed_5layer_direct
Xu_t022_004 u_t022_004/c0_w0_bl u_t022_004/c0_w0_br u_t022_004/c0_w1_bl u_t022_004/c0_w1_br
+ u_t022_004/c0_r0_rbl u_t022_004/c0_r1_rbl u_t022_004/c1_w0_bl u_t022_004/c1_w0_br
+ u_t022_004/c1_w1_bl u_t022_004/c1_w1_br u_t022_004/c1_r0_rbl u_t022_004/c1_r1_rbl
+ u_t022_004/c2_w0_bl u_t022_004/c2_w0_br u_t022_004/c2_w1_bl u_t022_004/c2_w1_br
+ u_t022_004/c2_r0_rbl u_t022_004/c2_r1_rbl u_t022_004/c3_w0_bl u_t022_004/c3_w0_br
+ u_t022_004/c3_w1_bl u_t022_004/c3_w1_br u_t022_004/c3_r0_rbl u_t022_004/c3_r1_rbl
+ u_t022_004/r0_w0_wl u_t022_004/r0_w1_wl u_t022_004/r0_r0_rwl u_t022_004/r0_r1_rwl
+ u_t022_004/r1_w0_wl u_t022_004/r1_w1_wl u_t022_004/r1_r0_rwl u_t022_004/r1_r1_rwl
+ u_t022_004/r2_w0_wl u_t022_004/r2_w1_wl u_t022_004/r2_r0_rwl u_t022_004/r2_r1_rwl
+ u_t022_004/r3_w0_wl u_t022_004/r3_w1_wl u_t022_004/r3_r0_rwl u_t022_004/r3_r1_rwl
+ u_t022_004/VDD u_t022_031/VSS VSUBS detronyx_12t_2w2r_rc4_4x4_routed_5layer_direct
Xgf180mcu_as_sc_mcu7t3v3__nand4_2_460 gf180mcu_as_sc_mcu7t3v3__inv_2_1589/VDD gf180mcu_as_sc_mcu7t3v3__inv_2_1589/VSS
+ VSS VSS VSS VSS gf180mcu_as_sc_mcu7t3v3__nand4_2_460/Y gf180mcu_as_sc_mcu7t3v3__inv_2_1589/VNW
+ VSUBS gf180mcu_as_sc_mcu7t3v3__nand4_2
Xgf180mcu_as_sc_mcu7t3v3__nand4_2_471 VSS VSS VSS VSS VSS VSS VSS gf180mcu_as_sc_mcu7t3v3__inv_2_1553/VNW
+ VSUBS gf180mcu_as_sc_mcu7t3v3__nand4_2
Xu_t013_015 u_t013_015/c0_w0_bl u_t013_015/c0_w0_br u_t013_015/c0_w1_bl u_t013_015/c0_w1_br
+ u_t013_015/c0_r0_rbl u_t013_015/c0_r1_rbl u_t013_015/c1_w0_bl u_t013_015/c1_w0_br
+ u_t013_015/c1_w1_bl u_t013_015/c1_w1_br u_t013_015/c1_r0_rbl u_t013_015/c1_r1_rbl
+ u_t013_015/c2_w0_bl u_t013_015/c2_w0_br u_t013_015/c2_w1_bl u_t013_015/c2_w1_br
+ u_t013_015/c2_r0_rbl u_t013_015/c2_r1_rbl u_t013_015/c3_w0_bl u_t013_015/c3_w0_br
+ u_t013_015/c3_w1_bl u_t013_015/c3_w1_br u_t013_015/c3_r0_rbl u_t013_015/c3_r1_rbl
+ u_t013_015/r0_w0_wl u_t013_015/r0_w1_wl u_t013_015/r0_r0_rwl u_t013_015/r0_r1_rwl
+ u_t013_015/r1_w0_wl u_t013_015/r1_w1_wl u_t013_015/r1_r0_rwl u_t013_015/r1_r1_rwl
+ u_t013_015/r2_w0_wl u_t013_015/r2_w1_wl u_t013_015/r2_r0_rwl u_t013_015/r2_r1_rwl
+ u_t013_015/r3_w0_wl u_t013_015/r3_w1_wl u_t013_015/r3_r0_rwl u_t013_015/r3_r1_rwl
+ VSS u_t013_031/VSS VSUBS detronyx_12t_2w2r_rc4_4x4_routed_5layer_direct
Xu_t013_004 u_t013_004/c0_w0_bl u_t013_004/c0_w0_br u_t013_004/c0_w1_bl u_t013_004/c0_w1_br
+ u_t013_004/c0_r0_rbl u_t013_004/c0_r1_rbl u_t013_004/c1_w0_bl u_t013_004/c1_w0_br
+ u_t013_004/c1_w1_bl u_t013_004/c1_w1_br u_t013_004/c1_r0_rbl u_t013_004/c1_r1_rbl
+ u_t013_004/c2_w0_bl u_t013_004/c2_w0_br u_t013_004/c2_w1_bl u_t013_004/c2_w1_br
+ u_t013_004/c2_r0_rbl u_t013_004/c2_r1_rbl u_t013_004/c3_w0_bl u_t013_004/c3_w0_br
+ u_t013_004/c3_w1_bl u_t013_004/c3_w1_br u_t013_004/c3_r0_rbl u_t013_004/c3_r1_rbl
+ u_t013_004/r0_w0_wl u_t013_004/r0_w1_wl u_t013_004/r0_r0_rwl u_t013_004/r0_r1_rwl
+ u_t013_004/r1_w0_wl u_t013_004/r1_w1_wl u_t013_004/r1_r0_rwl u_t013_004/r1_r1_rwl
+ u_t013_004/r2_w0_wl u_t013_004/r2_w1_wl u_t013_004/r2_r0_rwl u_t013_004/r2_r1_rwl
+ u_t013_004/r3_w0_wl u_t013_004/r3_w1_wl u_t013_004/r3_r0_rwl u_t013_004/r3_r1_rwl
+ u_t013_004/VDD u_t013_031/VSS VSUBS detronyx_12t_2w2r_rc4_4x4_routed_5layer_direct
Xgf180mcu_as_sc_mcu7t3v3__nand4_2_493 gf180mcu_as_sc_mcu7t3v3__inv_2_1665/VDD VSS
+ VSS VSS VSS VSS VSS gf180mcu_as_sc_mcu7t3v3__inv_2_1665/VNW VSUBS gf180mcu_as_sc_mcu7t3v3__nand4_2
Xgf180mcu_as_sc_mcu7t3v3__nand4_2_482 VSS gf180mcu_as_sc_mcu7t3v3__inv_2_1653/VDD
+ VSS VSS VSS VSS VSS gf180mcu_as_sc_mcu7t3v3__inv_2_1652/VNW VSUBS gf180mcu_as_sc_mcu7t3v3__nand4_2
Xu_t013_026 u_t013_026/c0_w0_bl u_t013_026/c0_w0_br u_t013_026/c0_w1_bl u_t013_026/c0_w1_br
+ u_t013_026/c0_r0_rbl u_t013_026/c0_r1_rbl u_t013_026/c1_w0_bl u_t013_026/c1_w0_br
+ u_t013_026/c1_w1_bl u_t013_026/c1_w1_br u_t013_026/c1_r0_rbl u_t013_026/c1_r1_rbl
+ u_t013_026/c2_w0_bl u_t013_026/c2_w0_br u_t013_026/c2_w1_bl u_t013_026/c2_w1_br
+ u_t013_026/c2_r0_rbl u_t013_026/c2_r1_rbl u_t013_026/c3_w0_bl u_t013_026/c3_w0_br
+ u_t013_026/c3_w1_bl u_t013_026/c3_w1_br u_t013_026/c3_r0_rbl u_t013_026/c3_r1_rbl
+ u_t013_026/r0_w0_wl u_t013_026/r0_w1_wl u_t013_026/r0_r0_rwl u_t013_026/r0_r1_rwl
+ u_t013_026/r1_w0_wl u_t013_026/r1_w1_wl u_t013_026/r1_r0_rwl u_t013_026/r1_r1_rwl
+ u_t013_026/r2_w0_wl u_t013_026/r2_w1_wl u_t013_026/r2_r0_rwl u_t013_026/r2_r1_rwl
+ u_t013_026/r3_w0_wl u_t013_026/r3_w1_wl u_t013_026/r3_r0_rwl u_t013_026/r3_r1_rwl
+ u_t013_026/VDD u_t013_031/VSS VSUBS detronyx_12t_2w2r_rc4_4x4_routed_5layer_direct
Xgf180mcu_as_sc_mcu7t3v3__inv_2_402 gf180mcu_as_sc_mcu7t3v3__nor2_2_4/VDD gf180mcu_as_sc_mcu7t3v3__nor2_2_4/VSS
+ VSS VSS gf180mcu_as_sc_mcu7t3v3__nor2_2_4/VNW VSUBS gf180mcu_as_sc_mcu7t3v3__inv_2
Xu_t004_026 u_t004_026/c0_w0_bl u_t004_026/c0_w0_br u_t004_026/c0_w1_bl u_t004_026/c0_w1_br
+ u_t004_026/c0_r0_rbl u_t004_026/c0_r1_rbl u_t004_026/c1_w0_bl u_t004_026/c1_w0_br
+ u_t004_026/c1_w1_bl u_t004_026/c1_w1_br u_t004_026/c1_r0_rbl u_t004_026/c1_r1_rbl
+ u_t004_026/c2_w0_bl u_t004_026/c2_w0_br u_t004_026/c2_w1_bl u_t004_026/c2_w1_br
+ u_t004_026/c2_r0_rbl u_t004_026/c2_r1_rbl u_t004_026/c3_w0_bl u_t004_026/c3_w0_br
+ u_t004_026/c3_w1_bl u_t004_026/c3_w1_br u_t004_026/c3_r0_rbl u_t004_026/c3_r1_rbl
+ u_t004_026/r0_w0_wl u_t004_026/r0_w1_wl u_t004_026/r0_r0_rwl u_t004_026/r0_r1_rwl
+ u_t004_026/r1_w0_wl u_t004_026/r1_w1_wl u_t004_026/r1_r0_rwl u_t004_026/r1_r1_rwl
+ u_t004_026/r2_w0_wl u_t004_026/r2_w1_wl u_t004_026/r2_r0_rwl u_t004_026/r2_r1_rwl
+ u_t004_026/r3_w0_wl u_t004_026/r3_w1_wl u_t004_026/r3_r0_rwl u_t004_026/r3_r1_rwl
+ u_t004_026/VDD u_t004_031/VSS VSUBS detronyx_12t_2w2r_rc4_4x4_routed_5layer_direct
Xu_t004_015 u_t004_015/c0_w0_bl u_t004_015/c0_w0_br u_t004_015/c0_w1_bl u_t004_015/c0_w1_br
+ u_t004_015/c0_r0_rbl u_t004_015/c0_r1_rbl u_t004_015/c1_w0_bl u_t004_015/c1_w0_br
+ u_t004_015/c1_w1_bl u_t004_015/c1_w1_br u_t004_015/c1_r0_rbl u_t004_015/c1_r1_rbl
+ u_t004_015/c2_w0_bl u_t004_015/c2_w0_br u_t004_015/c2_w1_bl u_t004_015/c2_w1_br
+ u_t004_015/c2_r0_rbl u_t004_015/c2_r1_rbl u_t004_015/c3_w0_bl u_t004_015/c3_w0_br
+ u_t004_015/c3_w1_bl u_t004_015/c3_w1_br u_t004_015/c3_r0_rbl u_t004_015/c3_r1_rbl
+ u_t004_015/r0_w0_wl u_t004_015/r0_w1_wl u_t004_015/r0_r0_rwl u_t004_015/r0_r1_rwl
+ u_t004_015/r1_w0_wl u_t004_015/r1_w1_wl u_t004_015/r1_r0_rwl u_t004_015/r1_r1_rwl
+ u_t004_015/r2_w0_wl u_t004_015/r2_w1_wl u_t004_015/r2_r0_rwl u_t004_015/r2_r1_rwl
+ u_t004_015/r3_w0_wl u_t004_015/r3_w1_wl u_t004_015/r3_r0_rwl u_t004_015/r3_r1_rwl
+ VSS u_t004_031/VSS VSUBS detronyx_12t_2w2r_rc4_4x4_routed_5layer_direct
Xu_t004_004 u_t004_004/c0_w0_bl u_t004_004/c0_w0_br u_t004_004/c0_w1_bl u_t004_004/c0_w1_br
+ u_t004_004/c0_r0_rbl u_t004_004/c0_r1_rbl u_t004_004/c1_w0_bl u_t004_004/c1_w0_br
+ u_t004_004/c1_w1_bl u_t004_004/c1_w1_br u_t004_004/c1_r0_rbl u_t004_004/c1_r1_rbl
+ u_t004_004/c2_w0_bl u_t004_004/c2_w0_br u_t004_004/c2_w1_bl u_t004_004/c2_w1_br
+ u_t004_004/c2_r0_rbl u_t004_004/c2_r1_rbl u_t004_004/c3_w0_bl u_t004_004/c3_w0_br
+ u_t004_004/c3_w1_bl u_t004_004/c3_w1_br u_t004_004/c3_r0_rbl u_t004_004/c3_r1_rbl
+ u_t004_004/r0_w0_wl u_t004_004/r0_w1_wl u_t004_004/r0_r0_rwl u_t004_004/r0_r1_rwl
+ u_t004_004/r1_w0_wl u_t004_004/r1_w1_wl u_t004_004/r1_r0_rwl u_t004_004/r1_r1_rwl
+ u_t004_004/r2_w0_wl u_t004_004/r2_w1_wl u_t004_004/r2_r0_rwl u_t004_004/r2_r1_rwl
+ u_t004_004/r3_w0_wl u_t004_004/r3_w1_wl u_t004_004/r3_r0_rwl u_t004_004/r3_r1_rwl
+ u_t004_004/VDD u_t004_031/VSS VSUBS detronyx_12t_2w2r_rc4_4x4_routed_5layer_direct
Xgf180mcu_as_sc_mcu7t3v3__inv_2_413 VSS VSS gf180mcu_as_sc_mcu7t3v3__inv_2_413/Y VSS
+ gf180mcu_as_sc_mcu7t3v3__inv_2_443/VNW VSUBS gf180mcu_as_sc_mcu7t3v3__inv_2
Xgf180mcu_as_sc_mcu7t3v3__inv_2_446 VSS VSS VSS VSS gf180mcu_as_sc_mcu7t3v3__inv_2_447/VNW
+ VSUBS gf180mcu_as_sc_mcu7t3v3__inv_2
Xgf180mcu_as_sc_mcu7t3v3__inv_2_435 VSS VSS gf180mcu_as_sc_mcu7t3v3__inv_2_435/Y VSS
+ gf180mcu_as_sc_mcu7t3v3__inv_2_437/VNW VSUBS gf180mcu_as_sc_mcu7t3v3__inv_2
Xgf180mcu_as_sc_mcu7t3v3__inv_2_424 gf180mcu_as_sc_mcu7t3v3__nor2_2_5/VDD gf180mcu_as_sc_mcu7t3v3__nand3_2_8/VSS
+ VSS VSS gf180mcu_as_sc_mcu7t3v3__nor2_2_5/VNW VSUBS gf180mcu_as_sc_mcu7t3v3__inv_2
Xgf180mcu_as_sc_mcu7t3v3__inv_2_468 gf180mcu_as_sc_mcu7t3v3__nor2_2_5/VDD gf180mcu_as_sc_mcu7t3v3__nand3_2_8/VSS
+ VSS VSS gf180mcu_as_sc_mcu7t3v3__nor2_2_5/VNW VSUBS gf180mcu_as_sc_mcu7t3v3__inv_2
Xgf180mcu_as_sc_mcu7t3v3__inv_2_479 gf180mcu_as_sc_mcu7t3v3__nor2_2_6/VDD gf180mcu_as_sc_mcu7t3v3__nor2_2_6/VSS
+ VSS VSS gf180mcu_as_sc_mcu7t3v3__nor2_2_6/VNW VSUBS gf180mcu_as_sc_mcu7t3v3__inv_2
Xgf180mcu_as_sc_mcu7t3v3__inv_2_457 gf180mcu_as_sc_mcu7t3v3__nand3_2_5/VDD gf180mcu_as_sc_mcu7t3v3__nor2_2_6/VSS
+ VSS VSS gf180mcu_as_sc_mcu7t3v3__nand3_2_5/VNW VSUBS gf180mcu_as_sc_mcu7t3v3__inv_2
Xu_t010_029 u_t010_029/c0_w0_bl u_t010_029/c0_w0_br u_t010_029/c0_w1_bl u_t010_029/c0_w1_br
+ u_t010_029/c0_r0_rbl u_t010_029/c0_r1_rbl u_t010_029/c1_w0_bl u_t010_029/c1_w0_br
+ u_t010_029/c1_w1_bl u_t010_029/c1_w1_br u_t010_029/c1_r0_rbl u_t010_029/c1_r1_rbl
+ u_t010_029/c2_w0_bl u_t010_029/c2_w0_br u_t010_029/c2_w1_bl u_t010_029/c2_w1_br
+ u_t010_029/c2_r0_rbl u_t010_029/c2_r1_rbl u_t010_029/c3_w0_bl u_t010_029/c3_w0_br
+ u_t010_029/c3_w1_bl u_t010_029/c3_w1_br u_t010_029/c3_r0_rbl u_t010_029/c3_r1_rbl
+ u_t010_029/r0_w0_wl u_t010_029/r0_w1_wl u_t010_029/r0_r0_rwl u_t010_029/r0_r1_rwl
+ u_t010_029/r1_w0_wl u_t010_029/r1_w1_wl u_t010_029/r1_r0_rwl u_t010_029/r1_r1_rwl
+ u_t010_029/r2_w0_wl u_t010_029/r2_w1_wl u_t010_029/r2_r0_rwl u_t010_029/r2_r1_rwl
+ u_t010_029/r3_w0_wl u_t010_029/r3_w1_wl u_t010_029/r3_r0_rwl u_t010_029/r3_r1_rwl
+ u_t010_029/VDD u_t010_031/VSS VSUBS detronyx_12t_2w2r_rc4_4x4_routed_5layer_direct
Xu_t010_018 u_t010_018/c0_w0_bl u_t010_018/c0_w0_br u_t010_018/c0_w1_bl u_t010_018/c0_w1_br
+ u_t010_018/c0_r0_rbl u_t010_018/c0_r1_rbl u_t010_018/c1_w0_bl u_t010_018/c1_w0_br
+ u_t010_018/c1_w1_bl u_t010_018/c1_w1_br u_t010_018/c1_r0_rbl u_t010_018/c1_r1_rbl
+ u_t010_018/c2_w0_bl u_t010_018/c2_w0_br u_t010_018/c2_w1_bl u_t010_018/c2_w1_br
+ u_t010_018/c2_r0_rbl u_t010_018/c2_r1_rbl u_t010_018/c3_w0_bl u_t010_018/c3_w0_br
+ u_t010_018/c3_w1_bl u_t010_018/c3_w1_br u_t010_018/c3_r0_rbl u_t010_018/c3_r1_rbl
+ u_t010_018/r0_w0_wl u_t010_018/r0_w1_wl u_t010_018/r0_r0_rwl u_t010_018/r0_r1_rwl
+ u_t010_018/r1_w0_wl u_t010_018/r1_w1_wl u_t010_018/r1_r0_rwl u_t010_018/r1_r1_rwl
+ u_t010_018/r2_w0_wl u_t010_018/r2_w1_wl u_t010_018/r2_r0_rwl u_t010_018/r2_r1_rwl
+ u_t010_018/r3_w0_wl u_t010_018/r3_w1_wl u_t010_018/r3_r0_rwl u_t010_018/r3_r1_rwl
+ u_t010_018/VDD u_t010_018/VSS VSUBS detronyx_12t_2w2r_rc4_4x4_routed_5layer_direct
Xu_t010_007 u_t010_007/c0_w0_bl u_t010_007/c0_w0_br u_t010_007/c0_w1_bl u_t010_007/c0_w1_br
+ u_t010_007/c0_r0_rbl u_t010_007/c0_r1_rbl u_t010_007/c1_w0_bl u_t010_007/c1_w0_br
+ u_t010_007/c1_w1_bl u_t010_007/c1_w1_br u_t010_007/c1_r0_rbl u_t010_007/c1_r1_rbl
+ u_t010_007/c2_w0_bl u_t010_007/c2_w0_br u_t010_007/c2_w1_bl u_t010_007/c2_w1_br
+ u_t010_007/c2_r0_rbl u_t010_007/c2_r1_rbl u_t010_007/c3_w0_bl u_t010_007/c3_w0_br
+ u_t010_007/c3_w1_bl u_t010_007/c3_w1_br u_t010_007/c3_r0_rbl u_t010_007/c3_r1_rbl
+ u_t010_007/r0_w0_wl u_t010_007/r0_w1_wl u_t010_007/r0_r0_rwl u_t010_007/r0_r1_rwl
+ u_t010_007/r1_w0_wl u_t010_007/r1_w1_wl u_t010_007/r1_r0_rwl u_t010_007/r1_r1_rwl
+ u_t010_007/r2_w0_wl u_t010_007/r2_w1_wl u_t010_007/r2_r0_rwl u_t010_007/r2_r1_rwl
+ u_t010_007/r3_w0_wl u_t010_007/r3_w1_wl u_t010_007/r3_r0_rwl u_t010_007/r3_r1_rwl
+ VSS u_t010_009/VSS VSUBS detronyx_12t_2w2r_rc4_4x4_routed_5layer_direct
Xgf180mcu_as_sc_mcu7t3v3__inv_2_980 gf180mcu_as_sc_mcu7t3v3__inv_2_982/VDD VSS VSS
+ gf180mcu_as_sc_mcu7t3v3__inv_2_991/A gf180mcu_as_sc_mcu7t3v3__inv_2_982/VNW VSUBS
+ gf180mcu_as_sc_mcu7t3v3__inv_2
Xgf180mcu_as_sc_mcu7t3v3__inv_2_991 VSS gf180mcu_as_sc_mcu7t3v3__inv_2_999/VSS VSS
+ gf180mcu_as_sc_mcu7t3v3__inv_2_991/A gf180mcu_as_sc_mcu7t3v3__inv_2_999/VNW VSUBS
+ gf180mcu_as_sc_mcu7t3v3__inv_2
Xgf180mcu_as_sc_mcu7t3v3__nand4_2_290 gf180mcu_as_sc_mcu7t3v3__inv_2_978/VDD gf180mcu_as_sc_mcu7t3v3__inv_2_982/VDD
+ VSS VSS VSS VSS VSS gf180mcu_as_sc_mcu7t3v3__inv_2_978/VNW VSUBS gf180mcu_as_sc_mcu7t3v3__nand4_2
Xu_t001_007 u_t001_007/c0_w0_bl u_t001_007/c0_w0_br u_t001_007/c0_w1_bl u_t001_007/c0_w1_br
+ u_t001_007/c0_r0_rbl u_t001_007/c0_r1_rbl u_t001_007/c1_w0_bl u_t001_007/c1_w0_br
+ u_t001_007/c1_w1_bl u_t001_007/c1_w1_br u_t001_007/c1_r0_rbl u_t001_007/c1_r1_rbl
+ u_t001_007/c2_w0_bl u_t001_007/c2_w0_br u_t001_007/c2_w1_bl u_t001_007/c2_w1_br
+ u_t001_007/c2_r0_rbl u_t001_007/c2_r1_rbl u_t001_007/c3_w0_bl u_t001_007/c3_w0_br
+ u_t001_007/c3_w1_bl u_t001_007/c3_w1_br u_t001_007/c3_r0_rbl u_t001_007/c3_r1_rbl
+ u_t001_007/r0_w0_wl u_t001_007/r0_w1_wl u_t001_007/r0_r0_rwl u_t001_007/r0_r1_rwl
+ u_t001_007/r1_w0_wl u_t001_007/r1_w1_wl u_t001_007/r1_r0_rwl u_t001_007/r1_r1_rwl
+ u_t001_007/r2_w0_wl u_t001_007/r2_w1_wl u_t001_007/r2_r0_rwl u_t001_007/r2_r1_rwl
+ u_t001_007/r3_w0_wl u_t001_007/r3_w1_wl u_t001_007/r3_r0_rwl u_t001_007/r3_r1_rwl
+ VSS u_t001_031/VSS VSUBS detronyx_12t_2w2r_rc4_4x4_routed_5layer_direct
Xu_t001_029 u_t001_029/c0_w0_bl u_t001_029/c0_w0_br u_t001_029/c0_w1_bl u_t001_029/c0_w1_br
+ u_t001_029/c0_r0_rbl u_t001_029/c0_r1_rbl u_t001_029/c1_w0_bl u_t001_029/c1_w0_br
+ u_t001_029/c1_w1_bl u_t001_029/c1_w1_br u_t001_029/c1_r0_rbl u_t001_029/c1_r1_rbl
+ u_t001_029/c2_w0_bl u_t001_029/c2_w0_br u_t001_029/c2_w1_bl u_t001_029/c2_w1_br
+ u_t001_029/c2_r0_rbl u_t001_029/c2_r1_rbl u_t001_029/c3_w0_bl u_t001_029/c3_w0_br
+ u_t001_029/c3_w1_bl u_t001_029/c3_w1_br u_t001_029/c3_r0_rbl u_t001_029/c3_r1_rbl
+ u_t001_029/r0_w0_wl u_t001_029/r0_w1_wl u_t001_029/r0_r0_rwl u_t001_029/r0_r1_rwl
+ u_t001_029/r1_w0_wl u_t001_029/r1_w1_wl u_t001_029/r1_r0_rwl u_t001_029/r1_r1_rwl
+ u_t001_029/r2_w0_wl u_t001_029/r2_w1_wl u_t001_029/r2_r0_rwl u_t001_029/r2_r1_rwl
+ u_t001_029/r3_w0_wl u_t001_029/r3_w1_wl u_t001_029/r3_r0_rwl u_t001_029/r3_r1_rwl
+ u_t001_029/VDD u_t001_031/VSS VSUBS detronyx_12t_2w2r_rc4_4x4_routed_5layer_direct
Xu_t001_018 u_t001_018/c0_w0_bl u_t001_018/c0_w0_br u_t001_018/c0_w1_bl u_t001_018/c0_w1_br
+ u_t001_018/c0_r0_rbl u_t001_018/c0_r1_rbl u_t001_018/c1_w0_bl u_t001_018/c1_w0_br
+ u_t001_018/c1_w1_bl u_t001_018/c1_w1_br u_t001_018/c1_r0_rbl u_t001_018/c1_r1_rbl
+ u_t001_018/c2_w0_bl u_t001_018/c2_w0_br u_t001_018/c2_w1_bl u_t001_018/c2_w1_br
+ u_t001_018/c2_r0_rbl u_t001_018/c2_r1_rbl u_t001_018/c3_w0_bl u_t001_018/c3_w0_br
+ u_t001_018/c3_w1_bl u_t001_018/c3_w1_br u_t001_018/c3_r0_rbl u_t001_018/c3_r1_rbl
+ u_t001_018/r0_w0_wl u_t001_018/r0_w1_wl u_t001_018/r0_r0_rwl u_t001_018/r0_r1_rwl
+ u_t001_018/r1_w0_wl u_t001_018/r1_w1_wl u_t001_018/r1_r0_rwl u_t001_018/r1_r1_rwl
+ u_t001_018/r2_w0_wl u_t001_018/r2_w1_wl u_t001_018/r2_r0_rwl u_t001_018/r2_r1_rwl
+ u_t001_018/r3_w0_wl u_t001_018/r3_w1_wl u_t001_018/r3_r0_rwl u_t001_018/r3_r1_rwl
+ u_t001_018/VDD u_t001_031/VSS VSUBS detronyx_12t_2w2r_rc4_4x4_routed_5layer_direct
Xgf180mcu_as_sc_mcu7t3v3__inv_2_210 gf180mcu_as_sc_mcu7t3v3__inv_2_228/VSS VSS gf180mcu_as_sc_mcu7t3v3__inv_2_210/Y
+ VSS gf180mcu_as_sc_mcu7t3v3__inv_2_210/VNW VSUBS gf180mcu_as_sc_mcu7t3v3__inv_2
Xgf180mcu_as_sc_mcu7t3v3__inv_2_243 gf180mcu_as_sc_mcu7t3v3__inv_2_245/VDD VSS VSS
+ VSS gf180mcu_as_sc_mcu7t3v3__inv_2_245/VNW VSUBS gf180mcu_as_sc_mcu7t3v3__inv_2
Xgf180mcu_as_sc_mcu7t3v3__inv_2_232 gf180mcu_as_sc_mcu7t3v3__inv_2_233/VDD VSS VSS
+ VSS gf180mcu_as_sc_mcu7t3v3__inv_2_233/VNW VSUBS gf180mcu_as_sc_mcu7t3v3__inv_2
Xgf180mcu_as_sc_mcu7t3v3__inv_2_221 gf180mcu_as_sc_mcu7t3v3__inv_2_229/VDD gf180mcu_as_sc_mcu7t3v3__inv_2_233/VDD
+ VSS VSS gf180mcu_as_sc_mcu7t3v3__inv_2_229/VNW VSUBS gf180mcu_as_sc_mcu7t3v3__inv_2
Xgf180mcu_as_sc_mcu7t3v3__inv_2_265 VSS gf180mcu_as_sc_mcu7t3v3__inv_2_350/VDD VSS
+ gf180mcu_as_sc_mcu7t3v3__inv_2_66/Y gf180mcu_as_sc_mcu7t3v3__inv_2_349/VNW VSUBS
+ gf180mcu_as_sc_mcu7t3v3__inv_2
Xgf180mcu_as_sc_mcu7t3v3__inv_2_276 gf180mcu_as_sc_mcu7t3v3__inv_2_363/VDD gf180mcu_as_sc_mcu7t3v3__inv_2_363/VDD
+ gf180mcu_as_sc_mcu7t3v3__inv_2_364/Y gf180mcu_as_sc_mcu7t3v3__inv_2_364/Y gf180mcu_as_sc_mcu7t3v3__inv_2_362/VNW
+ VSUBS gf180mcu_as_sc_mcu7t3v3__inv_2
Xgf180mcu_as_sc_mcu7t3v3__inv_2_287 gf180mcu_as_sc_mcu7t3v3__inv_2_360/VDD gf180mcu_as_sc_mcu7t3v3__inv_2_361/VDD
+ VSS gf180mcu_as_sc_mcu7t3v3__inv_2_361/Y gf180mcu_as_sc_mcu7t3v3__inv_2_360/VNW
+ VSUBS gf180mcu_as_sc_mcu7t3v3__inv_2
Xgf180mcu_as_sc_mcu7t3v3__inv_2_254 VSS VSS VSS VSS gf180mcu_as_sc_mcu7t3v3__inv_2_256/VNW
+ VSUBS gf180mcu_as_sc_mcu7t3v3__inv_2
Xgf180mcu_as_sc_mcu7t3v3__inv_2_298 VSS gf180mcu_as_sc_mcu7t3v3__inv_2_331/VDD VSS
+ gf180mcu_as_sc_mcu7t3v3__inv_2_338/Y gf180mcu_as_sc_mcu7t3v3__inv_2_330/VNW VSUBS
+ gf180mcu_as_sc_mcu7t3v3__inv_2
Xgf180mcu_as_sc_mcu7t3v3__inv_2_1517 VSS gf180mcu_as_sc_mcu7t3v3__inv_2_1535/VDD VSS
+ VSS gf180mcu_as_sc_mcu7t3v3__inv_2_1518/VNW VSUBS gf180mcu_as_sc_mcu7t3v3__inv_2
Xgf180mcu_as_sc_mcu7t3v3__inv_2_1539 gf180mcu_as_sc_mcu7t3v3__inv_2_1539/VDD VSS gf180mcu_as_sc_mcu7t3v3__inv_2_1539/Y
+ VSS gf180mcu_as_sc_mcu7t3v3__inv_2_1539/VNW VSUBS gf180mcu_as_sc_mcu7t3v3__inv_2
Xgf180mcu_as_sc_mcu7t3v3__inv_2_1528 VSS VSS VSS VSS gf180mcu_as_sc_mcu7t3v3__inv_2_1528/VNW
+ VSUBS gf180mcu_as_sc_mcu7t3v3__inv_2
Xgf180mcu_as_sc_mcu7t3v3__inv_2_1506 gf180mcu_as_sc_mcu7t3v3__inv_2_1532/VSS gf180mcu_as_sc_mcu7t3v3__inv_2_1688/VDD
+ gf180mcu_as_sc_mcu7t3v3__inv_2_1506/Y VSS gf180mcu_as_sc_mcu7t3v3__inv_2_1506/VNW
+ VSUBS gf180mcu_as_sc_mcu7t3v3__inv_2
Xgf180mcu_as_sc_mcu7t3v3__nor2_2_0 gf180mcu_as_sc_mcu7t3v3__nor2_2_4/VDD gf180mcu_as_sc_mcu7t3v3__nor2_2_4/VSS
+ VSS VSS VSS gf180mcu_as_sc_mcu7t3v3__nor2_2_4/VNW VSUBS gf180mcu_as_sc_mcu7t3v3__nor2_2
Xgf180mcu_as_sc_mcu7t3v3__nand2_2_5 gf180mcu_as_sc_mcu7t3v3__nand3_2_5/VDD gf180mcu_as_sc_mcu7t3v3__nor2_2_4/VSS
+ VSS VSS VSS gf180mcu_as_sc_mcu7t3v3__nand3_2_5/VNW VSUBS gf180mcu_as_sc_mcu7t3v3__nand2_2
Xgf180mcu_as_sc_mcu7t3v3__inv_2_1347 gf180mcu_as_sc_mcu7t3v3__inv_2_1400/VSS VSS VSS
+ gf180mcu_as_sc_mcu7t3v3__inv_2_1685/Y gf180mcu_as_sc_mcu7t3v3__inv_2_1381/VNW VSUBS
+ gf180mcu_as_sc_mcu7t3v3__inv_2
Xgf180mcu_as_sc_mcu7t3v3__inv_2_1314 gf180mcu_as_sc_mcu7t3v3__inv_2_1379/VDD VSS VSS
+ gf180mcu_as_sc_mcu7t3v3__inv_2_1379/Y gf180mcu_as_sc_mcu7t3v3__inv_2_1379/VNW VSUBS
+ gf180mcu_as_sc_mcu7t3v3__inv_2
Xgf180mcu_as_sc_mcu7t3v3__inv_2_1303 gf180mcu_as_sc_mcu7t3v3__inv_2_1373/VDD VSS gf180mcu_as_sc_mcu7t3v3__inv_2_1379/Y
+ gf180mcu_as_sc_mcu7t3v3__inv_2_1379/Y gf180mcu_as_sc_mcu7t3v3__inv_2_1373/VNW VSUBS
+ gf180mcu_as_sc_mcu7t3v3__inv_2
Xgf180mcu_as_sc_mcu7t3v3__inv_2_1325 VSS gf180mcu_as_sc_mcu7t3v3__inv_2_1372/VDD gf180mcu_as_sc_mcu7t3v3__inv_2_1325/Y
+ gf180mcu_as_sc_mcu7t3v3__inv_2_1379/Y gf180mcu_as_sc_mcu7t3v3__inv_2_1371/VNW VSUBS
+ gf180mcu_as_sc_mcu7t3v3__inv_2
Xgf180mcu_as_sc_mcu7t3v3__inv_2_1369 gf180mcu_as_sc_mcu7t3v3__inv_2_1369/VDD VSS gf180mcu_as_sc_mcu7t3v3__inv_2_1369/Y
+ VSS gf180mcu_as_sc_mcu7t3v3__inv_2_1369/VNW VSUBS gf180mcu_as_sc_mcu7t3v3__inv_2
Xgf180mcu_as_sc_mcu7t3v3__inv_2_1336 VSS gf180mcu_as_sc_mcu7t3v3__inv_2_1398/VSS gf180mcu_as_sc_mcu7t3v3__inv_2_1398/Y
+ gf180mcu_as_sc_mcu7t3v3__inv_2_1398/Y gf180mcu_as_sc_mcu7t3v3__inv_2_1398/VNW VSUBS
+ gf180mcu_as_sc_mcu7t3v3__inv_2
Xgf180mcu_as_sc_mcu7t3v3__inv_2_1358 gf180mcu_as_sc_mcu7t3v3__inv_2_1393/VDD gf180mcu_as_sc_mcu7t3v3__inv_2_1394/VDD
+ gf180mcu_as_sc_mcu7t3v3__inv_2_1358/Y gf180mcu_as_sc_mcu7t3v3__inv_2_1398/Y gf180mcu_as_sc_mcu7t3v3__inv_2_1393/VNW
+ VSUBS gf180mcu_as_sc_mcu7t3v3__inv_2
Xu_t028_021 u_t028_021/c0_w0_bl u_t028_021/c0_w0_br u_t028_021/c0_w1_bl u_t028_021/c0_w1_br
+ u_t028_021/c0_r0_rbl u_t028_021/c0_r1_rbl u_t028_021/c1_w0_bl u_t028_021/c1_w0_br
+ u_t028_021/c1_w1_bl u_t028_021/c1_w1_br u_t028_021/c1_r0_rbl u_t028_021/c1_r1_rbl
+ u_t028_021/c2_w0_bl u_t028_021/c2_w0_br u_t028_021/c2_w1_bl u_t028_021/c2_w1_br
+ u_t028_021/c2_r0_rbl u_t028_021/c2_r1_rbl u_t028_021/c3_w0_bl u_t028_021/c3_w0_br
+ u_t028_021/c3_w1_bl u_t028_021/c3_w1_br u_t028_021/c3_r0_rbl u_t028_021/c3_r1_rbl
+ u_t028_021/r0_w0_wl u_t028_021/r0_w1_wl u_t028_021/r0_r0_rwl u_t028_021/r0_r1_rwl
+ u_t028_021/r1_w0_wl u_t028_021/r1_w1_wl u_t028_021/r1_r0_rwl u_t028_021/r1_r1_rwl
+ u_t028_021/r2_w0_wl u_t028_021/r2_w1_wl u_t028_021/r2_r0_rwl u_t028_021/r2_r1_rwl
+ u_t028_021/r3_w0_wl u_t028_021/r3_w1_wl u_t028_021/r3_r0_rwl u_t028_021/r3_r1_rwl
+ u_t029_021/VDD u_t028_024/VSS VSUBS detronyx_12t_2w2r_rc4_4x4_routed_5layer_direct
Xu_t028_010 u_t028_010/c0_w0_bl u_t028_010/c0_w0_br u_t028_010/c0_w1_bl u_t028_010/c0_w1_br
+ u_t028_010/c0_r0_rbl u_t028_010/c0_r1_rbl u_t028_010/c1_w0_bl u_t028_010/c1_w0_br
+ u_t028_010/c1_w1_bl u_t028_010/c1_w1_br u_t028_010/c1_r0_rbl u_t028_010/c1_r1_rbl
+ u_t028_010/c2_w0_bl u_t028_010/c2_w0_br u_t028_010/c2_w1_bl u_t028_010/c2_w1_br
+ u_t028_010/c2_r0_rbl u_t028_010/c2_r1_rbl u_t028_010/c3_w0_bl u_t028_010/c3_w0_br
+ u_t028_010/c3_w1_bl u_t028_010/c3_w1_br u_t028_010/c3_r0_rbl u_t028_010/c3_r1_rbl
+ u_t028_010/r0_w0_wl u_t028_010/r0_w1_wl u_t028_010/r0_r0_rwl u_t028_010/r0_r1_rwl
+ u_t028_010/r1_w0_wl u_t028_010/r1_w1_wl u_t028_010/r1_r0_rwl u_t028_010/r1_r1_rwl
+ u_t028_010/r2_w0_wl u_t028_010/r2_w1_wl u_t028_010/r2_r0_rwl u_t028_010/r2_r1_rwl
+ u_t028_010/r3_w0_wl u_t028_010/r3_w1_wl u_t028_010/r3_r0_rwl u_t028_010/r3_r1_rwl
+ VSS u_t028_010/VSS VSUBS detronyx_12t_2w2r_rc4_4x4_routed_5layer_direct
Xgf180mcu_as_sc_mcu7t3v3__inv_2_809 VSS VSS VSS VSS gf180mcu_as_sc_mcu7t3v3__inv_2_813/VNW
+ VSUBS gf180mcu_as_sc_mcu7t3v3__inv_2
Xgf180mcu_as_sc_mcu7t3v3__nand4_2_108 VSS VSS VSS VSS VSS VSS VSS gf180mcu_as_sc_mcu7t3v3__inv_2_345/VNW
+ VSUBS gf180mcu_as_sc_mcu7t3v3__nand4_2
Xu_t019_021 u_t019_021/c0_w0_bl u_t019_021/c0_w0_br u_t019_021/c0_w1_bl u_t019_021/c0_w1_br
+ u_t019_021/c0_r0_rbl u_t019_021/c0_r1_rbl u_t019_021/c1_w0_bl u_t019_021/c1_w0_br
+ u_t019_021/c1_w1_bl u_t019_021/c1_w1_br u_t019_021/c1_r0_rbl u_t019_021/c1_r1_rbl
+ u_t019_021/c2_w0_bl u_t019_021/c2_w0_br u_t019_021/c2_w1_bl u_t019_021/c2_w1_br
+ u_t019_021/c2_r0_rbl u_t019_021/c2_r1_rbl u_t019_021/c3_w0_bl u_t019_021/c3_w0_br
+ u_t019_021/c3_w1_bl u_t019_021/c3_w1_br u_t019_021/c3_r0_rbl u_t019_021/c3_r1_rbl
+ u_t019_021/r0_w0_wl u_t019_021/r0_w1_wl u_t019_021/r0_r0_rwl u_t019_021/r0_r1_rwl
+ u_t019_021/r1_w0_wl u_t019_021/r1_w1_wl u_t019_021/r1_r0_rwl u_t019_021/r1_r1_rwl
+ u_t019_021/r2_w0_wl u_t019_021/r2_w1_wl u_t019_021/r2_r0_rwl u_t019_021/r2_r1_rwl
+ u_t019_021/r3_w0_wl u_t019_021/r3_w1_wl u_t019_021/r3_r0_rwl u_t019_021/r3_r1_rwl
+ u_t019_021/VDD u_t019_024/VSS VSUBS detronyx_12t_2w2r_rc4_4x4_routed_5layer_direct
Xu_t019_010 u_t019_010/c0_w0_bl u_t019_010/c0_w0_br u_t019_010/c0_w1_bl u_t019_010/c0_w1_br
+ u_t019_010/c0_r0_rbl u_t019_010/c0_r1_rbl u_t019_010/c1_w0_bl u_t019_010/c1_w0_br
+ u_t019_010/c1_w1_bl u_t019_010/c1_w1_br u_t019_010/c1_r0_rbl u_t019_010/c1_r1_rbl
+ u_t019_010/c2_w0_bl u_t019_010/c2_w0_br u_t019_010/c2_w1_bl u_t019_010/c2_w1_br
+ u_t019_010/c2_r0_rbl u_t019_010/c2_r1_rbl u_t019_010/c3_w0_bl u_t019_010/c3_w0_br
+ u_t019_010/c3_w1_bl u_t019_010/c3_w1_br u_t019_010/c3_r0_rbl u_t019_010/c3_r1_rbl
+ u_t019_010/r0_w0_wl u_t019_010/r0_w1_wl u_t019_010/r0_r0_rwl u_t019_010/r0_r1_rwl
+ u_t019_010/r1_w0_wl u_t019_010/r1_w1_wl u_t019_010/r1_r0_rwl u_t019_010/r1_r1_rwl
+ u_t019_010/r2_w0_wl u_t019_010/r2_w1_wl u_t019_010/r2_r0_rwl u_t019_010/r2_r1_rwl
+ u_t019_010/r3_w0_wl u_t019_010/r3_w1_wl u_t019_010/r3_r0_rwl u_t019_010/r3_r1_rwl
+ VSS u_t019_010/VSS VSUBS detronyx_12t_2w2r_rc4_4x4_routed_5layer_direct
Xgf180mcu_as_sc_mcu7t3v3__nand4_2_25 gf180mcu_as_sc_mcu7t3v3__inv_2_69/VSS gf180mcu_as_sc_mcu7t3v3__inv_2_69/VSS
+ VSS VSS VSS VSS VSS gf180mcu_as_sc_mcu7t3v3__inv_2_69/VNW VSUBS gf180mcu_as_sc_mcu7t3v3__nand4_2
Xgf180mcu_as_sc_mcu7t3v3__nand4_2_36 gf180mcu_as_sc_mcu7t3v3__inv_2_99/VDD gf180mcu_as_sc_mcu7t3v3__inv_2_99/VDD
+ VSS VSS VSS VSS VSS gf180mcu_as_sc_mcu7t3v3__inv_2_155/VNW VSUBS gf180mcu_as_sc_mcu7t3v3__nand4_2
Xgf180mcu_as_sc_mcu7t3v3__nand4_2_14 gf180mcu_as_sc_mcu7t3v3__inv_2_71/VDD gf180mcu_as_sc_mcu7t3v3__inv_2_73/VDD
+ VSS VSS VSS VSS VSS gf180mcu_as_sc_mcu7t3v3__inv_2_71/VNW VSUBS gf180mcu_as_sc_mcu7t3v3__nand4_2
Xgf180mcu_as_sc_mcu7t3v3__nand4_2_47 gf180mcu_as_sc_mcu7t3v3__inv_2_115/VDD gf180mcu_as_sc_mcu7t3v3__inv_2_119/VDD
+ VSS VSS VSS VSS gf180mcu_as_sc_mcu7t3v3__nand4_2_47/Y gf180mcu_as_sc_mcu7t3v3__inv_2_115/VNW
+ VSUBS gf180mcu_as_sc_mcu7t3v3__nand4_2
Xgf180mcu_as_sc_mcu7t3v3__nand4_2_58 VSS gf180mcu_as_sc_mcu7t3v3__inv_2_184/VDD VSS
+ VSS VSS VSS gf180mcu_as_sc_mcu7t3v3__nand4_2_58/Y gf180mcu_as_sc_mcu7t3v3__inv_2_180/VNW
+ VSUBS gf180mcu_as_sc_mcu7t3v3__nand4_2
Xgf180mcu_as_sc_mcu7t3v3__nand4_2_119 gf180mcu_as_sc_mcu7t3v3__inv_2_332/VDD VSS VSS
+ VSS VSS VSS VSS gf180mcu_as_sc_mcu7t3v3__inv_2_332/VNW VSUBS gf180mcu_as_sc_mcu7t3v3__nand4_2
Xgf180mcu_as_sc_mcu7t3v3__nand4_2_69 VSS gf180mcu_as_sc_mcu7t3v3__inv_2_177/VDD VSS
+ VSS VSS VSS gf180mcu_as_sc_mcu7t3v3__nand4_2_69/Y gf180mcu_as_sc_mcu7t3v3__inv_2_173/VNW
+ VSUBS gf180mcu_as_sc_mcu7t3v3__nand4_2
Xu_t025_024 u_t025_024/c0_w0_bl u_t025_024/c0_w0_br u_t025_024/c0_w1_bl u_t025_024/c0_w1_br
+ u_t025_024/c0_r0_rbl u_t025_024/c0_r1_rbl u_t025_024/c1_w0_bl u_t025_024/c1_w0_br
+ u_t025_024/c1_w1_bl u_t025_024/c1_w1_br u_t025_024/c1_r0_rbl u_t025_024/c1_r1_rbl
+ u_t025_024/c2_w0_bl u_t025_024/c2_w0_br u_t025_024/c2_w1_bl u_t025_024/c2_w1_br
+ u_t025_024/c2_r0_rbl u_t025_024/c2_r1_rbl u_t025_024/c3_w0_bl u_t025_024/c3_w0_br
+ u_t025_024/c3_w1_bl u_t025_024/c3_w1_br u_t025_024/c3_r0_rbl u_t025_024/c3_r1_rbl
+ u_t025_024/r0_w0_wl u_t025_024/r0_w1_wl u_t025_024/r0_r0_rwl u_t025_024/r0_r1_rwl
+ u_t025_024/r1_w0_wl u_t025_024/r1_w1_wl u_t025_024/r1_r0_rwl u_t025_024/r1_r1_rwl
+ u_t025_024/r2_w0_wl u_t025_024/r2_w1_wl u_t025_024/r2_r0_rwl u_t025_024/r2_r1_rwl
+ u_t025_024/r3_w0_wl u_t025_024/r3_w1_wl u_t025_024/r3_r0_rwl u_t025_024/r3_r1_rwl
+ VSS u_t025_031/VSS VSUBS detronyx_12t_2w2r_rc4_4x4_routed_5layer_direct
Xu_t025_013 u_t025_013/c0_w0_bl u_t025_013/c0_w0_br u_t025_013/c0_w1_bl u_t025_013/c0_w1_br
+ u_t025_013/c0_r0_rbl u_t025_013/c0_r1_rbl u_t025_013/c1_w0_bl u_t025_013/c1_w0_br
+ u_t025_013/c1_w1_bl u_t025_013/c1_w1_br u_t025_013/c1_r0_rbl u_t025_013/c1_r1_rbl
+ u_t025_013/c2_w0_bl u_t025_013/c2_w0_br u_t025_013/c2_w1_bl u_t025_013/c2_w1_br
+ u_t025_013/c2_r0_rbl u_t025_013/c2_r1_rbl u_t025_013/c3_w0_bl u_t025_013/c3_w0_br
+ u_t025_013/c3_w1_bl u_t025_013/c3_w1_br u_t025_013/c3_r0_rbl u_t025_013/c3_r1_rbl
+ u_t025_013/r0_w0_wl u_t025_013/r0_w1_wl u_t025_013/r0_r0_rwl u_t025_013/r0_r1_rwl
+ u_t025_013/r1_w0_wl u_t025_013/r1_w1_wl u_t025_013/r1_r0_rwl u_t025_013/r1_r1_rwl
+ u_t025_013/r2_w0_wl u_t025_013/r2_w1_wl u_t025_013/r2_r0_rwl u_t025_013/r2_r1_rwl
+ u_t025_013/r3_w0_wl u_t025_013/r3_w1_wl u_t025_013/r3_r0_rwl u_t025_013/r3_r1_rwl
+ u_t025_013/VDD u_t025_031/VSS VSUBS detronyx_12t_2w2r_rc4_4x4_routed_5layer_direct
Xu_t025_002 u_t025_002/c0_w0_bl u_t025_002/c0_w0_br u_t025_002/c0_w1_bl u_t025_002/c0_w1_br
+ u_t025_002/c0_r0_rbl u_t025_002/c0_r1_rbl u_t025_002/c1_w0_bl u_t025_002/c1_w0_br
+ u_t025_002/c1_w1_bl u_t025_002/c1_w1_br u_t025_002/c1_r0_rbl u_t025_002/c1_r1_rbl
+ u_t025_002/c2_w0_bl u_t025_002/c2_w0_br u_t025_002/c2_w1_bl u_t025_002/c2_w1_br
+ u_t025_002/c2_r0_rbl u_t025_002/c2_r1_rbl u_t025_002/c3_w0_bl u_t025_002/c3_w0_br
+ u_t025_002/c3_w1_bl u_t025_002/c3_w1_br u_t025_002/c3_r0_rbl u_t025_002/c3_r1_rbl
+ u_t025_002/r0_w0_wl u_t025_002/r0_w1_wl u_t025_002/r0_r0_rwl u_t025_002/r0_r1_rwl
+ u_t025_002/r1_w0_wl u_t025_002/r1_w1_wl u_t025_002/r1_r0_rwl u_t025_002/r1_r1_rwl
+ u_t025_002/r2_w0_wl u_t025_002/r2_w1_wl u_t025_002/r2_r0_rwl u_t025_002/r2_r1_rwl
+ u_t025_002/r3_w0_wl u_t025_002/r3_w1_wl u_t025_002/r3_r0_rwl u_t025_002/r3_r1_rwl
+ VSS u_t025_031/VSS VSUBS detronyx_12t_2w2r_rc4_4x4_routed_5layer_direct
Xgf180mcu_as_sc_mcu7t3v3__inv_2_1122 gf180mcu_as_sc_mcu7t3v3__inv_2_1123/VDD gf180mcu_as_sc_mcu7t3v3__inv_2_1126/VDD
+ gf180mcu_as_sc_mcu7t3v3__inv_2_1122/Y gf180mcu_as_sc_mcu7t3v3__inv_2_1123/Y gf180mcu_as_sc_mcu7t3v3__inv_2_1123/VNW
+ VSUBS gf180mcu_as_sc_mcu7t3v3__inv_2
Xgf180mcu_as_sc_mcu7t3v3__inv_2_1133 gf180mcu_as_sc_mcu7t3v3__inv_2_1135/VDD VSS VSS
+ VSS gf180mcu_as_sc_mcu7t3v3__inv_2_1135/VNW VSUBS gf180mcu_as_sc_mcu7t3v3__inv_2
Xgf180mcu_as_sc_mcu7t3v3__inv_2_1111 VSS VSS gf180mcu_as_sc_mcu7t3v3__inv_2_1111/Y
+ VSS gf180mcu_as_sc_mcu7t3v3__inv_2_1111/VNW VSUBS gf180mcu_as_sc_mcu7t3v3__inv_2
Xgf180mcu_as_sc_mcu7t3v3__inv_2_1144 VSS gf180mcu_as_sc_mcu7t3v3__inv_2_1146/VSS VSS
+ gf180mcu_as_sc_mcu7t3v3__inv_2_1144/A gf180mcu_as_sc_mcu7t3v3__inv_2_1146/VNW VSUBS
+ gf180mcu_as_sc_mcu7t3v3__inv_2
Xgf180mcu_as_sc_mcu7t3v3__inv_2_1100 VSS VSS gf180mcu_as_sc_mcu7t3v3__inv_2_1100/Y
+ VSS gf180mcu_as_sc_mcu7t3v3__inv_2_1100/VNW VSUBS gf180mcu_as_sc_mcu7t3v3__inv_2
Xgf180mcu_as_sc_mcu7t3v3__inv_2_1199 gf180mcu_as_sc_mcu7t3v3__nor2_2_8/VDD gf180mcu_as_sc_mcu7t3v3__nor2_2_8/VSS
+ VSS VSS gf180mcu_as_sc_mcu7t3v3__nor2_2_8/VNW VSUBS gf180mcu_as_sc_mcu7t3v3__inv_2
Xgf180mcu_as_sc_mcu7t3v3__inv_2_1177 VSS VSS gf180mcu_as_sc_mcu7t3v3__inv_2_1177/Y
+ VSS gf180mcu_as_sc_mcu7t3v3__inv_2_1177/VNW VSUBS gf180mcu_as_sc_mcu7t3v3__inv_2
Xgf180mcu_as_sc_mcu7t3v3__inv_2_1166 VSS VSS VSS VSS gf180mcu_as_sc_mcu7t3v3__inv_2_1168/VNW
+ VSUBS gf180mcu_as_sc_mcu7t3v3__inv_2
Xgf180mcu_as_sc_mcu7t3v3__inv_2_1188 VSS VSS VSS VSS gf180mcu_as_sc_mcu7t3v3__inv_2_1190/VNW
+ VSUBS gf180mcu_as_sc_mcu7t3v3__inv_2
Xgf180mcu_as_sc_mcu7t3v3__inv_2_1155 VSS VSS gf180mcu_as_sc_mcu7t3v3__inv_2_1155/Y
+ VSS gf180mcu_as_sc_mcu7t3v3__inv_2_1155/VNW VSUBS gf180mcu_as_sc_mcu7t3v3__inv_2
Xu_t031_027 u_t031_027/c0_w0_bl u_t031_027/c0_w0_br u_t031_027/c0_w1_bl u_t031_027/c0_w1_br
+ u_t031_027/c0_r0_rbl u_t031_027/c0_r1_rbl u_t031_027/c1_w0_bl u_t031_027/c1_w0_br
+ u_t031_027/c1_w1_bl u_t031_027/c1_w1_br u_t031_027/c1_r0_rbl u_t031_027/c1_r1_rbl
+ u_t031_027/c2_w0_bl u_t031_027/c2_w0_br u_t031_027/c2_w1_bl u_t031_027/c2_w1_br
+ u_t031_027/c2_r0_rbl u_t031_027/c2_r1_rbl u_t031_027/c3_w0_bl u_t031_027/c3_w0_br
+ u_t031_027/c3_w1_bl u_t031_027/c3_w1_br u_t031_027/c3_r0_rbl u_t031_027/c3_r1_rbl
+ u_t031_027/r0_w0_wl u_t031_027/r0_w1_wl u_t031_027/r0_r0_rwl u_t031_027/r0_r1_rwl
+ u_t031_027/r1_w0_wl u_t031_027/r1_w1_wl u_t031_027/r1_r0_rwl u_t031_027/r1_r1_rwl
+ u_t031_027/r2_w0_wl u_t031_027/r2_w1_wl u_t031_027/r2_r0_rwl u_t031_027/r2_r1_rwl
+ u_t031_027/r3_w0_wl u_t031_027/r3_w1_wl u_t031_027/r3_r0_rwl u_t031_027/r3_r1_rwl
+ u_t031_027/VDD u_t031_027/VSS VSUBS detronyx_12t_2w2r_rc4_4x4_routed_5layer_direct
Xu_t016_024 u_t016_024/c0_w0_bl u_t016_024/c0_w0_br u_t016_024/c0_w1_bl u_t016_024/c0_w1_br
+ u_t016_024/c0_r0_rbl u_t016_024/c0_r1_rbl u_t016_024/c1_w0_bl u_t016_024/c1_w0_br
+ u_t016_024/c1_w1_bl u_t016_024/c1_w1_br u_t016_024/c1_r0_rbl u_t016_024/c1_r1_rbl
+ u_t016_024/c2_w0_bl u_t016_024/c2_w0_br u_t016_024/c2_w1_bl u_t016_024/c2_w1_br
+ u_t016_024/c2_r0_rbl u_t016_024/c2_r1_rbl u_t016_024/c3_w0_bl u_t016_024/c3_w0_br
+ u_t016_024/c3_w1_bl u_t016_024/c3_w1_br u_t016_024/c3_r0_rbl u_t016_024/c3_r1_rbl
+ u_t016_024/r0_w0_wl u_t016_024/r0_w1_wl u_t016_024/r0_r0_rwl u_t016_024/r0_r1_rwl
+ u_t016_024/r1_w0_wl u_t016_024/r1_w1_wl u_t016_024/r1_r0_rwl u_t016_024/r1_r1_rwl
+ u_t016_024/r2_w0_wl u_t016_024/r2_w1_wl u_t016_024/r2_r0_rwl u_t016_024/r2_r1_rwl
+ u_t016_024/r3_w0_wl u_t016_024/r3_w1_wl u_t016_024/r3_r0_rwl u_t016_024/r3_r1_rwl
+ VSS u_t016_024/VSS VSUBS detronyx_12t_2w2r_rc4_4x4_routed_5layer_direct
Xu_t031_016 u_t031_016/c0_w0_bl u_t031_016/c0_w0_br u_t031_016/c0_w1_bl u_t031_016/c0_w1_br
+ u_t031_016/c0_r0_rbl u_t031_016/c0_r1_rbl u_t031_016/c1_w0_bl u_t031_016/c1_w0_br
+ u_t031_016/c1_w1_bl u_t031_016/c1_w1_br u_t031_016/c1_r0_rbl u_t031_016/c1_r1_rbl
+ u_t031_016/c2_w0_bl u_t031_016/c2_w0_br u_t031_016/c2_w1_bl u_t031_016/c2_w1_br
+ u_t031_016/c2_r0_rbl u_t031_016/c2_r1_rbl u_t031_016/c3_w0_bl u_t031_016/c3_w0_br
+ u_t031_016/c3_w1_bl u_t031_016/c3_w1_br u_t031_016/c3_r0_rbl u_t031_016/c3_r1_rbl
+ u_t031_016/r0_w0_wl u_t031_016/r0_w1_wl u_t031_016/r0_r0_rwl u_t031_016/r0_r1_rwl
+ u_t031_016/r1_w0_wl u_t031_016/r1_w1_wl u_t031_016/r1_r0_rwl u_t031_016/r1_r1_rwl
+ u_t031_016/r2_w0_wl u_t031_016/r2_w1_wl u_t031_016/r2_r0_rwl u_t031_016/r2_r1_rwl
+ u_t031_016/r3_w0_wl u_t031_016/r3_w1_wl u_t031_016/r3_r0_rwl u_t031_016/r3_r1_rwl
+ VSS u_t031_017/VSS VSUBS detronyx_12t_2w2r_rc4_4x4_routed_5layer_direct
Xu_t016_013 u_t016_013/c0_w0_bl u_t016_013/c0_w0_br u_t016_013/c0_w1_bl u_t016_013/c0_w1_br
+ u_t016_013/c0_r0_rbl u_t016_013/c0_r1_rbl u_t016_013/c1_w0_bl u_t016_013/c1_w0_br
+ u_t016_013/c1_w1_bl u_t016_013/c1_w1_br u_t016_013/c1_r0_rbl u_t016_013/c1_r1_rbl
+ u_t016_013/c2_w0_bl u_t016_013/c2_w0_br u_t016_013/c2_w1_bl u_t016_013/c2_w1_br
+ u_t016_013/c2_r0_rbl u_t016_013/c2_r1_rbl u_t016_013/c3_w0_bl u_t016_013/c3_w0_br
+ u_t016_013/c3_w1_bl u_t016_013/c3_w1_br u_t016_013/c3_r0_rbl u_t016_013/c3_r1_rbl
+ u_t016_013/r0_w0_wl u_t016_013/r0_w1_wl u_t016_013/r0_r0_rwl u_t016_013/r0_r1_rwl
+ u_t016_013/r1_w0_wl u_t016_013/r1_w1_wl u_t016_013/r1_r0_rwl u_t016_013/r1_r1_rwl
+ u_t016_013/r2_w0_wl u_t016_013/r2_w1_wl u_t016_013/r2_r0_rwl u_t016_013/r2_r1_rwl
+ u_t016_013/r3_w0_wl u_t016_013/r3_w1_wl u_t016_013/r3_r0_rwl u_t016_013/r3_r1_rwl
+ u_t016_013/VDD u_t016_013/VSS VSUBS detronyx_12t_2w2r_rc4_4x4_routed_5layer_direct
Xu_t031_005 u_t031_005/c0_w0_bl u_t031_005/c0_w0_br u_t031_005/c0_w1_bl u_t031_005/c0_w1_br
+ u_t031_005/c0_r0_rbl u_t031_005/c0_r1_rbl u_t031_005/c1_w0_bl u_t031_005/c1_w0_br
+ u_t031_005/c1_w1_bl u_t031_005/c1_w1_br u_t031_005/c1_r0_rbl u_t031_005/c1_r1_rbl
+ u_t031_005/c2_w0_bl u_t031_005/c2_w0_br u_t031_005/c2_w1_bl u_t031_005/c2_w1_br
+ u_t031_005/c2_r0_rbl u_t031_005/c2_r1_rbl u_t031_005/c3_w0_bl u_t031_005/c3_w0_br
+ u_t031_005/c3_w1_bl u_t031_005/c3_w1_br u_t031_005/c3_r0_rbl u_t031_005/c3_r1_rbl
+ u_t031_005/r0_w0_wl u_t031_005/r0_w1_wl u_t031_005/r0_r0_rwl u_t031_005/r0_r1_rwl
+ u_t031_005/r1_w0_wl u_t031_005/r1_w1_wl u_t031_005/r1_r0_rwl u_t031_005/r1_r1_rwl
+ u_t031_005/r2_w0_wl u_t031_005/r2_w1_wl u_t031_005/r2_r0_rwl u_t031_005/r2_r1_rwl
+ u_t031_005/r3_w0_wl u_t031_005/r3_w1_wl u_t031_005/r3_r0_rwl u_t031_005/r3_r1_rwl
+ u_t031_005/VDD u_t031_005/VSS VSUBS detronyx_12t_2w2r_rc4_4x4_routed_5layer_direct
Xu_t016_002 u_t016_002/c0_w0_bl u_t016_002/c0_w0_br u_t016_002/c0_w1_bl u_t016_002/c0_w1_br
+ u_t016_002/c0_r0_rbl u_t016_002/c0_r1_rbl u_t016_002/c1_w0_bl u_t016_002/c1_w0_br
+ u_t016_002/c1_w1_bl u_t016_002/c1_w1_br u_t016_002/c1_r0_rbl u_t016_002/c1_r1_rbl
+ u_t016_002/c2_w0_bl u_t016_002/c2_w0_br u_t016_002/c2_w1_bl u_t016_002/c2_w1_br
+ u_t016_002/c2_r0_rbl u_t016_002/c2_r1_rbl u_t016_002/c3_w0_bl u_t016_002/c3_w0_br
+ u_t016_002/c3_w1_bl u_t016_002/c3_w1_br u_t016_002/c3_r0_rbl u_t016_002/c3_r1_rbl
+ u_t016_002/r0_w0_wl u_t016_002/r0_w1_wl u_t016_002/r0_r0_rwl u_t016_002/r0_r1_rwl
+ u_t016_002/r1_w0_wl u_t016_002/r1_w1_wl u_t016_002/r1_r0_rwl u_t016_002/r1_r1_rwl
+ u_t016_002/r2_w0_wl u_t016_002/r2_w1_wl u_t016_002/r2_r0_rwl u_t016_002/r2_r1_rwl
+ u_t016_002/r3_w0_wl u_t016_002/r3_w1_wl u_t016_002/r3_r0_rwl u_t016_002/r3_r1_rwl
+ VSS u_t016_002/VSS VSUBS detronyx_12t_2w2r_rc4_4x4_routed_5layer_direct
Xgf180mcu_as_sc_mcu7t3v3__inv_2_628 gf180mcu_as_sc_mcu7t3v3__inv_2_629/VDD gf180mcu_as_sc_mcu7t3v3__inv_2_633/VDD
+ gf180mcu_as_sc_mcu7t3v3__inv_2_628/Y gf180mcu_as_sc_mcu7t3v3__inv_2_629/Y gf180mcu_as_sc_mcu7t3v3__inv_2_629/VNW
+ VSUBS gf180mcu_as_sc_mcu7t3v3__inv_2
Xgf180mcu_as_sc_mcu7t3v3__inv_2_606 gf180mcu_as_sc_mcu7t3v3__inv_2_630/VSS gf180mcu_as_sc_mcu7t3v3__inv_2_616/VDD
+ VSS gf180mcu_as_sc_mcu7t3v3__inv_2_848/Y gf180mcu_as_sc_mcu7t3v3__inv_2_608/VNW
+ VSUBS gf180mcu_as_sc_mcu7t3v3__inv_2
Xgf180mcu_as_sc_mcu7t3v3__inv_2_617 gf180mcu_as_sc_mcu7t3v3__inv_2_849/VSS gf180mcu_as_sc_mcu7t3v3__inv_2_630/VDD
+ gf180mcu_as_sc_mcu7t3v3__inv_2_617/Y VSS gf180mcu_as_sc_mcu7t3v3__inv_2_617/VNW
+ VSUBS gf180mcu_as_sc_mcu7t3v3__inv_2
Xgf180mcu_as_sc_mcu7t3v3__inv_2_639 VSS gf180mcu_as_sc_mcu7t3v3__inv_2_667/VDD gf180mcu_as_sc_mcu7t3v3__inv_2_639/Y
+ VSS gf180mcu_as_sc_mcu7t3v3__inv_2_639/VNW VSUBS gf180mcu_as_sc_mcu7t3v3__inv_2
Xu_t007_024 u_t007_024/c0_w0_bl u_t007_024/c0_w0_br u_t007_024/c0_w1_bl u_t007_024/c0_w1_br
+ u_t007_024/c0_r0_rbl u_t007_024/c0_r1_rbl u_t007_024/c1_w0_bl u_t007_024/c1_w0_br
+ u_t007_024/c1_w1_bl u_t007_024/c1_w1_br u_t007_024/c1_r0_rbl u_t007_024/c1_r1_rbl
+ u_t007_024/c2_w0_bl u_t007_024/c2_w0_br u_t007_024/c2_w1_bl u_t007_024/c2_w1_br
+ u_t007_024/c2_r0_rbl u_t007_024/c2_r1_rbl u_t007_024/c3_w0_bl u_t007_024/c3_w0_br
+ u_t007_024/c3_w1_bl u_t007_024/c3_w1_br u_t007_024/c3_r0_rbl u_t007_024/c3_r1_rbl
+ u_t007_024/r0_w0_wl u_t007_024/r0_w1_wl u_t007_024/r0_r0_rwl u_t007_024/r0_r1_rwl
+ u_t007_024/r1_w0_wl u_t007_024/r1_w1_wl u_t007_024/r1_r0_rwl u_t007_024/r1_r1_rwl
+ u_t007_024/r2_w0_wl u_t007_024/r2_w1_wl u_t007_024/r2_r0_rwl u_t007_024/r2_r1_rwl
+ u_t007_024/r3_w0_wl u_t007_024/r3_w1_wl u_t007_024/r3_r0_rwl u_t007_024/r3_r1_rwl
+ VSS u_t007_024/VSS VSUBS detronyx_12t_2w2r_rc4_4x4_routed_5layer_direct
Xu_t007_013 u_t007_013/c0_w0_bl u_t007_013/c0_w0_br u_t007_013/c0_w1_bl u_t007_013/c0_w1_br
+ u_t007_013/c0_r0_rbl u_t007_013/c0_r1_rbl u_t007_013/c1_w0_bl u_t007_013/c1_w0_br
+ u_t007_013/c1_w1_bl u_t007_013/c1_w1_br u_t007_013/c1_r0_rbl u_t007_013/c1_r1_rbl
+ u_t007_013/c2_w0_bl u_t007_013/c2_w0_br u_t007_013/c2_w1_bl u_t007_013/c2_w1_br
+ u_t007_013/c2_r0_rbl u_t007_013/c2_r1_rbl u_t007_013/c3_w0_bl u_t007_013/c3_w0_br
+ u_t007_013/c3_w1_bl u_t007_013/c3_w1_br u_t007_013/c3_r0_rbl u_t007_013/c3_r1_rbl
+ u_t007_013/r0_w0_wl u_t007_013/r0_w1_wl u_t007_013/r0_r0_rwl u_t007_013/r0_r1_rwl
+ u_t007_013/r1_w0_wl u_t007_013/r1_w1_wl u_t007_013/r1_r0_rwl u_t007_013/r1_r1_rwl
+ u_t007_013/r2_w0_wl u_t007_013/r2_w1_wl u_t007_013/r2_r0_rwl u_t007_013/r2_r1_rwl
+ u_t007_013/r3_w0_wl u_t007_013/r3_w1_wl u_t007_013/r3_r0_rwl u_t007_013/r3_r1_rwl
+ u_t008_013/VDD u_t007_013/VSS VSUBS detronyx_12t_2w2r_rc4_4x4_routed_5layer_direct
Xu_t007_002 u_t007_002/c0_w0_bl u_t007_002/c0_w0_br u_t007_002/c0_w1_bl u_t007_002/c0_w1_br
+ u_t007_002/c0_r0_rbl u_t007_002/c0_r1_rbl u_t007_002/c1_w0_bl u_t007_002/c1_w0_br
+ u_t007_002/c1_w1_bl u_t007_002/c1_w1_br u_t007_002/c1_r0_rbl u_t007_002/c1_r1_rbl
+ u_t007_002/c2_w0_bl u_t007_002/c2_w0_br u_t007_002/c2_w1_bl u_t007_002/c2_w1_br
+ u_t007_002/c2_r0_rbl u_t007_002/c2_r1_rbl u_t007_002/c3_w0_bl u_t007_002/c3_w0_br
+ u_t007_002/c3_w1_bl u_t007_002/c3_w1_br u_t007_002/c3_r0_rbl u_t007_002/c3_r1_rbl
+ u_t007_002/r0_w0_wl u_t007_002/r0_w1_wl u_t007_002/r0_r0_rwl u_t007_002/r0_r1_rwl
+ u_t007_002/r1_w0_wl u_t007_002/r1_w1_wl u_t007_002/r1_r0_rwl u_t007_002/r1_r1_rwl
+ u_t007_002/r2_w0_wl u_t007_002/r2_w1_wl u_t007_002/r2_r0_rwl u_t007_002/r2_r1_rwl
+ u_t007_002/r3_w0_wl u_t007_002/r3_w1_wl u_t007_002/r3_r0_rwl u_t007_002/r3_r1_rwl
+ VSS u_t007_002/VSS VSUBS detronyx_12t_2w2r_rc4_4x4_routed_5layer_direct
Xu_t022_027 u_t022_027/c0_w0_bl u_t022_027/c0_w0_br u_t022_027/c0_w1_bl u_t022_027/c0_w1_br
+ u_t022_027/c0_r0_rbl u_t022_027/c0_r1_rbl u_t022_027/c1_w0_bl u_t022_027/c1_w0_br
+ u_t022_027/c1_w1_bl u_t022_027/c1_w1_br u_t022_027/c1_r0_rbl u_t022_027/c1_r1_rbl
+ u_t022_027/c2_w0_bl u_t022_027/c2_w0_br u_t022_027/c2_w1_bl u_t022_027/c2_w1_br
+ u_t022_027/c2_r0_rbl u_t022_027/c2_r1_rbl u_t022_027/c3_w0_bl u_t022_027/c3_w0_br
+ u_t022_027/c3_w1_bl u_t022_027/c3_w1_br u_t022_027/c3_r0_rbl u_t022_027/c3_r1_rbl
+ u_t022_027/r0_w0_wl u_t022_027/r0_w1_wl u_t022_027/r0_r0_rwl u_t022_027/r0_r1_rwl
+ u_t022_027/r1_w0_wl u_t022_027/r1_w1_wl u_t022_027/r1_r0_rwl u_t022_027/r1_r1_rwl
+ u_t022_027/r2_w0_wl u_t022_027/r2_w1_wl u_t022_027/r2_r0_rwl u_t022_027/r2_r1_rwl
+ u_t022_027/r3_w0_wl u_t022_027/r3_w1_wl u_t022_027/r3_r0_rwl u_t022_027/r3_r1_rwl
+ u_t022_027/VDD u_t022_031/VSS VSUBS detronyx_12t_2w2r_rc4_4x4_routed_5layer_direct
Xu_t022_016 u_t022_016/c0_w0_bl u_t022_016/c0_w0_br u_t022_016/c0_w1_bl u_t022_016/c0_w1_br
+ u_t022_016/c0_r0_rbl u_t022_016/c0_r1_rbl u_t022_016/c1_w0_bl u_t022_016/c1_w0_br
+ u_t022_016/c1_w1_bl u_t022_016/c1_w1_br u_t022_016/c1_r0_rbl u_t022_016/c1_r1_rbl
+ u_t022_016/c2_w0_bl u_t022_016/c2_w0_br u_t022_016/c2_w1_bl u_t022_016/c2_w1_br
+ u_t022_016/c2_r0_rbl u_t022_016/c2_r1_rbl u_t022_016/c3_w0_bl u_t022_016/c3_w0_br
+ u_t022_016/c3_w1_bl u_t022_016/c3_w1_br u_t022_016/c3_r0_rbl u_t022_016/c3_r1_rbl
+ u_t022_016/r0_w0_wl u_t022_016/r0_w1_wl u_t022_016/r0_r0_rwl u_t022_016/r0_r1_rwl
+ u_t022_016/r1_w0_wl u_t022_016/r1_w1_wl u_t022_016/r1_r0_rwl u_t022_016/r1_r1_rwl
+ u_t022_016/r2_w0_wl u_t022_016/r2_w1_wl u_t022_016/r2_r0_rwl u_t022_016/r2_r1_rwl
+ u_t022_016/r3_w0_wl u_t022_016/r3_w1_wl u_t022_016/r3_r0_rwl u_t022_016/r3_r1_rwl
+ VSS u_t022_031/VSS VSUBS detronyx_12t_2w2r_rc4_4x4_routed_5layer_direct
Xu_t022_005 u_t022_005/c0_w0_bl u_t022_005/c0_w0_br u_t022_005/c0_w1_bl u_t022_005/c0_w1_br
+ u_t022_005/c0_r0_rbl u_t022_005/c0_r1_rbl u_t022_005/c1_w0_bl u_t022_005/c1_w0_br
+ u_t022_005/c1_w1_bl u_t022_005/c1_w1_br u_t022_005/c1_r0_rbl u_t022_005/c1_r1_rbl
+ u_t022_005/c2_w0_bl u_t022_005/c2_w0_br u_t022_005/c2_w1_bl u_t022_005/c2_w1_br
+ u_t022_005/c2_r0_rbl u_t022_005/c2_r1_rbl u_t022_005/c3_w0_bl u_t022_005/c3_w0_br
+ u_t022_005/c3_w1_bl u_t022_005/c3_w1_br u_t022_005/c3_r0_rbl u_t022_005/c3_r1_rbl
+ u_t022_005/r0_w0_wl u_t022_005/r0_w1_wl u_t022_005/r0_r0_rwl u_t022_005/r0_r1_rwl
+ u_t022_005/r1_w0_wl u_t022_005/r1_w1_wl u_t022_005/r1_r0_rwl u_t022_005/r1_r1_rwl
+ u_t022_005/r2_w0_wl u_t022_005/r2_w1_wl u_t022_005/r2_r0_rwl u_t022_005/r2_r1_rwl
+ u_t022_005/r3_w0_wl u_t022_005/r3_w1_wl u_t022_005/r3_r0_rwl u_t022_005/r3_r1_rwl
+ u_t022_005/VDD u_t022_031/VSS VSUBS detronyx_12t_2w2r_rc4_4x4_routed_5layer_direct
Xgf180mcu_as_sc_mcu7t3v3__nand4_2_461 gf180mcu_as_sc_mcu7t3v3__inv_2_1589/VSS VSS
+ VSS VSS VSS VSS gf180mcu_as_sc_mcu7t3v3__nand4_2_461/Y gf180mcu_as_sc_mcu7t3v3__inv_2_1557/VNW
+ VSUBS gf180mcu_as_sc_mcu7t3v3__nand4_2
Xgf180mcu_as_sc_mcu7t3v3__nand4_2_450 gf180mcu_as_sc_mcu7t3v3__inv_2_1552/VSS gf180mcu_as_sc_mcu7t3v3__inv_2_1514/VDD
+ VSS VSS VSS VSS gf180mcu_as_sc_mcu7t3v3__nand4_2_450/Y gf180mcu_as_sc_mcu7t3v3__inv_2_1510/VNW
+ VSUBS gf180mcu_as_sc_mcu7t3v3__nand4_2
Xgf180mcu_as_sc_mcu7t3v3__nand4_2_494 VSS VSS VSS VSS VSS VSS VSS gf180mcu_as_sc_mcu7t3v3__inv_2_1658/VNW
+ VSUBS gf180mcu_as_sc_mcu7t3v3__nand4_2
Xgf180mcu_as_sc_mcu7t3v3__nand4_2_472 VSS gf180mcu_as_sc_mcu7t3v3__inv_2_1524/VDD
+ VSS VSS VSS VSS gf180mcu_as_sc_mcu7t3v3__nand4_2_472/Y gf180mcu_as_sc_mcu7t3v3__inv_2_1520/VNW
+ VSUBS gf180mcu_as_sc_mcu7t3v3__nand4_2
Xgf180mcu_as_sc_mcu7t3v3__nand4_2_483 gf180mcu_as_sc_mcu7t3v3__inv_2_1660/VDD VSS
+ VSS VSS VSS VSS VSS gf180mcu_as_sc_mcu7t3v3__inv_2_1660/VNW VSUBS gf180mcu_as_sc_mcu7t3v3__nand4_2
Xu_t013_027 u_t013_027/c0_w0_bl u_t013_027/c0_w0_br u_t013_027/c0_w1_bl u_t013_027/c0_w1_br
+ u_t013_027/c0_r0_rbl u_t013_027/c0_r1_rbl u_t013_027/c1_w0_bl u_t013_027/c1_w0_br
+ u_t013_027/c1_w1_bl u_t013_027/c1_w1_br u_t013_027/c1_r0_rbl u_t013_027/c1_r1_rbl
+ u_t013_027/c2_w0_bl u_t013_027/c2_w0_br u_t013_027/c2_w1_bl u_t013_027/c2_w1_br
+ u_t013_027/c2_r0_rbl u_t013_027/c2_r1_rbl u_t013_027/c3_w0_bl u_t013_027/c3_w0_br
+ u_t013_027/c3_w1_bl u_t013_027/c3_w1_br u_t013_027/c3_r0_rbl u_t013_027/c3_r1_rbl
+ u_t013_027/r0_w0_wl u_t013_027/r0_w1_wl u_t013_027/r0_r0_rwl u_t013_027/r0_r1_rwl
+ u_t013_027/r1_w0_wl u_t013_027/r1_w1_wl u_t013_027/r1_r0_rwl u_t013_027/r1_r1_rwl
+ u_t013_027/r2_w0_wl u_t013_027/r2_w1_wl u_t013_027/r2_r0_rwl u_t013_027/r2_r1_rwl
+ u_t013_027/r3_w0_wl u_t013_027/r3_w1_wl u_t013_027/r3_r0_rwl u_t013_027/r3_r1_rwl
+ u_t013_027/VDD u_t013_031/VSS VSUBS detronyx_12t_2w2r_rc4_4x4_routed_5layer_direct
Xu_t013_016 u_t013_016/c0_w0_bl u_t013_016/c0_w0_br u_t013_016/c0_w1_bl u_t013_016/c0_w1_br
+ u_t013_016/c0_r0_rbl u_t013_016/c0_r1_rbl u_t013_016/c1_w0_bl u_t013_016/c1_w0_br
+ u_t013_016/c1_w1_bl u_t013_016/c1_w1_br u_t013_016/c1_r0_rbl u_t013_016/c1_r1_rbl
+ u_t013_016/c2_w0_bl u_t013_016/c2_w0_br u_t013_016/c2_w1_bl u_t013_016/c2_w1_br
+ u_t013_016/c2_r0_rbl u_t013_016/c2_r1_rbl u_t013_016/c3_w0_bl u_t013_016/c3_w0_br
+ u_t013_016/c3_w1_bl u_t013_016/c3_w1_br u_t013_016/c3_r0_rbl u_t013_016/c3_r1_rbl
+ u_t013_016/r0_w0_wl u_t013_016/r0_w1_wl u_t013_016/r0_r0_rwl u_t013_016/r0_r1_rwl
+ u_t013_016/r1_w0_wl u_t013_016/r1_w1_wl u_t013_016/r1_r0_rwl u_t013_016/r1_r1_rwl
+ u_t013_016/r2_w0_wl u_t013_016/r2_w1_wl u_t013_016/r2_r0_rwl u_t013_016/r2_r1_rwl
+ u_t013_016/r3_w0_wl u_t013_016/r3_w1_wl u_t013_016/r3_r0_rwl u_t013_016/r3_r1_rwl
+ VSS u_t013_031/VSS VSUBS detronyx_12t_2w2r_rc4_4x4_routed_5layer_direct
Xu_t013_005 u_t013_005/c0_w0_bl u_t013_005/c0_w0_br u_t013_005/c0_w1_bl u_t013_005/c0_w1_br
+ u_t013_005/c0_r0_rbl u_t013_005/c0_r1_rbl u_t013_005/c1_w0_bl u_t013_005/c1_w0_br
+ u_t013_005/c1_w1_bl u_t013_005/c1_w1_br u_t013_005/c1_r0_rbl u_t013_005/c1_r1_rbl
+ u_t013_005/c2_w0_bl u_t013_005/c2_w0_br u_t013_005/c2_w1_bl u_t013_005/c2_w1_br
+ u_t013_005/c2_r0_rbl u_t013_005/c2_r1_rbl u_t013_005/c3_w0_bl u_t013_005/c3_w0_br
+ u_t013_005/c3_w1_bl u_t013_005/c3_w1_br u_t013_005/c3_r0_rbl u_t013_005/c3_r1_rbl
+ u_t013_005/r0_w0_wl u_t013_005/r0_w1_wl u_t013_005/r0_r0_rwl u_t013_005/r0_r1_rwl
+ u_t013_005/r1_w0_wl u_t013_005/r1_w1_wl u_t013_005/r1_r0_rwl u_t013_005/r1_r1_rwl
+ u_t013_005/r2_w0_wl u_t013_005/r2_w1_wl u_t013_005/r2_r0_rwl u_t013_005/r2_r1_rwl
+ u_t013_005/r3_w0_wl u_t013_005/r3_w1_wl u_t013_005/r3_r0_rwl u_t013_005/r3_r1_rwl
+ u_t013_005/VDD u_t013_031/VSS VSUBS detronyx_12t_2w2r_rc4_4x4_routed_5layer_direct
Xgf180mcu_as_sc_mcu7t3v3__inv_2_414 VSS VSS VSS VSS gf180mcu_as_sc_mcu7t3v3__inv_2_443/VNW
+ VSUBS gf180mcu_as_sc_mcu7t3v3__inv_2
Xgf180mcu_as_sc_mcu7t3v3__inv_2_436 VSS VSS VSS VSS gf180mcu_as_sc_mcu7t3v3__inv_2_437/VNW
+ VSUBS gf180mcu_as_sc_mcu7t3v3__inv_2
Xgf180mcu_as_sc_mcu7t3v3__inv_2_425 gf180mcu_as_sc_mcu7t3v3__nor2_2_4/VDD gf180mcu_as_sc_mcu7t3v3__nand3_2_8/VSS
+ VSS VSS gf180mcu_as_sc_mcu7t3v3__nor2_2_4/VNW VSUBS gf180mcu_as_sc_mcu7t3v3__inv_2
Xgf180mcu_as_sc_mcu7t3v3__inv_2_403 gf180mcu_as_sc_mcu7t3v3__nand3_2_5/VDD gf180mcu_as_sc_mcu7t3v3__nor2_2_4/VSS
+ VSS VSS gf180mcu_as_sc_mcu7t3v3__nand3_2_5/VNW VSUBS gf180mcu_as_sc_mcu7t3v3__inv_2
Xu_t004_027 u_t004_027/c0_w0_bl u_t004_027/c0_w0_br u_t004_027/c0_w1_bl u_t004_027/c0_w1_br
+ u_t004_027/c0_r0_rbl u_t004_027/c0_r1_rbl u_t004_027/c1_w0_bl u_t004_027/c1_w0_br
+ u_t004_027/c1_w1_bl u_t004_027/c1_w1_br u_t004_027/c1_r0_rbl u_t004_027/c1_r1_rbl
+ u_t004_027/c2_w0_bl u_t004_027/c2_w0_br u_t004_027/c2_w1_bl u_t004_027/c2_w1_br
+ u_t004_027/c2_r0_rbl u_t004_027/c2_r1_rbl u_t004_027/c3_w0_bl u_t004_027/c3_w0_br
+ u_t004_027/c3_w1_bl u_t004_027/c3_w1_br u_t004_027/c3_r0_rbl u_t004_027/c3_r1_rbl
+ u_t004_027/r0_w0_wl u_t004_027/r0_w1_wl u_t004_027/r0_r0_rwl u_t004_027/r0_r1_rwl
+ u_t004_027/r1_w0_wl u_t004_027/r1_w1_wl u_t004_027/r1_r0_rwl u_t004_027/r1_r1_rwl
+ u_t004_027/r2_w0_wl u_t004_027/r2_w1_wl u_t004_027/r2_r0_rwl u_t004_027/r2_r1_rwl
+ u_t004_027/r3_w0_wl u_t004_027/r3_w1_wl u_t004_027/r3_r0_rwl u_t004_027/r3_r1_rwl
+ u_t004_027/VDD u_t004_031/VSS VSUBS detronyx_12t_2w2r_rc4_4x4_routed_5layer_direct
Xu_t004_016 u_t004_016/c0_w0_bl u_t004_016/c0_w0_br u_t004_016/c0_w1_bl u_t004_016/c0_w1_br
+ u_t004_016/c0_r0_rbl u_t004_016/c0_r1_rbl u_t004_016/c1_w0_bl u_t004_016/c1_w0_br
+ u_t004_016/c1_w1_bl u_t004_016/c1_w1_br u_t004_016/c1_r0_rbl u_t004_016/c1_r1_rbl
+ u_t004_016/c2_w0_bl u_t004_016/c2_w0_br u_t004_016/c2_w1_bl u_t004_016/c2_w1_br
+ u_t004_016/c2_r0_rbl u_t004_016/c2_r1_rbl u_t004_016/c3_w0_bl u_t004_016/c3_w0_br
+ u_t004_016/c3_w1_bl u_t004_016/c3_w1_br u_t004_016/c3_r0_rbl u_t004_016/c3_r1_rbl
+ u_t004_016/r0_w0_wl u_t004_016/r0_w1_wl u_t004_016/r0_r0_rwl u_t004_016/r0_r1_rwl
+ u_t004_016/r1_w0_wl u_t004_016/r1_w1_wl u_t004_016/r1_r0_rwl u_t004_016/r1_r1_rwl
+ u_t004_016/r2_w0_wl u_t004_016/r2_w1_wl u_t004_016/r2_r0_rwl u_t004_016/r2_r1_rwl
+ u_t004_016/r3_w0_wl u_t004_016/r3_w1_wl u_t004_016/r3_r0_rwl u_t004_016/r3_r1_rwl
+ VSS u_t004_031/VSS VSUBS detronyx_12t_2w2r_rc4_4x4_routed_5layer_direct
Xu_t004_005 u_t004_005/c0_w0_bl u_t004_005/c0_w0_br u_t004_005/c0_w1_bl u_t004_005/c0_w1_br
+ u_t004_005/c0_r0_rbl u_t004_005/c0_r1_rbl u_t004_005/c1_w0_bl u_t004_005/c1_w0_br
+ u_t004_005/c1_w1_bl u_t004_005/c1_w1_br u_t004_005/c1_r0_rbl u_t004_005/c1_r1_rbl
+ u_t004_005/c2_w0_bl u_t004_005/c2_w0_br u_t004_005/c2_w1_bl u_t004_005/c2_w1_br
+ u_t004_005/c2_r0_rbl u_t004_005/c2_r1_rbl u_t004_005/c3_w0_bl u_t004_005/c3_w0_br
+ u_t004_005/c3_w1_bl u_t004_005/c3_w1_br u_t004_005/c3_r0_rbl u_t004_005/c3_r1_rbl
+ u_t004_005/r0_w0_wl u_t004_005/r0_w1_wl u_t004_005/r0_r0_rwl u_t004_005/r0_r1_rwl
+ u_t004_005/r1_w0_wl u_t004_005/r1_w1_wl u_t004_005/r1_r0_rwl u_t004_005/r1_r1_rwl
+ u_t004_005/r2_w0_wl u_t004_005/r2_w1_wl u_t004_005/r2_r0_rwl u_t004_005/r2_r1_rwl
+ u_t004_005/r3_w0_wl u_t004_005/r3_w1_wl u_t004_005/r3_r0_rwl u_t004_005/r3_r1_rwl
+ u_t004_005/VDD u_t004_031/VSS VSUBS detronyx_12t_2w2r_rc4_4x4_routed_5layer_direct
Xgf180mcu_as_sc_mcu7t3v3__inv_2_447 VSS VSS gf180mcu_as_sc_mcu7t3v3__inv_2_447/Y VSS
+ gf180mcu_as_sc_mcu7t3v3__inv_2_447/VNW VSUBS gf180mcu_as_sc_mcu7t3v3__inv_2
Xgf180mcu_as_sc_mcu7t3v3__inv_2_469 gf180mcu_as_sc_mcu7t3v3__nor2_2_4/VDD gf180mcu_as_sc_mcu7t3v3__nand3_2_8/VSS
+ VSS VSS gf180mcu_as_sc_mcu7t3v3__nor2_2_4/VNW VSUBS gf180mcu_as_sc_mcu7t3v3__inv_2
Xgf180mcu_as_sc_mcu7t3v3__inv_2_458 gf180mcu_as_sc_mcu7t3v3__nor2_2_6/VDD gf180mcu_as_sc_mcu7t3v3__nor2_2_6/VSS
+ VSS VSS gf180mcu_as_sc_mcu7t3v3__nor2_2_6/VNW VSUBS gf180mcu_as_sc_mcu7t3v3__inv_2
Xgf180mcu_as_sc_mcu7t3v3__inv_2_981 gf180mcu_as_sc_mcu7t3v3__inv_2_982/VDD VSS gf180mcu_as_sc_mcu7t3v3__inv_2_981/Y
+ gf180mcu_as_sc_mcu7t3v3__inv_2_982/Y gf180mcu_as_sc_mcu7t3v3__inv_2_982/VNW VSUBS
+ gf180mcu_as_sc_mcu7t3v3__inv_2
Xgf180mcu_as_sc_mcu7t3v3__inv_2_970 gf180mcu_as_sc_mcu7t3v3__inv_2_970/VDD VSS gf180mcu_as_sc_mcu7t3v3__inv_2_970/Y
+ VSS gf180mcu_as_sc_mcu7t3v3__inv_2_970/VNW VSUBS gf180mcu_as_sc_mcu7t3v3__inv_2
Xu_t010_019 u_t010_019/c0_w0_bl u_t010_019/c0_w0_br u_t010_019/c0_w1_bl u_t010_019/c0_w1_br
+ u_t010_019/c0_r0_rbl u_t010_019/c0_r1_rbl u_t010_019/c1_w0_bl u_t010_019/c1_w0_br
+ u_t010_019/c1_w1_bl u_t010_019/c1_w1_br u_t010_019/c1_r0_rbl u_t010_019/c1_r1_rbl
+ u_t010_019/c2_w0_bl u_t010_019/c2_w0_br u_t010_019/c2_w1_bl u_t010_019/c2_w1_br
+ u_t010_019/c2_r0_rbl u_t010_019/c2_r1_rbl u_t010_019/c3_w0_bl u_t010_019/c3_w0_br
+ u_t010_019/c3_w1_bl u_t010_019/c3_w1_br u_t010_019/c3_r0_rbl u_t010_019/c3_r1_rbl
+ u_t010_019/r0_w0_wl u_t010_019/r0_w1_wl u_t010_019/r0_r0_rwl u_t010_019/r0_r1_rwl
+ u_t010_019/r1_w0_wl u_t010_019/r1_w1_wl u_t010_019/r1_r0_rwl u_t010_019/r1_r1_rwl
+ u_t010_019/r2_w0_wl u_t010_019/r2_w1_wl u_t010_019/r2_r0_rwl u_t010_019/r2_r1_rwl
+ u_t010_019/r3_w0_wl u_t010_019/r3_w1_wl u_t010_019/r3_r0_rwl u_t010_019/r3_r1_rwl
+ u_t010_019/VDD u_t010_019/VSS VSUBS detronyx_12t_2w2r_rc4_4x4_routed_5layer_direct
Xu_t010_008 u_t010_008/c0_w0_bl u_t010_008/c0_w0_br u_t010_008/c0_w1_bl u_t010_008/c0_w1_br
+ u_t010_008/c0_r0_rbl u_t010_008/c0_r1_rbl u_t010_008/c1_w0_bl u_t010_008/c1_w0_br
+ u_t010_008/c1_w1_bl u_t010_008/c1_w1_br u_t010_008/c1_r0_rbl u_t010_008/c1_r1_rbl
+ u_t010_008/c2_w0_bl u_t010_008/c2_w0_br u_t010_008/c2_w1_bl u_t010_008/c2_w1_br
+ u_t010_008/c2_r0_rbl u_t010_008/c2_r1_rbl u_t010_008/c3_w0_bl u_t010_008/c3_w0_br
+ u_t010_008/c3_w1_bl u_t010_008/c3_w1_br u_t010_008/c3_r0_rbl u_t010_008/c3_r1_rbl
+ u_t010_008/r0_w0_wl u_t010_008/r0_w1_wl u_t010_008/r0_r0_rwl u_t010_008/r0_r1_rwl
+ u_t010_008/r1_w0_wl u_t010_008/r1_w1_wl u_t010_008/r1_r0_rwl u_t010_008/r1_r1_rwl
+ u_t010_008/r2_w0_wl u_t010_008/r2_w1_wl u_t010_008/r2_r0_rwl u_t010_008/r2_r1_rwl
+ u_t010_008/r3_w0_wl u_t010_008/r3_w1_wl u_t010_008/r3_r0_rwl u_t010_008/r3_r1_rwl
+ VSS u_t010_009/VSS VSUBS detronyx_12t_2w2r_rc4_4x4_routed_5layer_direct
Xgf180mcu_as_sc_mcu7t3v3__inv_2_992 gf180mcu_as_sc_mcu7t3v3__inv_2_994/VDD VSS VSS
+ gf180mcu_as_sc_mcu7t3v3__inv_2_992/A gf180mcu_as_sc_mcu7t3v3__inv_2_994/VNW VSUBS
+ gf180mcu_as_sc_mcu7t3v3__inv_2
Xgf180mcu_as_sc_mcu7t3v3__nand4_2_291 gf180mcu_as_sc_mcu7t3v3__inv_2_982/VDD VSS VSS
+ VSS VSS VSS VSS gf180mcu_as_sc_mcu7t3v3__inv_2_982/VNW VSUBS gf180mcu_as_sc_mcu7t3v3__nand4_2
Xgf180mcu_as_sc_mcu7t3v3__nand4_2_280 VSS VSS VSS VSS VSS VSS VSS gf180mcu_as_sc_mcu7t3v3__inv_2_933/VNW
+ VSUBS gf180mcu_as_sc_mcu7t3v3__nand4_2
Xu_t001_019 u_t001_019/c0_w0_bl u_t001_019/c0_w0_br u_t001_019/c0_w1_bl u_t001_019/c0_w1_br
+ u_t001_019/c0_r0_rbl u_t001_019/c0_r1_rbl u_t001_019/c1_w0_bl u_t001_019/c1_w0_br
+ u_t001_019/c1_w1_bl u_t001_019/c1_w1_br u_t001_019/c1_r0_rbl u_t001_019/c1_r1_rbl
+ u_t001_019/c2_w0_bl u_t001_019/c2_w0_br u_t001_019/c2_w1_bl u_t001_019/c2_w1_br
+ u_t001_019/c2_r0_rbl u_t001_019/c2_r1_rbl u_t001_019/c3_w0_bl u_t001_019/c3_w0_br
+ u_t001_019/c3_w1_bl u_t001_019/c3_w1_br u_t001_019/c3_r0_rbl u_t001_019/c3_r1_rbl
+ u_t001_019/r0_w0_wl u_t001_019/r0_w1_wl u_t001_019/r0_r0_rwl u_t001_019/r0_r1_rwl
+ u_t001_019/r1_w0_wl u_t001_019/r1_w1_wl u_t001_019/r1_r0_rwl u_t001_019/r1_r1_rwl
+ u_t001_019/r2_w0_wl u_t001_019/r2_w1_wl u_t001_019/r2_r0_rwl u_t001_019/r2_r1_rwl
+ u_t001_019/r3_w0_wl u_t001_019/r3_w1_wl u_t001_019/r3_r0_rwl u_t001_019/r3_r1_rwl
+ u_t001_019/VDD u_t001_031/VSS VSUBS detronyx_12t_2w2r_rc4_4x4_routed_5layer_direct
Xu_t001_008 u_t001_008/c0_w0_bl u_t001_008/c0_w0_br u_t001_008/c0_w1_bl u_t001_008/c0_w1_br
+ u_t001_008/c0_r0_rbl u_t001_008/c0_r1_rbl u_t001_008/c1_w0_bl u_t001_008/c1_w0_br
+ u_t001_008/c1_w1_bl u_t001_008/c1_w1_br u_t001_008/c1_r0_rbl u_t001_008/c1_r1_rbl
+ u_t001_008/c2_w0_bl u_t001_008/c2_w0_br u_t001_008/c2_w1_bl u_t001_008/c2_w1_br
+ u_t001_008/c2_r0_rbl u_t001_008/c2_r1_rbl u_t001_008/c3_w0_bl u_t001_008/c3_w0_br
+ u_t001_008/c3_w1_bl u_t001_008/c3_w1_br u_t001_008/c3_r0_rbl u_t001_008/c3_r1_rbl
+ u_t001_008/r0_w0_wl u_t001_008/r0_w1_wl u_t001_008/r0_r0_rwl u_t001_008/r0_r1_rwl
+ u_t001_008/r1_w0_wl u_t001_008/r1_w1_wl u_t001_008/r1_r0_rwl u_t001_008/r1_r1_rwl
+ u_t001_008/r2_w0_wl u_t001_008/r2_w1_wl u_t001_008/r2_r0_rwl u_t001_008/r2_r1_rwl
+ u_t001_008/r3_w0_wl u_t001_008/r3_w1_wl u_t001_008/r3_r0_rwl u_t001_008/r3_r1_rwl
+ VSS u_t001_031/VSS VSUBS detronyx_12t_2w2r_rc4_4x4_routed_5layer_direct
Xgf180mcu_as_sc_mcu7t3v3__inv_2_277 VSS gf180mcu_as_sc_mcu7t3v3__inv_2_353/VDD VSS
+ gf180mcu_as_sc_mcu7t3v3__inv_2_66/Y gf180mcu_as_sc_mcu7t3v3__inv_2_352/VNW VSUBS
+ gf180mcu_as_sc_mcu7t3v3__inv_2
Xgf180mcu_as_sc_mcu7t3v3__inv_2_200 gf180mcu_as_sc_mcu7t3v3__inv_2_200/VDD VSS VSS
+ VSS gf180mcu_as_sc_mcu7t3v3__inv_2_200/VNW VSUBS gf180mcu_as_sc_mcu7t3v3__inv_2
Xgf180mcu_as_sc_mcu7t3v3__inv_2_266 VSS gf180mcu_as_sc_mcu7t3v3__inv_2_350/VDD gf180mcu_as_sc_mcu7t3v3__inv_2_266/Y
+ gf180mcu_as_sc_mcu7t3v3__inv_2_66/Y gf180mcu_as_sc_mcu7t3v3__inv_2_349/VNW VSUBS
+ gf180mcu_as_sc_mcu7t3v3__inv_2
Xgf180mcu_as_sc_mcu7t3v3__inv_2_222 VSS VSS VSS VSS gf180mcu_as_sc_mcu7t3v3__inv_2_224/VNW
+ VSUBS gf180mcu_as_sc_mcu7t3v3__inv_2
Xgf180mcu_as_sc_mcu7t3v3__inv_2_244 gf180mcu_as_sc_mcu7t3v3__inv_2_245/VDD VSS VSS
+ VSS gf180mcu_as_sc_mcu7t3v3__inv_2_245/VNW VSUBS gf180mcu_as_sc_mcu7t3v3__inv_2
Xgf180mcu_as_sc_mcu7t3v3__inv_2_233 gf180mcu_as_sc_mcu7t3v3__inv_2_233/VDD VSS VSS
+ VSS gf180mcu_as_sc_mcu7t3v3__inv_2_233/VNW VSUBS gf180mcu_as_sc_mcu7t3v3__inv_2
Xgf180mcu_as_sc_mcu7t3v3__inv_2_255 VSS VSS VSS VSS gf180mcu_as_sc_mcu7t3v3__inv_2_256/VNW
+ VSUBS gf180mcu_as_sc_mcu7t3v3__inv_2
Xgf180mcu_as_sc_mcu7t3v3__inv_2_211 VSS gf180mcu_as_sc_mcu7t3v3__inv_2_229/VDD gf180mcu_as_sc_mcu7t3v3__inv_2_211/Y
+ VSS gf180mcu_as_sc_mcu7t3v3__inv_2_213/VNW VSUBS gf180mcu_as_sc_mcu7t3v3__inv_2
Xu_t000_030 u_t000_030/c0_w0_bl u_t000_030/c0_w0_br u_t000_030/c0_w1_bl u_t000_030/c0_w1_br
+ u_t000_030/c0_r0_rbl u_t000_030/c0_r1_rbl u_t000_030/c1_w0_bl u_t000_030/c1_w0_br
+ u_t000_030/c1_w1_bl u_t000_030/c1_w1_br u_t000_030/c1_r0_rbl u_t000_030/c1_r1_rbl
+ u_t000_030/c2_w0_bl u_t000_030/c2_w0_br u_t000_030/c2_w1_bl u_t000_030/c2_w1_br
+ u_t000_030/c2_r0_rbl u_t000_030/c2_r1_rbl u_t000_030/c3_w0_bl u_t000_030/c3_w0_br
+ u_t000_030/c3_w1_bl u_t000_030/c3_w1_br u_t000_030/c3_r0_rbl u_t000_030/c3_r1_rbl
+ u_t000_030/r0_w0_wl u_t000_030/r0_w1_wl u_t000_030/r0_r0_rwl u_t000_030/r0_r1_rwl
+ u_t000_030/r1_w0_wl u_t000_030/r1_w1_wl u_t000_030/r1_r0_rwl u_t000_030/r1_r1_rwl
+ u_t000_030/r2_w0_wl u_t000_030/r2_w1_wl u_t000_030/r2_r0_rwl u_t000_030/r2_r1_rwl
+ u_t000_030/r3_w0_wl u_t000_030/r3_w1_wl u_t000_030/r3_r0_rwl u_t000_030/r3_r1_rwl
+ VSS u_t000_031/VSS VSUBS detronyx_12t_2w2r_rc4_4x4_routed_5layer_direct
Xgf180mcu_as_sc_mcu7t3v3__inv_2_288 gf180mcu_as_sc_mcu7t3v3__inv_2_360/VDD gf180mcu_as_sc_mcu7t3v3__inv_2_361/VDD
+ gf180mcu_as_sc_mcu7t3v3__inv_2_288/Y gf180mcu_as_sc_mcu7t3v3__inv_2_361/Y gf180mcu_as_sc_mcu7t3v3__inv_2_360/VNW
+ VSUBS gf180mcu_as_sc_mcu7t3v3__inv_2
Xgf180mcu_as_sc_mcu7t3v3__inv_2_299 VSS gf180mcu_as_sc_mcu7t3v3__inv_2_331/VDD gf180mcu_as_sc_mcu7t3v3__inv_2_299/Y
+ gf180mcu_as_sc_mcu7t3v3__inv_2_338/Y gf180mcu_as_sc_mcu7t3v3__inv_2_330/VNW VSUBS
+ gf180mcu_as_sc_mcu7t3v3__inv_2
Xgf180mcu_as_sc_mcu7t3v3__inv_2_1529 VSS gf180mcu_as_sc_mcu7t3v3__inv_2_1552/VSS gf180mcu_as_sc_mcu7t3v3__inv_2_1529/Y
+ VSS gf180mcu_as_sc_mcu7t3v3__inv_2_1552/VNW VSUBS gf180mcu_as_sc_mcu7t3v3__inv_2
Xgf180mcu_as_sc_mcu7t3v3__inv_2_1518 VSS gf180mcu_as_sc_mcu7t3v3__inv_2_1535/VDD VSS
+ VSS gf180mcu_as_sc_mcu7t3v3__inv_2_1518/VNW VSUBS gf180mcu_as_sc_mcu7t3v3__inv_2
Xgf180mcu_as_sc_mcu7t3v3__inv_2_1507 VSS VSS VSS VSS gf180mcu_as_sc_mcu7t3v3__inv_2_1553/VNW
+ VSUBS gf180mcu_as_sc_mcu7t3v3__inv_2
Xgf180mcu_as_sc_mcu7t3v3__nor2_2_1 gf180mcu_as_sc_mcu7t3v3__nor2_2_6/VDD gf180mcu_as_sc_mcu7t3v3__nor2_2_6/VSS
+ VSS VSS VSS gf180mcu_as_sc_mcu7t3v3__nor2_2_6/VNW VSUBS gf180mcu_as_sc_mcu7t3v3__nor2_2
Xgf180mcu_as_sc_mcu7t3v3__nand2_2_6 gf180mcu_as_sc_mcu7t3v3__nand3_2_5/VDD gf180mcu_as_sc_mcu7t3v3__nor2_2_6/VSS
+ VSS VSS VSS gf180mcu_as_sc_mcu7t3v3__nand3_2_5/VNW VSUBS gf180mcu_as_sc_mcu7t3v3__nand2_2
Xgf180mcu_as_sc_mcu7t3v3__inv_2_1315 gf180mcu_as_sc_mcu7t3v3__inv_2_1379/VDD VSS gf180mcu_as_sc_mcu7t3v3__inv_2_1315/Y
+ gf180mcu_as_sc_mcu7t3v3__inv_2_1379/Y gf180mcu_as_sc_mcu7t3v3__inv_2_1379/VNW VSUBS
+ gf180mcu_as_sc_mcu7t3v3__inv_2
Xgf180mcu_as_sc_mcu7t3v3__inv_2_1326 gf180mcu_as_sc_mcu7t3v3__inv_2_1376/VDD VSS VSS
+ gf180mcu_as_sc_mcu7t3v3__inv_2_1379/Y gf180mcu_as_sc_mcu7t3v3__inv_2_1376/VNW VSUBS
+ gf180mcu_as_sc_mcu7t3v3__inv_2
Xgf180mcu_as_sc_mcu7t3v3__inv_2_1304 gf180mcu_as_sc_mcu7t3v3__inv_2_1397/VSS VSS VSS
+ gf180mcu_as_sc_mcu7t3v3__inv_2_1398/Y gf180mcu_as_sc_mcu7t3v3__inv_2_1366/VNW VSUBS
+ gf180mcu_as_sc_mcu7t3v3__inv_2
Xgf180mcu_as_sc_mcu7t3v3__inv_2_1348 gf180mcu_as_sc_mcu7t3v3__inv_2_1400/VSS VSS gf180mcu_as_sc_mcu7t3v3__inv_2_1685/Y
+ gf180mcu_as_sc_mcu7t3v3__inv_2_1685/Y gf180mcu_as_sc_mcu7t3v3__inv_2_1381/VNW VSUBS
+ gf180mcu_as_sc_mcu7t3v3__inv_2
Xgf180mcu_as_sc_mcu7t3v3__inv_2_1359 VSS VSS VSS gf180mcu_as_sc_mcu7t3v3__inv_2_1387/Y
+ gf180mcu_as_sc_mcu7t3v3__inv_2_1385/VNW VSUBS gf180mcu_as_sc_mcu7t3v3__inv_2
Xgf180mcu_as_sc_mcu7t3v3__inv_2_1337 VSS gf180mcu_as_sc_mcu7t3v3__inv_2_1390/VDD VSS
+ gf180mcu_as_sc_mcu7t3v3__inv_2_1398/Y gf180mcu_as_sc_mcu7t3v3__inv_2_1389/VNW VSUBS
+ gf180mcu_as_sc_mcu7t3v3__inv_2
Xu_t028_022 u_t028_022/c0_w0_bl u_t028_022/c0_w0_br u_t028_022/c0_w1_bl u_t028_022/c0_w1_br
+ u_t028_022/c0_r0_rbl u_t028_022/c0_r1_rbl u_t028_022/c1_w0_bl u_t028_022/c1_w0_br
+ u_t028_022/c1_w1_bl u_t028_022/c1_w1_br u_t028_022/c1_r0_rbl u_t028_022/c1_r1_rbl
+ u_t028_022/c2_w0_bl u_t028_022/c2_w0_br u_t028_022/c2_w1_bl u_t028_022/c2_w1_br
+ u_t028_022/c2_r0_rbl u_t028_022/c2_r1_rbl u_t028_022/c3_w0_bl u_t028_022/c3_w0_br
+ u_t028_022/c3_w1_bl u_t028_022/c3_w1_br u_t028_022/c3_r0_rbl u_t028_022/c3_r1_rbl
+ u_t028_022/r0_w0_wl u_t028_022/r0_w1_wl u_t028_022/r0_r0_rwl u_t028_022/r0_r1_rwl
+ u_t028_022/r1_w0_wl u_t028_022/r1_w1_wl u_t028_022/r1_r0_rwl u_t028_022/r1_r1_rwl
+ u_t028_022/r2_w0_wl u_t028_022/r2_w1_wl u_t028_022/r2_r0_rwl u_t028_022/r2_r1_rwl
+ u_t028_022/r3_w0_wl u_t028_022/r3_w1_wl u_t028_022/r3_r0_rwl u_t028_022/r3_r1_rwl
+ VSS u_t028_024/VSS VSUBS detronyx_12t_2w2r_rc4_4x4_routed_5layer_direct
Xu_t028_011 u_t028_011/c0_w0_bl u_t028_011/c0_w0_br u_t028_011/c0_w1_bl u_t028_011/c0_w1_br
+ u_t028_011/c0_r0_rbl u_t028_011/c0_r1_rbl u_t028_011/c1_w0_bl u_t028_011/c1_w0_br
+ u_t028_011/c1_w1_bl u_t028_011/c1_w1_br u_t028_011/c1_r0_rbl u_t028_011/c1_r1_rbl
+ u_t028_011/c2_w0_bl u_t028_011/c2_w0_br u_t028_011/c2_w1_bl u_t028_011/c2_w1_br
+ u_t028_011/c2_r0_rbl u_t028_011/c2_r1_rbl u_t028_011/c3_w0_bl u_t028_011/c3_w0_br
+ u_t028_011/c3_w1_bl u_t028_011/c3_w1_br u_t028_011/c3_r0_rbl u_t028_011/c3_r1_rbl
+ u_t028_011/r0_w0_wl u_t028_011/r0_w1_wl u_t028_011/r0_r0_rwl u_t028_011/r0_r1_rwl
+ u_t028_011/r1_w0_wl u_t028_011/r1_w1_wl u_t028_011/r1_r0_rwl u_t028_011/r1_r1_rwl
+ u_t028_011/r2_w0_wl u_t028_011/r2_w1_wl u_t028_011/r2_r0_rwl u_t028_011/r2_r1_rwl
+ u_t028_011/r3_w0_wl u_t028_011/r3_w1_wl u_t028_011/r3_r0_rwl u_t028_011/r3_r1_rwl
+ u_t029_011/VDD u_t028_011/VSS VSUBS detronyx_12t_2w2r_rc4_4x4_routed_5layer_direct
Xu_t028_000 u_t028_000/c0_w0_bl u_t028_000/c0_w0_br u_t028_000/c0_w1_bl u_t028_000/c0_w1_br
+ u_t028_000/c0_r0_rbl u_t028_000/c0_r1_rbl u_t028_000/c1_w0_bl u_t028_000/c1_w0_br
+ u_t028_000/c1_w1_bl u_t028_000/c1_w1_br u_t028_000/c1_r0_rbl u_t028_000/c1_r1_rbl
+ u_t028_000/c2_w0_bl u_t028_000/c2_w0_br u_t028_000/c2_w1_bl u_t028_000/c2_w1_br
+ u_t028_000/c2_r0_rbl u_t028_000/c2_r1_rbl u_t028_000/c3_w0_bl u_t028_000/c3_w0_br
+ u_t028_000/c3_w1_bl u_t028_000/c3_w1_br u_t028_000/c3_r0_rbl u_t028_000/c3_r1_rbl
+ u_t028_000/r0_w0_wl u_t028_000/r0_w1_wl u_t028_000/r0_r0_rwl u_t028_000/r0_r1_rwl
+ u_t028_000/r1_w0_wl u_t028_000/r1_w1_wl u_t028_000/r1_r0_rwl u_t028_000/r1_r1_rwl
+ u_t028_000/r2_w0_wl u_t028_000/r2_w1_wl u_t028_000/r2_r0_rwl u_t028_000/r2_r1_rwl
+ u_t028_000/r3_w0_wl u_t028_000/r3_w1_wl u_t028_000/r3_r0_rwl u_t028_000/r3_r1_rwl
+ VSS u_t028_002/VSS VSUBS detronyx_12t_2w2r_rc4_4x4_routed_5layer_direct
Xgf180mcu_as_sc_mcu7t3v3__nand4_2_109 gf180mcu_as_sc_mcu7t3v3__inv_2_344/VDD VSS VSS
+ VSS VSS VSS VSS gf180mcu_as_sc_mcu7t3v3__inv_2_344/VNW VSUBS gf180mcu_as_sc_mcu7t3v3__nand4_2
Xu_t019_022 u_t019_022/c0_w0_bl u_t019_022/c0_w0_br u_t019_022/c0_w1_bl u_t019_022/c0_w1_br
+ u_t019_022/c0_r0_rbl u_t019_022/c0_r1_rbl u_t019_022/c1_w0_bl u_t019_022/c1_w0_br
+ u_t019_022/c1_w1_bl u_t019_022/c1_w1_br u_t019_022/c1_r0_rbl u_t019_022/c1_r1_rbl
+ u_t019_022/c2_w0_bl u_t019_022/c2_w0_br u_t019_022/c2_w1_bl u_t019_022/c2_w1_br
+ u_t019_022/c2_r0_rbl u_t019_022/c2_r1_rbl u_t019_022/c3_w0_bl u_t019_022/c3_w0_br
+ u_t019_022/c3_w1_bl u_t019_022/c3_w1_br u_t019_022/c3_r0_rbl u_t019_022/c3_r1_rbl
+ u_t019_022/r0_w0_wl u_t019_022/r0_w1_wl u_t019_022/r0_r0_rwl u_t019_022/r0_r1_rwl
+ u_t019_022/r1_w0_wl u_t019_022/r1_w1_wl u_t019_022/r1_r0_rwl u_t019_022/r1_r1_rwl
+ u_t019_022/r2_w0_wl u_t019_022/r2_w1_wl u_t019_022/r2_r0_rwl u_t019_022/r2_r1_rwl
+ u_t019_022/r3_w0_wl u_t019_022/r3_w1_wl u_t019_022/r3_r0_rwl u_t019_022/r3_r1_rwl
+ VSS u_t019_024/VSS VSUBS detronyx_12t_2w2r_rc4_4x4_routed_5layer_direct
Xu_t019_011 u_t019_011/c0_w0_bl u_t019_011/c0_w0_br u_t019_011/c0_w1_bl u_t019_011/c0_w1_br
+ u_t019_011/c0_r0_rbl u_t019_011/c0_r1_rbl u_t019_011/c1_w0_bl u_t019_011/c1_w0_br
+ u_t019_011/c1_w1_bl u_t019_011/c1_w1_br u_t019_011/c1_r0_rbl u_t019_011/c1_r1_rbl
+ u_t019_011/c2_w0_bl u_t019_011/c2_w0_br u_t019_011/c2_w1_bl u_t019_011/c2_w1_br
+ u_t019_011/c2_r0_rbl u_t019_011/c2_r1_rbl u_t019_011/c3_w0_bl u_t019_011/c3_w0_br
+ u_t019_011/c3_w1_bl u_t019_011/c3_w1_br u_t019_011/c3_r0_rbl u_t019_011/c3_r1_rbl
+ u_t019_011/r0_w0_wl u_t019_011/r0_w1_wl u_t019_011/r0_r0_rwl u_t019_011/r0_r1_rwl
+ u_t019_011/r1_w0_wl u_t019_011/r1_w1_wl u_t019_011/r1_r0_rwl u_t019_011/r1_r1_rwl
+ u_t019_011/r2_w0_wl u_t019_011/r2_w1_wl u_t019_011/r2_r0_rwl u_t019_011/r2_r1_rwl
+ u_t019_011/r3_w0_wl u_t019_011/r3_w1_wl u_t019_011/r3_r0_rwl u_t019_011/r3_r1_rwl
+ u_t019_011/VDD u_t019_011/VSS VSUBS detronyx_12t_2w2r_rc4_4x4_routed_5layer_direct
Xu_t019_000 u_t019_000/c0_w0_bl u_t019_000/c0_w0_br u_t019_000/c0_w1_bl u_t019_000/c0_w1_br
+ u_t019_000/c0_r0_rbl u_t019_000/c0_r1_rbl u_t019_000/c1_w0_bl u_t019_000/c1_w0_br
+ u_t019_000/c1_w1_bl u_t019_000/c1_w1_br u_t019_000/c1_r0_rbl u_t019_000/c1_r1_rbl
+ u_t019_000/c2_w0_bl u_t019_000/c2_w0_br u_t019_000/c2_w1_bl u_t019_000/c2_w1_br
+ u_t019_000/c2_r0_rbl u_t019_000/c2_r1_rbl u_t019_000/c3_w0_bl u_t019_000/c3_w0_br
+ u_t019_000/c3_w1_bl u_t019_000/c3_w1_br u_t019_000/c3_r0_rbl u_t019_000/c3_r1_rbl
+ u_t019_000/r0_w0_wl u_t019_000/r0_w1_wl u_t019_000/r0_r0_rwl u_t019_000/r0_r1_rwl
+ u_t019_000/r1_w0_wl u_t019_000/r1_w1_wl u_t019_000/r1_r0_rwl u_t019_000/r1_r1_rwl
+ u_t019_000/r2_w0_wl u_t019_000/r2_w1_wl u_t019_000/r2_r0_rwl u_t019_000/r2_r1_rwl
+ u_t019_000/r3_w0_wl u_t019_000/r3_w1_wl u_t019_000/r3_r0_rwl u_t019_000/r3_r1_rwl
+ VSS u_t019_002/VSS VSUBS detronyx_12t_2w2r_rc4_4x4_routed_5layer_direct
Xgf180mcu_as_sc_mcu7t3v3__nand4_2_26 gf180mcu_as_sc_mcu7t3v3__inv_2_96/VSS gf180mcu_as_sc_mcu7t3v3__inv_2_88/VSS
+ VSS VSS VSS VSS gf180mcu_as_sc_mcu7t3v3__nand4_2_26/Y gf180mcu_as_sc_mcu7t3v3__inv_2_88/VNW
+ VSUBS gf180mcu_as_sc_mcu7t3v3__nand4_2
Xgf180mcu_as_sc_mcu7t3v3__nand4_2_37 gf180mcu_as_sc_mcu7t3v3__inv_2_139/VSS gf180mcu_as_sc_mcu7t3v3__inv_2_126/VDD
+ VSS VSS VSS VSS gf180mcu_as_sc_mcu7t3v3__nand4_2_37/Y gf180mcu_as_sc_mcu7t3v3__inv_2_122/VNW
+ VSUBS gf180mcu_as_sc_mcu7t3v3__nand4_2
Xgf180mcu_as_sc_mcu7t3v3__nand4_2_15 gf180mcu_as_sc_mcu7t3v3__inv_2_74/VDD gf180mcu_as_sc_mcu7t3v3__inv_2_75/VDD
+ VSS VSS VSS VSS VSS gf180mcu_as_sc_mcu7t3v3__inv_2_74/VNW VSUBS gf180mcu_as_sc_mcu7t3v3__nand4_2
Xgf180mcu_as_sc_mcu7t3v3__nand4_2_48 gf180mcu_as_sc_mcu7t3v3__inv_2_119/VDD gf180mcu_as_sc_mcu7t3v3__inv_2_152/VSS
+ VSS VSS VSS VSS gf180mcu_as_sc_mcu7t3v3__nand4_2_48/Y gf180mcu_as_sc_mcu7t3v3__inv_2_119/VNW
+ VSUBS gf180mcu_as_sc_mcu7t3v3__nand4_2
Xgf180mcu_as_sc_mcu7t3v3__nand4_2_59 gf180mcu_as_sc_mcu7t3v3__inv_2_184/VDD gf180mcu_as_sc_mcu7t3v3__inv_2_200/VDD
+ VSS VSS VSS VSS gf180mcu_as_sc_mcu7t3v3__nand4_2_59/Y gf180mcu_as_sc_mcu7t3v3__inv_2_184/VNW
+ VSUBS gf180mcu_as_sc_mcu7t3v3__nand4_2
Xu_t025_025 u_t025_025/c0_w0_bl u_t025_025/c0_w0_br u_t025_025/c0_w1_bl u_t025_025/c0_w1_br
+ u_t025_025/c0_r0_rbl u_t025_025/c0_r1_rbl u_t025_025/c1_w0_bl u_t025_025/c1_w0_br
+ u_t025_025/c1_w1_bl u_t025_025/c1_w1_br u_t025_025/c1_r0_rbl u_t025_025/c1_r1_rbl
+ u_t025_025/c2_w0_bl u_t025_025/c2_w0_br u_t025_025/c2_w1_bl u_t025_025/c2_w1_br
+ u_t025_025/c2_r0_rbl u_t025_025/c2_r1_rbl u_t025_025/c3_w0_bl u_t025_025/c3_w0_br
+ u_t025_025/c3_w1_bl u_t025_025/c3_w1_br u_t025_025/c3_r0_rbl u_t025_025/c3_r1_rbl
+ u_t025_025/r0_w0_wl u_t025_025/r0_w1_wl u_t025_025/r0_r0_rwl u_t025_025/r0_r1_rwl
+ u_t025_025/r1_w0_wl u_t025_025/r1_w1_wl u_t025_025/r1_r0_rwl u_t025_025/r1_r1_rwl
+ u_t025_025/r2_w0_wl u_t025_025/r2_w1_wl u_t025_025/r2_r0_rwl u_t025_025/r2_r1_rwl
+ u_t025_025/r3_w0_wl u_t025_025/r3_w1_wl u_t025_025/r3_r0_rwl u_t025_025/r3_r1_rwl
+ VSS u_t025_031/VSS VSUBS detronyx_12t_2w2r_rc4_4x4_routed_5layer_direct
Xu_t025_014 u_t025_014/c0_w0_bl u_t025_014/c0_w0_br u_t025_014/c0_w1_bl u_t025_014/c0_w1_br
+ u_t025_014/c0_r0_rbl u_t025_014/c0_r1_rbl u_t025_014/c1_w0_bl u_t025_014/c1_w0_br
+ u_t025_014/c1_w1_bl u_t025_014/c1_w1_br u_t025_014/c1_r0_rbl u_t025_014/c1_r1_rbl
+ u_t025_014/c2_w0_bl u_t025_014/c2_w0_br u_t025_014/c2_w1_bl u_t025_014/c2_w1_br
+ u_t025_014/c2_r0_rbl u_t025_014/c2_r1_rbl u_t025_014/c3_w0_bl u_t025_014/c3_w0_br
+ u_t025_014/c3_w1_bl u_t025_014/c3_w1_br u_t025_014/c3_r0_rbl u_t025_014/c3_r1_rbl
+ u_t025_014/r0_w0_wl u_t025_014/r0_w1_wl u_t025_014/r0_r0_rwl u_t025_014/r0_r1_rwl
+ u_t025_014/r1_w0_wl u_t025_014/r1_w1_wl u_t025_014/r1_r0_rwl u_t025_014/r1_r1_rwl
+ u_t025_014/r2_w0_wl u_t025_014/r2_w1_wl u_t025_014/r2_r0_rwl u_t025_014/r2_r1_rwl
+ u_t025_014/r3_w0_wl u_t025_014/r3_w1_wl u_t025_014/r3_r0_rwl u_t025_014/r3_r1_rwl
+ u_t025_014/VDD u_t025_031/VSS VSUBS detronyx_12t_2w2r_rc4_4x4_routed_5layer_direct
Xu_t025_003 u_t025_003/c0_w0_bl u_t025_003/c0_w0_br u_t025_003/c0_w1_bl u_t025_003/c0_w1_br
+ u_t025_003/c0_r0_rbl u_t025_003/c0_r1_rbl u_t025_003/c1_w0_bl u_t025_003/c1_w0_br
+ u_t025_003/c1_w1_bl u_t025_003/c1_w1_br u_t025_003/c1_r0_rbl u_t025_003/c1_r1_rbl
+ u_t025_003/c2_w0_bl u_t025_003/c2_w0_br u_t025_003/c2_w1_bl u_t025_003/c2_w1_br
+ u_t025_003/c2_r0_rbl u_t025_003/c2_r1_rbl u_t025_003/c3_w0_bl u_t025_003/c3_w0_br
+ u_t025_003/c3_w1_bl u_t025_003/c3_w1_br u_t025_003/c3_r0_rbl u_t025_003/c3_r1_rbl
+ u_t025_003/r0_w0_wl u_t025_003/r0_w1_wl u_t025_003/r0_r0_rwl u_t025_003/r0_r1_rwl
+ u_t025_003/r1_w0_wl u_t025_003/r1_w1_wl u_t025_003/r1_r0_rwl u_t025_003/r1_r1_rwl
+ u_t025_003/r2_w0_wl u_t025_003/r2_w1_wl u_t025_003/r2_r0_rwl u_t025_003/r2_r1_rwl
+ u_t025_003/r3_w0_wl u_t025_003/r3_w1_wl u_t025_003/r3_r0_rwl u_t025_003/r3_r1_rwl
+ u_t025_003/VDD u_t025_031/VSS VSUBS detronyx_12t_2w2r_rc4_4x4_routed_5layer_direct
Xgf180mcu_as_sc_mcu7t3v3__inv_2_1123 gf180mcu_as_sc_mcu7t3v3__inv_2_1123/VDD gf180mcu_as_sc_mcu7t3v3__inv_2_1126/VDD
+ gf180mcu_as_sc_mcu7t3v3__inv_2_1123/Y VSS gf180mcu_as_sc_mcu7t3v3__inv_2_1123/VNW
+ VSUBS gf180mcu_as_sc_mcu7t3v3__inv_2
Xgf180mcu_as_sc_mcu7t3v3__inv_2_1134 gf180mcu_as_sc_mcu7t3v3__inv_2_1135/VDD VSS VSS
+ gf180mcu_as_sc_mcu7t3v3__inv_2_1135/Y gf180mcu_as_sc_mcu7t3v3__inv_2_1135/VNW VSUBS
+ gf180mcu_as_sc_mcu7t3v3__inv_2
Xgf180mcu_as_sc_mcu7t3v3__inv_2_1112 VSS gf180mcu_as_sc_mcu7t3v3__inv_2_1117/VDD VSS
+ gf180mcu_as_sc_mcu7t3v3__inv_2_1115/A gf180mcu_as_sc_mcu7t3v3__inv_2_1114/VNW VSUBS
+ gf180mcu_as_sc_mcu7t3v3__inv_2
Xgf180mcu_as_sc_mcu7t3v3__inv_2_1145 VSS gf180mcu_as_sc_mcu7t3v3__inv_2_1146/VSS gf180mcu_as_sc_mcu7t3v3__inv_2_1145/Y
+ gf180mcu_as_sc_mcu7t3v3__inv_2_1146/Y gf180mcu_as_sc_mcu7t3v3__inv_2_1146/VNW VSUBS
+ gf180mcu_as_sc_mcu7t3v3__inv_2
Xgf180mcu_as_sc_mcu7t3v3__inv_2_1156 VSS VSS gf180mcu_as_sc_mcu7t3v3__inv_2_1156/Y
+ VSS gf180mcu_as_sc_mcu7t3v3__inv_2_1156/VNW VSUBS gf180mcu_as_sc_mcu7t3v3__inv_2
Xgf180mcu_as_sc_mcu7t3v3__inv_2_1101 gf180mcu_as_sc_mcu7t3v3__inv_2_1146/VSS gf180mcu_as_sc_mcu7t3v3__inv_2_1105/VSS
+ gf180mcu_as_sc_mcu7t3v3__inv_2_1101/Y gf180mcu_as_sc_mcu7t3v3__inv_2_1105/Y gf180mcu_as_sc_mcu7t3v3__inv_2_1105/VNW
+ VSUBS gf180mcu_as_sc_mcu7t3v3__inv_2
Xgf180mcu_as_sc_mcu7t3v3__inv_2_1167 VSS VSS VSS VSS gf180mcu_as_sc_mcu7t3v3__inv_2_1168/VNW
+ VSUBS gf180mcu_as_sc_mcu7t3v3__inv_2
Xgf180mcu_as_sc_mcu7t3v3__inv_2_1178 VSS VSS gf180mcu_as_sc_mcu7t3v3__inv_2_1178/Y
+ VSS gf180mcu_as_sc_mcu7t3v3__inv_2_1178/VNW VSUBS gf180mcu_as_sc_mcu7t3v3__inv_2
Xgf180mcu_as_sc_mcu7t3v3__inv_2_1189 VSS VSS VSS VSS gf180mcu_as_sc_mcu7t3v3__inv_2_1190/VNW
+ VSUBS gf180mcu_as_sc_mcu7t3v3__inv_2
Xu_t016_025 u_t016_025/c0_w0_bl u_t016_025/c0_w0_br u_t016_025/c0_w1_bl u_t016_025/c0_w1_br
+ u_t016_025/c0_r0_rbl u_t016_025/c0_r1_rbl u_t016_025/c1_w0_bl u_t016_025/c1_w0_br
+ u_t016_025/c1_w1_bl u_t016_025/c1_w1_br u_t016_025/c1_r0_rbl u_t016_025/c1_r1_rbl
+ u_t016_025/c2_w0_bl u_t016_025/c2_w0_br u_t016_025/c2_w1_bl u_t016_025/c2_w1_br
+ u_t016_025/c2_r0_rbl u_t016_025/c2_r1_rbl u_t016_025/c3_w0_bl u_t016_025/c3_w0_br
+ u_t016_025/c3_w1_bl u_t016_025/c3_w1_br u_t016_025/c3_r0_rbl u_t016_025/c3_r1_rbl
+ u_t016_025/r0_w0_wl u_t016_025/r0_w1_wl u_t016_025/r0_r0_rwl u_t016_025/r0_r1_rwl
+ u_t016_025/r1_w0_wl u_t016_025/r1_w1_wl u_t016_025/r1_r0_rwl u_t016_025/r1_r1_rwl
+ u_t016_025/r2_w0_wl u_t016_025/r2_w1_wl u_t016_025/r2_r0_rwl u_t016_025/r2_r1_rwl
+ u_t016_025/r3_w0_wl u_t016_025/r3_w1_wl u_t016_025/r3_r0_rwl u_t016_025/r3_r1_rwl
+ VSS u_t016_025/VSS VSUBS detronyx_12t_2w2r_rc4_4x4_routed_5layer_direct
Xu_t016_014 u_t016_014/c0_w0_bl u_t016_014/c0_w0_br u_t016_014/c0_w1_bl u_t016_014/c0_w1_br
+ u_t016_014/c0_r0_rbl u_t016_014/c0_r1_rbl u_t016_014/c1_w0_bl u_t016_014/c1_w0_br
+ u_t016_014/c1_w1_bl u_t016_014/c1_w1_br u_t016_014/c1_r0_rbl u_t016_014/c1_r1_rbl
+ u_t016_014/c2_w0_bl u_t016_014/c2_w0_br u_t016_014/c2_w1_bl u_t016_014/c2_w1_br
+ u_t016_014/c2_r0_rbl u_t016_014/c2_r1_rbl u_t016_014/c3_w0_bl u_t016_014/c3_w0_br
+ u_t016_014/c3_w1_bl u_t016_014/c3_w1_br u_t016_014/c3_r0_rbl u_t016_014/c3_r1_rbl
+ u_t016_014/r0_w0_wl u_t016_014/r0_w1_wl u_t016_014/r0_r0_rwl u_t016_014/r0_r1_rwl
+ u_t016_014/r1_w0_wl u_t016_014/r1_w1_wl u_t016_014/r1_r0_rwl u_t016_014/r1_r1_rwl
+ u_t016_014/r2_w0_wl u_t016_014/r2_w1_wl u_t016_014/r2_r0_rwl u_t016_014/r2_r1_rwl
+ u_t016_014/r3_w0_wl u_t016_014/r3_w1_wl u_t016_014/r3_r0_rwl u_t016_014/r3_r1_rwl
+ u_t016_014/VDD u_t016_017/VSS VSUBS detronyx_12t_2w2r_rc4_4x4_routed_5layer_direct
Xu_t016_003 u_t016_003/c0_w0_bl u_t016_003/c0_w0_br u_t016_003/c0_w1_bl u_t016_003/c0_w1_br
+ u_t016_003/c0_r0_rbl u_t016_003/c0_r1_rbl u_t016_003/c1_w0_bl u_t016_003/c1_w0_br
+ u_t016_003/c1_w1_bl u_t016_003/c1_w1_br u_t016_003/c1_r0_rbl u_t016_003/c1_r1_rbl
+ u_t016_003/c2_w0_bl u_t016_003/c2_w0_br u_t016_003/c2_w1_bl u_t016_003/c2_w1_br
+ u_t016_003/c2_r0_rbl u_t016_003/c2_r1_rbl u_t016_003/c3_w0_bl u_t016_003/c3_w0_br
+ u_t016_003/c3_w1_bl u_t016_003/c3_w1_br u_t016_003/c3_r0_rbl u_t016_003/c3_r1_rbl
+ u_t016_003/r0_w0_wl u_t016_003/r0_w1_wl u_t016_003/r0_r0_rwl u_t016_003/r0_r1_rwl
+ u_t016_003/r1_w0_wl u_t016_003/r1_w1_wl u_t016_003/r1_r0_rwl u_t016_003/r1_r1_rwl
+ u_t016_003/r2_w0_wl u_t016_003/r2_w1_wl u_t016_003/r2_r0_rwl u_t016_003/r2_r1_rwl
+ u_t016_003/r3_w0_wl u_t016_003/r3_w1_wl u_t016_003/r3_r0_rwl u_t016_003/r3_r1_rwl
+ u_t016_003/VDD u_t016_003/VSS VSUBS detronyx_12t_2w2r_rc4_4x4_routed_5layer_direct
Xgf180mcu_as_sc_mcu7t3v3__inv_2_618 gf180mcu_as_sc_mcu7t3v3__inv_2_620/VDD gf180mcu_as_sc_mcu7t3v3__inv_2_629/VDD
+ gf180mcu_as_sc_mcu7t3v3__inv_2_618/Y gf180mcu_as_sc_mcu7t3v3__inv_2_618/A gf180mcu_as_sc_mcu7t3v3__inv_2_620/VNW
+ VSUBS gf180mcu_as_sc_mcu7t3v3__inv_2
Xgf180mcu_as_sc_mcu7t3v3__inv_2_607 gf180mcu_as_sc_mcu7t3v3__inv_2_630/VSS gf180mcu_as_sc_mcu7t3v3__inv_2_616/VDD
+ gf180mcu_as_sc_mcu7t3v3__inv_2_607/Y gf180mcu_as_sc_mcu7t3v3__inv_2_608/Y gf180mcu_as_sc_mcu7t3v3__inv_2_608/VNW
+ VSUBS gf180mcu_as_sc_mcu7t3v3__inv_2
Xu_t031_028 u_t031_028/c0_w0_bl u_t031_028/c0_w0_br u_t031_028/c0_w1_bl u_t031_028/c0_w1_br
+ u_t031_028/c0_r0_rbl u_t031_028/c0_r1_rbl u_t031_028/c1_w0_bl u_t031_028/c1_w0_br
+ u_t031_028/c1_w1_bl u_t031_028/c1_w1_br u_t031_028/c1_r0_rbl u_t031_028/c1_r1_rbl
+ u_t031_028/c2_w0_bl u_t031_028/c2_w0_br u_t031_028/c2_w1_bl u_t031_028/c2_w1_br
+ u_t031_028/c2_r0_rbl u_t031_028/c2_r1_rbl u_t031_028/c3_w0_bl u_t031_028/c3_w0_br
+ u_t031_028/c3_w1_bl u_t031_028/c3_w1_br u_t031_028/c3_r0_rbl u_t031_028/c3_r1_rbl
+ u_t031_028/r0_w0_wl u_t031_028/r0_w1_wl u_t031_028/r0_r0_rwl u_t031_028/r0_r1_rwl
+ u_t031_028/r1_w0_wl u_t031_028/r1_w1_wl u_t031_028/r1_r0_rwl u_t031_028/r1_r1_rwl
+ u_t031_028/r2_w0_wl u_t031_028/r2_w1_wl u_t031_028/r2_r0_rwl u_t031_028/r2_r1_rwl
+ u_t031_028/r3_w0_wl u_t031_028/r3_w1_wl u_t031_028/r3_r0_rwl u_t031_028/r3_r1_rwl
+ u_t031_028/VDD u_t031_028/VSS VSUBS detronyx_12t_2w2r_rc4_4x4_routed_5layer_direct
Xu_t031_017 u_t031_017/c0_w0_bl u_t031_017/c0_w0_br u_t031_017/c0_w1_bl u_t031_017/c0_w1_br
+ u_t031_017/c0_r0_rbl u_t031_017/c0_r1_rbl u_t031_017/c1_w0_bl u_t031_017/c1_w0_br
+ u_t031_017/c1_w1_bl u_t031_017/c1_w1_br u_t031_017/c1_r0_rbl u_t031_017/c1_r1_rbl
+ u_t031_017/c2_w0_bl u_t031_017/c2_w0_br u_t031_017/c2_w1_bl u_t031_017/c2_w1_br
+ u_t031_017/c2_r0_rbl u_t031_017/c2_r1_rbl u_t031_017/c3_w0_bl u_t031_017/c3_w0_br
+ u_t031_017/c3_w1_bl u_t031_017/c3_w1_br u_t031_017/c3_r0_rbl u_t031_017/c3_r1_rbl
+ u_t031_017/r0_w0_wl u_t031_017/r0_w1_wl u_t031_017/r0_r0_rwl u_t031_017/r0_r1_rwl
+ u_t031_017/r1_w0_wl u_t031_017/r1_w1_wl u_t031_017/r1_r0_rwl u_t031_017/r1_r1_rwl
+ u_t031_017/r2_w0_wl u_t031_017/r2_w1_wl u_t031_017/r2_r0_rwl u_t031_017/r2_r1_rwl
+ u_t031_017/r3_w0_wl u_t031_017/r3_w1_wl u_t031_017/r3_r0_rwl u_t031_017/r3_r1_rwl
+ VSS u_t031_017/VSS VSUBS detronyx_12t_2w2r_rc4_4x4_routed_5layer_direct
Xu_t031_006 u_t031_006/c0_w0_bl u_t031_006/c0_w0_br u_t031_006/c0_w1_bl u_t031_006/c0_w1_br
+ u_t031_006/c0_r0_rbl u_t031_006/c0_r1_rbl u_t031_006/c1_w0_bl u_t031_006/c1_w0_br
+ u_t031_006/c1_w1_bl u_t031_006/c1_w1_br u_t031_006/c1_r0_rbl u_t031_006/c1_r1_rbl
+ u_t031_006/c2_w0_bl u_t031_006/c2_w0_br u_t031_006/c2_w1_bl u_t031_006/c2_w1_br
+ u_t031_006/c2_r0_rbl u_t031_006/c2_r1_rbl u_t031_006/c3_w0_bl u_t031_006/c3_w0_br
+ u_t031_006/c3_w1_bl u_t031_006/c3_w1_br u_t031_006/c3_r0_rbl u_t031_006/c3_r1_rbl
+ u_t031_006/r0_w0_wl u_t031_006/r0_w1_wl u_t031_006/r0_r0_rwl u_t031_006/r0_r1_rwl
+ u_t031_006/r1_w0_wl u_t031_006/r1_w1_wl u_t031_006/r1_r0_rwl u_t031_006/r1_r1_rwl
+ u_t031_006/r2_w0_wl u_t031_006/r2_w1_wl u_t031_006/r2_r0_rwl u_t031_006/r2_r1_rwl
+ u_t031_006/r3_w0_wl u_t031_006/r3_w1_wl u_t031_006/r3_r0_rwl u_t031_006/r3_r1_rwl
+ u_t031_006/VDD u_t031_009/VSS VSUBS detronyx_12t_2w2r_rc4_4x4_routed_5layer_direct
Xgf180mcu_as_sc_mcu7t3v3__inv_2_629 gf180mcu_as_sc_mcu7t3v3__inv_2_629/VDD gf180mcu_as_sc_mcu7t3v3__inv_2_633/VDD
+ gf180mcu_as_sc_mcu7t3v3__inv_2_629/Y VSS gf180mcu_as_sc_mcu7t3v3__inv_2_629/VNW
+ VSUBS gf180mcu_as_sc_mcu7t3v3__inv_2
Xgf180mcu_as_sc_mcu7t3v3__inv_2_1690 gf180mcu_as_sc_mcu7t3v3__inv_2_1691/VDD VSS gf180mcu_as_sc_mcu7t3v3__inv_2_1690/Y
+ gf180mcu_as_sc_mcu7t3v3__inv_2_1691/Y gf180mcu_as_sc_mcu7t3v3__inv_2_1691/VNW VSUBS
+ gf180mcu_as_sc_mcu7t3v3__inv_2
Xu_t007_025 u_t007_025/c0_w0_bl u_t007_025/c0_w0_br u_t007_025/c0_w1_bl u_t007_025/c0_w1_br
+ u_t007_025/c0_r0_rbl u_t007_025/c0_r1_rbl u_t007_025/c1_w0_bl u_t007_025/c1_w0_br
+ u_t007_025/c1_w1_bl u_t007_025/c1_w1_br u_t007_025/c1_r0_rbl u_t007_025/c1_r1_rbl
+ u_t007_025/c2_w0_bl u_t007_025/c2_w0_br u_t007_025/c2_w1_bl u_t007_025/c2_w1_br
+ u_t007_025/c2_r0_rbl u_t007_025/c2_r1_rbl u_t007_025/c3_w0_bl u_t007_025/c3_w0_br
+ u_t007_025/c3_w1_bl u_t007_025/c3_w1_br u_t007_025/c3_r0_rbl u_t007_025/c3_r1_rbl
+ u_t007_025/r0_w0_wl u_t007_025/r0_w1_wl u_t007_025/r0_r0_rwl u_t007_025/r0_r1_rwl
+ u_t007_025/r1_w0_wl u_t007_025/r1_w1_wl u_t007_025/r1_r0_rwl u_t007_025/r1_r1_rwl
+ u_t007_025/r2_w0_wl u_t007_025/r2_w1_wl u_t007_025/r2_r0_rwl u_t007_025/r2_r1_rwl
+ u_t007_025/r3_w0_wl u_t007_025/r3_w1_wl u_t007_025/r3_r0_rwl u_t007_025/r3_r1_rwl
+ VSS u_t007_025/VSS VSUBS detronyx_12t_2w2r_rc4_4x4_routed_5layer_direct
Xu_t022_017 u_t022_017/c0_w0_bl u_t022_017/c0_w0_br u_t022_017/c0_w1_bl u_t022_017/c0_w1_br
+ u_t022_017/c0_r0_rbl u_t022_017/c0_r1_rbl u_t022_017/c1_w0_bl u_t022_017/c1_w0_br
+ u_t022_017/c1_w1_bl u_t022_017/c1_w1_br u_t022_017/c1_r0_rbl u_t022_017/c1_r1_rbl
+ u_t022_017/c2_w0_bl u_t022_017/c2_w0_br u_t022_017/c2_w1_bl u_t022_017/c2_w1_br
+ u_t022_017/c2_r0_rbl u_t022_017/c2_r1_rbl u_t022_017/c3_w0_bl u_t022_017/c3_w0_br
+ u_t022_017/c3_w1_bl u_t022_017/c3_w1_br u_t022_017/c3_r0_rbl u_t022_017/c3_r1_rbl
+ u_t022_017/r0_w0_wl u_t022_017/r0_w1_wl u_t022_017/r0_r0_rwl u_t022_017/r0_r1_rwl
+ u_t022_017/r1_w0_wl u_t022_017/r1_w1_wl u_t022_017/r1_r0_rwl u_t022_017/r1_r1_rwl
+ u_t022_017/r2_w0_wl u_t022_017/r2_w1_wl u_t022_017/r2_r0_rwl u_t022_017/r2_r1_rwl
+ u_t022_017/r3_w0_wl u_t022_017/r3_w1_wl u_t022_017/r3_r0_rwl u_t022_017/r3_r1_rwl
+ VSS u_t022_031/VSS VSUBS detronyx_12t_2w2r_rc4_4x4_routed_5layer_direct
Xu_t007_014 u_t007_014/c0_w0_bl u_t007_014/c0_w0_br u_t007_014/c0_w1_bl u_t007_014/c0_w1_br
+ u_t007_014/c0_r0_rbl u_t007_014/c0_r1_rbl u_t007_014/c1_w0_bl u_t007_014/c1_w0_br
+ u_t007_014/c1_w1_bl u_t007_014/c1_w1_br u_t007_014/c1_r0_rbl u_t007_014/c1_r1_rbl
+ u_t007_014/c2_w0_bl u_t007_014/c2_w0_br u_t007_014/c2_w1_bl u_t007_014/c2_w1_br
+ u_t007_014/c2_r0_rbl u_t007_014/c2_r1_rbl u_t007_014/c3_w0_bl u_t007_014/c3_w0_br
+ u_t007_014/c3_w1_bl u_t007_014/c3_w1_br u_t007_014/c3_r0_rbl u_t007_014/c3_r1_rbl
+ u_t007_014/r0_w0_wl u_t007_014/r0_w1_wl u_t007_014/r0_r0_rwl u_t007_014/r0_r1_rwl
+ u_t007_014/r1_w0_wl u_t007_014/r1_w1_wl u_t007_014/r1_r0_rwl u_t007_014/r1_r1_rwl
+ u_t007_014/r2_w0_wl u_t007_014/r2_w1_wl u_t007_014/r2_r0_rwl u_t007_014/r2_r1_rwl
+ u_t007_014/r3_w0_wl u_t007_014/r3_w1_wl u_t007_014/r3_r0_rwl u_t007_014/r3_r1_rwl
+ u_t008_014/VDD u_t007_017/VSS VSUBS detronyx_12t_2w2r_rc4_4x4_routed_5layer_direct
Xu_t022_006 u_t022_006/c0_w0_bl u_t022_006/c0_w0_br u_t022_006/c0_w1_bl u_t022_006/c0_w1_br
+ u_t022_006/c0_r0_rbl u_t022_006/c0_r1_rbl u_t022_006/c1_w0_bl u_t022_006/c1_w0_br
+ u_t022_006/c1_w1_bl u_t022_006/c1_w1_br u_t022_006/c1_r0_rbl u_t022_006/c1_r1_rbl
+ u_t022_006/c2_w0_bl u_t022_006/c2_w0_br u_t022_006/c2_w1_bl u_t022_006/c2_w1_br
+ u_t022_006/c2_r0_rbl u_t022_006/c2_r1_rbl u_t022_006/c3_w0_bl u_t022_006/c3_w0_br
+ u_t022_006/c3_w1_bl u_t022_006/c3_w1_br u_t022_006/c3_r0_rbl u_t022_006/c3_r1_rbl
+ u_t022_006/r0_w0_wl u_t022_006/r0_w1_wl u_t022_006/r0_r0_rwl u_t022_006/r0_r1_rwl
+ u_t022_006/r1_w0_wl u_t022_006/r1_w1_wl u_t022_006/r1_r0_rwl u_t022_006/r1_r1_rwl
+ u_t022_006/r2_w0_wl u_t022_006/r2_w1_wl u_t022_006/r2_r0_rwl u_t022_006/r2_r1_rwl
+ u_t022_006/r3_w0_wl u_t022_006/r3_w1_wl u_t022_006/r3_r0_rwl u_t022_006/r3_r1_rwl
+ u_t022_006/VDD u_t022_031/VSS VSUBS detronyx_12t_2w2r_rc4_4x4_routed_5layer_direct
Xu_t007_003 u_t007_003/c0_w0_bl u_t007_003/c0_w0_br u_t007_003/c0_w1_bl u_t007_003/c0_w1_br
+ u_t007_003/c0_r0_rbl u_t007_003/c0_r1_rbl u_t007_003/c1_w0_bl u_t007_003/c1_w0_br
+ u_t007_003/c1_w1_bl u_t007_003/c1_w1_br u_t007_003/c1_r0_rbl u_t007_003/c1_r1_rbl
+ u_t007_003/c2_w0_bl u_t007_003/c2_w0_br u_t007_003/c2_w1_bl u_t007_003/c2_w1_br
+ u_t007_003/c2_r0_rbl u_t007_003/c2_r1_rbl u_t007_003/c3_w0_bl u_t007_003/c3_w0_br
+ u_t007_003/c3_w1_bl u_t007_003/c3_w1_br u_t007_003/c3_r0_rbl u_t007_003/c3_r1_rbl
+ u_t007_003/r0_w0_wl u_t007_003/r0_w1_wl u_t007_003/r0_r0_rwl u_t007_003/r0_r1_rwl
+ u_t007_003/r1_w0_wl u_t007_003/r1_w1_wl u_t007_003/r1_r0_rwl u_t007_003/r1_r1_rwl
+ u_t007_003/r2_w0_wl u_t007_003/r2_w1_wl u_t007_003/r2_r0_rwl u_t007_003/r2_r1_rwl
+ u_t007_003/r3_w0_wl u_t007_003/r3_w1_wl u_t007_003/r3_r0_rwl u_t007_003/r3_r1_rwl
+ u_t008_003/VDD u_t007_003/VSS VSUBS detronyx_12t_2w2r_rc4_4x4_routed_5layer_direct
Xu_t022_028 u_t022_028/c0_w0_bl u_t022_028/c0_w0_br u_t022_028/c0_w1_bl u_t022_028/c0_w1_br
+ u_t022_028/c0_r0_rbl u_t022_028/c0_r1_rbl u_t022_028/c1_w0_bl u_t022_028/c1_w0_br
+ u_t022_028/c1_w1_bl u_t022_028/c1_w1_br u_t022_028/c1_r0_rbl u_t022_028/c1_r1_rbl
+ u_t022_028/c2_w0_bl u_t022_028/c2_w0_br u_t022_028/c2_w1_bl u_t022_028/c2_w1_br
+ u_t022_028/c2_r0_rbl u_t022_028/c2_r1_rbl u_t022_028/c3_w0_bl u_t022_028/c3_w0_br
+ u_t022_028/c3_w1_bl u_t022_028/c3_w1_br u_t022_028/c3_r0_rbl u_t022_028/c3_r1_rbl
+ u_t022_028/r0_w0_wl u_t022_028/r0_w1_wl u_t022_028/r0_r0_rwl u_t022_028/r0_r1_rwl
+ u_t022_028/r1_w0_wl u_t022_028/r1_w1_wl u_t022_028/r1_r0_rwl u_t022_028/r1_r1_rwl
+ u_t022_028/r2_w0_wl u_t022_028/r2_w1_wl u_t022_028/r2_r0_rwl u_t022_028/r2_r1_rwl
+ u_t022_028/r3_w0_wl u_t022_028/r3_w1_wl u_t022_028/r3_r0_rwl u_t022_028/r3_r1_rwl
+ u_t022_028/VDD u_t022_031/VSS VSUBS detronyx_12t_2w2r_rc4_4x4_routed_5layer_direct
Xgf180mcu_as_sc_mcu7t3v3__nand4_2_495 gf180mcu_as_sc_mcu7t3v3__inv_2_1675/VDD VSS
+ VSS VSS VSS VSS VSS gf180mcu_as_sc_mcu7t3v3__inv_2_1675/VNW VSUBS gf180mcu_as_sc_mcu7t3v3__nand4_2
Xgf180mcu_as_sc_mcu7t3v3__nand4_2_462 VSS VSS VSS VSS VSS VSS VSS gf180mcu_as_sc_mcu7t3v3__inv_2_1570/VNW
+ VSUBS gf180mcu_as_sc_mcu7t3v3__nand4_2
Xgf180mcu_as_sc_mcu7t3v3__nand4_2_451 gf180mcu_as_sc_mcu7t3v3__inv_2_1514/VDD VSS
+ VSS VSS VSS VSS VSS gf180mcu_as_sc_mcu7t3v3__inv_2_1514/VNW VSUBS gf180mcu_as_sc_mcu7t3v3__nand4_2
Xgf180mcu_as_sc_mcu7t3v3__nand4_2_484 gf180mcu_as_sc_mcu7t3v3__inv_2_1653/VDD gf180mcu_as_sc_mcu7t3v3__inv_2_1654/VDD
+ VSS VSS VSS VSS VSS gf180mcu_as_sc_mcu7t3v3__inv_2_1653/VNW VSUBS gf180mcu_as_sc_mcu7t3v3__nand4_2
Xgf180mcu_as_sc_mcu7t3v3__nand4_2_473 gf180mcu_as_sc_mcu7t3v3__inv_2_1524/VDD VSS
+ VSS VSS VSS VSS gf180mcu_as_sc_mcu7t3v3__nand4_2_473/Y gf180mcu_as_sc_mcu7t3v3__inv_2_1524/VNW
+ VSUBS gf180mcu_as_sc_mcu7t3v3__nand4_2
Xgf180mcu_as_sc_mcu7t3v3__nand4_2_440 gf180mcu_as_sc_mcu7t3v3__inv_2_1499/VSS gf180mcu_as_sc_mcu7t3v3__inv_2_1457/VDD
+ VSS VSS VSS VSS gf180mcu_as_sc_mcu7t3v3__nand4_2_440/Y gf180mcu_as_sc_mcu7t3v3__inv_2_1453/VNW
+ VSUBS gf180mcu_as_sc_mcu7t3v3__nand4_2
Xu_t013_028 u_t013_028/c0_w0_bl u_t013_028/c0_w0_br u_t013_028/c0_w1_bl u_t013_028/c0_w1_br
+ u_t013_028/c0_r0_rbl u_t013_028/c0_r1_rbl u_t013_028/c1_w0_bl u_t013_028/c1_w0_br
+ u_t013_028/c1_w1_bl u_t013_028/c1_w1_br u_t013_028/c1_r0_rbl u_t013_028/c1_r1_rbl
+ u_t013_028/c2_w0_bl u_t013_028/c2_w0_br u_t013_028/c2_w1_bl u_t013_028/c2_w1_br
+ u_t013_028/c2_r0_rbl u_t013_028/c2_r1_rbl u_t013_028/c3_w0_bl u_t013_028/c3_w0_br
+ u_t013_028/c3_w1_bl u_t013_028/c3_w1_br u_t013_028/c3_r0_rbl u_t013_028/c3_r1_rbl
+ u_t013_028/r0_w0_wl u_t013_028/r0_w1_wl u_t013_028/r0_r0_rwl u_t013_028/r0_r1_rwl
+ u_t013_028/r1_w0_wl u_t013_028/r1_w1_wl u_t013_028/r1_r0_rwl u_t013_028/r1_r1_rwl
+ u_t013_028/r2_w0_wl u_t013_028/r2_w1_wl u_t013_028/r2_r0_rwl u_t013_028/r2_r1_rwl
+ u_t013_028/r3_w0_wl u_t013_028/r3_w1_wl u_t013_028/r3_r0_rwl u_t013_028/r3_r1_rwl
+ u_t013_028/VDD u_t013_031/VSS VSUBS detronyx_12t_2w2r_rc4_4x4_routed_5layer_direct
Xu_t013_017 u_t013_017/c0_w0_bl u_t013_017/c0_w0_br u_t013_017/c0_w1_bl u_t013_017/c0_w1_br
+ u_t013_017/c0_r0_rbl u_t013_017/c0_r1_rbl u_t013_017/c1_w0_bl u_t013_017/c1_w0_br
+ u_t013_017/c1_w1_bl u_t013_017/c1_w1_br u_t013_017/c1_r0_rbl u_t013_017/c1_r1_rbl
+ u_t013_017/c2_w0_bl u_t013_017/c2_w0_br u_t013_017/c2_w1_bl u_t013_017/c2_w1_br
+ u_t013_017/c2_r0_rbl u_t013_017/c2_r1_rbl u_t013_017/c3_w0_bl u_t013_017/c3_w0_br
+ u_t013_017/c3_w1_bl u_t013_017/c3_w1_br u_t013_017/c3_r0_rbl u_t013_017/c3_r1_rbl
+ u_t013_017/r0_w0_wl u_t013_017/r0_w1_wl u_t013_017/r0_r0_rwl u_t013_017/r0_r1_rwl
+ u_t013_017/r1_w0_wl u_t013_017/r1_w1_wl u_t013_017/r1_r0_rwl u_t013_017/r1_r1_rwl
+ u_t013_017/r2_w0_wl u_t013_017/r2_w1_wl u_t013_017/r2_r0_rwl u_t013_017/r2_r1_rwl
+ u_t013_017/r3_w0_wl u_t013_017/r3_w1_wl u_t013_017/r3_r0_rwl u_t013_017/r3_r1_rwl
+ VSS u_t013_031/VSS VSUBS detronyx_12t_2w2r_rc4_4x4_routed_5layer_direct
Xu_t013_006 u_t013_006/c0_w0_bl u_t013_006/c0_w0_br u_t013_006/c0_w1_bl u_t013_006/c0_w1_br
+ u_t013_006/c0_r0_rbl u_t013_006/c0_r1_rbl u_t013_006/c1_w0_bl u_t013_006/c1_w0_br
+ u_t013_006/c1_w1_bl u_t013_006/c1_w1_br u_t013_006/c1_r0_rbl u_t013_006/c1_r1_rbl
+ u_t013_006/c2_w0_bl u_t013_006/c2_w0_br u_t013_006/c2_w1_bl u_t013_006/c2_w1_br
+ u_t013_006/c2_r0_rbl u_t013_006/c2_r1_rbl u_t013_006/c3_w0_bl u_t013_006/c3_w0_br
+ u_t013_006/c3_w1_bl u_t013_006/c3_w1_br u_t013_006/c3_r0_rbl u_t013_006/c3_r1_rbl
+ u_t013_006/r0_w0_wl u_t013_006/r0_w1_wl u_t013_006/r0_r0_rwl u_t013_006/r0_r1_rwl
+ u_t013_006/r1_w0_wl u_t013_006/r1_w1_wl u_t013_006/r1_r0_rwl u_t013_006/r1_r1_rwl
+ u_t013_006/r2_w0_wl u_t013_006/r2_w1_wl u_t013_006/r2_r0_rwl u_t013_006/r2_r1_rwl
+ u_t013_006/r3_w0_wl u_t013_006/r3_w1_wl u_t013_006/r3_r0_rwl u_t013_006/r3_r1_rwl
+ u_t013_006/VDD u_t013_031/VSS VSUBS detronyx_12t_2w2r_rc4_4x4_routed_5layer_direct
Xu_t004_006 u_t004_006/c0_w0_bl u_t004_006/c0_w0_br u_t004_006/c0_w1_bl u_t004_006/c0_w1_br
+ u_t004_006/c0_r0_rbl u_t004_006/c0_r1_rbl u_t004_006/c1_w0_bl u_t004_006/c1_w0_br
+ u_t004_006/c1_w1_bl u_t004_006/c1_w1_br u_t004_006/c1_r0_rbl u_t004_006/c1_r1_rbl
+ u_t004_006/c2_w0_bl u_t004_006/c2_w0_br u_t004_006/c2_w1_bl u_t004_006/c2_w1_br
+ u_t004_006/c2_r0_rbl u_t004_006/c2_r1_rbl u_t004_006/c3_w0_bl u_t004_006/c3_w0_br
+ u_t004_006/c3_w1_bl u_t004_006/c3_w1_br u_t004_006/c3_r0_rbl u_t004_006/c3_r1_rbl
+ u_t004_006/r0_w0_wl u_t004_006/r0_w1_wl u_t004_006/r0_r0_rwl u_t004_006/r0_r1_rwl
+ u_t004_006/r1_w0_wl u_t004_006/r1_w1_wl u_t004_006/r1_r0_rwl u_t004_006/r1_r1_rwl
+ u_t004_006/r2_w0_wl u_t004_006/r2_w1_wl u_t004_006/r2_r0_rwl u_t004_006/r2_r1_rwl
+ u_t004_006/r3_w0_wl u_t004_006/r3_w1_wl u_t004_006/r3_r0_rwl u_t004_006/r3_r1_rwl
+ u_t004_006/VDD u_t004_031/VSS VSUBS detronyx_12t_2w2r_rc4_4x4_routed_5layer_direct
Xgf180mcu_as_sc_mcu7t3v3__inv_2_448 VSS VSS gf180mcu_as_sc_mcu7t3v3__inv_2_448/Y VSS
+ gf180mcu_as_sc_mcu7t3v3__inv_2_448/VNW VSUBS gf180mcu_as_sc_mcu7t3v3__inv_2
Xgf180mcu_as_sc_mcu7t3v3__inv_2_437 VSS VSS VSS VSS gf180mcu_as_sc_mcu7t3v3__inv_2_437/VNW
+ VSUBS gf180mcu_as_sc_mcu7t3v3__inv_2
Xgf180mcu_as_sc_mcu7t3v3__inv_2_415 gf180mcu_as_sc_mcu7t3v3__nor2_2_5/VDD gf180mcu_as_sc_mcu7t3v3__nor2_2_5/VSS
+ VSS VSS gf180mcu_as_sc_mcu7t3v3__nor2_2_5/VNW VSUBS gf180mcu_as_sc_mcu7t3v3__inv_2
Xgf180mcu_as_sc_mcu7t3v3__inv_2_426 gf180mcu_as_sc_mcu7t3v3__nor2_2_5/VDD gf180mcu_as_sc_mcu7t3v3__nor2_2_5/VSS
+ VSS VSS gf180mcu_as_sc_mcu7t3v3__nor2_2_5/VNW VSUBS gf180mcu_as_sc_mcu7t3v3__inv_2
Xgf180mcu_as_sc_mcu7t3v3__inv_2_459 gf180mcu_as_sc_mcu7t3v3__nor2_2_6/VDD gf180mcu_as_sc_mcu7t3v3__nand3_2_3/VSS
+ VSS VSS gf180mcu_as_sc_mcu7t3v3__nor2_2_6/VNW VSUBS gf180mcu_as_sc_mcu7t3v3__inv_2
Xgf180mcu_as_sc_mcu7t3v3__inv_2_404 gf180mcu_as_sc_mcu7t3v3__nand3_2_5/VDD gf180mcu_as_sc_mcu7t3v3__nor2_2_6/VSS
+ VSS VSS gf180mcu_as_sc_mcu7t3v3__nand3_2_5/VNW VSUBS gf180mcu_as_sc_mcu7t3v3__inv_2
Xu_t004_028 u_t004_028/c0_w0_bl u_t004_028/c0_w0_br u_t004_028/c0_w1_bl u_t004_028/c0_w1_br
+ u_t004_028/c0_r0_rbl u_t004_028/c0_r1_rbl u_t004_028/c1_w0_bl u_t004_028/c1_w0_br
+ u_t004_028/c1_w1_bl u_t004_028/c1_w1_br u_t004_028/c1_r0_rbl u_t004_028/c1_r1_rbl
+ u_t004_028/c2_w0_bl u_t004_028/c2_w0_br u_t004_028/c2_w1_bl u_t004_028/c2_w1_br
+ u_t004_028/c2_r0_rbl u_t004_028/c2_r1_rbl u_t004_028/c3_w0_bl u_t004_028/c3_w0_br
+ u_t004_028/c3_w1_bl u_t004_028/c3_w1_br u_t004_028/c3_r0_rbl u_t004_028/c3_r1_rbl
+ u_t004_028/r0_w0_wl u_t004_028/r0_w1_wl u_t004_028/r0_r0_rwl u_t004_028/r0_r1_rwl
+ u_t004_028/r1_w0_wl u_t004_028/r1_w1_wl u_t004_028/r1_r0_rwl u_t004_028/r1_r1_rwl
+ u_t004_028/r2_w0_wl u_t004_028/r2_w1_wl u_t004_028/r2_r0_rwl u_t004_028/r2_r1_rwl
+ u_t004_028/r3_w0_wl u_t004_028/r3_w1_wl u_t004_028/r3_r0_rwl u_t004_028/r3_r1_rwl
+ u_t004_028/VDD u_t004_031/VSS VSUBS detronyx_12t_2w2r_rc4_4x4_routed_5layer_direct
Xu_t004_017 u_t004_017/c0_w0_bl u_t004_017/c0_w0_br u_t004_017/c0_w1_bl u_t004_017/c0_w1_br
+ u_t004_017/c0_r0_rbl u_t004_017/c0_r1_rbl u_t004_017/c1_w0_bl u_t004_017/c1_w0_br
+ u_t004_017/c1_w1_bl u_t004_017/c1_w1_br u_t004_017/c1_r0_rbl u_t004_017/c1_r1_rbl
+ u_t004_017/c2_w0_bl u_t004_017/c2_w0_br u_t004_017/c2_w1_bl u_t004_017/c2_w1_br
+ u_t004_017/c2_r0_rbl u_t004_017/c2_r1_rbl u_t004_017/c3_w0_bl u_t004_017/c3_w0_br
+ u_t004_017/c3_w1_bl u_t004_017/c3_w1_br u_t004_017/c3_r0_rbl u_t004_017/c3_r1_rbl
+ u_t004_017/r0_w0_wl u_t004_017/r0_w1_wl u_t004_017/r0_r0_rwl u_t004_017/r0_r1_rwl
+ u_t004_017/r1_w0_wl u_t004_017/r1_w1_wl u_t004_017/r1_r0_rwl u_t004_017/r1_r1_rwl
+ u_t004_017/r2_w0_wl u_t004_017/r2_w1_wl u_t004_017/r2_r0_rwl u_t004_017/r2_r1_rwl
+ u_t004_017/r3_w0_wl u_t004_017/r3_w1_wl u_t004_017/r3_r0_rwl u_t004_017/r3_r1_rwl
+ VSS u_t004_031/VSS VSUBS detronyx_12t_2w2r_rc4_4x4_routed_5layer_direct
Xgf180mcu_as_sc_mcu7t3v3__inv_2_982 gf180mcu_as_sc_mcu7t3v3__inv_2_982/VDD VSS gf180mcu_as_sc_mcu7t3v3__inv_2_982/Y
+ VSS gf180mcu_as_sc_mcu7t3v3__inv_2_982/VNW VSUBS gf180mcu_as_sc_mcu7t3v3__inv_2
Xgf180mcu_as_sc_mcu7t3v3__inv_2_960 VSS gf180mcu_as_sc_mcu7t3v3__inv_2_966/VDD VSS
+ gf180mcu_as_sc_mcu7t3v3__inv_2_991/A gf180mcu_as_sc_mcu7t3v3__inv_2_962/VNW VSUBS
+ gf180mcu_as_sc_mcu7t3v3__inv_2
Xgf180mcu_as_sc_mcu7t3v3__inv_2_971 gf180mcu_as_sc_mcu7t3v3__inv_2_999/VSS gf180mcu_as_sc_mcu7t3v3__inv_2_987/VSS
+ VSS gf180mcu_as_sc_mcu7t3v3__inv_2_991/A gf180mcu_as_sc_mcu7t3v3__inv_2_987/VNW
+ VSUBS gf180mcu_as_sc_mcu7t3v3__inv_2
Xgf180mcu_as_sc_mcu7t3v3__inv_2_993 gf180mcu_as_sc_mcu7t3v3__inv_2_994/VDD VSS gf180mcu_as_sc_mcu7t3v3__inv_2_993/Y
+ gf180mcu_as_sc_mcu7t3v3__inv_2_994/Y gf180mcu_as_sc_mcu7t3v3__inv_2_994/VNW VSUBS
+ gf180mcu_as_sc_mcu7t3v3__inv_2
Xu_t010_009 u_t010_009/c0_w0_bl u_t010_009/c0_w0_br u_t010_009/c0_w1_bl u_t010_009/c0_w1_br
+ u_t010_009/c0_r0_rbl u_t010_009/c0_r1_rbl u_t010_009/c1_w0_bl u_t010_009/c1_w0_br
+ u_t010_009/c1_w1_bl u_t010_009/c1_w1_br u_t010_009/c1_r0_rbl u_t010_009/c1_r1_rbl
+ u_t010_009/c2_w0_bl u_t010_009/c2_w0_br u_t010_009/c2_w1_bl u_t010_009/c2_w1_br
+ u_t010_009/c2_r0_rbl u_t010_009/c2_r1_rbl u_t010_009/c3_w0_bl u_t010_009/c3_w0_br
+ u_t010_009/c3_w1_bl u_t010_009/c3_w1_br u_t010_009/c3_r0_rbl u_t010_009/c3_r1_rbl
+ u_t010_009/r0_w0_wl u_t010_009/r0_w1_wl u_t010_009/r0_r0_rwl u_t010_009/r0_r1_rwl
+ u_t010_009/r1_w0_wl u_t010_009/r1_w1_wl u_t010_009/r1_r0_rwl u_t010_009/r1_r1_rwl
+ u_t010_009/r2_w0_wl u_t010_009/r2_w1_wl u_t010_009/r2_r0_rwl u_t010_009/r2_r1_rwl
+ u_t010_009/r3_w0_wl u_t010_009/r3_w1_wl u_t010_009/r3_r0_rwl u_t010_009/r3_r1_rwl
+ VSS u_t010_009/VSS VSUBS detronyx_12t_2w2r_rc4_4x4_routed_5layer_direct
Xgf180mcu_as_sc_mcu7t3v3__nand4_2_270 VSS VSS VSS VSS VSS VSS gf180mcu_as_sc_mcu7t3v3__nand4_2_270/Y
+ gf180mcu_as_sc_mcu7t3v3__inv_2_932/VNW VSUBS gf180mcu_as_sc_mcu7t3v3__nand4_2
Xgf180mcu_as_sc_mcu7t3v3__nand4_2_292 VSS VSS VSS VSS VSS VSS VSS gf180mcu_as_sc_mcu7t3v3__inv_2_986/VNW
+ VSUBS gf180mcu_as_sc_mcu7t3v3__nand4_2
Xgf180mcu_as_sc_mcu7t3v3__nand4_2_281 VSS VSS VSS VSS VSS VSS gf180mcu_as_sc_mcu7t3v3__nand4_2_281/Y
+ gf180mcu_as_sc_mcu7t3v3__inv_2_954/VNW VSUBS gf180mcu_as_sc_mcu7t3v3__nand4_2
Xu_t001_009 u_t001_009/c0_w0_bl u_t001_009/c0_w0_br u_t001_009/c0_w1_bl u_t001_009/c0_w1_br
+ u_t001_009/c0_r0_rbl u_t001_009/c0_r1_rbl u_t001_009/c1_w0_bl u_t001_009/c1_w0_br
+ u_t001_009/c1_w1_bl u_t001_009/c1_w1_br u_t001_009/c1_r0_rbl u_t001_009/c1_r1_rbl
+ u_t001_009/c2_w0_bl u_t001_009/c2_w0_br u_t001_009/c2_w1_bl u_t001_009/c2_w1_br
+ u_t001_009/c2_r0_rbl u_t001_009/c2_r1_rbl u_t001_009/c3_w0_bl u_t001_009/c3_w0_br
+ u_t001_009/c3_w1_bl u_t001_009/c3_w1_br u_t001_009/c3_r0_rbl u_t001_009/c3_r1_rbl
+ u_t001_009/r0_w0_wl u_t001_009/r0_w1_wl u_t001_009/r0_r0_rwl u_t001_009/r0_r1_rwl
+ u_t001_009/r1_w0_wl u_t001_009/r1_w1_wl u_t001_009/r1_r0_rwl u_t001_009/r1_r1_rwl
+ u_t001_009/r2_w0_wl u_t001_009/r2_w1_wl u_t001_009/r2_r0_rwl u_t001_009/r2_r1_rwl
+ u_t001_009/r3_w0_wl u_t001_009/r3_w1_wl u_t001_009/r3_r0_rwl u_t001_009/r3_r1_rwl
+ VSS u_t001_031/VSS VSUBS detronyx_12t_2w2r_rc4_4x4_routed_5layer_direct
Xgf180mcu_as_sc_mcu7t3v3__inv_2_278 VSS gf180mcu_as_sc_mcu7t3v3__inv_2_353/VDD gf180mcu_as_sc_mcu7t3v3__inv_2_66/Y
+ gf180mcu_as_sc_mcu7t3v3__inv_2_66/Y gf180mcu_as_sc_mcu7t3v3__inv_2_352/VNW VSUBS
+ gf180mcu_as_sc_mcu7t3v3__inv_2
Xgf180mcu_as_sc_mcu7t3v3__inv_2_267 VSS VSS VSS gf180mcu_as_sc_mcu7t3v3__inv_2_66/Y
+ gf180mcu_as_sc_mcu7t3v3__inv_2_365/VNW VSUBS gf180mcu_as_sc_mcu7t3v3__inv_2
Xgf180mcu_as_sc_mcu7t3v3__inv_2_201 gf180mcu_as_sc_mcu7t3v3__inv_2_205/VDD VSS VSS
+ VSS gf180mcu_as_sc_mcu7t3v3__inv_2_205/VNW VSUBS gf180mcu_as_sc_mcu7t3v3__inv_2
Xgf180mcu_as_sc_mcu7t3v3__inv_2_289 gf180mcu_as_sc_mcu7t3v3__inv_2_355/VDD gf180mcu_as_sc_mcu7t3v3__inv_2_356/VDD
+ VSS gf180mcu_as_sc_mcu7t3v3__inv_2_358/Y gf180mcu_as_sc_mcu7t3v3__inv_2_355/VNW
+ VSUBS gf180mcu_as_sc_mcu7t3v3__inv_2
Xgf180mcu_as_sc_mcu7t3v3__inv_2_223 VSS VSS VSS VSS gf180mcu_as_sc_mcu7t3v3__inv_2_224/VNW
+ VSUBS gf180mcu_as_sc_mcu7t3v3__inv_2
Xgf180mcu_as_sc_mcu7t3v3__inv_2_234 VSS VSS VSS VSS gf180mcu_as_sc_mcu7t3v3__inv_2_253/VNW
+ VSUBS gf180mcu_as_sc_mcu7t3v3__inv_2
Xgf180mcu_as_sc_mcu7t3v3__inv_2_212 VSS VSS VSS VSS gf180mcu_as_sc_mcu7t3v3__inv_2_253/VNW
+ VSUBS gf180mcu_as_sc_mcu7t3v3__inv_2
Xgf180mcu_as_sc_mcu7t3v3__inv_2_245 gf180mcu_as_sc_mcu7t3v3__inv_2_245/VDD VSS VSS
+ VSS gf180mcu_as_sc_mcu7t3v3__inv_2_245/VNW VSUBS gf180mcu_as_sc_mcu7t3v3__inv_2
Xgf180mcu_as_sc_mcu7t3v3__inv_2_256 VSS VSS VSS VSS gf180mcu_as_sc_mcu7t3v3__inv_2_256/VNW
+ VSUBS gf180mcu_as_sc_mcu7t3v3__inv_2
Xu_t000_031 u_t000_031/c0_w0_bl u_t000_031/c0_w0_br u_t000_031/c0_w1_bl u_t000_031/c0_w1_br
+ u_t000_031/c0_r0_rbl u_t000_031/c0_r1_rbl u_t000_031/c1_w0_bl u_t000_031/c1_w0_br
+ u_t000_031/c1_w1_bl u_t000_031/c1_w1_br u_t000_031/c1_r0_rbl u_t000_031/c1_r1_rbl
+ u_t000_031/c2_w0_bl u_t000_031/c2_w0_br u_t000_031/c2_w1_bl u_t000_031/c2_w1_br
+ u_t000_031/c2_r0_rbl u_t000_031/c2_r1_rbl u_t000_031/c3_w0_bl u_t000_031/c3_w0_br
+ u_t000_031/c3_w1_bl u_t000_031/c3_w1_br u_t000_031/c3_r0_rbl u_t000_031/c3_r1_rbl
+ u_t000_031/r0_w0_wl u_t000_031/r0_w1_wl u_t000_031/r0_r0_rwl u_t000_031/r0_r1_rwl
+ u_t000_031/r1_w0_wl u_t000_031/r1_w1_wl u_t000_031/r1_r0_rwl u_t000_031/r1_r1_rwl
+ u_t000_031/r2_w0_wl u_t000_031/r2_w1_wl u_t000_031/r2_r0_rwl u_t000_031/r2_r1_rwl
+ u_t000_031/r3_w0_wl u_t000_031/r3_w1_wl u_t000_031/r3_r0_rwl u_t000_031/r3_r1_rwl
+ VSS u_t000_031/VSS VSUBS detronyx_12t_2w2r_rc4_4x4_routed_5layer_direct
Xu_t000_020 u_t000_020/c0_w0_bl u_t000_020/c0_w0_br u_t000_020/c0_w1_bl u_t000_020/c0_w1_br
+ u_t000_020/c0_r0_rbl u_t000_020/c0_r1_rbl u_t000_020/c1_w0_bl u_t000_020/c1_w0_br
+ u_t000_020/c1_w1_bl u_t000_020/c1_w1_br u_t000_020/c1_r0_rbl u_t000_020/c1_r1_rbl
+ u_t000_020/c2_w0_bl u_t000_020/c2_w0_br u_t000_020/c2_w1_bl u_t000_020/c2_w1_br
+ u_t000_020/c2_r0_rbl u_t000_020/c2_r1_rbl u_t000_020/c3_w0_bl u_t000_020/c3_w0_br
+ u_t000_020/c3_w1_bl u_t000_020/c3_w1_br u_t000_020/c3_r0_rbl u_t000_020/c3_r1_rbl
+ u_t000_020/r0_w0_wl u_t000_020/r0_w1_wl u_t000_020/r0_r0_rwl u_t000_020/r0_r1_rwl
+ u_t000_020/r1_w0_wl u_t000_020/r1_w1_wl u_t000_020/r1_r0_rwl u_t000_020/r1_r1_rwl
+ u_t000_020/r2_w0_wl u_t000_020/r2_w1_wl u_t000_020/r2_r0_rwl u_t000_020/r2_r1_rwl
+ u_t000_020/r3_w0_wl u_t000_020/r3_w1_wl u_t000_020/r3_r0_rwl u_t000_020/r3_r1_rwl
+ u_t000_020/VDD u_t000_031/VSS VSUBS detronyx_12t_2w2r_rc4_4x4_routed_5layer_direct
Xgf180mcu_as_sc_mcu7t3v3__inv_2_790 VSS VSS gf180mcu_as_sc_mcu7t3v3__inv_2_790/Y VSS
+ gf180mcu_as_sc_mcu7t3v3__inv_2_792/VNW VSUBS gf180mcu_as_sc_mcu7t3v3__inv_2
Xgf180mcu_as_sc_mcu7t3v3__inv_2_1508 gf180mcu_as_sc_mcu7t3v3__inv_2_1552/VSS gf180mcu_as_sc_mcu7t3v3__inv_2_1514/VDD
+ VSS VSS gf180mcu_as_sc_mcu7t3v3__inv_2_1510/VNW VSUBS gf180mcu_as_sc_mcu7t3v3__inv_2
Xgf180mcu_as_sc_mcu7t3v3__inv_2_1519 VSS gf180mcu_as_sc_mcu7t3v3__inv_2_1524/VDD gf180mcu_as_sc_mcu7t3v3__inv_2_1519/Y
+ VSS gf180mcu_as_sc_mcu7t3v3__inv_2_1520/VNW VSUBS gf180mcu_as_sc_mcu7t3v3__inv_2
Xgf180mcu_as_sc_mcu7t3v3__nor2_2_2 gf180mcu_as_sc_mcu7t3v3__nor2_2_5/VDD gf180mcu_as_sc_mcu7t3v3__nor2_2_5/VSS
+ VSS VSS VSS gf180mcu_as_sc_mcu7t3v3__nor2_2_5/VNW VSUBS gf180mcu_as_sc_mcu7t3v3__nor2_2
Xgf180mcu_as_sc_mcu7t3v3__nand2_2_7 gf180mcu_as_sc_mcu7t3v3__nor2_2_6/VDD gf180mcu_as_sc_mcu7t3v3__nand3_2_3/VSS
+ VSS VSS VSS gf180mcu_as_sc_mcu7t3v3__nor2_2_6/VNW VSUBS gf180mcu_as_sc_mcu7t3v3__nand2_2
Xgf180mcu_as_sc_mcu7t3v3__inv_2_1338 VSS gf180mcu_as_sc_mcu7t3v3__inv_2_1390/VDD gf180mcu_as_sc_mcu7t3v3__inv_2_1338/Y
+ gf180mcu_as_sc_mcu7t3v3__inv_2_1398/Y gf180mcu_as_sc_mcu7t3v3__inv_2_1389/VNW VSUBS
+ gf180mcu_as_sc_mcu7t3v3__inv_2
Xgf180mcu_as_sc_mcu7t3v3__inv_2_1327 gf180mcu_as_sc_mcu7t3v3__inv_2_1376/VDD VSS gf180mcu_as_sc_mcu7t3v3__inv_2_1379/Y
+ gf180mcu_as_sc_mcu7t3v3__inv_2_1379/Y gf180mcu_as_sc_mcu7t3v3__inv_2_1376/VNW VSUBS
+ gf180mcu_as_sc_mcu7t3v3__inv_2
Xgf180mcu_as_sc_mcu7t3v3__inv_2_1316 gf180mcu_as_sc_mcu7t3v3__inv_2_1369/VDD VSS VSS
+ gf180mcu_as_sc_mcu7t3v3__inv_2_1369/Y gf180mcu_as_sc_mcu7t3v3__inv_2_1369/VNW VSUBS
+ gf180mcu_as_sc_mcu7t3v3__inv_2
Xgf180mcu_as_sc_mcu7t3v3__inv_2_1305 gf180mcu_as_sc_mcu7t3v3__inv_2_1397/VSS VSS gf180mcu_as_sc_mcu7t3v3__inv_2_1305/Y
+ gf180mcu_as_sc_mcu7t3v3__inv_2_1398/Y gf180mcu_as_sc_mcu7t3v3__inv_2_1366/VNW VSUBS
+ gf180mcu_as_sc_mcu7t3v3__inv_2
Xgf180mcu_as_sc_mcu7t3v3__inv_2_1349 VSS gf180mcu_as_sc_mcu7t3v3__inv_2_1393/VDD gf180mcu_as_sc_mcu7t3v3__inv_2_1398/Y
+ gf180mcu_as_sc_mcu7t3v3__inv_2_1398/Y gf180mcu_as_sc_mcu7t3v3__inv_2_1392/VNW VSUBS
+ gf180mcu_as_sc_mcu7t3v3__inv_2
Xu_t028_023 u_t028_023/c0_w0_bl u_t028_023/c0_w0_br u_t028_023/c0_w1_bl u_t028_023/c0_w1_br
+ u_t028_023/c0_r0_rbl u_t028_023/c0_r1_rbl u_t028_023/c1_w0_bl u_t028_023/c1_w0_br
+ u_t028_023/c1_w1_bl u_t028_023/c1_w1_br u_t028_023/c1_r0_rbl u_t028_023/c1_r1_rbl
+ u_t028_023/c2_w0_bl u_t028_023/c2_w0_br u_t028_023/c2_w1_bl u_t028_023/c2_w1_br
+ u_t028_023/c2_r0_rbl u_t028_023/c2_r1_rbl u_t028_023/c3_w0_bl u_t028_023/c3_w0_br
+ u_t028_023/c3_w1_bl u_t028_023/c3_w1_br u_t028_023/c3_r0_rbl u_t028_023/c3_r1_rbl
+ u_t028_023/r0_w0_wl u_t028_023/r0_w1_wl u_t028_023/r0_r0_rwl u_t028_023/r0_r1_rwl
+ u_t028_023/r1_w0_wl u_t028_023/r1_w1_wl u_t028_023/r1_r0_rwl u_t028_023/r1_r1_rwl
+ u_t028_023/r2_w0_wl u_t028_023/r2_w1_wl u_t028_023/r2_r0_rwl u_t028_023/r2_r1_rwl
+ u_t028_023/r3_w0_wl u_t028_023/r3_w1_wl u_t028_023/r3_r0_rwl u_t028_023/r3_r1_rwl
+ VSS u_t028_024/VSS VSUBS detronyx_12t_2w2r_rc4_4x4_routed_5layer_direct
Xu_t028_012 u_t028_012/c0_w0_bl u_t028_012/c0_w0_br u_t028_012/c0_w1_bl u_t028_012/c0_w1_br
+ u_t028_012/c0_r0_rbl u_t028_012/c0_r1_rbl u_t028_012/c1_w0_bl u_t028_012/c1_w0_br
+ u_t028_012/c1_w1_bl u_t028_012/c1_w1_br u_t028_012/c1_r0_rbl u_t028_012/c1_r1_rbl
+ u_t028_012/c2_w0_bl u_t028_012/c2_w0_br u_t028_012/c2_w1_bl u_t028_012/c2_w1_br
+ u_t028_012/c2_r0_rbl u_t028_012/c2_r1_rbl u_t028_012/c3_w0_bl u_t028_012/c3_w0_br
+ u_t028_012/c3_w1_bl u_t028_012/c3_w1_br u_t028_012/c3_r0_rbl u_t028_012/c3_r1_rbl
+ u_t028_012/r0_w0_wl u_t028_012/r0_w1_wl u_t028_012/r0_r0_rwl u_t028_012/r0_r1_rwl
+ u_t028_012/r1_w0_wl u_t028_012/r1_w1_wl u_t028_012/r1_r0_rwl u_t028_012/r1_r1_rwl
+ u_t028_012/r2_w0_wl u_t028_012/r2_w1_wl u_t028_012/r2_r0_rwl u_t028_012/r2_r1_rwl
+ u_t028_012/r3_w0_wl u_t028_012/r3_w1_wl u_t028_012/r3_r0_rwl u_t028_012/r3_r1_rwl
+ u_t029_012/VDD u_t028_012/VSS VSUBS detronyx_12t_2w2r_rc4_4x4_routed_5layer_direct
Xu_t028_001 u_t028_001/c0_w0_bl u_t028_001/c0_w0_br u_t028_001/c0_w1_bl u_t028_001/c0_w1_br
+ u_t028_001/c0_r0_rbl u_t028_001/c0_r1_rbl u_t028_001/c1_w0_bl u_t028_001/c1_w0_br
+ u_t028_001/c1_w1_bl u_t028_001/c1_w1_br u_t028_001/c1_r0_rbl u_t028_001/c1_r1_rbl
+ u_t028_001/c2_w0_bl u_t028_001/c2_w0_br u_t028_001/c2_w1_bl u_t028_001/c2_w1_br
+ u_t028_001/c2_r0_rbl u_t028_001/c2_r1_rbl u_t028_001/c3_w0_bl u_t028_001/c3_w0_br
+ u_t028_001/c3_w1_bl u_t028_001/c3_w1_br u_t028_001/c3_r0_rbl u_t028_001/c3_r1_rbl
+ u_t028_001/r0_w0_wl u_t028_001/r0_w1_wl u_t028_001/r0_r0_rwl u_t028_001/r0_r1_rwl
+ u_t028_001/r1_w0_wl u_t028_001/r1_w1_wl u_t028_001/r1_r0_rwl u_t028_001/r1_r1_rwl
+ u_t028_001/r2_w0_wl u_t028_001/r2_w1_wl u_t028_001/r2_r0_rwl u_t028_001/r2_r1_rwl
+ u_t028_001/r3_w0_wl u_t028_001/r3_w1_wl u_t028_001/r3_r0_rwl u_t028_001/r3_r1_rwl
+ VSS u_t028_002/VSS VSUBS detronyx_12t_2w2r_rc4_4x4_routed_5layer_direct
Xu_t019_023 u_t019_023/c0_w0_bl u_t019_023/c0_w0_br u_t019_023/c0_w1_bl u_t019_023/c0_w1_br
+ u_t019_023/c0_r0_rbl u_t019_023/c0_r1_rbl u_t019_023/c1_w0_bl u_t019_023/c1_w0_br
+ u_t019_023/c1_w1_bl u_t019_023/c1_w1_br u_t019_023/c1_r0_rbl u_t019_023/c1_r1_rbl
+ u_t019_023/c2_w0_bl u_t019_023/c2_w0_br u_t019_023/c2_w1_bl u_t019_023/c2_w1_br
+ u_t019_023/c2_r0_rbl u_t019_023/c2_r1_rbl u_t019_023/c3_w0_bl u_t019_023/c3_w0_br
+ u_t019_023/c3_w1_bl u_t019_023/c3_w1_br u_t019_023/c3_r0_rbl u_t019_023/c3_r1_rbl
+ u_t019_023/r0_w0_wl u_t019_023/r0_w1_wl u_t019_023/r0_r0_rwl u_t019_023/r0_r1_rwl
+ u_t019_023/r1_w0_wl u_t019_023/r1_w1_wl u_t019_023/r1_r0_rwl u_t019_023/r1_r1_rwl
+ u_t019_023/r2_w0_wl u_t019_023/r2_w1_wl u_t019_023/r2_r0_rwl u_t019_023/r2_r1_rwl
+ u_t019_023/r3_w0_wl u_t019_023/r3_w1_wl u_t019_023/r3_r0_rwl u_t019_023/r3_r1_rwl
+ VSS u_t019_024/VSS VSUBS detronyx_12t_2w2r_rc4_4x4_routed_5layer_direct
Xu_t019_012 u_t019_012/c0_w0_bl u_t019_012/c0_w0_br u_t019_012/c0_w1_bl u_t019_012/c0_w1_br
+ u_t019_012/c0_r0_rbl u_t019_012/c0_r1_rbl u_t019_012/c1_w0_bl u_t019_012/c1_w0_br
+ u_t019_012/c1_w1_bl u_t019_012/c1_w1_br u_t019_012/c1_r0_rbl u_t019_012/c1_r1_rbl
+ u_t019_012/c2_w0_bl u_t019_012/c2_w0_br u_t019_012/c2_w1_bl u_t019_012/c2_w1_br
+ u_t019_012/c2_r0_rbl u_t019_012/c2_r1_rbl u_t019_012/c3_w0_bl u_t019_012/c3_w0_br
+ u_t019_012/c3_w1_bl u_t019_012/c3_w1_br u_t019_012/c3_r0_rbl u_t019_012/c3_r1_rbl
+ u_t019_012/r0_w0_wl u_t019_012/r0_w1_wl u_t019_012/r0_r0_rwl u_t019_012/r0_r1_rwl
+ u_t019_012/r1_w0_wl u_t019_012/r1_w1_wl u_t019_012/r1_r0_rwl u_t019_012/r1_r1_rwl
+ u_t019_012/r2_w0_wl u_t019_012/r2_w1_wl u_t019_012/r2_r0_rwl u_t019_012/r2_r1_rwl
+ u_t019_012/r3_w0_wl u_t019_012/r3_w1_wl u_t019_012/r3_r0_rwl u_t019_012/r3_r1_rwl
+ u_t019_012/VDD u_t019_012/VSS VSUBS detronyx_12t_2w2r_rc4_4x4_routed_5layer_direct
Xu_t019_001 u_t019_001/c0_w0_bl u_t019_001/c0_w0_br u_t019_001/c0_w1_bl u_t019_001/c0_w1_br
+ u_t019_001/c0_r0_rbl u_t019_001/c0_r1_rbl u_t019_001/c1_w0_bl u_t019_001/c1_w0_br
+ u_t019_001/c1_w1_bl u_t019_001/c1_w1_br u_t019_001/c1_r0_rbl u_t019_001/c1_r1_rbl
+ u_t019_001/c2_w0_bl u_t019_001/c2_w0_br u_t019_001/c2_w1_bl u_t019_001/c2_w1_br
+ u_t019_001/c2_r0_rbl u_t019_001/c2_r1_rbl u_t019_001/c3_w0_bl u_t019_001/c3_w0_br
+ u_t019_001/c3_w1_bl u_t019_001/c3_w1_br u_t019_001/c3_r0_rbl u_t019_001/c3_r1_rbl
+ u_t019_001/r0_w0_wl u_t019_001/r0_w1_wl u_t019_001/r0_r0_rwl u_t019_001/r0_r1_rwl
+ u_t019_001/r1_w0_wl u_t019_001/r1_w1_wl u_t019_001/r1_r0_rwl u_t019_001/r1_r1_rwl
+ u_t019_001/r2_w0_wl u_t019_001/r2_w1_wl u_t019_001/r2_r0_rwl u_t019_001/r2_r1_rwl
+ u_t019_001/r3_w0_wl u_t019_001/r3_w1_wl u_t019_001/r3_r0_rwl u_t019_001/r3_r1_rwl
+ VSS u_t019_002/VSS VSUBS detronyx_12t_2w2r_rc4_4x4_routed_5layer_direct
Xgf180mcu_as_sc_mcu7t3v3__nand4_2_27 gf180mcu_as_sc_mcu7t3v3__inv_2_88/VSS gf180mcu_as_sc_mcu7t3v3__inv_2_88/VSS
+ VSS VSS VSS VSS VSS gf180mcu_as_sc_mcu7t3v3__inv_2_83/VNW VSUBS gf180mcu_as_sc_mcu7t3v3__nand4_2
Xgf180mcu_as_sc_mcu7t3v3__nand4_2_38 gf180mcu_as_sc_mcu7t3v3__inv_2_126/VDD VSS VSS
+ VSS VSS VSS VSS gf180mcu_as_sc_mcu7t3v3__inv_2_126/VNW VSUBS gf180mcu_as_sc_mcu7t3v3__nand4_2
Xgf180mcu_as_sc_mcu7t3v3__nand4_2_49 gf180mcu_as_sc_mcu7t3v3__inv_2_152/VSS gf180mcu_as_sc_mcu7t3v3__inv_2_151/VDD
+ VSS VSS VSS VSS gf180mcu_as_sc_mcu7t3v3__nand4_2_49/Y gf180mcu_as_sc_mcu7t3v3__inv_2_135/VNW
+ VSUBS gf180mcu_as_sc_mcu7t3v3__nand4_2
Xgf180mcu_as_sc_mcu7t3v3__nand4_2_16 gf180mcu_as_sc_mcu7t3v3__inv_2_65/VDD gf180mcu_as_sc_mcu7t3v3__inv_2_66/VDD
+ VSS VSS VSS VSS VSS gf180mcu_as_sc_mcu7t3v3__inv_2_65/VNW VSUBS gf180mcu_as_sc_mcu7t3v3__nand4_2
Xu_t025_026 u_t025_026/c0_w0_bl u_t025_026/c0_w0_br u_t025_026/c0_w1_bl u_t025_026/c0_w1_br
+ u_t025_026/c0_r0_rbl u_t025_026/c0_r1_rbl u_t025_026/c1_w0_bl u_t025_026/c1_w0_br
+ u_t025_026/c1_w1_bl u_t025_026/c1_w1_br u_t025_026/c1_r0_rbl u_t025_026/c1_r1_rbl
+ u_t025_026/c2_w0_bl u_t025_026/c2_w0_br u_t025_026/c2_w1_bl u_t025_026/c2_w1_br
+ u_t025_026/c2_r0_rbl u_t025_026/c2_r1_rbl u_t025_026/c3_w0_bl u_t025_026/c3_w0_br
+ u_t025_026/c3_w1_bl u_t025_026/c3_w1_br u_t025_026/c3_r0_rbl u_t025_026/c3_r1_rbl
+ u_t025_026/r0_w0_wl u_t025_026/r0_w1_wl u_t025_026/r0_r0_rwl u_t025_026/r0_r1_rwl
+ u_t025_026/r1_w0_wl u_t025_026/r1_w1_wl u_t025_026/r1_r0_rwl u_t025_026/r1_r1_rwl
+ u_t025_026/r2_w0_wl u_t025_026/r2_w1_wl u_t025_026/r2_r0_rwl u_t025_026/r2_r1_rwl
+ u_t025_026/r3_w0_wl u_t025_026/r3_w1_wl u_t025_026/r3_r0_rwl u_t025_026/r3_r1_rwl
+ u_t025_026/VDD u_t025_031/VSS VSUBS detronyx_12t_2w2r_rc4_4x4_routed_5layer_direct
Xu_t025_015 u_t025_015/c0_w0_bl u_t025_015/c0_w0_br u_t025_015/c0_w1_bl u_t025_015/c0_w1_br
+ u_t025_015/c0_r0_rbl u_t025_015/c0_r1_rbl u_t025_015/c1_w0_bl u_t025_015/c1_w0_br
+ u_t025_015/c1_w1_bl u_t025_015/c1_w1_br u_t025_015/c1_r0_rbl u_t025_015/c1_r1_rbl
+ u_t025_015/c2_w0_bl u_t025_015/c2_w0_br u_t025_015/c2_w1_bl u_t025_015/c2_w1_br
+ u_t025_015/c2_r0_rbl u_t025_015/c2_r1_rbl u_t025_015/c3_w0_bl u_t025_015/c3_w0_br
+ u_t025_015/c3_w1_bl u_t025_015/c3_w1_br u_t025_015/c3_r0_rbl u_t025_015/c3_r1_rbl
+ u_t025_015/r0_w0_wl u_t025_015/r0_w1_wl u_t025_015/r0_r0_rwl u_t025_015/r0_r1_rwl
+ u_t025_015/r1_w0_wl u_t025_015/r1_w1_wl u_t025_015/r1_r0_rwl u_t025_015/r1_r1_rwl
+ u_t025_015/r2_w0_wl u_t025_015/r2_w1_wl u_t025_015/r2_r0_rwl u_t025_015/r2_r1_rwl
+ u_t025_015/r3_w0_wl u_t025_015/r3_w1_wl u_t025_015/r3_r0_rwl u_t025_015/r3_r1_rwl
+ VSS u_t025_031/VSS VSUBS detronyx_12t_2w2r_rc4_4x4_routed_5layer_direct
Xu_t025_004 u_t025_004/c0_w0_bl u_t025_004/c0_w0_br u_t025_004/c0_w1_bl u_t025_004/c0_w1_br
+ u_t025_004/c0_r0_rbl u_t025_004/c0_r1_rbl u_t025_004/c1_w0_bl u_t025_004/c1_w0_br
+ u_t025_004/c1_w1_bl u_t025_004/c1_w1_br u_t025_004/c1_r0_rbl u_t025_004/c1_r1_rbl
+ u_t025_004/c2_w0_bl u_t025_004/c2_w0_br u_t025_004/c2_w1_bl u_t025_004/c2_w1_br
+ u_t025_004/c2_r0_rbl u_t025_004/c2_r1_rbl u_t025_004/c3_w0_bl u_t025_004/c3_w0_br
+ u_t025_004/c3_w1_bl u_t025_004/c3_w1_br u_t025_004/c3_r0_rbl u_t025_004/c3_r1_rbl
+ u_t025_004/r0_w0_wl u_t025_004/r0_w1_wl u_t025_004/r0_r0_rwl u_t025_004/r0_r1_rwl
+ u_t025_004/r1_w0_wl u_t025_004/r1_w1_wl u_t025_004/r1_r0_rwl u_t025_004/r1_r1_rwl
+ u_t025_004/r2_w0_wl u_t025_004/r2_w1_wl u_t025_004/r2_r0_rwl u_t025_004/r2_r1_rwl
+ u_t025_004/r3_w0_wl u_t025_004/r3_w1_wl u_t025_004/r3_r0_rwl u_t025_004/r3_r1_rwl
+ u_t025_004/VDD u_t025_031/VSS VSUBS detronyx_12t_2w2r_rc4_4x4_routed_5layer_direct
Xgf180mcu_as_sc_mcu7t3v3__inv_2_1124 gf180mcu_as_sc_mcu7t3v3__inv_2_1126/VDD VSS VSS
+ VSS gf180mcu_as_sc_mcu7t3v3__inv_2_1126/VNW VSUBS gf180mcu_as_sc_mcu7t3v3__inv_2
Xgf180mcu_as_sc_mcu7t3v3__inv_2_1135 gf180mcu_as_sc_mcu7t3v3__inv_2_1135/VDD VSS gf180mcu_as_sc_mcu7t3v3__inv_2_1135/Y
+ VSS gf180mcu_as_sc_mcu7t3v3__inv_2_1135/VNW VSUBS gf180mcu_as_sc_mcu7t3v3__inv_2
Xgf180mcu_as_sc_mcu7t3v3__inv_2_1113 VSS gf180mcu_as_sc_mcu7t3v3__inv_2_1117/VDD gf180mcu_as_sc_mcu7t3v3__inv_2_1113/Y
+ gf180mcu_as_sc_mcu7t3v3__inv_2_1114/Y gf180mcu_as_sc_mcu7t3v3__inv_2_1114/VNW VSUBS
+ gf180mcu_as_sc_mcu7t3v3__inv_2
Xgf180mcu_as_sc_mcu7t3v3__inv_2_1146 VSS gf180mcu_as_sc_mcu7t3v3__inv_2_1146/VSS gf180mcu_as_sc_mcu7t3v3__inv_2_1146/Y
+ VSS gf180mcu_as_sc_mcu7t3v3__inv_2_1146/VNW VSUBS gf180mcu_as_sc_mcu7t3v3__inv_2
Xgf180mcu_as_sc_mcu7t3v3__inv_2_1179 VSS VSS VSS VSS gf180mcu_as_sc_mcu7t3v3__inv_2_1195/VNW
+ VSUBS gf180mcu_as_sc_mcu7t3v3__inv_2
Xgf180mcu_as_sc_mcu7t3v3__inv_2_1168 VSS VSS VSS VSS gf180mcu_as_sc_mcu7t3v3__inv_2_1168/VNW
+ VSUBS gf180mcu_as_sc_mcu7t3v3__inv_2
Xgf180mcu_as_sc_mcu7t3v3__inv_2_1102 VSS gf180mcu_as_sc_mcu7t3v3__inv_2_1107/VDD VSS
+ gf180mcu_as_sc_mcu7t3v3__inv_2_1106/A gf180mcu_as_sc_mcu7t3v3__inv_2_1104/VNW VSUBS
+ gf180mcu_as_sc_mcu7t3v3__inv_2
Xgf180mcu_as_sc_mcu7t3v3__inv_2_1157 VSS VSS VSS VSS gf180mcu_as_sc_mcu7t3v3__inv_2_1162/VNW
+ VSUBS gf180mcu_as_sc_mcu7t3v3__inv_2
Xu_t016_026 u_t016_026/c0_w0_bl u_t016_026/c0_w0_br u_t016_026/c0_w1_bl u_t016_026/c0_w1_br
+ u_t016_026/c0_r0_rbl u_t016_026/c0_r1_rbl u_t016_026/c1_w0_bl u_t016_026/c1_w0_br
+ u_t016_026/c1_w1_bl u_t016_026/c1_w1_br u_t016_026/c1_r0_rbl u_t016_026/c1_r1_rbl
+ u_t016_026/c2_w0_bl u_t016_026/c2_w0_br u_t016_026/c2_w1_bl u_t016_026/c2_w1_br
+ u_t016_026/c2_r0_rbl u_t016_026/c2_r1_rbl u_t016_026/c3_w0_bl u_t016_026/c3_w0_br
+ u_t016_026/c3_w1_bl u_t016_026/c3_w1_br u_t016_026/c3_r0_rbl u_t016_026/c3_r1_rbl
+ u_t016_026/r0_w0_wl u_t016_026/r0_w1_wl u_t016_026/r0_r0_rwl u_t016_026/r0_r1_rwl
+ u_t016_026/r1_w0_wl u_t016_026/r1_w1_wl u_t016_026/r1_r0_rwl u_t016_026/r1_r1_rwl
+ u_t016_026/r2_w0_wl u_t016_026/r2_w1_wl u_t016_026/r2_r0_rwl u_t016_026/r2_r1_rwl
+ u_t016_026/r3_w0_wl u_t016_026/r3_w1_wl u_t016_026/r3_r0_rwl u_t016_026/r3_r1_rwl
+ u_t016_026/VDD u_t016_026/VSS VSUBS detronyx_12t_2w2r_rc4_4x4_routed_5layer_direct
Xu_t016_015 u_t016_015/c0_w0_bl u_t016_015/c0_w0_br u_t016_015/c0_w1_bl u_t016_015/c0_w1_br
+ u_t016_015/c0_r0_rbl u_t016_015/c0_r1_rbl u_t016_015/c1_w0_bl u_t016_015/c1_w0_br
+ u_t016_015/c1_w1_bl u_t016_015/c1_w1_br u_t016_015/c1_r0_rbl u_t016_015/c1_r1_rbl
+ u_t016_015/c2_w0_bl u_t016_015/c2_w0_br u_t016_015/c2_w1_bl u_t016_015/c2_w1_br
+ u_t016_015/c2_r0_rbl u_t016_015/c2_r1_rbl u_t016_015/c3_w0_bl u_t016_015/c3_w0_br
+ u_t016_015/c3_w1_bl u_t016_015/c3_w1_br u_t016_015/c3_r0_rbl u_t016_015/c3_r1_rbl
+ u_t016_015/r0_w0_wl u_t016_015/r0_w1_wl u_t016_015/r0_r0_rwl u_t016_015/r0_r1_rwl
+ u_t016_015/r1_w0_wl u_t016_015/r1_w1_wl u_t016_015/r1_r0_rwl u_t016_015/r1_r1_rwl
+ u_t016_015/r2_w0_wl u_t016_015/r2_w1_wl u_t016_015/r2_r0_rwl u_t016_015/r2_r1_rwl
+ u_t016_015/r3_w0_wl u_t016_015/r3_w1_wl u_t016_015/r3_r0_rwl u_t016_015/r3_r1_rwl
+ VSS u_t016_017/VSS VSUBS detronyx_12t_2w2r_rc4_4x4_routed_5layer_direct
Xu_t016_004 u_t016_004/c0_w0_bl u_t016_004/c0_w0_br u_t016_004/c0_w1_bl u_t016_004/c0_w1_br
+ u_t016_004/c0_r0_rbl u_t016_004/c0_r1_rbl u_t016_004/c1_w0_bl u_t016_004/c1_w0_br
+ u_t016_004/c1_w1_bl u_t016_004/c1_w1_br u_t016_004/c1_r0_rbl u_t016_004/c1_r1_rbl
+ u_t016_004/c2_w0_bl u_t016_004/c2_w0_br u_t016_004/c2_w1_bl u_t016_004/c2_w1_br
+ u_t016_004/c2_r0_rbl u_t016_004/c2_r1_rbl u_t016_004/c3_w0_bl u_t016_004/c3_w0_br
+ u_t016_004/c3_w1_bl u_t016_004/c3_w1_br u_t016_004/c3_r0_rbl u_t016_004/c3_r1_rbl
+ u_t016_004/r0_w0_wl u_t016_004/r0_w1_wl u_t016_004/r0_r0_rwl u_t016_004/r0_r1_rwl
+ u_t016_004/r1_w0_wl u_t016_004/r1_w1_wl u_t016_004/r1_r0_rwl u_t016_004/r1_r1_rwl
+ u_t016_004/r2_w0_wl u_t016_004/r2_w1_wl u_t016_004/r2_r0_rwl u_t016_004/r2_r1_rwl
+ u_t016_004/r3_w0_wl u_t016_004/r3_w1_wl u_t016_004/r3_r0_rwl u_t016_004/r3_r1_rwl
+ u_t016_004/VDD u_t016_004/VSS VSUBS detronyx_12t_2w2r_rc4_4x4_routed_5layer_direct
Xgf180mcu_as_sc_mcu7t3v3__inv_2_619 gf180mcu_as_sc_mcu7t3v3__inv_2_620/VDD gf180mcu_as_sc_mcu7t3v3__inv_2_629/VDD
+ gf180mcu_as_sc_mcu7t3v3__inv_2_619/Y gf180mcu_as_sc_mcu7t3v3__inv_2_620/Y gf180mcu_as_sc_mcu7t3v3__inv_2_620/VNW
+ VSUBS gf180mcu_as_sc_mcu7t3v3__inv_2
Xgf180mcu_as_sc_mcu7t3v3__inv_2_608 gf180mcu_as_sc_mcu7t3v3__inv_2_630/VSS gf180mcu_as_sc_mcu7t3v3__inv_2_616/VDD
+ gf180mcu_as_sc_mcu7t3v3__inv_2_608/Y VSS gf180mcu_as_sc_mcu7t3v3__inv_2_608/VNW
+ VSUBS gf180mcu_as_sc_mcu7t3v3__inv_2
Xu_t031_029 u_t031_029/c0_w0_bl u_t031_029/c0_w0_br u_t031_029/c0_w1_bl u_t031_029/c0_w1_br
+ u_t031_029/c0_r0_rbl u_t031_029/c0_r1_rbl u_t031_029/c1_w0_bl u_t031_029/c1_w0_br
+ u_t031_029/c1_w1_bl u_t031_029/c1_w1_br u_t031_029/c1_r0_rbl u_t031_029/c1_r1_rbl
+ u_t031_029/c2_w0_bl u_t031_029/c2_w0_br u_t031_029/c2_w1_bl u_t031_029/c2_w1_br
+ u_t031_029/c2_r0_rbl u_t031_029/c2_r1_rbl u_t031_029/c3_w0_bl u_t031_029/c3_w0_br
+ u_t031_029/c3_w1_bl u_t031_029/c3_w1_br u_t031_029/c3_r0_rbl u_t031_029/c3_r1_rbl
+ u_t031_029/r0_w0_wl u_t031_029/r0_w1_wl u_t031_029/r0_r0_rwl u_t031_029/r0_r1_rwl
+ u_t031_029/r1_w0_wl u_t031_029/r1_w1_wl u_t031_029/r1_r0_rwl u_t031_029/r1_r1_rwl
+ u_t031_029/r2_w0_wl u_t031_029/r2_w1_wl u_t031_029/r2_r0_rwl u_t031_029/r2_r1_rwl
+ u_t031_029/r3_w0_wl u_t031_029/r3_w1_wl u_t031_029/r3_r0_rwl u_t031_029/r3_r1_rwl
+ u_t031_029/VDD u_t031_031/VSS VSUBS detronyx_12t_2w2r_rc4_4x4_routed_5layer_direct
Xu_t031_018 u_t031_018/c0_w0_bl u_t031_018/c0_w0_br u_t031_018/c0_w1_bl u_t031_018/c0_w1_br
+ u_t031_018/c0_r0_rbl u_t031_018/c0_r1_rbl u_t031_018/c1_w0_bl u_t031_018/c1_w0_br
+ u_t031_018/c1_w1_bl u_t031_018/c1_w1_br u_t031_018/c1_r0_rbl u_t031_018/c1_r1_rbl
+ u_t031_018/c2_w0_bl u_t031_018/c2_w0_br u_t031_018/c2_w1_bl u_t031_018/c2_w1_br
+ u_t031_018/c2_r0_rbl u_t031_018/c2_r1_rbl u_t031_018/c3_w0_bl u_t031_018/c3_w0_br
+ u_t031_018/c3_w1_bl u_t031_018/c3_w1_br u_t031_018/c3_r0_rbl u_t031_018/c3_r1_rbl
+ u_t031_018/r0_w0_wl u_t031_018/r0_w1_wl u_t031_018/r0_r0_rwl u_t031_018/r0_r1_rwl
+ u_t031_018/r1_w0_wl u_t031_018/r1_w1_wl u_t031_018/r1_r0_rwl u_t031_018/r1_r1_rwl
+ u_t031_018/r2_w0_wl u_t031_018/r2_w1_wl u_t031_018/r2_r0_rwl u_t031_018/r2_r1_rwl
+ u_t031_018/r3_w0_wl u_t031_018/r3_w1_wl u_t031_018/r3_r0_rwl u_t031_018/r3_r1_rwl
+ u_t031_018/VDD u_t031_018/VSS VSUBS detronyx_12t_2w2r_rc4_4x4_routed_5layer_direct
Xu_t031_007 u_t031_007/c0_w0_bl u_t031_007/c0_w0_br u_t031_007/c0_w1_bl u_t031_007/c0_w1_br
+ u_t031_007/c0_r0_rbl u_t031_007/c0_r1_rbl u_t031_007/c1_w0_bl u_t031_007/c1_w0_br
+ u_t031_007/c1_w1_bl u_t031_007/c1_w1_br u_t031_007/c1_r0_rbl u_t031_007/c1_r1_rbl
+ u_t031_007/c2_w0_bl u_t031_007/c2_w0_br u_t031_007/c2_w1_bl u_t031_007/c2_w1_br
+ u_t031_007/c2_r0_rbl u_t031_007/c2_r1_rbl u_t031_007/c3_w0_bl u_t031_007/c3_w0_br
+ u_t031_007/c3_w1_bl u_t031_007/c3_w1_br u_t031_007/c3_r0_rbl u_t031_007/c3_r1_rbl
+ u_t031_007/r0_w0_wl u_t031_007/r0_w1_wl u_t031_007/r0_r0_rwl u_t031_007/r0_r1_rwl
+ u_t031_007/r1_w0_wl u_t031_007/r1_w1_wl u_t031_007/r1_r0_rwl u_t031_007/r1_r1_rwl
+ u_t031_007/r2_w0_wl u_t031_007/r2_w1_wl u_t031_007/r2_r0_rwl u_t031_007/r2_r1_rwl
+ u_t031_007/r3_w0_wl u_t031_007/r3_w1_wl u_t031_007/r3_r0_rwl u_t031_007/r3_r1_rwl
+ VSS u_t031_009/VSS VSUBS detronyx_12t_2w2r_rc4_4x4_routed_5layer_direct
Xgf180mcu_as_sc_mcu7t3v3__inv_2_1680 VSS gf180mcu_as_sc_mcu7t3v3__inv_2_1682/VSS VSS
+ gf180mcu_as_sc_mcu7t3v3__inv_2_1682/Y gf180mcu_as_sc_mcu7t3v3__inv_2_1682/VNW VSUBS
+ gf180mcu_as_sc_mcu7t3v3__inv_2
Xgf180mcu_as_sc_mcu7t3v3__inv_2_1691 gf180mcu_as_sc_mcu7t3v3__inv_2_1691/VDD VSS gf180mcu_as_sc_mcu7t3v3__inv_2_1691/Y
+ VSS gf180mcu_as_sc_mcu7t3v3__inv_2_1691/VNW VSUBS gf180mcu_as_sc_mcu7t3v3__inv_2
Xu_t022_029 u_t022_029/c0_w0_bl u_t022_029/c0_w0_br u_t022_029/c0_w1_bl u_t022_029/c0_w1_br
+ u_t022_029/c0_r0_rbl u_t022_029/c0_r1_rbl u_t022_029/c1_w0_bl u_t022_029/c1_w0_br
+ u_t022_029/c1_w1_bl u_t022_029/c1_w1_br u_t022_029/c1_r0_rbl u_t022_029/c1_r1_rbl
+ u_t022_029/c2_w0_bl u_t022_029/c2_w0_br u_t022_029/c2_w1_bl u_t022_029/c2_w1_br
+ u_t022_029/c2_r0_rbl u_t022_029/c2_r1_rbl u_t022_029/c3_w0_bl u_t022_029/c3_w0_br
+ u_t022_029/c3_w1_bl u_t022_029/c3_w1_br u_t022_029/c3_r0_rbl u_t022_029/c3_r1_rbl
+ u_t022_029/r0_w0_wl u_t022_029/r0_w1_wl u_t022_029/r0_r0_rwl u_t022_029/r0_r1_rwl
+ u_t022_029/r1_w0_wl u_t022_029/r1_w1_wl u_t022_029/r1_r0_rwl u_t022_029/r1_r1_rwl
+ u_t022_029/r2_w0_wl u_t022_029/r2_w1_wl u_t022_029/r2_r0_rwl u_t022_029/r2_r1_rwl
+ u_t022_029/r3_w0_wl u_t022_029/r3_w1_wl u_t022_029/r3_r0_rwl u_t022_029/r3_r1_rwl
+ u_t022_029/VDD u_t022_031/VSS VSUBS detronyx_12t_2w2r_rc4_4x4_routed_5layer_direct
Xu_t007_026 u_t007_026/c0_w0_bl u_t007_026/c0_w0_br u_t007_026/c0_w1_bl u_t007_026/c0_w1_br
+ u_t007_026/c0_r0_rbl u_t007_026/c0_r1_rbl u_t007_026/c1_w0_bl u_t007_026/c1_w0_br
+ u_t007_026/c1_w1_bl u_t007_026/c1_w1_br u_t007_026/c1_r0_rbl u_t007_026/c1_r1_rbl
+ u_t007_026/c2_w0_bl u_t007_026/c2_w0_br u_t007_026/c2_w1_bl u_t007_026/c2_w1_br
+ u_t007_026/c2_r0_rbl u_t007_026/c2_r1_rbl u_t007_026/c3_w0_bl u_t007_026/c3_w0_br
+ u_t007_026/c3_w1_bl u_t007_026/c3_w1_br u_t007_026/c3_r0_rbl u_t007_026/c3_r1_rbl
+ u_t007_026/r0_w0_wl u_t007_026/r0_w1_wl u_t007_026/r0_r0_rwl u_t007_026/r0_r1_rwl
+ u_t007_026/r1_w0_wl u_t007_026/r1_w1_wl u_t007_026/r1_r0_rwl u_t007_026/r1_r1_rwl
+ u_t007_026/r2_w0_wl u_t007_026/r2_w1_wl u_t007_026/r2_r0_rwl u_t007_026/r2_r1_rwl
+ u_t007_026/r3_w0_wl u_t007_026/r3_w1_wl u_t007_026/r3_r0_rwl u_t007_026/r3_r1_rwl
+ u_t008_026/VDD u_t007_026/VSS VSUBS detronyx_12t_2w2r_rc4_4x4_routed_5layer_direct
Xu_t022_018 u_t022_018/c0_w0_bl u_t022_018/c0_w0_br u_t022_018/c0_w1_bl u_t022_018/c0_w1_br
+ u_t022_018/c0_r0_rbl u_t022_018/c0_r1_rbl u_t022_018/c1_w0_bl u_t022_018/c1_w0_br
+ u_t022_018/c1_w1_bl u_t022_018/c1_w1_br u_t022_018/c1_r0_rbl u_t022_018/c1_r1_rbl
+ u_t022_018/c2_w0_bl u_t022_018/c2_w0_br u_t022_018/c2_w1_bl u_t022_018/c2_w1_br
+ u_t022_018/c2_r0_rbl u_t022_018/c2_r1_rbl u_t022_018/c3_w0_bl u_t022_018/c3_w0_br
+ u_t022_018/c3_w1_bl u_t022_018/c3_w1_br u_t022_018/c3_r0_rbl u_t022_018/c3_r1_rbl
+ u_t022_018/r0_w0_wl u_t022_018/r0_w1_wl u_t022_018/r0_r0_rwl u_t022_018/r0_r1_rwl
+ u_t022_018/r1_w0_wl u_t022_018/r1_w1_wl u_t022_018/r1_r0_rwl u_t022_018/r1_r1_rwl
+ u_t022_018/r2_w0_wl u_t022_018/r2_w1_wl u_t022_018/r2_r0_rwl u_t022_018/r2_r1_rwl
+ u_t022_018/r3_w0_wl u_t022_018/r3_w1_wl u_t022_018/r3_r0_rwl u_t022_018/r3_r1_rwl
+ u_t022_018/VDD u_t022_031/VSS VSUBS detronyx_12t_2w2r_rc4_4x4_routed_5layer_direct
Xu_t007_015 u_t007_015/c0_w0_bl u_t007_015/c0_w0_br u_t007_015/c0_w1_bl u_t007_015/c0_w1_br
+ u_t007_015/c0_r0_rbl u_t007_015/c0_r1_rbl u_t007_015/c1_w0_bl u_t007_015/c1_w0_br
+ u_t007_015/c1_w1_bl u_t007_015/c1_w1_br u_t007_015/c1_r0_rbl u_t007_015/c1_r1_rbl
+ u_t007_015/c2_w0_bl u_t007_015/c2_w0_br u_t007_015/c2_w1_bl u_t007_015/c2_w1_br
+ u_t007_015/c2_r0_rbl u_t007_015/c2_r1_rbl u_t007_015/c3_w0_bl u_t007_015/c3_w0_br
+ u_t007_015/c3_w1_bl u_t007_015/c3_w1_br u_t007_015/c3_r0_rbl u_t007_015/c3_r1_rbl
+ u_t007_015/r0_w0_wl u_t007_015/r0_w1_wl u_t007_015/r0_r0_rwl u_t007_015/r0_r1_rwl
+ u_t007_015/r1_w0_wl u_t007_015/r1_w1_wl u_t007_015/r1_r0_rwl u_t007_015/r1_r1_rwl
+ u_t007_015/r2_w0_wl u_t007_015/r2_w1_wl u_t007_015/r2_r0_rwl u_t007_015/r2_r1_rwl
+ u_t007_015/r3_w0_wl u_t007_015/r3_w1_wl u_t007_015/r3_r0_rwl u_t007_015/r3_r1_rwl
+ VSS u_t007_017/VSS VSUBS detronyx_12t_2w2r_rc4_4x4_routed_5layer_direct
Xu_t022_007 u_t022_007/c0_w0_bl u_t022_007/c0_w0_br u_t022_007/c0_w1_bl u_t022_007/c0_w1_br
+ u_t022_007/c0_r0_rbl u_t022_007/c0_r1_rbl u_t022_007/c1_w0_bl u_t022_007/c1_w0_br
+ u_t022_007/c1_w1_bl u_t022_007/c1_w1_br u_t022_007/c1_r0_rbl u_t022_007/c1_r1_rbl
+ u_t022_007/c2_w0_bl u_t022_007/c2_w0_br u_t022_007/c2_w1_bl u_t022_007/c2_w1_br
+ u_t022_007/c2_r0_rbl u_t022_007/c2_r1_rbl u_t022_007/c3_w0_bl u_t022_007/c3_w0_br
+ u_t022_007/c3_w1_bl u_t022_007/c3_w1_br u_t022_007/c3_r0_rbl u_t022_007/c3_r1_rbl
+ u_t022_007/r0_w0_wl u_t022_007/r0_w1_wl u_t022_007/r0_r0_rwl u_t022_007/r0_r1_rwl
+ u_t022_007/r1_w0_wl u_t022_007/r1_w1_wl u_t022_007/r1_r0_rwl u_t022_007/r1_r1_rwl
+ u_t022_007/r2_w0_wl u_t022_007/r2_w1_wl u_t022_007/r2_r0_rwl u_t022_007/r2_r1_rwl
+ u_t022_007/r3_w0_wl u_t022_007/r3_w1_wl u_t022_007/r3_r0_rwl u_t022_007/r3_r1_rwl
+ VSS u_t022_031/VSS VSUBS detronyx_12t_2w2r_rc4_4x4_routed_5layer_direct
Xu_t007_004 u_t007_004/c0_w0_bl u_t007_004/c0_w0_br u_t007_004/c0_w1_bl u_t007_004/c0_w1_br
+ u_t007_004/c0_r0_rbl u_t007_004/c0_r1_rbl u_t007_004/c1_w0_bl u_t007_004/c1_w0_br
+ u_t007_004/c1_w1_bl u_t007_004/c1_w1_br u_t007_004/c1_r0_rbl u_t007_004/c1_r1_rbl
+ u_t007_004/c2_w0_bl u_t007_004/c2_w0_br u_t007_004/c2_w1_bl u_t007_004/c2_w1_br
+ u_t007_004/c2_r0_rbl u_t007_004/c2_r1_rbl u_t007_004/c3_w0_bl u_t007_004/c3_w0_br
+ u_t007_004/c3_w1_bl u_t007_004/c3_w1_br u_t007_004/c3_r0_rbl u_t007_004/c3_r1_rbl
+ u_t007_004/r0_w0_wl u_t007_004/r0_w1_wl u_t007_004/r0_r0_rwl u_t007_004/r0_r1_rwl
+ u_t007_004/r1_w0_wl u_t007_004/r1_w1_wl u_t007_004/r1_r0_rwl u_t007_004/r1_r1_rwl
+ u_t007_004/r2_w0_wl u_t007_004/r2_w1_wl u_t007_004/r2_r0_rwl u_t007_004/r2_r1_rwl
+ u_t007_004/r3_w0_wl u_t007_004/r3_w1_wl u_t007_004/r3_r0_rwl u_t007_004/r3_r1_rwl
+ u_t008_004/VDD u_t007_004/VSS VSUBS detronyx_12t_2w2r_rc4_4x4_routed_5layer_direct
Xgf180mcu_as_sc_mcu7t3v3__nand4_2_496 gf180mcu_as_sc_mcu7t3v3__inv_2_1669/VDD VSS
+ VSS VSS VSS VSS VSS gf180mcu_as_sc_mcu7t3v3__inv_2_1669/VNW VSUBS gf180mcu_as_sc_mcu7t3v3__nand4_2
Xgf180mcu_as_sc_mcu7t3v3__nand4_2_463 VSS gf180mcu_as_sc_mcu7t3v3__inv_2_1586/VSS
+ VSS VSS VSS VSS gf180mcu_as_sc_mcu7t3v3__nand4_2_463/Y gf180mcu_as_sc_mcu7t3v3__inv_2_1586/VNW
+ VSUBS gf180mcu_as_sc_mcu7t3v3__nand4_2
Xgf180mcu_as_sc_mcu7t3v3__nand4_2_485 gf180mcu_as_sc_mcu7t3v3__inv_2_1682/VSS gf180mcu_as_sc_mcu7t3v3__inv_2_1665/VDD
+ VSS VSS VSS VSS VSS gf180mcu_as_sc_mcu7t3v3__inv_2_1664/VNW VSUBS gf180mcu_as_sc_mcu7t3v3__nand4_2
Xgf180mcu_as_sc_mcu7t3v3__nand4_2_452 VSS gf180mcu_as_sc_mcu7t3v3__inv_2_1535/VDD
+ VSS VSS VSS VSS VSS gf180mcu_as_sc_mcu7t3v3__inv_2_1518/VNW VSUBS gf180mcu_as_sc_mcu7t3v3__nand4_2
Xgf180mcu_as_sc_mcu7t3v3__nand4_2_474 VSS VSS VSS VSS VSS VSS VSS gf180mcu_as_sc_mcu7t3v3__inv_2_1528/VNW
+ VSUBS gf180mcu_as_sc_mcu7t3v3__nand4_2
Xgf180mcu_as_sc_mcu7t3v3__nand4_2_430 VSS gf180mcu_as_sc_mcu7t3v3__inv_2_1433/VSS
+ VSS VSS VSS VSS gf180mcu_as_sc_mcu7t3v3__nand4_2_430/Y gf180mcu_as_sc_mcu7t3v3__inv_2_1433/VNW
+ VSUBS gf180mcu_as_sc_mcu7t3v3__nand4_2
Xgf180mcu_as_sc_mcu7t3v3__nand4_2_441 gf180mcu_as_sc_mcu7t3v3__inv_2_1457/VDD VSS
+ VSS VSS VSS VSS VSS gf180mcu_as_sc_mcu7t3v3__inv_2_1457/VNW VSUBS gf180mcu_as_sc_mcu7t3v3__nand4_2
Xu_t013_029 u_t013_029/c0_w0_bl u_t013_029/c0_w0_br u_t013_029/c0_w1_bl u_t013_029/c0_w1_br
+ u_t013_029/c0_r0_rbl u_t013_029/c0_r1_rbl u_t013_029/c1_w0_bl u_t013_029/c1_w0_br
+ u_t013_029/c1_w1_bl u_t013_029/c1_w1_br u_t013_029/c1_r0_rbl u_t013_029/c1_r1_rbl
+ u_t013_029/c2_w0_bl u_t013_029/c2_w0_br u_t013_029/c2_w1_bl u_t013_029/c2_w1_br
+ u_t013_029/c2_r0_rbl u_t013_029/c2_r1_rbl u_t013_029/c3_w0_bl u_t013_029/c3_w0_br
+ u_t013_029/c3_w1_bl u_t013_029/c3_w1_br u_t013_029/c3_r0_rbl u_t013_029/c3_r1_rbl
+ u_t013_029/r0_w0_wl u_t013_029/r0_w1_wl u_t013_029/r0_r0_rwl u_t013_029/r0_r1_rwl
+ u_t013_029/r1_w0_wl u_t013_029/r1_w1_wl u_t013_029/r1_r0_rwl u_t013_029/r1_r1_rwl
+ u_t013_029/r2_w0_wl u_t013_029/r2_w1_wl u_t013_029/r2_r0_rwl u_t013_029/r2_r1_rwl
+ u_t013_029/r3_w0_wl u_t013_029/r3_w1_wl u_t013_029/r3_r0_rwl u_t013_029/r3_r1_rwl
+ u_t013_029/VDD u_t013_031/VSS VSUBS detronyx_12t_2w2r_rc4_4x4_routed_5layer_direct
Xu_t013_018 u_t013_018/c0_w0_bl u_t013_018/c0_w0_br u_t013_018/c0_w1_bl u_t013_018/c0_w1_br
+ u_t013_018/c0_r0_rbl u_t013_018/c0_r1_rbl u_t013_018/c1_w0_bl u_t013_018/c1_w0_br
+ u_t013_018/c1_w1_bl u_t013_018/c1_w1_br u_t013_018/c1_r0_rbl u_t013_018/c1_r1_rbl
+ u_t013_018/c2_w0_bl u_t013_018/c2_w0_br u_t013_018/c2_w1_bl u_t013_018/c2_w1_br
+ u_t013_018/c2_r0_rbl u_t013_018/c2_r1_rbl u_t013_018/c3_w0_bl u_t013_018/c3_w0_br
+ u_t013_018/c3_w1_bl u_t013_018/c3_w1_br u_t013_018/c3_r0_rbl u_t013_018/c3_r1_rbl
+ u_t013_018/r0_w0_wl u_t013_018/r0_w1_wl u_t013_018/r0_r0_rwl u_t013_018/r0_r1_rwl
+ u_t013_018/r1_w0_wl u_t013_018/r1_w1_wl u_t013_018/r1_r0_rwl u_t013_018/r1_r1_rwl
+ u_t013_018/r2_w0_wl u_t013_018/r2_w1_wl u_t013_018/r2_r0_rwl u_t013_018/r2_r1_rwl
+ u_t013_018/r3_w0_wl u_t013_018/r3_w1_wl u_t013_018/r3_r0_rwl u_t013_018/r3_r1_rwl
+ u_t013_018/VDD u_t013_031/VSS VSUBS detronyx_12t_2w2r_rc4_4x4_routed_5layer_direct
Xu_t013_007 u_t013_007/c0_w0_bl u_t013_007/c0_w0_br u_t013_007/c0_w1_bl u_t013_007/c0_w1_br
+ u_t013_007/c0_r0_rbl u_t013_007/c0_r1_rbl u_t013_007/c1_w0_bl u_t013_007/c1_w0_br
+ u_t013_007/c1_w1_bl u_t013_007/c1_w1_br u_t013_007/c1_r0_rbl u_t013_007/c1_r1_rbl
+ u_t013_007/c2_w0_bl u_t013_007/c2_w0_br u_t013_007/c2_w1_bl u_t013_007/c2_w1_br
+ u_t013_007/c2_r0_rbl u_t013_007/c2_r1_rbl u_t013_007/c3_w0_bl u_t013_007/c3_w0_br
+ u_t013_007/c3_w1_bl u_t013_007/c3_w1_br u_t013_007/c3_r0_rbl u_t013_007/c3_r1_rbl
+ u_t013_007/r0_w0_wl u_t013_007/r0_w1_wl u_t013_007/r0_r0_rwl u_t013_007/r0_r1_rwl
+ u_t013_007/r1_w0_wl u_t013_007/r1_w1_wl u_t013_007/r1_r0_rwl u_t013_007/r1_r1_rwl
+ u_t013_007/r2_w0_wl u_t013_007/r2_w1_wl u_t013_007/r2_r0_rwl u_t013_007/r2_r1_rwl
+ u_t013_007/r3_w0_wl u_t013_007/r3_w1_wl u_t013_007/r3_r0_rwl u_t013_007/r3_r1_rwl
+ VSS u_t013_031/VSS VSUBS detronyx_12t_2w2r_rc4_4x4_routed_5layer_direct
Xu_t004_029 u_t004_029/c0_w0_bl u_t004_029/c0_w0_br u_t004_029/c0_w1_bl u_t004_029/c0_w1_br
+ u_t004_029/c0_r0_rbl u_t004_029/c0_r1_rbl u_t004_029/c1_w0_bl u_t004_029/c1_w0_br
+ u_t004_029/c1_w1_bl u_t004_029/c1_w1_br u_t004_029/c1_r0_rbl u_t004_029/c1_r1_rbl
+ u_t004_029/c2_w0_bl u_t004_029/c2_w0_br u_t004_029/c2_w1_bl u_t004_029/c2_w1_br
+ u_t004_029/c2_r0_rbl u_t004_029/c2_r1_rbl u_t004_029/c3_w0_bl u_t004_029/c3_w0_br
+ u_t004_029/c3_w1_bl u_t004_029/c3_w1_br u_t004_029/c3_r0_rbl u_t004_029/c3_r1_rbl
+ u_t004_029/r0_w0_wl u_t004_029/r0_w1_wl u_t004_029/r0_r0_rwl u_t004_029/r0_r1_rwl
+ u_t004_029/r1_w0_wl u_t004_029/r1_w1_wl u_t004_029/r1_r0_rwl u_t004_029/r1_r1_rwl
+ u_t004_029/r2_w0_wl u_t004_029/r2_w1_wl u_t004_029/r2_r0_rwl u_t004_029/r2_r1_rwl
+ u_t004_029/r3_w0_wl u_t004_029/r3_w1_wl u_t004_029/r3_r0_rwl u_t004_029/r3_r1_rwl
+ u_t004_029/VDD u_t004_031/VSS VSUBS detronyx_12t_2w2r_rc4_4x4_routed_5layer_direct
Xu_t004_018 u_t004_018/c0_w0_bl u_t004_018/c0_w0_br u_t004_018/c0_w1_bl u_t004_018/c0_w1_br
+ u_t004_018/c0_r0_rbl u_t004_018/c0_r1_rbl u_t004_018/c1_w0_bl u_t004_018/c1_w0_br
+ u_t004_018/c1_w1_bl u_t004_018/c1_w1_br u_t004_018/c1_r0_rbl u_t004_018/c1_r1_rbl
+ u_t004_018/c2_w0_bl u_t004_018/c2_w0_br u_t004_018/c2_w1_bl u_t004_018/c2_w1_br
+ u_t004_018/c2_r0_rbl u_t004_018/c2_r1_rbl u_t004_018/c3_w0_bl u_t004_018/c3_w0_br
+ u_t004_018/c3_w1_bl u_t004_018/c3_w1_br u_t004_018/c3_r0_rbl u_t004_018/c3_r1_rbl
+ u_t004_018/r0_w0_wl u_t004_018/r0_w1_wl u_t004_018/r0_r0_rwl u_t004_018/r0_r1_rwl
+ u_t004_018/r1_w0_wl u_t004_018/r1_w1_wl u_t004_018/r1_r0_rwl u_t004_018/r1_r1_rwl
+ u_t004_018/r2_w0_wl u_t004_018/r2_w1_wl u_t004_018/r2_r0_rwl u_t004_018/r2_r1_rwl
+ u_t004_018/r3_w0_wl u_t004_018/r3_w1_wl u_t004_018/r3_r0_rwl u_t004_018/r3_r1_rwl
+ u_t004_018/VDD u_t004_031/VSS VSUBS detronyx_12t_2w2r_rc4_4x4_routed_5layer_direct
Xu_t004_007 u_t004_007/c0_w0_bl u_t004_007/c0_w0_br u_t004_007/c0_w1_bl u_t004_007/c0_w1_br
+ u_t004_007/c0_r0_rbl u_t004_007/c0_r1_rbl u_t004_007/c1_w0_bl u_t004_007/c1_w0_br
+ u_t004_007/c1_w1_bl u_t004_007/c1_w1_br u_t004_007/c1_r0_rbl u_t004_007/c1_r1_rbl
+ u_t004_007/c2_w0_bl u_t004_007/c2_w0_br u_t004_007/c2_w1_bl u_t004_007/c2_w1_br
+ u_t004_007/c2_r0_rbl u_t004_007/c2_r1_rbl u_t004_007/c3_w0_bl u_t004_007/c3_w0_br
+ u_t004_007/c3_w1_bl u_t004_007/c3_w1_br u_t004_007/c3_r0_rbl u_t004_007/c3_r1_rbl
+ u_t004_007/r0_w0_wl u_t004_007/r0_w1_wl u_t004_007/r0_r0_rwl u_t004_007/r0_r1_rwl
+ u_t004_007/r1_w0_wl u_t004_007/r1_w1_wl u_t004_007/r1_r0_rwl u_t004_007/r1_r1_rwl
+ u_t004_007/r2_w0_wl u_t004_007/r2_w1_wl u_t004_007/r2_r0_rwl u_t004_007/r2_r1_rwl
+ u_t004_007/r3_w0_wl u_t004_007/r3_w1_wl u_t004_007/r3_r0_rwl u_t004_007/r3_r1_rwl
+ VSS u_t004_031/VSS VSUBS detronyx_12t_2w2r_rc4_4x4_routed_5layer_direct
Xgf180mcu_as_sc_mcu7t3v3__inv_2_449 VSS VSS gf180mcu_as_sc_mcu7t3v3__inv_2_449/Y VSS
+ gf180mcu_as_sc_mcu7t3v3__inv_2_451/VNW VSUBS gf180mcu_as_sc_mcu7t3v3__inv_2
Xgf180mcu_as_sc_mcu7t3v3__inv_2_438 gf180mcu_as_sc_mcu7t3v3__nor2_2_5/VDD gf180mcu_as_sc_mcu7t3v3__nor2_2_5/VSS
+ VSS VSS gf180mcu_as_sc_mcu7t3v3__nor2_2_5/VNW VSUBS gf180mcu_as_sc_mcu7t3v3__inv_2
Xgf180mcu_as_sc_mcu7t3v3__inv_2_416 gf180mcu_as_sc_mcu7t3v3__nor2_2_5/VDD gf180mcu_as_sc_mcu7t3v3__nand3_2_8/VSS
+ VSS VSS gf180mcu_as_sc_mcu7t3v3__nor2_2_5/VNW VSUBS gf180mcu_as_sc_mcu7t3v3__inv_2
Xgf180mcu_as_sc_mcu7t3v3__inv_2_427 gf180mcu_as_sc_mcu7t3v3__nor2_2_5/VDD gf180mcu_as_sc_mcu7t3v3__nand3_2_8/VSS
+ VSS VSS gf180mcu_as_sc_mcu7t3v3__nor2_2_5/VNW VSUBS gf180mcu_as_sc_mcu7t3v3__inv_2
Xgf180mcu_as_sc_mcu7t3v3__inv_2_405 gf180mcu_as_sc_mcu7t3v3__nor2_2_6/VDD gf180mcu_as_sc_mcu7t3v3__nor2_2_6/VSS
+ VSS VSS gf180mcu_as_sc_mcu7t3v3__nor2_2_6/VNW VSUBS gf180mcu_as_sc_mcu7t3v3__inv_2
Xgf180mcu_as_sc_mcu7t3v3__inv_2_950 VSS VSS VSS VSS gf180mcu_as_sc_mcu7t3v3__inv_2_951/VNW
+ VSUBS gf180mcu_as_sc_mcu7t3v3__inv_2
Xgf180mcu_as_sc_mcu7t3v3__inv_2_972 VSS gf180mcu_as_sc_mcu7t3v3__inv_2_978/VDD VSS
+ gf180mcu_as_sc_mcu7t3v3__inv_2_991/A gf180mcu_as_sc_mcu7t3v3__inv_2_974/VNW VSUBS
+ gf180mcu_as_sc_mcu7t3v3__inv_2
Xgf180mcu_as_sc_mcu7t3v3__inv_2_961 VSS gf180mcu_as_sc_mcu7t3v3__inv_2_966/VDD gf180mcu_as_sc_mcu7t3v3__inv_2_991/A
+ gf180mcu_as_sc_mcu7t3v3__inv_2_962/Y gf180mcu_as_sc_mcu7t3v3__inv_2_962/VNW VSUBS
+ gf180mcu_as_sc_mcu7t3v3__inv_2
Xgf180mcu_as_sc_mcu7t3v3__inv_2_983 VSS VSS gf180mcu_as_sc_mcu7t3v3__inv_2_983/Y VSS
+ gf180mcu_as_sc_mcu7t3v3__inv_2_983/VNW VSUBS gf180mcu_as_sc_mcu7t3v3__inv_2
Xgf180mcu_as_sc_mcu7t3v3__inv_2_994 gf180mcu_as_sc_mcu7t3v3__inv_2_994/VDD VSS gf180mcu_as_sc_mcu7t3v3__inv_2_994/Y
+ VSS gf180mcu_as_sc_mcu7t3v3__inv_2_994/VNW VSUBS gf180mcu_as_sc_mcu7t3v3__inv_2
Xgf180mcu_as_sc_mcu7t3v3__nand4_2_271 VSS VSS VSS VSS VSS VSS VSS gf180mcu_as_sc_mcu7t3v3__inv_2_936/VNW
+ VSUBS gf180mcu_as_sc_mcu7t3v3__nand4_2
Xgf180mcu_as_sc_mcu7t3v3__nand4_2_260 VSS VSS VSS VSS VSS VSS gf180mcu_as_sc_mcu7t3v3__nand4_2_260/Y
+ gf180mcu_as_sc_mcu7t3v3__inv_2_892/VNW VSUBS gf180mcu_as_sc_mcu7t3v3__nand4_2
Xgf180mcu_as_sc_mcu7t3v3__nand4_2_293 VSS gf180mcu_as_sc_mcu7t3v3__inv_2_990/VSS VSS
+ VSS VSS VSS VSS gf180mcu_as_sc_mcu7t3v3__inv_2_990/VNW VSUBS gf180mcu_as_sc_mcu7t3v3__nand4_2
Xgf180mcu_as_sc_mcu7t3v3__nand4_2_282 VSS VSS VSS VSS VSS VSS VSS gf180mcu_as_sc_mcu7t3v3__inv_2_914/VNW
+ VSUBS gf180mcu_as_sc_mcu7t3v3__nand4_2
Xgf180mcu_as_sc_mcu7t3v3__inv_2_202 VSS gf180mcu_as_sc_mcu7t3v3__inv_2_206/VDD VSS
+ VSS gf180mcu_as_sc_mcu7t3v3__inv_2_204/VNW VSUBS gf180mcu_as_sc_mcu7t3v3__inv_2
Xgf180mcu_as_sc_mcu7t3v3__inv_2_268 VSS VSS gf180mcu_as_sc_mcu7t3v3__inv_2_66/Y gf180mcu_as_sc_mcu7t3v3__inv_2_66/Y
+ gf180mcu_as_sc_mcu7t3v3__inv_2_365/VNW VSUBS gf180mcu_as_sc_mcu7t3v3__inv_2
Xgf180mcu_as_sc_mcu7t3v3__inv_2_279 gf180mcu_as_sc_mcu7t3v3__inv_2_359/VDD gf180mcu_as_sc_mcu7t3v3__inv_2_360/VDD
+ VSS gf180mcu_as_sc_mcu7t3v3__inv_2_361/Y gf180mcu_as_sc_mcu7t3v3__inv_2_359/VNW
+ VSUBS gf180mcu_as_sc_mcu7t3v3__inv_2
Xgf180mcu_as_sc_mcu7t3v3__inv_2_224 VSS VSS VSS VSS gf180mcu_as_sc_mcu7t3v3__inv_2_224/VNW
+ VSUBS gf180mcu_as_sc_mcu7t3v3__inv_2
Xgf180mcu_as_sc_mcu7t3v3__inv_2_257 gf180mcu_as_sc_mcu7t3v3__inv_2_257/VDD gf180mcu_as_sc_mcu7t3v3__inv_2_257/VSS
+ VSS VSS gf180mcu_as_sc_mcu7t3v3__inv_2_257/VNW VSUBS gf180mcu_as_sc_mcu7t3v3__inv_2
Xgf180mcu_as_sc_mcu7t3v3__inv_2_246 gf180mcu_as_sc_mcu7t3v3__inv_2_257/VSS VSS gf180mcu_as_sc_mcu7t3v3__inv_2_246/Y
+ VSS gf180mcu_as_sc_mcu7t3v3__inv_2_246/VNW VSUBS gf180mcu_as_sc_mcu7t3v3__inv_2
Xgf180mcu_as_sc_mcu7t3v3__inv_2_235 VSS gf180mcu_as_sc_mcu7t3v3__inv_2_241/VDD VSS
+ VSS gf180mcu_as_sc_mcu7t3v3__inv_2_237/VNW VSUBS gf180mcu_as_sc_mcu7t3v3__inv_2
Xgf180mcu_as_sc_mcu7t3v3__inv_2_213 VSS gf180mcu_as_sc_mcu7t3v3__inv_2_229/VDD gf180mcu_as_sc_mcu7t3v3__inv_2_213/Y
+ VSS gf180mcu_as_sc_mcu7t3v3__inv_2_213/VNW VSUBS gf180mcu_as_sc_mcu7t3v3__inv_2
Xu_t000_021 u_t000_021/c0_w0_bl u_t000_021/c0_w0_br u_t000_021/c0_w1_bl u_t000_021/c0_w1_br
+ u_t000_021/c0_r0_rbl u_t000_021/c0_r1_rbl u_t000_021/c1_w0_bl u_t000_021/c1_w0_br
+ u_t000_021/c1_w1_bl u_t000_021/c1_w1_br u_t000_021/c1_r0_rbl u_t000_021/c1_r1_rbl
+ u_t000_021/c2_w0_bl u_t000_021/c2_w0_br u_t000_021/c2_w1_bl u_t000_021/c2_w1_br
+ u_t000_021/c2_r0_rbl u_t000_021/c2_r1_rbl u_t000_021/c3_w0_bl u_t000_021/c3_w0_br
+ u_t000_021/c3_w1_bl u_t000_021/c3_w1_br u_t000_021/c3_r0_rbl u_t000_021/c3_r1_rbl
+ u_t000_021/r0_w0_wl u_t000_021/r0_w1_wl u_t000_021/r0_r0_rwl u_t000_021/r0_r1_rwl
+ u_t000_021/r1_w0_wl u_t000_021/r1_w1_wl u_t000_021/r1_r0_rwl u_t000_021/r1_r1_rwl
+ u_t000_021/r2_w0_wl u_t000_021/r2_w1_wl u_t000_021/r2_r0_rwl u_t000_021/r2_r1_rwl
+ u_t000_021/r3_w0_wl u_t000_021/r3_w1_wl u_t000_021/r3_r0_rwl u_t000_021/r3_r1_rwl
+ u_t000_021/VDD u_t000_031/VSS VSUBS detronyx_12t_2w2r_rc4_4x4_routed_5layer_direct
Xu_t000_010 u_t000_010/c0_w0_bl u_t000_010/c0_w0_br u_t000_010/c0_w1_bl u_t000_010/c0_w1_br
+ u_t000_010/c0_r0_rbl u_t000_010/c0_r1_rbl u_t000_010/c1_w0_bl u_t000_010/c1_w0_br
+ u_t000_010/c1_w1_bl u_t000_010/c1_w1_br u_t000_010/c1_r0_rbl u_t000_010/c1_r1_rbl
+ u_t000_010/c2_w0_bl u_t000_010/c2_w0_br u_t000_010/c2_w1_bl u_t000_010/c2_w1_br
+ u_t000_010/c2_r0_rbl u_t000_010/c2_r1_rbl u_t000_010/c3_w0_bl u_t000_010/c3_w0_br
+ u_t000_010/c3_w1_bl u_t000_010/c3_w1_br u_t000_010/c3_r0_rbl u_t000_010/c3_r1_rbl
+ u_t000_010/r0_w0_wl u_t000_010/r0_w1_wl u_t000_010/r0_r0_rwl u_t000_010/r0_r1_rwl
+ u_t000_010/r1_w0_wl u_t000_010/r1_w1_wl u_t000_010/r1_r0_rwl u_t000_010/r1_r1_rwl
+ u_t000_010/r2_w0_wl u_t000_010/r2_w1_wl u_t000_010/r2_r0_rwl u_t000_010/r2_r1_rwl
+ u_t000_010/r3_w0_wl u_t000_010/r3_w1_wl u_t000_010/r3_r0_rwl u_t000_010/r3_r1_rwl
+ VSS u_t000_031/VSS VSUBS detronyx_12t_2w2r_rc4_4x4_routed_5layer_direct
Xgf180mcu_as_sc_mcu7t3v3__inv_2_791 VSS VSS VSS VSS gf180mcu_as_sc_mcu7t3v3__inv_2_792/VNW
+ VSUBS gf180mcu_as_sc_mcu7t3v3__inv_2
Xgf180mcu_as_sc_mcu7t3v3__inv_2_780 VSS VSS VSS VSS gf180mcu_as_sc_mcu7t3v3__inv_2_780/VNW
+ VSUBS gf180mcu_as_sc_mcu7t3v3__inv_2
Xgf180mcu_as_sc_mcu7t3v3__inv_2_1509 gf180mcu_as_sc_mcu7t3v3__inv_2_1552/VSS gf180mcu_as_sc_mcu7t3v3__inv_2_1514/VDD
+ gf180mcu_as_sc_mcu7t3v3__inv_2_1509/Y VSS gf180mcu_as_sc_mcu7t3v3__inv_2_1510/VNW
+ VSUBS gf180mcu_as_sc_mcu7t3v3__inv_2
Xgf180mcu_as_sc_mcu7t3v3__nor2_2_3 gf180mcu_as_sc_mcu7t3v3__nor2_2_4/VDD gf180mcu_as_sc_mcu7t3v3__nor2_2_4/VSS
+ VSS VSS VSS gf180mcu_as_sc_mcu7t3v3__nor2_2_4/VNW VSUBS gf180mcu_as_sc_mcu7t3v3__nor2_2
Xgf180mcu_as_sc_mcu7t3v3__nand2_2_8 gf180mcu_as_sc_mcu7t3v3__nor2_2_6/VDD gf180mcu_as_sc_mcu7t3v3__nor2_2_6/VSS
+ VSS VSS VSS gf180mcu_as_sc_mcu7t3v3__nor2_2_6/VNW VSUBS gf180mcu_as_sc_mcu7t3v3__nand2_2
Xgf180mcu_as_sc_mcu7t3v3__inv_2_1339 gf180mcu_as_sc_mcu7t3v3__inv_2_1400/VDD gf180mcu_as_sc_mcu7t3v3__inv_2_1400/VSS
+ VSS gf180mcu_as_sc_mcu7t3v3__inv_2_1685/Y gf180mcu_as_sc_mcu7t3v3__inv_2_1400/VNW
+ VSUBS gf180mcu_as_sc_mcu7t3v3__inv_2
Xgf180mcu_as_sc_mcu7t3v3__inv_2_1306 VSS gf180mcu_as_sc_mcu7t3v3__inv_2_1378/VDD VSS
+ gf180mcu_as_sc_mcu7t3v3__inv_2_1379/Y gf180mcu_as_sc_mcu7t3v3__inv_2_1377/VNW VSUBS
+ gf180mcu_as_sc_mcu7t3v3__inv_2
Xgf180mcu_as_sc_mcu7t3v3__inv_2_1328 gf180mcu_as_sc_mcu7t3v3__inv_2_1372/VDD gf180mcu_as_sc_mcu7t3v3__inv_2_1373/VDD
+ VSS gf180mcu_as_sc_mcu7t3v3__inv_2_1379/Y gf180mcu_as_sc_mcu7t3v3__inv_2_1372/VNW
+ VSUBS gf180mcu_as_sc_mcu7t3v3__inv_2
Xgf180mcu_as_sc_mcu7t3v3__inv_2_1317 gf180mcu_as_sc_mcu7t3v3__inv_2_1369/VDD VSS gf180mcu_as_sc_mcu7t3v3__inv_2_1317/Y
+ gf180mcu_as_sc_mcu7t3v3__inv_2_1369/Y gf180mcu_as_sc_mcu7t3v3__inv_2_1369/VNW VSUBS
+ gf180mcu_as_sc_mcu7t3v3__inv_2
Xu_t028_024 u_t028_024/c0_w0_bl u_t028_024/c0_w0_br u_t028_024/c0_w1_bl u_t028_024/c0_w1_br
+ u_t028_024/c0_r0_rbl u_t028_024/c0_r1_rbl u_t028_024/c1_w0_bl u_t028_024/c1_w0_br
+ u_t028_024/c1_w1_bl u_t028_024/c1_w1_br u_t028_024/c1_r0_rbl u_t028_024/c1_r1_rbl
+ u_t028_024/c2_w0_bl u_t028_024/c2_w0_br u_t028_024/c2_w1_bl u_t028_024/c2_w1_br
+ u_t028_024/c2_r0_rbl u_t028_024/c2_r1_rbl u_t028_024/c3_w0_bl u_t028_024/c3_w0_br
+ u_t028_024/c3_w1_bl u_t028_024/c3_w1_br u_t028_024/c3_r0_rbl u_t028_024/c3_r1_rbl
+ u_t028_024/r0_w0_wl u_t028_024/r0_w1_wl u_t028_024/r0_r0_rwl u_t028_024/r0_r1_rwl
+ u_t028_024/r1_w0_wl u_t028_024/r1_w1_wl u_t028_024/r1_r0_rwl u_t028_024/r1_r1_rwl
+ u_t028_024/r2_w0_wl u_t028_024/r2_w1_wl u_t028_024/r2_r0_rwl u_t028_024/r2_r1_rwl
+ u_t028_024/r3_w0_wl u_t028_024/r3_w1_wl u_t028_024/r3_r0_rwl u_t028_024/r3_r1_rwl
+ VSS u_t028_024/VSS VSUBS detronyx_12t_2w2r_rc4_4x4_routed_5layer_direct
Xu_t028_013 u_t028_013/c0_w0_bl u_t028_013/c0_w0_br u_t028_013/c0_w1_bl u_t028_013/c0_w1_br
+ u_t028_013/c0_r0_rbl u_t028_013/c0_r1_rbl u_t028_013/c1_w0_bl u_t028_013/c1_w0_br
+ u_t028_013/c1_w1_bl u_t028_013/c1_w1_br u_t028_013/c1_r0_rbl u_t028_013/c1_r1_rbl
+ u_t028_013/c2_w0_bl u_t028_013/c2_w0_br u_t028_013/c2_w1_bl u_t028_013/c2_w1_br
+ u_t028_013/c2_r0_rbl u_t028_013/c2_r1_rbl u_t028_013/c3_w0_bl u_t028_013/c3_w0_br
+ u_t028_013/c3_w1_bl u_t028_013/c3_w1_br u_t028_013/c3_r0_rbl u_t028_013/c3_r1_rbl
+ u_t028_013/r0_w0_wl u_t028_013/r0_w1_wl u_t028_013/r0_r0_rwl u_t028_013/r0_r1_rwl
+ u_t028_013/r1_w0_wl u_t028_013/r1_w1_wl u_t028_013/r1_r0_rwl u_t028_013/r1_r1_rwl
+ u_t028_013/r2_w0_wl u_t028_013/r2_w1_wl u_t028_013/r2_r0_rwl u_t028_013/r2_r1_rwl
+ u_t028_013/r3_w0_wl u_t028_013/r3_w1_wl u_t028_013/r3_r0_rwl u_t028_013/r3_r1_rwl
+ u_t029_013/VDD u_t028_013/VSS VSUBS detronyx_12t_2w2r_rc4_4x4_routed_5layer_direct
Xu_t028_002 u_t028_002/c0_w0_bl u_t028_002/c0_w0_br u_t028_002/c0_w1_bl u_t028_002/c0_w1_br
+ u_t028_002/c0_r0_rbl u_t028_002/c0_r1_rbl u_t028_002/c1_w0_bl u_t028_002/c1_w0_br
+ u_t028_002/c1_w1_bl u_t028_002/c1_w1_br u_t028_002/c1_r0_rbl u_t028_002/c1_r1_rbl
+ u_t028_002/c2_w0_bl u_t028_002/c2_w0_br u_t028_002/c2_w1_bl u_t028_002/c2_w1_br
+ u_t028_002/c2_r0_rbl u_t028_002/c2_r1_rbl u_t028_002/c3_w0_bl u_t028_002/c3_w0_br
+ u_t028_002/c3_w1_bl u_t028_002/c3_w1_br u_t028_002/c3_r0_rbl u_t028_002/c3_r1_rbl
+ u_t028_002/r0_w0_wl u_t028_002/r0_w1_wl u_t028_002/r0_r0_rwl u_t028_002/r0_r1_rwl
+ u_t028_002/r1_w0_wl u_t028_002/r1_w1_wl u_t028_002/r1_r0_rwl u_t028_002/r1_r1_rwl
+ u_t028_002/r2_w0_wl u_t028_002/r2_w1_wl u_t028_002/r2_r0_rwl u_t028_002/r2_r1_rwl
+ u_t028_002/r3_w0_wl u_t028_002/r3_w1_wl u_t028_002/r3_r0_rwl u_t028_002/r3_r1_rwl
+ VSS u_t028_002/VSS VSUBS detronyx_12t_2w2r_rc4_4x4_routed_5layer_direct
Xu_t019_024 u_t019_024/c0_w0_bl u_t019_024/c0_w0_br u_t019_024/c0_w1_bl u_t019_024/c0_w1_br
+ u_t019_024/c0_r0_rbl u_t019_024/c0_r1_rbl u_t019_024/c1_w0_bl u_t019_024/c1_w0_br
+ u_t019_024/c1_w1_bl u_t019_024/c1_w1_br u_t019_024/c1_r0_rbl u_t019_024/c1_r1_rbl
+ u_t019_024/c2_w0_bl u_t019_024/c2_w0_br u_t019_024/c2_w1_bl u_t019_024/c2_w1_br
+ u_t019_024/c2_r0_rbl u_t019_024/c2_r1_rbl u_t019_024/c3_w0_bl u_t019_024/c3_w0_br
+ u_t019_024/c3_w1_bl u_t019_024/c3_w1_br u_t019_024/c3_r0_rbl u_t019_024/c3_r1_rbl
+ u_t019_024/r0_w0_wl u_t019_024/r0_w1_wl u_t019_024/r0_r0_rwl u_t019_024/r0_r1_rwl
+ u_t019_024/r1_w0_wl u_t019_024/r1_w1_wl u_t019_024/r1_r0_rwl u_t019_024/r1_r1_rwl
+ u_t019_024/r2_w0_wl u_t019_024/r2_w1_wl u_t019_024/r2_r0_rwl u_t019_024/r2_r1_rwl
+ u_t019_024/r3_w0_wl u_t019_024/r3_w1_wl u_t019_024/r3_r0_rwl u_t019_024/r3_r1_rwl
+ VSS u_t019_024/VSS VSUBS detronyx_12t_2w2r_rc4_4x4_routed_5layer_direct
Xu_t019_013 u_t019_013/c0_w0_bl u_t019_013/c0_w0_br u_t019_013/c0_w1_bl u_t019_013/c0_w1_br
+ u_t019_013/c0_r0_rbl u_t019_013/c0_r1_rbl u_t019_013/c1_w0_bl u_t019_013/c1_w0_br
+ u_t019_013/c1_w1_bl u_t019_013/c1_w1_br u_t019_013/c1_r0_rbl u_t019_013/c1_r1_rbl
+ u_t019_013/c2_w0_bl u_t019_013/c2_w0_br u_t019_013/c2_w1_bl u_t019_013/c2_w1_br
+ u_t019_013/c2_r0_rbl u_t019_013/c2_r1_rbl u_t019_013/c3_w0_bl u_t019_013/c3_w0_br
+ u_t019_013/c3_w1_bl u_t019_013/c3_w1_br u_t019_013/c3_r0_rbl u_t019_013/c3_r1_rbl
+ u_t019_013/r0_w0_wl u_t019_013/r0_w1_wl u_t019_013/r0_r0_rwl u_t019_013/r0_r1_rwl
+ u_t019_013/r1_w0_wl u_t019_013/r1_w1_wl u_t019_013/r1_r0_rwl u_t019_013/r1_r1_rwl
+ u_t019_013/r2_w0_wl u_t019_013/r2_w1_wl u_t019_013/r2_r0_rwl u_t019_013/r2_r1_rwl
+ u_t019_013/r3_w0_wl u_t019_013/r3_w1_wl u_t019_013/r3_r0_rwl u_t019_013/r3_r1_rwl
+ u_t019_013/VDD u_t019_013/VSS VSUBS detronyx_12t_2w2r_rc4_4x4_routed_5layer_direct
Xu_t019_002 u_t019_002/c0_w0_bl u_t019_002/c0_w0_br u_t019_002/c0_w1_bl u_t019_002/c0_w1_br
+ u_t019_002/c0_r0_rbl u_t019_002/c0_r1_rbl u_t019_002/c1_w0_bl u_t019_002/c1_w0_br
+ u_t019_002/c1_w1_bl u_t019_002/c1_w1_br u_t019_002/c1_r0_rbl u_t019_002/c1_r1_rbl
+ u_t019_002/c2_w0_bl u_t019_002/c2_w0_br u_t019_002/c2_w1_bl u_t019_002/c2_w1_br
+ u_t019_002/c2_r0_rbl u_t019_002/c2_r1_rbl u_t019_002/c3_w0_bl u_t019_002/c3_w0_br
+ u_t019_002/c3_w1_bl u_t019_002/c3_w1_br u_t019_002/c3_r0_rbl u_t019_002/c3_r1_rbl
+ u_t019_002/r0_w0_wl u_t019_002/r0_w1_wl u_t019_002/r0_r0_rwl u_t019_002/r0_r1_rwl
+ u_t019_002/r1_w0_wl u_t019_002/r1_w1_wl u_t019_002/r1_r0_rwl u_t019_002/r1_r1_rwl
+ u_t019_002/r2_w0_wl u_t019_002/r2_w1_wl u_t019_002/r2_r0_rwl u_t019_002/r2_r1_rwl
+ u_t019_002/r3_w0_wl u_t019_002/r3_w1_wl u_t019_002/r3_r0_rwl u_t019_002/r3_r1_rwl
+ VSS u_t019_002/VSS VSUBS detronyx_12t_2w2r_rc4_4x4_routed_5layer_direct
Xgf180mcu_as_sc_mcu7t3v3__nand4_2_17 gf180mcu_as_sc_mcu7t3v3__inv_2_62/VDD gf180mcu_as_sc_mcu7t3v3__inv_2_69/VSS
+ VSS VSS VSS VSS VSS gf180mcu_as_sc_mcu7t3v3__inv_2_62/VNW VSUBS gf180mcu_as_sc_mcu7t3v3__nand4_2
Xgf180mcu_as_sc_mcu7t3v3__nand4_2_28 gf180mcu_as_sc_mcu7t3v3__inv_2_88/VSS gf180mcu_as_sc_mcu7t3v3__inv_2_91/VDD
+ VSS VSS VSS VSS gf180mcu_as_sc_mcu7t3v3__nand4_2_28/Y gf180mcu_as_sc_mcu7t3v3__inv_2_87/VNW
+ VSUBS gf180mcu_as_sc_mcu7t3v3__nand4_2
Xgf180mcu_as_sc_mcu7t3v3__nand4_2_39 VSS gf180mcu_as_sc_mcu7t3v3__inv_2_134/VDD VSS
+ VSS VSS VSS VSS gf180mcu_as_sc_mcu7t3v3__inv_2_130/VNW VSUBS gf180mcu_as_sc_mcu7t3v3__nand4_2
Xu_t025_016 u_t025_016/c0_w0_bl u_t025_016/c0_w0_br u_t025_016/c0_w1_bl u_t025_016/c0_w1_br
+ u_t025_016/c0_r0_rbl u_t025_016/c0_r1_rbl u_t025_016/c1_w0_bl u_t025_016/c1_w0_br
+ u_t025_016/c1_w1_bl u_t025_016/c1_w1_br u_t025_016/c1_r0_rbl u_t025_016/c1_r1_rbl
+ u_t025_016/c2_w0_bl u_t025_016/c2_w0_br u_t025_016/c2_w1_bl u_t025_016/c2_w1_br
+ u_t025_016/c2_r0_rbl u_t025_016/c2_r1_rbl u_t025_016/c3_w0_bl u_t025_016/c3_w0_br
+ u_t025_016/c3_w1_bl u_t025_016/c3_w1_br u_t025_016/c3_r0_rbl u_t025_016/c3_r1_rbl
+ u_t025_016/r0_w0_wl u_t025_016/r0_w1_wl u_t025_016/r0_r0_rwl u_t025_016/r0_r1_rwl
+ u_t025_016/r1_w0_wl u_t025_016/r1_w1_wl u_t025_016/r1_r0_rwl u_t025_016/r1_r1_rwl
+ u_t025_016/r2_w0_wl u_t025_016/r2_w1_wl u_t025_016/r2_r0_rwl u_t025_016/r2_r1_rwl
+ u_t025_016/r3_w0_wl u_t025_016/r3_w1_wl u_t025_016/r3_r0_rwl u_t025_016/r3_r1_rwl
+ VSS u_t025_031/VSS VSUBS detronyx_12t_2w2r_rc4_4x4_routed_5layer_direct
Xu_t025_005 u_t025_005/c0_w0_bl u_t025_005/c0_w0_br u_t025_005/c0_w1_bl u_t025_005/c0_w1_br
+ u_t025_005/c0_r0_rbl u_t025_005/c0_r1_rbl u_t025_005/c1_w0_bl u_t025_005/c1_w0_br
+ u_t025_005/c1_w1_bl u_t025_005/c1_w1_br u_t025_005/c1_r0_rbl u_t025_005/c1_r1_rbl
+ u_t025_005/c2_w0_bl u_t025_005/c2_w0_br u_t025_005/c2_w1_bl u_t025_005/c2_w1_br
+ u_t025_005/c2_r0_rbl u_t025_005/c2_r1_rbl u_t025_005/c3_w0_bl u_t025_005/c3_w0_br
+ u_t025_005/c3_w1_bl u_t025_005/c3_w1_br u_t025_005/c3_r0_rbl u_t025_005/c3_r1_rbl
+ u_t025_005/r0_w0_wl u_t025_005/r0_w1_wl u_t025_005/r0_r0_rwl u_t025_005/r0_r1_rwl
+ u_t025_005/r1_w0_wl u_t025_005/r1_w1_wl u_t025_005/r1_r0_rwl u_t025_005/r1_r1_rwl
+ u_t025_005/r2_w0_wl u_t025_005/r2_w1_wl u_t025_005/r2_r0_rwl u_t025_005/r2_r1_rwl
+ u_t025_005/r3_w0_wl u_t025_005/r3_w1_wl u_t025_005/r3_r0_rwl u_t025_005/r3_r1_rwl
+ u_t025_005/VDD u_t025_031/VSS VSUBS detronyx_12t_2w2r_rc4_4x4_routed_5layer_direct
Xu_t025_027 u_t025_027/c0_w0_bl u_t025_027/c0_w0_br u_t025_027/c0_w1_bl u_t025_027/c0_w1_br
+ u_t025_027/c0_r0_rbl u_t025_027/c0_r1_rbl u_t025_027/c1_w0_bl u_t025_027/c1_w0_br
+ u_t025_027/c1_w1_bl u_t025_027/c1_w1_br u_t025_027/c1_r0_rbl u_t025_027/c1_r1_rbl
+ u_t025_027/c2_w0_bl u_t025_027/c2_w0_br u_t025_027/c2_w1_bl u_t025_027/c2_w1_br
+ u_t025_027/c2_r0_rbl u_t025_027/c2_r1_rbl u_t025_027/c3_w0_bl u_t025_027/c3_w0_br
+ u_t025_027/c3_w1_bl u_t025_027/c3_w1_br u_t025_027/c3_r0_rbl u_t025_027/c3_r1_rbl
+ u_t025_027/r0_w0_wl u_t025_027/r0_w1_wl u_t025_027/r0_r0_rwl u_t025_027/r0_r1_rwl
+ u_t025_027/r1_w0_wl u_t025_027/r1_w1_wl u_t025_027/r1_r0_rwl u_t025_027/r1_r1_rwl
+ u_t025_027/r2_w0_wl u_t025_027/r2_w1_wl u_t025_027/r2_r0_rwl u_t025_027/r2_r1_rwl
+ u_t025_027/r3_w0_wl u_t025_027/r3_w1_wl u_t025_027/r3_r0_rwl u_t025_027/r3_r1_rwl
+ u_t025_027/VDD u_t025_031/VSS VSUBS detronyx_12t_2w2r_rc4_4x4_routed_5layer_direct
Xgf180mcu_as_sc_mcu7t3v3__inv_2_1125 gf180mcu_as_sc_mcu7t3v3__inv_2_1126/VDD VSS VSS
+ gf180mcu_as_sc_mcu7t3v3__inv_2_1126/Y gf180mcu_as_sc_mcu7t3v3__inv_2_1126/VNW VSUBS
+ gf180mcu_as_sc_mcu7t3v3__inv_2
Xgf180mcu_as_sc_mcu7t3v3__inv_2_1136 VSS gf180mcu_as_sc_mcu7t3v3__inv_2_1141/VDD VSS
+ VSS gf180mcu_as_sc_mcu7t3v3__inv_2_1138/VNW VSUBS gf180mcu_as_sc_mcu7t3v3__inv_2
Xgf180mcu_as_sc_mcu7t3v3__inv_2_1114 VSS gf180mcu_as_sc_mcu7t3v3__inv_2_1117/VDD gf180mcu_as_sc_mcu7t3v3__inv_2_1114/Y
+ VSS gf180mcu_as_sc_mcu7t3v3__inv_2_1114/VNW VSUBS gf180mcu_as_sc_mcu7t3v3__inv_2
Xgf180mcu_as_sc_mcu7t3v3__inv_2_1158 VSS VSS VSS VSS gf180mcu_as_sc_mcu7t3v3__inv_2_1160/VNW
+ VSUBS gf180mcu_as_sc_mcu7t3v3__inv_2
Xgf180mcu_as_sc_mcu7t3v3__inv_2_1169 VSS VSS VSS VSS gf180mcu_as_sc_mcu7t3v3__inv_2_1171/VNW
+ VSUBS gf180mcu_as_sc_mcu7t3v3__inv_2
Xgf180mcu_as_sc_mcu7t3v3__inv_2_1147 VSS VSS VSS VSS gf180mcu_as_sc_mcu7t3v3__inv_2_1197/VNW
+ VSUBS gf180mcu_as_sc_mcu7t3v3__inv_2
Xgf180mcu_as_sc_mcu7t3v3__inv_2_1103 VSS gf180mcu_as_sc_mcu7t3v3__inv_2_1107/VDD gf180mcu_as_sc_mcu7t3v3__inv_2_1103/Y
+ gf180mcu_as_sc_mcu7t3v3__inv_2_1104/Y gf180mcu_as_sc_mcu7t3v3__inv_2_1104/VNW VSUBS
+ gf180mcu_as_sc_mcu7t3v3__inv_2
Xu_t016_027 u_t016_027/c0_w0_bl u_t016_027/c0_w0_br u_t016_027/c0_w1_bl u_t016_027/c0_w1_br
+ u_t016_027/c0_r0_rbl u_t016_027/c0_r1_rbl u_t016_027/c1_w0_bl u_t016_027/c1_w0_br
+ u_t016_027/c1_w1_bl u_t016_027/c1_w1_br u_t016_027/c1_r0_rbl u_t016_027/c1_r1_rbl
+ u_t016_027/c2_w0_bl u_t016_027/c2_w0_br u_t016_027/c2_w1_bl u_t016_027/c2_w1_br
+ u_t016_027/c2_r0_rbl u_t016_027/c2_r1_rbl u_t016_027/c3_w0_bl u_t016_027/c3_w0_br
+ u_t016_027/c3_w1_bl u_t016_027/c3_w1_br u_t016_027/c3_r0_rbl u_t016_027/c3_r1_rbl
+ u_t016_027/r0_w0_wl u_t016_027/r0_w1_wl u_t016_027/r0_r0_rwl u_t016_027/r0_r1_rwl
+ u_t016_027/r1_w0_wl u_t016_027/r1_w1_wl u_t016_027/r1_r0_rwl u_t016_027/r1_r1_rwl
+ u_t016_027/r2_w0_wl u_t016_027/r2_w1_wl u_t016_027/r2_r0_rwl u_t016_027/r2_r1_rwl
+ u_t016_027/r3_w0_wl u_t016_027/r3_w1_wl u_t016_027/r3_r0_rwl u_t016_027/r3_r1_rwl
+ u_t016_027/VDD u_t016_027/VSS VSUBS detronyx_12t_2w2r_rc4_4x4_routed_5layer_direct
Xu_t016_016 u_t016_016/c0_w0_bl u_t016_016/c0_w0_br u_t016_016/c0_w1_bl u_t016_016/c0_w1_br
+ u_t016_016/c0_r0_rbl u_t016_016/c0_r1_rbl u_t016_016/c1_w0_bl u_t016_016/c1_w0_br
+ u_t016_016/c1_w1_bl u_t016_016/c1_w1_br u_t016_016/c1_r0_rbl u_t016_016/c1_r1_rbl
+ u_t016_016/c2_w0_bl u_t016_016/c2_w0_br u_t016_016/c2_w1_bl u_t016_016/c2_w1_br
+ u_t016_016/c2_r0_rbl u_t016_016/c2_r1_rbl u_t016_016/c3_w0_bl u_t016_016/c3_w0_br
+ u_t016_016/c3_w1_bl u_t016_016/c3_w1_br u_t016_016/c3_r0_rbl u_t016_016/c3_r1_rbl
+ u_t016_016/r0_w0_wl u_t016_016/r0_w1_wl u_t016_016/r0_r0_rwl u_t016_016/r0_r1_rwl
+ u_t016_016/r1_w0_wl u_t016_016/r1_w1_wl u_t016_016/r1_r0_rwl u_t016_016/r1_r1_rwl
+ u_t016_016/r2_w0_wl u_t016_016/r2_w1_wl u_t016_016/r2_r0_rwl u_t016_016/r2_r1_rwl
+ u_t016_016/r3_w0_wl u_t016_016/r3_w1_wl u_t016_016/r3_r0_rwl u_t016_016/r3_r1_rwl
+ VSS u_t016_017/VSS VSUBS detronyx_12t_2w2r_rc4_4x4_routed_5layer_direct
Xu_t031_008 u_t031_008/c0_w0_bl u_t031_008/c0_w0_br u_t031_008/c0_w1_bl u_t031_008/c0_w1_br
+ u_t031_008/c0_r0_rbl u_t031_008/c0_r1_rbl u_t031_008/c1_w0_bl u_t031_008/c1_w0_br
+ u_t031_008/c1_w1_bl u_t031_008/c1_w1_br u_t031_008/c1_r0_rbl u_t031_008/c1_r1_rbl
+ u_t031_008/c2_w0_bl u_t031_008/c2_w0_br u_t031_008/c2_w1_bl u_t031_008/c2_w1_br
+ u_t031_008/c2_r0_rbl u_t031_008/c2_r1_rbl u_t031_008/c3_w0_bl u_t031_008/c3_w0_br
+ u_t031_008/c3_w1_bl u_t031_008/c3_w1_br u_t031_008/c3_r0_rbl u_t031_008/c3_r1_rbl
+ u_t031_008/r0_w0_wl u_t031_008/r0_w1_wl u_t031_008/r0_r0_rwl u_t031_008/r0_r1_rwl
+ u_t031_008/r1_w0_wl u_t031_008/r1_w1_wl u_t031_008/r1_r0_rwl u_t031_008/r1_r1_rwl
+ u_t031_008/r2_w0_wl u_t031_008/r2_w1_wl u_t031_008/r2_r0_rwl u_t031_008/r2_r1_rwl
+ u_t031_008/r3_w0_wl u_t031_008/r3_w1_wl u_t031_008/r3_r0_rwl u_t031_008/r3_r1_rwl
+ VSS u_t031_009/VSS VSUBS detronyx_12t_2w2r_rc4_4x4_routed_5layer_direct
Xu_t016_005 u_t016_005/c0_w0_bl u_t016_005/c0_w0_br u_t016_005/c0_w1_bl u_t016_005/c0_w1_br
+ u_t016_005/c0_r0_rbl u_t016_005/c0_r1_rbl u_t016_005/c1_w0_bl u_t016_005/c1_w0_br
+ u_t016_005/c1_w1_bl u_t016_005/c1_w1_br u_t016_005/c1_r0_rbl u_t016_005/c1_r1_rbl
+ u_t016_005/c2_w0_bl u_t016_005/c2_w0_br u_t016_005/c2_w1_bl u_t016_005/c2_w1_br
+ u_t016_005/c2_r0_rbl u_t016_005/c2_r1_rbl u_t016_005/c3_w0_bl u_t016_005/c3_w0_br
+ u_t016_005/c3_w1_bl u_t016_005/c3_w1_br u_t016_005/c3_r0_rbl u_t016_005/c3_r1_rbl
+ u_t016_005/r0_w0_wl u_t016_005/r0_w1_wl u_t016_005/r0_r0_rwl u_t016_005/r0_r1_rwl
+ u_t016_005/r1_w0_wl u_t016_005/r1_w1_wl u_t016_005/r1_r0_rwl u_t016_005/r1_r1_rwl
+ u_t016_005/r2_w0_wl u_t016_005/r2_w1_wl u_t016_005/r2_r0_rwl u_t016_005/r2_r1_rwl
+ u_t016_005/r3_w0_wl u_t016_005/r3_w1_wl u_t016_005/r3_r0_rwl u_t016_005/r3_r1_rwl
+ u_t016_005/VDD u_t016_005/VSS VSUBS detronyx_12t_2w2r_rc4_4x4_routed_5layer_direct
Xgf180mcu_as_sc_mcu7t3v3__inv_2_609 VSS gf180mcu_as_sc_mcu7t3v3__inv_2_626/VDD gf180mcu_as_sc_mcu7t3v3__inv_2_631/A
+ gf180mcu_as_sc_mcu7t3v3__inv_2_613/Y gf180mcu_as_sc_mcu7t3v3__inv_2_613/VNW VSUBS
+ gf180mcu_as_sc_mcu7t3v3__inv_2
Xu_t031_019 u_t031_019/c0_w0_bl u_t031_019/c0_w0_br u_t031_019/c0_w1_bl u_t031_019/c0_w1_br
+ u_t031_019/c0_r0_rbl u_t031_019/c0_r1_rbl u_t031_019/c1_w0_bl u_t031_019/c1_w0_br
+ u_t031_019/c1_w1_bl u_t031_019/c1_w1_br u_t031_019/c1_r0_rbl u_t031_019/c1_r1_rbl
+ u_t031_019/c2_w0_bl u_t031_019/c2_w0_br u_t031_019/c2_w1_bl u_t031_019/c2_w1_br
+ u_t031_019/c2_r0_rbl u_t031_019/c2_r1_rbl u_t031_019/c3_w0_bl u_t031_019/c3_w0_br
+ u_t031_019/c3_w1_bl u_t031_019/c3_w1_br u_t031_019/c3_r0_rbl u_t031_019/c3_r1_rbl
+ u_t031_019/r0_w0_wl u_t031_019/r0_w1_wl u_t031_019/r0_r0_rwl u_t031_019/r0_r1_rwl
+ u_t031_019/r1_w0_wl u_t031_019/r1_w1_wl u_t031_019/r1_r0_rwl u_t031_019/r1_r1_rwl
+ u_t031_019/r2_w0_wl u_t031_019/r2_w1_wl u_t031_019/r2_r0_rwl u_t031_019/r2_r1_rwl
+ u_t031_019/r3_w0_wl u_t031_019/r3_w1_wl u_t031_019/r3_r0_rwl u_t031_019/r3_r1_rwl
+ u_t031_019/VDD u_t031_019/VSS VSUBS detronyx_12t_2w2r_rc4_4x4_routed_5layer_direct
Xgf180mcu_as_sc_mcu7t3v3__inv_2_1670 VSS gf180mcu_as_sc_mcu7t3v3__inv_2_1671/VDD gf180mcu_as_sc_mcu7t3v3__inv_2_1675/Y
+ VSS gf180mcu_as_sc_mcu7t3v3__inv_2_1670/VNW VSUBS gf180mcu_as_sc_mcu7t3v3__inv_2
Xgf180mcu_as_sc_mcu7t3v3__inv_2_1681 VSS gf180mcu_as_sc_mcu7t3v3__inv_2_1682/VSS gf180mcu_as_sc_mcu7t3v3__inv_2_1681/Y
+ gf180mcu_as_sc_mcu7t3v3__inv_2_1682/Y gf180mcu_as_sc_mcu7t3v3__inv_2_1682/VNW VSUBS
+ gf180mcu_as_sc_mcu7t3v3__inv_2
Xgf180mcu_as_sc_mcu7t3v3__inv_2_1692 gf180mcu_as_sc_mcu7t3v3__inv_2_1694/VDD VSS VSS
+ VSS gf180mcu_as_sc_mcu7t3v3__inv_2_1694/VNW VSUBS gf180mcu_as_sc_mcu7t3v3__inv_2
Xu_t007_005 u_t007_005/c0_w0_bl u_t007_005/c0_w0_br u_t007_005/c0_w1_bl u_t007_005/c0_w1_br
+ u_t007_005/c0_r0_rbl u_t007_005/c0_r1_rbl u_t007_005/c1_w0_bl u_t007_005/c1_w0_br
+ u_t007_005/c1_w1_bl u_t007_005/c1_w1_br u_t007_005/c1_r0_rbl u_t007_005/c1_r1_rbl
+ u_t007_005/c2_w0_bl u_t007_005/c2_w0_br u_t007_005/c2_w1_bl u_t007_005/c2_w1_br
+ u_t007_005/c2_r0_rbl u_t007_005/c2_r1_rbl u_t007_005/c3_w0_bl u_t007_005/c3_w0_br
+ u_t007_005/c3_w1_bl u_t007_005/c3_w1_br u_t007_005/c3_r0_rbl u_t007_005/c3_r1_rbl
+ u_t007_005/r0_w0_wl u_t007_005/r0_w1_wl u_t007_005/r0_r0_rwl u_t007_005/r0_r1_rwl
+ u_t007_005/r1_w0_wl u_t007_005/r1_w1_wl u_t007_005/r1_r0_rwl u_t007_005/r1_r1_rwl
+ u_t007_005/r2_w0_wl u_t007_005/r2_w1_wl u_t007_005/r2_r0_rwl u_t007_005/r2_r1_rwl
+ u_t007_005/r3_w0_wl u_t007_005/r3_w1_wl u_t007_005/r3_r0_rwl u_t007_005/r3_r1_rwl
+ u_t008_005/VDD u_t007_005/VSS VSUBS detronyx_12t_2w2r_rc4_4x4_routed_5layer_direct
Xu_t030_030 u_t030_030/c0_w0_bl u_t030_030/c0_w0_br u_t030_030/c0_w1_bl u_t030_030/c0_w1_br
+ u_t030_030/c0_r0_rbl u_t030_030/c0_r1_rbl u_t030_030/c1_w0_bl u_t030_030/c1_w0_br
+ u_t030_030/c1_w1_bl u_t030_030/c1_w1_br u_t030_030/c1_r0_rbl u_t030_030/c1_r1_rbl
+ u_t030_030/c2_w0_bl u_t030_030/c2_w0_br u_t030_030/c2_w1_bl u_t030_030/c2_w1_br
+ u_t030_030/c2_r0_rbl u_t030_030/c2_r1_rbl u_t030_030/c3_w0_bl u_t030_030/c3_w0_br
+ u_t030_030/c3_w1_bl u_t030_030/c3_w1_br u_t030_030/c3_r0_rbl u_t030_030/c3_r1_rbl
+ u_t030_030/r0_w0_wl u_t030_030/r0_w1_wl u_t030_030/r0_r0_rwl u_t030_030/r0_r1_rwl
+ u_t030_030/r1_w0_wl u_t030_030/r1_w1_wl u_t030_030/r1_r0_rwl u_t030_030/r1_r1_rwl
+ u_t030_030/r2_w0_wl u_t030_030/r2_w1_wl u_t030_030/r2_r0_rwl u_t030_030/r2_r1_rwl
+ u_t030_030/r3_w0_wl u_t030_030/r3_w1_wl u_t030_030/r3_r0_rwl u_t030_030/r3_r1_rwl
+ VSS u_t030_031/VSS VSUBS detronyx_12t_2w2r_rc4_4x4_routed_5layer_direct
Xu_t007_027 u_t007_027/c0_w0_bl u_t007_027/c0_w0_br u_t007_027/c0_w1_bl u_t007_027/c0_w1_br
+ u_t007_027/c0_r0_rbl u_t007_027/c0_r1_rbl u_t007_027/c1_w0_bl u_t007_027/c1_w0_br
+ u_t007_027/c1_w1_bl u_t007_027/c1_w1_br u_t007_027/c1_r0_rbl u_t007_027/c1_r1_rbl
+ u_t007_027/c2_w0_bl u_t007_027/c2_w0_br u_t007_027/c2_w1_bl u_t007_027/c2_w1_br
+ u_t007_027/c2_r0_rbl u_t007_027/c2_r1_rbl u_t007_027/c3_w0_bl u_t007_027/c3_w0_br
+ u_t007_027/c3_w1_bl u_t007_027/c3_w1_br u_t007_027/c3_r0_rbl u_t007_027/c3_r1_rbl
+ u_t007_027/r0_w0_wl u_t007_027/r0_w1_wl u_t007_027/r0_r0_rwl u_t007_027/r0_r1_rwl
+ u_t007_027/r1_w0_wl u_t007_027/r1_w1_wl u_t007_027/r1_r0_rwl u_t007_027/r1_r1_rwl
+ u_t007_027/r2_w0_wl u_t007_027/r2_w1_wl u_t007_027/r2_r0_rwl u_t007_027/r2_r1_rwl
+ u_t007_027/r3_w0_wl u_t007_027/r3_w1_wl u_t007_027/r3_r0_rwl u_t007_027/r3_r1_rwl
+ u_t008_027/VDD u_t007_027/VSS VSUBS detronyx_12t_2w2r_rc4_4x4_routed_5layer_direct
Xu_t022_019 u_t022_019/c0_w0_bl u_t022_019/c0_w0_br u_t022_019/c0_w1_bl u_t022_019/c0_w1_br
+ u_t022_019/c0_r0_rbl u_t022_019/c0_r1_rbl u_t022_019/c1_w0_bl u_t022_019/c1_w0_br
+ u_t022_019/c1_w1_bl u_t022_019/c1_w1_br u_t022_019/c1_r0_rbl u_t022_019/c1_r1_rbl
+ u_t022_019/c2_w0_bl u_t022_019/c2_w0_br u_t022_019/c2_w1_bl u_t022_019/c2_w1_br
+ u_t022_019/c2_r0_rbl u_t022_019/c2_r1_rbl u_t022_019/c3_w0_bl u_t022_019/c3_w0_br
+ u_t022_019/c3_w1_bl u_t022_019/c3_w1_br u_t022_019/c3_r0_rbl u_t022_019/c3_r1_rbl
+ u_t022_019/r0_w0_wl u_t022_019/r0_w1_wl u_t022_019/r0_r0_rwl u_t022_019/r0_r1_rwl
+ u_t022_019/r1_w0_wl u_t022_019/r1_w1_wl u_t022_019/r1_r0_rwl u_t022_019/r1_r1_rwl
+ u_t022_019/r2_w0_wl u_t022_019/r2_w1_wl u_t022_019/r2_r0_rwl u_t022_019/r2_r1_rwl
+ u_t022_019/r3_w0_wl u_t022_019/r3_w1_wl u_t022_019/r3_r0_rwl u_t022_019/r3_r1_rwl
+ u_t022_019/VDD u_t022_031/VSS VSUBS detronyx_12t_2w2r_rc4_4x4_routed_5layer_direct
Xu_t007_016 u_t007_016/c0_w0_bl u_t007_016/c0_w0_br u_t007_016/c0_w1_bl u_t007_016/c0_w1_br
+ u_t007_016/c0_r0_rbl u_t007_016/c0_r1_rbl u_t007_016/c1_w0_bl u_t007_016/c1_w0_br
+ u_t007_016/c1_w1_bl u_t007_016/c1_w1_br u_t007_016/c1_r0_rbl u_t007_016/c1_r1_rbl
+ u_t007_016/c2_w0_bl u_t007_016/c2_w0_br u_t007_016/c2_w1_bl u_t007_016/c2_w1_br
+ u_t007_016/c2_r0_rbl u_t007_016/c2_r1_rbl u_t007_016/c3_w0_bl u_t007_016/c3_w0_br
+ u_t007_016/c3_w1_bl u_t007_016/c3_w1_br u_t007_016/c3_r0_rbl u_t007_016/c3_r1_rbl
+ u_t007_016/r0_w0_wl u_t007_016/r0_w1_wl u_t007_016/r0_r0_rwl u_t007_016/r0_r1_rwl
+ u_t007_016/r1_w0_wl u_t007_016/r1_w1_wl u_t007_016/r1_r0_rwl u_t007_016/r1_r1_rwl
+ u_t007_016/r2_w0_wl u_t007_016/r2_w1_wl u_t007_016/r2_r0_rwl u_t007_016/r2_r1_rwl
+ u_t007_016/r3_w0_wl u_t007_016/r3_w1_wl u_t007_016/r3_r0_rwl u_t007_016/r3_r1_rwl
+ VSS u_t007_017/VSS VSUBS detronyx_12t_2w2r_rc4_4x4_routed_5layer_direct
Xu_t022_008 u_t022_008/c0_w0_bl u_t022_008/c0_w0_br u_t022_008/c0_w1_bl u_t022_008/c0_w1_br
+ u_t022_008/c0_r0_rbl u_t022_008/c0_r1_rbl u_t022_008/c1_w0_bl u_t022_008/c1_w0_br
+ u_t022_008/c1_w1_bl u_t022_008/c1_w1_br u_t022_008/c1_r0_rbl u_t022_008/c1_r1_rbl
+ u_t022_008/c2_w0_bl u_t022_008/c2_w0_br u_t022_008/c2_w1_bl u_t022_008/c2_w1_br
+ u_t022_008/c2_r0_rbl u_t022_008/c2_r1_rbl u_t022_008/c3_w0_bl u_t022_008/c3_w0_br
+ u_t022_008/c3_w1_bl u_t022_008/c3_w1_br u_t022_008/c3_r0_rbl u_t022_008/c3_r1_rbl
+ u_t022_008/r0_w0_wl u_t022_008/r0_w1_wl u_t022_008/r0_r0_rwl u_t022_008/r0_r1_rwl
+ u_t022_008/r1_w0_wl u_t022_008/r1_w1_wl u_t022_008/r1_r0_rwl u_t022_008/r1_r1_rwl
+ u_t022_008/r2_w0_wl u_t022_008/r2_w1_wl u_t022_008/r2_r0_rwl u_t022_008/r2_r1_rwl
+ u_t022_008/r3_w0_wl u_t022_008/r3_w1_wl u_t022_008/r3_r0_rwl u_t022_008/r3_r1_rwl
+ VSS u_t022_031/VSS VSUBS detronyx_12t_2w2r_rc4_4x4_routed_5layer_direct
Xgf180mcu_as_sc_mcu7t3v3__nand4_2_453 VSS VSS VSS VSS VSS VSS VSS gf180mcu_as_sc_mcu7t3v3__inv_2_1561/VNW
+ VSUBS gf180mcu_as_sc_mcu7t3v3__nand4_2
Xgf180mcu_as_sc_mcu7t3v3__nand4_2_431 gf180mcu_as_sc_mcu7t3v3__inv_2_1468/VDD VSS
+ VSS VSS VSS VSS gf180mcu_as_sc_mcu7t3v3__nand4_2_431/Y gf180mcu_as_sc_mcu7t3v3__inv_2_1468/VNW
+ VSUBS gf180mcu_as_sc_mcu7t3v3__nand4_2
Xgf180mcu_as_sc_mcu7t3v3__nand4_2_420 VSS gf180mcu_as_sc_mcu7t3v3__inv_2_1428/VDD
+ VSS VSS VSS VSS VSS gf180mcu_as_sc_mcu7t3v3__inv_2_1424/VNW VSUBS gf180mcu_as_sc_mcu7t3v3__nand4_2
Xgf180mcu_as_sc_mcu7t3v3__nand4_2_442 VSS gf180mcu_as_sc_mcu7t3v3__inv_2_1502/VDD
+ VSS VSS VSS VSS VSS gf180mcu_as_sc_mcu7t3v3__inv_2_1461/VNW VSUBS gf180mcu_as_sc_mcu7t3v3__nand4_2
Xgf180mcu_as_sc_mcu7t3v3__nand4_2_497 VSS gf180mcu_as_sc_mcu7t3v3__inv_2_1678/VDD
+ VSS VSS VSS VSS VSS gf180mcu_as_sc_mcu7t3v3__inv_2_1677/VNW VSUBS gf180mcu_as_sc_mcu7t3v3__nand4_2
Xgf180mcu_as_sc_mcu7t3v3__nand4_2_464 gf180mcu_as_sc_mcu7t3v3__inv_2_1586/VSS VSS
+ VSS VSS VSS VSS gf180mcu_as_sc_mcu7t3v3__nand4_2_464/Y gf180mcu_as_sc_mcu7t3v3__inv_2_1574/VNW
+ VSUBS gf180mcu_as_sc_mcu7t3v3__nand4_2
Xgf180mcu_as_sc_mcu7t3v3__nand4_2_486 gf180mcu_as_sc_mcu7t3v3__inv_2_1654/VDD VSS
+ VSS VSS VSS VSS VSS gf180mcu_as_sc_mcu7t3v3__inv_2_1654/VNW VSUBS gf180mcu_as_sc_mcu7t3v3__nand4_2
Xgf180mcu_as_sc_mcu7t3v3__nand4_2_475 VSS gf180mcu_as_sc_mcu7t3v3__inv_2_1532/VSS
+ VSS VSS VSS VSS gf180mcu_as_sc_mcu7t3v3__nand4_2_475/Y gf180mcu_as_sc_mcu7t3v3__inv_2_1532/VNW
+ VSUBS gf180mcu_as_sc_mcu7t3v3__nand4_2
Xu_t021_030 u_t021_030/c0_w0_bl u_t021_030/c0_w0_br u_t021_030/c0_w1_bl u_t021_030/c0_w1_br
+ u_t021_030/c0_r0_rbl u_t021_030/c0_r1_rbl u_t021_030/c1_w0_bl u_t021_030/c1_w0_br
+ u_t021_030/c1_w1_bl u_t021_030/c1_w1_br u_t021_030/c1_r0_rbl u_t021_030/c1_r1_rbl
+ u_t021_030/c2_w0_bl u_t021_030/c2_w0_br u_t021_030/c2_w1_bl u_t021_030/c2_w1_br
+ u_t021_030/c2_r0_rbl u_t021_030/c2_r1_rbl u_t021_030/c3_w0_bl u_t021_030/c3_w0_br
+ u_t021_030/c3_w1_bl u_t021_030/c3_w1_br u_t021_030/c3_r0_rbl u_t021_030/c3_r1_rbl
+ u_t021_030/r0_w0_wl u_t021_030/r0_w1_wl u_t021_030/r0_r0_rwl u_t021_030/r0_r1_rwl
+ u_t021_030/r1_w0_wl u_t021_030/r1_w1_wl u_t021_030/r1_r0_rwl u_t021_030/r1_r1_rwl
+ u_t021_030/r2_w0_wl u_t021_030/r2_w1_wl u_t021_030/r2_r0_rwl u_t021_030/r2_r1_rwl
+ u_t021_030/r3_w0_wl u_t021_030/r3_w1_wl u_t021_030/r3_r0_rwl u_t021_030/r3_r1_rwl
+ VSS u_t021_031/VSS VSUBS detronyx_12t_2w2r_rc4_4x4_routed_5layer_direct
Xu_t013_019 u_t013_019/c0_w0_bl u_t013_019/c0_w0_br u_t013_019/c0_w1_bl u_t013_019/c0_w1_br
+ u_t013_019/c0_r0_rbl u_t013_019/c0_r1_rbl u_t013_019/c1_w0_bl u_t013_019/c1_w0_br
+ u_t013_019/c1_w1_bl u_t013_019/c1_w1_br u_t013_019/c1_r0_rbl u_t013_019/c1_r1_rbl
+ u_t013_019/c2_w0_bl u_t013_019/c2_w0_br u_t013_019/c2_w1_bl u_t013_019/c2_w1_br
+ u_t013_019/c2_r0_rbl u_t013_019/c2_r1_rbl u_t013_019/c3_w0_bl u_t013_019/c3_w0_br
+ u_t013_019/c3_w1_bl u_t013_019/c3_w1_br u_t013_019/c3_r0_rbl u_t013_019/c3_r1_rbl
+ u_t013_019/r0_w0_wl u_t013_019/r0_w1_wl u_t013_019/r0_r0_rwl u_t013_019/r0_r1_rwl
+ u_t013_019/r1_w0_wl u_t013_019/r1_w1_wl u_t013_019/r1_r0_rwl u_t013_019/r1_r1_rwl
+ u_t013_019/r2_w0_wl u_t013_019/r2_w1_wl u_t013_019/r2_r0_rwl u_t013_019/r2_r1_rwl
+ u_t013_019/r3_w0_wl u_t013_019/r3_w1_wl u_t013_019/r3_r0_rwl u_t013_019/r3_r1_rwl
+ u_t013_019/VDD u_t013_031/VSS VSUBS detronyx_12t_2w2r_rc4_4x4_routed_5layer_direct
Xu_t013_008 u_t013_008/c0_w0_bl u_t013_008/c0_w0_br u_t013_008/c0_w1_bl u_t013_008/c0_w1_br
+ u_t013_008/c0_r0_rbl u_t013_008/c0_r1_rbl u_t013_008/c1_w0_bl u_t013_008/c1_w0_br
+ u_t013_008/c1_w1_bl u_t013_008/c1_w1_br u_t013_008/c1_r0_rbl u_t013_008/c1_r1_rbl
+ u_t013_008/c2_w0_bl u_t013_008/c2_w0_br u_t013_008/c2_w1_bl u_t013_008/c2_w1_br
+ u_t013_008/c2_r0_rbl u_t013_008/c2_r1_rbl u_t013_008/c3_w0_bl u_t013_008/c3_w0_br
+ u_t013_008/c3_w1_bl u_t013_008/c3_w1_br u_t013_008/c3_r0_rbl u_t013_008/c3_r1_rbl
+ u_t013_008/r0_w0_wl u_t013_008/r0_w1_wl u_t013_008/r0_r0_rwl u_t013_008/r0_r1_rwl
+ u_t013_008/r1_w0_wl u_t013_008/r1_w1_wl u_t013_008/r1_r0_rwl u_t013_008/r1_r1_rwl
+ u_t013_008/r2_w0_wl u_t013_008/r2_w1_wl u_t013_008/r2_r0_rwl u_t013_008/r2_r1_rwl
+ u_t013_008/r3_w0_wl u_t013_008/r3_w1_wl u_t013_008/r3_r0_rwl u_t013_008/r3_r1_rwl
+ VSS u_t013_031/VSS VSUBS detronyx_12t_2w2r_rc4_4x4_routed_5layer_direct
Xu_t012_030 u_t012_030/c0_w0_bl u_t012_030/c0_w0_br u_t012_030/c0_w1_bl u_t012_030/c0_w1_br
+ u_t012_030/c0_r0_rbl u_t012_030/c0_r1_rbl u_t012_030/c1_w0_bl u_t012_030/c1_w0_br
+ u_t012_030/c1_w1_bl u_t012_030/c1_w1_br u_t012_030/c1_r0_rbl u_t012_030/c1_r1_rbl
+ u_t012_030/c2_w0_bl u_t012_030/c2_w0_br u_t012_030/c2_w1_bl u_t012_030/c2_w1_br
+ u_t012_030/c2_r0_rbl u_t012_030/c2_r1_rbl u_t012_030/c3_w0_bl u_t012_030/c3_w0_br
+ u_t012_030/c3_w1_bl u_t012_030/c3_w1_br u_t012_030/c3_r0_rbl u_t012_030/c3_r1_rbl
+ u_t012_030/r0_w0_wl u_t012_030/r0_w1_wl u_t012_030/r0_r0_rwl u_t012_030/r0_r1_rwl
+ u_t012_030/r1_w0_wl u_t012_030/r1_w1_wl u_t012_030/r1_r0_rwl u_t012_030/r1_r1_rwl
+ u_t012_030/r2_w0_wl u_t012_030/r2_w1_wl u_t012_030/r2_r0_rwl u_t012_030/r2_r1_rwl
+ u_t012_030/r3_w0_wl u_t012_030/r3_w1_wl u_t012_030/r3_r0_rwl u_t012_030/r3_r1_rwl
+ VSS u_t012_031/VSS VSUBS detronyx_12t_2w2r_rc4_4x4_routed_5layer_direct
Xu_t004_019 u_t004_019/c0_w0_bl u_t004_019/c0_w0_br u_t004_019/c0_w1_bl u_t004_019/c0_w1_br
+ u_t004_019/c0_r0_rbl u_t004_019/c0_r1_rbl u_t004_019/c1_w0_bl u_t004_019/c1_w0_br
+ u_t004_019/c1_w1_bl u_t004_019/c1_w1_br u_t004_019/c1_r0_rbl u_t004_019/c1_r1_rbl
+ u_t004_019/c2_w0_bl u_t004_019/c2_w0_br u_t004_019/c2_w1_bl u_t004_019/c2_w1_br
+ u_t004_019/c2_r0_rbl u_t004_019/c2_r1_rbl u_t004_019/c3_w0_bl u_t004_019/c3_w0_br
+ u_t004_019/c3_w1_bl u_t004_019/c3_w1_br u_t004_019/c3_r0_rbl u_t004_019/c3_r1_rbl
+ u_t004_019/r0_w0_wl u_t004_019/r0_w1_wl u_t004_019/r0_r0_rwl u_t004_019/r0_r1_rwl
+ u_t004_019/r1_w0_wl u_t004_019/r1_w1_wl u_t004_019/r1_r0_rwl u_t004_019/r1_r1_rwl
+ u_t004_019/r2_w0_wl u_t004_019/r2_w1_wl u_t004_019/r2_r0_rwl u_t004_019/r2_r1_rwl
+ u_t004_019/r3_w0_wl u_t004_019/r3_w1_wl u_t004_019/r3_r0_rwl u_t004_019/r3_r1_rwl
+ u_t004_019/VDD u_t004_031/VSS VSUBS detronyx_12t_2w2r_rc4_4x4_routed_5layer_direct
Xu_t004_008 u_t004_008/c0_w0_bl u_t004_008/c0_w0_br u_t004_008/c0_w1_bl u_t004_008/c0_w1_br
+ u_t004_008/c0_r0_rbl u_t004_008/c0_r1_rbl u_t004_008/c1_w0_bl u_t004_008/c1_w0_br
+ u_t004_008/c1_w1_bl u_t004_008/c1_w1_br u_t004_008/c1_r0_rbl u_t004_008/c1_r1_rbl
+ u_t004_008/c2_w0_bl u_t004_008/c2_w0_br u_t004_008/c2_w1_bl u_t004_008/c2_w1_br
+ u_t004_008/c2_r0_rbl u_t004_008/c2_r1_rbl u_t004_008/c3_w0_bl u_t004_008/c3_w0_br
+ u_t004_008/c3_w1_bl u_t004_008/c3_w1_br u_t004_008/c3_r0_rbl u_t004_008/c3_r1_rbl
+ u_t004_008/r0_w0_wl u_t004_008/r0_w1_wl u_t004_008/r0_r0_rwl u_t004_008/r0_r1_rwl
+ u_t004_008/r1_w0_wl u_t004_008/r1_w1_wl u_t004_008/r1_r0_rwl u_t004_008/r1_r1_rwl
+ u_t004_008/r2_w0_wl u_t004_008/r2_w1_wl u_t004_008/r2_r0_rwl u_t004_008/r2_r1_rwl
+ u_t004_008/r3_w0_wl u_t004_008/r3_w1_wl u_t004_008/r3_r0_rwl u_t004_008/r3_r1_rwl
+ VSS u_t004_031/VSS VSUBS detronyx_12t_2w2r_rc4_4x4_routed_5layer_direct
Xgf180mcu_as_sc_mcu7t3v3__inv_2_439 gf180mcu_as_sc_mcu7t3v3__nor2_2_5/VDD gf180mcu_as_sc_mcu7t3v3__nand3_2_8/VSS
+ VSS VSS gf180mcu_as_sc_mcu7t3v3__nor2_2_5/VNW VSUBS gf180mcu_as_sc_mcu7t3v3__inv_2
Xgf180mcu_as_sc_mcu7t3v3__inv_2_417 gf180mcu_as_sc_mcu7t3v3__nor2_2_4/VDD gf180mcu_as_sc_mcu7t3v3__nand3_2_8/VSS
+ VSS VSS gf180mcu_as_sc_mcu7t3v3__nor2_2_4/VNW VSUBS gf180mcu_as_sc_mcu7t3v3__inv_2
Xgf180mcu_as_sc_mcu7t3v3__inv_2_428 gf180mcu_as_sc_mcu7t3v3__nor2_2_4/VDD gf180mcu_as_sc_mcu7t3v3__nand3_2_8/VSS
+ VSS VSS gf180mcu_as_sc_mcu7t3v3__nor2_2_4/VNW VSUBS gf180mcu_as_sc_mcu7t3v3__inv_2
Xgf180mcu_as_sc_mcu7t3v3__inv_2_406 gf180mcu_as_sc_mcu7t3v3__nor2_2_6/VDD gf180mcu_as_sc_mcu7t3v3__nand3_2_3/VSS
+ VSS VSS gf180mcu_as_sc_mcu7t3v3__nor2_2_6/VNW VSUBS gf180mcu_as_sc_mcu7t3v3__inv_2
Xgf180mcu_as_sc_mcu7t3v3__inv_2_940 VSS VSS gf180mcu_as_sc_mcu7t3v3__inv_2_940/Y VSS
+ gf180mcu_as_sc_mcu7t3v3__inv_2_940/VNW VSUBS gf180mcu_as_sc_mcu7t3v3__inv_2
Xu_t003_030 u_t003_030/c0_w0_bl u_t003_030/c0_w0_br u_t003_030/c0_w1_bl u_t003_030/c0_w1_br
+ u_t003_030/c0_r0_rbl u_t003_030/c0_r1_rbl u_t003_030/c1_w0_bl u_t003_030/c1_w0_br
+ u_t003_030/c1_w1_bl u_t003_030/c1_w1_br u_t003_030/c1_r0_rbl u_t003_030/c1_r1_rbl
+ u_t003_030/c2_w0_bl u_t003_030/c2_w0_br u_t003_030/c2_w1_bl u_t003_030/c2_w1_br
+ u_t003_030/c2_r0_rbl u_t003_030/c2_r1_rbl u_t003_030/c3_w0_bl u_t003_030/c3_w0_br
+ u_t003_030/c3_w1_bl u_t003_030/c3_w1_br u_t003_030/c3_r0_rbl u_t003_030/c3_r1_rbl
+ u_t003_030/r0_w0_wl u_t003_030/r0_w1_wl u_t003_030/r0_r0_rwl u_t003_030/r0_r1_rwl
+ u_t003_030/r1_w0_wl u_t003_030/r1_w1_wl u_t003_030/r1_r0_rwl u_t003_030/r1_r1_rwl
+ u_t003_030/r2_w0_wl u_t003_030/r2_w1_wl u_t003_030/r2_r0_rwl u_t003_030/r2_r1_rwl
+ u_t003_030/r3_w0_wl u_t003_030/r3_w1_wl u_t003_030/r3_r0_rwl u_t003_030/r3_r1_rwl
+ VSS u_t003_031/VSS VSUBS detronyx_12t_2w2r_rc4_4x4_routed_5layer_direct
Xgf180mcu_as_sc_mcu7t3v3__inv_2_951 VSS VSS VSS VSS gf180mcu_as_sc_mcu7t3v3__inv_2_951/VNW
+ VSUBS gf180mcu_as_sc_mcu7t3v3__inv_2
Xgf180mcu_as_sc_mcu7t3v3__inv_2_984 VSS VSS VSS gf180mcu_as_sc_mcu7t3v3__inv_2_988/A
+ gf180mcu_as_sc_mcu7t3v3__inv_2_986/VNW VSUBS gf180mcu_as_sc_mcu7t3v3__inv_2
Xgf180mcu_as_sc_mcu7t3v3__inv_2_973 VSS gf180mcu_as_sc_mcu7t3v3__inv_2_978/VDD gf180mcu_as_sc_mcu7t3v3__inv_2_991/A
+ gf180mcu_as_sc_mcu7t3v3__inv_2_974/Y gf180mcu_as_sc_mcu7t3v3__inv_2_974/VNW VSUBS
+ gf180mcu_as_sc_mcu7t3v3__inv_2
Xgf180mcu_as_sc_mcu7t3v3__inv_2_962 VSS gf180mcu_as_sc_mcu7t3v3__inv_2_966/VDD gf180mcu_as_sc_mcu7t3v3__inv_2_962/Y
+ VSS gf180mcu_as_sc_mcu7t3v3__inv_2_962/VNW VSUBS gf180mcu_as_sc_mcu7t3v3__inv_2
Xgf180mcu_as_sc_mcu7t3v3__inv_2_995 VSS gf180mcu_as_sc_mcu7t3v3__inv_2_999/VSS gf180mcu_as_sc_mcu7t3v3__inv_2_995/Y
+ gf180mcu_as_sc_mcu7t3v3__inv_2_999/Y gf180mcu_as_sc_mcu7t3v3__inv_2_999/VNW VSUBS
+ gf180mcu_as_sc_mcu7t3v3__inv_2
Xgf180mcu_as_sc_mcu7t3v3__nand4_2_283 VSS VSS VSS VSS VSS VSS VSS gf180mcu_as_sc_mcu7t3v3__inv_2_945/VNW
+ VSUBS gf180mcu_as_sc_mcu7t3v3__nand4_2
Xgf180mcu_as_sc_mcu7t3v3__nand4_2_250 VSS VSS VSS VSS VSS VSS gf180mcu_as_sc_mcu7t3v3__nand4_2_250/Y
+ gf180mcu_as_sc_mcu7t3v3__inv_2_949/VNW VSUBS gf180mcu_as_sc_mcu7t3v3__nand4_2
Xgf180mcu_as_sc_mcu7t3v3__nand4_2_272 VSS VSS VSS VSS VSS VSS gf180mcu_as_sc_mcu7t3v3__nand4_2_272/Y
+ gf180mcu_as_sc_mcu7t3v3__inv_2_940/VNW VSUBS gf180mcu_as_sc_mcu7t3v3__nand4_2
Xgf180mcu_as_sc_mcu7t3v3__nand4_2_261 VSS VSS VSS VSS VSS VSS gf180mcu_as_sc_mcu7t3v3__nand4_2_261/Y
+ gf180mcu_as_sc_mcu7t3v3__inv_2_896/VNW VSUBS gf180mcu_as_sc_mcu7t3v3__nand4_2
Xgf180mcu_as_sc_mcu7t3v3__nand4_2_294 gf180mcu_as_sc_mcu7t3v3__inv_2_994/VDD VSS VSS
+ VSS VSS VSS VSS gf180mcu_as_sc_mcu7t3v3__inv_2_994/VNW VSUBS gf180mcu_as_sc_mcu7t3v3__nand4_2
Xgf180mcu_as_sc_mcu7t3v3__inv_2_203 VSS gf180mcu_as_sc_mcu7t3v3__inv_2_206/VDD VSS
+ VSS gf180mcu_as_sc_mcu7t3v3__inv_2_204/VNW VSUBS gf180mcu_as_sc_mcu7t3v3__inv_2
Xgf180mcu_as_sc_mcu7t3v3__inv_2_214 VSS gf180mcu_as_sc_mcu7t3v3__inv_2_220/VDD VSS
+ VSS gf180mcu_as_sc_mcu7t3v3__inv_2_216/VNW VSUBS gf180mcu_as_sc_mcu7t3v3__inv_2
Xgf180mcu_as_sc_mcu7t3v3__inv_2_225 gf180mcu_as_sc_mcu7t3v3__inv_2_229/VDD gf180mcu_as_sc_mcu7t3v3__inv_2_233/VDD
+ gf180mcu_as_sc_mcu7t3v3__inv_2_225/Y VSS gf180mcu_as_sc_mcu7t3v3__inv_2_229/VNW
+ VSUBS gf180mcu_as_sc_mcu7t3v3__inv_2
Xu_t000_022 u_t000_022/c0_w0_bl u_t000_022/c0_w0_br u_t000_022/c0_w1_bl u_t000_022/c0_w1_br
+ u_t000_022/c0_r0_rbl u_t000_022/c0_r1_rbl u_t000_022/c1_w0_bl u_t000_022/c1_w0_br
+ u_t000_022/c1_w1_bl u_t000_022/c1_w1_br u_t000_022/c1_r0_rbl u_t000_022/c1_r1_rbl
+ u_t000_022/c2_w0_bl u_t000_022/c2_w0_br u_t000_022/c2_w1_bl u_t000_022/c2_w1_br
+ u_t000_022/c2_r0_rbl u_t000_022/c2_r1_rbl u_t000_022/c3_w0_bl u_t000_022/c3_w0_br
+ u_t000_022/c3_w1_bl u_t000_022/c3_w1_br u_t000_022/c3_r0_rbl u_t000_022/c3_r1_rbl
+ u_t000_022/r0_w0_wl u_t000_022/r0_w1_wl u_t000_022/r0_r0_rwl u_t000_022/r0_r1_rwl
+ u_t000_022/r1_w0_wl u_t000_022/r1_w1_wl u_t000_022/r1_r0_rwl u_t000_022/r1_r1_rwl
+ u_t000_022/r2_w0_wl u_t000_022/r2_w1_wl u_t000_022/r2_r0_rwl u_t000_022/r2_r1_rwl
+ u_t000_022/r3_w0_wl u_t000_022/r3_w1_wl u_t000_022/r3_r0_rwl u_t000_022/r3_r1_rwl
+ VSS u_t000_031/VSS VSUBS detronyx_12t_2w2r_rc4_4x4_routed_5layer_direct
Xu_t000_011 u_t000_011/c0_w0_bl u_t000_011/c0_w0_br u_t000_011/c0_w1_bl u_t000_011/c0_w1_br
+ u_t000_011/c0_r0_rbl u_t000_011/c0_r1_rbl u_t000_011/c1_w0_bl u_t000_011/c1_w0_br
+ u_t000_011/c1_w1_bl u_t000_011/c1_w1_br u_t000_011/c1_r0_rbl u_t000_011/c1_r1_rbl
+ u_t000_011/c2_w0_bl u_t000_011/c2_w0_br u_t000_011/c2_w1_bl u_t000_011/c2_w1_br
+ u_t000_011/c2_r0_rbl u_t000_011/c2_r1_rbl u_t000_011/c3_w0_bl u_t000_011/c3_w0_br
+ u_t000_011/c3_w1_bl u_t000_011/c3_w1_br u_t000_011/c3_r0_rbl u_t000_011/c3_r1_rbl
+ u_t000_011/r0_w0_wl u_t000_011/r0_w1_wl u_t000_011/r0_r0_rwl u_t000_011/r0_r1_rwl
+ u_t000_011/r1_w0_wl u_t000_011/r1_w1_wl u_t000_011/r1_r0_rwl u_t000_011/r1_r1_rwl
+ u_t000_011/r2_w0_wl u_t000_011/r2_w1_wl u_t000_011/r2_r0_rwl u_t000_011/r2_r1_rwl
+ u_t000_011/r3_w0_wl u_t000_011/r3_w1_wl u_t000_011/r3_r0_rwl u_t000_011/r3_r1_rwl
+ u_t000_011/VDD u_t000_031/VSS VSUBS detronyx_12t_2w2r_rc4_4x4_routed_5layer_direct
Xu_t000_000 u_t000_000/c0_w0_bl u_t000_000/c0_w0_br u_t000_000/c0_w1_bl u_t000_000/c0_w1_br
+ u_t000_000/c0_r0_rbl u_t000_000/c0_r1_rbl u_t000_000/c1_w0_bl u_t000_000/c1_w0_br
+ u_t000_000/c1_w1_bl u_t000_000/c1_w1_br u_t000_000/c1_r0_rbl u_t000_000/c1_r1_rbl
+ u_t000_000/c2_w0_bl u_t000_000/c2_w0_br u_t000_000/c2_w1_bl u_t000_000/c2_w1_br
+ u_t000_000/c2_r0_rbl u_t000_000/c2_r1_rbl u_t000_000/c3_w0_bl u_t000_000/c3_w0_br
+ u_t000_000/c3_w1_bl u_t000_000/c3_w1_br u_t000_000/c3_r0_rbl u_t000_000/c3_r1_rbl
+ u_t000_000/r0_w0_wl u_t000_000/r0_w1_wl u_t000_000/r0_r0_rwl u_t000_000/r0_r1_rwl
+ u_t000_000/r1_w0_wl u_t000_000/r1_w1_wl u_t000_000/r1_r0_rwl u_t000_000/r1_r1_rwl
+ u_t000_000/r2_w0_wl u_t000_000/r2_w1_wl u_t000_000/r2_r0_rwl u_t000_000/r2_r1_rwl
+ u_t000_000/r3_w0_wl u_t000_000/r3_w1_wl u_t000_000/r3_r0_rwl u_t000_000/r3_r1_rwl
+ VSS u_t000_031/VSS VSUBS detronyx_12t_2w2r_rc4_4x4_routed_5layer_direct
Xgf180mcu_as_sc_mcu7t3v3__inv_2_269 gf180mcu_as_sc_mcu7t3v3__inv_2_350/VDD gf180mcu_as_sc_mcu7t3v3__inv_2_351/VDD
+ VSS gf180mcu_as_sc_mcu7t3v3__inv_2_66/Y gf180mcu_as_sc_mcu7t3v3__inv_2_350/VNW VSUBS
+ gf180mcu_as_sc_mcu7t3v3__inv_2
Xgf180mcu_as_sc_mcu7t3v3__inv_2_258 VSS gf180mcu_as_sc_mcu7t3v3__inv_2_260/VSS VSS
+ VSS gf180mcu_as_sc_mcu7t3v3__inv_2_260/VNW VSUBS gf180mcu_as_sc_mcu7t3v3__inv_2
Xgf180mcu_as_sc_mcu7t3v3__inv_2_247 VSS gf180mcu_as_sc_mcu7t3v3__inv_2_257/VDD VSS
+ VSS gf180mcu_as_sc_mcu7t3v3__inv_2_249/VNW VSUBS gf180mcu_as_sc_mcu7t3v3__inv_2
Xgf180mcu_as_sc_mcu7t3v3__inv_2_236 VSS gf180mcu_as_sc_mcu7t3v3__inv_2_241/VDD gf180mcu_as_sc_mcu7t3v3__inv_2_236/Y
+ VSS gf180mcu_as_sc_mcu7t3v3__inv_2_237/VNW VSUBS gf180mcu_as_sc_mcu7t3v3__inv_2
Xgf180mcu_as_sc_mcu7t3v3__inv_2_770 VSS VSS gf180mcu_as_sc_mcu7t3v3__inv_2_770/Y VSS
+ gf180mcu_as_sc_mcu7t3v3__inv_2_772/VNW VSUBS gf180mcu_as_sc_mcu7t3v3__inv_2
Xgf180mcu_as_sc_mcu7t3v3__inv_2_781 VSS VSS VSS VSS gf180mcu_as_sc_mcu7t3v3__inv_2_781/VNW
+ VSUBS gf180mcu_as_sc_mcu7t3v3__inv_2
Xgf180mcu_as_sc_mcu7t3v3__inv_2_792 VSS VSS VSS VSS gf180mcu_as_sc_mcu7t3v3__inv_2_792/VNW
+ VSUBS gf180mcu_as_sc_mcu7t3v3__inv_2
Xgf180mcu_as_sc_mcu7t3v3__nor2_2_4 gf180mcu_as_sc_mcu7t3v3__nor2_2_4/VDD gf180mcu_as_sc_mcu7t3v3__nor2_2_4/VSS
+ VSS VSS VSS gf180mcu_as_sc_mcu7t3v3__nor2_2_4/VNW VSUBS gf180mcu_as_sc_mcu7t3v3__nor2_2
Xgf180mcu_as_sc_mcu7t3v3__nand2_2_9 gf180mcu_as_sc_mcu7t3v3__nor2_2_5/VDD gf180mcu_as_sc_mcu7t3v3__nor2_2_5/VSS
+ VSS VSS VSS gf180mcu_as_sc_mcu7t3v3__nor2_2_5/VNW VSUBS gf180mcu_as_sc_mcu7t3v3__nand2_2
Xgf180mcu_as_sc_mcu7t3v3__inv_2_1307 VSS gf180mcu_as_sc_mcu7t3v3__inv_2_1378/VDD gf180mcu_as_sc_mcu7t3v3__inv_2_1379/Y
+ gf180mcu_as_sc_mcu7t3v3__inv_2_1379/Y gf180mcu_as_sc_mcu7t3v3__inv_2_1377/VNW VSUBS
+ gf180mcu_as_sc_mcu7t3v3__inv_2
Xgf180mcu_as_sc_mcu7t3v3__inv_2_1318 gf180mcu_as_sc_mcu7t3v3__inv_2_1375/VDD gf180mcu_as_sc_mcu7t3v3__inv_2_1376/VDD
+ VSS gf180mcu_as_sc_mcu7t3v3__inv_2_1379/Y gf180mcu_as_sc_mcu7t3v3__inv_2_1375/VNW
+ VSUBS gf180mcu_as_sc_mcu7t3v3__inv_2
Xgf180mcu_as_sc_mcu7t3v3__inv_2_1329 gf180mcu_as_sc_mcu7t3v3__inv_2_1372/VDD gf180mcu_as_sc_mcu7t3v3__inv_2_1373/VDD
+ gf180mcu_as_sc_mcu7t3v3__inv_2_1329/Y gf180mcu_as_sc_mcu7t3v3__inv_2_1379/Y gf180mcu_as_sc_mcu7t3v3__inv_2_1372/VNW
+ VSUBS gf180mcu_as_sc_mcu7t3v3__inv_2
Xu_t028_025 u_t028_025/c0_w0_bl u_t028_025/c0_w0_br u_t028_025/c0_w1_bl u_t028_025/c0_w1_br
+ u_t028_025/c0_r0_rbl u_t028_025/c0_r1_rbl u_t028_025/c1_w0_bl u_t028_025/c1_w0_br
+ u_t028_025/c1_w1_bl u_t028_025/c1_w1_br u_t028_025/c1_r0_rbl u_t028_025/c1_r1_rbl
+ u_t028_025/c2_w0_bl u_t028_025/c2_w0_br u_t028_025/c2_w1_bl u_t028_025/c2_w1_br
+ u_t028_025/c2_r0_rbl u_t028_025/c2_r1_rbl u_t028_025/c3_w0_bl u_t028_025/c3_w0_br
+ u_t028_025/c3_w1_bl u_t028_025/c3_w1_br u_t028_025/c3_r0_rbl u_t028_025/c3_r1_rbl
+ u_t028_025/r0_w0_wl u_t028_025/r0_w1_wl u_t028_025/r0_r0_rwl u_t028_025/r0_r1_rwl
+ u_t028_025/r1_w0_wl u_t028_025/r1_w1_wl u_t028_025/r1_r0_rwl u_t028_025/r1_r1_rwl
+ u_t028_025/r2_w0_wl u_t028_025/r2_w1_wl u_t028_025/r2_r0_rwl u_t028_025/r2_r1_rwl
+ u_t028_025/r3_w0_wl u_t028_025/r3_w1_wl u_t028_025/r3_r0_rwl u_t028_025/r3_r1_rwl
+ VSS u_t028_025/VSS VSUBS detronyx_12t_2w2r_rc4_4x4_routed_5layer_direct
Xu_t028_014 u_t028_014/c0_w0_bl u_t028_014/c0_w0_br u_t028_014/c0_w1_bl u_t028_014/c0_w1_br
+ u_t028_014/c0_r0_rbl u_t028_014/c0_r1_rbl u_t028_014/c1_w0_bl u_t028_014/c1_w0_br
+ u_t028_014/c1_w1_bl u_t028_014/c1_w1_br u_t028_014/c1_r0_rbl u_t028_014/c1_r1_rbl
+ u_t028_014/c2_w0_bl u_t028_014/c2_w0_br u_t028_014/c2_w1_bl u_t028_014/c2_w1_br
+ u_t028_014/c2_r0_rbl u_t028_014/c2_r1_rbl u_t028_014/c3_w0_bl u_t028_014/c3_w0_br
+ u_t028_014/c3_w1_bl u_t028_014/c3_w1_br u_t028_014/c3_r0_rbl u_t028_014/c3_r1_rbl
+ u_t028_014/r0_w0_wl u_t028_014/r0_w1_wl u_t028_014/r0_r0_rwl u_t028_014/r0_r1_rwl
+ u_t028_014/r1_w0_wl u_t028_014/r1_w1_wl u_t028_014/r1_r0_rwl u_t028_014/r1_r1_rwl
+ u_t028_014/r2_w0_wl u_t028_014/r2_w1_wl u_t028_014/r2_r0_rwl u_t028_014/r2_r1_rwl
+ u_t028_014/r3_w0_wl u_t028_014/r3_w1_wl u_t028_014/r3_r0_rwl u_t028_014/r3_r1_rwl
+ u_t029_014/VDD u_t028_017/VSS VSUBS detronyx_12t_2w2r_rc4_4x4_routed_5layer_direct
Xu_t028_003 u_t028_003/c0_w0_bl u_t028_003/c0_w0_br u_t028_003/c0_w1_bl u_t028_003/c0_w1_br
+ u_t028_003/c0_r0_rbl u_t028_003/c0_r1_rbl u_t028_003/c1_w0_bl u_t028_003/c1_w0_br
+ u_t028_003/c1_w1_bl u_t028_003/c1_w1_br u_t028_003/c1_r0_rbl u_t028_003/c1_r1_rbl
+ u_t028_003/c2_w0_bl u_t028_003/c2_w0_br u_t028_003/c2_w1_bl u_t028_003/c2_w1_br
+ u_t028_003/c2_r0_rbl u_t028_003/c2_r1_rbl u_t028_003/c3_w0_bl u_t028_003/c3_w0_br
+ u_t028_003/c3_w1_bl u_t028_003/c3_w1_br u_t028_003/c3_r0_rbl u_t028_003/c3_r1_rbl
+ u_t028_003/r0_w0_wl u_t028_003/r0_w1_wl u_t028_003/r0_r0_rwl u_t028_003/r0_r1_rwl
+ u_t028_003/r1_w0_wl u_t028_003/r1_w1_wl u_t028_003/r1_r0_rwl u_t028_003/r1_r1_rwl
+ u_t028_003/r2_w0_wl u_t028_003/r2_w1_wl u_t028_003/r2_r0_rwl u_t028_003/r2_r1_rwl
+ u_t028_003/r3_w0_wl u_t028_003/r3_w1_wl u_t028_003/r3_r0_rwl u_t028_003/r3_r1_rwl
+ u_t029_003/VDD u_t028_003/VSS VSUBS detronyx_12t_2w2r_rc4_4x4_routed_5layer_direct
Xu_t019_025 u_t019_025/c0_w0_bl u_t019_025/c0_w0_br u_t019_025/c0_w1_bl u_t019_025/c0_w1_br
+ u_t019_025/c0_r0_rbl u_t019_025/c0_r1_rbl u_t019_025/c1_w0_bl u_t019_025/c1_w0_br
+ u_t019_025/c1_w1_bl u_t019_025/c1_w1_br u_t019_025/c1_r0_rbl u_t019_025/c1_r1_rbl
+ u_t019_025/c2_w0_bl u_t019_025/c2_w0_br u_t019_025/c2_w1_bl u_t019_025/c2_w1_br
+ u_t019_025/c2_r0_rbl u_t019_025/c2_r1_rbl u_t019_025/c3_w0_bl u_t019_025/c3_w0_br
+ u_t019_025/c3_w1_bl u_t019_025/c3_w1_br u_t019_025/c3_r0_rbl u_t019_025/c3_r1_rbl
+ u_t019_025/r0_w0_wl u_t019_025/r0_w1_wl u_t019_025/r0_r0_rwl u_t019_025/r0_r1_rwl
+ u_t019_025/r1_w0_wl u_t019_025/r1_w1_wl u_t019_025/r1_r0_rwl u_t019_025/r1_r1_rwl
+ u_t019_025/r2_w0_wl u_t019_025/r2_w1_wl u_t019_025/r2_r0_rwl u_t019_025/r2_r1_rwl
+ u_t019_025/r3_w0_wl u_t019_025/r3_w1_wl u_t019_025/r3_r0_rwl u_t019_025/r3_r1_rwl
+ VSS u_t019_025/VSS VSUBS detronyx_12t_2w2r_rc4_4x4_routed_5layer_direct
Xu_t019_014 u_t019_014/c0_w0_bl u_t019_014/c0_w0_br u_t019_014/c0_w1_bl u_t019_014/c0_w1_br
+ u_t019_014/c0_r0_rbl u_t019_014/c0_r1_rbl u_t019_014/c1_w0_bl u_t019_014/c1_w0_br
+ u_t019_014/c1_w1_bl u_t019_014/c1_w1_br u_t019_014/c1_r0_rbl u_t019_014/c1_r1_rbl
+ u_t019_014/c2_w0_bl u_t019_014/c2_w0_br u_t019_014/c2_w1_bl u_t019_014/c2_w1_br
+ u_t019_014/c2_r0_rbl u_t019_014/c2_r1_rbl u_t019_014/c3_w0_bl u_t019_014/c3_w0_br
+ u_t019_014/c3_w1_bl u_t019_014/c3_w1_br u_t019_014/c3_r0_rbl u_t019_014/c3_r1_rbl
+ u_t019_014/r0_w0_wl u_t019_014/r0_w1_wl u_t019_014/r0_r0_rwl u_t019_014/r0_r1_rwl
+ u_t019_014/r1_w0_wl u_t019_014/r1_w1_wl u_t019_014/r1_r0_rwl u_t019_014/r1_r1_rwl
+ u_t019_014/r2_w0_wl u_t019_014/r2_w1_wl u_t019_014/r2_r0_rwl u_t019_014/r2_r1_rwl
+ u_t019_014/r3_w0_wl u_t019_014/r3_w1_wl u_t019_014/r3_r0_rwl u_t019_014/r3_r1_rwl
+ u_t019_014/VDD u_t019_017/VSS VSUBS detronyx_12t_2w2r_rc4_4x4_routed_5layer_direct
Xu_t019_003 u_t019_003/c0_w0_bl u_t019_003/c0_w0_br u_t019_003/c0_w1_bl u_t019_003/c0_w1_br
+ u_t019_003/c0_r0_rbl u_t019_003/c0_r1_rbl u_t019_003/c1_w0_bl u_t019_003/c1_w0_br
+ u_t019_003/c1_w1_bl u_t019_003/c1_w1_br u_t019_003/c1_r0_rbl u_t019_003/c1_r1_rbl
+ u_t019_003/c2_w0_bl u_t019_003/c2_w0_br u_t019_003/c2_w1_bl u_t019_003/c2_w1_br
+ u_t019_003/c2_r0_rbl u_t019_003/c2_r1_rbl u_t019_003/c3_w0_bl u_t019_003/c3_w0_br
+ u_t019_003/c3_w1_bl u_t019_003/c3_w1_br u_t019_003/c3_r0_rbl u_t019_003/c3_r1_rbl
+ u_t019_003/r0_w0_wl u_t019_003/r0_w1_wl u_t019_003/r0_r0_rwl u_t019_003/r0_r1_rwl
+ u_t019_003/r1_w0_wl u_t019_003/r1_w1_wl u_t019_003/r1_r0_rwl u_t019_003/r1_r1_rwl
+ u_t019_003/r2_w0_wl u_t019_003/r2_w1_wl u_t019_003/r2_r0_rwl u_t019_003/r2_r1_rwl
+ u_t019_003/r3_w0_wl u_t019_003/r3_w1_wl u_t019_003/r3_r0_rwl u_t019_003/r3_r1_rwl
+ u_t019_003/VDD u_t019_003/VSS VSUBS detronyx_12t_2w2r_rc4_4x4_routed_5layer_direct
Xgf180mcu_as_sc_mcu7t3v3__nand4_2_29 gf180mcu_as_sc_mcu7t3v3__inv_2_91/VDD gf180mcu_as_sc_mcu7t3v3__inv_2_95/VDD
+ VSS VSS VSS VSS gf180mcu_as_sc_mcu7t3v3__nand4_2_29/Y gf180mcu_as_sc_mcu7t3v3__inv_2_91/VNW
+ VSUBS gf180mcu_as_sc_mcu7t3v3__nand4_2
Xgf180mcu_as_sc_mcu7t3v3__nand4_2_18 gf180mcu_as_sc_mcu7t3v3__inv_2_73/VDD gf180mcu_as_sc_mcu7t3v3__inv_2_74/VDD
+ VSS VSS VSS VSS VSS gf180mcu_as_sc_mcu7t3v3__inv_2_73/VNW VSUBS gf180mcu_as_sc_mcu7t3v3__nand4_2
Xu_t025_028 u_t025_028/c0_w0_bl u_t025_028/c0_w0_br u_t025_028/c0_w1_bl u_t025_028/c0_w1_br
+ u_t025_028/c0_r0_rbl u_t025_028/c0_r1_rbl u_t025_028/c1_w0_bl u_t025_028/c1_w0_br
+ u_t025_028/c1_w1_bl u_t025_028/c1_w1_br u_t025_028/c1_r0_rbl u_t025_028/c1_r1_rbl
+ u_t025_028/c2_w0_bl u_t025_028/c2_w0_br u_t025_028/c2_w1_bl u_t025_028/c2_w1_br
+ u_t025_028/c2_r0_rbl u_t025_028/c2_r1_rbl u_t025_028/c3_w0_bl u_t025_028/c3_w0_br
+ u_t025_028/c3_w1_bl u_t025_028/c3_w1_br u_t025_028/c3_r0_rbl u_t025_028/c3_r1_rbl
+ u_t025_028/r0_w0_wl u_t025_028/r0_w1_wl u_t025_028/r0_r0_rwl u_t025_028/r0_r1_rwl
+ u_t025_028/r1_w0_wl u_t025_028/r1_w1_wl u_t025_028/r1_r0_rwl u_t025_028/r1_r1_rwl
+ u_t025_028/r2_w0_wl u_t025_028/r2_w1_wl u_t025_028/r2_r0_rwl u_t025_028/r2_r1_rwl
+ u_t025_028/r3_w0_wl u_t025_028/r3_w1_wl u_t025_028/r3_r0_rwl u_t025_028/r3_r1_rwl
+ u_t025_028/VDD u_t025_031/VSS VSUBS detronyx_12t_2w2r_rc4_4x4_routed_5layer_direct
Xu_t025_017 u_t025_017/c0_w0_bl u_t025_017/c0_w0_br u_t025_017/c0_w1_bl u_t025_017/c0_w1_br
+ u_t025_017/c0_r0_rbl u_t025_017/c0_r1_rbl u_t025_017/c1_w0_bl u_t025_017/c1_w0_br
+ u_t025_017/c1_w1_bl u_t025_017/c1_w1_br u_t025_017/c1_r0_rbl u_t025_017/c1_r1_rbl
+ u_t025_017/c2_w0_bl u_t025_017/c2_w0_br u_t025_017/c2_w1_bl u_t025_017/c2_w1_br
+ u_t025_017/c2_r0_rbl u_t025_017/c2_r1_rbl u_t025_017/c3_w0_bl u_t025_017/c3_w0_br
+ u_t025_017/c3_w1_bl u_t025_017/c3_w1_br u_t025_017/c3_r0_rbl u_t025_017/c3_r1_rbl
+ u_t025_017/r0_w0_wl u_t025_017/r0_w1_wl u_t025_017/r0_r0_rwl u_t025_017/r0_r1_rwl
+ u_t025_017/r1_w0_wl u_t025_017/r1_w1_wl u_t025_017/r1_r0_rwl u_t025_017/r1_r1_rwl
+ u_t025_017/r2_w0_wl u_t025_017/r2_w1_wl u_t025_017/r2_r0_rwl u_t025_017/r2_r1_rwl
+ u_t025_017/r3_w0_wl u_t025_017/r3_w1_wl u_t025_017/r3_r0_rwl u_t025_017/r3_r1_rwl
+ VSS u_t025_031/VSS VSUBS detronyx_12t_2w2r_rc4_4x4_routed_5layer_direct
Xu_t025_006 u_t025_006/c0_w0_bl u_t025_006/c0_w0_br u_t025_006/c0_w1_bl u_t025_006/c0_w1_br
+ u_t025_006/c0_r0_rbl u_t025_006/c0_r1_rbl u_t025_006/c1_w0_bl u_t025_006/c1_w0_br
+ u_t025_006/c1_w1_bl u_t025_006/c1_w1_br u_t025_006/c1_r0_rbl u_t025_006/c1_r1_rbl
+ u_t025_006/c2_w0_bl u_t025_006/c2_w0_br u_t025_006/c2_w1_bl u_t025_006/c2_w1_br
+ u_t025_006/c2_r0_rbl u_t025_006/c2_r1_rbl u_t025_006/c3_w0_bl u_t025_006/c3_w0_br
+ u_t025_006/c3_w1_bl u_t025_006/c3_w1_br u_t025_006/c3_r0_rbl u_t025_006/c3_r1_rbl
+ u_t025_006/r0_w0_wl u_t025_006/r0_w1_wl u_t025_006/r0_r0_rwl u_t025_006/r0_r1_rwl
+ u_t025_006/r1_w0_wl u_t025_006/r1_w1_wl u_t025_006/r1_r0_rwl u_t025_006/r1_r1_rwl
+ u_t025_006/r2_w0_wl u_t025_006/r2_w1_wl u_t025_006/r2_r0_rwl u_t025_006/r2_r1_rwl
+ u_t025_006/r3_w0_wl u_t025_006/r3_w1_wl u_t025_006/r3_r0_rwl u_t025_006/r3_r1_rwl
+ u_t025_006/VDD u_t025_031/VSS VSUBS detronyx_12t_2w2r_rc4_4x4_routed_5layer_direct
Xgf180mcu_as_sc_mcu7t3v3__inv_2_1126 gf180mcu_as_sc_mcu7t3v3__inv_2_1126/VDD VSS gf180mcu_as_sc_mcu7t3v3__inv_2_1126/Y
+ VSS gf180mcu_as_sc_mcu7t3v3__inv_2_1126/VNW VSUBS gf180mcu_as_sc_mcu7t3v3__inv_2
Xgf180mcu_as_sc_mcu7t3v3__inv_2_1115 gf180mcu_as_sc_mcu7t3v3__inv_2_1117/VDD VSS VSS
+ gf180mcu_as_sc_mcu7t3v3__inv_2_1115/A gf180mcu_as_sc_mcu7t3v3__inv_2_1117/VNW VSUBS
+ gf180mcu_as_sc_mcu7t3v3__inv_2
Xgf180mcu_as_sc_mcu7t3v3__inv_2_1104 VSS gf180mcu_as_sc_mcu7t3v3__inv_2_1107/VDD gf180mcu_as_sc_mcu7t3v3__inv_2_1104/Y
+ VSS gf180mcu_as_sc_mcu7t3v3__inv_2_1104/VNW VSUBS gf180mcu_as_sc_mcu7t3v3__inv_2
Xgf180mcu_as_sc_mcu7t3v3__inv_2_1137 VSS gf180mcu_as_sc_mcu7t3v3__inv_2_1141/VDD VSS
+ gf180mcu_as_sc_mcu7t3v3__inv_2_1138/Y gf180mcu_as_sc_mcu7t3v3__inv_2_1138/VNW VSUBS
+ gf180mcu_as_sc_mcu7t3v3__inv_2
Xgf180mcu_as_sc_mcu7t3v3__inv_2_1148 VSS VSS VSS VSS gf180mcu_as_sc_mcu7t3v3__inv_2_1156/VNW
+ VSUBS gf180mcu_as_sc_mcu7t3v3__inv_2
Xgf180mcu_as_sc_mcu7t3v3__inv_2_1159 VSS VSS VSS VSS gf180mcu_as_sc_mcu7t3v3__inv_2_1160/VNW
+ VSUBS gf180mcu_as_sc_mcu7t3v3__inv_2
Xu_t016_028 u_t016_028/c0_w0_bl u_t016_028/c0_w0_br u_t016_028/c0_w1_bl u_t016_028/c0_w1_br
+ u_t016_028/c0_r0_rbl u_t016_028/c0_r1_rbl u_t016_028/c1_w0_bl u_t016_028/c1_w0_br
+ u_t016_028/c1_w1_bl u_t016_028/c1_w1_br u_t016_028/c1_r0_rbl u_t016_028/c1_r1_rbl
+ u_t016_028/c2_w0_bl u_t016_028/c2_w0_br u_t016_028/c2_w1_bl u_t016_028/c2_w1_br
+ u_t016_028/c2_r0_rbl u_t016_028/c2_r1_rbl u_t016_028/c3_w0_bl u_t016_028/c3_w0_br
+ u_t016_028/c3_w1_bl u_t016_028/c3_w1_br u_t016_028/c3_r0_rbl u_t016_028/c3_r1_rbl
+ u_t016_028/r0_w0_wl u_t016_028/r0_w1_wl u_t016_028/r0_r0_rwl u_t016_028/r0_r1_rwl
+ u_t016_028/r1_w0_wl u_t016_028/r1_w1_wl u_t016_028/r1_r0_rwl u_t016_028/r1_r1_rwl
+ u_t016_028/r2_w0_wl u_t016_028/r2_w1_wl u_t016_028/r2_r0_rwl u_t016_028/r2_r1_rwl
+ u_t016_028/r3_w0_wl u_t016_028/r3_w1_wl u_t016_028/r3_r0_rwl u_t016_028/r3_r1_rwl
+ u_t016_028/VDD u_t016_028/VSS VSUBS detronyx_12t_2w2r_rc4_4x4_routed_5layer_direct
Xu_t016_017 u_t016_017/c0_w0_bl u_t016_017/c0_w0_br u_t016_017/c0_w1_bl u_t016_017/c0_w1_br
+ u_t016_017/c0_r0_rbl u_t016_017/c0_r1_rbl u_t016_017/c1_w0_bl u_t016_017/c1_w0_br
+ u_t016_017/c1_w1_bl u_t016_017/c1_w1_br u_t016_017/c1_r0_rbl u_t016_017/c1_r1_rbl
+ u_t016_017/c2_w0_bl u_t016_017/c2_w0_br u_t016_017/c2_w1_bl u_t016_017/c2_w1_br
+ u_t016_017/c2_r0_rbl u_t016_017/c2_r1_rbl u_t016_017/c3_w0_bl u_t016_017/c3_w0_br
+ u_t016_017/c3_w1_bl u_t016_017/c3_w1_br u_t016_017/c3_r0_rbl u_t016_017/c3_r1_rbl
+ u_t016_017/r0_w0_wl u_t016_017/r0_w1_wl u_t016_017/r0_r0_rwl u_t016_017/r0_r1_rwl
+ u_t016_017/r1_w0_wl u_t016_017/r1_w1_wl u_t016_017/r1_r0_rwl u_t016_017/r1_r1_rwl
+ u_t016_017/r2_w0_wl u_t016_017/r2_w1_wl u_t016_017/r2_r0_rwl u_t016_017/r2_r1_rwl
+ u_t016_017/r3_w0_wl u_t016_017/r3_w1_wl u_t016_017/r3_r0_rwl u_t016_017/r3_r1_rwl
+ VSS u_t016_017/VSS VSUBS detronyx_12t_2w2r_rc4_4x4_routed_5layer_direct
Xu_t031_009 u_t031_009/c0_w0_bl u_t031_009/c0_w0_br u_t031_009/c0_w1_bl u_t031_009/c0_w1_br
+ u_t031_009/c0_r0_rbl u_t031_009/c0_r1_rbl u_t031_009/c1_w0_bl u_t031_009/c1_w0_br
+ u_t031_009/c1_w1_bl u_t031_009/c1_w1_br u_t031_009/c1_r0_rbl u_t031_009/c1_r1_rbl
+ u_t031_009/c2_w0_bl u_t031_009/c2_w0_br u_t031_009/c2_w1_bl u_t031_009/c2_w1_br
+ u_t031_009/c2_r0_rbl u_t031_009/c2_r1_rbl u_t031_009/c3_w0_bl u_t031_009/c3_w0_br
+ u_t031_009/c3_w1_bl u_t031_009/c3_w1_br u_t031_009/c3_r0_rbl u_t031_009/c3_r1_rbl
+ u_t031_009/r0_w0_wl u_t031_009/r0_w1_wl u_t031_009/r0_r0_rwl u_t031_009/r0_r1_rwl
+ u_t031_009/r1_w0_wl u_t031_009/r1_w1_wl u_t031_009/r1_r0_rwl u_t031_009/r1_r1_rwl
+ u_t031_009/r2_w0_wl u_t031_009/r2_w1_wl u_t031_009/r2_r0_rwl u_t031_009/r2_r1_rwl
+ u_t031_009/r3_w0_wl u_t031_009/r3_w1_wl u_t031_009/r3_r0_rwl u_t031_009/r3_r1_rwl
+ VSS u_t031_009/VSS VSUBS detronyx_12t_2w2r_rc4_4x4_routed_5layer_direct
Xu_t016_006 u_t016_006/c0_w0_bl u_t016_006/c0_w0_br u_t016_006/c0_w1_bl u_t016_006/c0_w1_br
+ u_t016_006/c0_r0_rbl u_t016_006/c0_r1_rbl u_t016_006/c1_w0_bl u_t016_006/c1_w0_br
+ u_t016_006/c1_w1_bl u_t016_006/c1_w1_br u_t016_006/c1_r0_rbl u_t016_006/c1_r1_rbl
+ u_t016_006/c2_w0_bl u_t016_006/c2_w0_br u_t016_006/c2_w1_bl u_t016_006/c2_w1_br
+ u_t016_006/c2_r0_rbl u_t016_006/c2_r1_rbl u_t016_006/c3_w0_bl u_t016_006/c3_w0_br
+ u_t016_006/c3_w1_bl u_t016_006/c3_w1_br u_t016_006/c3_r0_rbl u_t016_006/c3_r1_rbl
+ u_t016_006/r0_w0_wl u_t016_006/r0_w1_wl u_t016_006/r0_r0_rwl u_t016_006/r0_r1_rwl
+ u_t016_006/r1_w0_wl u_t016_006/r1_w1_wl u_t016_006/r1_r0_rwl u_t016_006/r1_r1_rwl
+ u_t016_006/r2_w0_wl u_t016_006/r2_w1_wl u_t016_006/r2_r0_rwl u_t016_006/r2_r1_rwl
+ u_t016_006/r3_w0_wl u_t016_006/r3_w1_wl u_t016_006/r3_r0_rwl u_t016_006/r3_r1_rwl
+ u_t016_006/VDD u_t016_009/VSS VSUBS detronyx_12t_2w2r_rc4_4x4_routed_5layer_direct
Xgf180mcu_as_sc_mcu7t3v3__inv_2_1671 gf180mcu_as_sc_mcu7t3v3__inv_2_1671/VDD gf180mcu_as_sc_mcu7t3v3__inv_2_1672/VDD
+ gf180mcu_as_sc_mcu7t3v3__inv_2_1675/Y VSS gf180mcu_as_sc_mcu7t3v3__inv_2_1671/VNW
+ VSUBS gf180mcu_as_sc_mcu7t3v3__inv_2
Xgf180mcu_as_sc_mcu7t3v3__inv_2_1660 gf180mcu_as_sc_mcu7t3v3__inv_2_1660/VDD VSS gf180mcu_as_sc_mcu7t3v3__inv_2_1660/Y
+ VSS gf180mcu_as_sc_mcu7t3v3__inv_2_1660/VNW VSUBS gf180mcu_as_sc_mcu7t3v3__inv_2
Xgf180mcu_as_sc_mcu7t3v3__inv_2_1682 VSS gf180mcu_as_sc_mcu7t3v3__inv_2_1682/VSS gf180mcu_as_sc_mcu7t3v3__inv_2_1682/Y
+ VSS gf180mcu_as_sc_mcu7t3v3__inv_2_1682/VNW VSUBS gf180mcu_as_sc_mcu7t3v3__inv_2
Xgf180mcu_as_sc_mcu7t3v3__inv_2_1693 gf180mcu_as_sc_mcu7t3v3__inv_2_1694/VDD VSS gf180mcu_as_sc_mcu7t3v3__inv_2_1693/Y
+ VSS gf180mcu_as_sc_mcu7t3v3__inv_2_1694/VNW VSUBS gf180mcu_as_sc_mcu7t3v3__inv_2
Xu_t007_028 u_t007_028/c0_w0_bl u_t007_028/c0_w0_br u_t007_028/c0_w1_bl u_t007_028/c0_w1_br
+ u_t007_028/c0_r0_rbl u_t007_028/c0_r1_rbl u_t007_028/c1_w0_bl u_t007_028/c1_w0_br
+ u_t007_028/c1_w1_bl u_t007_028/c1_w1_br u_t007_028/c1_r0_rbl u_t007_028/c1_r1_rbl
+ u_t007_028/c2_w0_bl u_t007_028/c2_w0_br u_t007_028/c2_w1_bl u_t007_028/c2_w1_br
+ u_t007_028/c2_r0_rbl u_t007_028/c2_r1_rbl u_t007_028/c3_w0_bl u_t007_028/c3_w0_br
+ u_t007_028/c3_w1_bl u_t007_028/c3_w1_br u_t007_028/c3_r0_rbl u_t007_028/c3_r1_rbl
+ u_t007_028/r0_w0_wl u_t007_028/r0_w1_wl u_t007_028/r0_r0_rwl u_t007_028/r0_r1_rwl
+ u_t007_028/r1_w0_wl u_t007_028/r1_w1_wl u_t007_028/r1_r0_rwl u_t007_028/r1_r1_rwl
+ u_t007_028/r2_w0_wl u_t007_028/r2_w1_wl u_t007_028/r2_r0_rwl u_t007_028/r2_r1_rwl
+ u_t007_028/r3_w0_wl u_t007_028/r3_w1_wl u_t007_028/r3_r0_rwl u_t007_028/r3_r1_rwl
+ u_t008_028/VDD u_t007_028/VSS VSUBS detronyx_12t_2w2r_rc4_4x4_routed_5layer_direct
Xu_t007_017 u_t007_017/c0_w0_bl u_t007_017/c0_w0_br u_t007_017/c0_w1_bl u_t007_017/c0_w1_br
+ u_t007_017/c0_r0_rbl u_t007_017/c0_r1_rbl u_t007_017/c1_w0_bl u_t007_017/c1_w0_br
+ u_t007_017/c1_w1_bl u_t007_017/c1_w1_br u_t007_017/c1_r0_rbl u_t007_017/c1_r1_rbl
+ u_t007_017/c2_w0_bl u_t007_017/c2_w0_br u_t007_017/c2_w1_bl u_t007_017/c2_w1_br
+ u_t007_017/c2_r0_rbl u_t007_017/c2_r1_rbl u_t007_017/c3_w0_bl u_t007_017/c3_w0_br
+ u_t007_017/c3_w1_bl u_t007_017/c3_w1_br u_t007_017/c3_r0_rbl u_t007_017/c3_r1_rbl
+ u_t007_017/r0_w0_wl u_t007_017/r0_w1_wl u_t007_017/r0_r0_rwl u_t007_017/r0_r1_rwl
+ u_t007_017/r1_w0_wl u_t007_017/r1_w1_wl u_t007_017/r1_r0_rwl u_t007_017/r1_r1_rwl
+ u_t007_017/r2_w0_wl u_t007_017/r2_w1_wl u_t007_017/r2_r0_rwl u_t007_017/r2_r1_rwl
+ u_t007_017/r3_w0_wl u_t007_017/r3_w1_wl u_t007_017/r3_r0_rwl u_t007_017/r3_r1_rwl
+ VSS u_t007_017/VSS VSUBS detronyx_12t_2w2r_rc4_4x4_routed_5layer_direct
Xu_t007_006 u_t007_006/c0_w0_bl u_t007_006/c0_w0_br u_t007_006/c0_w1_bl u_t007_006/c0_w1_br
+ u_t007_006/c0_r0_rbl u_t007_006/c0_r1_rbl u_t007_006/c1_w0_bl u_t007_006/c1_w0_br
+ u_t007_006/c1_w1_bl u_t007_006/c1_w1_br u_t007_006/c1_r0_rbl u_t007_006/c1_r1_rbl
+ u_t007_006/c2_w0_bl u_t007_006/c2_w0_br u_t007_006/c2_w1_bl u_t007_006/c2_w1_br
+ u_t007_006/c2_r0_rbl u_t007_006/c2_r1_rbl u_t007_006/c3_w0_bl u_t007_006/c3_w0_br
+ u_t007_006/c3_w1_bl u_t007_006/c3_w1_br u_t007_006/c3_r0_rbl u_t007_006/c3_r1_rbl
+ u_t007_006/r0_w0_wl u_t007_006/r0_w1_wl u_t007_006/r0_r0_rwl u_t007_006/r0_r1_rwl
+ u_t007_006/r1_w0_wl u_t007_006/r1_w1_wl u_t007_006/r1_r0_rwl u_t007_006/r1_r1_rwl
+ u_t007_006/r2_w0_wl u_t007_006/r2_w1_wl u_t007_006/r2_r0_rwl u_t007_006/r2_r1_rwl
+ u_t007_006/r3_w0_wl u_t007_006/r3_w1_wl u_t007_006/r3_r0_rwl u_t007_006/r3_r1_rwl
+ u_t008_006/VDD u_t007_009/VSS VSUBS detronyx_12t_2w2r_rc4_4x4_routed_5layer_direct
Xu_t030_031 u_t030_031/c0_w0_bl u_t030_031/c0_w0_br u_t030_031/c0_w1_bl u_t030_031/c0_w1_br
+ u_t030_031/c0_r0_rbl u_t030_031/c0_r1_rbl u_t030_031/c1_w0_bl u_t030_031/c1_w0_br
+ u_t030_031/c1_w1_bl u_t030_031/c1_w1_br u_t030_031/c1_r0_rbl u_t030_031/c1_r1_rbl
+ u_t030_031/c2_w0_bl u_t030_031/c2_w0_br u_t030_031/c2_w1_bl u_t030_031/c2_w1_br
+ u_t030_031/c2_r0_rbl u_t030_031/c2_r1_rbl u_t030_031/c3_w0_bl u_t030_031/c3_w0_br
+ u_t030_031/c3_w1_bl u_t030_031/c3_w1_br u_t030_031/c3_r0_rbl u_t030_031/c3_r1_rbl
+ u_t030_031/r0_w0_wl u_t030_031/r0_w1_wl u_t030_031/r0_r0_rwl u_t030_031/r0_r1_rwl
+ u_t030_031/r1_w0_wl u_t030_031/r1_w1_wl u_t030_031/r1_r0_rwl u_t030_031/r1_r1_rwl
+ u_t030_031/r2_w0_wl u_t030_031/r2_w1_wl u_t030_031/r2_r0_rwl u_t030_031/r2_r1_rwl
+ u_t030_031/r3_w0_wl u_t030_031/r3_w1_wl u_t030_031/r3_r0_rwl u_t030_031/r3_r1_rwl
+ VSS u_t030_031/VSS VSUBS detronyx_12t_2w2r_rc4_4x4_routed_5layer_direct
Xu_t030_020 u_t030_020/c0_w0_bl u_t030_020/c0_w0_br u_t030_020/c0_w1_bl u_t030_020/c0_w1_br
+ u_t030_020/c0_r0_rbl u_t030_020/c0_r1_rbl u_t030_020/c1_w0_bl u_t030_020/c1_w0_br
+ u_t030_020/c1_w1_bl u_t030_020/c1_w1_br u_t030_020/c1_r0_rbl u_t030_020/c1_r1_rbl
+ u_t030_020/c2_w0_bl u_t030_020/c2_w0_br u_t030_020/c2_w1_bl u_t030_020/c2_w1_br
+ u_t030_020/c2_r0_rbl u_t030_020/c2_r1_rbl u_t030_020/c3_w0_bl u_t030_020/c3_w0_br
+ u_t030_020/c3_w1_bl u_t030_020/c3_w1_br u_t030_020/c3_r0_rbl u_t030_020/c3_r1_rbl
+ u_t030_020/r0_w0_wl u_t030_020/r0_w1_wl u_t030_020/r0_r0_rwl u_t030_020/r0_r1_rwl
+ u_t030_020/r1_w0_wl u_t030_020/r1_w1_wl u_t030_020/r1_r0_rwl u_t030_020/r1_r1_rwl
+ u_t030_020/r2_w0_wl u_t030_020/r2_w1_wl u_t030_020/r2_r0_rwl u_t030_020/r2_r1_rwl
+ u_t030_020/r3_w0_wl u_t030_020/r3_w1_wl u_t030_020/r3_r0_rwl u_t030_020/r3_r1_rwl
+ u_t030_020/VDD u_t030_031/VSS VSUBS detronyx_12t_2w2r_rc4_4x4_routed_5layer_direct
Xu_t022_009 u_t022_009/c0_w0_bl u_t022_009/c0_w0_br u_t022_009/c0_w1_bl u_t022_009/c0_w1_br
+ u_t022_009/c0_r0_rbl u_t022_009/c0_r1_rbl u_t022_009/c1_w0_bl u_t022_009/c1_w0_br
+ u_t022_009/c1_w1_bl u_t022_009/c1_w1_br u_t022_009/c1_r0_rbl u_t022_009/c1_r1_rbl
+ u_t022_009/c2_w0_bl u_t022_009/c2_w0_br u_t022_009/c2_w1_bl u_t022_009/c2_w1_br
+ u_t022_009/c2_r0_rbl u_t022_009/c2_r1_rbl u_t022_009/c3_w0_bl u_t022_009/c3_w0_br
+ u_t022_009/c3_w1_bl u_t022_009/c3_w1_br u_t022_009/c3_r0_rbl u_t022_009/c3_r1_rbl
+ u_t022_009/r0_w0_wl u_t022_009/r0_w1_wl u_t022_009/r0_r0_rwl u_t022_009/r0_r1_rwl
+ u_t022_009/r1_w0_wl u_t022_009/r1_w1_wl u_t022_009/r1_r0_rwl u_t022_009/r1_r1_rwl
+ u_t022_009/r2_w0_wl u_t022_009/r2_w1_wl u_t022_009/r2_r0_rwl u_t022_009/r2_r1_rwl
+ u_t022_009/r3_w0_wl u_t022_009/r3_w1_wl u_t022_009/r3_r0_rwl u_t022_009/r3_r1_rwl
+ VSS u_t022_031/VSS VSUBS detronyx_12t_2w2r_rc4_4x4_routed_5layer_direct
Xgf180mcu_as_sc_mcu7t3v3__nand4_2_454 gf180mcu_as_sc_mcu7t3v3__inv_2_1565/VDD gf180mcu_as_sc_mcu7t3v3__inv_2_1569/VDD
+ VSS VSS VSS VSS gf180mcu_as_sc_mcu7t3v3__nand4_2_454/Y gf180mcu_as_sc_mcu7t3v3__inv_2_1565/VNW
+ VSUBS gf180mcu_as_sc_mcu7t3v3__nand4_2
Xgf180mcu_as_sc_mcu7t3v3__nand4_2_465 VSS gf180mcu_as_sc_mcu7t3v3__inv_2_1592/VSS
+ VSS VSS VSS VSS gf180mcu_as_sc_mcu7t3v3__nand4_2_465/Y gf180mcu_as_sc_mcu7t3v3__inv_2_1592/VNW
+ VSUBS gf180mcu_as_sc_mcu7t3v3__nand4_2
Xgf180mcu_as_sc_mcu7t3v3__nand4_2_476 gf180mcu_as_sc_mcu7t3v3__inv_2_1592/VSS gf180mcu_as_sc_mcu7t3v3__inv_2_1548/VSS
+ VSS VSS VSS VSS gf180mcu_as_sc_mcu7t3v3__nand4_2_476/Y gf180mcu_as_sc_mcu7t3v3__inv_2_1548/VNW
+ VSUBS gf180mcu_as_sc_mcu7t3v3__nand4_2
Xgf180mcu_as_sc_mcu7t3v3__nand4_2_487 VSS VSS VSS VSS VSS VSS VSS gf180mcu_as_sc_mcu7t3v3__inv_2_1661/VNW
+ VSUBS gf180mcu_as_sc_mcu7t3v3__nand4_2
Xgf180mcu_as_sc_mcu7t3v3__nand4_2_443 gf180mcu_as_sc_mcu7t3v3__inv_2_1485/VSS gf180mcu_as_sc_mcu7t3v3__inv_2_1468/VDD
+ VSS VSS VSS VSS gf180mcu_as_sc_mcu7t3v3__nand4_2_443/Y gf180mcu_as_sc_mcu7t3v3__inv_2_1465/VNW
+ VSUBS gf180mcu_as_sc_mcu7t3v3__nand4_2
Xgf180mcu_as_sc_mcu7t3v3__nand4_2_432 VSS VSS VSS VSS VSS VSS VSS gf180mcu_as_sc_mcu7t3v3__inv_2_1472/VNW
+ VSUBS gf180mcu_as_sc_mcu7t3v3__nand4_2
Xgf180mcu_as_sc_mcu7t3v3__nand4_2_410 gf180mcu_as_sc_mcu7t3v3__inv_2_1391/VDD VSS
+ VSS VSS VSS VSS VSS gf180mcu_as_sc_mcu7t3v3__inv_2_1391/VNW VSUBS gf180mcu_as_sc_mcu7t3v3__nand4_2
Xgf180mcu_as_sc_mcu7t3v3__nand4_2_421 gf180mcu_as_sc_mcu7t3v3__inv_2_1428/VDD gf180mcu_as_sc_mcu7t3v3__inv_2_1432/VDD
+ VSS VSS VSS VSS gf180mcu_as_sc_mcu7t3v3__nand4_2_421/Y gf180mcu_as_sc_mcu7t3v3__inv_2_1428/VNW
+ VSUBS gf180mcu_as_sc_mcu7t3v3__nand4_2
Xu_t013_009 u_t013_009/c0_w0_bl u_t013_009/c0_w0_br u_t013_009/c0_w1_bl u_t013_009/c0_w1_br
+ u_t013_009/c0_r0_rbl u_t013_009/c0_r1_rbl u_t013_009/c1_w0_bl u_t013_009/c1_w0_br
+ u_t013_009/c1_w1_bl u_t013_009/c1_w1_br u_t013_009/c1_r0_rbl u_t013_009/c1_r1_rbl
+ u_t013_009/c2_w0_bl u_t013_009/c2_w0_br u_t013_009/c2_w1_bl u_t013_009/c2_w1_br
+ u_t013_009/c2_r0_rbl u_t013_009/c2_r1_rbl u_t013_009/c3_w0_bl u_t013_009/c3_w0_br
+ u_t013_009/c3_w1_bl u_t013_009/c3_w1_br u_t013_009/c3_r0_rbl u_t013_009/c3_r1_rbl
+ u_t013_009/r0_w0_wl u_t013_009/r0_w1_wl u_t013_009/r0_r0_rwl u_t013_009/r0_r1_rwl
+ u_t013_009/r1_w0_wl u_t013_009/r1_w1_wl u_t013_009/r1_r0_rwl u_t013_009/r1_r1_rwl
+ u_t013_009/r2_w0_wl u_t013_009/r2_w1_wl u_t013_009/r2_r0_rwl u_t013_009/r2_r1_rwl
+ u_t013_009/r3_w0_wl u_t013_009/r3_w1_wl u_t013_009/r3_r0_rwl u_t013_009/r3_r1_rwl
+ VSS u_t013_031/VSS VSUBS detronyx_12t_2w2r_rc4_4x4_routed_5layer_direct
Xgf180mcu_as_sc_mcu7t3v3__nand4_2_498 gf180mcu_as_sc_mcu7t3v3__inv_2_1672/VDD VSS
+ VSS VSS VSS VSS VSS gf180mcu_as_sc_mcu7t3v3__inv_2_1672/VNW VSUBS gf180mcu_as_sc_mcu7t3v3__nand4_2
Xgf180mcu_as_sc_mcu7t3v3__inv_2_0 gf180mcu_as_sc_mcu7t3v3__inv_2_9/VSS gf180mcu_as_sc_mcu7t3v3__inv_2_0/VSS
+ gf180mcu_as_sc_mcu7t3v3__inv_2_0/Y gf180mcu_as_sc_mcu7t3v3__inv_2_9/A gf180mcu_as_sc_mcu7t3v3__inv_2_0/VNW
+ VSUBS gf180mcu_as_sc_mcu7t3v3__inv_2
Xu_t021_031 u_t021_031/c0_w0_bl u_t021_031/c0_w0_br u_t021_031/c0_w1_bl u_t021_031/c0_w1_br
+ u_t021_031/c0_r0_rbl u_t021_031/c0_r1_rbl u_t021_031/c1_w0_bl u_t021_031/c1_w0_br
+ u_t021_031/c1_w1_bl u_t021_031/c1_w1_br u_t021_031/c1_r0_rbl u_t021_031/c1_r1_rbl
+ u_t021_031/c2_w0_bl u_t021_031/c2_w0_br u_t021_031/c2_w1_bl u_t021_031/c2_w1_br
+ u_t021_031/c2_r0_rbl u_t021_031/c2_r1_rbl u_t021_031/c3_w0_bl u_t021_031/c3_w0_br
+ u_t021_031/c3_w1_bl u_t021_031/c3_w1_br u_t021_031/c3_r0_rbl u_t021_031/c3_r1_rbl
+ u_t021_031/r0_w0_wl u_t021_031/r0_w1_wl u_t021_031/r0_r0_rwl u_t021_031/r0_r1_rwl
+ u_t021_031/r1_w0_wl u_t021_031/r1_w1_wl u_t021_031/r1_r0_rwl u_t021_031/r1_r1_rwl
+ u_t021_031/r2_w0_wl u_t021_031/r2_w1_wl u_t021_031/r2_r0_rwl u_t021_031/r2_r1_rwl
+ u_t021_031/r3_w0_wl u_t021_031/r3_w1_wl u_t021_031/r3_r0_rwl u_t021_031/r3_r1_rwl
+ VSS u_t021_031/VSS VSUBS detronyx_12t_2w2r_rc4_4x4_routed_5layer_direct
Xu_t021_020 u_t021_020/c0_w0_bl u_t021_020/c0_w0_br u_t021_020/c0_w1_bl u_t021_020/c0_w1_br
+ u_t021_020/c0_r0_rbl u_t021_020/c0_r1_rbl u_t021_020/c1_w0_bl u_t021_020/c1_w0_br
+ u_t021_020/c1_w1_bl u_t021_020/c1_w1_br u_t021_020/c1_r0_rbl u_t021_020/c1_r1_rbl
+ u_t021_020/c2_w0_bl u_t021_020/c2_w0_br u_t021_020/c2_w1_bl u_t021_020/c2_w1_br
+ u_t021_020/c2_r0_rbl u_t021_020/c2_r1_rbl u_t021_020/c3_w0_bl u_t021_020/c3_w0_br
+ u_t021_020/c3_w1_bl u_t021_020/c3_w1_br u_t021_020/c3_r0_rbl u_t021_020/c3_r1_rbl
+ u_t021_020/r0_w0_wl u_t021_020/r0_w1_wl u_t021_020/r0_r0_rwl u_t021_020/r0_r1_rwl
+ u_t021_020/r1_w0_wl u_t021_020/r1_w1_wl u_t021_020/r1_r0_rwl u_t021_020/r1_r1_rwl
+ u_t021_020/r2_w0_wl u_t021_020/r2_w1_wl u_t021_020/r2_r0_rwl u_t021_020/r2_r1_rwl
+ u_t021_020/r3_w0_wl u_t021_020/r3_w1_wl u_t021_020/r3_r0_rwl u_t021_020/r3_r1_rwl
+ u_t021_020/VDD u_t021_031/VSS VSUBS detronyx_12t_2w2r_rc4_4x4_routed_5layer_direct
Xgf180mcu_as_sc_mcu7t3v3__inv_2_407 VSS VSS gf180mcu_as_sc_mcu7t3v3__inv_2_407/Y VSS
+ gf180mcu_as_sc_mcu7t3v3__inv_2_450/VNW VSUBS gf180mcu_as_sc_mcu7t3v3__inv_2
Xgf180mcu_as_sc_mcu7t3v3__inv_2_418 gf180mcu_as_sc_mcu7t3v3__nor2_2_4/VDD gf180mcu_as_sc_mcu7t3v3__nor2_2_4/VSS
+ VSS VSS gf180mcu_as_sc_mcu7t3v3__nor2_2_4/VNW VSUBS gf180mcu_as_sc_mcu7t3v3__inv_2
Xu_t012_031 u_t012_031/c0_w0_bl u_t012_031/c0_w0_br u_t012_031/c0_w1_bl u_t012_031/c0_w1_br
+ u_t012_031/c0_r0_rbl u_t012_031/c0_r1_rbl u_t012_031/c1_w0_bl u_t012_031/c1_w0_br
+ u_t012_031/c1_w1_bl u_t012_031/c1_w1_br u_t012_031/c1_r0_rbl u_t012_031/c1_r1_rbl
+ u_t012_031/c2_w0_bl u_t012_031/c2_w0_br u_t012_031/c2_w1_bl u_t012_031/c2_w1_br
+ u_t012_031/c2_r0_rbl u_t012_031/c2_r1_rbl u_t012_031/c3_w0_bl u_t012_031/c3_w0_br
+ u_t012_031/c3_w1_bl u_t012_031/c3_w1_br u_t012_031/c3_r0_rbl u_t012_031/c3_r1_rbl
+ u_t012_031/r0_w0_wl u_t012_031/r0_w1_wl u_t012_031/r0_r0_rwl u_t012_031/r0_r1_rwl
+ u_t012_031/r1_w0_wl u_t012_031/r1_w1_wl u_t012_031/r1_r0_rwl u_t012_031/r1_r1_rwl
+ u_t012_031/r2_w0_wl u_t012_031/r2_w1_wl u_t012_031/r2_r0_rwl u_t012_031/r2_r1_rwl
+ u_t012_031/r3_w0_wl u_t012_031/r3_w1_wl u_t012_031/r3_r0_rwl u_t012_031/r3_r1_rwl
+ VSS u_t012_031/VSS VSUBS detronyx_12t_2w2r_rc4_4x4_routed_5layer_direct
Xu_t012_020 u_t012_020/c0_w0_bl u_t012_020/c0_w0_br u_t012_020/c0_w1_bl u_t012_020/c0_w1_br
+ u_t012_020/c0_r0_rbl u_t012_020/c0_r1_rbl u_t012_020/c1_w0_bl u_t012_020/c1_w0_br
+ u_t012_020/c1_w1_bl u_t012_020/c1_w1_br u_t012_020/c1_r0_rbl u_t012_020/c1_r1_rbl
+ u_t012_020/c2_w0_bl u_t012_020/c2_w0_br u_t012_020/c2_w1_bl u_t012_020/c2_w1_br
+ u_t012_020/c2_r0_rbl u_t012_020/c2_r1_rbl u_t012_020/c3_w0_bl u_t012_020/c3_w0_br
+ u_t012_020/c3_w1_bl u_t012_020/c3_w1_br u_t012_020/c3_r0_rbl u_t012_020/c3_r1_rbl
+ u_t012_020/r0_w0_wl u_t012_020/r0_w1_wl u_t012_020/r0_r0_rwl u_t012_020/r0_r1_rwl
+ u_t012_020/r1_w0_wl u_t012_020/r1_w1_wl u_t012_020/r1_r0_rwl u_t012_020/r1_r1_rwl
+ u_t012_020/r2_w0_wl u_t012_020/r2_w1_wl u_t012_020/r2_r0_rwl u_t012_020/r2_r1_rwl
+ u_t012_020/r3_w0_wl u_t012_020/r3_w1_wl u_t012_020/r3_r0_rwl u_t012_020/r3_r1_rwl
+ u_t012_020/VDD u_t012_031/VSS VSUBS detronyx_12t_2w2r_rc4_4x4_routed_5layer_direct
Xu_t004_009 u_t004_009/c0_w0_bl u_t004_009/c0_w0_br u_t004_009/c0_w1_bl u_t004_009/c0_w1_br
+ u_t004_009/c0_r0_rbl u_t004_009/c0_r1_rbl u_t004_009/c1_w0_bl u_t004_009/c1_w0_br
+ u_t004_009/c1_w1_bl u_t004_009/c1_w1_br u_t004_009/c1_r0_rbl u_t004_009/c1_r1_rbl
+ u_t004_009/c2_w0_bl u_t004_009/c2_w0_br u_t004_009/c2_w1_bl u_t004_009/c2_w1_br
+ u_t004_009/c2_r0_rbl u_t004_009/c2_r1_rbl u_t004_009/c3_w0_bl u_t004_009/c3_w0_br
+ u_t004_009/c3_w1_bl u_t004_009/c3_w1_br u_t004_009/c3_r0_rbl u_t004_009/c3_r1_rbl
+ u_t004_009/r0_w0_wl u_t004_009/r0_w1_wl u_t004_009/r0_r0_rwl u_t004_009/r0_r1_rwl
+ u_t004_009/r1_w0_wl u_t004_009/r1_w1_wl u_t004_009/r1_r0_rwl u_t004_009/r1_r1_rwl
+ u_t004_009/r2_w0_wl u_t004_009/r2_w1_wl u_t004_009/r2_r0_rwl u_t004_009/r2_r1_rwl
+ u_t004_009/r3_w0_wl u_t004_009/r3_w1_wl u_t004_009/r3_r0_rwl u_t004_009/r3_r1_rwl
+ VSS u_t004_031/VSS VSUBS detronyx_12t_2w2r_rc4_4x4_routed_5layer_direct
Xgf180mcu_as_sc_mcu7t3v3__inv_2_429 gf180mcu_as_sc_mcu7t3v3__nor2_2_4/VDD gf180mcu_as_sc_mcu7t3v3__nor2_2_4/VSS
+ VSS VSS gf180mcu_as_sc_mcu7t3v3__nor2_2_4/VNW VSUBS gf180mcu_as_sc_mcu7t3v3__inv_2
Xgf180mcu_as_sc_mcu7t3v3__inv_2_1490 gf180mcu_as_sc_mcu7t3v3__inv_2_1492/VDD gf180mcu_as_sc_mcu7t3v3__inv_2_1496/VDD
+ VSS VSS gf180mcu_as_sc_mcu7t3v3__inv_2_1492/VNW VSUBS gf180mcu_as_sc_mcu7t3v3__inv_2
Xgf180mcu_as_sc_mcu7t3v3__inv_2_941 VSS VSS VSS VSS gf180mcu_as_sc_mcu7t3v3__inv_2_945/VNW
+ VSUBS gf180mcu_as_sc_mcu7t3v3__inv_2
Xgf180mcu_as_sc_mcu7t3v3__inv_2_930 VSS VSS VSS VSS gf180mcu_as_sc_mcu7t3v3__inv_2_932/VNW
+ VSUBS gf180mcu_as_sc_mcu7t3v3__inv_2
Xgf180mcu_as_sc_mcu7t3v3__inv_2_963 gf180mcu_as_sc_mcu7t3v3__inv_2_967/VDD VSS gf180mcu_as_sc_mcu7t3v3__inv_2_963/Y
+ gf180mcu_as_sc_mcu7t3v3__inv_2_967/Y gf180mcu_as_sc_mcu7t3v3__inv_2_967/VNW VSUBS
+ gf180mcu_as_sc_mcu7t3v3__inv_2
Xgf180mcu_as_sc_mcu7t3v3__inv_2_952 VSS VSS VSS VSS gf180mcu_as_sc_mcu7t3v3__inv_2_954/VNW
+ VSUBS gf180mcu_as_sc_mcu7t3v3__inv_2
Xu_t003_031 u_t003_031/c0_w0_bl u_t003_031/c0_w0_br u_t003_031/c0_w1_bl u_t003_031/c0_w1_br
+ u_t003_031/c0_r0_rbl u_t003_031/c0_r1_rbl u_t003_031/c1_w0_bl u_t003_031/c1_w0_br
+ u_t003_031/c1_w1_bl u_t003_031/c1_w1_br u_t003_031/c1_r0_rbl u_t003_031/c1_r1_rbl
+ u_t003_031/c2_w0_bl u_t003_031/c2_w0_br u_t003_031/c2_w1_bl u_t003_031/c2_w1_br
+ u_t003_031/c2_r0_rbl u_t003_031/c2_r1_rbl u_t003_031/c3_w0_bl u_t003_031/c3_w0_br
+ u_t003_031/c3_w1_bl u_t003_031/c3_w1_br u_t003_031/c3_r0_rbl u_t003_031/c3_r1_rbl
+ u_t003_031/r0_w0_wl u_t003_031/r0_w1_wl u_t003_031/r0_r0_rwl u_t003_031/r0_r1_rwl
+ u_t003_031/r1_w0_wl u_t003_031/r1_w1_wl u_t003_031/r1_r0_rwl u_t003_031/r1_r1_rwl
+ u_t003_031/r2_w0_wl u_t003_031/r2_w1_wl u_t003_031/r2_r0_rwl u_t003_031/r2_r1_rwl
+ u_t003_031/r3_w0_wl u_t003_031/r3_w1_wl u_t003_031/r3_r0_rwl u_t003_031/r3_r1_rwl
+ VSS u_t003_031/VSS VSUBS detronyx_12t_2w2r_rc4_4x4_routed_5layer_direct
Xu_t003_020 u_t003_020/c0_w0_bl u_t003_020/c0_w0_br u_t003_020/c0_w1_bl u_t003_020/c0_w1_br
+ u_t003_020/c0_r0_rbl u_t003_020/c0_r1_rbl u_t003_020/c1_w0_bl u_t003_020/c1_w0_br
+ u_t003_020/c1_w1_bl u_t003_020/c1_w1_br u_t003_020/c1_r0_rbl u_t003_020/c1_r1_rbl
+ u_t003_020/c2_w0_bl u_t003_020/c2_w0_br u_t003_020/c2_w1_bl u_t003_020/c2_w1_br
+ u_t003_020/c2_r0_rbl u_t003_020/c2_r1_rbl u_t003_020/c3_w0_bl u_t003_020/c3_w0_br
+ u_t003_020/c3_w1_bl u_t003_020/c3_w1_br u_t003_020/c3_r0_rbl u_t003_020/c3_r1_rbl
+ u_t003_020/r0_w0_wl u_t003_020/r0_w1_wl u_t003_020/r0_r0_rwl u_t003_020/r0_r1_rwl
+ u_t003_020/r1_w0_wl u_t003_020/r1_w1_wl u_t003_020/r1_r0_rwl u_t003_020/r1_r1_rwl
+ u_t003_020/r2_w0_wl u_t003_020/r2_w1_wl u_t003_020/r2_r0_rwl u_t003_020/r2_r1_rwl
+ u_t003_020/r3_w0_wl u_t003_020/r3_w1_wl u_t003_020/r3_r0_rwl u_t003_020/r3_r1_rwl
+ u_t004_020/VDD u_t003_020/VSS VSUBS detronyx_12t_2w2r_rc4_4x4_routed_5layer_direct
Xgf180mcu_as_sc_mcu7t3v3__inv_2_985 VSS VSS gf180mcu_as_sc_mcu7t3v3__inv_2_988/A gf180mcu_as_sc_mcu7t3v3__inv_2_986/Y
+ gf180mcu_as_sc_mcu7t3v3__inv_2_986/VNW VSUBS gf180mcu_as_sc_mcu7t3v3__inv_2
Xgf180mcu_as_sc_mcu7t3v3__inv_2_974 VSS gf180mcu_as_sc_mcu7t3v3__inv_2_978/VDD gf180mcu_as_sc_mcu7t3v3__inv_2_974/Y
+ VSS gf180mcu_as_sc_mcu7t3v3__inv_2_974/VNW VSUBS gf180mcu_as_sc_mcu7t3v3__inv_2
Xgf180mcu_as_sc_mcu7t3v3__inv_2_996 VSS VSS VSS gf180mcu_as_sc_mcu7t3v3__inv_2_997/Y
+ gf180mcu_as_sc_mcu7t3v3__inv_2_998/VNW VSUBS gf180mcu_as_sc_mcu7t3v3__inv_2
Xgf180mcu_as_sc_mcu7t3v3__nand4_2_273 VSS VSS VSS VSS VSS VSS gf180mcu_as_sc_mcu7t3v3__nand4_2_273/Y
+ gf180mcu_as_sc_mcu7t3v3__inv_2_944/VNW VSUBS gf180mcu_as_sc_mcu7t3v3__nand4_2
Xgf180mcu_as_sc_mcu7t3v3__nand4_2_240 VSS VSS VSS VSS VSS VSS VSS gf180mcu_as_sc_mcu7t3v3__inv_2_804/VNW
+ VSUBS gf180mcu_as_sc_mcu7t3v3__nand4_2
Xgf180mcu_as_sc_mcu7t3v3__nand4_2_262 VSS VSS VSS VSS VSS VSS VSS gf180mcu_as_sc_mcu7t3v3__inv_2_900/VNW
+ VSUBS gf180mcu_as_sc_mcu7t3v3__nand4_2
Xgf180mcu_as_sc_mcu7t3v3__nand4_2_251 VSS VSS VSS VSS VSS VSS gf180mcu_as_sc_mcu7t3v3__nand4_2_251/Y
+ gf180mcu_as_sc_mcu7t3v3__inv_2_856/VNW VSUBS gf180mcu_as_sc_mcu7t3v3__nand4_2
Xgf180mcu_as_sc_mcu7t3v3__nand4_2_295 VSS VSS VSS VSS VSS VSS VSS gf180mcu_as_sc_mcu7t3v3__inv_2_998/VNW
+ VSUBS gf180mcu_as_sc_mcu7t3v3__nand4_2
Xgf180mcu_as_sc_mcu7t3v3__nand4_2_284 gf180mcu_as_sc_mcu7t3v3__inv_2_1056/VDD gf180mcu_as_sc_mcu7t3v3__inv_2_994/VDD
+ VSS VSS VSS VSS VSS gf180mcu_as_sc_mcu7t3v3__inv_2_1056/VNW VSUBS gf180mcu_as_sc_mcu7t3v3__nand4_2
Xgf180mcu_as_sc_mcu7t3v3__inv_2_204 VSS gf180mcu_as_sc_mcu7t3v3__inv_2_206/VDD VSS
+ VSS gf180mcu_as_sc_mcu7t3v3__inv_2_204/VNW VSUBS gf180mcu_as_sc_mcu7t3v3__inv_2
Xgf180mcu_as_sc_mcu7t3v3__inv_2_259 VSS gf180mcu_as_sc_mcu7t3v3__inv_2_260/VSS gf180mcu_as_sc_mcu7t3v3__inv_2_259/Y
+ VSS gf180mcu_as_sc_mcu7t3v3__inv_2_260/VNW VSUBS gf180mcu_as_sc_mcu7t3v3__inv_2
Xgf180mcu_as_sc_mcu7t3v3__inv_2_226 VSS gf180mcu_as_sc_mcu7t3v3__inv_2_228/VSS VSS
+ VSS gf180mcu_as_sc_mcu7t3v3__inv_2_228/VNW VSUBS gf180mcu_as_sc_mcu7t3v3__inv_2
Xgf180mcu_as_sc_mcu7t3v3__inv_2_215 VSS gf180mcu_as_sc_mcu7t3v3__inv_2_220/VDD gf180mcu_as_sc_mcu7t3v3__inv_2_215/Y
+ VSS gf180mcu_as_sc_mcu7t3v3__inv_2_216/VNW VSUBS gf180mcu_as_sc_mcu7t3v3__inv_2
Xgf180mcu_as_sc_mcu7t3v3__inv_2_248 VSS gf180mcu_as_sc_mcu7t3v3__inv_2_257/VDD VSS
+ VSS gf180mcu_as_sc_mcu7t3v3__inv_2_249/VNW VSUBS gf180mcu_as_sc_mcu7t3v3__inv_2
Xgf180mcu_as_sc_mcu7t3v3__inv_2_237 VSS gf180mcu_as_sc_mcu7t3v3__inv_2_241/VDD gf180mcu_as_sc_mcu7t3v3__inv_2_237/Y
+ VSS gf180mcu_as_sc_mcu7t3v3__inv_2_237/VNW VSUBS gf180mcu_as_sc_mcu7t3v3__inv_2
Xu_t000_023 u_t000_023/c0_w0_bl u_t000_023/c0_w0_br u_t000_023/c0_w1_bl u_t000_023/c0_w1_br
+ u_t000_023/c0_r0_rbl u_t000_023/c0_r1_rbl u_t000_023/c1_w0_bl u_t000_023/c1_w0_br
+ u_t000_023/c1_w1_bl u_t000_023/c1_w1_br u_t000_023/c1_r0_rbl u_t000_023/c1_r1_rbl
+ u_t000_023/c2_w0_bl u_t000_023/c2_w0_br u_t000_023/c2_w1_bl u_t000_023/c2_w1_br
+ u_t000_023/c2_r0_rbl u_t000_023/c2_r1_rbl u_t000_023/c3_w0_bl u_t000_023/c3_w0_br
+ u_t000_023/c3_w1_bl u_t000_023/c3_w1_br u_t000_023/c3_r0_rbl u_t000_023/c3_r1_rbl
+ u_t000_023/r0_w0_wl u_t000_023/r0_w1_wl u_t000_023/r0_r0_rwl u_t000_023/r0_r1_rwl
+ u_t000_023/r1_w0_wl u_t000_023/r1_w1_wl u_t000_023/r1_r0_rwl u_t000_023/r1_r1_rwl
+ u_t000_023/r2_w0_wl u_t000_023/r2_w1_wl u_t000_023/r2_r0_rwl u_t000_023/r2_r1_rwl
+ u_t000_023/r3_w0_wl u_t000_023/r3_w1_wl u_t000_023/r3_r0_rwl u_t000_023/r3_r1_rwl
+ VSS u_t000_031/VSS VSUBS detronyx_12t_2w2r_rc4_4x4_routed_5layer_direct
Xu_t000_012 u_t000_012/c0_w0_bl u_t000_012/c0_w0_br u_t000_012/c0_w1_bl u_t000_012/c0_w1_br
+ u_t000_012/c0_r0_rbl u_t000_012/c0_r1_rbl u_t000_012/c1_w0_bl u_t000_012/c1_w0_br
+ u_t000_012/c1_w1_bl u_t000_012/c1_w1_br u_t000_012/c1_r0_rbl u_t000_012/c1_r1_rbl
+ u_t000_012/c2_w0_bl u_t000_012/c2_w0_br u_t000_012/c2_w1_bl u_t000_012/c2_w1_br
+ u_t000_012/c2_r0_rbl u_t000_012/c2_r1_rbl u_t000_012/c3_w0_bl u_t000_012/c3_w0_br
+ u_t000_012/c3_w1_bl u_t000_012/c3_w1_br u_t000_012/c3_r0_rbl u_t000_012/c3_r1_rbl
+ u_t000_012/r0_w0_wl u_t000_012/r0_w1_wl u_t000_012/r0_r0_rwl u_t000_012/r0_r1_rwl
+ u_t000_012/r1_w0_wl u_t000_012/r1_w1_wl u_t000_012/r1_r0_rwl u_t000_012/r1_r1_rwl
+ u_t000_012/r2_w0_wl u_t000_012/r2_w1_wl u_t000_012/r2_r0_rwl u_t000_012/r2_r1_rwl
+ u_t000_012/r3_w0_wl u_t000_012/r3_w1_wl u_t000_012/r3_r0_rwl u_t000_012/r3_r1_rwl
+ u_t000_012/VDD u_t000_031/VSS VSUBS detronyx_12t_2w2r_rc4_4x4_routed_5layer_direct
Xu_t000_001 u_t000_001/c0_w0_bl u_t000_001/c0_w0_br u_t000_001/c0_w1_bl u_t000_001/c0_w1_br
+ u_t000_001/c0_r0_rbl u_t000_001/c0_r1_rbl u_t000_001/c1_w0_bl u_t000_001/c1_w0_br
+ u_t000_001/c1_w1_bl u_t000_001/c1_w1_br u_t000_001/c1_r0_rbl u_t000_001/c1_r1_rbl
+ u_t000_001/c2_w0_bl u_t000_001/c2_w0_br u_t000_001/c2_w1_bl u_t000_001/c2_w1_br
+ u_t000_001/c2_r0_rbl u_t000_001/c2_r1_rbl u_t000_001/c3_w0_bl u_t000_001/c3_w0_br
+ u_t000_001/c3_w1_bl u_t000_001/c3_w1_br u_t000_001/c3_r0_rbl u_t000_001/c3_r1_rbl
+ u_t000_001/r0_w0_wl u_t000_001/r0_w1_wl u_t000_001/r0_r0_rwl u_t000_001/r0_r1_rwl
+ u_t000_001/r1_w0_wl u_t000_001/r1_w1_wl u_t000_001/r1_r0_rwl u_t000_001/r1_r1_rwl
+ u_t000_001/r2_w0_wl u_t000_001/r2_w1_wl u_t000_001/r2_r0_rwl u_t000_001/r2_r1_rwl
+ u_t000_001/r3_w0_wl u_t000_001/r3_w1_wl u_t000_001/r3_r0_rwl u_t000_001/r3_r1_rwl
+ VSS u_t000_031/VSS VSUBS detronyx_12t_2w2r_rc4_4x4_routed_5layer_direct
Xgf180mcu_as_sc_mcu7t3v3__inv_2_771 VSS VSS VSS VSS gf180mcu_as_sc_mcu7t3v3__inv_2_772/VNW
+ VSUBS gf180mcu_as_sc_mcu7t3v3__inv_2
Xgf180mcu_as_sc_mcu7t3v3__inv_2_760 VSS VSS gf180mcu_as_sc_mcu7t3v3__inv_2_760/Y VSS
+ gf180mcu_as_sc_mcu7t3v3__inv_2_760/VNW VSUBS gf180mcu_as_sc_mcu7t3v3__inv_2
Xgf180mcu_as_sc_mcu7t3v3__inv_2_782 VSS VSS gf180mcu_as_sc_mcu7t3v3__inv_2_782/Y VSS
+ gf180mcu_as_sc_mcu7t3v3__inv_2_784/VNW VSUBS gf180mcu_as_sc_mcu7t3v3__inv_2
Xgf180mcu_as_sc_mcu7t3v3__inv_2_793 VSS VSS gf180mcu_as_sc_mcu7t3v3__inv_2_793/Y VSS
+ gf180mcu_as_sc_mcu7t3v3__inv_2_795/VNW VSUBS gf180mcu_as_sc_mcu7t3v3__inv_2
Xgf180mcu_as_sc_mcu7t3v3__inv_2_590 VSS gf180mcu_as_sc_mcu7t3v3__inv_2_636/VSS gf180mcu_as_sc_mcu7t3v3__inv_2_590/Y
+ gf180mcu_as_sc_mcu7t3v3__inv_2_594/Y gf180mcu_as_sc_mcu7t3v3__inv_2_594/VNW VSUBS
+ gf180mcu_as_sc_mcu7t3v3__inv_2
Xgf180mcu_as_sc_mcu7t3v3__nor2_2_5 gf180mcu_as_sc_mcu7t3v3__nor2_2_5/VDD gf180mcu_as_sc_mcu7t3v3__nor2_2_5/VSS
+ VSS VSS VSS gf180mcu_as_sc_mcu7t3v3__nor2_2_5/VNW VSUBS gf180mcu_as_sc_mcu7t3v3__nor2_2
Xgf180mcu_as_sc_mcu7t3v3__inv_2_1308 VSS VSS VSS gf180mcu_as_sc_mcu7t3v3__inv_2_1369/Y
+ gf180mcu_as_sc_mcu7t3v3__inv_2_1367/VNW VSUBS gf180mcu_as_sc_mcu7t3v3__inv_2
Xgf180mcu_as_sc_mcu7t3v3__inv_2_1319 gf180mcu_as_sc_mcu7t3v3__inv_2_1375/VDD gf180mcu_as_sc_mcu7t3v3__inv_2_1376/VDD
+ gf180mcu_as_sc_mcu7t3v3__inv_2_1319/Y gf180mcu_as_sc_mcu7t3v3__inv_2_1379/Y gf180mcu_as_sc_mcu7t3v3__inv_2_1375/VNW
+ VSUBS gf180mcu_as_sc_mcu7t3v3__inv_2
Xu_t028_015 u_t028_015/c0_w0_bl u_t028_015/c0_w0_br u_t028_015/c0_w1_bl u_t028_015/c0_w1_br
+ u_t028_015/c0_r0_rbl u_t028_015/c0_r1_rbl u_t028_015/c1_w0_bl u_t028_015/c1_w0_br
+ u_t028_015/c1_w1_bl u_t028_015/c1_w1_br u_t028_015/c1_r0_rbl u_t028_015/c1_r1_rbl
+ u_t028_015/c2_w0_bl u_t028_015/c2_w0_br u_t028_015/c2_w1_bl u_t028_015/c2_w1_br
+ u_t028_015/c2_r0_rbl u_t028_015/c2_r1_rbl u_t028_015/c3_w0_bl u_t028_015/c3_w0_br
+ u_t028_015/c3_w1_bl u_t028_015/c3_w1_br u_t028_015/c3_r0_rbl u_t028_015/c3_r1_rbl
+ u_t028_015/r0_w0_wl u_t028_015/r0_w1_wl u_t028_015/r0_r0_rwl u_t028_015/r0_r1_rwl
+ u_t028_015/r1_w0_wl u_t028_015/r1_w1_wl u_t028_015/r1_r0_rwl u_t028_015/r1_r1_rwl
+ u_t028_015/r2_w0_wl u_t028_015/r2_w1_wl u_t028_015/r2_r0_rwl u_t028_015/r2_r1_rwl
+ u_t028_015/r3_w0_wl u_t028_015/r3_w1_wl u_t028_015/r3_r0_rwl u_t028_015/r3_r1_rwl
+ VSS u_t028_017/VSS VSUBS detronyx_12t_2w2r_rc4_4x4_routed_5layer_direct
Xu_t028_004 u_t028_004/c0_w0_bl u_t028_004/c0_w0_br u_t028_004/c0_w1_bl u_t028_004/c0_w1_br
+ u_t028_004/c0_r0_rbl u_t028_004/c0_r1_rbl u_t028_004/c1_w0_bl u_t028_004/c1_w0_br
+ u_t028_004/c1_w1_bl u_t028_004/c1_w1_br u_t028_004/c1_r0_rbl u_t028_004/c1_r1_rbl
+ u_t028_004/c2_w0_bl u_t028_004/c2_w0_br u_t028_004/c2_w1_bl u_t028_004/c2_w1_br
+ u_t028_004/c2_r0_rbl u_t028_004/c2_r1_rbl u_t028_004/c3_w0_bl u_t028_004/c3_w0_br
+ u_t028_004/c3_w1_bl u_t028_004/c3_w1_br u_t028_004/c3_r0_rbl u_t028_004/c3_r1_rbl
+ u_t028_004/r0_w0_wl u_t028_004/r0_w1_wl u_t028_004/r0_r0_rwl u_t028_004/r0_r1_rwl
+ u_t028_004/r1_w0_wl u_t028_004/r1_w1_wl u_t028_004/r1_r0_rwl u_t028_004/r1_r1_rwl
+ u_t028_004/r2_w0_wl u_t028_004/r2_w1_wl u_t028_004/r2_r0_rwl u_t028_004/r2_r1_rwl
+ u_t028_004/r3_w0_wl u_t028_004/r3_w1_wl u_t028_004/r3_r0_rwl u_t028_004/r3_r1_rwl
+ u_t029_004/VDD u_t028_004/VSS VSUBS detronyx_12t_2w2r_rc4_4x4_routed_5layer_direct
Xu_t028_026 u_t028_026/c0_w0_bl u_t028_026/c0_w0_br u_t028_026/c0_w1_bl u_t028_026/c0_w1_br
+ u_t028_026/c0_r0_rbl u_t028_026/c0_r1_rbl u_t028_026/c1_w0_bl u_t028_026/c1_w0_br
+ u_t028_026/c1_w1_bl u_t028_026/c1_w1_br u_t028_026/c1_r0_rbl u_t028_026/c1_r1_rbl
+ u_t028_026/c2_w0_bl u_t028_026/c2_w0_br u_t028_026/c2_w1_bl u_t028_026/c2_w1_br
+ u_t028_026/c2_r0_rbl u_t028_026/c2_r1_rbl u_t028_026/c3_w0_bl u_t028_026/c3_w0_br
+ u_t028_026/c3_w1_bl u_t028_026/c3_w1_br u_t028_026/c3_r0_rbl u_t028_026/c3_r1_rbl
+ u_t028_026/r0_w0_wl u_t028_026/r0_w1_wl u_t028_026/r0_r0_rwl u_t028_026/r0_r1_rwl
+ u_t028_026/r1_w0_wl u_t028_026/r1_w1_wl u_t028_026/r1_r0_rwl u_t028_026/r1_r1_rwl
+ u_t028_026/r2_w0_wl u_t028_026/r2_w1_wl u_t028_026/r2_r0_rwl u_t028_026/r2_r1_rwl
+ u_t028_026/r3_w0_wl u_t028_026/r3_w1_wl u_t028_026/r3_r0_rwl u_t028_026/r3_r1_rwl
+ u_t029_026/VDD u_t028_026/VSS VSUBS detronyx_12t_2w2r_rc4_4x4_routed_5layer_direct
Xu_t019_026 u_t019_026/c0_w0_bl u_t019_026/c0_w0_br u_t019_026/c0_w1_bl u_t019_026/c0_w1_br
+ u_t019_026/c0_r0_rbl u_t019_026/c0_r1_rbl u_t019_026/c1_w0_bl u_t019_026/c1_w0_br
+ u_t019_026/c1_w1_bl u_t019_026/c1_w1_br u_t019_026/c1_r0_rbl u_t019_026/c1_r1_rbl
+ u_t019_026/c2_w0_bl u_t019_026/c2_w0_br u_t019_026/c2_w1_bl u_t019_026/c2_w1_br
+ u_t019_026/c2_r0_rbl u_t019_026/c2_r1_rbl u_t019_026/c3_w0_bl u_t019_026/c3_w0_br
+ u_t019_026/c3_w1_bl u_t019_026/c3_w1_br u_t019_026/c3_r0_rbl u_t019_026/c3_r1_rbl
+ u_t019_026/r0_w0_wl u_t019_026/r0_w1_wl u_t019_026/r0_r0_rwl u_t019_026/r0_r1_rwl
+ u_t019_026/r1_w0_wl u_t019_026/r1_w1_wl u_t019_026/r1_r0_rwl u_t019_026/r1_r1_rwl
+ u_t019_026/r2_w0_wl u_t019_026/r2_w1_wl u_t019_026/r2_r0_rwl u_t019_026/r2_r1_rwl
+ u_t019_026/r3_w0_wl u_t019_026/r3_w1_wl u_t019_026/r3_r0_rwl u_t019_026/r3_r1_rwl
+ u_t019_026/VDD u_t019_026/VSS VSUBS detronyx_12t_2w2r_rc4_4x4_routed_5layer_direct
Xu_t019_015 u_t019_015/c0_w0_bl u_t019_015/c0_w0_br u_t019_015/c0_w1_bl u_t019_015/c0_w1_br
+ u_t019_015/c0_r0_rbl u_t019_015/c0_r1_rbl u_t019_015/c1_w0_bl u_t019_015/c1_w0_br
+ u_t019_015/c1_w1_bl u_t019_015/c1_w1_br u_t019_015/c1_r0_rbl u_t019_015/c1_r1_rbl
+ u_t019_015/c2_w0_bl u_t019_015/c2_w0_br u_t019_015/c2_w1_bl u_t019_015/c2_w1_br
+ u_t019_015/c2_r0_rbl u_t019_015/c2_r1_rbl u_t019_015/c3_w0_bl u_t019_015/c3_w0_br
+ u_t019_015/c3_w1_bl u_t019_015/c3_w1_br u_t019_015/c3_r0_rbl u_t019_015/c3_r1_rbl
+ u_t019_015/r0_w0_wl u_t019_015/r0_w1_wl u_t019_015/r0_r0_rwl u_t019_015/r0_r1_rwl
+ u_t019_015/r1_w0_wl u_t019_015/r1_w1_wl u_t019_015/r1_r0_rwl u_t019_015/r1_r1_rwl
+ u_t019_015/r2_w0_wl u_t019_015/r2_w1_wl u_t019_015/r2_r0_rwl u_t019_015/r2_r1_rwl
+ u_t019_015/r3_w0_wl u_t019_015/r3_w1_wl u_t019_015/r3_r0_rwl u_t019_015/r3_r1_rwl
+ VSS u_t019_017/VSS VSUBS detronyx_12t_2w2r_rc4_4x4_routed_5layer_direct
Xu_t019_004 u_t019_004/c0_w0_bl u_t019_004/c0_w0_br u_t019_004/c0_w1_bl u_t019_004/c0_w1_br
+ u_t019_004/c0_r0_rbl u_t019_004/c0_r1_rbl u_t019_004/c1_w0_bl u_t019_004/c1_w0_br
+ u_t019_004/c1_w1_bl u_t019_004/c1_w1_br u_t019_004/c1_r0_rbl u_t019_004/c1_r1_rbl
+ u_t019_004/c2_w0_bl u_t019_004/c2_w0_br u_t019_004/c2_w1_bl u_t019_004/c2_w1_br
+ u_t019_004/c2_r0_rbl u_t019_004/c2_r1_rbl u_t019_004/c3_w0_bl u_t019_004/c3_w0_br
+ u_t019_004/c3_w1_bl u_t019_004/c3_w1_br u_t019_004/c3_r0_rbl u_t019_004/c3_r1_rbl
+ u_t019_004/r0_w0_wl u_t019_004/r0_w1_wl u_t019_004/r0_r0_rwl u_t019_004/r0_r1_rwl
+ u_t019_004/r1_w0_wl u_t019_004/r1_w1_wl u_t019_004/r1_r0_rwl u_t019_004/r1_r1_rwl
+ u_t019_004/r2_w0_wl u_t019_004/r2_w1_wl u_t019_004/r2_r0_rwl u_t019_004/r2_r1_rwl
+ u_t019_004/r3_w0_wl u_t019_004/r3_w1_wl u_t019_004/r3_r0_rwl u_t019_004/r3_r1_rwl
+ u_t019_004/VDD u_t019_004/VSS VSUBS detronyx_12t_2w2r_rc4_4x4_routed_5layer_direct
Xgf180mcu_as_sc_mcu7t3v3__nand4_2_19 gf180mcu_as_sc_mcu7t3v3__inv_2_66/VSS gf180mcu_as_sc_mcu7t3v3__inv_2_70/VDD
+ VSS VSS VSS VSS VSS gf180mcu_as_sc_mcu7t3v3__inv_2_63/VNW VSUBS gf180mcu_as_sc_mcu7t3v3__nand4_2
Xu_t025_029 u_t025_029/c0_w0_bl u_t025_029/c0_w0_br u_t025_029/c0_w1_bl u_t025_029/c0_w1_br
+ u_t025_029/c0_r0_rbl u_t025_029/c0_r1_rbl u_t025_029/c1_w0_bl u_t025_029/c1_w0_br
+ u_t025_029/c1_w1_bl u_t025_029/c1_w1_br u_t025_029/c1_r0_rbl u_t025_029/c1_r1_rbl
+ u_t025_029/c2_w0_bl u_t025_029/c2_w0_br u_t025_029/c2_w1_bl u_t025_029/c2_w1_br
+ u_t025_029/c2_r0_rbl u_t025_029/c2_r1_rbl u_t025_029/c3_w0_bl u_t025_029/c3_w0_br
+ u_t025_029/c3_w1_bl u_t025_029/c3_w1_br u_t025_029/c3_r0_rbl u_t025_029/c3_r1_rbl
+ u_t025_029/r0_w0_wl u_t025_029/r0_w1_wl u_t025_029/r0_r0_rwl u_t025_029/r0_r1_rwl
+ u_t025_029/r1_w0_wl u_t025_029/r1_w1_wl u_t025_029/r1_r0_rwl u_t025_029/r1_r1_rwl
+ u_t025_029/r2_w0_wl u_t025_029/r2_w1_wl u_t025_029/r2_r0_rwl u_t025_029/r2_r1_rwl
+ u_t025_029/r3_w0_wl u_t025_029/r3_w1_wl u_t025_029/r3_r0_rwl u_t025_029/r3_r1_rwl
+ u_t025_029/VDD u_t025_031/VSS VSUBS detronyx_12t_2w2r_rc4_4x4_routed_5layer_direct
Xu_t025_018 u_t025_018/c0_w0_bl u_t025_018/c0_w0_br u_t025_018/c0_w1_bl u_t025_018/c0_w1_br
+ u_t025_018/c0_r0_rbl u_t025_018/c0_r1_rbl u_t025_018/c1_w0_bl u_t025_018/c1_w0_br
+ u_t025_018/c1_w1_bl u_t025_018/c1_w1_br u_t025_018/c1_r0_rbl u_t025_018/c1_r1_rbl
+ u_t025_018/c2_w0_bl u_t025_018/c2_w0_br u_t025_018/c2_w1_bl u_t025_018/c2_w1_br
+ u_t025_018/c2_r0_rbl u_t025_018/c2_r1_rbl u_t025_018/c3_w0_bl u_t025_018/c3_w0_br
+ u_t025_018/c3_w1_bl u_t025_018/c3_w1_br u_t025_018/c3_r0_rbl u_t025_018/c3_r1_rbl
+ u_t025_018/r0_w0_wl u_t025_018/r0_w1_wl u_t025_018/r0_r0_rwl u_t025_018/r0_r1_rwl
+ u_t025_018/r1_w0_wl u_t025_018/r1_w1_wl u_t025_018/r1_r0_rwl u_t025_018/r1_r1_rwl
+ u_t025_018/r2_w0_wl u_t025_018/r2_w1_wl u_t025_018/r2_r0_rwl u_t025_018/r2_r1_rwl
+ u_t025_018/r3_w0_wl u_t025_018/r3_w1_wl u_t025_018/r3_r0_rwl u_t025_018/r3_r1_rwl
+ u_t025_018/VDD u_t025_031/VSS VSUBS detronyx_12t_2w2r_rc4_4x4_routed_5layer_direct
Xu_t025_007 u_t025_007/c0_w0_bl u_t025_007/c0_w0_br u_t025_007/c0_w1_bl u_t025_007/c0_w1_br
+ u_t025_007/c0_r0_rbl u_t025_007/c0_r1_rbl u_t025_007/c1_w0_bl u_t025_007/c1_w0_br
+ u_t025_007/c1_w1_bl u_t025_007/c1_w1_br u_t025_007/c1_r0_rbl u_t025_007/c1_r1_rbl
+ u_t025_007/c2_w0_bl u_t025_007/c2_w0_br u_t025_007/c2_w1_bl u_t025_007/c2_w1_br
+ u_t025_007/c2_r0_rbl u_t025_007/c2_r1_rbl u_t025_007/c3_w0_bl u_t025_007/c3_w0_br
+ u_t025_007/c3_w1_bl u_t025_007/c3_w1_br u_t025_007/c3_r0_rbl u_t025_007/c3_r1_rbl
+ u_t025_007/r0_w0_wl u_t025_007/r0_w1_wl u_t025_007/r0_r0_rwl u_t025_007/r0_r1_rwl
+ u_t025_007/r1_w0_wl u_t025_007/r1_w1_wl u_t025_007/r1_r0_rwl u_t025_007/r1_r1_rwl
+ u_t025_007/r2_w0_wl u_t025_007/r2_w1_wl u_t025_007/r2_r0_rwl u_t025_007/r2_r1_rwl
+ u_t025_007/r3_w0_wl u_t025_007/r3_w1_wl u_t025_007/r3_r0_rwl u_t025_007/r3_r1_rwl
+ VSS u_t025_031/VSS VSUBS detronyx_12t_2w2r_rc4_4x4_routed_5layer_direct
Xgf180mcu_as_sc_mcu7t3v3__inv_2_1127 VSS gf180mcu_as_sc_mcu7t3v3__inv_2_1132/VDD VSS
+ VSS gf180mcu_as_sc_mcu7t3v3__inv_2_1129/VNW VSUBS gf180mcu_as_sc_mcu7t3v3__inv_2
Xgf180mcu_as_sc_mcu7t3v3__inv_2_1138 VSS gf180mcu_as_sc_mcu7t3v3__inv_2_1141/VDD gf180mcu_as_sc_mcu7t3v3__inv_2_1138/Y
+ VSS gf180mcu_as_sc_mcu7t3v3__inv_2_1138/VNW VSUBS gf180mcu_as_sc_mcu7t3v3__inv_2
Xgf180mcu_as_sc_mcu7t3v3__inv_2_1116 gf180mcu_as_sc_mcu7t3v3__inv_2_1117/VDD VSS gf180mcu_as_sc_mcu7t3v3__inv_2_1116/Y
+ gf180mcu_as_sc_mcu7t3v3__inv_2_1117/Y gf180mcu_as_sc_mcu7t3v3__inv_2_1117/VNW VSUBS
+ gf180mcu_as_sc_mcu7t3v3__inv_2
Xgf180mcu_as_sc_mcu7t3v3__inv_2_1105 gf180mcu_as_sc_mcu7t3v3__inv_2_1146/VSS gf180mcu_as_sc_mcu7t3v3__inv_2_1105/VSS
+ gf180mcu_as_sc_mcu7t3v3__inv_2_1105/Y VSS gf180mcu_as_sc_mcu7t3v3__inv_2_1105/VNW
+ VSUBS gf180mcu_as_sc_mcu7t3v3__inv_2
Xgf180mcu_as_sc_mcu7t3v3__inv_2_1149 VSS VSS VSS VSS gf180mcu_as_sc_mcu7t3v3__inv_2_1151/VNW
+ VSUBS gf180mcu_as_sc_mcu7t3v3__inv_2
Xu_t016_007 u_t016_007/c0_w0_bl u_t016_007/c0_w0_br u_t016_007/c0_w1_bl u_t016_007/c0_w1_br
+ u_t016_007/c0_r0_rbl u_t016_007/c0_r1_rbl u_t016_007/c1_w0_bl u_t016_007/c1_w0_br
+ u_t016_007/c1_w1_bl u_t016_007/c1_w1_br u_t016_007/c1_r0_rbl u_t016_007/c1_r1_rbl
+ u_t016_007/c2_w0_bl u_t016_007/c2_w0_br u_t016_007/c2_w1_bl u_t016_007/c2_w1_br
+ u_t016_007/c2_r0_rbl u_t016_007/c2_r1_rbl u_t016_007/c3_w0_bl u_t016_007/c3_w0_br
+ u_t016_007/c3_w1_bl u_t016_007/c3_w1_br u_t016_007/c3_r0_rbl u_t016_007/c3_r1_rbl
+ u_t016_007/r0_w0_wl u_t016_007/r0_w1_wl u_t016_007/r0_r0_rwl u_t016_007/r0_r1_rwl
+ u_t016_007/r1_w0_wl u_t016_007/r1_w1_wl u_t016_007/r1_r0_rwl u_t016_007/r1_r1_rwl
+ u_t016_007/r2_w0_wl u_t016_007/r2_w1_wl u_t016_007/r2_r0_rwl u_t016_007/r2_r1_rwl
+ u_t016_007/r3_w0_wl u_t016_007/r3_w1_wl u_t016_007/r3_r0_rwl u_t016_007/r3_r1_rwl
+ VSS u_t016_009/VSS VSUBS detronyx_12t_2w2r_rc4_4x4_routed_5layer_direct
Xgf180mcu_as_sc_mcu7t3v3__nand3_2_30 gf180mcu_as_sc_mcu7t3v3__nand3_2_31/VDD gf180mcu_as_sc_mcu7t3v3__nor2_2_8/VSS
+ VSS VSS VSS VSS gf180mcu_as_sc_mcu7t3v3__nand3_2_31/VNW VSUBS gf180mcu_as_sc_mcu7t3v3__nand3_2
Xu_t016_029 u_t016_029/c0_w0_bl u_t016_029/c0_w0_br u_t016_029/c0_w1_bl u_t016_029/c0_w1_br
+ u_t016_029/c0_r0_rbl u_t016_029/c0_r1_rbl u_t016_029/c1_w0_bl u_t016_029/c1_w0_br
+ u_t016_029/c1_w1_bl u_t016_029/c1_w1_br u_t016_029/c1_r0_rbl u_t016_029/c1_r1_rbl
+ u_t016_029/c2_w0_bl u_t016_029/c2_w0_br u_t016_029/c2_w1_bl u_t016_029/c2_w1_br
+ u_t016_029/c2_r0_rbl u_t016_029/c2_r1_rbl u_t016_029/c3_w0_bl u_t016_029/c3_w0_br
+ u_t016_029/c3_w1_bl u_t016_029/c3_w1_br u_t016_029/c3_r0_rbl u_t016_029/c3_r1_rbl
+ u_t016_029/r0_w0_wl u_t016_029/r0_w1_wl u_t016_029/r0_r0_rwl u_t016_029/r0_r1_rwl
+ u_t016_029/r1_w0_wl u_t016_029/r1_w1_wl u_t016_029/r1_r0_rwl u_t016_029/r1_r1_rwl
+ u_t016_029/r2_w0_wl u_t016_029/r2_w1_wl u_t016_029/r2_r0_rwl u_t016_029/r2_r1_rwl
+ u_t016_029/r3_w0_wl u_t016_029/r3_w1_wl u_t016_029/r3_r0_rwl u_t016_029/r3_r1_rwl
+ u_t016_029/VDD u_t016_031/VSS VSUBS detronyx_12t_2w2r_rc4_4x4_routed_5layer_direct
Xu_t016_018 u_t016_018/c0_w0_bl u_t016_018/c0_w0_br u_t016_018/c0_w1_bl u_t016_018/c0_w1_br
+ u_t016_018/c0_r0_rbl u_t016_018/c0_r1_rbl u_t016_018/c1_w0_bl u_t016_018/c1_w0_br
+ u_t016_018/c1_w1_bl u_t016_018/c1_w1_br u_t016_018/c1_r0_rbl u_t016_018/c1_r1_rbl
+ u_t016_018/c2_w0_bl u_t016_018/c2_w0_br u_t016_018/c2_w1_bl u_t016_018/c2_w1_br
+ u_t016_018/c2_r0_rbl u_t016_018/c2_r1_rbl u_t016_018/c3_w0_bl u_t016_018/c3_w0_br
+ u_t016_018/c3_w1_bl u_t016_018/c3_w1_br u_t016_018/c3_r0_rbl u_t016_018/c3_r1_rbl
+ u_t016_018/r0_w0_wl u_t016_018/r0_w1_wl u_t016_018/r0_r0_rwl u_t016_018/r0_r1_rwl
+ u_t016_018/r1_w0_wl u_t016_018/r1_w1_wl u_t016_018/r1_r0_rwl u_t016_018/r1_r1_rwl
+ u_t016_018/r2_w0_wl u_t016_018/r2_w1_wl u_t016_018/r2_r0_rwl u_t016_018/r2_r1_rwl
+ u_t016_018/r3_w0_wl u_t016_018/r3_w1_wl u_t016_018/r3_r0_rwl u_t016_018/r3_r1_rwl
+ u_t016_018/VDD u_t016_018/VSS VSUBS detronyx_12t_2w2r_rc4_4x4_routed_5layer_direct
Xgf180mcu_as_sc_mcu7t3v3__inv_2_1672 gf180mcu_as_sc_mcu7t3v3__inv_2_1672/VDD VSS gf180mcu_as_sc_mcu7t3v3__inv_2_1675/Y
+ VSS gf180mcu_as_sc_mcu7t3v3__inv_2_1672/VNW VSUBS gf180mcu_as_sc_mcu7t3v3__inv_2
Xgf180mcu_as_sc_mcu7t3v3__inv_2_1650 VSS VSS gf180mcu_as_sc_mcu7t3v3__inv_2_1678/Y
+ gf180mcu_as_sc_mcu7t3v3__inv_2_1678/Y gf180mcu_as_sc_mcu7t3v3__inv_2_1676/VNW VSUBS
+ gf180mcu_as_sc_mcu7t3v3__inv_2
Xgf180mcu_as_sc_mcu7t3v3__inv_2_1661 VSS VSS gf180mcu_as_sc_mcu7t3v3__inv_2_1685/Y
+ VSS gf180mcu_as_sc_mcu7t3v3__inv_2_1661/VNW VSUBS gf180mcu_as_sc_mcu7t3v3__inv_2
Xgf180mcu_as_sc_mcu7t3v3__inv_2_1683 gf180mcu_as_sc_mcu7t3v3__inv_2_1685/VDD VSS VSS
+ gf180mcu_as_sc_mcu7t3v3__inv_2_1685/Y gf180mcu_as_sc_mcu7t3v3__inv_2_1685/VNW VSUBS
+ gf180mcu_as_sc_mcu7t3v3__inv_2
Xgf180mcu_as_sc_mcu7t3v3__inv_2_1694 gf180mcu_as_sc_mcu7t3v3__inv_2_1694/VDD VSS gf180mcu_as_sc_mcu7t3v3__inv_2_1694/Y
+ VSS gf180mcu_as_sc_mcu7t3v3__inv_2_1694/VNW VSUBS gf180mcu_as_sc_mcu7t3v3__inv_2
Xu_t007_029 u_t007_029/c0_w0_bl u_t007_029/c0_w0_br u_t007_029/c0_w1_bl u_t007_029/c0_w1_br
+ u_t007_029/c0_r0_rbl u_t007_029/c0_r1_rbl u_t007_029/c1_w0_bl u_t007_029/c1_w0_br
+ u_t007_029/c1_w1_bl u_t007_029/c1_w1_br u_t007_029/c1_r0_rbl u_t007_029/c1_r1_rbl
+ u_t007_029/c2_w0_bl u_t007_029/c2_w0_br u_t007_029/c2_w1_bl u_t007_029/c2_w1_br
+ u_t007_029/c2_r0_rbl u_t007_029/c2_r1_rbl u_t007_029/c3_w0_bl u_t007_029/c3_w0_br
+ u_t007_029/c3_w1_bl u_t007_029/c3_w1_br u_t007_029/c3_r0_rbl u_t007_029/c3_r1_rbl
+ u_t007_029/r0_w0_wl u_t007_029/r0_w1_wl u_t007_029/r0_r0_rwl u_t007_029/r0_r1_rwl
+ u_t007_029/r1_w0_wl u_t007_029/r1_w1_wl u_t007_029/r1_r0_rwl u_t007_029/r1_r1_rwl
+ u_t007_029/r2_w0_wl u_t007_029/r2_w1_wl u_t007_029/r2_r0_rwl u_t007_029/r2_r1_rwl
+ u_t007_029/r3_w0_wl u_t007_029/r3_w1_wl u_t007_029/r3_r0_rwl u_t007_029/r3_r1_rwl
+ u_t008_029/VDD u_t007_031/VSS VSUBS detronyx_12t_2w2r_rc4_4x4_routed_5layer_direct
Xu_t007_018 u_t007_018/c0_w0_bl u_t007_018/c0_w0_br u_t007_018/c0_w1_bl u_t007_018/c0_w1_br
+ u_t007_018/c0_r0_rbl u_t007_018/c0_r1_rbl u_t007_018/c1_w0_bl u_t007_018/c1_w0_br
+ u_t007_018/c1_w1_bl u_t007_018/c1_w1_br u_t007_018/c1_r0_rbl u_t007_018/c1_r1_rbl
+ u_t007_018/c2_w0_bl u_t007_018/c2_w0_br u_t007_018/c2_w1_bl u_t007_018/c2_w1_br
+ u_t007_018/c2_r0_rbl u_t007_018/c2_r1_rbl u_t007_018/c3_w0_bl u_t007_018/c3_w0_br
+ u_t007_018/c3_w1_bl u_t007_018/c3_w1_br u_t007_018/c3_r0_rbl u_t007_018/c3_r1_rbl
+ u_t007_018/r0_w0_wl u_t007_018/r0_w1_wl u_t007_018/r0_r0_rwl u_t007_018/r0_r1_rwl
+ u_t007_018/r1_w0_wl u_t007_018/r1_w1_wl u_t007_018/r1_r0_rwl u_t007_018/r1_r1_rwl
+ u_t007_018/r2_w0_wl u_t007_018/r2_w1_wl u_t007_018/r2_r0_rwl u_t007_018/r2_r1_rwl
+ u_t007_018/r3_w0_wl u_t007_018/r3_w1_wl u_t007_018/r3_r0_rwl u_t007_018/r3_r1_rwl
+ u_t008_018/VDD u_t007_018/VSS VSUBS detronyx_12t_2w2r_rc4_4x4_routed_5layer_direct
Xu_t007_007 u_t007_007/c0_w0_bl u_t007_007/c0_w0_br u_t007_007/c0_w1_bl u_t007_007/c0_w1_br
+ u_t007_007/c0_r0_rbl u_t007_007/c0_r1_rbl u_t007_007/c1_w0_bl u_t007_007/c1_w0_br
+ u_t007_007/c1_w1_bl u_t007_007/c1_w1_br u_t007_007/c1_r0_rbl u_t007_007/c1_r1_rbl
+ u_t007_007/c2_w0_bl u_t007_007/c2_w0_br u_t007_007/c2_w1_bl u_t007_007/c2_w1_br
+ u_t007_007/c2_r0_rbl u_t007_007/c2_r1_rbl u_t007_007/c3_w0_bl u_t007_007/c3_w0_br
+ u_t007_007/c3_w1_bl u_t007_007/c3_w1_br u_t007_007/c3_r0_rbl u_t007_007/c3_r1_rbl
+ u_t007_007/r0_w0_wl u_t007_007/r0_w1_wl u_t007_007/r0_r0_rwl u_t007_007/r0_r1_rwl
+ u_t007_007/r1_w0_wl u_t007_007/r1_w1_wl u_t007_007/r1_r0_rwl u_t007_007/r1_r1_rwl
+ u_t007_007/r2_w0_wl u_t007_007/r2_w1_wl u_t007_007/r2_r0_rwl u_t007_007/r2_r1_rwl
+ u_t007_007/r3_w0_wl u_t007_007/r3_w1_wl u_t007_007/r3_r0_rwl u_t007_007/r3_r1_rwl
+ VSS u_t007_009/VSS VSUBS detronyx_12t_2w2r_rc4_4x4_routed_5layer_direct
Xu_t030_021 u_t030_021/c0_w0_bl u_t030_021/c0_w0_br u_t030_021/c0_w1_bl u_t030_021/c0_w1_br
+ u_t030_021/c0_r0_rbl u_t030_021/c0_r1_rbl u_t030_021/c1_w0_bl u_t030_021/c1_w0_br
+ u_t030_021/c1_w1_bl u_t030_021/c1_w1_br u_t030_021/c1_r0_rbl u_t030_021/c1_r1_rbl
+ u_t030_021/c2_w0_bl u_t030_021/c2_w0_br u_t030_021/c2_w1_bl u_t030_021/c2_w1_br
+ u_t030_021/c2_r0_rbl u_t030_021/c2_r1_rbl u_t030_021/c3_w0_bl u_t030_021/c3_w0_br
+ u_t030_021/c3_w1_bl u_t030_021/c3_w1_br u_t030_021/c3_r0_rbl u_t030_021/c3_r1_rbl
+ u_t030_021/r0_w0_wl u_t030_021/r0_w1_wl u_t030_021/r0_r0_rwl u_t030_021/r0_r1_rwl
+ u_t030_021/r1_w0_wl u_t030_021/r1_w1_wl u_t030_021/r1_r0_rwl u_t030_021/r1_r1_rwl
+ u_t030_021/r2_w0_wl u_t030_021/r2_w1_wl u_t030_021/r2_r0_rwl u_t030_021/r2_r1_rwl
+ u_t030_021/r3_w0_wl u_t030_021/r3_w1_wl u_t030_021/r3_r0_rwl u_t030_021/r3_r1_rwl
+ u_t030_021/VDD u_t030_031/VSS VSUBS detronyx_12t_2w2r_rc4_4x4_routed_5layer_direct
Xu_t030_010 u_t030_010/c0_w0_bl u_t030_010/c0_w0_br u_t030_010/c0_w1_bl u_t030_010/c0_w1_br
+ u_t030_010/c0_r0_rbl u_t030_010/c0_r1_rbl u_t030_010/c1_w0_bl u_t030_010/c1_w0_br
+ u_t030_010/c1_w1_bl u_t030_010/c1_w1_br u_t030_010/c1_r0_rbl u_t030_010/c1_r1_rbl
+ u_t030_010/c2_w0_bl u_t030_010/c2_w0_br u_t030_010/c2_w1_bl u_t030_010/c2_w1_br
+ u_t030_010/c2_r0_rbl u_t030_010/c2_r1_rbl u_t030_010/c3_w0_bl u_t030_010/c3_w0_br
+ u_t030_010/c3_w1_bl u_t030_010/c3_w1_br u_t030_010/c3_r0_rbl u_t030_010/c3_r1_rbl
+ u_t030_010/r0_w0_wl u_t030_010/r0_w1_wl u_t030_010/r0_r0_rwl u_t030_010/r0_r1_rwl
+ u_t030_010/r1_w0_wl u_t030_010/r1_w1_wl u_t030_010/r1_r0_rwl u_t030_010/r1_r1_rwl
+ u_t030_010/r2_w0_wl u_t030_010/r2_w1_wl u_t030_010/r2_r0_rwl u_t030_010/r2_r1_rwl
+ u_t030_010/r3_w0_wl u_t030_010/r3_w1_wl u_t030_010/r3_r0_rwl u_t030_010/r3_r1_rwl
+ VSS u_t030_031/VSS VSUBS detronyx_12t_2w2r_rc4_4x4_routed_5layer_direct
Xgf180mcu_as_sc_mcu7t3v3__nand4_2_455 gf180mcu_as_sc_mcu7t3v3__inv_2_1569/VDD VSS
+ VSS VSS VSS VSS VSS gf180mcu_as_sc_mcu7t3v3__inv_2_1569/VNW VSUBS gf180mcu_as_sc_mcu7t3v3__nand4_2
Xgf180mcu_as_sc_mcu7t3v3__nand4_2_499 gf180mcu_as_sc_mcu7t3v3__inv_2_1674/VDD gf180mcu_as_sc_mcu7t3v3__inv_2_1675/VDD
+ VSS VSS VSS VSS VSS gf180mcu_as_sc_mcu7t3v3__inv_2_1674/VNW VSUBS gf180mcu_as_sc_mcu7t3v3__nand4_2
Xgf180mcu_as_sc_mcu7t3v3__nand4_2_477 gf180mcu_as_sc_mcu7t3v3__inv_2_1548/VSS VSS
+ VSS VSS VSS VSS VSS gf180mcu_as_sc_mcu7t3v3__inv_2_1525/VNW VSUBS gf180mcu_as_sc_mcu7t3v3__nand4_2
Xgf180mcu_as_sc_mcu7t3v3__nand4_2_466 gf180mcu_as_sc_mcu7t3v3__inv_2_1535/VDD gf180mcu_as_sc_mcu7t3v3__inv_2_1539/VDD
+ VSS VSS VSS VSS gf180mcu_as_sc_mcu7t3v3__nand4_2_466/Y gf180mcu_as_sc_mcu7t3v3__inv_2_1535/VNW
+ VSUBS gf180mcu_as_sc_mcu7t3v3__nand4_2
Xgf180mcu_as_sc_mcu7t3v3__nand4_2_488 VSS VSS VSS VSS VSS VSS VSS gf180mcu_as_sc_mcu7t3v3__inv_2_1655/VNW
+ VSUBS gf180mcu_as_sc_mcu7t3v3__nand4_2
Xgf180mcu_as_sc_mcu7t3v3__nand4_2_444 VSS gf180mcu_as_sc_mcu7t3v3__inv_2_1497/VDD
+ VSS VSS VSS VSS VSS gf180mcu_as_sc_mcu7t3v3__inv_2_1481/VNW VSUBS gf180mcu_as_sc_mcu7t3v3__nand4_2
Xgf180mcu_as_sc_mcu7t3v3__nand4_2_400 gf180mcu_as_sc_mcu7t3v3__inv_2_1400/VSS VSS
+ VSS VSS VSS VSS VSS gf180mcu_as_sc_mcu7t3v3__inv_2_1381/VNW VSUBS gf180mcu_as_sc_mcu7t3v3__nand4_2
Xgf180mcu_as_sc_mcu7t3v3__nand4_2_433 VSS gf180mcu_as_sc_mcu7t3v3__inv_2_1480/VDD
+ VSS VSS VSS VSS gf180mcu_as_sc_mcu7t3v3__nand4_2_433/Y gf180mcu_as_sc_mcu7t3v3__inv_2_1476/VNW
+ VSUBS gf180mcu_as_sc_mcu7t3v3__nand4_2
Xgf180mcu_as_sc_mcu7t3v3__nand4_2_411 gf180mcu_as_sc_mcu7t3v3__inv_2_1387/VDD VSS
+ VSS VSS VSS VSS VSS gf180mcu_as_sc_mcu7t3v3__inv_2_1387/VNW VSUBS gf180mcu_as_sc_mcu7t3v3__nand4_2
Xgf180mcu_as_sc_mcu7t3v3__nand4_2_422 gf180mcu_as_sc_mcu7t3v3__inv_2_1432/VDD VSS
+ VSS VSS VSS VSS VSS gf180mcu_as_sc_mcu7t3v3__inv_2_1432/VNW VSUBS gf180mcu_as_sc_mcu7t3v3__nand4_2
Xu_t021_021 u_t021_021/c0_w0_bl u_t021_021/c0_w0_br u_t021_021/c0_w1_bl u_t021_021/c0_w1_br
+ u_t021_021/c0_r0_rbl u_t021_021/c0_r1_rbl u_t021_021/c1_w0_bl u_t021_021/c1_w0_br
+ u_t021_021/c1_w1_bl u_t021_021/c1_w1_br u_t021_021/c1_r0_rbl u_t021_021/c1_r1_rbl
+ u_t021_021/c2_w0_bl u_t021_021/c2_w0_br u_t021_021/c2_w1_bl u_t021_021/c2_w1_br
+ u_t021_021/c2_r0_rbl u_t021_021/c2_r1_rbl u_t021_021/c3_w0_bl u_t021_021/c3_w0_br
+ u_t021_021/c3_w1_bl u_t021_021/c3_w1_br u_t021_021/c3_r0_rbl u_t021_021/c3_r1_rbl
+ u_t021_021/r0_w0_wl u_t021_021/r0_w1_wl u_t021_021/r0_r0_rwl u_t021_021/r0_r1_rwl
+ u_t021_021/r1_w0_wl u_t021_021/r1_w1_wl u_t021_021/r1_r0_rwl u_t021_021/r1_r1_rwl
+ u_t021_021/r2_w0_wl u_t021_021/r2_w1_wl u_t021_021/r2_r0_rwl u_t021_021/r2_r1_rwl
+ u_t021_021/r3_w0_wl u_t021_021/r3_w1_wl u_t021_021/r3_r0_rwl u_t021_021/r3_r1_rwl
+ u_t021_021/VDD u_t021_031/VSS VSUBS detronyx_12t_2w2r_rc4_4x4_routed_5layer_direct
Xu_t021_010 u_t021_010/c0_w0_bl u_t021_010/c0_w0_br u_t021_010/c0_w1_bl u_t021_010/c0_w1_br
+ u_t021_010/c0_r0_rbl u_t021_010/c0_r1_rbl u_t021_010/c1_w0_bl u_t021_010/c1_w0_br
+ u_t021_010/c1_w1_bl u_t021_010/c1_w1_br u_t021_010/c1_r0_rbl u_t021_010/c1_r1_rbl
+ u_t021_010/c2_w0_bl u_t021_010/c2_w0_br u_t021_010/c2_w1_bl u_t021_010/c2_w1_br
+ u_t021_010/c2_r0_rbl u_t021_010/c2_r1_rbl u_t021_010/c3_w0_bl u_t021_010/c3_w0_br
+ u_t021_010/c3_w1_bl u_t021_010/c3_w1_br u_t021_010/c3_r0_rbl u_t021_010/c3_r1_rbl
+ u_t021_010/r0_w0_wl u_t021_010/r0_w1_wl u_t021_010/r0_r0_rwl u_t021_010/r0_r1_rwl
+ u_t021_010/r1_w0_wl u_t021_010/r1_w1_wl u_t021_010/r1_r0_rwl u_t021_010/r1_r1_rwl
+ u_t021_010/r2_w0_wl u_t021_010/r2_w1_wl u_t021_010/r2_r0_rwl u_t021_010/r2_r1_rwl
+ u_t021_010/r3_w0_wl u_t021_010/r3_w1_wl u_t021_010/r3_r0_rwl u_t021_010/r3_r1_rwl
+ VSS u_t021_031/VSS VSUBS detronyx_12t_2w2r_rc4_4x4_routed_5layer_direct
Xgf180mcu_as_sc_mcu7t3v3__inv_2_1 gf180mcu_as_sc_mcu7t3v3__inv_2_2/VDD gf180mcu_as_sc_mcu7t3v3__inv_2_9/VSS
+ VSS gf180mcu_as_sc_mcu7t3v3__inv_2_2/A gf180mcu_as_sc_mcu7t3v3__inv_2_2/VNW VSUBS
+ gf180mcu_as_sc_mcu7t3v3__inv_2
Xgf180mcu_as_sc_mcu7t3v3__inv_2_408 VSS VSS gf180mcu_as_sc_mcu7t3v3__inv_2_408/Y VSS
+ gf180mcu_as_sc_mcu7t3v3__inv_2_410/VNW VSUBS gf180mcu_as_sc_mcu7t3v3__inv_2
Xgf180mcu_as_sc_mcu7t3v3__inv_2_419 gf180mcu_as_sc_mcu7t3v3__nand3_2_5/VDD gf180mcu_as_sc_mcu7t3v3__nor2_2_4/VSS
+ VSS VSS gf180mcu_as_sc_mcu7t3v3__nand3_2_5/VNW VSUBS gf180mcu_as_sc_mcu7t3v3__inv_2
Xu_t012_021 u_t012_021/c0_w0_bl u_t012_021/c0_w0_br u_t012_021/c0_w1_bl u_t012_021/c0_w1_br
+ u_t012_021/c0_r0_rbl u_t012_021/c0_r1_rbl u_t012_021/c1_w0_bl u_t012_021/c1_w0_br
+ u_t012_021/c1_w1_bl u_t012_021/c1_w1_br u_t012_021/c1_r0_rbl u_t012_021/c1_r1_rbl
+ u_t012_021/c2_w0_bl u_t012_021/c2_w0_br u_t012_021/c2_w1_bl u_t012_021/c2_w1_br
+ u_t012_021/c2_r0_rbl u_t012_021/c2_r1_rbl u_t012_021/c3_w0_bl u_t012_021/c3_w0_br
+ u_t012_021/c3_w1_bl u_t012_021/c3_w1_br u_t012_021/c3_r0_rbl u_t012_021/c3_r1_rbl
+ u_t012_021/r0_w0_wl u_t012_021/r0_w1_wl u_t012_021/r0_r0_rwl u_t012_021/r0_r1_rwl
+ u_t012_021/r1_w0_wl u_t012_021/r1_w1_wl u_t012_021/r1_r0_rwl u_t012_021/r1_r1_rwl
+ u_t012_021/r2_w0_wl u_t012_021/r2_w1_wl u_t012_021/r2_r0_rwl u_t012_021/r2_r1_rwl
+ u_t012_021/r3_w0_wl u_t012_021/r3_w1_wl u_t012_021/r3_r0_rwl u_t012_021/r3_r1_rwl
+ u_t012_021/VDD u_t012_031/VSS VSUBS detronyx_12t_2w2r_rc4_4x4_routed_5layer_direct
Xu_t012_010 u_t012_010/c0_w0_bl u_t012_010/c0_w0_br u_t012_010/c0_w1_bl u_t012_010/c0_w1_br
+ u_t012_010/c0_r0_rbl u_t012_010/c0_r1_rbl u_t012_010/c1_w0_bl u_t012_010/c1_w0_br
+ u_t012_010/c1_w1_bl u_t012_010/c1_w1_br u_t012_010/c1_r0_rbl u_t012_010/c1_r1_rbl
+ u_t012_010/c2_w0_bl u_t012_010/c2_w0_br u_t012_010/c2_w1_bl u_t012_010/c2_w1_br
+ u_t012_010/c2_r0_rbl u_t012_010/c2_r1_rbl u_t012_010/c3_w0_bl u_t012_010/c3_w0_br
+ u_t012_010/c3_w1_bl u_t012_010/c3_w1_br u_t012_010/c3_r0_rbl u_t012_010/c3_r1_rbl
+ u_t012_010/r0_w0_wl u_t012_010/r0_w1_wl u_t012_010/r0_r0_rwl u_t012_010/r0_r1_rwl
+ u_t012_010/r1_w0_wl u_t012_010/r1_w1_wl u_t012_010/r1_r0_rwl u_t012_010/r1_r1_rwl
+ u_t012_010/r2_w0_wl u_t012_010/r2_w1_wl u_t012_010/r2_r0_rwl u_t012_010/r2_r1_rwl
+ u_t012_010/r3_w0_wl u_t012_010/r3_w1_wl u_t012_010/r3_r0_rwl u_t012_010/r3_r1_rwl
+ VSS u_t012_031/VSS VSUBS detronyx_12t_2w2r_rc4_4x4_routed_5layer_direct
Xgf180mcu_as_sc_mcu7t3v3__inv_2_1480 gf180mcu_as_sc_mcu7t3v3__inv_2_1480/VDD VSS gf180mcu_as_sc_mcu7t3v3__inv_2_1480/Y
+ VSS gf180mcu_as_sc_mcu7t3v3__inv_2_1480/VNW VSUBS gf180mcu_as_sc_mcu7t3v3__inv_2
Xgf180mcu_as_sc_mcu7t3v3__inv_2_1491 gf180mcu_as_sc_mcu7t3v3__inv_2_1492/VDD gf180mcu_as_sc_mcu7t3v3__inv_2_1496/VDD
+ gf180mcu_as_sc_mcu7t3v3__inv_2_1491/Y VSS gf180mcu_as_sc_mcu7t3v3__inv_2_1492/VNW
+ VSUBS gf180mcu_as_sc_mcu7t3v3__inv_2
Xu_t003_021 u_t003_021/c0_w0_bl u_t003_021/c0_w0_br u_t003_021/c0_w1_bl u_t003_021/c0_w1_br
+ u_t003_021/c0_r0_rbl u_t003_021/c0_r1_rbl u_t003_021/c1_w0_bl u_t003_021/c1_w0_br
+ u_t003_021/c1_w1_bl u_t003_021/c1_w1_br u_t003_021/c1_r0_rbl u_t003_021/c1_r1_rbl
+ u_t003_021/c2_w0_bl u_t003_021/c2_w0_br u_t003_021/c2_w1_bl u_t003_021/c2_w1_br
+ u_t003_021/c2_r0_rbl u_t003_021/c2_r1_rbl u_t003_021/c3_w0_bl u_t003_021/c3_w0_br
+ u_t003_021/c3_w1_bl u_t003_021/c3_w1_br u_t003_021/c3_r0_rbl u_t003_021/c3_r1_rbl
+ u_t003_021/r0_w0_wl u_t003_021/r0_w1_wl u_t003_021/r0_r0_rwl u_t003_021/r0_r1_rwl
+ u_t003_021/r1_w0_wl u_t003_021/r1_w1_wl u_t003_021/r1_r0_rwl u_t003_021/r1_r1_rwl
+ u_t003_021/r2_w0_wl u_t003_021/r2_w1_wl u_t003_021/r2_r0_rwl u_t003_021/r2_r1_rwl
+ u_t003_021/r3_w0_wl u_t003_021/r3_w1_wl u_t003_021/r3_r0_rwl u_t003_021/r3_r1_rwl
+ u_t004_021/VDD u_t003_024/VSS VSUBS detronyx_12t_2w2r_rc4_4x4_routed_5layer_direct
Xu_t003_010 u_t003_010/c0_w0_bl u_t003_010/c0_w0_br u_t003_010/c0_w1_bl u_t003_010/c0_w1_br
+ u_t003_010/c0_r0_rbl u_t003_010/c0_r1_rbl u_t003_010/c1_w0_bl u_t003_010/c1_w0_br
+ u_t003_010/c1_w1_bl u_t003_010/c1_w1_br u_t003_010/c1_r0_rbl u_t003_010/c1_r1_rbl
+ u_t003_010/c2_w0_bl u_t003_010/c2_w0_br u_t003_010/c2_w1_bl u_t003_010/c2_w1_br
+ u_t003_010/c2_r0_rbl u_t003_010/c2_r1_rbl u_t003_010/c3_w0_bl u_t003_010/c3_w0_br
+ u_t003_010/c3_w1_bl u_t003_010/c3_w1_br u_t003_010/c3_r0_rbl u_t003_010/c3_r1_rbl
+ u_t003_010/r0_w0_wl u_t003_010/r0_w1_wl u_t003_010/r0_r0_rwl u_t003_010/r0_r1_rwl
+ u_t003_010/r1_w0_wl u_t003_010/r1_w1_wl u_t003_010/r1_r0_rwl u_t003_010/r1_r1_rwl
+ u_t003_010/r2_w0_wl u_t003_010/r2_w1_wl u_t003_010/r2_r0_rwl u_t003_010/r2_r1_rwl
+ u_t003_010/r3_w0_wl u_t003_010/r3_w1_wl u_t003_010/r3_r0_rwl u_t003_010/r3_r1_rwl
+ VSS u_t003_010/VSS VSUBS detronyx_12t_2w2r_rc4_4x4_routed_5layer_direct
Xgf180mcu_as_sc_mcu7t3v3__inv_2_920 VSS VSS VSS VSS gf180mcu_as_sc_mcu7t3v3__inv_2_920/VNW
+ VSUBS gf180mcu_as_sc_mcu7t3v3__inv_2
Xgf180mcu_as_sc_mcu7t3v3__inv_2_931 VSS VSS VSS VSS gf180mcu_as_sc_mcu7t3v3__inv_2_932/VNW
+ VSUBS gf180mcu_as_sc_mcu7t3v3__inv_2
Xgf180mcu_as_sc_mcu7t3v3__inv_2_942 VSS VSS VSS VSS gf180mcu_as_sc_mcu7t3v3__inv_2_944/VNW
+ VSUBS gf180mcu_as_sc_mcu7t3v3__inv_2
Xgf180mcu_as_sc_mcu7t3v3__inv_2_986 VSS VSS gf180mcu_as_sc_mcu7t3v3__inv_2_986/Y VSS
+ gf180mcu_as_sc_mcu7t3v3__inv_2_986/VNW VSUBS gf180mcu_as_sc_mcu7t3v3__inv_2
Xgf180mcu_as_sc_mcu7t3v3__inv_2_964 gf180mcu_as_sc_mcu7t3v3__inv_2_966/VDD gf180mcu_as_sc_mcu7t3v3__inv_2_970/VDD
+ VSS gf180mcu_as_sc_mcu7t3v3__inv_2_991/A gf180mcu_as_sc_mcu7t3v3__inv_2_966/VNW
+ VSUBS gf180mcu_as_sc_mcu7t3v3__inv_2
Xgf180mcu_as_sc_mcu7t3v3__inv_2_975 VSS VSS VSS gf180mcu_as_sc_mcu7t3v3__inv_2_991/A
+ gf180mcu_as_sc_mcu7t3v3__inv_2_983/VNW VSUBS gf180mcu_as_sc_mcu7t3v3__inv_2
Xgf180mcu_as_sc_mcu7t3v3__inv_2_997 VSS VSS gf180mcu_as_sc_mcu7t3v3__inv_2_997/Y gf180mcu_as_sc_mcu7t3v3__inv_2_998/Y
+ gf180mcu_as_sc_mcu7t3v3__inv_2_998/VNW VSUBS gf180mcu_as_sc_mcu7t3v3__inv_2
Xgf180mcu_as_sc_mcu7t3v3__inv_2_953 VSS VSS VSS VSS gf180mcu_as_sc_mcu7t3v3__inv_2_954/VNW
+ VSUBS gf180mcu_as_sc_mcu7t3v3__inv_2
Xgf180mcu_as_sc_mcu7t3v3__nand4_2_274 VSS VSS VSS VSS VSS VSS VSS gf180mcu_as_sc_mcu7t3v3__inv_2_948/VNW
+ VSUBS gf180mcu_as_sc_mcu7t3v3__nand4_2
Xgf180mcu_as_sc_mcu7t3v3__nand4_2_230 VSS VSS VSS VSS VSS VSS gf180mcu_as_sc_mcu7t3v3__nand4_2_230/Y
+ gf180mcu_as_sc_mcu7t3v3__inv_2_789/VNW VSUBS gf180mcu_as_sc_mcu7t3v3__nand4_2
Xgf180mcu_as_sc_mcu7t3v3__nand4_2_241 VSS VSS VSS VSS VSS VSS gf180mcu_as_sc_mcu7t3v3__nand4_2_241/Y
+ gf180mcu_as_sc_mcu7t3v3__inv_2_808/VNW VSUBS gf180mcu_as_sc_mcu7t3v3__nand4_2
Xgf180mcu_as_sc_mcu7t3v3__nand4_2_263 VSS VSS VSS VSS VSS VSS gf180mcu_as_sc_mcu7t3v3__nand4_2_263/Y
+ gf180mcu_as_sc_mcu7t3v3__inv_2_865/VNW VSUBS gf180mcu_as_sc_mcu7t3v3__nand4_2
Xgf180mcu_as_sc_mcu7t3v3__nand4_2_285 gf180mcu_as_sc_mcu7t3v3__inv_2_987/VSS VSS VSS
+ VSS VSS VSS VSS gf180mcu_as_sc_mcu7t3v3__inv_2_958/VNW VSUBS gf180mcu_as_sc_mcu7t3v3__nand4_2
Xgf180mcu_as_sc_mcu7t3v3__nand4_2_252 VSS VSS VSS VSS VSS VSS VSS gf180mcu_as_sc_mcu7t3v3__inv_2_860/VNW
+ VSUBS gf180mcu_as_sc_mcu7t3v3__nand4_2
Xgf180mcu_as_sc_mcu7t3v3__nand4_2_296 VSS gf180mcu_as_sc_mcu7t3v3__inv_2_967/VDD VSS
+ VSS VSS VSS VSS gf180mcu_as_sc_mcu7t3v3__inv_2_1002/VNW VSUBS gf180mcu_as_sc_mcu7t3v3__nand4_2
Xgf180mcu_as_sc_mcu7t3v3__inv_2_205 gf180mcu_as_sc_mcu7t3v3__inv_2_205/VDD VSS VSS
+ VSS gf180mcu_as_sc_mcu7t3v3__inv_2_205/VNW VSUBS gf180mcu_as_sc_mcu7t3v3__inv_2
Xgf180mcu_as_sc_mcu7t3v3__inv_2_227 VSS gf180mcu_as_sc_mcu7t3v3__inv_2_228/VSS gf180mcu_as_sc_mcu7t3v3__inv_2_227/Y
+ VSS gf180mcu_as_sc_mcu7t3v3__inv_2_228/VNW VSUBS gf180mcu_as_sc_mcu7t3v3__inv_2
Xgf180mcu_as_sc_mcu7t3v3__inv_2_216 VSS gf180mcu_as_sc_mcu7t3v3__inv_2_220/VDD gf180mcu_as_sc_mcu7t3v3__inv_2_216/Y
+ VSS gf180mcu_as_sc_mcu7t3v3__inv_2_216/VNW VSUBS gf180mcu_as_sc_mcu7t3v3__inv_2
Xgf180mcu_as_sc_mcu7t3v3__inv_2_238 gf180mcu_as_sc_mcu7t3v3__inv_2_257/VSS VSS VSS
+ VSS gf180mcu_as_sc_mcu7t3v3__inv_2_246/VNW VSUBS gf180mcu_as_sc_mcu7t3v3__inv_2
Xgf180mcu_as_sc_mcu7t3v3__inv_2_249 VSS gf180mcu_as_sc_mcu7t3v3__inv_2_257/VDD VSS
+ VSS gf180mcu_as_sc_mcu7t3v3__inv_2_249/VNW VSUBS gf180mcu_as_sc_mcu7t3v3__inv_2
Xu_t000_024 u_t000_024/c0_w0_bl u_t000_024/c0_w0_br u_t000_024/c0_w1_bl u_t000_024/c0_w1_br
+ u_t000_024/c0_r0_rbl u_t000_024/c0_r1_rbl u_t000_024/c1_w0_bl u_t000_024/c1_w0_br
+ u_t000_024/c1_w1_bl u_t000_024/c1_w1_br u_t000_024/c1_r0_rbl u_t000_024/c1_r1_rbl
+ u_t000_024/c2_w0_bl u_t000_024/c2_w0_br u_t000_024/c2_w1_bl u_t000_024/c2_w1_br
+ u_t000_024/c2_r0_rbl u_t000_024/c2_r1_rbl u_t000_024/c3_w0_bl u_t000_024/c3_w0_br
+ u_t000_024/c3_w1_bl u_t000_024/c3_w1_br u_t000_024/c3_r0_rbl u_t000_024/c3_r1_rbl
+ u_t000_024/r0_w0_wl u_t000_024/r0_w1_wl u_t000_024/r0_r0_rwl u_t000_024/r0_r1_rwl
+ u_t000_024/r1_w0_wl u_t000_024/r1_w1_wl u_t000_024/r1_r0_rwl u_t000_024/r1_r1_rwl
+ u_t000_024/r2_w0_wl u_t000_024/r2_w1_wl u_t000_024/r2_r0_rwl u_t000_024/r2_r1_rwl
+ u_t000_024/r3_w0_wl u_t000_024/r3_w1_wl u_t000_024/r3_r0_rwl u_t000_024/r3_r1_rwl
+ VSS u_t000_031/VSS VSUBS detronyx_12t_2w2r_rc4_4x4_routed_5layer_direct
Xu_t000_013 u_t000_013/c0_w0_bl u_t000_013/c0_w0_br u_t000_013/c0_w1_bl u_t000_013/c0_w1_br
+ u_t000_013/c0_r0_rbl u_t000_013/c0_r1_rbl u_t000_013/c1_w0_bl u_t000_013/c1_w0_br
+ u_t000_013/c1_w1_bl u_t000_013/c1_w1_br u_t000_013/c1_r0_rbl u_t000_013/c1_r1_rbl
+ u_t000_013/c2_w0_bl u_t000_013/c2_w0_br u_t000_013/c2_w1_bl u_t000_013/c2_w1_br
+ u_t000_013/c2_r0_rbl u_t000_013/c2_r1_rbl u_t000_013/c3_w0_bl u_t000_013/c3_w0_br
+ u_t000_013/c3_w1_bl u_t000_013/c3_w1_br u_t000_013/c3_r0_rbl u_t000_013/c3_r1_rbl
+ u_t000_013/r0_w0_wl u_t000_013/r0_w1_wl u_t000_013/r0_r0_rwl u_t000_013/r0_r1_rwl
+ u_t000_013/r1_w0_wl u_t000_013/r1_w1_wl u_t000_013/r1_r0_rwl u_t000_013/r1_r1_rwl
+ u_t000_013/r2_w0_wl u_t000_013/r2_w1_wl u_t000_013/r2_r0_rwl u_t000_013/r2_r1_rwl
+ u_t000_013/r3_w0_wl u_t000_013/r3_w1_wl u_t000_013/r3_r0_rwl u_t000_013/r3_r1_rwl
+ u_t000_013/VDD u_t000_031/VSS VSUBS detronyx_12t_2w2r_rc4_4x4_routed_5layer_direct
Xu_t000_002 u_t000_002/c0_w0_bl u_t000_002/c0_w0_br u_t000_002/c0_w1_bl u_t000_002/c0_w1_br
+ u_t000_002/c0_r0_rbl u_t000_002/c0_r1_rbl u_t000_002/c1_w0_bl u_t000_002/c1_w0_br
+ u_t000_002/c1_w1_bl u_t000_002/c1_w1_br u_t000_002/c1_r0_rbl u_t000_002/c1_r1_rbl
+ u_t000_002/c2_w0_bl u_t000_002/c2_w0_br u_t000_002/c2_w1_bl u_t000_002/c2_w1_br
+ u_t000_002/c2_r0_rbl u_t000_002/c2_r1_rbl u_t000_002/c3_w0_bl u_t000_002/c3_w0_br
+ u_t000_002/c3_w1_bl u_t000_002/c3_w1_br u_t000_002/c3_r0_rbl u_t000_002/c3_r1_rbl
+ u_t000_002/r0_w0_wl u_t000_002/r0_w1_wl u_t000_002/r0_r0_rwl u_t000_002/r0_r1_rwl
+ u_t000_002/r1_w0_wl u_t000_002/r1_w1_wl u_t000_002/r1_r0_rwl u_t000_002/r1_r1_rwl
+ u_t000_002/r2_w0_wl u_t000_002/r2_w1_wl u_t000_002/r2_r0_rwl u_t000_002/r2_r1_rwl
+ u_t000_002/r3_w0_wl u_t000_002/r3_w1_wl u_t000_002/r3_r0_rwl u_t000_002/r3_r1_rwl
+ VSS u_t000_031/VSS VSUBS detronyx_12t_2w2r_rc4_4x4_routed_5layer_direct
Xgf180mcu_as_sc_mcu7t3v3__inv_2_772 VSS VSS gf180mcu_as_sc_mcu7t3v3__inv_2_772/Y VSS
+ gf180mcu_as_sc_mcu7t3v3__inv_2_772/VNW VSUBS gf180mcu_as_sc_mcu7t3v3__inv_2
Xgf180mcu_as_sc_mcu7t3v3__inv_2_750 VSS VSS gf180mcu_as_sc_mcu7t3v3__inv_2_750/Y VSS
+ gf180mcu_as_sc_mcu7t3v3__inv_2_752/VNW VSUBS gf180mcu_as_sc_mcu7t3v3__inv_2
Xgf180mcu_as_sc_mcu7t3v3__inv_2_761 VSS VSS VSS VSS gf180mcu_as_sc_mcu7t3v3__inv_2_765/VNW
+ VSUBS gf180mcu_as_sc_mcu7t3v3__inv_2
Xgf180mcu_as_sc_mcu7t3v3__inv_2_783 VSS VSS VSS VSS gf180mcu_as_sc_mcu7t3v3__inv_2_784/VNW
+ VSUBS gf180mcu_as_sc_mcu7t3v3__inv_2
Xgf180mcu_as_sc_mcu7t3v3__inv_2_794 VSS VSS VSS VSS gf180mcu_as_sc_mcu7t3v3__inv_2_795/VNW
+ VSUBS gf180mcu_as_sc_mcu7t3v3__inv_2
Xgf180mcu_as_sc_mcu7t3v3__inv_2_580 gf180mcu_as_sc_mcu7t3v3__inv_2_584/VDD gf180mcu_as_sc_mcu7t3v3__inv_2_584/VDD
+ gf180mcu_as_sc_mcu7t3v3__inv_2_580/Y VSS gf180mcu_as_sc_mcu7t3v3__inv_2_580/VNW
+ VSUBS gf180mcu_as_sc_mcu7t3v3__inv_2
Xgf180mcu_as_sc_mcu7t3v3__inv_2_591 VSS gf180mcu_as_sc_mcu7t3v3__inv_2_597/VDD gf180mcu_as_sc_mcu7t3v3__inv_2_591/Y
+ gf180mcu_as_sc_mcu7t3v3__inv_2_631/A gf180mcu_as_sc_mcu7t3v3__inv_2_593/VNW VSUBS
+ gf180mcu_as_sc_mcu7t3v3__inv_2
Xgf180mcu_as_sc_mcu7t3v3__nor2_2_6 gf180mcu_as_sc_mcu7t3v3__nor2_2_6/VDD gf180mcu_as_sc_mcu7t3v3__nor2_2_6/VSS
+ VSS VSS VSS gf180mcu_as_sc_mcu7t3v3__nor2_2_6/VNW VSUBS gf180mcu_as_sc_mcu7t3v3__nor2_2
Xgf180mcu_as_sc_mcu7t3v3__inv_2_1309 VSS VSS gf180mcu_as_sc_mcu7t3v3__inv_2_1369/Y
+ gf180mcu_as_sc_mcu7t3v3__inv_2_1369/Y gf180mcu_as_sc_mcu7t3v3__inv_2_1367/VNW VSUBS
+ gf180mcu_as_sc_mcu7t3v3__inv_2
Xu_t028_027 u_t028_027/c0_w0_bl u_t028_027/c0_w0_br u_t028_027/c0_w1_bl u_t028_027/c0_w1_br
+ u_t028_027/c0_r0_rbl u_t028_027/c0_r1_rbl u_t028_027/c1_w0_bl u_t028_027/c1_w0_br
+ u_t028_027/c1_w1_bl u_t028_027/c1_w1_br u_t028_027/c1_r0_rbl u_t028_027/c1_r1_rbl
+ u_t028_027/c2_w0_bl u_t028_027/c2_w0_br u_t028_027/c2_w1_bl u_t028_027/c2_w1_br
+ u_t028_027/c2_r0_rbl u_t028_027/c2_r1_rbl u_t028_027/c3_w0_bl u_t028_027/c3_w0_br
+ u_t028_027/c3_w1_bl u_t028_027/c3_w1_br u_t028_027/c3_r0_rbl u_t028_027/c3_r1_rbl
+ u_t028_027/r0_w0_wl u_t028_027/r0_w1_wl u_t028_027/r0_r0_rwl u_t028_027/r0_r1_rwl
+ u_t028_027/r1_w0_wl u_t028_027/r1_w1_wl u_t028_027/r1_r0_rwl u_t028_027/r1_r1_rwl
+ u_t028_027/r2_w0_wl u_t028_027/r2_w1_wl u_t028_027/r2_r0_rwl u_t028_027/r2_r1_rwl
+ u_t028_027/r3_w0_wl u_t028_027/r3_w1_wl u_t028_027/r3_r0_rwl u_t028_027/r3_r1_rwl
+ u_t029_027/VDD u_t028_027/VSS VSUBS detronyx_12t_2w2r_rc4_4x4_routed_5layer_direct
Xu_t028_016 u_t028_016/c0_w0_bl u_t028_016/c0_w0_br u_t028_016/c0_w1_bl u_t028_016/c0_w1_br
+ u_t028_016/c0_r0_rbl u_t028_016/c0_r1_rbl u_t028_016/c1_w0_bl u_t028_016/c1_w0_br
+ u_t028_016/c1_w1_bl u_t028_016/c1_w1_br u_t028_016/c1_r0_rbl u_t028_016/c1_r1_rbl
+ u_t028_016/c2_w0_bl u_t028_016/c2_w0_br u_t028_016/c2_w1_bl u_t028_016/c2_w1_br
+ u_t028_016/c2_r0_rbl u_t028_016/c2_r1_rbl u_t028_016/c3_w0_bl u_t028_016/c3_w0_br
+ u_t028_016/c3_w1_bl u_t028_016/c3_w1_br u_t028_016/c3_r0_rbl u_t028_016/c3_r1_rbl
+ u_t028_016/r0_w0_wl u_t028_016/r0_w1_wl u_t028_016/r0_r0_rwl u_t028_016/r0_r1_rwl
+ u_t028_016/r1_w0_wl u_t028_016/r1_w1_wl u_t028_016/r1_r0_rwl u_t028_016/r1_r1_rwl
+ u_t028_016/r2_w0_wl u_t028_016/r2_w1_wl u_t028_016/r2_r0_rwl u_t028_016/r2_r1_rwl
+ u_t028_016/r3_w0_wl u_t028_016/r3_w1_wl u_t028_016/r3_r0_rwl u_t028_016/r3_r1_rwl
+ VSS u_t028_017/VSS VSUBS detronyx_12t_2w2r_rc4_4x4_routed_5layer_direct
Xu_t028_005 u_t028_005/c0_w0_bl u_t028_005/c0_w0_br u_t028_005/c0_w1_bl u_t028_005/c0_w1_br
+ u_t028_005/c0_r0_rbl u_t028_005/c0_r1_rbl u_t028_005/c1_w0_bl u_t028_005/c1_w0_br
+ u_t028_005/c1_w1_bl u_t028_005/c1_w1_br u_t028_005/c1_r0_rbl u_t028_005/c1_r1_rbl
+ u_t028_005/c2_w0_bl u_t028_005/c2_w0_br u_t028_005/c2_w1_bl u_t028_005/c2_w1_br
+ u_t028_005/c2_r0_rbl u_t028_005/c2_r1_rbl u_t028_005/c3_w0_bl u_t028_005/c3_w0_br
+ u_t028_005/c3_w1_bl u_t028_005/c3_w1_br u_t028_005/c3_r0_rbl u_t028_005/c3_r1_rbl
+ u_t028_005/r0_w0_wl u_t028_005/r0_w1_wl u_t028_005/r0_r0_rwl u_t028_005/r0_r1_rwl
+ u_t028_005/r1_w0_wl u_t028_005/r1_w1_wl u_t028_005/r1_r0_rwl u_t028_005/r1_r1_rwl
+ u_t028_005/r2_w0_wl u_t028_005/r2_w1_wl u_t028_005/r2_r0_rwl u_t028_005/r2_r1_rwl
+ u_t028_005/r3_w0_wl u_t028_005/r3_w1_wl u_t028_005/r3_r0_rwl u_t028_005/r3_r1_rwl
+ u_t029_005/VDD u_t028_005/VSS VSUBS detronyx_12t_2w2r_rc4_4x4_routed_5layer_direct
Xu_t019_027 u_t019_027/c0_w0_bl u_t019_027/c0_w0_br u_t019_027/c0_w1_bl u_t019_027/c0_w1_br
+ u_t019_027/c0_r0_rbl u_t019_027/c0_r1_rbl u_t019_027/c1_w0_bl u_t019_027/c1_w0_br
+ u_t019_027/c1_w1_bl u_t019_027/c1_w1_br u_t019_027/c1_r0_rbl u_t019_027/c1_r1_rbl
+ u_t019_027/c2_w0_bl u_t019_027/c2_w0_br u_t019_027/c2_w1_bl u_t019_027/c2_w1_br
+ u_t019_027/c2_r0_rbl u_t019_027/c2_r1_rbl u_t019_027/c3_w0_bl u_t019_027/c3_w0_br
+ u_t019_027/c3_w1_bl u_t019_027/c3_w1_br u_t019_027/c3_r0_rbl u_t019_027/c3_r1_rbl
+ u_t019_027/r0_w0_wl u_t019_027/r0_w1_wl u_t019_027/r0_r0_rwl u_t019_027/r0_r1_rwl
+ u_t019_027/r1_w0_wl u_t019_027/r1_w1_wl u_t019_027/r1_r0_rwl u_t019_027/r1_r1_rwl
+ u_t019_027/r2_w0_wl u_t019_027/r2_w1_wl u_t019_027/r2_r0_rwl u_t019_027/r2_r1_rwl
+ u_t019_027/r3_w0_wl u_t019_027/r3_w1_wl u_t019_027/r3_r0_rwl u_t019_027/r3_r1_rwl
+ u_t019_027/VDD u_t019_027/VSS VSUBS detronyx_12t_2w2r_rc4_4x4_routed_5layer_direct
Xu_t019_016 u_t019_016/c0_w0_bl u_t019_016/c0_w0_br u_t019_016/c0_w1_bl u_t019_016/c0_w1_br
+ u_t019_016/c0_r0_rbl u_t019_016/c0_r1_rbl u_t019_016/c1_w0_bl u_t019_016/c1_w0_br
+ u_t019_016/c1_w1_bl u_t019_016/c1_w1_br u_t019_016/c1_r0_rbl u_t019_016/c1_r1_rbl
+ u_t019_016/c2_w0_bl u_t019_016/c2_w0_br u_t019_016/c2_w1_bl u_t019_016/c2_w1_br
+ u_t019_016/c2_r0_rbl u_t019_016/c2_r1_rbl u_t019_016/c3_w0_bl u_t019_016/c3_w0_br
+ u_t019_016/c3_w1_bl u_t019_016/c3_w1_br u_t019_016/c3_r0_rbl u_t019_016/c3_r1_rbl
+ u_t019_016/r0_w0_wl u_t019_016/r0_w1_wl u_t019_016/r0_r0_rwl u_t019_016/r0_r1_rwl
+ u_t019_016/r1_w0_wl u_t019_016/r1_w1_wl u_t019_016/r1_r0_rwl u_t019_016/r1_r1_rwl
+ u_t019_016/r2_w0_wl u_t019_016/r2_w1_wl u_t019_016/r2_r0_rwl u_t019_016/r2_r1_rwl
+ u_t019_016/r3_w0_wl u_t019_016/r3_w1_wl u_t019_016/r3_r0_rwl u_t019_016/r3_r1_rwl
+ VSS u_t019_017/VSS VSUBS detronyx_12t_2w2r_rc4_4x4_routed_5layer_direct
Xu_t019_005 u_t019_005/c0_w0_bl u_t019_005/c0_w0_br u_t019_005/c0_w1_bl u_t019_005/c0_w1_br
+ u_t019_005/c0_r0_rbl u_t019_005/c0_r1_rbl u_t019_005/c1_w0_bl u_t019_005/c1_w0_br
+ u_t019_005/c1_w1_bl u_t019_005/c1_w1_br u_t019_005/c1_r0_rbl u_t019_005/c1_r1_rbl
+ u_t019_005/c2_w0_bl u_t019_005/c2_w0_br u_t019_005/c2_w1_bl u_t019_005/c2_w1_br
+ u_t019_005/c2_r0_rbl u_t019_005/c2_r1_rbl u_t019_005/c3_w0_bl u_t019_005/c3_w0_br
+ u_t019_005/c3_w1_bl u_t019_005/c3_w1_br u_t019_005/c3_r0_rbl u_t019_005/c3_r1_rbl
+ u_t019_005/r0_w0_wl u_t019_005/r0_w1_wl u_t019_005/r0_r0_rwl u_t019_005/r0_r1_rwl
+ u_t019_005/r1_w0_wl u_t019_005/r1_w1_wl u_t019_005/r1_r0_rwl u_t019_005/r1_r1_rwl
+ u_t019_005/r2_w0_wl u_t019_005/r2_w1_wl u_t019_005/r2_r0_rwl u_t019_005/r2_r1_rwl
+ u_t019_005/r3_w0_wl u_t019_005/r3_w1_wl u_t019_005/r3_r0_rwl u_t019_005/r3_r1_rwl
+ u_t019_005/VDD u_t019_005/VSS VSUBS detronyx_12t_2w2r_rc4_4x4_routed_5layer_direct
Xu_t025_019 u_t025_019/c0_w0_bl u_t025_019/c0_w0_br u_t025_019/c0_w1_bl u_t025_019/c0_w1_br
+ u_t025_019/c0_r0_rbl u_t025_019/c0_r1_rbl u_t025_019/c1_w0_bl u_t025_019/c1_w0_br
+ u_t025_019/c1_w1_bl u_t025_019/c1_w1_br u_t025_019/c1_r0_rbl u_t025_019/c1_r1_rbl
+ u_t025_019/c2_w0_bl u_t025_019/c2_w0_br u_t025_019/c2_w1_bl u_t025_019/c2_w1_br
+ u_t025_019/c2_r0_rbl u_t025_019/c2_r1_rbl u_t025_019/c3_w0_bl u_t025_019/c3_w0_br
+ u_t025_019/c3_w1_bl u_t025_019/c3_w1_br u_t025_019/c3_r0_rbl u_t025_019/c3_r1_rbl
+ u_t025_019/r0_w0_wl u_t025_019/r0_w1_wl u_t025_019/r0_r0_rwl u_t025_019/r0_r1_rwl
+ u_t025_019/r1_w0_wl u_t025_019/r1_w1_wl u_t025_019/r1_r0_rwl u_t025_019/r1_r1_rwl
+ u_t025_019/r2_w0_wl u_t025_019/r2_w1_wl u_t025_019/r2_r0_rwl u_t025_019/r2_r1_rwl
+ u_t025_019/r3_w0_wl u_t025_019/r3_w1_wl u_t025_019/r3_r0_rwl u_t025_019/r3_r1_rwl
+ u_t025_019/VDD u_t025_031/VSS VSUBS detronyx_12t_2w2r_rc4_4x4_routed_5layer_direct
Xu_t025_008 u_t025_008/c0_w0_bl u_t025_008/c0_w0_br u_t025_008/c0_w1_bl u_t025_008/c0_w1_br
+ u_t025_008/c0_r0_rbl u_t025_008/c0_r1_rbl u_t025_008/c1_w0_bl u_t025_008/c1_w0_br
+ u_t025_008/c1_w1_bl u_t025_008/c1_w1_br u_t025_008/c1_r0_rbl u_t025_008/c1_r1_rbl
+ u_t025_008/c2_w0_bl u_t025_008/c2_w0_br u_t025_008/c2_w1_bl u_t025_008/c2_w1_br
+ u_t025_008/c2_r0_rbl u_t025_008/c2_r1_rbl u_t025_008/c3_w0_bl u_t025_008/c3_w0_br
+ u_t025_008/c3_w1_bl u_t025_008/c3_w1_br u_t025_008/c3_r0_rbl u_t025_008/c3_r1_rbl
+ u_t025_008/r0_w0_wl u_t025_008/r0_w1_wl u_t025_008/r0_r0_rwl u_t025_008/r0_r1_rwl
+ u_t025_008/r1_w0_wl u_t025_008/r1_w1_wl u_t025_008/r1_r0_rwl u_t025_008/r1_r1_rwl
+ u_t025_008/r2_w0_wl u_t025_008/r2_w1_wl u_t025_008/r2_r0_rwl u_t025_008/r2_r1_rwl
+ u_t025_008/r3_w0_wl u_t025_008/r3_w1_wl u_t025_008/r3_r0_rwl u_t025_008/r3_r1_rwl
+ VSS u_t025_031/VSS VSUBS detronyx_12t_2w2r_rc4_4x4_routed_5layer_direct
Xgf180mcu_as_sc_mcu7t3v3__inv_2_1128 VSS gf180mcu_as_sc_mcu7t3v3__inv_2_1132/VDD VSS
+ gf180mcu_as_sc_mcu7t3v3__inv_2_1129/Y gf180mcu_as_sc_mcu7t3v3__inv_2_1129/VNW VSUBS
+ gf180mcu_as_sc_mcu7t3v3__inv_2
Xgf180mcu_as_sc_mcu7t3v3__inv_2_1139 gf180mcu_as_sc_mcu7t3v3__inv_2_1141/VDD gf180mcu_as_sc_mcu7t3v3__inv_2_1143/VDD
+ VSS VSS gf180mcu_as_sc_mcu7t3v3__inv_2_1141/VNW VSUBS gf180mcu_as_sc_mcu7t3v3__inv_2
Xgf180mcu_as_sc_mcu7t3v3__inv_2_1117 gf180mcu_as_sc_mcu7t3v3__inv_2_1117/VDD VSS gf180mcu_as_sc_mcu7t3v3__inv_2_1117/Y
+ VSS gf180mcu_as_sc_mcu7t3v3__inv_2_1117/VNW VSUBS gf180mcu_as_sc_mcu7t3v3__inv_2
Xgf180mcu_as_sc_mcu7t3v3__inv_2_1106 gf180mcu_as_sc_mcu7t3v3__inv_2_1107/VDD VSS VSS
+ gf180mcu_as_sc_mcu7t3v3__inv_2_1106/A gf180mcu_as_sc_mcu7t3v3__inv_2_1107/VNW VSUBS
+ gf180mcu_as_sc_mcu7t3v3__inv_2
Xu_t016_019 u_t016_019/c0_w0_bl u_t016_019/c0_w0_br u_t016_019/c0_w1_bl u_t016_019/c0_w1_br
+ u_t016_019/c0_r0_rbl u_t016_019/c0_r1_rbl u_t016_019/c1_w0_bl u_t016_019/c1_w0_br
+ u_t016_019/c1_w1_bl u_t016_019/c1_w1_br u_t016_019/c1_r0_rbl u_t016_019/c1_r1_rbl
+ u_t016_019/c2_w0_bl u_t016_019/c2_w0_br u_t016_019/c2_w1_bl u_t016_019/c2_w1_br
+ u_t016_019/c2_r0_rbl u_t016_019/c2_r1_rbl u_t016_019/c3_w0_bl u_t016_019/c3_w0_br
+ u_t016_019/c3_w1_bl u_t016_019/c3_w1_br u_t016_019/c3_r0_rbl u_t016_019/c3_r1_rbl
+ u_t016_019/r0_w0_wl u_t016_019/r0_w1_wl u_t016_019/r0_r0_rwl u_t016_019/r0_r1_rwl
+ u_t016_019/r1_w0_wl u_t016_019/r1_w1_wl u_t016_019/r1_r0_rwl u_t016_019/r1_r1_rwl
+ u_t016_019/r2_w0_wl u_t016_019/r2_w1_wl u_t016_019/r2_r0_rwl u_t016_019/r2_r1_rwl
+ u_t016_019/r3_w0_wl u_t016_019/r3_w1_wl u_t016_019/r3_r0_rwl u_t016_019/r3_r1_rwl
+ u_t016_019/VDD u_t016_019/VSS VSUBS detronyx_12t_2w2r_rc4_4x4_routed_5layer_direct
Xu_t016_008 u_t016_008/c0_w0_bl u_t016_008/c0_w0_br u_t016_008/c0_w1_bl u_t016_008/c0_w1_br
+ u_t016_008/c0_r0_rbl u_t016_008/c0_r1_rbl u_t016_008/c1_w0_bl u_t016_008/c1_w0_br
+ u_t016_008/c1_w1_bl u_t016_008/c1_w1_br u_t016_008/c1_r0_rbl u_t016_008/c1_r1_rbl
+ u_t016_008/c2_w0_bl u_t016_008/c2_w0_br u_t016_008/c2_w1_bl u_t016_008/c2_w1_br
+ u_t016_008/c2_r0_rbl u_t016_008/c2_r1_rbl u_t016_008/c3_w0_bl u_t016_008/c3_w0_br
+ u_t016_008/c3_w1_bl u_t016_008/c3_w1_br u_t016_008/c3_r0_rbl u_t016_008/c3_r1_rbl
+ u_t016_008/r0_w0_wl u_t016_008/r0_w1_wl u_t016_008/r0_r0_rwl u_t016_008/r0_r1_rwl
+ u_t016_008/r1_w0_wl u_t016_008/r1_w1_wl u_t016_008/r1_r0_rwl u_t016_008/r1_r1_rwl
+ u_t016_008/r2_w0_wl u_t016_008/r2_w1_wl u_t016_008/r2_r0_rwl u_t016_008/r2_r1_rwl
+ u_t016_008/r3_w0_wl u_t016_008/r3_w1_wl u_t016_008/r3_r0_rwl u_t016_008/r3_r1_rwl
+ VSS u_t016_009/VSS VSUBS detronyx_12t_2w2r_rc4_4x4_routed_5layer_direct
Xgf180mcu_as_sc_mcu7t3v3__nand3_2_31 gf180mcu_as_sc_mcu7t3v3__nand3_2_31/VDD gf180mcu_as_sc_mcu7t3v3__nand3_2_31/VSS
+ VSS VSS VSS VSS gf180mcu_as_sc_mcu7t3v3__nand3_2_31/VNW VSUBS gf180mcu_as_sc_mcu7t3v3__nand3_2
Xgf180mcu_as_sc_mcu7t3v3__nand3_2_20 gf180mcu_as_sc_mcu7t3v3__nor2_2_6/VDD gf180mcu_as_sc_mcu7t3v3__nor2_2_6/VSS
+ VSS VSS VSS VSS gf180mcu_as_sc_mcu7t3v3__nor2_2_6/VNW VSUBS gf180mcu_as_sc_mcu7t3v3__nand3_2
Xu_t024_030 u_t024_030/c0_w0_bl u_t024_030/c0_w0_br u_t024_030/c0_w1_bl u_t024_030/c0_w1_br
+ u_t024_030/c0_r0_rbl u_t024_030/c0_r1_rbl u_t024_030/c1_w0_bl u_t024_030/c1_w0_br
+ u_t024_030/c1_w1_bl u_t024_030/c1_w1_br u_t024_030/c1_r0_rbl u_t024_030/c1_r1_rbl
+ u_t024_030/c2_w0_bl u_t024_030/c2_w0_br u_t024_030/c2_w1_bl u_t024_030/c2_w1_br
+ u_t024_030/c2_r0_rbl u_t024_030/c2_r1_rbl u_t024_030/c3_w0_bl u_t024_030/c3_w0_br
+ u_t024_030/c3_w1_bl u_t024_030/c3_w1_br u_t024_030/c3_r0_rbl u_t024_030/c3_r1_rbl
+ u_t024_030/r0_w0_wl u_t024_030/r0_w1_wl u_t024_030/r0_r0_rwl u_t024_030/r0_r1_rwl
+ u_t024_030/r1_w0_wl u_t024_030/r1_w1_wl u_t024_030/r1_r0_rwl u_t024_030/r1_r1_rwl
+ u_t024_030/r2_w0_wl u_t024_030/r2_w1_wl u_t024_030/r2_r0_rwl u_t024_030/r2_r1_rwl
+ u_t024_030/r3_w0_wl u_t024_030/r3_w1_wl u_t024_030/r3_r0_rwl u_t024_030/r3_r1_rwl
+ VSS u_t024_031/VSS VSUBS detronyx_12t_2w2r_rc4_4x4_routed_5layer_direct
Xgf180mcu_as_sc_mcu7t3v3__inv_2_1673 VSS gf180mcu_as_sc_mcu7t3v3__inv_2_1674/VDD gf180mcu_as_sc_mcu7t3v3__inv_2_1675/Y
+ VSS gf180mcu_as_sc_mcu7t3v3__inv_2_1673/VNW VSUBS gf180mcu_as_sc_mcu7t3v3__inv_2
Xgf180mcu_as_sc_mcu7t3v3__inv_2_1640 gf180mcu_as_sc_mcu7t3v3__inv_2_1674/VDD gf180mcu_as_sc_mcu7t3v3__inv_2_1675/VDD
+ gf180mcu_as_sc_mcu7t3v3__inv_2_1640/Y gf180mcu_as_sc_mcu7t3v3__inv_2_1675/Y gf180mcu_as_sc_mcu7t3v3__inv_2_1674/VNW
+ VSUBS gf180mcu_as_sc_mcu7t3v3__inv_2
Xgf180mcu_as_sc_mcu7t3v3__inv_2_1651 gf180mcu_as_sc_mcu7t3v3__inv_2_1667/VSS VSS gf180mcu_as_sc_mcu7t3v3__inv_2_1682/Y
+ VSS gf180mcu_as_sc_mcu7t3v3__inv_2_1651/VNW VSUBS gf180mcu_as_sc_mcu7t3v3__inv_2
Xgf180mcu_as_sc_mcu7t3v3__inv_2_1662 VSS gf180mcu_as_sc_mcu7t3v3__inv_2_1663/VDD gf180mcu_as_sc_mcu7t3v3__inv_2_1685/Y
+ VSS gf180mcu_as_sc_mcu7t3v3__inv_2_1662/VNW VSUBS gf180mcu_as_sc_mcu7t3v3__inv_2
Xgf180mcu_as_sc_mcu7t3v3__inv_2_1684 gf180mcu_as_sc_mcu7t3v3__inv_2_1685/VDD VSS gf180mcu_as_sc_mcu7t3v3__inv_2_1685/Y
+ gf180mcu_as_sc_mcu7t3v3__inv_2_1685/Y gf180mcu_as_sc_mcu7t3v3__inv_2_1685/VNW VSUBS
+ gf180mcu_as_sc_mcu7t3v3__inv_2
Xgf180mcu_as_sc_mcu7t3v3__inv_2_1695 VSS VSS gf180mcu_as_sc_mcu7t3v3__inv_2_1695/Y
+ VSS gf180mcu_as_sc_mcu7t3v3__inv_2_1697/VNW VSUBS gf180mcu_as_sc_mcu7t3v3__inv_2
Xu_t015_030 u_t015_030/c0_w0_bl u_t015_030/c0_w0_br u_t015_030/c0_w1_bl u_t015_030/c0_w1_br
+ u_t015_030/c0_r0_rbl u_t015_030/c0_r1_rbl u_t015_030/c1_w0_bl u_t015_030/c1_w0_br
+ u_t015_030/c1_w1_bl u_t015_030/c1_w1_br u_t015_030/c1_r0_rbl u_t015_030/c1_r1_rbl
+ u_t015_030/c2_w0_bl u_t015_030/c2_w0_br u_t015_030/c2_w1_bl u_t015_030/c2_w1_br
+ u_t015_030/c2_r0_rbl u_t015_030/c2_r1_rbl u_t015_030/c3_w0_bl u_t015_030/c3_w0_br
+ u_t015_030/c3_w1_bl u_t015_030/c3_w1_br u_t015_030/c3_r0_rbl u_t015_030/c3_r1_rbl
+ u_t015_030/r0_w0_wl u_t015_030/r0_w1_wl u_t015_030/r0_r0_rwl u_t015_030/r0_r1_rwl
+ u_t015_030/r1_w0_wl u_t015_030/r1_w1_wl u_t015_030/r1_r0_rwl u_t015_030/r1_r1_rwl
+ u_t015_030/r2_w0_wl u_t015_030/r2_w1_wl u_t015_030/r2_r0_rwl u_t015_030/r2_r1_rwl
+ u_t015_030/r3_w0_wl u_t015_030/r3_w1_wl u_t015_030/r3_r0_rwl u_t015_030/r3_r1_rwl
+ VSS u_t015_031/VSS VSUBS detronyx_12t_2w2r_rc4_4x4_routed_5layer_direct
Xu_t007_019 u_t007_019/c0_w0_bl u_t007_019/c0_w0_br u_t007_019/c0_w1_bl u_t007_019/c0_w1_br
+ u_t007_019/c0_r0_rbl u_t007_019/c0_r1_rbl u_t007_019/c1_w0_bl u_t007_019/c1_w0_br
+ u_t007_019/c1_w1_bl u_t007_019/c1_w1_br u_t007_019/c1_r0_rbl u_t007_019/c1_r1_rbl
+ u_t007_019/c2_w0_bl u_t007_019/c2_w0_br u_t007_019/c2_w1_bl u_t007_019/c2_w1_br
+ u_t007_019/c2_r0_rbl u_t007_019/c2_r1_rbl u_t007_019/c3_w0_bl u_t007_019/c3_w0_br
+ u_t007_019/c3_w1_bl u_t007_019/c3_w1_br u_t007_019/c3_r0_rbl u_t007_019/c3_r1_rbl
+ u_t007_019/r0_w0_wl u_t007_019/r0_w1_wl u_t007_019/r0_r0_rwl u_t007_019/r0_r1_rwl
+ u_t007_019/r1_w0_wl u_t007_019/r1_w1_wl u_t007_019/r1_r0_rwl u_t007_019/r1_r1_rwl
+ u_t007_019/r2_w0_wl u_t007_019/r2_w1_wl u_t007_019/r2_r0_rwl u_t007_019/r2_r1_rwl
+ u_t007_019/r3_w0_wl u_t007_019/r3_w1_wl u_t007_019/r3_r0_rwl u_t007_019/r3_r1_rwl
+ u_t008_019/VDD u_t007_019/VSS VSUBS detronyx_12t_2w2r_rc4_4x4_routed_5layer_direct
Xu_t007_008 u_t007_008/c0_w0_bl u_t007_008/c0_w0_br u_t007_008/c0_w1_bl u_t007_008/c0_w1_br
+ u_t007_008/c0_r0_rbl u_t007_008/c0_r1_rbl u_t007_008/c1_w0_bl u_t007_008/c1_w0_br
+ u_t007_008/c1_w1_bl u_t007_008/c1_w1_br u_t007_008/c1_r0_rbl u_t007_008/c1_r1_rbl
+ u_t007_008/c2_w0_bl u_t007_008/c2_w0_br u_t007_008/c2_w1_bl u_t007_008/c2_w1_br
+ u_t007_008/c2_r0_rbl u_t007_008/c2_r1_rbl u_t007_008/c3_w0_bl u_t007_008/c3_w0_br
+ u_t007_008/c3_w1_bl u_t007_008/c3_w1_br u_t007_008/c3_r0_rbl u_t007_008/c3_r1_rbl
+ u_t007_008/r0_w0_wl u_t007_008/r0_w1_wl u_t007_008/r0_r0_rwl u_t007_008/r0_r1_rwl
+ u_t007_008/r1_w0_wl u_t007_008/r1_w1_wl u_t007_008/r1_r0_rwl u_t007_008/r1_r1_rwl
+ u_t007_008/r2_w0_wl u_t007_008/r2_w1_wl u_t007_008/r2_r0_rwl u_t007_008/r2_r1_rwl
+ u_t007_008/r3_w0_wl u_t007_008/r3_w1_wl u_t007_008/r3_r0_rwl u_t007_008/r3_r1_rwl
+ VSS u_t007_009/VSS VSUBS detronyx_12t_2w2r_rc4_4x4_routed_5layer_direct
Xu_t030_022 u_t030_022/c0_w0_bl u_t030_022/c0_w0_br u_t030_022/c0_w1_bl u_t030_022/c0_w1_br
+ u_t030_022/c0_r0_rbl u_t030_022/c0_r1_rbl u_t030_022/c1_w0_bl u_t030_022/c1_w0_br
+ u_t030_022/c1_w1_bl u_t030_022/c1_w1_br u_t030_022/c1_r0_rbl u_t030_022/c1_r1_rbl
+ u_t030_022/c2_w0_bl u_t030_022/c2_w0_br u_t030_022/c2_w1_bl u_t030_022/c2_w1_br
+ u_t030_022/c2_r0_rbl u_t030_022/c2_r1_rbl u_t030_022/c3_w0_bl u_t030_022/c3_w0_br
+ u_t030_022/c3_w1_bl u_t030_022/c3_w1_br u_t030_022/c3_r0_rbl u_t030_022/c3_r1_rbl
+ u_t030_022/r0_w0_wl u_t030_022/r0_w1_wl u_t030_022/r0_r0_rwl u_t030_022/r0_r1_rwl
+ u_t030_022/r1_w0_wl u_t030_022/r1_w1_wl u_t030_022/r1_r0_rwl u_t030_022/r1_r1_rwl
+ u_t030_022/r2_w0_wl u_t030_022/r2_w1_wl u_t030_022/r2_r0_rwl u_t030_022/r2_r1_rwl
+ u_t030_022/r3_w0_wl u_t030_022/r3_w1_wl u_t030_022/r3_r0_rwl u_t030_022/r3_r1_rwl
+ VSS u_t030_031/VSS VSUBS detronyx_12t_2w2r_rc4_4x4_routed_5layer_direct
Xu_t030_011 u_t030_011/c0_w0_bl u_t030_011/c0_w0_br u_t030_011/c0_w1_bl u_t030_011/c0_w1_br
+ u_t030_011/c0_r0_rbl u_t030_011/c0_r1_rbl u_t030_011/c1_w0_bl u_t030_011/c1_w0_br
+ u_t030_011/c1_w1_bl u_t030_011/c1_w1_br u_t030_011/c1_r0_rbl u_t030_011/c1_r1_rbl
+ u_t030_011/c2_w0_bl u_t030_011/c2_w0_br u_t030_011/c2_w1_bl u_t030_011/c2_w1_br
+ u_t030_011/c2_r0_rbl u_t030_011/c2_r1_rbl u_t030_011/c3_w0_bl u_t030_011/c3_w0_br
+ u_t030_011/c3_w1_bl u_t030_011/c3_w1_br u_t030_011/c3_r0_rbl u_t030_011/c3_r1_rbl
+ u_t030_011/r0_w0_wl u_t030_011/r0_w1_wl u_t030_011/r0_r0_rwl u_t030_011/r0_r1_rwl
+ u_t030_011/r1_w0_wl u_t030_011/r1_w1_wl u_t030_011/r1_r0_rwl u_t030_011/r1_r1_rwl
+ u_t030_011/r2_w0_wl u_t030_011/r2_w1_wl u_t030_011/r2_r0_rwl u_t030_011/r2_r1_rwl
+ u_t030_011/r3_w0_wl u_t030_011/r3_w1_wl u_t030_011/r3_r0_rwl u_t030_011/r3_r1_rwl
+ u_t030_011/VDD u_t030_031/VSS VSUBS detronyx_12t_2w2r_rc4_4x4_routed_5layer_direct
Xu_t030_000 u_t030_000/c0_w0_bl u_t030_000/c0_w0_br u_t030_000/c0_w1_bl u_t030_000/c0_w1_br
+ u_t030_000/c0_r0_rbl u_t030_000/c0_r1_rbl u_t030_000/c1_w0_bl u_t030_000/c1_w0_br
+ u_t030_000/c1_w1_bl u_t030_000/c1_w1_br u_t030_000/c1_r0_rbl u_t030_000/c1_r1_rbl
+ u_t030_000/c2_w0_bl u_t030_000/c2_w0_br u_t030_000/c2_w1_bl u_t030_000/c2_w1_br
+ u_t030_000/c2_r0_rbl u_t030_000/c2_r1_rbl u_t030_000/c3_w0_bl u_t030_000/c3_w0_br
+ u_t030_000/c3_w1_bl u_t030_000/c3_w1_br u_t030_000/c3_r0_rbl u_t030_000/c3_r1_rbl
+ u_t030_000/r0_w0_wl u_t030_000/r0_w1_wl u_t030_000/r0_r0_rwl u_t030_000/r0_r1_rwl
+ u_t030_000/r1_w0_wl u_t030_000/r1_w1_wl u_t030_000/r1_r0_rwl u_t030_000/r1_r1_rwl
+ u_t030_000/r2_w0_wl u_t030_000/r2_w1_wl u_t030_000/r2_r0_rwl u_t030_000/r2_r1_rwl
+ u_t030_000/r3_w0_wl u_t030_000/r3_w1_wl u_t030_000/r3_r0_rwl u_t030_000/r3_r1_rwl
+ VSS u_t030_031/VSS VSUBS detronyx_12t_2w2r_rc4_4x4_routed_5layer_direct
Xgf180mcu_as_sc_mcu7t3v3__nand4_2_401 VSS VSS VSS VSS VSS VSS VSS gf180mcu_as_sc_mcu7t3v3__inv_2_1385/VNW
+ VSUBS gf180mcu_as_sc_mcu7t3v3__nand4_2
Xgf180mcu_as_sc_mcu7t3v3__nand4_2_456 VSS gf180mcu_as_sc_mcu7t3v3__inv_2_1577/VDD
+ VSS VSS VSS VSS VSS gf180mcu_as_sc_mcu7t3v3__inv_2_1573/VNW VSUBS gf180mcu_as_sc_mcu7t3v3__nand4_2
Xgf180mcu_as_sc_mcu7t3v3__nand4_2_489 VSS gf180mcu_as_sc_mcu7t3v3__inv_2_1667/VDD
+ VSS VSS VSS VSS VSS gf180mcu_as_sc_mcu7t3v3__inv_2_1666/VNW VSUBS gf180mcu_as_sc_mcu7t3v3__nand4_2
Xgf180mcu_as_sc_mcu7t3v3__nand4_2_467 gf180mcu_as_sc_mcu7t3v3__inv_2_1539/VDD VSS
+ VSS VSS VSS VSS gf180mcu_as_sc_mcu7t3v3__nand4_2_467/Y gf180mcu_as_sc_mcu7t3v3__inv_2_1539/VNW
+ VSUBS gf180mcu_as_sc_mcu7t3v3__nand4_2
Xgf180mcu_as_sc_mcu7t3v3__nand4_2_478 gf180mcu_as_sc_mcu7t3v3__inv_2_1663/VDD gf180mcu_as_sc_mcu7t3v3__inv_2_1685/VDD
+ VSS VSS VSS VSS VSS gf180mcu_as_sc_mcu7t3v3__inv_2_1663/VNW VSUBS gf180mcu_as_sc_mcu7t3v3__nand4_2
Xgf180mcu_as_sc_mcu7t3v3__nand4_2_445 gf180mcu_as_sc_mcu7t3v3__inv_2_1497/VDD gf180mcu_as_sc_mcu7t3v3__inv_2_1497/VSS
+ VSS VSS VSS VSS gf180mcu_as_sc_mcu7t3v3__nand4_2_445/Y gf180mcu_as_sc_mcu7t3v3__inv_2_1497/VNW
+ VSUBS gf180mcu_as_sc_mcu7t3v3__nand4_2
Xgf180mcu_as_sc_mcu7t3v3__nand4_2_412 gf180mcu_as_sc_mcu7t3v3__inv_2_1384/VDD VSS
+ VSS VSS VSS VSS VSS gf180mcu_as_sc_mcu7t3v3__inv_2_1384/VNW VSUBS gf180mcu_as_sc_mcu7t3v3__nand4_2
Xgf180mcu_as_sc_mcu7t3v3__nand4_2_434 gf180mcu_as_sc_mcu7t3v3__inv_2_1480/VDD VSS
+ VSS VSS VSS VSS gf180mcu_as_sc_mcu7t3v3__nand4_2_434/Y gf180mcu_as_sc_mcu7t3v3__inv_2_1480/VNW
+ VSUBS gf180mcu_as_sc_mcu7t3v3__nand4_2
Xgf180mcu_as_sc_mcu7t3v3__inv_2_2 gf180mcu_as_sc_mcu7t3v3__inv_2_2/VDD gf180mcu_as_sc_mcu7t3v3__inv_2_9/VSS
+ gf180mcu_as_sc_mcu7t3v3__inv_2_2/Y gf180mcu_as_sc_mcu7t3v3__inv_2_2/A gf180mcu_as_sc_mcu7t3v3__inv_2_2/VNW
+ VSUBS gf180mcu_as_sc_mcu7t3v3__inv_2
Xgf180mcu_as_sc_mcu7t3v3__nand4_2_423 VSS gf180mcu_as_sc_mcu7t3v3__inv_2_1440/VDD
+ VSS VSS VSS VSS VSS gf180mcu_as_sc_mcu7t3v3__inv_2_1436/VNW VSUBS gf180mcu_as_sc_mcu7t3v3__nand4_2
Xu_t006_030 u_t006_030/c0_w0_bl u_t006_030/c0_w0_br u_t006_030/c0_w1_bl u_t006_030/c0_w1_br
+ u_t006_030/c0_r0_rbl u_t006_030/c0_r1_rbl u_t006_030/c1_w0_bl u_t006_030/c1_w0_br
+ u_t006_030/c1_w1_bl u_t006_030/c1_w1_br u_t006_030/c1_r0_rbl u_t006_030/c1_r1_rbl
+ u_t006_030/c2_w0_bl u_t006_030/c2_w0_br u_t006_030/c2_w1_bl u_t006_030/c2_w1_br
+ u_t006_030/c2_r0_rbl u_t006_030/c2_r1_rbl u_t006_030/c3_w0_bl u_t006_030/c3_w0_br
+ u_t006_030/c3_w1_bl u_t006_030/c3_w1_br u_t006_030/c3_r0_rbl u_t006_030/c3_r1_rbl
+ u_t006_030/r0_w0_wl u_t006_030/r0_w1_wl u_t006_030/r0_r0_rwl u_t006_030/r0_r1_rwl
+ u_t006_030/r1_w0_wl u_t006_030/r1_w1_wl u_t006_030/r1_r0_rwl u_t006_030/r1_r1_rwl
+ u_t006_030/r2_w0_wl u_t006_030/r2_w1_wl u_t006_030/r2_r0_rwl u_t006_030/r2_r1_rwl
+ u_t006_030/r3_w0_wl u_t006_030/r3_w1_wl u_t006_030/r3_r0_rwl u_t006_030/r3_r1_rwl
+ VSS u_t006_031/VSS VSUBS detronyx_12t_2w2r_rc4_4x4_routed_5layer_direct
Xu_t021_022 u_t021_022/c0_w0_bl u_t021_022/c0_w0_br u_t021_022/c0_w1_bl u_t021_022/c0_w1_br
+ u_t021_022/c0_r0_rbl u_t021_022/c0_r1_rbl u_t021_022/c1_w0_bl u_t021_022/c1_w0_br
+ u_t021_022/c1_w1_bl u_t021_022/c1_w1_br u_t021_022/c1_r0_rbl u_t021_022/c1_r1_rbl
+ u_t021_022/c2_w0_bl u_t021_022/c2_w0_br u_t021_022/c2_w1_bl u_t021_022/c2_w1_br
+ u_t021_022/c2_r0_rbl u_t021_022/c2_r1_rbl u_t021_022/c3_w0_bl u_t021_022/c3_w0_br
+ u_t021_022/c3_w1_bl u_t021_022/c3_w1_br u_t021_022/c3_r0_rbl u_t021_022/c3_r1_rbl
+ u_t021_022/r0_w0_wl u_t021_022/r0_w1_wl u_t021_022/r0_r0_rwl u_t021_022/r0_r1_rwl
+ u_t021_022/r1_w0_wl u_t021_022/r1_w1_wl u_t021_022/r1_r0_rwl u_t021_022/r1_r1_rwl
+ u_t021_022/r2_w0_wl u_t021_022/r2_w1_wl u_t021_022/r2_r0_rwl u_t021_022/r2_r1_rwl
+ u_t021_022/r3_w0_wl u_t021_022/r3_w1_wl u_t021_022/r3_r0_rwl u_t021_022/r3_r1_rwl
+ VSS u_t021_031/VSS VSUBS detronyx_12t_2w2r_rc4_4x4_routed_5layer_direct
Xu_t021_011 u_t021_011/c0_w0_bl u_t021_011/c0_w0_br u_t021_011/c0_w1_bl u_t021_011/c0_w1_br
+ u_t021_011/c0_r0_rbl u_t021_011/c0_r1_rbl u_t021_011/c1_w0_bl u_t021_011/c1_w0_br
+ u_t021_011/c1_w1_bl u_t021_011/c1_w1_br u_t021_011/c1_r0_rbl u_t021_011/c1_r1_rbl
+ u_t021_011/c2_w0_bl u_t021_011/c2_w0_br u_t021_011/c2_w1_bl u_t021_011/c2_w1_br
+ u_t021_011/c2_r0_rbl u_t021_011/c2_r1_rbl u_t021_011/c3_w0_bl u_t021_011/c3_w0_br
+ u_t021_011/c3_w1_bl u_t021_011/c3_w1_br u_t021_011/c3_r0_rbl u_t021_011/c3_r1_rbl
+ u_t021_011/r0_w0_wl u_t021_011/r0_w1_wl u_t021_011/r0_r0_rwl u_t021_011/r0_r1_rwl
+ u_t021_011/r1_w0_wl u_t021_011/r1_w1_wl u_t021_011/r1_r0_rwl u_t021_011/r1_r1_rwl
+ u_t021_011/r2_w0_wl u_t021_011/r2_w1_wl u_t021_011/r2_r0_rwl u_t021_011/r2_r1_rwl
+ u_t021_011/r3_w0_wl u_t021_011/r3_w1_wl u_t021_011/r3_r0_rwl u_t021_011/r3_r1_rwl
+ u_t021_011/VDD u_t021_031/VSS VSUBS detronyx_12t_2w2r_rc4_4x4_routed_5layer_direct
Xu_t021_000 u_t021_000/c0_w0_bl u_t021_000/c0_w0_br u_t021_000/c0_w1_bl u_t021_000/c0_w1_br
+ u_t021_000/c0_r0_rbl u_t021_000/c0_r1_rbl u_t021_000/c1_w0_bl u_t021_000/c1_w0_br
+ u_t021_000/c1_w1_bl u_t021_000/c1_w1_br u_t021_000/c1_r0_rbl u_t021_000/c1_r1_rbl
+ u_t021_000/c2_w0_bl u_t021_000/c2_w0_br u_t021_000/c2_w1_bl u_t021_000/c2_w1_br
+ u_t021_000/c2_r0_rbl u_t021_000/c2_r1_rbl u_t021_000/c3_w0_bl u_t021_000/c3_w0_br
+ u_t021_000/c3_w1_bl u_t021_000/c3_w1_br u_t021_000/c3_r0_rbl u_t021_000/c3_r1_rbl
+ u_t021_000/r0_w0_wl u_t021_000/r0_w1_wl u_t021_000/r0_r0_rwl u_t021_000/r0_r1_rwl
+ u_t021_000/r1_w0_wl u_t021_000/r1_w1_wl u_t021_000/r1_r0_rwl u_t021_000/r1_r1_rwl
+ u_t021_000/r2_w0_wl u_t021_000/r2_w1_wl u_t021_000/r2_r0_rwl u_t021_000/r2_r1_rwl
+ u_t021_000/r3_w0_wl u_t021_000/r3_w1_wl u_t021_000/r3_r0_rwl u_t021_000/r3_r1_rwl
+ VSS u_t021_031/VSS VSUBS detronyx_12t_2w2r_rc4_4x4_routed_5layer_direct
Xgf180mcu_as_sc_mcu7t3v3__inv_2_409 VSS VSS VSS VSS gf180mcu_as_sc_mcu7t3v3__inv_2_410/VNW
+ VSUBS gf180mcu_as_sc_mcu7t3v3__inv_2
Xu_t012_022 u_t012_022/c0_w0_bl u_t012_022/c0_w0_br u_t012_022/c0_w1_bl u_t012_022/c0_w1_br
+ u_t012_022/c0_r0_rbl u_t012_022/c0_r1_rbl u_t012_022/c1_w0_bl u_t012_022/c1_w0_br
+ u_t012_022/c1_w1_bl u_t012_022/c1_w1_br u_t012_022/c1_r0_rbl u_t012_022/c1_r1_rbl
+ u_t012_022/c2_w0_bl u_t012_022/c2_w0_br u_t012_022/c2_w1_bl u_t012_022/c2_w1_br
+ u_t012_022/c2_r0_rbl u_t012_022/c2_r1_rbl u_t012_022/c3_w0_bl u_t012_022/c3_w0_br
+ u_t012_022/c3_w1_bl u_t012_022/c3_w1_br u_t012_022/c3_r0_rbl u_t012_022/c3_r1_rbl
+ u_t012_022/r0_w0_wl u_t012_022/r0_w1_wl u_t012_022/r0_r0_rwl u_t012_022/r0_r1_rwl
+ u_t012_022/r1_w0_wl u_t012_022/r1_w1_wl u_t012_022/r1_r0_rwl u_t012_022/r1_r1_rwl
+ u_t012_022/r2_w0_wl u_t012_022/r2_w1_wl u_t012_022/r2_r0_rwl u_t012_022/r2_r1_rwl
+ u_t012_022/r3_w0_wl u_t012_022/r3_w1_wl u_t012_022/r3_r0_rwl u_t012_022/r3_r1_rwl
+ VSS u_t012_031/VSS VSUBS detronyx_12t_2w2r_rc4_4x4_routed_5layer_direct
Xu_t012_011 u_t012_011/c0_w0_bl u_t012_011/c0_w0_br u_t012_011/c0_w1_bl u_t012_011/c0_w1_br
+ u_t012_011/c0_r0_rbl u_t012_011/c0_r1_rbl u_t012_011/c1_w0_bl u_t012_011/c1_w0_br
+ u_t012_011/c1_w1_bl u_t012_011/c1_w1_br u_t012_011/c1_r0_rbl u_t012_011/c1_r1_rbl
+ u_t012_011/c2_w0_bl u_t012_011/c2_w0_br u_t012_011/c2_w1_bl u_t012_011/c2_w1_br
+ u_t012_011/c2_r0_rbl u_t012_011/c2_r1_rbl u_t012_011/c3_w0_bl u_t012_011/c3_w0_br
+ u_t012_011/c3_w1_bl u_t012_011/c3_w1_br u_t012_011/c3_r0_rbl u_t012_011/c3_r1_rbl
+ u_t012_011/r0_w0_wl u_t012_011/r0_w1_wl u_t012_011/r0_r0_rwl u_t012_011/r0_r1_rwl
+ u_t012_011/r1_w0_wl u_t012_011/r1_w1_wl u_t012_011/r1_r0_rwl u_t012_011/r1_r1_rwl
+ u_t012_011/r2_w0_wl u_t012_011/r2_w1_wl u_t012_011/r2_r0_rwl u_t012_011/r2_r1_rwl
+ u_t012_011/r3_w0_wl u_t012_011/r3_w1_wl u_t012_011/r3_r0_rwl u_t012_011/r3_r1_rwl
+ u_t012_011/VDD u_t012_031/VSS VSUBS detronyx_12t_2w2r_rc4_4x4_routed_5layer_direct
Xu_t012_000 u_t012_000/c0_w0_bl u_t012_000/c0_w0_br u_t012_000/c0_w1_bl u_t012_000/c0_w1_br
+ u_t012_000/c0_r0_rbl u_t012_000/c0_r1_rbl u_t012_000/c1_w0_bl u_t012_000/c1_w0_br
+ u_t012_000/c1_w1_bl u_t012_000/c1_w1_br u_t012_000/c1_r0_rbl u_t012_000/c1_r1_rbl
+ u_t012_000/c2_w0_bl u_t012_000/c2_w0_br u_t012_000/c2_w1_bl u_t012_000/c2_w1_br
+ u_t012_000/c2_r0_rbl u_t012_000/c2_r1_rbl u_t012_000/c3_w0_bl u_t012_000/c3_w0_br
+ u_t012_000/c3_w1_bl u_t012_000/c3_w1_br u_t012_000/c3_r0_rbl u_t012_000/c3_r1_rbl
+ u_t012_000/r0_w0_wl u_t012_000/r0_w1_wl u_t012_000/r0_r0_rwl u_t012_000/r0_r1_rwl
+ u_t012_000/r1_w0_wl u_t012_000/r1_w1_wl u_t012_000/r1_r0_rwl u_t012_000/r1_r1_rwl
+ u_t012_000/r2_w0_wl u_t012_000/r2_w1_wl u_t012_000/r2_r0_rwl u_t012_000/r2_r1_rwl
+ u_t012_000/r3_w0_wl u_t012_000/r3_w1_wl u_t012_000/r3_r0_rwl u_t012_000/r3_r1_rwl
+ VSS u_t012_031/VSS VSUBS detronyx_12t_2w2r_rc4_4x4_routed_5layer_direct
Xgf180mcu_as_sc_mcu7t3v3__inv_2_1481 VSS gf180mcu_as_sc_mcu7t3v3__inv_2_1497/VDD VSS
+ VSS gf180mcu_as_sc_mcu7t3v3__inv_2_1481/VNW VSUBS gf180mcu_as_sc_mcu7t3v3__inv_2
Xgf180mcu_as_sc_mcu7t3v3__inv_2_1470 VSS VSS VSS VSS gf180mcu_as_sc_mcu7t3v3__inv_2_1472/VNW
+ VSUBS gf180mcu_as_sc_mcu7t3v3__inv_2
Xgf180mcu_as_sc_mcu7t3v3__inv_2_1492 gf180mcu_as_sc_mcu7t3v3__inv_2_1492/VDD gf180mcu_as_sc_mcu7t3v3__inv_2_1496/VDD
+ gf180mcu_as_sc_mcu7t3v3__inv_2_1492/Y VSS gf180mcu_as_sc_mcu7t3v3__inv_2_1492/VNW
+ VSUBS gf180mcu_as_sc_mcu7t3v3__inv_2
Xu_t003_022 u_t003_022/c0_w0_bl u_t003_022/c0_w0_br u_t003_022/c0_w1_bl u_t003_022/c0_w1_br
+ u_t003_022/c0_r0_rbl u_t003_022/c0_r1_rbl u_t003_022/c1_w0_bl u_t003_022/c1_w0_br
+ u_t003_022/c1_w1_bl u_t003_022/c1_w1_br u_t003_022/c1_r0_rbl u_t003_022/c1_r1_rbl
+ u_t003_022/c2_w0_bl u_t003_022/c2_w0_br u_t003_022/c2_w1_bl u_t003_022/c2_w1_br
+ u_t003_022/c2_r0_rbl u_t003_022/c2_r1_rbl u_t003_022/c3_w0_bl u_t003_022/c3_w0_br
+ u_t003_022/c3_w1_bl u_t003_022/c3_w1_br u_t003_022/c3_r0_rbl u_t003_022/c3_r1_rbl
+ u_t003_022/r0_w0_wl u_t003_022/r0_w1_wl u_t003_022/r0_r0_rwl u_t003_022/r0_r1_rwl
+ u_t003_022/r1_w0_wl u_t003_022/r1_w1_wl u_t003_022/r1_r0_rwl u_t003_022/r1_r1_rwl
+ u_t003_022/r2_w0_wl u_t003_022/r2_w1_wl u_t003_022/r2_r0_rwl u_t003_022/r2_r1_rwl
+ u_t003_022/r3_w0_wl u_t003_022/r3_w1_wl u_t003_022/r3_r0_rwl u_t003_022/r3_r1_rwl
+ VSS u_t003_024/VSS VSUBS detronyx_12t_2w2r_rc4_4x4_routed_5layer_direct
Xu_t003_011 u_t003_011/c0_w0_bl u_t003_011/c0_w0_br u_t003_011/c0_w1_bl u_t003_011/c0_w1_br
+ u_t003_011/c0_r0_rbl u_t003_011/c0_r1_rbl u_t003_011/c1_w0_bl u_t003_011/c1_w0_br
+ u_t003_011/c1_w1_bl u_t003_011/c1_w1_br u_t003_011/c1_r0_rbl u_t003_011/c1_r1_rbl
+ u_t003_011/c2_w0_bl u_t003_011/c2_w0_br u_t003_011/c2_w1_bl u_t003_011/c2_w1_br
+ u_t003_011/c2_r0_rbl u_t003_011/c2_r1_rbl u_t003_011/c3_w0_bl u_t003_011/c3_w0_br
+ u_t003_011/c3_w1_bl u_t003_011/c3_w1_br u_t003_011/c3_r0_rbl u_t003_011/c3_r1_rbl
+ u_t003_011/r0_w0_wl u_t003_011/r0_w1_wl u_t003_011/r0_r0_rwl u_t003_011/r0_r1_rwl
+ u_t003_011/r1_w0_wl u_t003_011/r1_w1_wl u_t003_011/r1_r0_rwl u_t003_011/r1_r1_rwl
+ u_t003_011/r2_w0_wl u_t003_011/r2_w1_wl u_t003_011/r2_r0_rwl u_t003_011/r2_r1_rwl
+ u_t003_011/r3_w0_wl u_t003_011/r3_w1_wl u_t003_011/r3_r0_rwl u_t003_011/r3_r1_rwl
+ u_t004_011/VDD u_t003_011/VSS VSUBS detronyx_12t_2w2r_rc4_4x4_routed_5layer_direct
Xu_t003_000 u_t003_000/c0_w0_bl u_t003_000/c0_w0_br u_t003_000/c0_w1_bl u_t003_000/c0_w1_br
+ u_t003_000/c0_r0_rbl u_t003_000/c0_r1_rbl u_t003_000/c1_w0_bl u_t003_000/c1_w0_br
+ u_t003_000/c1_w1_bl u_t003_000/c1_w1_br u_t003_000/c1_r0_rbl u_t003_000/c1_r1_rbl
+ u_t003_000/c2_w0_bl u_t003_000/c2_w0_br u_t003_000/c2_w1_bl u_t003_000/c2_w1_br
+ u_t003_000/c2_r0_rbl u_t003_000/c2_r1_rbl u_t003_000/c3_w0_bl u_t003_000/c3_w0_br
+ u_t003_000/c3_w1_bl u_t003_000/c3_w1_br u_t003_000/c3_r0_rbl u_t003_000/c3_r1_rbl
+ u_t003_000/r0_w0_wl u_t003_000/r0_w1_wl u_t003_000/r0_r0_rwl u_t003_000/r0_r1_rwl
+ u_t003_000/r1_w0_wl u_t003_000/r1_w1_wl u_t003_000/r1_r0_rwl u_t003_000/r1_r1_rwl
+ u_t003_000/r2_w0_wl u_t003_000/r2_w1_wl u_t003_000/r2_r0_rwl u_t003_000/r2_r1_rwl
+ u_t003_000/r3_w0_wl u_t003_000/r3_w1_wl u_t003_000/r3_r0_rwl u_t003_000/r3_r1_rwl
+ VSS u_t003_002/VSS VSUBS detronyx_12t_2w2r_rc4_4x4_routed_5layer_direct
Xgf180mcu_as_sc_mcu7t3v3__inv_2_921 VSS VSS VSS VSS gf180mcu_as_sc_mcu7t3v3__inv_2_949/VNW
+ VSUBS gf180mcu_as_sc_mcu7t3v3__inv_2
Xgf180mcu_as_sc_mcu7t3v3__inv_2_932 VSS VSS gf180mcu_as_sc_mcu7t3v3__inv_2_932/Y VSS
+ gf180mcu_as_sc_mcu7t3v3__inv_2_932/VNW VSUBS gf180mcu_as_sc_mcu7t3v3__inv_2
Xgf180mcu_as_sc_mcu7t3v3__inv_2_943 VSS VSS VSS VSS gf180mcu_as_sc_mcu7t3v3__inv_2_944/VNW
+ VSUBS gf180mcu_as_sc_mcu7t3v3__inv_2
Xgf180mcu_as_sc_mcu7t3v3__inv_2_976 gf180mcu_as_sc_mcu7t3v3__inv_2_978/VDD gf180mcu_as_sc_mcu7t3v3__inv_2_982/VDD
+ VSS gf180mcu_as_sc_mcu7t3v3__inv_2_991/A gf180mcu_as_sc_mcu7t3v3__inv_2_978/VNW
+ VSUBS gf180mcu_as_sc_mcu7t3v3__inv_2
Xgf180mcu_as_sc_mcu7t3v3__inv_2_965 gf180mcu_as_sc_mcu7t3v3__inv_2_966/VDD gf180mcu_as_sc_mcu7t3v3__inv_2_970/VDD
+ gf180mcu_as_sc_mcu7t3v3__inv_2_965/Y gf180mcu_as_sc_mcu7t3v3__inv_2_966/Y gf180mcu_as_sc_mcu7t3v3__inv_2_966/VNW
+ VSUBS gf180mcu_as_sc_mcu7t3v3__inv_2
Xgf180mcu_as_sc_mcu7t3v3__inv_2_987 gf180mcu_as_sc_mcu7t3v3__inv_2_999/VSS gf180mcu_as_sc_mcu7t3v3__inv_2_987/VSS
+ gf180mcu_as_sc_mcu7t3v3__inv_2_987/Y gf180mcu_as_sc_mcu7t3v3__inv_2_987/A gf180mcu_as_sc_mcu7t3v3__inv_2_987/VNW
+ VSUBS gf180mcu_as_sc_mcu7t3v3__inv_2
Xgf180mcu_as_sc_mcu7t3v3__inv_2_998 VSS VSS gf180mcu_as_sc_mcu7t3v3__inv_2_998/Y VSS
+ gf180mcu_as_sc_mcu7t3v3__inv_2_998/VNW VSUBS gf180mcu_as_sc_mcu7t3v3__inv_2
Xgf180mcu_as_sc_mcu7t3v3__inv_2_954 VSS VSS gf180mcu_as_sc_mcu7t3v3__inv_2_954/Y VSS
+ gf180mcu_as_sc_mcu7t3v3__inv_2_954/VNW VSUBS gf180mcu_as_sc_mcu7t3v3__inv_2
Xgf180mcu_as_sc_mcu7t3v3__inv_2_910 VSS VSS VSS VSS gf180mcu_as_sc_mcu7t3v3__inv_2_914/VNW
+ VSUBS gf180mcu_as_sc_mcu7t3v3__inv_2
Xgf180mcu_as_sc_mcu7t3v3__nand4_2_220 VSS VSS VSS VSS VSS VSS gf180mcu_as_sc_mcu7t3v3__nand4_2_220/Y
+ gf180mcu_as_sc_mcu7t3v3__inv_2_772/VNW VSUBS gf180mcu_as_sc_mcu7t3v3__nand4_2
Xgf180mcu_as_sc_mcu7t3v3__nand4_2_231 VSS VSS VSS VSS VSS VSS gf180mcu_as_sc_mcu7t3v3__nand4_2_231/Y
+ gf180mcu_as_sc_mcu7t3v3__inv_2_785/VNW VSUBS gf180mcu_as_sc_mcu7t3v3__nand4_2
Xgf180mcu_as_sc_mcu7t3v3__nand4_2_242 VSS VSS VSS VSS VSS VSS gf180mcu_as_sc_mcu7t3v3__nand4_2_242/Y
+ gf180mcu_as_sc_mcu7t3v3__inv_2_812/VNW VSUBS gf180mcu_as_sc_mcu7t3v3__nand4_2
Xgf180mcu_as_sc_mcu7t3v3__nand4_2_253 VSS VSS VSS VSS VSS VSS gf180mcu_as_sc_mcu7t3v3__nand4_2_253/Y
+ gf180mcu_as_sc_mcu7t3v3__inv_2_864/VNW VSUBS gf180mcu_as_sc_mcu7t3v3__nand4_2
Xgf180mcu_as_sc_mcu7t3v3__nand4_2_275 VSS VSS VSS VSS VSS VSS gf180mcu_as_sc_mcu7t3v3__nand4_2_275/Y
+ gf180mcu_as_sc_mcu7t3v3__inv_2_951/VNW VSUBS gf180mcu_as_sc_mcu7t3v3__nand4_2
Xgf180mcu_as_sc_mcu7t3v3__nand4_2_286 VSS gf180mcu_as_sc_mcu7t3v3__inv_2_966/VDD VSS
+ VSS VSS VSS VSS gf180mcu_as_sc_mcu7t3v3__inv_2_962/VNW VSUBS gf180mcu_as_sc_mcu7t3v3__nand4_2
Xgf180mcu_as_sc_mcu7t3v3__nand4_2_297 gf180mcu_as_sc_mcu7t3v3__inv_2_967/VDD VSS VSS
+ VSS VSS VSS VSS gf180mcu_as_sc_mcu7t3v3__inv_2_967/VNW VSUBS gf180mcu_as_sc_mcu7t3v3__nand4_2
Xgf180mcu_as_sc_mcu7t3v3__nand4_2_264 VSS VSS VSS VSS VSS VSS gf180mcu_as_sc_mcu7t3v3__nand4_2_264/Y
+ gf180mcu_as_sc_mcu7t3v3__inv_2_881/VNW VSUBS gf180mcu_as_sc_mcu7t3v3__nand4_2
Xgf180mcu_as_sc_mcu7t3v3__inv_2_206 gf180mcu_as_sc_mcu7t3v3__inv_2_206/VDD gf180mcu_as_sc_mcu7t3v3__inv_2_371/VDD
+ VSS VSS gf180mcu_as_sc_mcu7t3v3__inv_2_206/VNW VSUBS gf180mcu_as_sc_mcu7t3v3__inv_2
Xgf180mcu_as_sc_mcu7t3v3__inv_2_228 VSS gf180mcu_as_sc_mcu7t3v3__inv_2_228/VSS gf180mcu_as_sc_mcu7t3v3__inv_2_228/Y
+ VSS gf180mcu_as_sc_mcu7t3v3__inv_2_228/VNW VSUBS gf180mcu_as_sc_mcu7t3v3__inv_2
Xgf180mcu_as_sc_mcu7t3v3__inv_2_217 gf180mcu_as_sc_mcu7t3v3__inv_2_257/VDD gf180mcu_as_sc_mcu7t3v3__inv_2_257/VSS
+ gf180mcu_as_sc_mcu7t3v3__inv_2_217/Y VSS gf180mcu_as_sc_mcu7t3v3__inv_2_257/VNW
+ VSUBS gf180mcu_as_sc_mcu7t3v3__inv_2
Xgf180mcu_as_sc_mcu7t3v3__inv_2_239 gf180mcu_as_sc_mcu7t3v3__inv_2_241/VDD gf180mcu_as_sc_mcu7t3v3__inv_2_245/VDD
+ VSS VSS gf180mcu_as_sc_mcu7t3v3__inv_2_241/VNW VSUBS gf180mcu_as_sc_mcu7t3v3__inv_2
Xu_t000_025 u_t000_025/c0_w0_bl u_t000_025/c0_w0_br u_t000_025/c0_w1_bl u_t000_025/c0_w1_br
+ u_t000_025/c0_r0_rbl u_t000_025/c0_r1_rbl u_t000_025/c1_w0_bl u_t000_025/c1_w0_br
+ u_t000_025/c1_w1_bl u_t000_025/c1_w1_br u_t000_025/c1_r0_rbl u_t000_025/c1_r1_rbl
+ u_t000_025/c2_w0_bl u_t000_025/c2_w0_br u_t000_025/c2_w1_bl u_t000_025/c2_w1_br
+ u_t000_025/c2_r0_rbl u_t000_025/c2_r1_rbl u_t000_025/c3_w0_bl u_t000_025/c3_w0_br
+ u_t000_025/c3_w1_bl u_t000_025/c3_w1_br u_t000_025/c3_r0_rbl u_t000_025/c3_r1_rbl
+ u_t000_025/r0_w0_wl u_t000_025/r0_w1_wl u_t000_025/r0_r0_rwl u_t000_025/r0_r1_rwl
+ u_t000_025/r1_w0_wl u_t000_025/r1_w1_wl u_t000_025/r1_r0_rwl u_t000_025/r1_r1_rwl
+ u_t000_025/r2_w0_wl u_t000_025/r2_w1_wl u_t000_025/r2_r0_rwl u_t000_025/r2_r1_rwl
+ u_t000_025/r3_w0_wl u_t000_025/r3_w1_wl u_t000_025/r3_r0_rwl u_t000_025/r3_r1_rwl
+ VSS u_t000_031/VSS VSUBS detronyx_12t_2w2r_rc4_4x4_routed_5layer_direct
Xu_t000_014 u_t000_014/c0_w0_bl u_t000_014/c0_w0_br u_t000_014/c0_w1_bl u_t000_014/c0_w1_br
+ u_t000_014/c0_r0_rbl u_t000_014/c0_r1_rbl u_t000_014/c1_w0_bl u_t000_014/c1_w0_br
+ u_t000_014/c1_w1_bl u_t000_014/c1_w1_br u_t000_014/c1_r0_rbl u_t000_014/c1_r1_rbl
+ u_t000_014/c2_w0_bl u_t000_014/c2_w0_br u_t000_014/c2_w1_bl u_t000_014/c2_w1_br
+ u_t000_014/c2_r0_rbl u_t000_014/c2_r1_rbl u_t000_014/c3_w0_bl u_t000_014/c3_w0_br
+ u_t000_014/c3_w1_bl u_t000_014/c3_w1_br u_t000_014/c3_r0_rbl u_t000_014/c3_r1_rbl
+ u_t000_014/r0_w0_wl u_t000_014/r0_w1_wl u_t000_014/r0_r0_rwl u_t000_014/r0_r1_rwl
+ u_t000_014/r1_w0_wl u_t000_014/r1_w1_wl u_t000_014/r1_r0_rwl u_t000_014/r1_r1_rwl
+ u_t000_014/r2_w0_wl u_t000_014/r2_w1_wl u_t000_014/r2_r0_rwl u_t000_014/r2_r1_rwl
+ u_t000_014/r3_w0_wl u_t000_014/r3_w1_wl u_t000_014/r3_r0_rwl u_t000_014/r3_r1_rwl
+ u_t000_014/VDD u_t000_031/VSS VSUBS detronyx_12t_2w2r_rc4_4x4_routed_5layer_direct
Xu_t000_003 u_t000_003/c0_w0_bl u_t000_003/c0_w0_br u_t000_003/c0_w1_bl u_t000_003/c0_w1_br
+ u_t000_003/c0_r0_rbl u_t000_003/c0_r1_rbl u_t000_003/c1_w0_bl u_t000_003/c1_w0_br
+ u_t000_003/c1_w1_bl u_t000_003/c1_w1_br u_t000_003/c1_r0_rbl u_t000_003/c1_r1_rbl
+ u_t000_003/c2_w0_bl u_t000_003/c2_w0_br u_t000_003/c2_w1_bl u_t000_003/c2_w1_br
+ u_t000_003/c2_r0_rbl u_t000_003/c2_r1_rbl u_t000_003/c3_w0_bl u_t000_003/c3_w0_br
+ u_t000_003/c3_w1_bl u_t000_003/c3_w1_br u_t000_003/c3_r0_rbl u_t000_003/c3_r1_rbl
+ u_t000_003/r0_w0_wl u_t000_003/r0_w1_wl u_t000_003/r0_r0_rwl u_t000_003/r0_r1_rwl
+ u_t000_003/r1_w0_wl u_t000_003/r1_w1_wl u_t000_003/r1_r0_rwl u_t000_003/r1_r1_rwl
+ u_t000_003/r2_w0_wl u_t000_003/r2_w1_wl u_t000_003/r2_r0_rwl u_t000_003/r2_r1_rwl
+ u_t000_003/r3_w0_wl u_t000_003/r3_w1_wl u_t000_003/r3_r0_rwl u_t000_003/r3_r1_rwl
+ u_t000_003/VDD u_t000_031/VSS VSUBS detronyx_12t_2w2r_rc4_4x4_routed_5layer_direct
Xgf180mcu_as_sc_mcu7t3v3__inv_2_762 VSS VSS gf180mcu_as_sc_mcu7t3v3__inv_2_762/Y VSS
+ gf180mcu_as_sc_mcu7t3v3__inv_2_764/VNW VSUBS gf180mcu_as_sc_mcu7t3v3__inv_2
Xgf180mcu_as_sc_mcu7t3v3__inv_2_751 VSS VSS VSS VSS gf180mcu_as_sc_mcu7t3v3__inv_2_752/VNW
+ VSUBS gf180mcu_as_sc_mcu7t3v3__inv_2
Xgf180mcu_as_sc_mcu7t3v3__inv_2_773 VSS VSS gf180mcu_as_sc_mcu7t3v3__inv_2_773/Y VSS
+ gf180mcu_as_sc_mcu7t3v3__inv_2_781/VNW VSUBS gf180mcu_as_sc_mcu7t3v3__inv_2
Xgf180mcu_as_sc_mcu7t3v3__inv_2_784 VSS VSS VSS VSS gf180mcu_as_sc_mcu7t3v3__inv_2_784/VNW
+ VSUBS gf180mcu_as_sc_mcu7t3v3__inv_2
Xgf180mcu_as_sc_mcu7t3v3__inv_2_740 VSS gf180mcu_as_sc_mcu7t3v3__inv_2_741/VSS gf180mcu_as_sc_mcu7t3v3__inv_2_740/Y
+ gf180mcu_as_sc_mcu7t3v3__inv_2_741/Y gf180mcu_as_sc_mcu7t3v3__inv_2_741/VNW VSUBS
+ gf180mcu_as_sc_mcu7t3v3__inv_2
Xgf180mcu_as_sc_mcu7t3v3__inv_2_795 VSS VSS gf180mcu_as_sc_mcu7t3v3__inv_2_795/Y VSS
+ gf180mcu_as_sc_mcu7t3v3__inv_2_795/VNW VSUBS gf180mcu_as_sc_mcu7t3v3__inv_2
Xgf180mcu_as_sc_mcu7t3v3__inv_2_570 gf180mcu_as_sc_mcu7t3v3__inv_2_572/VDD gf180mcu_as_sc_mcu7t3v3__inv_2_576/VDD
+ gf180mcu_as_sc_mcu7t3v3__inv_2_570/Y gf180mcu_as_sc_mcu7t3v3__inv_2_574/A gf180mcu_as_sc_mcu7t3v3__inv_2_572/VNW
+ VSUBS gf180mcu_as_sc_mcu7t3v3__inv_2
Xgf180mcu_as_sc_mcu7t3v3__inv_2_581 gf180mcu_as_sc_mcu7t3v3__inv_2_585/VSS VSS gf180mcu_as_sc_mcu7t3v3__inv_2_581/Y
+ VSS gf180mcu_as_sc_mcu7t3v3__inv_2_581/VNW VSUBS gf180mcu_as_sc_mcu7t3v3__inv_2
Xgf180mcu_as_sc_mcu7t3v3__inv_2_592 VSS gf180mcu_as_sc_mcu7t3v3__inv_2_597/VDD gf180mcu_as_sc_mcu7t3v3__inv_2_631/A
+ gf180mcu_as_sc_mcu7t3v3__inv_2_593/Y gf180mcu_as_sc_mcu7t3v3__inv_2_593/VNW VSUBS
+ gf180mcu_as_sc_mcu7t3v3__inv_2
Xgf180mcu_as_sc_mcu7t3v3__nor2_2_7 gf180mcu_as_sc_mcu7t3v3__nor2_2_8/VDD gf180mcu_as_sc_mcu7t3v3__nor2_2_8/VSS
+ VSS VSS VSS gf180mcu_as_sc_mcu7t3v3__nor2_2_8/VNW VSUBS gf180mcu_as_sc_mcu7t3v3__nor2_2
Xu_t028_028 u_t028_028/c0_w0_bl u_t028_028/c0_w0_br u_t028_028/c0_w1_bl u_t028_028/c0_w1_br
+ u_t028_028/c0_r0_rbl u_t028_028/c0_r1_rbl u_t028_028/c1_w0_bl u_t028_028/c1_w0_br
+ u_t028_028/c1_w1_bl u_t028_028/c1_w1_br u_t028_028/c1_r0_rbl u_t028_028/c1_r1_rbl
+ u_t028_028/c2_w0_bl u_t028_028/c2_w0_br u_t028_028/c2_w1_bl u_t028_028/c2_w1_br
+ u_t028_028/c2_r0_rbl u_t028_028/c2_r1_rbl u_t028_028/c3_w0_bl u_t028_028/c3_w0_br
+ u_t028_028/c3_w1_bl u_t028_028/c3_w1_br u_t028_028/c3_r0_rbl u_t028_028/c3_r1_rbl
+ u_t028_028/r0_w0_wl u_t028_028/r0_w1_wl u_t028_028/r0_r0_rwl u_t028_028/r0_r1_rwl
+ u_t028_028/r1_w0_wl u_t028_028/r1_w1_wl u_t028_028/r1_r0_rwl u_t028_028/r1_r1_rwl
+ u_t028_028/r2_w0_wl u_t028_028/r2_w1_wl u_t028_028/r2_r0_rwl u_t028_028/r2_r1_rwl
+ u_t028_028/r3_w0_wl u_t028_028/r3_w1_wl u_t028_028/r3_r0_rwl u_t028_028/r3_r1_rwl
+ u_t029_028/VDD u_t028_028/VSS VSUBS detronyx_12t_2w2r_rc4_4x4_routed_5layer_direct
Xu_t028_017 u_t028_017/c0_w0_bl u_t028_017/c0_w0_br u_t028_017/c0_w1_bl u_t028_017/c0_w1_br
+ u_t028_017/c0_r0_rbl u_t028_017/c0_r1_rbl u_t028_017/c1_w0_bl u_t028_017/c1_w0_br
+ u_t028_017/c1_w1_bl u_t028_017/c1_w1_br u_t028_017/c1_r0_rbl u_t028_017/c1_r1_rbl
+ u_t028_017/c2_w0_bl u_t028_017/c2_w0_br u_t028_017/c2_w1_bl u_t028_017/c2_w1_br
+ u_t028_017/c2_r0_rbl u_t028_017/c2_r1_rbl u_t028_017/c3_w0_bl u_t028_017/c3_w0_br
+ u_t028_017/c3_w1_bl u_t028_017/c3_w1_br u_t028_017/c3_r0_rbl u_t028_017/c3_r1_rbl
+ u_t028_017/r0_w0_wl u_t028_017/r0_w1_wl u_t028_017/r0_r0_rwl u_t028_017/r0_r1_rwl
+ u_t028_017/r1_w0_wl u_t028_017/r1_w1_wl u_t028_017/r1_r0_rwl u_t028_017/r1_r1_rwl
+ u_t028_017/r2_w0_wl u_t028_017/r2_w1_wl u_t028_017/r2_r0_rwl u_t028_017/r2_r1_rwl
+ u_t028_017/r3_w0_wl u_t028_017/r3_w1_wl u_t028_017/r3_r0_rwl u_t028_017/r3_r1_rwl
+ VSS u_t028_017/VSS VSUBS detronyx_12t_2w2r_rc4_4x4_routed_5layer_direct
Xu_t028_006 u_t028_006/c0_w0_bl u_t028_006/c0_w0_br u_t028_006/c0_w1_bl u_t028_006/c0_w1_br
+ u_t028_006/c0_r0_rbl u_t028_006/c0_r1_rbl u_t028_006/c1_w0_bl u_t028_006/c1_w0_br
+ u_t028_006/c1_w1_bl u_t028_006/c1_w1_br u_t028_006/c1_r0_rbl u_t028_006/c1_r1_rbl
+ u_t028_006/c2_w0_bl u_t028_006/c2_w0_br u_t028_006/c2_w1_bl u_t028_006/c2_w1_br
+ u_t028_006/c2_r0_rbl u_t028_006/c2_r1_rbl u_t028_006/c3_w0_bl u_t028_006/c3_w0_br
+ u_t028_006/c3_w1_bl u_t028_006/c3_w1_br u_t028_006/c3_r0_rbl u_t028_006/c3_r1_rbl
+ u_t028_006/r0_w0_wl u_t028_006/r0_w1_wl u_t028_006/r0_r0_rwl u_t028_006/r0_r1_rwl
+ u_t028_006/r1_w0_wl u_t028_006/r1_w1_wl u_t028_006/r1_r0_rwl u_t028_006/r1_r1_rwl
+ u_t028_006/r2_w0_wl u_t028_006/r2_w1_wl u_t028_006/r2_r0_rwl u_t028_006/r2_r1_rwl
+ u_t028_006/r3_w0_wl u_t028_006/r3_w1_wl u_t028_006/r3_r0_rwl u_t028_006/r3_r1_rwl
+ u_t029_006/VDD u_t028_009/VSS VSUBS detronyx_12t_2w2r_rc4_4x4_routed_5layer_direct
Xu_t019_006 u_t019_006/c0_w0_bl u_t019_006/c0_w0_br u_t019_006/c0_w1_bl u_t019_006/c0_w1_br
+ u_t019_006/c0_r0_rbl u_t019_006/c0_r1_rbl u_t019_006/c1_w0_bl u_t019_006/c1_w0_br
+ u_t019_006/c1_w1_bl u_t019_006/c1_w1_br u_t019_006/c1_r0_rbl u_t019_006/c1_r1_rbl
+ u_t019_006/c2_w0_bl u_t019_006/c2_w0_br u_t019_006/c2_w1_bl u_t019_006/c2_w1_br
+ u_t019_006/c2_r0_rbl u_t019_006/c2_r1_rbl u_t019_006/c3_w0_bl u_t019_006/c3_w0_br
+ u_t019_006/c3_w1_bl u_t019_006/c3_w1_br u_t019_006/c3_r0_rbl u_t019_006/c3_r1_rbl
+ u_t019_006/r0_w0_wl u_t019_006/r0_w1_wl u_t019_006/r0_r0_rwl u_t019_006/r0_r1_rwl
+ u_t019_006/r1_w0_wl u_t019_006/r1_w1_wl u_t019_006/r1_r0_rwl u_t019_006/r1_r1_rwl
+ u_t019_006/r2_w0_wl u_t019_006/r2_w1_wl u_t019_006/r2_r0_rwl u_t019_006/r2_r1_rwl
+ u_t019_006/r3_w0_wl u_t019_006/r3_w1_wl u_t019_006/r3_r0_rwl u_t019_006/r3_r1_rwl
+ u_t019_006/VDD u_t019_009/VSS VSUBS detronyx_12t_2w2r_rc4_4x4_routed_5layer_direct
Xu_t019_028 u_t019_028/c0_w0_bl u_t019_028/c0_w0_br u_t019_028/c0_w1_bl u_t019_028/c0_w1_br
+ u_t019_028/c0_r0_rbl u_t019_028/c0_r1_rbl u_t019_028/c1_w0_bl u_t019_028/c1_w0_br
+ u_t019_028/c1_w1_bl u_t019_028/c1_w1_br u_t019_028/c1_r0_rbl u_t019_028/c1_r1_rbl
+ u_t019_028/c2_w0_bl u_t019_028/c2_w0_br u_t019_028/c2_w1_bl u_t019_028/c2_w1_br
+ u_t019_028/c2_r0_rbl u_t019_028/c2_r1_rbl u_t019_028/c3_w0_bl u_t019_028/c3_w0_br
+ u_t019_028/c3_w1_bl u_t019_028/c3_w1_br u_t019_028/c3_r0_rbl u_t019_028/c3_r1_rbl
+ u_t019_028/r0_w0_wl u_t019_028/r0_w1_wl u_t019_028/r0_r0_rwl u_t019_028/r0_r1_rwl
+ u_t019_028/r1_w0_wl u_t019_028/r1_w1_wl u_t019_028/r1_r0_rwl u_t019_028/r1_r1_rwl
+ u_t019_028/r2_w0_wl u_t019_028/r2_w1_wl u_t019_028/r2_r0_rwl u_t019_028/r2_r1_rwl
+ u_t019_028/r3_w0_wl u_t019_028/r3_w1_wl u_t019_028/r3_r0_rwl u_t019_028/r3_r1_rwl
+ u_t019_028/VDD u_t019_028/VSS VSUBS detronyx_12t_2w2r_rc4_4x4_routed_5layer_direct
Xu_t019_017 u_t019_017/c0_w0_bl u_t019_017/c0_w0_br u_t019_017/c0_w1_bl u_t019_017/c0_w1_br
+ u_t019_017/c0_r0_rbl u_t019_017/c0_r1_rbl u_t019_017/c1_w0_bl u_t019_017/c1_w0_br
+ u_t019_017/c1_w1_bl u_t019_017/c1_w1_br u_t019_017/c1_r0_rbl u_t019_017/c1_r1_rbl
+ u_t019_017/c2_w0_bl u_t019_017/c2_w0_br u_t019_017/c2_w1_bl u_t019_017/c2_w1_br
+ u_t019_017/c2_r0_rbl u_t019_017/c2_r1_rbl u_t019_017/c3_w0_bl u_t019_017/c3_w0_br
+ u_t019_017/c3_w1_bl u_t019_017/c3_w1_br u_t019_017/c3_r0_rbl u_t019_017/c3_r1_rbl
+ u_t019_017/r0_w0_wl u_t019_017/r0_w1_wl u_t019_017/r0_r0_rwl u_t019_017/r0_r1_rwl
+ u_t019_017/r1_w0_wl u_t019_017/r1_w1_wl u_t019_017/r1_r0_rwl u_t019_017/r1_r1_rwl
+ u_t019_017/r2_w0_wl u_t019_017/r2_w1_wl u_t019_017/r2_r0_rwl u_t019_017/r2_r1_rwl
+ u_t019_017/r3_w0_wl u_t019_017/r3_w1_wl u_t019_017/r3_r0_rwl u_t019_017/r3_r1_rwl
+ VSS u_t019_017/VSS VSUBS detronyx_12t_2w2r_rc4_4x4_routed_5layer_direct
Xu_t025_009 u_t025_009/c0_w0_bl u_t025_009/c0_w0_br u_t025_009/c0_w1_bl u_t025_009/c0_w1_br
+ u_t025_009/c0_r0_rbl u_t025_009/c0_r1_rbl u_t025_009/c1_w0_bl u_t025_009/c1_w0_br
+ u_t025_009/c1_w1_bl u_t025_009/c1_w1_br u_t025_009/c1_r0_rbl u_t025_009/c1_r1_rbl
+ u_t025_009/c2_w0_bl u_t025_009/c2_w0_br u_t025_009/c2_w1_bl u_t025_009/c2_w1_br
+ u_t025_009/c2_r0_rbl u_t025_009/c2_r1_rbl u_t025_009/c3_w0_bl u_t025_009/c3_w0_br
+ u_t025_009/c3_w1_bl u_t025_009/c3_w1_br u_t025_009/c3_r0_rbl u_t025_009/c3_r1_rbl
+ u_t025_009/r0_w0_wl u_t025_009/r0_w1_wl u_t025_009/r0_r0_rwl u_t025_009/r0_r1_rwl
+ u_t025_009/r1_w0_wl u_t025_009/r1_w1_wl u_t025_009/r1_r0_rwl u_t025_009/r1_r1_rwl
+ u_t025_009/r2_w0_wl u_t025_009/r2_w1_wl u_t025_009/r2_r0_rwl u_t025_009/r2_r1_rwl
+ u_t025_009/r3_w0_wl u_t025_009/r3_w1_wl u_t025_009/r3_r0_rwl u_t025_009/r3_r1_rwl
+ VSS u_t025_031/VSS VSUBS detronyx_12t_2w2r_rc4_4x4_routed_5layer_direct
Xgf180mcu_as_sc_mcu7t3v3__inv_2_1129 VSS gf180mcu_as_sc_mcu7t3v3__inv_2_1132/VDD gf180mcu_as_sc_mcu7t3v3__inv_2_1129/Y
+ VSS gf180mcu_as_sc_mcu7t3v3__inv_2_1129/VNW VSUBS gf180mcu_as_sc_mcu7t3v3__inv_2
Xgf180mcu_as_sc_mcu7t3v3__inv_2_1118 VSS VSS VSS gf180mcu_as_sc_mcu7t3v3__inv_2_1144/A
+ gf180mcu_as_sc_mcu7t3v3__inv_2_1120/VNW VSUBS gf180mcu_as_sc_mcu7t3v3__inv_2
Xgf180mcu_as_sc_mcu7t3v3__inv_2_1107 gf180mcu_as_sc_mcu7t3v3__inv_2_1107/VDD VSS gf180mcu_as_sc_mcu7t3v3__inv_2_1107/Y
+ gf180mcu_as_sc_mcu7t3v3__inv_2_1107/A gf180mcu_as_sc_mcu7t3v3__inv_2_1107/VNW VSUBS
+ gf180mcu_as_sc_mcu7t3v3__inv_2
Xu_t024_020 u_t024_020/c0_w0_bl u_t024_020/c0_w0_br u_t024_020/c0_w1_bl u_t024_020/c0_w1_br
+ u_t024_020/c0_r0_rbl u_t024_020/c0_r1_rbl u_t024_020/c1_w0_bl u_t024_020/c1_w0_br
+ u_t024_020/c1_w1_bl u_t024_020/c1_w1_br u_t024_020/c1_r0_rbl u_t024_020/c1_r1_rbl
+ u_t024_020/c2_w0_bl u_t024_020/c2_w0_br u_t024_020/c2_w1_bl u_t024_020/c2_w1_br
+ u_t024_020/c2_r0_rbl u_t024_020/c2_r1_rbl u_t024_020/c3_w0_bl u_t024_020/c3_w0_br
+ u_t024_020/c3_w1_bl u_t024_020/c3_w1_br u_t024_020/c3_r0_rbl u_t024_020/c3_r1_rbl
+ u_t024_020/r0_w0_wl u_t024_020/r0_w1_wl u_t024_020/r0_r0_rwl u_t024_020/r0_r1_rwl
+ u_t024_020/r1_w0_wl u_t024_020/r1_w1_wl u_t024_020/r1_r0_rwl u_t024_020/r1_r1_rwl
+ u_t024_020/r2_w0_wl u_t024_020/r2_w1_wl u_t024_020/r2_r0_rwl u_t024_020/r2_r1_rwl
+ u_t024_020/r3_w0_wl u_t024_020/r3_w1_wl u_t024_020/r3_r0_rwl u_t024_020/r3_r1_rwl
+ u_t025_020/VDD u_t024_020/VSS VSUBS detronyx_12t_2w2r_rc4_4x4_routed_5layer_direct
Xu_t016_009 u_t016_009/c0_w0_bl u_t016_009/c0_w0_br u_t016_009/c0_w1_bl u_t016_009/c0_w1_br
+ u_t016_009/c0_r0_rbl u_t016_009/c0_r1_rbl u_t016_009/c1_w0_bl u_t016_009/c1_w0_br
+ u_t016_009/c1_w1_bl u_t016_009/c1_w1_br u_t016_009/c1_r0_rbl u_t016_009/c1_r1_rbl
+ u_t016_009/c2_w0_bl u_t016_009/c2_w0_br u_t016_009/c2_w1_bl u_t016_009/c2_w1_br
+ u_t016_009/c2_r0_rbl u_t016_009/c2_r1_rbl u_t016_009/c3_w0_bl u_t016_009/c3_w0_br
+ u_t016_009/c3_w1_bl u_t016_009/c3_w1_br u_t016_009/c3_r0_rbl u_t016_009/c3_r1_rbl
+ u_t016_009/r0_w0_wl u_t016_009/r0_w1_wl u_t016_009/r0_r0_rwl u_t016_009/r0_r1_rwl
+ u_t016_009/r1_w0_wl u_t016_009/r1_w1_wl u_t016_009/r1_r0_rwl u_t016_009/r1_r1_rwl
+ u_t016_009/r2_w0_wl u_t016_009/r2_w1_wl u_t016_009/r2_r0_rwl u_t016_009/r2_r1_rwl
+ u_t016_009/r3_w0_wl u_t016_009/r3_w1_wl u_t016_009/r3_r0_rwl u_t016_009/r3_r1_rwl
+ VSS u_t016_009/VSS VSUBS detronyx_12t_2w2r_rc4_4x4_routed_5layer_direct
Xgf180mcu_as_sc_mcu7t3v3__nand3_2_32 gf180mcu_as_sc_mcu7t3v3__nor2_2_8/VDD gf180mcu_as_sc_mcu7t3v3__nand3_2_32/VSS
+ VSS VSS VSS VSS gf180mcu_as_sc_mcu7t3v3__nor2_2_8/VNW VSUBS gf180mcu_as_sc_mcu7t3v3__nand3_2
Xgf180mcu_as_sc_mcu7t3v3__nand3_2_21 gf180mcu_as_sc_mcu7t3v3__nor2_2_6/VDD gf180mcu_as_sc_mcu7t3v3__nand3_2_3/VSS
+ VSS VSS VSS VSS gf180mcu_as_sc_mcu7t3v3__nor2_2_6/VNW VSUBS gf180mcu_as_sc_mcu7t3v3__nand3_2
Xgf180mcu_as_sc_mcu7t3v3__nand3_2_10 gf180mcu_as_sc_mcu7t3v3__nand3_2_5/VDD gf180mcu_as_sc_mcu7t3v3__nor2_2_4/VSS
+ VSS VSS VSS VSS gf180mcu_as_sc_mcu7t3v3__nand3_2_5/VNW VSUBS gf180mcu_as_sc_mcu7t3v3__nand3_2
Xu_t024_031 u_t024_031/c0_w0_bl u_t024_031/c0_w0_br u_t024_031/c0_w1_bl u_t024_031/c0_w1_br
+ u_t024_031/c0_r0_rbl u_t024_031/c0_r1_rbl u_t024_031/c1_w0_bl u_t024_031/c1_w0_br
+ u_t024_031/c1_w1_bl u_t024_031/c1_w1_br u_t024_031/c1_r0_rbl u_t024_031/c1_r1_rbl
+ u_t024_031/c2_w0_bl u_t024_031/c2_w0_br u_t024_031/c2_w1_bl u_t024_031/c2_w1_br
+ u_t024_031/c2_r0_rbl u_t024_031/c2_r1_rbl u_t024_031/c3_w0_bl u_t024_031/c3_w0_br
+ u_t024_031/c3_w1_bl u_t024_031/c3_w1_br u_t024_031/c3_r0_rbl u_t024_031/c3_r1_rbl
+ u_t024_031/r0_w0_wl u_t024_031/r0_w1_wl u_t024_031/r0_r0_rwl u_t024_031/r0_r1_rwl
+ u_t024_031/r1_w0_wl u_t024_031/r1_w1_wl u_t024_031/r1_r0_rwl u_t024_031/r1_r1_rwl
+ u_t024_031/r2_w0_wl u_t024_031/r2_w1_wl u_t024_031/r2_r0_rwl u_t024_031/r2_r1_rwl
+ u_t024_031/r3_w0_wl u_t024_031/r3_w1_wl u_t024_031/r3_r0_rwl u_t024_031/r3_r1_rwl
+ VSS u_t024_031/VSS VSUBS detronyx_12t_2w2r_rc4_4x4_routed_5layer_direct
Xgf180mcu_as_sc_mcu7t3v3__inv_2_1630 gf180mcu_as_sc_mcu7t3v3__inv_2_1671/VDD gf180mcu_as_sc_mcu7t3v3__inv_2_1672/VDD
+ VSS gf180mcu_as_sc_mcu7t3v3__inv_2_1675/Y gf180mcu_as_sc_mcu7t3v3__inv_2_1671/VNW
+ VSUBS gf180mcu_as_sc_mcu7t3v3__inv_2
Xgf180mcu_as_sc_mcu7t3v3__inv_2_1674 gf180mcu_as_sc_mcu7t3v3__inv_2_1674/VDD gf180mcu_as_sc_mcu7t3v3__inv_2_1675/VDD
+ gf180mcu_as_sc_mcu7t3v3__inv_2_1675/Y VSS gf180mcu_as_sc_mcu7t3v3__inv_2_1674/VNW
+ VSUBS gf180mcu_as_sc_mcu7t3v3__inv_2
Xgf180mcu_as_sc_mcu7t3v3__inv_2_1641 gf180mcu_as_sc_mcu7t3v3__inv_2_1678/VDD VSS VSS
+ gf180mcu_as_sc_mcu7t3v3__inv_2_1678/Y gf180mcu_as_sc_mcu7t3v3__inv_2_1678/VNW VSUBS
+ gf180mcu_as_sc_mcu7t3v3__inv_2
Xgf180mcu_as_sc_mcu7t3v3__inv_2_1652 VSS gf180mcu_as_sc_mcu7t3v3__inv_2_1653/VDD gf180mcu_as_sc_mcu7t3v3__inv_2_1682/Y
+ VSS gf180mcu_as_sc_mcu7t3v3__inv_2_1652/VNW VSUBS gf180mcu_as_sc_mcu7t3v3__inv_2
Xgf180mcu_as_sc_mcu7t3v3__inv_2_1663 gf180mcu_as_sc_mcu7t3v3__inv_2_1663/VDD gf180mcu_as_sc_mcu7t3v3__inv_2_1685/VDD
+ gf180mcu_as_sc_mcu7t3v3__inv_2_1685/Y VSS gf180mcu_as_sc_mcu7t3v3__inv_2_1663/VNW
+ VSUBS gf180mcu_as_sc_mcu7t3v3__inv_2
Xgf180mcu_as_sc_mcu7t3v3__inv_2_1685 gf180mcu_as_sc_mcu7t3v3__inv_2_1685/VDD VSS gf180mcu_as_sc_mcu7t3v3__inv_2_1685/Y
+ VSS gf180mcu_as_sc_mcu7t3v3__inv_2_1685/VNW VSUBS gf180mcu_as_sc_mcu7t3v3__inv_2
Xgf180mcu_as_sc_mcu7t3v3__inv_2_1696 VSS VSS VSS VSS gf180mcu_as_sc_mcu7t3v3__inv_2_1697/VNW
+ VSUBS gf180mcu_as_sc_mcu7t3v3__inv_2
Xu_t015_031 u_t015_031/c0_w0_bl u_t015_031/c0_w0_br u_t015_031/c0_w1_bl u_t015_031/c0_w1_br
+ u_t015_031/c0_r0_rbl u_t015_031/c0_r1_rbl u_t015_031/c1_w0_bl u_t015_031/c1_w0_br
+ u_t015_031/c1_w1_bl u_t015_031/c1_w1_br u_t015_031/c1_r0_rbl u_t015_031/c1_r1_rbl
+ u_t015_031/c2_w0_bl u_t015_031/c2_w0_br u_t015_031/c2_w1_bl u_t015_031/c2_w1_br
+ u_t015_031/c2_r0_rbl u_t015_031/c2_r1_rbl u_t015_031/c3_w0_bl u_t015_031/c3_w0_br
+ u_t015_031/c3_w1_bl u_t015_031/c3_w1_br u_t015_031/c3_r0_rbl u_t015_031/c3_r1_rbl
+ u_t015_031/r0_w0_wl u_t015_031/r0_w1_wl u_t015_031/r0_r0_rwl u_t015_031/r0_r1_rwl
+ u_t015_031/r1_w0_wl u_t015_031/r1_w1_wl u_t015_031/r1_r0_rwl u_t015_031/r1_r1_rwl
+ u_t015_031/r2_w0_wl u_t015_031/r2_w1_wl u_t015_031/r2_r0_rwl u_t015_031/r2_r1_rwl
+ u_t015_031/r3_w0_wl u_t015_031/r3_w1_wl u_t015_031/r3_r0_rwl u_t015_031/r3_r1_rwl
+ VSS u_t015_031/VSS VSUBS detronyx_12t_2w2r_rc4_4x4_routed_5layer_direct
Xu_t015_020 u_t015_020/c0_w0_bl u_t015_020/c0_w0_br u_t015_020/c0_w1_bl u_t015_020/c0_w1_br
+ u_t015_020/c0_r0_rbl u_t015_020/c0_r1_rbl u_t015_020/c1_w0_bl u_t015_020/c1_w0_br
+ u_t015_020/c1_w1_bl u_t015_020/c1_w1_br u_t015_020/c1_r0_rbl u_t015_020/c1_r1_rbl
+ u_t015_020/c2_w0_bl u_t015_020/c2_w0_br u_t015_020/c2_w1_bl u_t015_020/c2_w1_br
+ u_t015_020/c2_r0_rbl u_t015_020/c2_r1_rbl u_t015_020/c3_w0_bl u_t015_020/c3_w0_br
+ u_t015_020/c3_w1_bl u_t015_020/c3_w1_br u_t015_020/c3_r0_rbl u_t015_020/c3_r1_rbl
+ u_t015_020/r0_w0_wl u_t015_020/r0_w1_wl u_t015_020/r0_r0_rwl u_t015_020/r0_r1_rwl
+ u_t015_020/r1_w0_wl u_t015_020/r1_w1_wl u_t015_020/r1_r0_rwl u_t015_020/r1_r1_rwl
+ u_t015_020/r2_w0_wl u_t015_020/r2_w1_wl u_t015_020/r2_r0_rwl u_t015_020/r2_r1_rwl
+ u_t015_020/r3_w0_wl u_t015_020/r3_w1_wl u_t015_020/r3_r0_rwl u_t015_020/r3_r1_rwl
+ u_t015_020/VDD u_t015_020/VSS VSUBS detronyx_12t_2w2r_rc4_4x4_routed_5layer_direct
Xu_t030_012 u_t030_012/c0_w0_bl u_t030_012/c0_w0_br u_t030_012/c0_w1_bl u_t030_012/c0_w1_br
+ u_t030_012/c0_r0_rbl u_t030_012/c0_r1_rbl u_t030_012/c1_w0_bl u_t030_012/c1_w0_br
+ u_t030_012/c1_w1_bl u_t030_012/c1_w1_br u_t030_012/c1_r0_rbl u_t030_012/c1_r1_rbl
+ u_t030_012/c2_w0_bl u_t030_012/c2_w0_br u_t030_012/c2_w1_bl u_t030_012/c2_w1_br
+ u_t030_012/c2_r0_rbl u_t030_012/c2_r1_rbl u_t030_012/c3_w0_bl u_t030_012/c3_w0_br
+ u_t030_012/c3_w1_bl u_t030_012/c3_w1_br u_t030_012/c3_r0_rbl u_t030_012/c3_r1_rbl
+ u_t030_012/r0_w0_wl u_t030_012/r0_w1_wl u_t030_012/r0_r0_rwl u_t030_012/r0_r1_rwl
+ u_t030_012/r1_w0_wl u_t030_012/r1_w1_wl u_t030_012/r1_r0_rwl u_t030_012/r1_r1_rwl
+ u_t030_012/r2_w0_wl u_t030_012/r2_w1_wl u_t030_012/r2_r0_rwl u_t030_012/r2_r1_rwl
+ u_t030_012/r3_w0_wl u_t030_012/r3_w1_wl u_t030_012/r3_r0_rwl u_t030_012/r3_r1_rwl
+ u_t030_012/VDD u_t030_031/VSS VSUBS detronyx_12t_2w2r_rc4_4x4_routed_5layer_direct
Xu_t007_009 u_t007_009/c0_w0_bl u_t007_009/c0_w0_br u_t007_009/c0_w1_bl u_t007_009/c0_w1_br
+ u_t007_009/c0_r0_rbl u_t007_009/c0_r1_rbl u_t007_009/c1_w0_bl u_t007_009/c1_w0_br
+ u_t007_009/c1_w1_bl u_t007_009/c1_w1_br u_t007_009/c1_r0_rbl u_t007_009/c1_r1_rbl
+ u_t007_009/c2_w0_bl u_t007_009/c2_w0_br u_t007_009/c2_w1_bl u_t007_009/c2_w1_br
+ u_t007_009/c2_r0_rbl u_t007_009/c2_r1_rbl u_t007_009/c3_w0_bl u_t007_009/c3_w0_br
+ u_t007_009/c3_w1_bl u_t007_009/c3_w1_br u_t007_009/c3_r0_rbl u_t007_009/c3_r1_rbl
+ u_t007_009/r0_w0_wl u_t007_009/r0_w1_wl u_t007_009/r0_r0_rwl u_t007_009/r0_r1_rwl
+ u_t007_009/r1_w0_wl u_t007_009/r1_w1_wl u_t007_009/r1_r0_rwl u_t007_009/r1_r1_rwl
+ u_t007_009/r2_w0_wl u_t007_009/r2_w1_wl u_t007_009/r2_r0_rwl u_t007_009/r2_r1_rwl
+ u_t007_009/r3_w0_wl u_t007_009/r3_w1_wl u_t007_009/r3_r0_rwl u_t007_009/r3_r1_rwl
+ VSS u_t007_009/VSS VSUBS detronyx_12t_2w2r_rc4_4x4_routed_5layer_direct
Xu_t030_001 u_t030_001/c0_w0_bl u_t030_001/c0_w0_br u_t030_001/c0_w1_bl u_t030_001/c0_w1_br
+ u_t030_001/c0_r0_rbl u_t030_001/c0_r1_rbl u_t030_001/c1_w0_bl u_t030_001/c1_w0_br
+ u_t030_001/c1_w1_bl u_t030_001/c1_w1_br u_t030_001/c1_r0_rbl u_t030_001/c1_r1_rbl
+ u_t030_001/c2_w0_bl u_t030_001/c2_w0_br u_t030_001/c2_w1_bl u_t030_001/c2_w1_br
+ u_t030_001/c2_r0_rbl u_t030_001/c2_r1_rbl u_t030_001/c3_w0_bl u_t030_001/c3_w0_br
+ u_t030_001/c3_w1_bl u_t030_001/c3_w1_br u_t030_001/c3_r0_rbl u_t030_001/c3_r1_rbl
+ u_t030_001/r0_w0_wl u_t030_001/r0_w1_wl u_t030_001/r0_r0_rwl u_t030_001/r0_r1_rwl
+ u_t030_001/r1_w0_wl u_t030_001/r1_w1_wl u_t030_001/r1_r0_rwl u_t030_001/r1_r1_rwl
+ u_t030_001/r2_w0_wl u_t030_001/r2_w1_wl u_t030_001/r2_r0_rwl u_t030_001/r2_r1_rwl
+ u_t030_001/r3_w0_wl u_t030_001/r3_w1_wl u_t030_001/r3_r0_rwl u_t030_001/r3_r1_rwl
+ VSS u_t030_031/VSS VSUBS detronyx_12t_2w2r_rc4_4x4_routed_5layer_direct
Xu_t030_023 u_t030_023/c0_w0_bl u_t030_023/c0_w0_br u_t030_023/c0_w1_bl u_t030_023/c0_w1_br
+ u_t030_023/c0_r0_rbl u_t030_023/c0_r1_rbl u_t030_023/c1_w0_bl u_t030_023/c1_w0_br
+ u_t030_023/c1_w1_bl u_t030_023/c1_w1_br u_t030_023/c1_r0_rbl u_t030_023/c1_r1_rbl
+ u_t030_023/c2_w0_bl u_t030_023/c2_w0_br u_t030_023/c2_w1_bl u_t030_023/c2_w1_br
+ u_t030_023/c2_r0_rbl u_t030_023/c2_r1_rbl u_t030_023/c3_w0_bl u_t030_023/c3_w0_br
+ u_t030_023/c3_w1_bl u_t030_023/c3_w1_br u_t030_023/c3_r0_rbl u_t030_023/c3_r1_rbl
+ u_t030_023/r0_w0_wl u_t030_023/r0_w1_wl u_t030_023/r0_r0_rwl u_t030_023/r0_r1_rwl
+ u_t030_023/r1_w0_wl u_t030_023/r1_w1_wl u_t030_023/r1_r0_rwl u_t030_023/r1_r1_rwl
+ u_t030_023/r2_w0_wl u_t030_023/r2_w1_wl u_t030_023/r2_r0_rwl u_t030_023/r2_r1_rwl
+ u_t030_023/r3_w0_wl u_t030_023/r3_w1_wl u_t030_023/r3_r0_rwl u_t030_023/r3_r1_rwl
+ VSS u_t030_031/VSS VSUBS detronyx_12t_2w2r_rc4_4x4_routed_5layer_direct
Xgf180mcu_as_sc_mcu7t3v3__nand4_2_402 VSS VSS VSS VSS VSS VSS VSS gf180mcu_as_sc_mcu7t3v3__inv_2_1388/VNW
+ VSUBS gf180mcu_as_sc_mcu7t3v3__nand4_2
Xgf180mcu_as_sc_mcu7t3v3__nand4_2_435 VSS VSS VSS VSS VSS VSS VSS gf180mcu_as_sc_mcu7t3v3__inv_2_1484/VNW
+ VSUBS gf180mcu_as_sc_mcu7t3v3__nand4_2
Xgf180mcu_as_sc_mcu7t3v3__nand4_2_424 gf180mcu_as_sc_mcu7t3v3__inv_2_1440/VDD gf180mcu_as_sc_mcu7t3v3__inv_2_1444/VDD
+ VSS VSS VSS VSS gf180mcu_as_sc_mcu7t3v3__nand4_2_424/Y gf180mcu_as_sc_mcu7t3v3__inv_2_1440/VNW
+ VSUBS gf180mcu_as_sc_mcu7t3v3__nand4_2
Xgf180mcu_as_sc_mcu7t3v3__nand4_2_413 gf180mcu_as_sc_mcu7t3v3__inv_2_1398/VSS gf180mcu_as_sc_mcu7t3v3__inv_2_1397/VSS
+ VSS VSS VSS VSS VSS gf180mcu_as_sc_mcu7t3v3__inv_2_1397/VNW VSUBS gf180mcu_as_sc_mcu7t3v3__nand4_2
Xu_t006_020 u_t006_020/c0_w0_bl u_t006_020/c0_w0_br u_t006_020/c0_w1_bl u_t006_020/c0_w1_br
+ u_t006_020/c0_r0_rbl u_t006_020/c0_r1_rbl u_t006_020/c1_w0_bl u_t006_020/c1_w0_br
+ u_t006_020/c1_w1_bl u_t006_020/c1_w1_br u_t006_020/c1_r0_rbl u_t006_020/c1_r1_rbl
+ u_t006_020/c2_w0_bl u_t006_020/c2_w0_br u_t006_020/c2_w1_bl u_t006_020/c2_w1_br
+ u_t006_020/c2_r0_rbl u_t006_020/c2_r1_rbl u_t006_020/c3_w0_bl u_t006_020/c3_w0_br
+ u_t006_020/c3_w1_bl u_t006_020/c3_w1_br u_t006_020/c3_r0_rbl u_t006_020/c3_r1_rbl
+ u_t006_020/r0_w0_wl u_t006_020/r0_w1_wl u_t006_020/r0_r0_rwl u_t006_020/r0_r1_rwl
+ u_t006_020/r1_w0_wl u_t006_020/r1_w1_wl u_t006_020/r1_r0_rwl u_t006_020/r1_r1_rwl
+ u_t006_020/r2_w0_wl u_t006_020/r2_w1_wl u_t006_020/r2_r0_rwl u_t006_020/r2_r1_rwl
+ u_t006_020/r3_w0_wl u_t006_020/r3_w1_wl u_t006_020/r3_r0_rwl u_t006_020/r3_r1_rwl
+ u_t006_020/VDD u_t006_020/VSS VSUBS detronyx_12t_2w2r_rc4_4x4_routed_5layer_direct
Xgf180mcu_as_sc_mcu7t3v3__nand4_2_457 gf180mcu_as_sc_mcu7t3v3__inv_2_1577/VDD gf180mcu_as_sc_mcu7t3v3__inv_2_1581/VDD
+ VSS VSS VSS VSS gf180mcu_as_sc_mcu7t3v3__nand4_2_457/Y gf180mcu_as_sc_mcu7t3v3__inv_2_1577/VNW
+ VSUBS gf180mcu_as_sc_mcu7t3v3__nand4_2
Xgf180mcu_as_sc_mcu7t3v3__nand4_2_468 VSS VSS VSS VSS VSS VSS VSS gf180mcu_as_sc_mcu7t3v3__inv_2_1543/VNW
+ VSUBS gf180mcu_as_sc_mcu7t3v3__nand4_2
Xgf180mcu_as_sc_mcu7t3v3__nand4_2_479 VSS gf180mcu_as_sc_mcu7t3v3__inv_2_1660/VDD
+ VSS VSS VSS VSS VSS gf180mcu_as_sc_mcu7t3v3__inv_2_1659/VNW VSUBS gf180mcu_as_sc_mcu7t3v3__nand4_2
Xgf180mcu_as_sc_mcu7t3v3__nand4_2_446 gf180mcu_as_sc_mcu7t3v3__inv_2_1497/VSS VSS
+ VSS VSS VSS VSS VSS gf180mcu_as_sc_mcu7t3v3__inv_2_1462/VNW VSUBS gf180mcu_as_sc_mcu7t3v3__nand4_2
Xgf180mcu_as_sc_mcu7t3v3__inv_2_3 gf180mcu_as_sc_mcu7t3v3__inv_2_6/VSS gf180mcu_as_sc_mcu7t3v3__inv_2_8/VDD
+ VSS gf180mcu_as_sc_mcu7t3v3__inv_2_8/A gf180mcu_as_sc_mcu7t3v3__inv_2_4/VNW VSUBS
+ gf180mcu_as_sc_mcu7t3v3__inv_2
Xu_t006_031 u_t006_031/c0_w0_bl u_t006_031/c0_w0_br u_t006_031/c0_w1_bl u_t006_031/c0_w1_br
+ u_t006_031/c0_r0_rbl u_t006_031/c0_r1_rbl u_t006_031/c1_w0_bl u_t006_031/c1_w0_br
+ u_t006_031/c1_w1_bl u_t006_031/c1_w1_br u_t006_031/c1_r0_rbl u_t006_031/c1_r1_rbl
+ u_t006_031/c2_w0_bl u_t006_031/c2_w0_br u_t006_031/c2_w1_bl u_t006_031/c2_w1_br
+ u_t006_031/c2_r0_rbl u_t006_031/c2_r1_rbl u_t006_031/c3_w0_bl u_t006_031/c3_w0_br
+ u_t006_031/c3_w1_bl u_t006_031/c3_w1_br u_t006_031/c3_r0_rbl u_t006_031/c3_r1_rbl
+ u_t006_031/r0_w0_wl u_t006_031/r0_w1_wl u_t006_031/r0_r0_rwl u_t006_031/r0_r1_rwl
+ u_t006_031/r1_w0_wl u_t006_031/r1_w1_wl u_t006_031/r1_r0_rwl u_t006_031/r1_r1_rwl
+ u_t006_031/r2_w0_wl u_t006_031/r2_w1_wl u_t006_031/r2_r0_rwl u_t006_031/r2_r1_rwl
+ u_t006_031/r3_w0_wl u_t006_031/r3_w1_wl u_t006_031/r3_r0_rwl u_t006_031/r3_r1_rwl
+ VSS u_t006_031/VSS VSUBS detronyx_12t_2w2r_rc4_4x4_routed_5layer_direct
Xu_t021_023 u_t021_023/c0_w0_bl u_t021_023/c0_w0_br u_t021_023/c0_w1_bl u_t021_023/c0_w1_br
+ u_t021_023/c0_r0_rbl u_t021_023/c0_r1_rbl u_t021_023/c1_w0_bl u_t021_023/c1_w0_br
+ u_t021_023/c1_w1_bl u_t021_023/c1_w1_br u_t021_023/c1_r0_rbl u_t021_023/c1_r1_rbl
+ u_t021_023/c2_w0_bl u_t021_023/c2_w0_br u_t021_023/c2_w1_bl u_t021_023/c2_w1_br
+ u_t021_023/c2_r0_rbl u_t021_023/c2_r1_rbl u_t021_023/c3_w0_bl u_t021_023/c3_w0_br
+ u_t021_023/c3_w1_bl u_t021_023/c3_w1_br u_t021_023/c3_r0_rbl u_t021_023/c3_r1_rbl
+ u_t021_023/r0_w0_wl u_t021_023/r0_w1_wl u_t021_023/r0_r0_rwl u_t021_023/r0_r1_rwl
+ u_t021_023/r1_w0_wl u_t021_023/r1_w1_wl u_t021_023/r1_r0_rwl u_t021_023/r1_r1_rwl
+ u_t021_023/r2_w0_wl u_t021_023/r2_w1_wl u_t021_023/r2_r0_rwl u_t021_023/r2_r1_rwl
+ u_t021_023/r3_w0_wl u_t021_023/r3_w1_wl u_t021_023/r3_r0_rwl u_t021_023/r3_r1_rwl
+ VSS u_t021_031/VSS VSUBS detronyx_12t_2w2r_rc4_4x4_routed_5layer_direct
Xu_t021_012 u_t021_012/c0_w0_bl u_t021_012/c0_w0_br u_t021_012/c0_w1_bl u_t021_012/c0_w1_br
+ u_t021_012/c0_r0_rbl u_t021_012/c0_r1_rbl u_t021_012/c1_w0_bl u_t021_012/c1_w0_br
+ u_t021_012/c1_w1_bl u_t021_012/c1_w1_br u_t021_012/c1_r0_rbl u_t021_012/c1_r1_rbl
+ u_t021_012/c2_w0_bl u_t021_012/c2_w0_br u_t021_012/c2_w1_bl u_t021_012/c2_w1_br
+ u_t021_012/c2_r0_rbl u_t021_012/c2_r1_rbl u_t021_012/c3_w0_bl u_t021_012/c3_w0_br
+ u_t021_012/c3_w1_bl u_t021_012/c3_w1_br u_t021_012/c3_r0_rbl u_t021_012/c3_r1_rbl
+ u_t021_012/r0_w0_wl u_t021_012/r0_w1_wl u_t021_012/r0_r0_rwl u_t021_012/r0_r1_rwl
+ u_t021_012/r1_w0_wl u_t021_012/r1_w1_wl u_t021_012/r1_r0_rwl u_t021_012/r1_r1_rwl
+ u_t021_012/r2_w0_wl u_t021_012/r2_w1_wl u_t021_012/r2_r0_rwl u_t021_012/r2_r1_rwl
+ u_t021_012/r3_w0_wl u_t021_012/r3_w1_wl u_t021_012/r3_r0_rwl u_t021_012/r3_r1_rwl
+ u_t021_012/VDD u_t021_031/VSS VSUBS detronyx_12t_2w2r_rc4_4x4_routed_5layer_direct
Xu_t021_001 u_t021_001/c0_w0_bl u_t021_001/c0_w0_br u_t021_001/c0_w1_bl u_t021_001/c0_w1_br
+ u_t021_001/c0_r0_rbl u_t021_001/c0_r1_rbl u_t021_001/c1_w0_bl u_t021_001/c1_w0_br
+ u_t021_001/c1_w1_bl u_t021_001/c1_w1_br u_t021_001/c1_r0_rbl u_t021_001/c1_r1_rbl
+ u_t021_001/c2_w0_bl u_t021_001/c2_w0_br u_t021_001/c2_w1_bl u_t021_001/c2_w1_br
+ u_t021_001/c2_r0_rbl u_t021_001/c2_r1_rbl u_t021_001/c3_w0_bl u_t021_001/c3_w0_br
+ u_t021_001/c3_w1_bl u_t021_001/c3_w1_br u_t021_001/c3_r0_rbl u_t021_001/c3_r1_rbl
+ u_t021_001/r0_w0_wl u_t021_001/r0_w1_wl u_t021_001/r0_r0_rwl u_t021_001/r0_r1_rwl
+ u_t021_001/r1_w0_wl u_t021_001/r1_w1_wl u_t021_001/r1_r0_rwl u_t021_001/r1_r1_rwl
+ u_t021_001/r2_w0_wl u_t021_001/r2_w1_wl u_t021_001/r2_r0_rwl u_t021_001/r2_r1_rwl
+ u_t021_001/r3_w0_wl u_t021_001/r3_w1_wl u_t021_001/r3_r0_rwl u_t021_001/r3_r1_rwl
+ VSS u_t021_031/VSS VSUBS detronyx_12t_2w2r_rc4_4x4_routed_5layer_direct
Xu_t012_012 u_t012_012/c0_w0_bl u_t012_012/c0_w0_br u_t012_012/c0_w1_bl u_t012_012/c0_w1_br
+ u_t012_012/c0_r0_rbl u_t012_012/c0_r1_rbl u_t012_012/c1_w0_bl u_t012_012/c1_w0_br
+ u_t012_012/c1_w1_bl u_t012_012/c1_w1_br u_t012_012/c1_r0_rbl u_t012_012/c1_r1_rbl
+ u_t012_012/c2_w0_bl u_t012_012/c2_w0_br u_t012_012/c2_w1_bl u_t012_012/c2_w1_br
+ u_t012_012/c2_r0_rbl u_t012_012/c2_r1_rbl u_t012_012/c3_w0_bl u_t012_012/c3_w0_br
+ u_t012_012/c3_w1_bl u_t012_012/c3_w1_br u_t012_012/c3_r0_rbl u_t012_012/c3_r1_rbl
+ u_t012_012/r0_w0_wl u_t012_012/r0_w1_wl u_t012_012/r0_r0_rwl u_t012_012/r0_r1_rwl
+ u_t012_012/r1_w0_wl u_t012_012/r1_w1_wl u_t012_012/r1_r0_rwl u_t012_012/r1_r1_rwl
+ u_t012_012/r2_w0_wl u_t012_012/r2_w1_wl u_t012_012/r2_r0_rwl u_t012_012/r2_r1_rwl
+ u_t012_012/r3_w0_wl u_t012_012/r3_w1_wl u_t012_012/r3_r0_rwl u_t012_012/r3_r1_rwl
+ u_t012_012/VDD u_t012_031/VSS VSUBS detronyx_12t_2w2r_rc4_4x4_routed_5layer_direct
Xu_t012_001 u_t012_001/c0_w0_bl u_t012_001/c0_w0_br u_t012_001/c0_w1_bl u_t012_001/c0_w1_br
+ u_t012_001/c0_r0_rbl u_t012_001/c0_r1_rbl u_t012_001/c1_w0_bl u_t012_001/c1_w0_br
+ u_t012_001/c1_w1_bl u_t012_001/c1_w1_br u_t012_001/c1_r0_rbl u_t012_001/c1_r1_rbl
+ u_t012_001/c2_w0_bl u_t012_001/c2_w0_br u_t012_001/c2_w1_bl u_t012_001/c2_w1_br
+ u_t012_001/c2_r0_rbl u_t012_001/c2_r1_rbl u_t012_001/c3_w0_bl u_t012_001/c3_w0_br
+ u_t012_001/c3_w1_bl u_t012_001/c3_w1_br u_t012_001/c3_r0_rbl u_t012_001/c3_r1_rbl
+ u_t012_001/r0_w0_wl u_t012_001/r0_w1_wl u_t012_001/r0_r0_rwl u_t012_001/r0_r1_rwl
+ u_t012_001/r1_w0_wl u_t012_001/r1_w1_wl u_t012_001/r1_r0_rwl u_t012_001/r1_r1_rwl
+ u_t012_001/r2_w0_wl u_t012_001/r2_w1_wl u_t012_001/r2_r0_rwl u_t012_001/r2_r1_rwl
+ u_t012_001/r3_w0_wl u_t012_001/r3_w1_wl u_t012_001/r3_r0_rwl u_t012_001/r3_r1_rwl
+ VSS u_t012_031/VSS VSUBS detronyx_12t_2w2r_rc4_4x4_routed_5layer_direct
Xu_t012_023 u_t012_023/c0_w0_bl u_t012_023/c0_w0_br u_t012_023/c0_w1_bl u_t012_023/c0_w1_br
+ u_t012_023/c0_r0_rbl u_t012_023/c0_r1_rbl u_t012_023/c1_w0_bl u_t012_023/c1_w0_br
+ u_t012_023/c1_w1_bl u_t012_023/c1_w1_br u_t012_023/c1_r0_rbl u_t012_023/c1_r1_rbl
+ u_t012_023/c2_w0_bl u_t012_023/c2_w0_br u_t012_023/c2_w1_bl u_t012_023/c2_w1_br
+ u_t012_023/c2_r0_rbl u_t012_023/c2_r1_rbl u_t012_023/c3_w0_bl u_t012_023/c3_w0_br
+ u_t012_023/c3_w1_bl u_t012_023/c3_w1_br u_t012_023/c3_r0_rbl u_t012_023/c3_r1_rbl
+ u_t012_023/r0_w0_wl u_t012_023/r0_w1_wl u_t012_023/r0_r0_rwl u_t012_023/r0_r1_rwl
+ u_t012_023/r1_w0_wl u_t012_023/r1_w1_wl u_t012_023/r1_r0_rwl u_t012_023/r1_r1_rwl
+ u_t012_023/r2_w0_wl u_t012_023/r2_w1_wl u_t012_023/r2_r0_rwl u_t012_023/r2_r1_rwl
+ u_t012_023/r3_w0_wl u_t012_023/r3_w1_wl u_t012_023/r3_r0_rwl u_t012_023/r3_r1_rwl
+ VSS u_t012_031/VSS VSUBS detronyx_12t_2w2r_rc4_4x4_routed_5layer_direct
Xgf180mcu_as_sc_mcu7t3v3__inv_2_1471 VSS VSS VSS VSS gf180mcu_as_sc_mcu7t3v3__inv_2_1472/VNW
+ VSUBS gf180mcu_as_sc_mcu7t3v3__inv_2
Xgf180mcu_as_sc_mcu7t3v3__inv_2_1460 VSS gf180mcu_as_sc_mcu7t3v3__inv_2_1502/VDD VSS
+ VSS gf180mcu_as_sc_mcu7t3v3__inv_2_1461/VNW VSUBS gf180mcu_as_sc_mcu7t3v3__inv_2
Xgf180mcu_as_sc_mcu7t3v3__inv_2_1493 gf180mcu_as_sc_mcu7t3v3__inv_2_1497/VDD gf180mcu_as_sc_mcu7t3v3__inv_2_1497/VSS
+ gf180mcu_as_sc_mcu7t3v3__inv_2_1493/Y VSS gf180mcu_as_sc_mcu7t3v3__inv_2_1497/VNW
+ VSUBS gf180mcu_as_sc_mcu7t3v3__inv_2
Xgf180mcu_as_sc_mcu7t3v3__inv_2_1482 VSS VSS VSS VSS gf180mcu_as_sc_mcu7t3v3__inv_2_1484/VNW
+ VSUBS gf180mcu_as_sc_mcu7t3v3__inv_2
Xgf180mcu_as_sc_mcu7t3v3__inv_2_922 VSS VSS VSS VSS gf180mcu_as_sc_mcu7t3v3__inv_2_924/VNW
+ VSUBS gf180mcu_as_sc_mcu7t3v3__inv_2
Xgf180mcu_as_sc_mcu7t3v3__inv_2_900 VSS VSS VSS VSS gf180mcu_as_sc_mcu7t3v3__inv_2_900/VNW
+ VSUBS gf180mcu_as_sc_mcu7t3v3__inv_2
Xgf180mcu_as_sc_mcu7t3v3__inv_2_911 VSS VSS VSS VSS gf180mcu_as_sc_mcu7t3v3__inv_2_913/VNW
+ VSUBS gf180mcu_as_sc_mcu7t3v3__inv_2
Xu_t003_023 u_t003_023/c0_w0_bl u_t003_023/c0_w0_br u_t003_023/c0_w1_bl u_t003_023/c0_w1_br
+ u_t003_023/c0_r0_rbl u_t003_023/c0_r1_rbl u_t003_023/c1_w0_bl u_t003_023/c1_w0_br
+ u_t003_023/c1_w1_bl u_t003_023/c1_w1_br u_t003_023/c1_r0_rbl u_t003_023/c1_r1_rbl
+ u_t003_023/c2_w0_bl u_t003_023/c2_w0_br u_t003_023/c2_w1_bl u_t003_023/c2_w1_br
+ u_t003_023/c2_r0_rbl u_t003_023/c2_r1_rbl u_t003_023/c3_w0_bl u_t003_023/c3_w0_br
+ u_t003_023/c3_w1_bl u_t003_023/c3_w1_br u_t003_023/c3_r0_rbl u_t003_023/c3_r1_rbl
+ u_t003_023/r0_w0_wl u_t003_023/r0_w1_wl u_t003_023/r0_r0_rwl u_t003_023/r0_r1_rwl
+ u_t003_023/r1_w0_wl u_t003_023/r1_w1_wl u_t003_023/r1_r0_rwl u_t003_023/r1_r1_rwl
+ u_t003_023/r2_w0_wl u_t003_023/r2_w1_wl u_t003_023/r2_r0_rwl u_t003_023/r2_r1_rwl
+ u_t003_023/r3_w0_wl u_t003_023/r3_w1_wl u_t003_023/r3_r0_rwl u_t003_023/r3_r1_rwl
+ VSS u_t003_024/VSS VSUBS detronyx_12t_2w2r_rc4_4x4_routed_5layer_direct
Xu_t003_012 u_t003_012/c0_w0_bl u_t003_012/c0_w0_br u_t003_012/c0_w1_bl u_t003_012/c0_w1_br
+ u_t003_012/c0_r0_rbl u_t003_012/c0_r1_rbl u_t003_012/c1_w0_bl u_t003_012/c1_w0_br
+ u_t003_012/c1_w1_bl u_t003_012/c1_w1_br u_t003_012/c1_r0_rbl u_t003_012/c1_r1_rbl
+ u_t003_012/c2_w0_bl u_t003_012/c2_w0_br u_t003_012/c2_w1_bl u_t003_012/c2_w1_br
+ u_t003_012/c2_r0_rbl u_t003_012/c2_r1_rbl u_t003_012/c3_w0_bl u_t003_012/c3_w0_br
+ u_t003_012/c3_w1_bl u_t003_012/c3_w1_br u_t003_012/c3_r0_rbl u_t003_012/c3_r1_rbl
+ u_t003_012/r0_w0_wl u_t003_012/r0_w1_wl u_t003_012/r0_r0_rwl u_t003_012/r0_r1_rwl
+ u_t003_012/r1_w0_wl u_t003_012/r1_w1_wl u_t003_012/r1_r0_rwl u_t003_012/r1_r1_rwl
+ u_t003_012/r2_w0_wl u_t003_012/r2_w1_wl u_t003_012/r2_r0_rwl u_t003_012/r2_r1_rwl
+ u_t003_012/r3_w0_wl u_t003_012/r3_w1_wl u_t003_012/r3_r0_rwl u_t003_012/r3_r1_rwl
+ u_t004_012/VDD u_t003_012/VSS VSUBS detronyx_12t_2w2r_rc4_4x4_routed_5layer_direct
Xu_t003_001 u_t003_001/c0_w0_bl u_t003_001/c0_w0_br u_t003_001/c0_w1_bl u_t003_001/c0_w1_br
+ u_t003_001/c0_r0_rbl u_t003_001/c0_r1_rbl u_t003_001/c1_w0_bl u_t003_001/c1_w0_br
+ u_t003_001/c1_w1_bl u_t003_001/c1_w1_br u_t003_001/c1_r0_rbl u_t003_001/c1_r1_rbl
+ u_t003_001/c2_w0_bl u_t003_001/c2_w0_br u_t003_001/c2_w1_bl u_t003_001/c2_w1_br
+ u_t003_001/c2_r0_rbl u_t003_001/c2_r1_rbl u_t003_001/c3_w0_bl u_t003_001/c3_w0_br
+ u_t003_001/c3_w1_bl u_t003_001/c3_w1_br u_t003_001/c3_r0_rbl u_t003_001/c3_r1_rbl
+ u_t003_001/r0_w0_wl u_t003_001/r0_w1_wl u_t003_001/r0_r0_rwl u_t003_001/r0_r1_rwl
+ u_t003_001/r1_w0_wl u_t003_001/r1_w1_wl u_t003_001/r1_r0_rwl u_t003_001/r1_r1_rwl
+ u_t003_001/r2_w0_wl u_t003_001/r2_w1_wl u_t003_001/r2_r0_rwl u_t003_001/r2_r1_rwl
+ u_t003_001/r3_w0_wl u_t003_001/r3_w1_wl u_t003_001/r3_r0_rwl u_t003_001/r3_r1_rwl
+ VSS u_t003_002/VSS VSUBS detronyx_12t_2w2r_rc4_4x4_routed_5layer_direct
Xgf180mcu_as_sc_mcu7t3v3__inv_2_944 VSS VSS gf180mcu_as_sc_mcu7t3v3__inv_2_944/Y VSS
+ gf180mcu_as_sc_mcu7t3v3__inv_2_944/VNW VSUBS gf180mcu_as_sc_mcu7t3v3__inv_2
Xgf180mcu_as_sc_mcu7t3v3__inv_2_988 VSS gf180mcu_as_sc_mcu7t3v3__inv_2_990/VSS gf180mcu_as_sc_mcu7t3v3__inv_2_988/Y
+ gf180mcu_as_sc_mcu7t3v3__inv_2_988/A gf180mcu_as_sc_mcu7t3v3__inv_2_990/VNW VSUBS
+ gf180mcu_as_sc_mcu7t3v3__inv_2
Xgf180mcu_as_sc_mcu7t3v3__inv_2_977 gf180mcu_as_sc_mcu7t3v3__inv_2_978/VDD gf180mcu_as_sc_mcu7t3v3__inv_2_982/VDD
+ gf180mcu_as_sc_mcu7t3v3__inv_2_977/Y gf180mcu_as_sc_mcu7t3v3__inv_2_978/Y gf180mcu_as_sc_mcu7t3v3__inv_2_978/VNW
+ VSUBS gf180mcu_as_sc_mcu7t3v3__inv_2
Xgf180mcu_as_sc_mcu7t3v3__inv_2_966 gf180mcu_as_sc_mcu7t3v3__inv_2_966/VDD gf180mcu_as_sc_mcu7t3v3__inv_2_970/VDD
+ gf180mcu_as_sc_mcu7t3v3__inv_2_966/Y VSS gf180mcu_as_sc_mcu7t3v3__inv_2_966/VNW
+ VSUBS gf180mcu_as_sc_mcu7t3v3__inv_2
Xgf180mcu_as_sc_mcu7t3v3__inv_2_955 gf180mcu_as_sc_mcu7t3v3__inv_2_999/VSS gf180mcu_as_sc_mcu7t3v3__inv_2_987/VSS
+ gf180mcu_as_sc_mcu7t3v3__inv_2_987/A VSS gf180mcu_as_sc_mcu7t3v3__inv_2_987/VNW
+ VSUBS gf180mcu_as_sc_mcu7t3v3__inv_2
Xgf180mcu_as_sc_mcu7t3v3__inv_2_999 VSS gf180mcu_as_sc_mcu7t3v3__inv_2_999/VSS gf180mcu_as_sc_mcu7t3v3__inv_2_999/Y
+ VSS gf180mcu_as_sc_mcu7t3v3__inv_2_999/VNW VSUBS gf180mcu_as_sc_mcu7t3v3__inv_2
Xgf180mcu_as_sc_mcu7t3v3__inv_2_933 VSS VSS VSS VSS gf180mcu_as_sc_mcu7t3v3__inv_2_933/VNW
+ VSUBS gf180mcu_as_sc_mcu7t3v3__inv_2
Xgf180mcu_as_sc_mcu7t3v3__nand4_2_276 VSS VSS VSS VSS VSS VSS gf180mcu_as_sc_mcu7t3v3__nand4_2_276/Y
+ gf180mcu_as_sc_mcu7t3v3__inv_2_905/VNW VSUBS gf180mcu_as_sc_mcu7t3v3__nand4_2
Xgf180mcu_as_sc_mcu7t3v3__nand4_2_210 VSS gf180mcu_as_sc_mcu7t3v3__inv_2_684/VSS VSS
+ VSS VSS VSS VSS gf180mcu_as_sc_mcu7t3v3__inv_2_684/VNW VSUBS gf180mcu_as_sc_mcu7t3v3__nand4_2
Xgf180mcu_as_sc_mcu7t3v3__nand4_2_221 VSS VSS VSS VSS VSS VSS gf180mcu_as_sc_mcu7t3v3__nand4_2_221/Y
+ gf180mcu_as_sc_mcu7t3v3__inv_2_776/VNW VSUBS gf180mcu_as_sc_mcu7t3v3__nand4_2
Xgf180mcu_as_sc_mcu7t3v3__nand4_2_232 VSS VSS VSS VSS VSS VSS VSS gf180mcu_as_sc_mcu7t3v3__inv_2_820/VNW
+ VSUBS gf180mcu_as_sc_mcu7t3v3__nand4_2
Xgf180mcu_as_sc_mcu7t3v3__nand4_2_243 VSS VSS VSS VSS VSS VSS VSS gf180mcu_as_sc_mcu7t3v3__inv_2_816/VNW
+ VSUBS gf180mcu_as_sc_mcu7t3v3__nand4_2
Xgf180mcu_as_sc_mcu7t3v3__nand4_2_287 gf180mcu_as_sc_mcu7t3v3__inv_2_966/VDD gf180mcu_as_sc_mcu7t3v3__inv_2_970/VDD
+ VSS VSS VSS VSS VSS gf180mcu_as_sc_mcu7t3v3__inv_2_966/VNW VSUBS gf180mcu_as_sc_mcu7t3v3__nand4_2
Xgf180mcu_as_sc_mcu7t3v3__nand4_2_254 VSS VSS VSS VSS VSS VSS gf180mcu_as_sc_mcu7t3v3__nand4_2_254/Y
+ gf180mcu_as_sc_mcu7t3v3__inv_2_868/VNW VSUBS gf180mcu_as_sc_mcu7t3v3__nand4_2
Xgf180mcu_as_sc_mcu7t3v3__nand4_2_265 VSS VSS VSS VSS VSS VSS VSS gf180mcu_as_sc_mcu7t3v3__inv_2_897/VNW
+ VSUBS gf180mcu_as_sc_mcu7t3v3__nand4_2
Xgf180mcu_as_sc_mcu7t3v3__nand4_2_298 VSS VSS VSS VSS VSS VSS VSS gf180mcu_as_sc_mcu7t3v3__inv_2_983/VNW
+ VSUBS gf180mcu_as_sc_mcu7t3v3__nand4_2
Xgf180mcu_as_sc_mcu7t3v3__inv_2_207 VSS gf180mcu_as_sc_mcu7t3v3__inv_2_229/VDD VSS
+ VSS gf180mcu_as_sc_mcu7t3v3__inv_2_213/VNW VSUBS gf180mcu_as_sc_mcu7t3v3__inv_2
Xu_t000_004 u_t000_004/c0_w0_bl u_t000_004/c0_w0_br u_t000_004/c0_w1_bl u_t000_004/c0_w1_br
+ u_t000_004/c0_r0_rbl u_t000_004/c0_r1_rbl u_t000_004/c1_w0_bl u_t000_004/c1_w0_br
+ u_t000_004/c1_w1_bl u_t000_004/c1_w1_br u_t000_004/c1_r0_rbl u_t000_004/c1_r1_rbl
+ u_t000_004/c2_w0_bl u_t000_004/c2_w0_br u_t000_004/c2_w1_bl u_t000_004/c2_w1_br
+ u_t000_004/c2_r0_rbl u_t000_004/c2_r1_rbl u_t000_004/c3_w0_bl u_t000_004/c3_w0_br
+ u_t000_004/c3_w1_bl u_t000_004/c3_w1_br u_t000_004/c3_r0_rbl u_t000_004/c3_r1_rbl
+ u_t000_004/r0_w0_wl u_t000_004/r0_w1_wl u_t000_004/r0_r0_rwl u_t000_004/r0_r1_rwl
+ u_t000_004/r1_w0_wl u_t000_004/r1_w1_wl u_t000_004/r1_r0_rwl u_t000_004/r1_r1_rwl
+ u_t000_004/r2_w0_wl u_t000_004/r2_w1_wl u_t000_004/r2_r0_rwl u_t000_004/r2_r1_rwl
+ u_t000_004/r3_w0_wl u_t000_004/r3_w1_wl u_t000_004/r3_r0_rwl u_t000_004/r3_r1_rwl
+ u_t000_004/VDD u_t000_031/VSS VSUBS detronyx_12t_2w2r_rc4_4x4_routed_5layer_direct
Xgf180mcu_as_sc_mcu7t3v3__inv_2_218 gf180mcu_as_sc_mcu7t3v3__inv_2_220/VDD VSS VSS
+ VSS gf180mcu_as_sc_mcu7t3v3__inv_2_220/VNW VSUBS gf180mcu_as_sc_mcu7t3v3__inv_2
Xgf180mcu_as_sc_mcu7t3v3__inv_2_229 gf180mcu_as_sc_mcu7t3v3__inv_2_229/VDD gf180mcu_as_sc_mcu7t3v3__inv_2_233/VDD
+ gf180mcu_as_sc_mcu7t3v3__inv_2_229/Y VSS gf180mcu_as_sc_mcu7t3v3__inv_2_229/VNW
+ VSUBS gf180mcu_as_sc_mcu7t3v3__inv_2
Xu_t000_026 u_t000_026/c0_w0_bl u_t000_026/c0_w0_br u_t000_026/c0_w1_bl u_t000_026/c0_w1_br
+ u_t000_026/c0_r0_rbl u_t000_026/c0_r1_rbl u_t000_026/c1_w0_bl u_t000_026/c1_w0_br
+ u_t000_026/c1_w1_bl u_t000_026/c1_w1_br u_t000_026/c1_r0_rbl u_t000_026/c1_r1_rbl
+ u_t000_026/c2_w0_bl u_t000_026/c2_w0_br u_t000_026/c2_w1_bl u_t000_026/c2_w1_br
+ u_t000_026/c2_r0_rbl u_t000_026/c2_r1_rbl u_t000_026/c3_w0_bl u_t000_026/c3_w0_br
+ u_t000_026/c3_w1_bl u_t000_026/c3_w1_br u_t000_026/c3_r0_rbl u_t000_026/c3_r1_rbl
+ u_t000_026/r0_w0_wl u_t000_026/r0_w1_wl u_t000_026/r0_r0_rwl u_t000_026/r0_r1_rwl
+ u_t000_026/r1_w0_wl u_t000_026/r1_w1_wl u_t000_026/r1_r0_rwl u_t000_026/r1_r1_rwl
+ u_t000_026/r2_w0_wl u_t000_026/r2_w1_wl u_t000_026/r2_r0_rwl u_t000_026/r2_r1_rwl
+ u_t000_026/r3_w0_wl u_t000_026/r3_w1_wl u_t000_026/r3_r0_rwl u_t000_026/r3_r1_rwl
+ u_t000_026/VDD u_t000_031/VSS VSUBS detronyx_12t_2w2r_rc4_4x4_routed_5layer_direct
Xu_t000_015 u_t000_015/c0_w0_bl u_t000_015/c0_w0_br u_t000_015/c0_w1_bl u_t000_015/c0_w1_br
+ u_t000_015/c0_r0_rbl u_t000_015/c0_r1_rbl u_t000_015/c1_w0_bl u_t000_015/c1_w0_br
+ u_t000_015/c1_w1_bl u_t000_015/c1_w1_br u_t000_015/c1_r0_rbl u_t000_015/c1_r1_rbl
+ u_t000_015/c2_w0_bl u_t000_015/c2_w0_br u_t000_015/c2_w1_bl u_t000_015/c2_w1_br
+ u_t000_015/c2_r0_rbl u_t000_015/c2_r1_rbl u_t000_015/c3_w0_bl u_t000_015/c3_w0_br
+ u_t000_015/c3_w1_bl u_t000_015/c3_w1_br u_t000_015/c3_r0_rbl u_t000_015/c3_r1_rbl
+ u_t000_015/r0_w0_wl u_t000_015/r0_w1_wl u_t000_015/r0_r0_rwl u_t000_015/r0_r1_rwl
+ u_t000_015/r1_w0_wl u_t000_015/r1_w1_wl u_t000_015/r1_r0_rwl u_t000_015/r1_r1_rwl
+ u_t000_015/r2_w0_wl u_t000_015/r2_w1_wl u_t000_015/r2_r0_rwl u_t000_015/r2_r1_rwl
+ u_t000_015/r3_w0_wl u_t000_015/r3_w1_wl u_t000_015/r3_r0_rwl u_t000_015/r3_r1_rwl
+ VSS u_t000_031/VSS VSUBS detronyx_12t_2w2r_rc4_4x4_routed_5layer_direct
Xgf180mcu_as_sc_mcu7t3v3__inv_2_1290 VSS VSS VSS VSS gf180mcu_as_sc_mcu7t3v3__inv_2_1292/VNW
+ VSUBS gf180mcu_as_sc_mcu7t3v3__inv_2
Xgf180mcu_as_sc_mcu7t3v3__inv_2_763 VSS VSS VSS VSS gf180mcu_as_sc_mcu7t3v3__inv_2_764/VNW
+ VSUBS gf180mcu_as_sc_mcu7t3v3__inv_2
Xgf180mcu_as_sc_mcu7t3v3__inv_2_752 VSS VSS VSS VSS gf180mcu_as_sc_mcu7t3v3__inv_2_752/VNW
+ VSUBS gf180mcu_as_sc_mcu7t3v3__inv_2
Xgf180mcu_as_sc_mcu7t3v3__inv_2_741 VSS gf180mcu_as_sc_mcu7t3v3__inv_2_741/VSS gf180mcu_as_sc_mcu7t3v3__inv_2_741/Y
+ VSS gf180mcu_as_sc_mcu7t3v3__inv_2_741/VNW VSUBS gf180mcu_as_sc_mcu7t3v3__inv_2
Xgf180mcu_as_sc_mcu7t3v3__inv_2_730 gf180mcu_as_sc_mcu7t3v3__inv_2_731/VDD VSS gf180mcu_as_sc_mcu7t3v3__inv_2_730/Y
+ gf180mcu_as_sc_mcu7t3v3__inv_2_731/Y gf180mcu_as_sc_mcu7t3v3__inv_2_731/VNW VSUBS
+ gf180mcu_as_sc_mcu7t3v3__inv_2
Xgf180mcu_as_sc_mcu7t3v3__inv_2_785 VSS VSS VSS VSS gf180mcu_as_sc_mcu7t3v3__inv_2_785/VNW
+ VSUBS gf180mcu_as_sc_mcu7t3v3__inv_2
Xgf180mcu_as_sc_mcu7t3v3__inv_2_774 VSS VSS gf180mcu_as_sc_mcu7t3v3__inv_2_774/Y VSS
+ gf180mcu_as_sc_mcu7t3v3__inv_2_776/VNW VSUBS gf180mcu_as_sc_mcu7t3v3__inv_2
Xgf180mcu_as_sc_mcu7t3v3__inv_2_796 VSS VSS gf180mcu_as_sc_mcu7t3v3__inv_2_796/Y VSS
+ gf180mcu_as_sc_mcu7t3v3__inv_2_843/VNW VSUBS gf180mcu_as_sc_mcu7t3v3__inv_2
Xgf180mcu_as_sc_mcu7t3v3__inv_2_560 gf180mcu_as_sc_mcu7t3v3__inv_2_636/VSS VSS gf180mcu_as_sc_mcu7t3v3__inv_2_560/Y
+ gf180mcu_as_sc_mcu7t3v3__inv_2_561/Y gf180mcu_as_sc_mcu7t3v3__inv_2_561/VNW VSUBS
+ gf180mcu_as_sc_mcu7t3v3__inv_2
Xgf180mcu_as_sc_mcu7t3v3__inv_2_571 gf180mcu_as_sc_mcu7t3v3__inv_2_572/VDD gf180mcu_as_sc_mcu7t3v3__inv_2_576/VDD
+ gf180mcu_as_sc_mcu7t3v3__inv_2_571/Y gf180mcu_as_sc_mcu7t3v3__inv_2_572/Y gf180mcu_as_sc_mcu7t3v3__inv_2_572/VNW
+ VSUBS gf180mcu_as_sc_mcu7t3v3__inv_2
Xgf180mcu_as_sc_mcu7t3v3__inv_2_582 gf180mcu_as_sc_mcu7t3v3__inv_2_584/VDD gf180mcu_as_sc_mcu7t3v3__inv_2_585/VDD
+ gf180mcu_as_sc_mcu7t3v3__inv_2_582/Y VSS gf180mcu_as_sc_mcu7t3v3__inv_2_584/VNW
+ VSUBS gf180mcu_as_sc_mcu7t3v3__inv_2
Xgf180mcu_as_sc_mcu7t3v3__inv_2_593 VSS gf180mcu_as_sc_mcu7t3v3__inv_2_597/VDD gf180mcu_as_sc_mcu7t3v3__inv_2_593/Y
+ VSS gf180mcu_as_sc_mcu7t3v3__inv_2_593/VNW VSUBS gf180mcu_as_sc_mcu7t3v3__inv_2
Xgf180mcu_as_sc_mcu7t3v3__nor2_2_8 gf180mcu_as_sc_mcu7t3v3__nor2_2_8/VDD gf180mcu_as_sc_mcu7t3v3__nor2_2_8/VSS
+ VSS VSS VSS gf180mcu_as_sc_mcu7t3v3__nor2_2_8/VNW VSUBS gf180mcu_as_sc_mcu7t3v3__nor2_2
Xu_t028_029 u_t028_029/c0_w0_bl u_t028_029/c0_w0_br u_t028_029/c0_w1_bl u_t028_029/c0_w1_br
+ u_t028_029/c0_r0_rbl u_t028_029/c0_r1_rbl u_t028_029/c1_w0_bl u_t028_029/c1_w0_br
+ u_t028_029/c1_w1_bl u_t028_029/c1_w1_br u_t028_029/c1_r0_rbl u_t028_029/c1_r1_rbl
+ u_t028_029/c2_w0_bl u_t028_029/c2_w0_br u_t028_029/c2_w1_bl u_t028_029/c2_w1_br
+ u_t028_029/c2_r0_rbl u_t028_029/c2_r1_rbl u_t028_029/c3_w0_bl u_t028_029/c3_w0_br
+ u_t028_029/c3_w1_bl u_t028_029/c3_w1_br u_t028_029/c3_r0_rbl u_t028_029/c3_r1_rbl
+ u_t028_029/r0_w0_wl u_t028_029/r0_w1_wl u_t028_029/r0_r0_rwl u_t028_029/r0_r1_rwl
+ u_t028_029/r1_w0_wl u_t028_029/r1_w1_wl u_t028_029/r1_r0_rwl u_t028_029/r1_r1_rwl
+ u_t028_029/r2_w0_wl u_t028_029/r2_w1_wl u_t028_029/r2_r0_rwl u_t028_029/r2_r1_rwl
+ u_t028_029/r3_w0_wl u_t028_029/r3_w1_wl u_t028_029/r3_r0_rwl u_t028_029/r3_r1_rwl
+ u_t029_029/VDD u_t028_031/VSS VSUBS detronyx_12t_2w2r_rc4_4x4_routed_5layer_direct
Xu_t028_018 u_t028_018/c0_w0_bl u_t028_018/c0_w0_br u_t028_018/c0_w1_bl u_t028_018/c0_w1_br
+ u_t028_018/c0_r0_rbl u_t028_018/c0_r1_rbl u_t028_018/c1_w0_bl u_t028_018/c1_w0_br
+ u_t028_018/c1_w1_bl u_t028_018/c1_w1_br u_t028_018/c1_r0_rbl u_t028_018/c1_r1_rbl
+ u_t028_018/c2_w0_bl u_t028_018/c2_w0_br u_t028_018/c2_w1_bl u_t028_018/c2_w1_br
+ u_t028_018/c2_r0_rbl u_t028_018/c2_r1_rbl u_t028_018/c3_w0_bl u_t028_018/c3_w0_br
+ u_t028_018/c3_w1_bl u_t028_018/c3_w1_br u_t028_018/c3_r0_rbl u_t028_018/c3_r1_rbl
+ u_t028_018/r0_w0_wl u_t028_018/r0_w1_wl u_t028_018/r0_r0_rwl u_t028_018/r0_r1_rwl
+ u_t028_018/r1_w0_wl u_t028_018/r1_w1_wl u_t028_018/r1_r0_rwl u_t028_018/r1_r1_rwl
+ u_t028_018/r2_w0_wl u_t028_018/r2_w1_wl u_t028_018/r2_r0_rwl u_t028_018/r2_r1_rwl
+ u_t028_018/r3_w0_wl u_t028_018/r3_w1_wl u_t028_018/r3_r0_rwl u_t028_018/r3_r1_rwl
+ u_t029_018/VDD u_t028_018/VSS VSUBS detronyx_12t_2w2r_rc4_4x4_routed_5layer_direct
Xu_t028_007 u_t028_007/c0_w0_bl u_t028_007/c0_w0_br u_t028_007/c0_w1_bl u_t028_007/c0_w1_br
+ u_t028_007/c0_r0_rbl u_t028_007/c0_r1_rbl u_t028_007/c1_w0_bl u_t028_007/c1_w0_br
+ u_t028_007/c1_w1_bl u_t028_007/c1_w1_br u_t028_007/c1_r0_rbl u_t028_007/c1_r1_rbl
+ u_t028_007/c2_w0_bl u_t028_007/c2_w0_br u_t028_007/c2_w1_bl u_t028_007/c2_w1_br
+ u_t028_007/c2_r0_rbl u_t028_007/c2_r1_rbl u_t028_007/c3_w0_bl u_t028_007/c3_w0_br
+ u_t028_007/c3_w1_bl u_t028_007/c3_w1_br u_t028_007/c3_r0_rbl u_t028_007/c3_r1_rbl
+ u_t028_007/r0_w0_wl u_t028_007/r0_w1_wl u_t028_007/r0_r0_rwl u_t028_007/r0_r1_rwl
+ u_t028_007/r1_w0_wl u_t028_007/r1_w1_wl u_t028_007/r1_r0_rwl u_t028_007/r1_r1_rwl
+ u_t028_007/r2_w0_wl u_t028_007/r2_w1_wl u_t028_007/r2_r0_rwl u_t028_007/r2_r1_rwl
+ u_t028_007/r3_w0_wl u_t028_007/r3_w1_wl u_t028_007/r3_r0_rwl u_t028_007/r3_r1_rwl
+ VSS u_t028_009/VSS VSUBS detronyx_12t_2w2r_rc4_4x4_routed_5layer_direct
Xgf180mcu_as_sc_mcu7t3v3__inv_2_390 gf180mcu_as_sc_mcu7t3v3__nor2_2_6/VDD gf180mcu_as_sc_mcu7t3v3__nand3_2_3/VSS
+ VSS VSS gf180mcu_as_sc_mcu7t3v3__nor2_2_6/VNW VSUBS gf180mcu_as_sc_mcu7t3v3__inv_2
Xu_t019_029 u_t019_029/c0_w0_bl u_t019_029/c0_w0_br u_t019_029/c0_w1_bl u_t019_029/c0_w1_br
+ u_t019_029/c0_r0_rbl u_t019_029/c0_r1_rbl u_t019_029/c1_w0_bl u_t019_029/c1_w0_br
+ u_t019_029/c1_w1_bl u_t019_029/c1_w1_br u_t019_029/c1_r0_rbl u_t019_029/c1_r1_rbl
+ u_t019_029/c2_w0_bl u_t019_029/c2_w0_br u_t019_029/c2_w1_bl u_t019_029/c2_w1_br
+ u_t019_029/c2_r0_rbl u_t019_029/c2_r1_rbl u_t019_029/c3_w0_bl u_t019_029/c3_w0_br
+ u_t019_029/c3_w1_bl u_t019_029/c3_w1_br u_t019_029/c3_r0_rbl u_t019_029/c3_r1_rbl
+ u_t019_029/r0_w0_wl u_t019_029/r0_w1_wl u_t019_029/r0_r0_rwl u_t019_029/r0_r1_rwl
+ u_t019_029/r1_w0_wl u_t019_029/r1_w1_wl u_t019_029/r1_r0_rwl u_t019_029/r1_r1_rwl
+ u_t019_029/r2_w0_wl u_t019_029/r2_w1_wl u_t019_029/r2_r0_rwl u_t019_029/r2_r1_rwl
+ u_t019_029/r3_w0_wl u_t019_029/r3_w1_wl u_t019_029/r3_r0_rwl u_t019_029/r3_r1_rwl
+ u_t019_029/VDD u_t019_031/VSS VSUBS detronyx_12t_2w2r_rc4_4x4_routed_5layer_direct
Xu_t019_018 u_t019_018/c0_w0_bl u_t019_018/c0_w0_br u_t019_018/c0_w1_bl u_t019_018/c0_w1_br
+ u_t019_018/c0_r0_rbl u_t019_018/c0_r1_rbl u_t019_018/c1_w0_bl u_t019_018/c1_w0_br
+ u_t019_018/c1_w1_bl u_t019_018/c1_w1_br u_t019_018/c1_r0_rbl u_t019_018/c1_r1_rbl
+ u_t019_018/c2_w0_bl u_t019_018/c2_w0_br u_t019_018/c2_w1_bl u_t019_018/c2_w1_br
+ u_t019_018/c2_r0_rbl u_t019_018/c2_r1_rbl u_t019_018/c3_w0_bl u_t019_018/c3_w0_br
+ u_t019_018/c3_w1_bl u_t019_018/c3_w1_br u_t019_018/c3_r0_rbl u_t019_018/c3_r1_rbl
+ u_t019_018/r0_w0_wl u_t019_018/r0_w1_wl u_t019_018/r0_r0_rwl u_t019_018/r0_r1_rwl
+ u_t019_018/r1_w0_wl u_t019_018/r1_w1_wl u_t019_018/r1_r0_rwl u_t019_018/r1_r1_rwl
+ u_t019_018/r2_w0_wl u_t019_018/r2_w1_wl u_t019_018/r2_r0_rwl u_t019_018/r2_r1_rwl
+ u_t019_018/r3_w0_wl u_t019_018/r3_w1_wl u_t019_018/r3_r0_rwl u_t019_018/r3_r1_rwl
+ u_t019_018/VDD u_t019_018/VSS VSUBS detronyx_12t_2w2r_rc4_4x4_routed_5layer_direct
Xu_t019_007 u_t019_007/c0_w0_bl u_t019_007/c0_w0_br u_t019_007/c0_w1_bl u_t019_007/c0_w1_br
+ u_t019_007/c0_r0_rbl u_t019_007/c0_r1_rbl u_t019_007/c1_w0_bl u_t019_007/c1_w0_br
+ u_t019_007/c1_w1_bl u_t019_007/c1_w1_br u_t019_007/c1_r0_rbl u_t019_007/c1_r1_rbl
+ u_t019_007/c2_w0_bl u_t019_007/c2_w0_br u_t019_007/c2_w1_bl u_t019_007/c2_w1_br
+ u_t019_007/c2_r0_rbl u_t019_007/c2_r1_rbl u_t019_007/c3_w0_bl u_t019_007/c3_w0_br
+ u_t019_007/c3_w1_bl u_t019_007/c3_w1_br u_t019_007/c3_r0_rbl u_t019_007/c3_r1_rbl
+ u_t019_007/r0_w0_wl u_t019_007/r0_w1_wl u_t019_007/r0_r0_rwl u_t019_007/r0_r1_rwl
+ u_t019_007/r1_w0_wl u_t019_007/r1_w1_wl u_t019_007/r1_r0_rwl u_t019_007/r1_r1_rwl
+ u_t019_007/r2_w0_wl u_t019_007/r2_w1_wl u_t019_007/r2_r0_rwl u_t019_007/r2_r1_rwl
+ u_t019_007/r3_w0_wl u_t019_007/r3_w1_wl u_t019_007/r3_r0_rwl u_t019_007/r3_r1_rwl
+ VSS u_t019_009/VSS VSUBS detronyx_12t_2w2r_rc4_4x4_routed_5layer_direct
Xgf180mcu_as_sc_mcu7t3v3__inv_2_1108 gf180mcu_as_sc_mcu7t3v3__inv_2_1143/VDD VSS gf180mcu_as_sc_mcu7t3v3__inv_2_1143/A
+ VSS gf180mcu_as_sc_mcu7t3v3__inv_2_1143/VNW VSUBS gf180mcu_as_sc_mcu7t3v3__inv_2
Xgf180mcu_as_sc_mcu7t3v3__inv_2_1119 VSS VSS gf180mcu_as_sc_mcu7t3v3__inv_2_1144/A
+ gf180mcu_as_sc_mcu7t3v3__inv_2_1120/Y gf180mcu_as_sc_mcu7t3v3__inv_2_1120/VNW VSUBS
+ gf180mcu_as_sc_mcu7t3v3__inv_2
Xu_t024_021 u_t024_021/c0_w0_bl u_t024_021/c0_w0_br u_t024_021/c0_w1_bl u_t024_021/c0_w1_br
+ u_t024_021/c0_r0_rbl u_t024_021/c0_r1_rbl u_t024_021/c1_w0_bl u_t024_021/c1_w0_br
+ u_t024_021/c1_w1_bl u_t024_021/c1_w1_br u_t024_021/c1_r0_rbl u_t024_021/c1_r1_rbl
+ u_t024_021/c2_w0_bl u_t024_021/c2_w0_br u_t024_021/c2_w1_bl u_t024_021/c2_w1_br
+ u_t024_021/c2_r0_rbl u_t024_021/c2_r1_rbl u_t024_021/c3_w0_bl u_t024_021/c3_w0_br
+ u_t024_021/c3_w1_bl u_t024_021/c3_w1_br u_t024_021/c3_r0_rbl u_t024_021/c3_r1_rbl
+ u_t024_021/r0_w0_wl u_t024_021/r0_w1_wl u_t024_021/r0_r0_rwl u_t024_021/r0_r1_rwl
+ u_t024_021/r1_w0_wl u_t024_021/r1_w1_wl u_t024_021/r1_r0_rwl u_t024_021/r1_r1_rwl
+ u_t024_021/r2_w0_wl u_t024_021/r2_w1_wl u_t024_021/r2_r0_rwl u_t024_021/r2_r1_rwl
+ u_t024_021/r3_w0_wl u_t024_021/r3_w1_wl u_t024_021/r3_r0_rwl u_t024_021/r3_r1_rwl
+ u_t025_021/VDD u_t024_024/VSS VSUBS detronyx_12t_2w2r_rc4_4x4_routed_5layer_direct
Xu_t024_010 u_t024_010/c0_w0_bl u_t024_010/c0_w0_br u_t024_010/c0_w1_bl u_t024_010/c0_w1_br
+ u_t024_010/c0_r0_rbl u_t024_010/c0_r1_rbl u_t024_010/c1_w0_bl u_t024_010/c1_w0_br
+ u_t024_010/c1_w1_bl u_t024_010/c1_w1_br u_t024_010/c1_r0_rbl u_t024_010/c1_r1_rbl
+ u_t024_010/c2_w0_bl u_t024_010/c2_w0_br u_t024_010/c2_w1_bl u_t024_010/c2_w1_br
+ u_t024_010/c2_r0_rbl u_t024_010/c2_r1_rbl u_t024_010/c3_w0_bl u_t024_010/c3_w0_br
+ u_t024_010/c3_w1_bl u_t024_010/c3_w1_br u_t024_010/c3_r0_rbl u_t024_010/c3_r1_rbl
+ u_t024_010/r0_w0_wl u_t024_010/r0_w1_wl u_t024_010/r0_r0_rwl u_t024_010/r0_r1_rwl
+ u_t024_010/r1_w0_wl u_t024_010/r1_w1_wl u_t024_010/r1_r0_rwl u_t024_010/r1_r1_rwl
+ u_t024_010/r2_w0_wl u_t024_010/r2_w1_wl u_t024_010/r2_r0_rwl u_t024_010/r2_r1_rwl
+ u_t024_010/r3_w0_wl u_t024_010/r3_w1_wl u_t024_010/r3_r0_rwl u_t024_010/r3_r1_rwl
+ VSS u_t024_010/VSS VSUBS detronyx_12t_2w2r_rc4_4x4_routed_5layer_direct
Xgf180mcu_as_sc_mcu7t3v3__nand3_2_33 gf180mcu_as_sc_mcu7t3v3__nor2_2_8/VDD gf180mcu_as_sc_mcu7t3v3__nor2_2_8/VSS
+ VSS VSS VSS VSS gf180mcu_as_sc_mcu7t3v3__nor2_2_8/VNW VSUBS gf180mcu_as_sc_mcu7t3v3__nand3_2
Xgf180mcu_as_sc_mcu7t3v3__nand3_2_22 gf180mcu_as_sc_mcu7t3v3__nand3_2_31/VDD gf180mcu_as_sc_mcu7t3v3__nor2_2_8/VSS
+ VSS VSS VSS VSS gf180mcu_as_sc_mcu7t3v3__nand3_2_31/VNW VSUBS gf180mcu_as_sc_mcu7t3v3__nand3_2
Xgf180mcu_as_sc_mcu7t3v3__nand3_2_11 gf180mcu_as_sc_mcu7t3v3__nand3_2_5/VDD gf180mcu_as_sc_mcu7t3v3__nor2_2_6/VSS
+ VSS VSS VSS VSS gf180mcu_as_sc_mcu7t3v3__nand3_2_5/VNW VSUBS gf180mcu_as_sc_mcu7t3v3__nand3_2
Xgf180mcu_as_sc_mcu7t3v3__inv_2_1631 gf180mcu_as_sc_mcu7t3v3__inv_2_1671/VDD gf180mcu_as_sc_mcu7t3v3__inv_2_1672/VDD
+ gf180mcu_as_sc_mcu7t3v3__inv_2_1631/Y gf180mcu_as_sc_mcu7t3v3__inv_2_1675/Y gf180mcu_as_sc_mcu7t3v3__inv_2_1671/VNW
+ VSUBS gf180mcu_as_sc_mcu7t3v3__inv_2
Xgf180mcu_as_sc_mcu7t3v3__inv_2_1642 gf180mcu_as_sc_mcu7t3v3__inv_2_1675/VDD VSS VSS
+ gf180mcu_as_sc_mcu7t3v3__inv_2_1675/Y gf180mcu_as_sc_mcu7t3v3__inv_2_1675/VNW VSUBS
+ gf180mcu_as_sc_mcu7t3v3__inv_2
Xgf180mcu_as_sc_mcu7t3v3__inv_2_1620 gf180mcu_as_sc_mcu7t3v3__inv_2_1665/VDD VSS VSS
+ gf180mcu_as_sc_mcu7t3v3__inv_2_1682/Y gf180mcu_as_sc_mcu7t3v3__inv_2_1665/VNW VSUBS
+ gf180mcu_as_sc_mcu7t3v3__inv_2
Xgf180mcu_as_sc_mcu7t3v3__inv_2_1653 gf180mcu_as_sc_mcu7t3v3__inv_2_1653/VDD gf180mcu_as_sc_mcu7t3v3__inv_2_1654/VDD
+ gf180mcu_as_sc_mcu7t3v3__inv_2_1682/Y VSS gf180mcu_as_sc_mcu7t3v3__inv_2_1653/VNW
+ VSUBS gf180mcu_as_sc_mcu7t3v3__inv_2
Xgf180mcu_as_sc_mcu7t3v3__inv_2_1675 gf180mcu_as_sc_mcu7t3v3__inv_2_1675/VDD VSS gf180mcu_as_sc_mcu7t3v3__inv_2_1675/Y
+ VSS gf180mcu_as_sc_mcu7t3v3__inv_2_1675/VNW VSUBS gf180mcu_as_sc_mcu7t3v3__inv_2
Xgf180mcu_as_sc_mcu7t3v3__inv_2_1664 gf180mcu_as_sc_mcu7t3v3__inv_2_1682/VSS gf180mcu_as_sc_mcu7t3v3__inv_2_1665/VDD
+ gf180mcu_as_sc_mcu7t3v3__inv_2_1682/Y VSS gf180mcu_as_sc_mcu7t3v3__inv_2_1664/VNW
+ VSUBS gf180mcu_as_sc_mcu7t3v3__inv_2
Xgf180mcu_as_sc_mcu7t3v3__inv_2_1686 gf180mcu_as_sc_mcu7t3v3__inv_2_1688/VDD VSS VSS
+ VSS gf180mcu_as_sc_mcu7t3v3__inv_2_1688/VNW VSUBS gf180mcu_as_sc_mcu7t3v3__inv_2
Xgf180mcu_as_sc_mcu7t3v3__inv_2_1697 VSS VSS gf180mcu_as_sc_mcu7t3v3__inv_2_1697/Y
+ VSS gf180mcu_as_sc_mcu7t3v3__inv_2_1697/VNW VSUBS gf180mcu_as_sc_mcu7t3v3__inv_2
Xu_t030_024 u_t030_024/c0_w0_bl u_t030_024/c0_w0_br u_t030_024/c0_w1_bl u_t030_024/c0_w1_br
+ u_t030_024/c0_r0_rbl u_t030_024/c0_r1_rbl u_t030_024/c1_w0_bl u_t030_024/c1_w0_br
+ u_t030_024/c1_w1_bl u_t030_024/c1_w1_br u_t030_024/c1_r0_rbl u_t030_024/c1_r1_rbl
+ u_t030_024/c2_w0_bl u_t030_024/c2_w0_br u_t030_024/c2_w1_bl u_t030_024/c2_w1_br
+ u_t030_024/c2_r0_rbl u_t030_024/c2_r1_rbl u_t030_024/c3_w0_bl u_t030_024/c3_w0_br
+ u_t030_024/c3_w1_bl u_t030_024/c3_w1_br u_t030_024/c3_r0_rbl u_t030_024/c3_r1_rbl
+ u_t030_024/r0_w0_wl u_t030_024/r0_w1_wl u_t030_024/r0_r0_rwl u_t030_024/r0_r1_rwl
+ u_t030_024/r1_w0_wl u_t030_024/r1_w1_wl u_t030_024/r1_r0_rwl u_t030_024/r1_r1_rwl
+ u_t030_024/r2_w0_wl u_t030_024/r2_w1_wl u_t030_024/r2_r0_rwl u_t030_024/r2_r1_rwl
+ u_t030_024/r3_w0_wl u_t030_024/r3_w1_wl u_t030_024/r3_r0_rwl u_t030_024/r3_r1_rwl
+ VSS u_t030_031/VSS VSUBS detronyx_12t_2w2r_rc4_4x4_routed_5layer_direct
Xu_t015_021 u_t015_021/c0_w0_bl u_t015_021/c0_w0_br u_t015_021/c0_w1_bl u_t015_021/c0_w1_br
+ u_t015_021/c0_r0_rbl u_t015_021/c0_r1_rbl u_t015_021/c1_w0_bl u_t015_021/c1_w0_br
+ u_t015_021/c1_w1_bl u_t015_021/c1_w1_br u_t015_021/c1_r0_rbl u_t015_021/c1_r1_rbl
+ u_t015_021/c2_w0_bl u_t015_021/c2_w0_br u_t015_021/c2_w1_bl u_t015_021/c2_w1_br
+ u_t015_021/c2_r0_rbl u_t015_021/c2_r1_rbl u_t015_021/c3_w0_bl u_t015_021/c3_w0_br
+ u_t015_021/c3_w1_bl u_t015_021/c3_w1_br u_t015_021/c3_r0_rbl u_t015_021/c3_r1_rbl
+ u_t015_021/r0_w0_wl u_t015_021/r0_w1_wl u_t015_021/r0_r0_rwl u_t015_021/r0_r1_rwl
+ u_t015_021/r1_w0_wl u_t015_021/r1_w1_wl u_t015_021/r1_r0_rwl u_t015_021/r1_r1_rwl
+ u_t015_021/r2_w0_wl u_t015_021/r2_w1_wl u_t015_021/r2_r0_rwl u_t015_021/r2_r1_rwl
+ u_t015_021/r3_w0_wl u_t015_021/r3_w1_wl u_t015_021/r3_r0_rwl u_t015_021/r3_r1_rwl
+ u_t015_021/VDD u_t015_024/VSS VSUBS detronyx_12t_2w2r_rc4_4x4_routed_5layer_direct
Xu_t030_013 u_t030_013/c0_w0_bl u_t030_013/c0_w0_br u_t030_013/c0_w1_bl u_t030_013/c0_w1_br
+ u_t030_013/c0_r0_rbl u_t030_013/c0_r1_rbl u_t030_013/c1_w0_bl u_t030_013/c1_w0_br
+ u_t030_013/c1_w1_bl u_t030_013/c1_w1_br u_t030_013/c1_r0_rbl u_t030_013/c1_r1_rbl
+ u_t030_013/c2_w0_bl u_t030_013/c2_w0_br u_t030_013/c2_w1_bl u_t030_013/c2_w1_br
+ u_t030_013/c2_r0_rbl u_t030_013/c2_r1_rbl u_t030_013/c3_w0_bl u_t030_013/c3_w0_br
+ u_t030_013/c3_w1_bl u_t030_013/c3_w1_br u_t030_013/c3_r0_rbl u_t030_013/c3_r1_rbl
+ u_t030_013/r0_w0_wl u_t030_013/r0_w1_wl u_t030_013/r0_r0_rwl u_t030_013/r0_r1_rwl
+ u_t030_013/r1_w0_wl u_t030_013/r1_w1_wl u_t030_013/r1_r0_rwl u_t030_013/r1_r1_rwl
+ u_t030_013/r2_w0_wl u_t030_013/r2_w1_wl u_t030_013/r2_r0_rwl u_t030_013/r2_r1_rwl
+ u_t030_013/r3_w0_wl u_t030_013/r3_w1_wl u_t030_013/r3_r0_rwl u_t030_013/r3_r1_rwl
+ u_t030_013/VDD u_t030_031/VSS VSUBS detronyx_12t_2w2r_rc4_4x4_routed_5layer_direct
Xu_t015_010 u_t015_010/c0_w0_bl u_t015_010/c0_w0_br u_t015_010/c0_w1_bl u_t015_010/c0_w1_br
+ u_t015_010/c0_r0_rbl u_t015_010/c0_r1_rbl u_t015_010/c1_w0_bl u_t015_010/c1_w0_br
+ u_t015_010/c1_w1_bl u_t015_010/c1_w1_br u_t015_010/c1_r0_rbl u_t015_010/c1_r1_rbl
+ u_t015_010/c2_w0_bl u_t015_010/c2_w0_br u_t015_010/c2_w1_bl u_t015_010/c2_w1_br
+ u_t015_010/c2_r0_rbl u_t015_010/c2_r1_rbl u_t015_010/c3_w0_bl u_t015_010/c3_w0_br
+ u_t015_010/c3_w1_bl u_t015_010/c3_w1_br u_t015_010/c3_r0_rbl u_t015_010/c3_r1_rbl
+ u_t015_010/r0_w0_wl u_t015_010/r0_w1_wl u_t015_010/r0_r0_rwl u_t015_010/r0_r1_rwl
+ u_t015_010/r1_w0_wl u_t015_010/r1_w1_wl u_t015_010/r1_r0_rwl u_t015_010/r1_r1_rwl
+ u_t015_010/r2_w0_wl u_t015_010/r2_w1_wl u_t015_010/r2_r0_rwl u_t015_010/r2_r1_rwl
+ u_t015_010/r3_w0_wl u_t015_010/r3_w1_wl u_t015_010/r3_r0_rwl u_t015_010/r3_r1_rwl
+ VSS u_t015_010/VSS VSUBS detronyx_12t_2w2r_rc4_4x4_routed_5layer_direct
Xu_t030_002 u_t030_002/c0_w0_bl u_t030_002/c0_w0_br u_t030_002/c0_w1_bl u_t030_002/c0_w1_br
+ u_t030_002/c0_r0_rbl u_t030_002/c0_r1_rbl u_t030_002/c1_w0_bl u_t030_002/c1_w0_br
+ u_t030_002/c1_w1_bl u_t030_002/c1_w1_br u_t030_002/c1_r0_rbl u_t030_002/c1_r1_rbl
+ u_t030_002/c2_w0_bl u_t030_002/c2_w0_br u_t030_002/c2_w1_bl u_t030_002/c2_w1_br
+ u_t030_002/c2_r0_rbl u_t030_002/c2_r1_rbl u_t030_002/c3_w0_bl u_t030_002/c3_w0_br
+ u_t030_002/c3_w1_bl u_t030_002/c3_w1_br u_t030_002/c3_r0_rbl u_t030_002/c3_r1_rbl
+ u_t030_002/r0_w0_wl u_t030_002/r0_w1_wl u_t030_002/r0_r0_rwl u_t030_002/r0_r1_rwl
+ u_t030_002/r1_w0_wl u_t030_002/r1_w1_wl u_t030_002/r1_r0_rwl u_t030_002/r1_r1_rwl
+ u_t030_002/r2_w0_wl u_t030_002/r2_w1_wl u_t030_002/r2_r0_rwl u_t030_002/r2_r1_rwl
+ u_t030_002/r3_w0_wl u_t030_002/r3_w1_wl u_t030_002/r3_r0_rwl u_t030_002/r3_r1_rwl
+ VSS u_t030_031/VSS VSUBS detronyx_12t_2w2r_rc4_4x4_routed_5layer_direct
Xgf180mcu_as_sc_mcu7t3v3__nand4_2_458 gf180mcu_as_sc_mcu7t3v3__inv_2_1581/VDD VSS
+ VSS VSS VSS VSS VSS gf180mcu_as_sc_mcu7t3v3__inv_2_1581/VNW VSUBS gf180mcu_as_sc_mcu7t3v3__nand4_2
Xgf180mcu_as_sc_mcu7t3v3__nand4_2_469 VSS gf180mcu_as_sc_mcu7t3v3__inv_2_1551/VDD
+ VSS VSS VSS VSS gf180mcu_as_sc_mcu7t3v3__nand4_2_469/Y gf180mcu_as_sc_mcu7t3v3__inv_2_1547/VNW
+ VSUBS gf180mcu_as_sc_mcu7t3v3__nand4_2
Xgf180mcu_as_sc_mcu7t3v3__nand4_2_447 VSS gf180mcu_as_sc_mcu7t3v3__inv_2_1485/VSS
+ VSS VSS VSS VSS VSS gf180mcu_as_sc_mcu7t3v3__inv_2_1485/VNW VSUBS gf180mcu_as_sc_mcu7t3v3__nand4_2
Xgf180mcu_as_sc_mcu7t3v3__nand4_2_436 VSS gf180mcu_as_sc_mcu7t3v3__inv_2_1492/VDD
+ VSS VSS VSS VSS gf180mcu_as_sc_mcu7t3v3__nand4_2_436/Y gf180mcu_as_sc_mcu7t3v3__inv_2_1488/VNW
+ VSUBS gf180mcu_as_sc_mcu7t3v3__nand4_2
Xgf180mcu_as_sc_mcu7t3v3__nand4_2_425 gf180mcu_as_sc_mcu7t3v3__inv_2_1444/VDD VSS
+ VSS VSS VSS VSS gf180mcu_as_sc_mcu7t3v3__nand4_2_425/Y gf180mcu_as_sc_mcu7t3v3__inv_2_1444/VNW
+ VSUBS gf180mcu_as_sc_mcu7t3v3__nand4_2
Xgf180mcu_as_sc_mcu7t3v3__nand4_2_414 gf180mcu_as_sc_mcu7t3v3__inv_2_1502/VDD gf180mcu_as_sc_mcu7t3v3__inv_2_1502/VSS
+ VSS VSS VSS VSS gf180mcu_as_sc_mcu7t3v3__nand4_2_414/Y gf180mcu_as_sc_mcu7t3v3__inv_2_1502/VNW
+ VSUBS gf180mcu_as_sc_mcu7t3v3__nand4_2
Xgf180mcu_as_sc_mcu7t3v3__nand4_2_403 gf180mcu_as_sc_mcu7t3v3__inv_2_1393/VDD gf180mcu_as_sc_mcu7t3v3__inv_2_1394/VDD
+ VSS VSS VSS VSS VSS gf180mcu_as_sc_mcu7t3v3__inv_2_1393/VNW VSUBS gf180mcu_as_sc_mcu7t3v3__nand4_2
Xu_t006_021 u_t006_021/c0_w0_bl u_t006_021/c0_w0_br u_t006_021/c0_w1_bl u_t006_021/c0_w1_br
+ u_t006_021/c0_r0_rbl u_t006_021/c0_r1_rbl u_t006_021/c1_w0_bl u_t006_021/c1_w0_br
+ u_t006_021/c1_w1_bl u_t006_021/c1_w1_br u_t006_021/c1_r0_rbl u_t006_021/c1_r1_rbl
+ u_t006_021/c2_w0_bl u_t006_021/c2_w0_br u_t006_021/c2_w1_bl u_t006_021/c2_w1_br
+ u_t006_021/c2_r0_rbl u_t006_021/c2_r1_rbl u_t006_021/c3_w0_bl u_t006_021/c3_w0_br
+ u_t006_021/c3_w1_bl u_t006_021/c3_w1_br u_t006_021/c3_r0_rbl u_t006_021/c3_r1_rbl
+ u_t006_021/r0_w0_wl u_t006_021/r0_w1_wl u_t006_021/r0_r0_rwl u_t006_021/r0_r1_rwl
+ u_t006_021/r1_w0_wl u_t006_021/r1_w1_wl u_t006_021/r1_r0_rwl u_t006_021/r1_r1_rwl
+ u_t006_021/r2_w0_wl u_t006_021/r2_w1_wl u_t006_021/r2_r0_rwl u_t006_021/r2_r1_rwl
+ u_t006_021/r3_w0_wl u_t006_021/r3_w1_wl u_t006_021/r3_r0_rwl u_t006_021/r3_r1_rwl
+ u_t006_021/VDD u_t006_024/VSS VSUBS detronyx_12t_2w2r_rc4_4x4_routed_5layer_direct
Xu_t006_010 u_t006_010/c0_w0_bl u_t006_010/c0_w0_br u_t006_010/c0_w1_bl u_t006_010/c0_w1_br
+ u_t006_010/c0_r0_rbl u_t006_010/c0_r1_rbl u_t006_010/c1_w0_bl u_t006_010/c1_w0_br
+ u_t006_010/c1_w1_bl u_t006_010/c1_w1_br u_t006_010/c1_r0_rbl u_t006_010/c1_r1_rbl
+ u_t006_010/c2_w0_bl u_t006_010/c2_w0_br u_t006_010/c2_w1_bl u_t006_010/c2_w1_br
+ u_t006_010/c2_r0_rbl u_t006_010/c2_r1_rbl u_t006_010/c3_w0_bl u_t006_010/c3_w0_br
+ u_t006_010/c3_w1_bl u_t006_010/c3_w1_br u_t006_010/c3_r0_rbl u_t006_010/c3_r1_rbl
+ u_t006_010/r0_w0_wl u_t006_010/r0_w1_wl u_t006_010/r0_r0_rwl u_t006_010/r0_r1_rwl
+ u_t006_010/r1_w0_wl u_t006_010/r1_w1_wl u_t006_010/r1_r0_rwl u_t006_010/r1_r1_rwl
+ u_t006_010/r2_w0_wl u_t006_010/r2_w1_wl u_t006_010/r2_r0_rwl u_t006_010/r2_r1_rwl
+ u_t006_010/r3_w0_wl u_t006_010/r3_w1_wl u_t006_010/r3_r0_rwl u_t006_010/r3_r1_rwl
+ VSS u_t006_010/VSS VSUBS detronyx_12t_2w2r_rc4_4x4_routed_5layer_direct
Xgf180mcu_as_sc_mcu7t3v3__inv_2_4 gf180mcu_as_sc_mcu7t3v3__inv_2_6/VSS gf180mcu_as_sc_mcu7t3v3__inv_2_8/VDD
+ gf180mcu_as_sc_mcu7t3v3__inv_2_4/Y gf180mcu_as_sc_mcu7t3v3__inv_2_8/A gf180mcu_as_sc_mcu7t3v3__inv_2_4/VNW
+ VSUBS gf180mcu_as_sc_mcu7t3v3__inv_2
Xu_t021_024 u_t021_024/c0_w0_bl u_t021_024/c0_w0_br u_t021_024/c0_w1_bl u_t021_024/c0_w1_br
+ u_t021_024/c0_r0_rbl u_t021_024/c0_r1_rbl u_t021_024/c1_w0_bl u_t021_024/c1_w0_br
+ u_t021_024/c1_w1_bl u_t021_024/c1_w1_br u_t021_024/c1_r0_rbl u_t021_024/c1_r1_rbl
+ u_t021_024/c2_w0_bl u_t021_024/c2_w0_br u_t021_024/c2_w1_bl u_t021_024/c2_w1_br
+ u_t021_024/c2_r0_rbl u_t021_024/c2_r1_rbl u_t021_024/c3_w0_bl u_t021_024/c3_w0_br
+ u_t021_024/c3_w1_bl u_t021_024/c3_w1_br u_t021_024/c3_r0_rbl u_t021_024/c3_r1_rbl
+ u_t021_024/r0_w0_wl u_t021_024/r0_w1_wl u_t021_024/r0_r0_rwl u_t021_024/r0_r1_rwl
+ u_t021_024/r1_w0_wl u_t021_024/r1_w1_wl u_t021_024/r1_r0_rwl u_t021_024/r1_r1_rwl
+ u_t021_024/r2_w0_wl u_t021_024/r2_w1_wl u_t021_024/r2_r0_rwl u_t021_024/r2_r1_rwl
+ u_t021_024/r3_w0_wl u_t021_024/r3_w1_wl u_t021_024/r3_r0_rwl u_t021_024/r3_r1_rwl
+ VSS u_t021_031/VSS VSUBS detronyx_12t_2w2r_rc4_4x4_routed_5layer_direct
Xu_t021_013 u_t021_013/c0_w0_bl u_t021_013/c0_w0_br u_t021_013/c0_w1_bl u_t021_013/c0_w1_br
+ u_t021_013/c0_r0_rbl u_t021_013/c0_r1_rbl u_t021_013/c1_w0_bl u_t021_013/c1_w0_br
+ u_t021_013/c1_w1_bl u_t021_013/c1_w1_br u_t021_013/c1_r0_rbl u_t021_013/c1_r1_rbl
+ u_t021_013/c2_w0_bl u_t021_013/c2_w0_br u_t021_013/c2_w1_bl u_t021_013/c2_w1_br
+ u_t021_013/c2_r0_rbl u_t021_013/c2_r1_rbl u_t021_013/c3_w0_bl u_t021_013/c3_w0_br
+ u_t021_013/c3_w1_bl u_t021_013/c3_w1_br u_t021_013/c3_r0_rbl u_t021_013/c3_r1_rbl
+ u_t021_013/r0_w0_wl u_t021_013/r0_w1_wl u_t021_013/r0_r0_rwl u_t021_013/r0_r1_rwl
+ u_t021_013/r1_w0_wl u_t021_013/r1_w1_wl u_t021_013/r1_r0_rwl u_t021_013/r1_r1_rwl
+ u_t021_013/r2_w0_wl u_t021_013/r2_w1_wl u_t021_013/r2_r0_rwl u_t021_013/r2_r1_rwl
+ u_t021_013/r3_w0_wl u_t021_013/r3_w1_wl u_t021_013/r3_r0_rwl u_t021_013/r3_r1_rwl
+ u_t021_013/VDD u_t021_031/VSS VSUBS detronyx_12t_2w2r_rc4_4x4_routed_5layer_direct
Xu_t021_002 u_t021_002/c0_w0_bl u_t021_002/c0_w0_br u_t021_002/c0_w1_bl u_t021_002/c0_w1_br
+ u_t021_002/c0_r0_rbl u_t021_002/c0_r1_rbl u_t021_002/c1_w0_bl u_t021_002/c1_w0_br
+ u_t021_002/c1_w1_bl u_t021_002/c1_w1_br u_t021_002/c1_r0_rbl u_t021_002/c1_r1_rbl
+ u_t021_002/c2_w0_bl u_t021_002/c2_w0_br u_t021_002/c2_w1_bl u_t021_002/c2_w1_br
+ u_t021_002/c2_r0_rbl u_t021_002/c2_r1_rbl u_t021_002/c3_w0_bl u_t021_002/c3_w0_br
+ u_t021_002/c3_w1_bl u_t021_002/c3_w1_br u_t021_002/c3_r0_rbl u_t021_002/c3_r1_rbl
+ u_t021_002/r0_w0_wl u_t021_002/r0_w1_wl u_t021_002/r0_r0_rwl u_t021_002/r0_r1_rwl
+ u_t021_002/r1_w0_wl u_t021_002/r1_w1_wl u_t021_002/r1_r0_rwl u_t021_002/r1_r1_rwl
+ u_t021_002/r2_w0_wl u_t021_002/r2_w1_wl u_t021_002/r2_r0_rwl u_t021_002/r2_r1_rwl
+ u_t021_002/r3_w0_wl u_t021_002/r3_w1_wl u_t021_002/r3_r0_rwl u_t021_002/r3_r1_rwl
+ VSS u_t021_031/VSS VSUBS detronyx_12t_2w2r_rc4_4x4_routed_5layer_direct
Xu_t012_024 u_t012_024/c0_w0_bl u_t012_024/c0_w0_br u_t012_024/c0_w1_bl u_t012_024/c0_w1_br
+ u_t012_024/c0_r0_rbl u_t012_024/c0_r1_rbl u_t012_024/c1_w0_bl u_t012_024/c1_w0_br
+ u_t012_024/c1_w1_bl u_t012_024/c1_w1_br u_t012_024/c1_r0_rbl u_t012_024/c1_r1_rbl
+ u_t012_024/c2_w0_bl u_t012_024/c2_w0_br u_t012_024/c2_w1_bl u_t012_024/c2_w1_br
+ u_t012_024/c2_r0_rbl u_t012_024/c2_r1_rbl u_t012_024/c3_w0_bl u_t012_024/c3_w0_br
+ u_t012_024/c3_w1_bl u_t012_024/c3_w1_br u_t012_024/c3_r0_rbl u_t012_024/c3_r1_rbl
+ u_t012_024/r0_w0_wl u_t012_024/r0_w1_wl u_t012_024/r0_r0_rwl u_t012_024/r0_r1_rwl
+ u_t012_024/r1_w0_wl u_t012_024/r1_w1_wl u_t012_024/r1_r0_rwl u_t012_024/r1_r1_rwl
+ u_t012_024/r2_w0_wl u_t012_024/r2_w1_wl u_t012_024/r2_r0_rwl u_t012_024/r2_r1_rwl
+ u_t012_024/r3_w0_wl u_t012_024/r3_w1_wl u_t012_024/r3_r0_rwl u_t012_024/r3_r1_rwl
+ VSS u_t012_031/VSS VSUBS detronyx_12t_2w2r_rc4_4x4_routed_5layer_direct
Xu_t012_013 u_t012_013/c0_w0_bl u_t012_013/c0_w0_br u_t012_013/c0_w1_bl u_t012_013/c0_w1_br
+ u_t012_013/c0_r0_rbl u_t012_013/c0_r1_rbl u_t012_013/c1_w0_bl u_t012_013/c1_w0_br
+ u_t012_013/c1_w1_bl u_t012_013/c1_w1_br u_t012_013/c1_r0_rbl u_t012_013/c1_r1_rbl
+ u_t012_013/c2_w0_bl u_t012_013/c2_w0_br u_t012_013/c2_w1_bl u_t012_013/c2_w1_br
+ u_t012_013/c2_r0_rbl u_t012_013/c2_r1_rbl u_t012_013/c3_w0_bl u_t012_013/c3_w0_br
+ u_t012_013/c3_w1_bl u_t012_013/c3_w1_br u_t012_013/c3_r0_rbl u_t012_013/c3_r1_rbl
+ u_t012_013/r0_w0_wl u_t012_013/r0_w1_wl u_t012_013/r0_r0_rwl u_t012_013/r0_r1_rwl
+ u_t012_013/r1_w0_wl u_t012_013/r1_w1_wl u_t012_013/r1_r0_rwl u_t012_013/r1_r1_rwl
+ u_t012_013/r2_w0_wl u_t012_013/r2_w1_wl u_t012_013/r2_r0_rwl u_t012_013/r2_r1_rwl
+ u_t012_013/r3_w0_wl u_t012_013/r3_w1_wl u_t012_013/r3_r0_rwl u_t012_013/r3_r1_rwl
+ u_t012_013/VDD u_t012_031/VSS VSUBS detronyx_12t_2w2r_rc4_4x4_routed_5layer_direct
Xu_t012_002 u_t012_002/c0_w0_bl u_t012_002/c0_w0_br u_t012_002/c0_w1_bl u_t012_002/c0_w1_br
+ u_t012_002/c0_r0_rbl u_t012_002/c0_r1_rbl u_t012_002/c1_w0_bl u_t012_002/c1_w0_br
+ u_t012_002/c1_w1_bl u_t012_002/c1_w1_br u_t012_002/c1_r0_rbl u_t012_002/c1_r1_rbl
+ u_t012_002/c2_w0_bl u_t012_002/c2_w0_br u_t012_002/c2_w1_bl u_t012_002/c2_w1_br
+ u_t012_002/c2_r0_rbl u_t012_002/c2_r1_rbl u_t012_002/c3_w0_bl u_t012_002/c3_w0_br
+ u_t012_002/c3_w1_bl u_t012_002/c3_w1_br u_t012_002/c3_r0_rbl u_t012_002/c3_r1_rbl
+ u_t012_002/r0_w0_wl u_t012_002/r0_w1_wl u_t012_002/r0_r0_rwl u_t012_002/r0_r1_rwl
+ u_t012_002/r1_w0_wl u_t012_002/r1_w1_wl u_t012_002/r1_r0_rwl u_t012_002/r1_r1_rwl
+ u_t012_002/r2_w0_wl u_t012_002/r2_w1_wl u_t012_002/r2_r0_rwl u_t012_002/r2_r1_rwl
+ u_t012_002/r3_w0_wl u_t012_002/r3_w1_wl u_t012_002/r3_r0_rwl u_t012_002/r3_r1_rwl
+ VSS u_t012_031/VSS VSUBS detronyx_12t_2w2r_rc4_4x4_routed_5layer_direct
Xgf180mcu_as_sc_mcu7t3v3__inv_2_1450 VSS gf180mcu_as_sc_mcu7t3v3__inv_2_1485/VSS VSS
+ VSS gf180mcu_as_sc_mcu7t3v3__inv_2_1485/VNW VSUBS gf180mcu_as_sc_mcu7t3v3__inv_2
Xgf180mcu_as_sc_mcu7t3v3__inv_2_1472 VSS VSS VSS VSS gf180mcu_as_sc_mcu7t3v3__inv_2_1472/VNW
+ VSUBS gf180mcu_as_sc_mcu7t3v3__inv_2
Xgf180mcu_as_sc_mcu7t3v3__inv_2_1483 VSS VSS VSS VSS gf180mcu_as_sc_mcu7t3v3__inv_2_1484/VNW
+ VSUBS gf180mcu_as_sc_mcu7t3v3__inv_2
Xgf180mcu_as_sc_mcu7t3v3__inv_2_1494 gf180mcu_as_sc_mcu7t3v3__inv_2_1496/VDD VSS VSS
+ VSS gf180mcu_as_sc_mcu7t3v3__inv_2_1496/VNW VSUBS gf180mcu_as_sc_mcu7t3v3__inv_2
Xgf180mcu_as_sc_mcu7t3v3__inv_2_1461 VSS gf180mcu_as_sc_mcu7t3v3__inv_2_1502/VDD VSS
+ VSS gf180mcu_as_sc_mcu7t3v3__inv_2_1461/VNW VSUBS gf180mcu_as_sc_mcu7t3v3__inv_2
Xgf180mcu_as_sc_mcu7t3v3__inv_2_945 VSS VSS VSS VSS gf180mcu_as_sc_mcu7t3v3__inv_2_945/VNW
+ VSUBS gf180mcu_as_sc_mcu7t3v3__inv_2
Xgf180mcu_as_sc_mcu7t3v3__inv_2_923 VSS VSS VSS VSS gf180mcu_as_sc_mcu7t3v3__inv_2_924/VNW
+ VSUBS gf180mcu_as_sc_mcu7t3v3__inv_2
Xgf180mcu_as_sc_mcu7t3v3__inv_2_934 VSS VSS VSS VSS gf180mcu_as_sc_mcu7t3v3__inv_2_936/VNW
+ VSUBS gf180mcu_as_sc_mcu7t3v3__inv_2
Xgf180mcu_as_sc_mcu7t3v3__inv_2_901 VSS VSS gf180mcu_as_sc_mcu7t3v3__inv_2_901/Y VSS
+ gf180mcu_as_sc_mcu7t3v3__inv_2_951/VNW VSUBS gf180mcu_as_sc_mcu7t3v3__inv_2
Xgf180mcu_as_sc_mcu7t3v3__inv_2_912 VSS VSS VSS VSS gf180mcu_as_sc_mcu7t3v3__inv_2_913/VNW
+ VSUBS gf180mcu_as_sc_mcu7t3v3__inv_2
Xu_t003_024 u_t003_024/c0_w0_bl u_t003_024/c0_w0_br u_t003_024/c0_w1_bl u_t003_024/c0_w1_br
+ u_t003_024/c0_r0_rbl u_t003_024/c0_r1_rbl u_t003_024/c1_w0_bl u_t003_024/c1_w0_br
+ u_t003_024/c1_w1_bl u_t003_024/c1_w1_br u_t003_024/c1_r0_rbl u_t003_024/c1_r1_rbl
+ u_t003_024/c2_w0_bl u_t003_024/c2_w0_br u_t003_024/c2_w1_bl u_t003_024/c2_w1_br
+ u_t003_024/c2_r0_rbl u_t003_024/c2_r1_rbl u_t003_024/c3_w0_bl u_t003_024/c3_w0_br
+ u_t003_024/c3_w1_bl u_t003_024/c3_w1_br u_t003_024/c3_r0_rbl u_t003_024/c3_r1_rbl
+ u_t003_024/r0_w0_wl u_t003_024/r0_w1_wl u_t003_024/r0_r0_rwl u_t003_024/r0_r1_rwl
+ u_t003_024/r1_w0_wl u_t003_024/r1_w1_wl u_t003_024/r1_r0_rwl u_t003_024/r1_r1_rwl
+ u_t003_024/r2_w0_wl u_t003_024/r2_w1_wl u_t003_024/r2_r0_rwl u_t003_024/r2_r1_rwl
+ u_t003_024/r3_w0_wl u_t003_024/r3_w1_wl u_t003_024/r3_r0_rwl u_t003_024/r3_r1_rwl
+ VSS u_t003_024/VSS VSUBS detronyx_12t_2w2r_rc4_4x4_routed_5layer_direct
Xu_t003_013 u_t003_013/c0_w0_bl u_t003_013/c0_w0_br u_t003_013/c0_w1_bl u_t003_013/c0_w1_br
+ u_t003_013/c0_r0_rbl u_t003_013/c0_r1_rbl u_t003_013/c1_w0_bl u_t003_013/c1_w0_br
+ u_t003_013/c1_w1_bl u_t003_013/c1_w1_br u_t003_013/c1_r0_rbl u_t003_013/c1_r1_rbl
+ u_t003_013/c2_w0_bl u_t003_013/c2_w0_br u_t003_013/c2_w1_bl u_t003_013/c2_w1_br
+ u_t003_013/c2_r0_rbl u_t003_013/c2_r1_rbl u_t003_013/c3_w0_bl u_t003_013/c3_w0_br
+ u_t003_013/c3_w1_bl u_t003_013/c3_w1_br u_t003_013/c3_r0_rbl u_t003_013/c3_r1_rbl
+ u_t003_013/r0_w0_wl u_t003_013/r0_w1_wl u_t003_013/r0_r0_rwl u_t003_013/r0_r1_rwl
+ u_t003_013/r1_w0_wl u_t003_013/r1_w1_wl u_t003_013/r1_r0_rwl u_t003_013/r1_r1_rwl
+ u_t003_013/r2_w0_wl u_t003_013/r2_w1_wl u_t003_013/r2_r0_rwl u_t003_013/r2_r1_rwl
+ u_t003_013/r3_w0_wl u_t003_013/r3_w1_wl u_t003_013/r3_r0_rwl u_t003_013/r3_r1_rwl
+ u_t004_013/VDD u_t003_013/VSS VSUBS detronyx_12t_2w2r_rc4_4x4_routed_5layer_direct
Xu_t003_002 u_t003_002/c0_w0_bl u_t003_002/c0_w0_br u_t003_002/c0_w1_bl u_t003_002/c0_w1_br
+ u_t003_002/c0_r0_rbl u_t003_002/c0_r1_rbl u_t003_002/c1_w0_bl u_t003_002/c1_w0_br
+ u_t003_002/c1_w1_bl u_t003_002/c1_w1_br u_t003_002/c1_r0_rbl u_t003_002/c1_r1_rbl
+ u_t003_002/c2_w0_bl u_t003_002/c2_w0_br u_t003_002/c2_w1_bl u_t003_002/c2_w1_br
+ u_t003_002/c2_r0_rbl u_t003_002/c2_r1_rbl u_t003_002/c3_w0_bl u_t003_002/c3_w0_br
+ u_t003_002/c3_w1_bl u_t003_002/c3_w1_br u_t003_002/c3_r0_rbl u_t003_002/c3_r1_rbl
+ u_t003_002/r0_w0_wl u_t003_002/r0_w1_wl u_t003_002/r0_r0_rwl u_t003_002/r0_r1_rwl
+ u_t003_002/r1_w0_wl u_t003_002/r1_w1_wl u_t003_002/r1_r0_rwl u_t003_002/r1_r1_rwl
+ u_t003_002/r2_w0_wl u_t003_002/r2_w1_wl u_t003_002/r2_r0_rwl u_t003_002/r2_r1_rwl
+ u_t003_002/r3_w0_wl u_t003_002/r3_w1_wl u_t003_002/r3_r0_rwl u_t003_002/r3_r1_rwl
+ VSS u_t003_002/VSS VSUBS detronyx_12t_2w2r_rc4_4x4_routed_5layer_direct
Xgf180mcu_as_sc_mcu7t3v3__inv_2_989 VSS gf180mcu_as_sc_mcu7t3v3__inv_2_990/VSS gf180mcu_as_sc_mcu7t3v3__inv_2_989/Y
+ gf180mcu_as_sc_mcu7t3v3__inv_2_990/Y gf180mcu_as_sc_mcu7t3v3__inv_2_990/VNW VSUBS
+ gf180mcu_as_sc_mcu7t3v3__inv_2
Xgf180mcu_as_sc_mcu7t3v3__inv_2_978 gf180mcu_as_sc_mcu7t3v3__inv_2_978/VDD gf180mcu_as_sc_mcu7t3v3__inv_2_982/VDD
+ gf180mcu_as_sc_mcu7t3v3__inv_2_978/Y VSS gf180mcu_as_sc_mcu7t3v3__inv_2_978/VNW
+ VSUBS gf180mcu_as_sc_mcu7t3v3__inv_2
Xgf180mcu_as_sc_mcu7t3v3__inv_2_956 gf180mcu_as_sc_mcu7t3v3__inv_2_987/VSS VSS VSS
+ gf180mcu_as_sc_mcu7t3v3__inv_2_991/A gf180mcu_as_sc_mcu7t3v3__inv_2_958/VNW VSUBS
+ gf180mcu_as_sc_mcu7t3v3__inv_2
Xgf180mcu_as_sc_mcu7t3v3__inv_2_967 gf180mcu_as_sc_mcu7t3v3__inv_2_967/VDD VSS gf180mcu_as_sc_mcu7t3v3__inv_2_967/Y
+ VSS gf180mcu_as_sc_mcu7t3v3__inv_2_967/VNW VSUBS gf180mcu_as_sc_mcu7t3v3__inv_2
Xgf180mcu_as_sc_mcu7t3v3__nand4_2_200 gf180mcu_as_sc_mcu7t3v3__inv_2_679/VDD gf180mcu_as_sc_mcu7t3v3__inv_2_849/VDD
+ VSS VSS VSS VSS VSS gf180mcu_as_sc_mcu7t3v3__inv_2_679/VNW VSUBS gf180mcu_as_sc_mcu7t3v3__nand4_2
Xgf180mcu_as_sc_mcu7t3v3__nand4_2_211 gf180mcu_as_sc_mcu7t3v3__inv_2_684/VSS VSS VSS
+ VSS VSS VSS VSS gf180mcu_as_sc_mcu7t3v3__inv_2_660/VNW VSUBS gf180mcu_as_sc_mcu7t3v3__nand4_2
Xgf180mcu_as_sc_mcu7t3v3__nand4_2_222 VSS VSS VSS VSS VSS VSS VSS gf180mcu_as_sc_mcu7t3v3__inv_2_780/VNW
+ VSUBS gf180mcu_as_sc_mcu7t3v3__nand4_2
Xgf180mcu_as_sc_mcu7t3v3__nand4_2_244 VSS VSS VSS VSS VSS VSS gf180mcu_as_sc_mcu7t3v3__nand4_2_244/Y
+ gf180mcu_as_sc_mcu7t3v3__inv_2_829/VNW VSUBS gf180mcu_as_sc_mcu7t3v3__nand4_2
Xgf180mcu_as_sc_mcu7t3v3__nand4_2_233 VSS VSS VSS VSS VSS VSS VSS gf180mcu_as_sc_mcu7t3v3__inv_2_824/VNW
+ VSUBS gf180mcu_as_sc_mcu7t3v3__nand4_2
Xgf180mcu_as_sc_mcu7t3v3__nand4_2_288 gf180mcu_as_sc_mcu7t3v3__inv_2_970/VDD VSS VSS
+ VSS VSS VSS VSS gf180mcu_as_sc_mcu7t3v3__inv_2_970/VNW VSUBS gf180mcu_as_sc_mcu7t3v3__nand4_2
Xgf180mcu_as_sc_mcu7t3v3__nand4_2_255 VSS VSS VSS VSS VSS VSS VSS gf180mcu_as_sc_mcu7t3v3__inv_2_872/VNW
+ VSUBS gf180mcu_as_sc_mcu7t3v3__nand4_2
Xgf180mcu_as_sc_mcu7t3v3__nand4_2_299 VSS gf180mcu_as_sc_mcu7t3v3__inv_2_999/VSS VSS
+ VSS VSS VSS VSS gf180mcu_as_sc_mcu7t3v3__inv_2_999/VNW VSUBS gf180mcu_as_sc_mcu7t3v3__nand4_2
Xgf180mcu_as_sc_mcu7t3v3__nand4_2_266 VSS VSS VSS VSS VSS VSS gf180mcu_as_sc_mcu7t3v3__nand4_2_266/Y
+ gf180mcu_as_sc_mcu7t3v3__inv_2_885/VNW VSUBS gf180mcu_as_sc_mcu7t3v3__nand4_2
Xgf180mcu_as_sc_mcu7t3v3__nand4_2_277 VSS VSS VSS VSS VSS VSS VSS gf180mcu_as_sc_mcu7t3v3__inv_2_909/VNW
+ VSUBS gf180mcu_as_sc_mcu7t3v3__nand4_2
Xgf180mcu_as_sc_mcu7t3v3__inv_2_208 gf180mcu_as_sc_mcu7t3v3__inv_2_228/VSS VSS VSS
+ VSS gf180mcu_as_sc_mcu7t3v3__inv_2_210/VNW VSUBS gf180mcu_as_sc_mcu7t3v3__inv_2
Xgf180mcu_as_sc_mcu7t3v3__inv_2_219 gf180mcu_as_sc_mcu7t3v3__inv_2_220/VDD VSS gf180mcu_as_sc_mcu7t3v3__inv_2_219/Y
+ VSS gf180mcu_as_sc_mcu7t3v3__inv_2_220/VNW VSUBS gf180mcu_as_sc_mcu7t3v3__inv_2
Xu_t000_027 u_t000_027/c0_w0_bl u_t000_027/c0_w0_br u_t000_027/c0_w1_bl u_t000_027/c0_w1_br
+ u_t000_027/c0_r0_rbl u_t000_027/c0_r1_rbl u_t000_027/c1_w0_bl u_t000_027/c1_w0_br
+ u_t000_027/c1_w1_bl u_t000_027/c1_w1_br u_t000_027/c1_r0_rbl u_t000_027/c1_r1_rbl
+ u_t000_027/c2_w0_bl u_t000_027/c2_w0_br u_t000_027/c2_w1_bl u_t000_027/c2_w1_br
+ u_t000_027/c2_r0_rbl u_t000_027/c2_r1_rbl u_t000_027/c3_w0_bl u_t000_027/c3_w0_br
+ u_t000_027/c3_w1_bl u_t000_027/c3_w1_br u_t000_027/c3_r0_rbl u_t000_027/c3_r1_rbl
+ u_t000_027/r0_w0_wl u_t000_027/r0_w1_wl u_t000_027/r0_r0_rwl u_t000_027/r0_r1_rwl
+ u_t000_027/r1_w0_wl u_t000_027/r1_w1_wl u_t000_027/r1_r0_rwl u_t000_027/r1_r1_rwl
+ u_t000_027/r2_w0_wl u_t000_027/r2_w1_wl u_t000_027/r2_r0_rwl u_t000_027/r2_r1_rwl
+ u_t000_027/r3_w0_wl u_t000_027/r3_w1_wl u_t000_027/r3_r0_rwl u_t000_027/r3_r1_rwl
+ u_t000_027/VDD u_t000_031/VSS VSUBS detronyx_12t_2w2r_rc4_4x4_routed_5layer_direct
Xu_t000_016 u_t000_016/c0_w0_bl u_t000_016/c0_w0_br u_t000_016/c0_w1_bl u_t000_016/c0_w1_br
+ u_t000_016/c0_r0_rbl u_t000_016/c0_r1_rbl u_t000_016/c1_w0_bl u_t000_016/c1_w0_br
+ u_t000_016/c1_w1_bl u_t000_016/c1_w1_br u_t000_016/c1_r0_rbl u_t000_016/c1_r1_rbl
+ u_t000_016/c2_w0_bl u_t000_016/c2_w0_br u_t000_016/c2_w1_bl u_t000_016/c2_w1_br
+ u_t000_016/c2_r0_rbl u_t000_016/c2_r1_rbl u_t000_016/c3_w0_bl u_t000_016/c3_w0_br
+ u_t000_016/c3_w1_bl u_t000_016/c3_w1_br u_t000_016/c3_r0_rbl u_t000_016/c3_r1_rbl
+ u_t000_016/r0_w0_wl u_t000_016/r0_w1_wl u_t000_016/r0_r0_rwl u_t000_016/r0_r1_rwl
+ u_t000_016/r1_w0_wl u_t000_016/r1_w1_wl u_t000_016/r1_r0_rwl u_t000_016/r1_r1_rwl
+ u_t000_016/r2_w0_wl u_t000_016/r2_w1_wl u_t000_016/r2_r0_rwl u_t000_016/r2_r1_rwl
+ u_t000_016/r3_w0_wl u_t000_016/r3_w1_wl u_t000_016/r3_r0_rwl u_t000_016/r3_r1_rwl
+ VSS u_t000_031/VSS VSUBS detronyx_12t_2w2r_rc4_4x4_routed_5layer_direct
Xu_t000_005 u_t000_005/c0_w0_bl u_t000_005/c0_w0_br u_t000_005/c0_w1_bl u_t000_005/c0_w1_br
+ u_t000_005/c0_r0_rbl u_t000_005/c0_r1_rbl u_t000_005/c1_w0_bl u_t000_005/c1_w0_br
+ u_t000_005/c1_w1_bl u_t000_005/c1_w1_br u_t000_005/c1_r0_rbl u_t000_005/c1_r1_rbl
+ u_t000_005/c2_w0_bl u_t000_005/c2_w0_br u_t000_005/c2_w1_bl u_t000_005/c2_w1_br
+ u_t000_005/c2_r0_rbl u_t000_005/c2_r1_rbl u_t000_005/c3_w0_bl u_t000_005/c3_w0_br
+ u_t000_005/c3_w1_bl u_t000_005/c3_w1_br u_t000_005/c3_r0_rbl u_t000_005/c3_r1_rbl
+ u_t000_005/r0_w0_wl u_t000_005/r0_w1_wl u_t000_005/r0_r0_rwl u_t000_005/r0_r1_rwl
+ u_t000_005/r1_w0_wl u_t000_005/r1_w1_wl u_t000_005/r1_r0_rwl u_t000_005/r1_r1_rwl
+ u_t000_005/r2_w0_wl u_t000_005/r2_w1_wl u_t000_005/r2_r0_rwl u_t000_005/r2_r1_rwl
+ u_t000_005/r3_w0_wl u_t000_005/r3_w1_wl u_t000_005/r3_r0_rwl u_t000_005/r3_r1_rwl
+ u_t000_005/VDD u_t000_031/VSS VSUBS detronyx_12t_2w2r_rc4_4x4_routed_5layer_direct
Xgf180mcu_as_sc_mcu7t3v3__inv_2_1280 VSS VSS VSS VSS gf180mcu_as_sc_mcu7t3v3__inv_2_1281/VNW
+ VSUBS gf180mcu_as_sc_mcu7t3v3__inv_2
Xgf180mcu_as_sc_mcu7t3v3__inv_2_1291 VSS VSS VSS VSS gf180mcu_as_sc_mcu7t3v3__inv_2_1292/VNW
+ VSUBS gf180mcu_as_sc_mcu7t3v3__inv_2
Xgf180mcu_as_sc_mcu7t3v3__inv_2_764 VSS VSS VSS VSS gf180mcu_as_sc_mcu7t3v3__inv_2_764/VNW
+ VSUBS gf180mcu_as_sc_mcu7t3v3__inv_2
Xgf180mcu_as_sc_mcu7t3v3__inv_2_753 VSS VSS gf180mcu_as_sc_mcu7t3v3__inv_2_753/Y VSS
+ gf180mcu_as_sc_mcu7t3v3__inv_2_785/VNW VSUBS gf180mcu_as_sc_mcu7t3v3__inv_2
Xgf180mcu_as_sc_mcu7t3v3__inv_2_742 VSS VSS VSS VSS gf180mcu_as_sc_mcu7t3v3__inv_2_789/VNW
+ VSUBS gf180mcu_as_sc_mcu7t3v3__inv_2
Xgf180mcu_as_sc_mcu7t3v3__inv_2_786 VSS VSS gf180mcu_as_sc_mcu7t3v3__inv_2_786/Y VSS
+ gf180mcu_as_sc_mcu7t3v3__inv_2_788/VNW VSUBS gf180mcu_as_sc_mcu7t3v3__inv_2
Xgf180mcu_as_sc_mcu7t3v3__inv_2_775 VSS VSS VSS VSS gf180mcu_as_sc_mcu7t3v3__inv_2_776/VNW
+ VSUBS gf180mcu_as_sc_mcu7t3v3__inv_2
Xgf180mcu_as_sc_mcu7t3v3__inv_2_720 VSS VSS gf180mcu_as_sc_mcu7t3v3__inv_2_720/Y VSS
+ gf180mcu_as_sc_mcu7t3v3__inv_2_720/VNW VSUBS gf180mcu_as_sc_mcu7t3v3__inv_2
Xgf180mcu_as_sc_mcu7t3v3__inv_2_797 VSS VSS gf180mcu_as_sc_mcu7t3v3__inv_2_797/Y VSS
+ gf180mcu_as_sc_mcu7t3v3__inv_2_841/VNW VSUBS gf180mcu_as_sc_mcu7t3v3__inv_2
Xgf180mcu_as_sc_mcu7t3v3__inv_2_731 gf180mcu_as_sc_mcu7t3v3__inv_2_731/VDD VSS gf180mcu_as_sc_mcu7t3v3__inv_2_731/Y
+ VSS gf180mcu_as_sc_mcu7t3v3__inv_2_731/VNW VSUBS gf180mcu_as_sc_mcu7t3v3__inv_2
Xgf180mcu_as_sc_mcu7t3v3__nand4_2_0 gf180mcu_as_sc_mcu7t3v3__inv_2_9/VSS gf180mcu_as_sc_mcu7t3v3__inv_2_9/VSS
+ VSS VSS VSS VSS VSS gf180mcu_as_sc_mcu7t3v3__inv_2_9/VNW VSUBS gf180mcu_as_sc_mcu7t3v3__nand4_2
Xgf180mcu_as_sc_mcu7t3v3__inv_2_594 VSS gf180mcu_as_sc_mcu7t3v3__inv_2_636/VSS gf180mcu_as_sc_mcu7t3v3__inv_2_594/Y
+ VSS gf180mcu_as_sc_mcu7t3v3__inv_2_594/VNW VSUBS gf180mcu_as_sc_mcu7t3v3__inv_2
Xgf180mcu_as_sc_mcu7t3v3__inv_2_561 gf180mcu_as_sc_mcu7t3v3__inv_2_636/VSS VSS gf180mcu_as_sc_mcu7t3v3__inv_2_561/Y
+ VSS gf180mcu_as_sc_mcu7t3v3__inv_2_561/VNW VSUBS gf180mcu_as_sc_mcu7t3v3__inv_2
Xgf180mcu_as_sc_mcu7t3v3__inv_2_572 gf180mcu_as_sc_mcu7t3v3__inv_2_572/VDD gf180mcu_as_sc_mcu7t3v3__inv_2_576/VDD
+ gf180mcu_as_sc_mcu7t3v3__inv_2_572/Y VSS gf180mcu_as_sc_mcu7t3v3__inv_2_572/VNW
+ VSUBS gf180mcu_as_sc_mcu7t3v3__inv_2
Xgf180mcu_as_sc_mcu7t3v3__inv_2_583 gf180mcu_as_sc_mcu7t3v3__inv_2_584/VDD gf180mcu_as_sc_mcu7t3v3__inv_2_585/VDD
+ gf180mcu_as_sc_mcu7t3v3__inv_2_583/Y gf180mcu_as_sc_mcu7t3v3__inv_2_584/Y gf180mcu_as_sc_mcu7t3v3__inv_2_584/VNW
+ VSUBS gf180mcu_as_sc_mcu7t3v3__inv_2
Xgf180mcu_as_sc_mcu7t3v3__inv_2_550 gf180mcu_as_sc_mcu7t3v3__nor2_2_6/VDD gf180mcu_as_sc_mcu7t3v3__nor2_2_6/VSS
+ VSS VSS gf180mcu_as_sc_mcu7t3v3__nor2_2_6/VNW VSUBS gf180mcu_as_sc_mcu7t3v3__inv_2
Xu_t028_019 u_t028_019/c0_w0_bl u_t028_019/c0_w0_br u_t028_019/c0_w1_bl u_t028_019/c0_w1_br
+ u_t028_019/c0_r0_rbl u_t028_019/c0_r1_rbl u_t028_019/c1_w0_bl u_t028_019/c1_w0_br
+ u_t028_019/c1_w1_bl u_t028_019/c1_w1_br u_t028_019/c1_r0_rbl u_t028_019/c1_r1_rbl
+ u_t028_019/c2_w0_bl u_t028_019/c2_w0_br u_t028_019/c2_w1_bl u_t028_019/c2_w1_br
+ u_t028_019/c2_r0_rbl u_t028_019/c2_r1_rbl u_t028_019/c3_w0_bl u_t028_019/c3_w0_br
+ u_t028_019/c3_w1_bl u_t028_019/c3_w1_br u_t028_019/c3_r0_rbl u_t028_019/c3_r1_rbl
+ u_t028_019/r0_w0_wl u_t028_019/r0_w1_wl u_t028_019/r0_r0_rwl u_t028_019/r0_r1_rwl
+ u_t028_019/r1_w0_wl u_t028_019/r1_w1_wl u_t028_019/r1_r0_rwl u_t028_019/r1_r1_rwl
+ u_t028_019/r2_w0_wl u_t028_019/r2_w1_wl u_t028_019/r2_r0_rwl u_t028_019/r2_r1_rwl
+ u_t028_019/r3_w0_wl u_t028_019/r3_w1_wl u_t028_019/r3_r0_rwl u_t028_019/r3_r1_rwl
+ u_t029_019/VDD u_t028_019/VSS VSUBS detronyx_12t_2w2r_rc4_4x4_routed_5layer_direct
Xu_t028_008 u_t028_008/c0_w0_bl u_t028_008/c0_w0_br u_t028_008/c0_w1_bl u_t028_008/c0_w1_br
+ u_t028_008/c0_r0_rbl u_t028_008/c0_r1_rbl u_t028_008/c1_w0_bl u_t028_008/c1_w0_br
+ u_t028_008/c1_w1_bl u_t028_008/c1_w1_br u_t028_008/c1_r0_rbl u_t028_008/c1_r1_rbl
+ u_t028_008/c2_w0_bl u_t028_008/c2_w0_br u_t028_008/c2_w1_bl u_t028_008/c2_w1_br
+ u_t028_008/c2_r0_rbl u_t028_008/c2_r1_rbl u_t028_008/c3_w0_bl u_t028_008/c3_w0_br
+ u_t028_008/c3_w1_bl u_t028_008/c3_w1_br u_t028_008/c3_r0_rbl u_t028_008/c3_r1_rbl
+ u_t028_008/r0_w0_wl u_t028_008/r0_w1_wl u_t028_008/r0_r0_rwl u_t028_008/r0_r1_rwl
+ u_t028_008/r1_w0_wl u_t028_008/r1_w1_wl u_t028_008/r1_r0_rwl u_t028_008/r1_r1_rwl
+ u_t028_008/r2_w0_wl u_t028_008/r2_w1_wl u_t028_008/r2_r0_rwl u_t028_008/r2_r1_rwl
+ u_t028_008/r3_w0_wl u_t028_008/r3_w1_wl u_t028_008/r3_r0_rwl u_t028_008/r3_r1_rwl
+ VSS u_t028_009/VSS VSUBS detronyx_12t_2w2r_rc4_4x4_routed_5layer_direct
Xgf180mcu_as_sc_mcu7t3v3__inv_2_391 VSS VSS gf180mcu_as_sc_mcu7t3v3__inv_2_391/Y VSS
+ gf180mcu_as_sc_mcu7t3v3__inv_2_451/VNW VSUBS gf180mcu_as_sc_mcu7t3v3__inv_2
Xgf180mcu_as_sc_mcu7t3v3__inv_2_380 gf180mcu_as_sc_mcu7t3v3__nor2_2_5/VDD gf180mcu_as_sc_mcu7t3v3__nand3_2_8/VSS
+ VSS VSS gf180mcu_as_sc_mcu7t3v3__nor2_2_5/VNW VSUBS gf180mcu_as_sc_mcu7t3v3__inv_2
Xu_t019_019 u_t019_019/c0_w0_bl u_t019_019/c0_w0_br u_t019_019/c0_w1_bl u_t019_019/c0_w1_br
+ u_t019_019/c0_r0_rbl u_t019_019/c0_r1_rbl u_t019_019/c1_w0_bl u_t019_019/c1_w0_br
+ u_t019_019/c1_w1_bl u_t019_019/c1_w1_br u_t019_019/c1_r0_rbl u_t019_019/c1_r1_rbl
+ u_t019_019/c2_w0_bl u_t019_019/c2_w0_br u_t019_019/c2_w1_bl u_t019_019/c2_w1_br
+ u_t019_019/c2_r0_rbl u_t019_019/c2_r1_rbl u_t019_019/c3_w0_bl u_t019_019/c3_w0_br
+ u_t019_019/c3_w1_bl u_t019_019/c3_w1_br u_t019_019/c3_r0_rbl u_t019_019/c3_r1_rbl
+ u_t019_019/r0_w0_wl u_t019_019/r0_w1_wl u_t019_019/r0_r0_rwl u_t019_019/r0_r1_rwl
+ u_t019_019/r1_w0_wl u_t019_019/r1_w1_wl u_t019_019/r1_r0_rwl u_t019_019/r1_r1_rwl
+ u_t019_019/r2_w0_wl u_t019_019/r2_w1_wl u_t019_019/r2_r0_rwl u_t019_019/r2_r1_rwl
+ u_t019_019/r3_w0_wl u_t019_019/r3_w1_wl u_t019_019/r3_r0_rwl u_t019_019/r3_r1_rwl
+ u_t019_019/VDD u_t019_019/VSS VSUBS detronyx_12t_2w2r_rc4_4x4_routed_5layer_direct
Xu_t019_008 u_t019_008/c0_w0_bl u_t019_008/c0_w0_br u_t019_008/c0_w1_bl u_t019_008/c0_w1_br
+ u_t019_008/c0_r0_rbl u_t019_008/c0_r1_rbl u_t019_008/c1_w0_bl u_t019_008/c1_w0_br
+ u_t019_008/c1_w1_bl u_t019_008/c1_w1_br u_t019_008/c1_r0_rbl u_t019_008/c1_r1_rbl
+ u_t019_008/c2_w0_bl u_t019_008/c2_w0_br u_t019_008/c2_w1_bl u_t019_008/c2_w1_br
+ u_t019_008/c2_r0_rbl u_t019_008/c2_r1_rbl u_t019_008/c3_w0_bl u_t019_008/c3_w0_br
+ u_t019_008/c3_w1_bl u_t019_008/c3_w1_br u_t019_008/c3_r0_rbl u_t019_008/c3_r1_rbl
+ u_t019_008/r0_w0_wl u_t019_008/r0_w1_wl u_t019_008/r0_r0_rwl u_t019_008/r0_r1_rwl
+ u_t019_008/r1_w0_wl u_t019_008/r1_w1_wl u_t019_008/r1_r0_rwl u_t019_008/r1_r1_rwl
+ u_t019_008/r2_w0_wl u_t019_008/r2_w1_wl u_t019_008/r2_r0_rwl u_t019_008/r2_r1_rwl
+ u_t019_008/r3_w0_wl u_t019_008/r3_w1_wl u_t019_008/r3_r0_rwl u_t019_008/r3_r1_rwl
+ VSS u_t019_009/VSS VSUBS detronyx_12t_2w2r_rc4_4x4_routed_5layer_direct
Xu_t027_030 u_t027_030/c0_w0_bl u_t027_030/c0_w0_br u_t027_030/c0_w1_bl u_t027_030/c0_w1_br
+ u_t027_030/c0_r0_rbl u_t027_030/c0_r1_rbl u_t027_030/c1_w0_bl u_t027_030/c1_w0_br
+ u_t027_030/c1_w1_bl u_t027_030/c1_w1_br u_t027_030/c1_r0_rbl u_t027_030/c1_r1_rbl
+ u_t027_030/c2_w0_bl u_t027_030/c2_w0_br u_t027_030/c2_w1_bl u_t027_030/c2_w1_br
+ u_t027_030/c2_r0_rbl u_t027_030/c2_r1_rbl u_t027_030/c3_w0_bl u_t027_030/c3_w0_br
+ u_t027_030/c3_w1_bl u_t027_030/c3_w1_br u_t027_030/c3_r0_rbl u_t027_030/c3_r1_rbl
+ u_t027_030/r0_w0_wl u_t027_030/r0_w1_wl u_t027_030/r0_r0_rwl u_t027_030/r0_r1_rwl
+ u_t027_030/r1_w0_wl u_t027_030/r1_w1_wl u_t027_030/r1_r0_rwl u_t027_030/r1_r1_rwl
+ u_t027_030/r2_w0_wl u_t027_030/r2_w1_wl u_t027_030/r2_r0_rwl u_t027_030/r2_r1_rwl
+ u_t027_030/r3_w0_wl u_t027_030/r3_w1_wl u_t027_030/r3_r0_rwl u_t027_030/r3_r1_rwl
+ VSS u_t027_031/VSS VSUBS detronyx_12t_2w2r_rc4_4x4_routed_5layer_direct
Xu_t018_030 u_t018_030/c0_w0_bl u_t018_030/c0_w0_br u_t018_030/c0_w1_bl u_t018_030/c0_w1_br
+ u_t018_030/c0_r0_rbl u_t018_030/c0_r1_rbl u_t018_030/c1_w0_bl u_t018_030/c1_w0_br
+ u_t018_030/c1_w1_bl u_t018_030/c1_w1_br u_t018_030/c1_r0_rbl u_t018_030/c1_r1_rbl
+ u_t018_030/c2_w0_bl u_t018_030/c2_w0_br u_t018_030/c2_w1_bl u_t018_030/c2_w1_br
+ u_t018_030/c2_r0_rbl u_t018_030/c2_r1_rbl u_t018_030/c3_w0_bl u_t018_030/c3_w0_br
+ u_t018_030/c3_w1_bl u_t018_030/c3_w1_br u_t018_030/c3_r0_rbl u_t018_030/c3_r1_rbl
+ u_t018_030/r0_w0_wl u_t018_030/r0_w1_wl u_t018_030/r0_r0_rwl u_t018_030/r0_r1_rwl
+ u_t018_030/r1_w0_wl u_t018_030/r1_w1_wl u_t018_030/r1_r0_rwl u_t018_030/r1_r1_rwl
+ u_t018_030/r2_w0_wl u_t018_030/r2_w1_wl u_t018_030/r2_r0_rwl u_t018_030/r2_r1_rwl
+ u_t018_030/r3_w0_wl u_t018_030/r3_w1_wl u_t018_030/r3_r0_rwl u_t018_030/r3_r1_rwl
+ VSS u_t018_031/VSS VSUBS detronyx_12t_2w2r_rc4_4x4_routed_5layer_direct
Xgf180mcu_as_sc_mcu7t3v3__inv_2_1109 VSS VSS VSS gf180mcu_as_sc_mcu7t3v3__inv_2_1115/A
+ gf180mcu_as_sc_mcu7t3v3__inv_2_1111/VNW VSUBS gf180mcu_as_sc_mcu7t3v3__inv_2
Xgf180mcu_as_sc_mcu7t3v3__nand3_2_12 gf180mcu_as_sc_mcu7t3v3__nand3_2_5/VDD gf180mcu_as_sc_mcu7t3v3__nor2_2_4/VSS
+ VSS VSS VSS VSS gf180mcu_as_sc_mcu7t3v3__nand3_2_5/VNW VSUBS gf180mcu_as_sc_mcu7t3v3__nand3_2
Xu_t009_030 u_t009_030/c0_w0_bl u_t009_030/c0_w0_br u_t009_030/c0_w1_bl u_t009_030/c0_w1_br
+ u_t009_030/c0_r0_rbl u_t009_030/c0_r1_rbl u_t009_030/c1_w0_bl u_t009_030/c1_w0_br
+ u_t009_030/c1_w1_bl u_t009_030/c1_w1_br u_t009_030/c1_r0_rbl u_t009_030/c1_r1_rbl
+ u_t009_030/c2_w0_bl u_t009_030/c2_w0_br u_t009_030/c2_w1_bl u_t009_030/c2_w1_br
+ u_t009_030/c2_r0_rbl u_t009_030/c2_r1_rbl u_t009_030/c3_w0_bl u_t009_030/c3_w0_br
+ u_t009_030/c3_w1_bl u_t009_030/c3_w1_br u_t009_030/c3_r0_rbl u_t009_030/c3_r1_rbl
+ u_t009_030/r0_w0_wl u_t009_030/r0_w1_wl u_t009_030/r0_r0_rwl u_t009_030/r0_r1_rwl
+ u_t009_030/r1_w0_wl u_t009_030/r1_w1_wl u_t009_030/r1_r0_rwl u_t009_030/r1_r1_rwl
+ u_t009_030/r2_w0_wl u_t009_030/r2_w1_wl u_t009_030/r2_r0_rwl u_t009_030/r2_r1_rwl
+ u_t009_030/r3_w0_wl u_t009_030/r3_w1_wl u_t009_030/r3_r0_rwl u_t009_030/r3_r1_rwl
+ VSS u_t009_031/VSS VSUBS detronyx_12t_2w2r_rc4_4x4_routed_5layer_direct
Xu_t024_022 u_t024_022/c0_w0_bl u_t024_022/c0_w0_br u_t024_022/c0_w1_bl u_t024_022/c0_w1_br
+ u_t024_022/c0_r0_rbl u_t024_022/c0_r1_rbl u_t024_022/c1_w0_bl u_t024_022/c1_w0_br
+ u_t024_022/c1_w1_bl u_t024_022/c1_w1_br u_t024_022/c1_r0_rbl u_t024_022/c1_r1_rbl
+ u_t024_022/c2_w0_bl u_t024_022/c2_w0_br u_t024_022/c2_w1_bl u_t024_022/c2_w1_br
+ u_t024_022/c2_r0_rbl u_t024_022/c2_r1_rbl u_t024_022/c3_w0_bl u_t024_022/c3_w0_br
+ u_t024_022/c3_w1_bl u_t024_022/c3_w1_br u_t024_022/c3_r0_rbl u_t024_022/c3_r1_rbl
+ u_t024_022/r0_w0_wl u_t024_022/r0_w1_wl u_t024_022/r0_r0_rwl u_t024_022/r0_r1_rwl
+ u_t024_022/r1_w0_wl u_t024_022/r1_w1_wl u_t024_022/r1_r0_rwl u_t024_022/r1_r1_rwl
+ u_t024_022/r2_w0_wl u_t024_022/r2_w1_wl u_t024_022/r2_r0_rwl u_t024_022/r2_r1_rwl
+ u_t024_022/r3_w0_wl u_t024_022/r3_w1_wl u_t024_022/r3_r0_rwl u_t024_022/r3_r1_rwl
+ VSS u_t024_024/VSS VSUBS detronyx_12t_2w2r_rc4_4x4_routed_5layer_direct
Xu_t024_011 u_t024_011/c0_w0_bl u_t024_011/c0_w0_br u_t024_011/c0_w1_bl u_t024_011/c0_w1_br
+ u_t024_011/c0_r0_rbl u_t024_011/c0_r1_rbl u_t024_011/c1_w0_bl u_t024_011/c1_w0_br
+ u_t024_011/c1_w1_bl u_t024_011/c1_w1_br u_t024_011/c1_r0_rbl u_t024_011/c1_r1_rbl
+ u_t024_011/c2_w0_bl u_t024_011/c2_w0_br u_t024_011/c2_w1_bl u_t024_011/c2_w1_br
+ u_t024_011/c2_r0_rbl u_t024_011/c2_r1_rbl u_t024_011/c3_w0_bl u_t024_011/c3_w0_br
+ u_t024_011/c3_w1_bl u_t024_011/c3_w1_br u_t024_011/c3_r0_rbl u_t024_011/c3_r1_rbl
+ u_t024_011/r0_w0_wl u_t024_011/r0_w1_wl u_t024_011/r0_r0_rwl u_t024_011/r0_r1_rwl
+ u_t024_011/r1_w0_wl u_t024_011/r1_w1_wl u_t024_011/r1_r0_rwl u_t024_011/r1_r1_rwl
+ u_t024_011/r2_w0_wl u_t024_011/r2_w1_wl u_t024_011/r2_r0_rwl u_t024_011/r2_r1_rwl
+ u_t024_011/r3_w0_wl u_t024_011/r3_w1_wl u_t024_011/r3_r0_rwl u_t024_011/r3_r1_rwl
+ u_t025_011/VDD u_t024_011/VSS VSUBS detronyx_12t_2w2r_rc4_4x4_routed_5layer_direct
Xu_t024_000 u_t024_000/c0_w0_bl u_t024_000/c0_w0_br u_t024_000/c0_w1_bl u_t024_000/c0_w1_br
+ u_t024_000/c0_r0_rbl u_t024_000/c0_r1_rbl u_t024_000/c1_w0_bl u_t024_000/c1_w0_br
+ u_t024_000/c1_w1_bl u_t024_000/c1_w1_br u_t024_000/c1_r0_rbl u_t024_000/c1_r1_rbl
+ u_t024_000/c2_w0_bl u_t024_000/c2_w0_br u_t024_000/c2_w1_bl u_t024_000/c2_w1_br
+ u_t024_000/c2_r0_rbl u_t024_000/c2_r1_rbl u_t024_000/c3_w0_bl u_t024_000/c3_w0_br
+ u_t024_000/c3_w1_bl u_t024_000/c3_w1_br u_t024_000/c3_r0_rbl u_t024_000/c3_r1_rbl
+ u_t024_000/r0_w0_wl u_t024_000/r0_w1_wl u_t024_000/r0_r0_rwl u_t024_000/r0_r1_rwl
+ u_t024_000/r1_w0_wl u_t024_000/r1_w1_wl u_t024_000/r1_r0_rwl u_t024_000/r1_r1_rwl
+ u_t024_000/r2_w0_wl u_t024_000/r2_w1_wl u_t024_000/r2_r0_rwl u_t024_000/r2_r1_rwl
+ u_t024_000/r3_w0_wl u_t024_000/r3_w1_wl u_t024_000/r3_r0_rwl u_t024_000/r3_r1_rwl
+ VSS u_t024_002/VSS VSUBS detronyx_12t_2w2r_rc4_4x4_routed_5layer_direct
Xgf180mcu_as_sc_mcu7t3v3__nand3_2_23 gf180mcu_as_sc_mcu7t3v3__nand3_2_31/VDD gf180mcu_as_sc_mcu7t3v3__nand3_2_31/VSS
+ VSS VSS VSS VSS gf180mcu_as_sc_mcu7t3v3__nand3_2_31/VNW VSUBS gf180mcu_as_sc_mcu7t3v3__nand3_2
Xgf180mcu_as_sc_mcu7t3v3__inv_2_1643 gf180mcu_as_sc_mcu7t3v3__inv_2_1675/VDD VSS gf180mcu_as_sc_mcu7t3v3__inv_2_1643/Y
+ gf180mcu_as_sc_mcu7t3v3__inv_2_1675/Y gf180mcu_as_sc_mcu7t3v3__inv_2_1675/VNW VSUBS
+ gf180mcu_as_sc_mcu7t3v3__inv_2
Xgf180mcu_as_sc_mcu7t3v3__inv_2_1676 VSS VSS gf180mcu_as_sc_mcu7t3v3__inv_2_1678/Y
+ VSS gf180mcu_as_sc_mcu7t3v3__inv_2_1676/VNW VSUBS gf180mcu_as_sc_mcu7t3v3__inv_2
Xgf180mcu_as_sc_mcu7t3v3__inv_2_1632 VSS gf180mcu_as_sc_mcu7t3v3__inv_2_1678/VDD VSS
+ gf180mcu_as_sc_mcu7t3v3__inv_2_1678/Y gf180mcu_as_sc_mcu7t3v3__inv_2_1677/VNW VSUBS
+ gf180mcu_as_sc_mcu7t3v3__inv_2
Xgf180mcu_as_sc_mcu7t3v3__inv_2_1621 gf180mcu_as_sc_mcu7t3v3__inv_2_1665/VDD VSS gf180mcu_as_sc_mcu7t3v3__inv_2_1682/Y
+ gf180mcu_as_sc_mcu7t3v3__inv_2_1682/Y gf180mcu_as_sc_mcu7t3v3__inv_2_1665/VNW VSUBS
+ gf180mcu_as_sc_mcu7t3v3__inv_2
Xgf180mcu_as_sc_mcu7t3v3__inv_2_1665 gf180mcu_as_sc_mcu7t3v3__inv_2_1665/VDD VSS gf180mcu_as_sc_mcu7t3v3__inv_2_1682/Y
+ VSS gf180mcu_as_sc_mcu7t3v3__inv_2_1665/VNW VSUBS gf180mcu_as_sc_mcu7t3v3__inv_2
Xgf180mcu_as_sc_mcu7t3v3__inv_2_1654 gf180mcu_as_sc_mcu7t3v3__inv_2_1654/VDD VSS gf180mcu_as_sc_mcu7t3v3__inv_2_1682/Y
+ VSS gf180mcu_as_sc_mcu7t3v3__inv_2_1654/VNW VSUBS gf180mcu_as_sc_mcu7t3v3__inv_2
Xgf180mcu_as_sc_mcu7t3v3__inv_2_1610 VSS VSS VSS gf180mcu_as_sc_mcu7t3v3__inv_2_1657/Y
+ gf180mcu_as_sc_mcu7t3v3__inv_2_1655/VNW VSUBS gf180mcu_as_sc_mcu7t3v3__inv_2
Xgf180mcu_as_sc_mcu7t3v3__inv_2_1687 gf180mcu_as_sc_mcu7t3v3__inv_2_1688/VDD VSS VSS
+ VSS gf180mcu_as_sc_mcu7t3v3__inv_2_1688/VNW VSUBS gf180mcu_as_sc_mcu7t3v3__inv_2
Xgf180mcu_as_sc_mcu7t3v3__inv_2_1698 gf180mcu_as_sc_mcu7t3v3__inv_2_990/VSS VSS gf180mcu_as_sc_mcu7t3v3__inv_2_1698/Y
+ gf180mcu_as_sc_mcu7t3v3__inv_2_988/A gf180mcu_as_sc_mcu7t3v3__inv_2_1700/VNW VSUBS
+ gf180mcu_as_sc_mcu7t3v3__inv_2
Xu_t015_011 u_t015_011/c0_w0_bl u_t015_011/c0_w0_br u_t015_011/c0_w1_bl u_t015_011/c0_w1_br
+ u_t015_011/c0_r0_rbl u_t015_011/c0_r1_rbl u_t015_011/c1_w0_bl u_t015_011/c1_w0_br
+ u_t015_011/c1_w1_bl u_t015_011/c1_w1_br u_t015_011/c1_r0_rbl u_t015_011/c1_r1_rbl
+ u_t015_011/c2_w0_bl u_t015_011/c2_w0_br u_t015_011/c2_w1_bl u_t015_011/c2_w1_br
+ u_t015_011/c2_r0_rbl u_t015_011/c2_r1_rbl u_t015_011/c3_w0_bl u_t015_011/c3_w0_br
+ u_t015_011/c3_w1_bl u_t015_011/c3_w1_br u_t015_011/c3_r0_rbl u_t015_011/c3_r1_rbl
+ u_t015_011/r0_w0_wl u_t015_011/r0_w1_wl u_t015_011/r0_r0_rwl u_t015_011/r0_r1_rwl
+ u_t015_011/r1_w0_wl u_t015_011/r1_w1_wl u_t015_011/r1_r0_rwl u_t015_011/r1_r1_rwl
+ u_t015_011/r2_w0_wl u_t015_011/r2_w1_wl u_t015_011/r2_r0_rwl u_t015_011/r2_r1_rwl
+ u_t015_011/r3_w0_wl u_t015_011/r3_w1_wl u_t015_011/r3_r0_rwl u_t015_011/r3_r1_rwl
+ u_t015_011/VDD u_t015_011/VSS VSUBS detronyx_12t_2w2r_rc4_4x4_routed_5layer_direct
Xu_t015_000 u_t015_000/c0_w0_bl u_t015_000/c0_w0_br u_t015_000/c0_w1_bl u_t015_000/c0_w1_br
+ u_t015_000/c0_r0_rbl u_t015_000/c0_r1_rbl u_t015_000/c1_w0_bl u_t015_000/c1_w0_br
+ u_t015_000/c1_w1_bl u_t015_000/c1_w1_br u_t015_000/c1_r0_rbl u_t015_000/c1_r1_rbl
+ u_t015_000/c2_w0_bl u_t015_000/c2_w0_br u_t015_000/c2_w1_bl u_t015_000/c2_w1_br
+ u_t015_000/c2_r0_rbl u_t015_000/c2_r1_rbl u_t015_000/c3_w0_bl u_t015_000/c3_w0_br
+ u_t015_000/c3_w1_bl u_t015_000/c3_w1_br u_t015_000/c3_r0_rbl u_t015_000/c3_r1_rbl
+ u_t015_000/r0_w0_wl u_t015_000/r0_w1_wl u_t015_000/r0_r0_rwl u_t015_000/r0_r1_rwl
+ u_t015_000/r1_w0_wl u_t015_000/r1_w1_wl u_t015_000/r1_r0_rwl u_t015_000/r1_r1_rwl
+ u_t015_000/r2_w0_wl u_t015_000/r2_w1_wl u_t015_000/r2_r0_rwl u_t015_000/r2_r1_rwl
+ u_t015_000/r3_w0_wl u_t015_000/r3_w1_wl u_t015_000/r3_r0_rwl u_t015_000/r3_r1_rwl
+ VSS u_t015_002/VSS VSUBS detronyx_12t_2w2r_rc4_4x4_routed_5layer_direct
Xu_t030_025 u_t030_025/c0_w0_bl u_t030_025/c0_w0_br u_t030_025/c0_w1_bl u_t030_025/c0_w1_br
+ u_t030_025/c0_r0_rbl u_t030_025/c0_r1_rbl u_t030_025/c1_w0_bl u_t030_025/c1_w0_br
+ u_t030_025/c1_w1_bl u_t030_025/c1_w1_br u_t030_025/c1_r0_rbl u_t030_025/c1_r1_rbl
+ u_t030_025/c2_w0_bl u_t030_025/c2_w0_br u_t030_025/c2_w1_bl u_t030_025/c2_w1_br
+ u_t030_025/c2_r0_rbl u_t030_025/c2_r1_rbl u_t030_025/c3_w0_bl u_t030_025/c3_w0_br
+ u_t030_025/c3_w1_bl u_t030_025/c3_w1_br u_t030_025/c3_r0_rbl u_t030_025/c3_r1_rbl
+ u_t030_025/r0_w0_wl u_t030_025/r0_w1_wl u_t030_025/r0_r0_rwl u_t030_025/r0_r1_rwl
+ u_t030_025/r1_w0_wl u_t030_025/r1_w1_wl u_t030_025/r1_r0_rwl u_t030_025/r1_r1_rwl
+ u_t030_025/r2_w0_wl u_t030_025/r2_w1_wl u_t030_025/r2_r0_rwl u_t030_025/r2_r1_rwl
+ u_t030_025/r3_w0_wl u_t030_025/r3_w1_wl u_t030_025/r3_r0_rwl u_t030_025/r3_r1_rwl
+ VSS u_t030_031/VSS VSUBS detronyx_12t_2w2r_rc4_4x4_routed_5layer_direct
Xu_t015_022 u_t015_022/c0_w0_bl u_t015_022/c0_w0_br u_t015_022/c0_w1_bl u_t015_022/c0_w1_br
+ u_t015_022/c0_r0_rbl u_t015_022/c0_r1_rbl u_t015_022/c1_w0_bl u_t015_022/c1_w0_br
+ u_t015_022/c1_w1_bl u_t015_022/c1_w1_br u_t015_022/c1_r0_rbl u_t015_022/c1_r1_rbl
+ u_t015_022/c2_w0_bl u_t015_022/c2_w0_br u_t015_022/c2_w1_bl u_t015_022/c2_w1_br
+ u_t015_022/c2_r0_rbl u_t015_022/c2_r1_rbl u_t015_022/c3_w0_bl u_t015_022/c3_w0_br
+ u_t015_022/c3_w1_bl u_t015_022/c3_w1_br u_t015_022/c3_r0_rbl u_t015_022/c3_r1_rbl
+ u_t015_022/r0_w0_wl u_t015_022/r0_w1_wl u_t015_022/r0_r0_rwl u_t015_022/r0_r1_rwl
+ u_t015_022/r1_w0_wl u_t015_022/r1_w1_wl u_t015_022/r1_r0_rwl u_t015_022/r1_r1_rwl
+ u_t015_022/r2_w0_wl u_t015_022/r2_w1_wl u_t015_022/r2_r0_rwl u_t015_022/r2_r1_rwl
+ u_t015_022/r3_w0_wl u_t015_022/r3_w1_wl u_t015_022/r3_r0_rwl u_t015_022/r3_r1_rwl
+ VSS u_t015_024/VSS VSUBS detronyx_12t_2w2r_rc4_4x4_routed_5layer_direct
Xu_t030_014 u_t030_014/c0_w0_bl u_t030_014/c0_w0_br u_t030_014/c0_w1_bl u_t030_014/c0_w1_br
+ u_t030_014/c0_r0_rbl u_t030_014/c0_r1_rbl u_t030_014/c1_w0_bl u_t030_014/c1_w0_br
+ u_t030_014/c1_w1_bl u_t030_014/c1_w1_br u_t030_014/c1_r0_rbl u_t030_014/c1_r1_rbl
+ u_t030_014/c2_w0_bl u_t030_014/c2_w0_br u_t030_014/c2_w1_bl u_t030_014/c2_w1_br
+ u_t030_014/c2_r0_rbl u_t030_014/c2_r1_rbl u_t030_014/c3_w0_bl u_t030_014/c3_w0_br
+ u_t030_014/c3_w1_bl u_t030_014/c3_w1_br u_t030_014/c3_r0_rbl u_t030_014/c3_r1_rbl
+ u_t030_014/r0_w0_wl u_t030_014/r0_w1_wl u_t030_014/r0_r0_rwl u_t030_014/r0_r1_rwl
+ u_t030_014/r1_w0_wl u_t030_014/r1_w1_wl u_t030_014/r1_r0_rwl u_t030_014/r1_r1_rwl
+ u_t030_014/r2_w0_wl u_t030_014/r2_w1_wl u_t030_014/r2_r0_rwl u_t030_014/r2_r1_rwl
+ u_t030_014/r3_w0_wl u_t030_014/r3_w1_wl u_t030_014/r3_r0_rwl u_t030_014/r3_r1_rwl
+ u_t030_014/VDD u_t030_031/VSS VSUBS detronyx_12t_2w2r_rc4_4x4_routed_5layer_direct
Xu_t030_003 u_t030_003/c0_w0_bl u_t030_003/c0_w0_br u_t030_003/c0_w1_bl u_t030_003/c0_w1_br
+ u_t030_003/c0_r0_rbl u_t030_003/c0_r1_rbl u_t030_003/c1_w0_bl u_t030_003/c1_w0_br
+ u_t030_003/c1_w1_bl u_t030_003/c1_w1_br u_t030_003/c1_r0_rbl u_t030_003/c1_r1_rbl
+ u_t030_003/c2_w0_bl u_t030_003/c2_w0_br u_t030_003/c2_w1_bl u_t030_003/c2_w1_br
+ u_t030_003/c2_r0_rbl u_t030_003/c2_r1_rbl u_t030_003/c3_w0_bl u_t030_003/c3_w0_br
+ u_t030_003/c3_w1_bl u_t030_003/c3_w1_br u_t030_003/c3_r0_rbl u_t030_003/c3_r1_rbl
+ u_t030_003/r0_w0_wl u_t030_003/r0_w1_wl u_t030_003/r0_r0_rwl u_t030_003/r0_r1_rwl
+ u_t030_003/r1_w0_wl u_t030_003/r1_w1_wl u_t030_003/r1_r0_rwl u_t030_003/r1_r1_rwl
+ u_t030_003/r2_w0_wl u_t030_003/r2_w1_wl u_t030_003/r2_r0_rwl u_t030_003/r2_r1_rwl
+ u_t030_003/r3_w0_wl u_t030_003/r3_w1_wl u_t030_003/r3_r0_rwl u_t030_003/r3_r1_rwl
+ u_t030_003/VDD u_t030_031/VSS VSUBS detronyx_12t_2w2r_rc4_4x4_routed_5layer_direct
Xgf180mcu_as_sc_mcu7t3v3__nand4_2_459 VSS gf180mcu_as_sc_mcu7t3v3__inv_2_1589/VDD
+ VSS VSS VSS VSS VSS gf180mcu_as_sc_mcu7t3v3__inv_2_1585/VNW VSUBS gf180mcu_as_sc_mcu7t3v3__nand4_2
Xgf180mcu_as_sc_mcu7t3v3__nand4_2_448 VSS gf180mcu_as_sc_mcu7t3v3__inv_2_1552/VSS
+ VSS VSS VSS VSS gf180mcu_as_sc_mcu7t3v3__nand4_2_448/Y gf180mcu_as_sc_mcu7t3v3__inv_2_1552/VNW
+ VSUBS gf180mcu_as_sc_mcu7t3v3__nand4_2
Xgf180mcu_as_sc_mcu7t3v3__nand4_2_404 VSS gf180mcu_as_sc_mcu7t3v3__inv_2_1383/VDD
+ VSS VSS VSS VSS VSS gf180mcu_as_sc_mcu7t3v3__inv_2_1382/VNW VSUBS gf180mcu_as_sc_mcu7t3v3__nand4_2
Xgf180mcu_as_sc_mcu7t3v3__nand4_2_437 gf180mcu_as_sc_mcu7t3v3__inv_2_1492/VDD gf180mcu_as_sc_mcu7t3v3__inv_2_1496/VDD
+ VSS VSS VSS VSS gf180mcu_as_sc_mcu7t3v3__nand4_2_437/Y gf180mcu_as_sc_mcu7t3v3__inv_2_1492/VNW
+ VSUBS gf180mcu_as_sc_mcu7t3v3__nand4_2
Xgf180mcu_as_sc_mcu7t3v3__nand4_2_426 VSS VSS VSS VSS VSS VSS VSS gf180mcu_as_sc_mcu7t3v3__inv_2_1448/VNW
+ VSUBS gf180mcu_as_sc_mcu7t3v3__nand4_2
Xgf180mcu_as_sc_mcu7t3v3__nand4_2_415 gf180mcu_as_sc_mcu7t3v3__inv_2_1433/VSS VSS
+ VSS VSS VSS VSS gf180mcu_as_sc_mcu7t3v3__nand4_2_415/Y gf180mcu_as_sc_mcu7t3v3__inv_2_1404/VNW
+ VSUBS gf180mcu_as_sc_mcu7t3v3__nand4_2
Xu_t006_022 u_t006_022/c0_w0_bl u_t006_022/c0_w0_br u_t006_022/c0_w1_bl u_t006_022/c0_w1_br
+ u_t006_022/c0_r0_rbl u_t006_022/c0_r1_rbl u_t006_022/c1_w0_bl u_t006_022/c1_w0_br
+ u_t006_022/c1_w1_bl u_t006_022/c1_w1_br u_t006_022/c1_r0_rbl u_t006_022/c1_r1_rbl
+ u_t006_022/c2_w0_bl u_t006_022/c2_w0_br u_t006_022/c2_w1_bl u_t006_022/c2_w1_br
+ u_t006_022/c2_r0_rbl u_t006_022/c2_r1_rbl u_t006_022/c3_w0_bl u_t006_022/c3_w0_br
+ u_t006_022/c3_w1_bl u_t006_022/c3_w1_br u_t006_022/c3_r0_rbl u_t006_022/c3_r1_rbl
+ u_t006_022/r0_w0_wl u_t006_022/r0_w1_wl u_t006_022/r0_r0_rwl u_t006_022/r0_r1_rwl
+ u_t006_022/r1_w0_wl u_t006_022/r1_w1_wl u_t006_022/r1_r0_rwl u_t006_022/r1_r1_rwl
+ u_t006_022/r2_w0_wl u_t006_022/r2_w1_wl u_t006_022/r2_r0_rwl u_t006_022/r2_r1_rwl
+ u_t006_022/r3_w0_wl u_t006_022/r3_w1_wl u_t006_022/r3_r0_rwl u_t006_022/r3_r1_rwl
+ VSS u_t006_024/VSS VSUBS detronyx_12t_2w2r_rc4_4x4_routed_5layer_direct
Xu_t006_011 u_t006_011/c0_w0_bl u_t006_011/c0_w0_br u_t006_011/c0_w1_bl u_t006_011/c0_w1_br
+ u_t006_011/c0_r0_rbl u_t006_011/c0_r1_rbl u_t006_011/c1_w0_bl u_t006_011/c1_w0_br
+ u_t006_011/c1_w1_bl u_t006_011/c1_w1_br u_t006_011/c1_r0_rbl u_t006_011/c1_r1_rbl
+ u_t006_011/c2_w0_bl u_t006_011/c2_w0_br u_t006_011/c2_w1_bl u_t006_011/c2_w1_br
+ u_t006_011/c2_r0_rbl u_t006_011/c2_r1_rbl u_t006_011/c3_w0_bl u_t006_011/c3_w0_br
+ u_t006_011/c3_w1_bl u_t006_011/c3_w1_br u_t006_011/c3_r0_rbl u_t006_011/c3_r1_rbl
+ u_t006_011/r0_w0_wl u_t006_011/r0_w1_wl u_t006_011/r0_r0_rwl u_t006_011/r0_r1_rwl
+ u_t006_011/r1_w0_wl u_t006_011/r1_w1_wl u_t006_011/r1_r0_rwl u_t006_011/r1_r1_rwl
+ u_t006_011/r2_w0_wl u_t006_011/r2_w1_wl u_t006_011/r2_r0_rwl u_t006_011/r2_r1_rwl
+ u_t006_011/r3_w0_wl u_t006_011/r3_w1_wl u_t006_011/r3_r0_rwl u_t006_011/r3_r1_rwl
+ u_t006_011/VDD u_t006_011/VSS VSUBS detronyx_12t_2w2r_rc4_4x4_routed_5layer_direct
Xu_t021_003 u_t021_003/c0_w0_bl u_t021_003/c0_w0_br u_t021_003/c0_w1_bl u_t021_003/c0_w1_br
+ u_t021_003/c0_r0_rbl u_t021_003/c0_r1_rbl u_t021_003/c1_w0_bl u_t021_003/c1_w0_br
+ u_t021_003/c1_w1_bl u_t021_003/c1_w1_br u_t021_003/c1_r0_rbl u_t021_003/c1_r1_rbl
+ u_t021_003/c2_w0_bl u_t021_003/c2_w0_br u_t021_003/c2_w1_bl u_t021_003/c2_w1_br
+ u_t021_003/c2_r0_rbl u_t021_003/c2_r1_rbl u_t021_003/c3_w0_bl u_t021_003/c3_w0_br
+ u_t021_003/c3_w1_bl u_t021_003/c3_w1_br u_t021_003/c3_r0_rbl u_t021_003/c3_r1_rbl
+ u_t021_003/r0_w0_wl u_t021_003/r0_w1_wl u_t021_003/r0_r0_rwl u_t021_003/r0_r1_rwl
+ u_t021_003/r1_w0_wl u_t021_003/r1_w1_wl u_t021_003/r1_r0_rwl u_t021_003/r1_r1_rwl
+ u_t021_003/r2_w0_wl u_t021_003/r2_w1_wl u_t021_003/r2_r0_rwl u_t021_003/r2_r1_rwl
+ u_t021_003/r3_w0_wl u_t021_003/r3_w1_wl u_t021_003/r3_r0_rwl u_t021_003/r3_r1_rwl
+ u_t021_003/VDD u_t021_031/VSS VSUBS detronyx_12t_2w2r_rc4_4x4_routed_5layer_direct
Xu_t006_000 u_t006_000/c0_w0_bl u_t006_000/c0_w0_br u_t006_000/c0_w1_bl u_t006_000/c0_w1_br
+ u_t006_000/c0_r0_rbl u_t006_000/c0_r1_rbl u_t006_000/c1_w0_bl u_t006_000/c1_w0_br
+ u_t006_000/c1_w1_bl u_t006_000/c1_w1_br u_t006_000/c1_r0_rbl u_t006_000/c1_r1_rbl
+ u_t006_000/c2_w0_bl u_t006_000/c2_w0_br u_t006_000/c2_w1_bl u_t006_000/c2_w1_br
+ u_t006_000/c2_r0_rbl u_t006_000/c2_r1_rbl u_t006_000/c3_w0_bl u_t006_000/c3_w0_br
+ u_t006_000/c3_w1_bl u_t006_000/c3_w1_br u_t006_000/c3_r0_rbl u_t006_000/c3_r1_rbl
+ u_t006_000/r0_w0_wl u_t006_000/r0_w1_wl u_t006_000/r0_r0_rwl u_t006_000/r0_r1_rwl
+ u_t006_000/r1_w0_wl u_t006_000/r1_w1_wl u_t006_000/r1_r0_rwl u_t006_000/r1_r1_rwl
+ u_t006_000/r2_w0_wl u_t006_000/r2_w1_wl u_t006_000/r2_r0_rwl u_t006_000/r2_r1_rwl
+ u_t006_000/r3_w0_wl u_t006_000/r3_w1_wl u_t006_000/r3_r0_rwl u_t006_000/r3_r1_rwl
+ VSS u_t006_002/VSS VSUBS detronyx_12t_2w2r_rc4_4x4_routed_5layer_direct
Xgf180mcu_as_sc_mcu7t3v3__inv_2_5 gf180mcu_as_sc_mcu7t3v3__inv_2_6/VSS gf180mcu_as_sc_mcu7t3v3__inv_2_6/VSS
+ VSS gf180mcu_as_sc_mcu7t3v3__inv_2_8/A gf180mcu_as_sc_mcu7t3v3__inv_2_6/VNW VSUBS
+ gf180mcu_as_sc_mcu7t3v3__inv_2
Xu_t021_025 u_t021_025/c0_w0_bl u_t021_025/c0_w0_br u_t021_025/c0_w1_bl u_t021_025/c0_w1_br
+ u_t021_025/c0_r0_rbl u_t021_025/c0_r1_rbl u_t021_025/c1_w0_bl u_t021_025/c1_w0_br
+ u_t021_025/c1_w1_bl u_t021_025/c1_w1_br u_t021_025/c1_r0_rbl u_t021_025/c1_r1_rbl
+ u_t021_025/c2_w0_bl u_t021_025/c2_w0_br u_t021_025/c2_w1_bl u_t021_025/c2_w1_br
+ u_t021_025/c2_r0_rbl u_t021_025/c2_r1_rbl u_t021_025/c3_w0_bl u_t021_025/c3_w0_br
+ u_t021_025/c3_w1_bl u_t021_025/c3_w1_br u_t021_025/c3_r0_rbl u_t021_025/c3_r1_rbl
+ u_t021_025/r0_w0_wl u_t021_025/r0_w1_wl u_t021_025/r0_r0_rwl u_t021_025/r0_r1_rwl
+ u_t021_025/r1_w0_wl u_t021_025/r1_w1_wl u_t021_025/r1_r0_rwl u_t021_025/r1_r1_rwl
+ u_t021_025/r2_w0_wl u_t021_025/r2_w1_wl u_t021_025/r2_r0_rwl u_t021_025/r2_r1_rwl
+ u_t021_025/r3_w0_wl u_t021_025/r3_w1_wl u_t021_025/r3_r0_rwl u_t021_025/r3_r1_rwl
+ VSS u_t021_031/VSS VSUBS detronyx_12t_2w2r_rc4_4x4_routed_5layer_direct
Xu_t021_014 u_t021_014/c0_w0_bl u_t021_014/c0_w0_br u_t021_014/c0_w1_bl u_t021_014/c0_w1_br
+ u_t021_014/c0_r0_rbl u_t021_014/c0_r1_rbl u_t021_014/c1_w0_bl u_t021_014/c1_w0_br
+ u_t021_014/c1_w1_bl u_t021_014/c1_w1_br u_t021_014/c1_r0_rbl u_t021_014/c1_r1_rbl
+ u_t021_014/c2_w0_bl u_t021_014/c2_w0_br u_t021_014/c2_w1_bl u_t021_014/c2_w1_br
+ u_t021_014/c2_r0_rbl u_t021_014/c2_r1_rbl u_t021_014/c3_w0_bl u_t021_014/c3_w0_br
+ u_t021_014/c3_w1_bl u_t021_014/c3_w1_br u_t021_014/c3_r0_rbl u_t021_014/c3_r1_rbl
+ u_t021_014/r0_w0_wl u_t021_014/r0_w1_wl u_t021_014/r0_r0_rwl u_t021_014/r0_r1_rwl
+ u_t021_014/r1_w0_wl u_t021_014/r1_w1_wl u_t021_014/r1_r0_rwl u_t021_014/r1_r1_rwl
+ u_t021_014/r2_w0_wl u_t021_014/r2_w1_wl u_t021_014/r2_r0_rwl u_t021_014/r2_r1_rwl
+ u_t021_014/r3_w0_wl u_t021_014/r3_w1_wl u_t021_014/r3_r0_rwl u_t021_014/r3_r1_rwl
+ u_t021_014/VDD u_t021_031/VSS VSUBS detronyx_12t_2w2r_rc4_4x4_routed_5layer_direct
Xu_t012_025 u_t012_025/c0_w0_bl u_t012_025/c0_w0_br u_t012_025/c0_w1_bl u_t012_025/c0_w1_br
+ u_t012_025/c0_r0_rbl u_t012_025/c0_r1_rbl u_t012_025/c1_w0_bl u_t012_025/c1_w0_br
+ u_t012_025/c1_w1_bl u_t012_025/c1_w1_br u_t012_025/c1_r0_rbl u_t012_025/c1_r1_rbl
+ u_t012_025/c2_w0_bl u_t012_025/c2_w0_br u_t012_025/c2_w1_bl u_t012_025/c2_w1_br
+ u_t012_025/c2_r0_rbl u_t012_025/c2_r1_rbl u_t012_025/c3_w0_bl u_t012_025/c3_w0_br
+ u_t012_025/c3_w1_bl u_t012_025/c3_w1_br u_t012_025/c3_r0_rbl u_t012_025/c3_r1_rbl
+ u_t012_025/r0_w0_wl u_t012_025/r0_w1_wl u_t012_025/r0_r0_rwl u_t012_025/r0_r1_rwl
+ u_t012_025/r1_w0_wl u_t012_025/r1_w1_wl u_t012_025/r1_r0_rwl u_t012_025/r1_r1_rwl
+ u_t012_025/r2_w0_wl u_t012_025/r2_w1_wl u_t012_025/r2_r0_rwl u_t012_025/r2_r1_rwl
+ u_t012_025/r3_w0_wl u_t012_025/r3_w1_wl u_t012_025/r3_r0_rwl u_t012_025/r3_r1_rwl
+ VSS u_t012_031/VSS VSUBS detronyx_12t_2w2r_rc4_4x4_routed_5layer_direct
Xu_t012_014 u_t012_014/c0_w0_bl u_t012_014/c0_w0_br u_t012_014/c0_w1_bl u_t012_014/c0_w1_br
+ u_t012_014/c0_r0_rbl u_t012_014/c0_r1_rbl u_t012_014/c1_w0_bl u_t012_014/c1_w0_br
+ u_t012_014/c1_w1_bl u_t012_014/c1_w1_br u_t012_014/c1_r0_rbl u_t012_014/c1_r1_rbl
+ u_t012_014/c2_w0_bl u_t012_014/c2_w0_br u_t012_014/c2_w1_bl u_t012_014/c2_w1_br
+ u_t012_014/c2_r0_rbl u_t012_014/c2_r1_rbl u_t012_014/c3_w0_bl u_t012_014/c3_w0_br
+ u_t012_014/c3_w1_bl u_t012_014/c3_w1_br u_t012_014/c3_r0_rbl u_t012_014/c3_r1_rbl
+ u_t012_014/r0_w0_wl u_t012_014/r0_w1_wl u_t012_014/r0_r0_rwl u_t012_014/r0_r1_rwl
+ u_t012_014/r1_w0_wl u_t012_014/r1_w1_wl u_t012_014/r1_r0_rwl u_t012_014/r1_r1_rwl
+ u_t012_014/r2_w0_wl u_t012_014/r2_w1_wl u_t012_014/r2_r0_rwl u_t012_014/r2_r1_rwl
+ u_t012_014/r3_w0_wl u_t012_014/r3_w1_wl u_t012_014/r3_r0_rwl u_t012_014/r3_r1_rwl
+ u_t012_014/VDD u_t012_031/VSS VSUBS detronyx_12t_2w2r_rc4_4x4_routed_5layer_direct
Xu_t012_003 u_t012_003/c0_w0_bl u_t012_003/c0_w0_br u_t012_003/c0_w1_bl u_t012_003/c0_w1_br
+ u_t012_003/c0_r0_rbl u_t012_003/c0_r1_rbl u_t012_003/c1_w0_bl u_t012_003/c1_w0_br
+ u_t012_003/c1_w1_bl u_t012_003/c1_w1_br u_t012_003/c1_r0_rbl u_t012_003/c1_r1_rbl
+ u_t012_003/c2_w0_bl u_t012_003/c2_w0_br u_t012_003/c2_w1_bl u_t012_003/c2_w1_br
+ u_t012_003/c2_r0_rbl u_t012_003/c2_r1_rbl u_t012_003/c3_w0_bl u_t012_003/c3_w0_br
+ u_t012_003/c3_w1_bl u_t012_003/c3_w1_br u_t012_003/c3_r0_rbl u_t012_003/c3_r1_rbl
+ u_t012_003/r0_w0_wl u_t012_003/r0_w1_wl u_t012_003/r0_r0_rwl u_t012_003/r0_r1_rwl
+ u_t012_003/r1_w0_wl u_t012_003/r1_w1_wl u_t012_003/r1_r0_rwl u_t012_003/r1_r1_rwl
+ u_t012_003/r2_w0_wl u_t012_003/r2_w1_wl u_t012_003/r2_r0_rwl u_t012_003/r2_r1_rwl
+ u_t012_003/r3_w0_wl u_t012_003/r3_w1_wl u_t012_003/r3_r0_rwl u_t012_003/r3_r1_rwl
+ u_t012_003/VDD u_t012_031/VSS VSUBS detronyx_12t_2w2r_rc4_4x4_routed_5layer_direct
Xgf180mcu_as_sc_mcu7t3v3__inv_2_1473 VSS gf180mcu_as_sc_mcu7t3v3__inv_2_1497/VDD VSS
+ VSS gf180mcu_as_sc_mcu7t3v3__inv_2_1481/VNW VSUBS gf180mcu_as_sc_mcu7t3v3__inv_2
Xgf180mcu_as_sc_mcu7t3v3__inv_2_1462 gf180mcu_as_sc_mcu7t3v3__inv_2_1497/VSS VSS VSS
+ VSS gf180mcu_as_sc_mcu7t3v3__inv_2_1462/VNW VSUBS gf180mcu_as_sc_mcu7t3v3__inv_2
Xgf180mcu_as_sc_mcu7t3v3__inv_2_1484 VSS VSS VSS VSS gf180mcu_as_sc_mcu7t3v3__inv_2_1484/VNW
+ VSUBS gf180mcu_as_sc_mcu7t3v3__inv_2
Xgf180mcu_as_sc_mcu7t3v3__inv_2_1495 gf180mcu_as_sc_mcu7t3v3__inv_2_1496/VDD VSS VSS
+ VSS gf180mcu_as_sc_mcu7t3v3__inv_2_1496/VNW VSUBS gf180mcu_as_sc_mcu7t3v3__inv_2
Xgf180mcu_as_sc_mcu7t3v3__inv_2_1440 gf180mcu_as_sc_mcu7t3v3__inv_2_1440/VDD gf180mcu_as_sc_mcu7t3v3__inv_2_1444/VDD
+ gf180mcu_as_sc_mcu7t3v3__inv_2_1440/Y VSS gf180mcu_as_sc_mcu7t3v3__inv_2_1440/VNW
+ VSUBS gf180mcu_as_sc_mcu7t3v3__inv_2
Xgf180mcu_as_sc_mcu7t3v3__inv_2_1451 gf180mcu_as_sc_mcu7t3v3__inv_2_1499/VSS gf180mcu_as_sc_mcu7t3v3__inv_2_1457/VDD
+ VSS VSS gf180mcu_as_sc_mcu7t3v3__inv_2_1453/VNW VSUBS gf180mcu_as_sc_mcu7t3v3__inv_2
Xu_t003_003 u_t003_003/c0_w0_bl u_t003_003/c0_w0_br u_t003_003/c0_w1_bl u_t003_003/c0_w1_br
+ u_t003_003/c0_r0_rbl u_t003_003/c0_r1_rbl u_t003_003/c1_w0_bl u_t003_003/c1_w0_br
+ u_t003_003/c1_w1_bl u_t003_003/c1_w1_br u_t003_003/c1_r0_rbl u_t003_003/c1_r1_rbl
+ u_t003_003/c2_w0_bl u_t003_003/c2_w0_br u_t003_003/c2_w1_bl u_t003_003/c2_w1_br
+ u_t003_003/c2_r0_rbl u_t003_003/c2_r1_rbl u_t003_003/c3_w0_bl u_t003_003/c3_w0_br
+ u_t003_003/c3_w1_bl u_t003_003/c3_w1_br u_t003_003/c3_r0_rbl u_t003_003/c3_r1_rbl
+ u_t003_003/r0_w0_wl u_t003_003/r0_w1_wl u_t003_003/r0_r0_rwl u_t003_003/r0_r1_rwl
+ u_t003_003/r1_w0_wl u_t003_003/r1_w1_wl u_t003_003/r1_r0_rwl u_t003_003/r1_r1_rwl
+ u_t003_003/r2_w0_wl u_t003_003/r2_w1_wl u_t003_003/r2_r0_rwl u_t003_003/r2_r1_rwl
+ u_t003_003/r3_w0_wl u_t003_003/r3_w1_wl u_t003_003/r3_r0_rwl u_t003_003/r3_r1_rwl
+ u_t004_003/VDD u_t003_003/VSS VSUBS detronyx_12t_2w2r_rc4_4x4_routed_5layer_direct
Xgf180mcu_as_sc_mcu7t3v3__inv_2_902 VSS VSS VSS VSS gf180mcu_as_sc_mcu7t3v3__inv_2_949/VNW
+ VSUBS gf180mcu_as_sc_mcu7t3v3__inv_2
Xgf180mcu_as_sc_mcu7t3v3__inv_2_924 VSS VSS VSS VSS gf180mcu_as_sc_mcu7t3v3__inv_2_924/VNW
+ VSUBS gf180mcu_as_sc_mcu7t3v3__inv_2
Xgf180mcu_as_sc_mcu7t3v3__inv_2_935 VSS VSS VSS VSS gf180mcu_as_sc_mcu7t3v3__inv_2_936/VNW
+ VSUBS gf180mcu_as_sc_mcu7t3v3__inv_2
Xgf180mcu_as_sc_mcu7t3v3__inv_2_946 VSS VSS VSS VSS gf180mcu_as_sc_mcu7t3v3__inv_2_948/VNW
+ VSUBS gf180mcu_as_sc_mcu7t3v3__inv_2
Xgf180mcu_as_sc_mcu7t3v3__inv_2_968 gf180mcu_as_sc_mcu7t3v3__inv_2_970/VDD VSS VSS
+ gf180mcu_as_sc_mcu7t3v3__inv_2_991/A gf180mcu_as_sc_mcu7t3v3__inv_2_970/VNW VSUBS
+ gf180mcu_as_sc_mcu7t3v3__inv_2
Xgf180mcu_as_sc_mcu7t3v3__inv_2_957 gf180mcu_as_sc_mcu7t3v3__inv_2_987/VSS VSS gf180mcu_as_sc_mcu7t3v3__inv_2_991/A
+ gf180mcu_as_sc_mcu7t3v3__inv_2_958/Y gf180mcu_as_sc_mcu7t3v3__inv_2_958/VNW VSUBS
+ gf180mcu_as_sc_mcu7t3v3__inv_2
Xgf180mcu_as_sc_mcu7t3v3__inv_2_979 VSS VSS gf180mcu_as_sc_mcu7t3v3__inv_2_991/A gf180mcu_as_sc_mcu7t3v3__inv_2_983/Y
+ gf180mcu_as_sc_mcu7t3v3__inv_2_983/VNW VSUBS gf180mcu_as_sc_mcu7t3v3__inv_2
Xgf180mcu_as_sc_mcu7t3v3__inv_2_913 VSS VSS VSS VSS gf180mcu_as_sc_mcu7t3v3__inv_2_913/VNW
+ VSUBS gf180mcu_as_sc_mcu7t3v3__inv_2
Xu_t003_025 u_t003_025/c0_w0_bl u_t003_025/c0_w0_br u_t003_025/c0_w1_bl u_t003_025/c0_w1_br
+ u_t003_025/c0_r0_rbl u_t003_025/c0_r1_rbl u_t003_025/c1_w0_bl u_t003_025/c1_w0_br
+ u_t003_025/c1_w1_bl u_t003_025/c1_w1_br u_t003_025/c1_r0_rbl u_t003_025/c1_r1_rbl
+ u_t003_025/c2_w0_bl u_t003_025/c2_w0_br u_t003_025/c2_w1_bl u_t003_025/c2_w1_br
+ u_t003_025/c2_r0_rbl u_t003_025/c2_r1_rbl u_t003_025/c3_w0_bl u_t003_025/c3_w0_br
+ u_t003_025/c3_w1_bl u_t003_025/c3_w1_br u_t003_025/c3_r0_rbl u_t003_025/c3_r1_rbl
+ u_t003_025/r0_w0_wl u_t003_025/r0_w1_wl u_t003_025/r0_r0_rwl u_t003_025/r0_r1_rwl
+ u_t003_025/r1_w0_wl u_t003_025/r1_w1_wl u_t003_025/r1_r0_rwl u_t003_025/r1_r1_rwl
+ u_t003_025/r2_w0_wl u_t003_025/r2_w1_wl u_t003_025/r2_r0_rwl u_t003_025/r2_r1_rwl
+ u_t003_025/r3_w0_wl u_t003_025/r3_w1_wl u_t003_025/r3_r0_rwl u_t003_025/r3_r1_rwl
+ VSS u_t003_025/VSS VSUBS detronyx_12t_2w2r_rc4_4x4_routed_5layer_direct
Xu_t003_014 u_t003_014/c0_w0_bl u_t003_014/c0_w0_br u_t003_014/c0_w1_bl u_t003_014/c0_w1_br
+ u_t003_014/c0_r0_rbl u_t003_014/c0_r1_rbl u_t003_014/c1_w0_bl u_t003_014/c1_w0_br
+ u_t003_014/c1_w1_bl u_t003_014/c1_w1_br u_t003_014/c1_r0_rbl u_t003_014/c1_r1_rbl
+ u_t003_014/c2_w0_bl u_t003_014/c2_w0_br u_t003_014/c2_w1_bl u_t003_014/c2_w1_br
+ u_t003_014/c2_r0_rbl u_t003_014/c2_r1_rbl u_t003_014/c3_w0_bl u_t003_014/c3_w0_br
+ u_t003_014/c3_w1_bl u_t003_014/c3_w1_br u_t003_014/c3_r0_rbl u_t003_014/c3_r1_rbl
+ u_t003_014/r0_w0_wl u_t003_014/r0_w1_wl u_t003_014/r0_r0_rwl u_t003_014/r0_r1_rwl
+ u_t003_014/r1_w0_wl u_t003_014/r1_w1_wl u_t003_014/r1_r0_rwl u_t003_014/r1_r1_rwl
+ u_t003_014/r2_w0_wl u_t003_014/r2_w1_wl u_t003_014/r2_r0_rwl u_t003_014/r2_r1_rwl
+ u_t003_014/r3_w0_wl u_t003_014/r3_w1_wl u_t003_014/r3_r0_rwl u_t003_014/r3_r1_rwl
+ u_t004_014/VDD u_t003_017/VSS VSUBS detronyx_12t_2w2r_rc4_4x4_routed_5layer_direct
Xgf180mcu_as_sc_mcu7t3v3__nand4_2_201 gf180mcu_as_sc_mcu7t3v3__inv_2_741/VSS gf180mcu_as_sc_mcu7t3v3__inv_2_687/VDD
+ VSS VSS VSS VSS VSS gf180mcu_as_sc_mcu7t3v3__inv_2_683/VNW VSUBS gf180mcu_as_sc_mcu7t3v3__nand4_2
Xgf180mcu_as_sc_mcu7t3v3__nand4_2_267 VSS VSS VSS VSS VSS VSS VSS gf180mcu_as_sc_mcu7t3v3__inv_2_920/VNW
+ VSUBS gf180mcu_as_sc_mcu7t3v3__nand4_2
Xgf180mcu_as_sc_mcu7t3v3__nand4_2_212 VSS VSS VSS VSS VSS VSS VSS gf180mcu_as_sc_mcu7t3v3__inv_2_680/VNW
+ VSUBS gf180mcu_as_sc_mcu7t3v3__nand4_2
Xgf180mcu_as_sc_mcu7t3v3__nand4_2_223 VSS VSS VSS VSS VSS VSS VSS gf180mcu_as_sc_mcu7t3v3__inv_2_784/VNW
+ VSUBS gf180mcu_as_sc_mcu7t3v3__nand4_2
Xgf180mcu_as_sc_mcu7t3v3__nand4_2_245 VSS VSS VSS VSS VSS VSS gf180mcu_as_sc_mcu7t3v3__nand4_2_245/Y
+ gf180mcu_as_sc_mcu7t3v3__inv_2_841/VNW VSUBS gf180mcu_as_sc_mcu7t3v3__nand4_2
Xgf180mcu_as_sc_mcu7t3v3__nand4_2_234 VSS VSS VSS VSS VSS VSS gf180mcu_as_sc_mcu7t3v3__nand4_2_234/Y
+ gf180mcu_as_sc_mcu7t3v3__inv_2_828/VNW VSUBS gf180mcu_as_sc_mcu7t3v3__nand4_2
Xgf180mcu_as_sc_mcu7t3v3__nand4_2_289 VSS gf180mcu_as_sc_mcu7t3v3__inv_2_978/VDD VSS
+ VSS VSS VSS VSS gf180mcu_as_sc_mcu7t3v3__inv_2_974/VNW VSUBS gf180mcu_as_sc_mcu7t3v3__nand4_2
Xgf180mcu_as_sc_mcu7t3v3__nand4_2_256 VSS VSS VSS VSS VSS VSS VSS gf180mcu_as_sc_mcu7t3v3__inv_2_876/VNW
+ VSUBS gf180mcu_as_sc_mcu7t3v3__nand4_2
Xgf180mcu_as_sc_mcu7t3v3__nand4_2_278 VSS VSS VSS VSS VSS VSS VSS gf180mcu_as_sc_mcu7t3v3__inv_2_913/VNW
+ VSUBS gf180mcu_as_sc_mcu7t3v3__nand4_2
Xgf180mcu_as_sc_mcu7t3v3__inv_2_209 gf180mcu_as_sc_mcu7t3v3__inv_2_228/VSS VSS gf180mcu_as_sc_mcu7t3v3__inv_2_209/Y
+ VSS gf180mcu_as_sc_mcu7t3v3__inv_2_210/VNW VSUBS gf180mcu_as_sc_mcu7t3v3__inv_2
Xu_t000_028 u_t000_028/c0_w0_bl u_t000_028/c0_w0_br u_t000_028/c0_w1_bl u_t000_028/c0_w1_br
+ u_t000_028/c0_r0_rbl u_t000_028/c0_r1_rbl u_t000_028/c1_w0_bl u_t000_028/c1_w0_br
+ u_t000_028/c1_w1_bl u_t000_028/c1_w1_br u_t000_028/c1_r0_rbl u_t000_028/c1_r1_rbl
+ u_t000_028/c2_w0_bl u_t000_028/c2_w0_br u_t000_028/c2_w1_bl u_t000_028/c2_w1_br
+ u_t000_028/c2_r0_rbl u_t000_028/c2_r1_rbl u_t000_028/c3_w0_bl u_t000_028/c3_w0_br
+ u_t000_028/c3_w1_bl u_t000_028/c3_w1_br u_t000_028/c3_r0_rbl u_t000_028/c3_r1_rbl
+ u_t000_028/r0_w0_wl u_t000_028/r0_w1_wl u_t000_028/r0_r0_rwl u_t000_028/r0_r1_rwl
+ u_t000_028/r1_w0_wl u_t000_028/r1_w1_wl u_t000_028/r1_r0_rwl u_t000_028/r1_r1_rwl
+ u_t000_028/r2_w0_wl u_t000_028/r2_w1_wl u_t000_028/r2_r0_rwl u_t000_028/r2_r1_rwl
+ u_t000_028/r3_w0_wl u_t000_028/r3_w1_wl u_t000_028/r3_r0_rwl u_t000_028/r3_r1_rwl
+ u_t000_028/VDD u_t000_031/VSS VSUBS detronyx_12t_2w2r_rc4_4x4_routed_5layer_direct
Xu_t000_017 u_t000_017/c0_w0_bl u_t000_017/c0_w0_br u_t000_017/c0_w1_bl u_t000_017/c0_w1_br
+ u_t000_017/c0_r0_rbl u_t000_017/c0_r1_rbl u_t000_017/c1_w0_bl u_t000_017/c1_w0_br
+ u_t000_017/c1_w1_bl u_t000_017/c1_w1_br u_t000_017/c1_r0_rbl u_t000_017/c1_r1_rbl
+ u_t000_017/c2_w0_bl u_t000_017/c2_w0_br u_t000_017/c2_w1_bl u_t000_017/c2_w1_br
+ u_t000_017/c2_r0_rbl u_t000_017/c2_r1_rbl u_t000_017/c3_w0_bl u_t000_017/c3_w0_br
+ u_t000_017/c3_w1_bl u_t000_017/c3_w1_br u_t000_017/c3_r0_rbl u_t000_017/c3_r1_rbl
+ u_t000_017/r0_w0_wl u_t000_017/r0_w1_wl u_t000_017/r0_r0_rwl u_t000_017/r0_r1_rwl
+ u_t000_017/r1_w0_wl u_t000_017/r1_w1_wl u_t000_017/r1_r0_rwl u_t000_017/r1_r1_rwl
+ u_t000_017/r2_w0_wl u_t000_017/r2_w1_wl u_t000_017/r2_r0_rwl u_t000_017/r2_r1_rwl
+ u_t000_017/r3_w0_wl u_t000_017/r3_w1_wl u_t000_017/r3_r0_rwl u_t000_017/r3_r1_rwl
+ VSS u_t000_031/VSS VSUBS detronyx_12t_2w2r_rc4_4x4_routed_5layer_direct
Xu_t000_006 u_t000_006/c0_w0_bl u_t000_006/c0_w0_br u_t000_006/c0_w1_bl u_t000_006/c0_w1_br
+ u_t000_006/c0_r0_rbl u_t000_006/c0_r1_rbl u_t000_006/c1_w0_bl u_t000_006/c1_w0_br
+ u_t000_006/c1_w1_bl u_t000_006/c1_w1_br u_t000_006/c1_r0_rbl u_t000_006/c1_r1_rbl
+ u_t000_006/c2_w0_bl u_t000_006/c2_w0_br u_t000_006/c2_w1_bl u_t000_006/c2_w1_br
+ u_t000_006/c2_r0_rbl u_t000_006/c2_r1_rbl u_t000_006/c3_w0_bl u_t000_006/c3_w0_br
+ u_t000_006/c3_w1_bl u_t000_006/c3_w1_br u_t000_006/c3_r0_rbl u_t000_006/c3_r1_rbl
+ u_t000_006/r0_w0_wl u_t000_006/r0_w1_wl u_t000_006/r0_r0_rwl u_t000_006/r0_r1_rwl
+ u_t000_006/r1_w0_wl u_t000_006/r1_w1_wl u_t000_006/r1_r0_rwl u_t000_006/r1_r1_rwl
+ u_t000_006/r2_w0_wl u_t000_006/r2_w1_wl u_t000_006/r2_r0_rwl u_t000_006/r2_r1_rwl
+ u_t000_006/r3_w0_wl u_t000_006/r3_w1_wl u_t000_006/r3_r0_rwl u_t000_006/r3_r1_rwl
+ u_t000_006/VDD u_t000_031/VSS VSUBS detronyx_12t_2w2r_rc4_4x4_routed_5layer_direct
Xgf180mcu_as_sc_mcu7t3v3__inv_2_1270 gf180mcu_as_sc_mcu7t3v3__nand3_2_31/VDD gf180mcu_as_sc_mcu7t3v3__nor2_2_8/VSS
+ VSS VSS gf180mcu_as_sc_mcu7t3v3__nand3_2_31/VNW VSUBS gf180mcu_as_sc_mcu7t3v3__inv_2
Xgf180mcu_as_sc_mcu7t3v3__inv_2_1281 VSS VSS gf180mcu_as_sc_mcu7t3v3__inv_2_1281/Y
+ VSS gf180mcu_as_sc_mcu7t3v3__inv_2_1281/VNW VSUBS gf180mcu_as_sc_mcu7t3v3__inv_2
Xgf180mcu_as_sc_mcu7t3v3__inv_2_1292 VSS VSS gf180mcu_as_sc_mcu7t3v3__inv_2_1292/Y
+ VSS gf180mcu_as_sc_mcu7t3v3__inv_2_1292/VNW VSUBS gf180mcu_as_sc_mcu7t3v3__inv_2
Xgf180mcu_as_sc_mcu7t3v3__inv_2_754 VSS VSS gf180mcu_as_sc_mcu7t3v3__inv_2_754/Y VSS
+ gf180mcu_as_sc_mcu7t3v3__inv_2_756/VNW VSUBS gf180mcu_as_sc_mcu7t3v3__inv_2
Xgf180mcu_as_sc_mcu7t3v3__inv_2_765 VSS VSS gf180mcu_as_sc_mcu7t3v3__inv_2_765/Y VSS
+ gf180mcu_as_sc_mcu7t3v3__inv_2_765/VNW VSUBS gf180mcu_as_sc_mcu7t3v3__inv_2
Xgf180mcu_as_sc_mcu7t3v3__inv_2_743 VSS VSS gf180mcu_as_sc_mcu7t3v3__inv_2_743/Y VSS
+ gf180mcu_as_sc_mcu7t3v3__inv_2_745/VNW VSUBS gf180mcu_as_sc_mcu7t3v3__inv_2
Xgf180mcu_as_sc_mcu7t3v3__inv_2_787 VSS VSS VSS VSS gf180mcu_as_sc_mcu7t3v3__inv_2_788/VNW
+ VSUBS gf180mcu_as_sc_mcu7t3v3__inv_2
Xgf180mcu_as_sc_mcu7t3v3__inv_2_776 VSS VSS gf180mcu_as_sc_mcu7t3v3__inv_2_776/Y VSS
+ gf180mcu_as_sc_mcu7t3v3__inv_2_776/VNW VSUBS gf180mcu_as_sc_mcu7t3v3__inv_2
Xgf180mcu_as_sc_mcu7t3v3__inv_2_721 gf180mcu_as_sc_mcu7t3v3__inv_2_723/VDD VSS gf180mcu_as_sc_mcu7t3v3__inv_2_721/Y
+ gf180mcu_as_sc_mcu7t3v3__inv_2_732/Y gf180mcu_as_sc_mcu7t3v3__inv_2_723/VNW VSUBS
+ gf180mcu_as_sc_mcu7t3v3__inv_2
Xgf180mcu_as_sc_mcu7t3v3__inv_2_798 VSS VSS gf180mcu_as_sc_mcu7t3v3__inv_2_798/Y VSS
+ gf180mcu_as_sc_mcu7t3v3__inv_2_800/VNW VSUBS gf180mcu_as_sc_mcu7t3v3__inv_2
Xgf180mcu_as_sc_mcu7t3v3__inv_2_710 gf180mcu_as_sc_mcu7t3v3__inv_2_711/VDD VSS gf180mcu_as_sc_mcu7t3v3__inv_2_732/Y
+ gf180mcu_as_sc_mcu7t3v3__inv_2_711/Y gf180mcu_as_sc_mcu7t3v3__inv_2_711/VNW VSUBS
+ gf180mcu_as_sc_mcu7t3v3__inv_2
Xgf180mcu_as_sc_mcu7t3v3__inv_2_732 VSS VSS gf180mcu_as_sc_mcu7t3v3__inv_2_732/Y gf180mcu_as_sc_mcu7t3v3__inv_2_736/Y
+ gf180mcu_as_sc_mcu7t3v3__inv_2_736/VNW VSUBS gf180mcu_as_sc_mcu7t3v3__inv_2
Xgf180mcu_as_sc_mcu7t3v3__nand4_2_1 gf180mcu_as_sc_mcu7t3v3__inv_2_69/VSS gf180mcu_as_sc_mcu7t3v3__inv_2_2/VDD
+ VSS VSS VSS VSS VSS gf180mcu_as_sc_mcu7t3v3__inv_2_54/VNW VSUBS gf180mcu_as_sc_mcu7t3v3__nand4_2
Xgf180mcu_as_sc_mcu7t3v3__inv_2_584 gf180mcu_as_sc_mcu7t3v3__inv_2_584/VDD gf180mcu_as_sc_mcu7t3v3__inv_2_585/VDD
+ gf180mcu_as_sc_mcu7t3v3__inv_2_584/Y VSS gf180mcu_as_sc_mcu7t3v3__inv_2_584/VNW
+ VSUBS gf180mcu_as_sc_mcu7t3v3__inv_2
Xgf180mcu_as_sc_mcu7t3v3__inv_2_562 gf180mcu_as_sc_mcu7t3v3__inv_2_585/VDD gf180mcu_as_sc_mcu7t3v3__inv_2_585/VSS
+ gf180mcu_as_sc_mcu7t3v3__inv_2_562/Y gf180mcu_as_sc_mcu7t3v3__inv_2_566/Y gf180mcu_as_sc_mcu7t3v3__inv_2_585/VNW
+ VSUBS gf180mcu_as_sc_mcu7t3v3__inv_2
Xgf180mcu_as_sc_mcu7t3v3__inv_2_573 gf180mcu_as_sc_mcu7t3v3__inv_2_585/VSS VSS gf180mcu_as_sc_mcu7t3v3__inv_2_573/Y
+ VSS gf180mcu_as_sc_mcu7t3v3__inv_2_581/VNW VSUBS gf180mcu_as_sc_mcu7t3v3__inv_2
Xgf180mcu_as_sc_mcu7t3v3__inv_2_551 gf180mcu_as_sc_mcu7t3v3__nor2_2_6/VDD gf180mcu_as_sc_mcu7t3v3__nand3_2_3/VSS
+ VSS VSS gf180mcu_as_sc_mcu7t3v3__nor2_2_6/VNW VSUBS gf180mcu_as_sc_mcu7t3v3__inv_2
Xgf180mcu_as_sc_mcu7t3v3__inv_2_595 gf180mcu_as_sc_mcu7t3v3__inv_2_597/VDD gf180mcu_as_sc_mcu7t3v3__inv_2_601/VDD
+ gf180mcu_as_sc_mcu7t3v3__inv_2_595/Y gf180mcu_as_sc_mcu7t3v3__inv_2_631/A gf180mcu_as_sc_mcu7t3v3__inv_2_597/VNW
+ VSUBS gf180mcu_as_sc_mcu7t3v3__inv_2
Xgf180mcu_as_sc_mcu7t3v3__inv_2_540 VSS VSS gf180mcu_as_sc_mcu7t3v3__inv_2_540/Y VSS
+ gf180mcu_as_sc_mcu7t3v3__inv_2_542/VNW VSUBS gf180mcu_as_sc_mcu7t3v3__inv_2
Xu_t028_009 u_t028_009/c0_w0_bl u_t028_009/c0_w0_br u_t028_009/c0_w1_bl u_t028_009/c0_w1_br
+ u_t028_009/c0_r0_rbl u_t028_009/c0_r1_rbl u_t028_009/c1_w0_bl u_t028_009/c1_w0_br
+ u_t028_009/c1_w1_bl u_t028_009/c1_w1_br u_t028_009/c1_r0_rbl u_t028_009/c1_r1_rbl
+ u_t028_009/c2_w0_bl u_t028_009/c2_w0_br u_t028_009/c2_w1_bl u_t028_009/c2_w1_br
+ u_t028_009/c2_r0_rbl u_t028_009/c2_r1_rbl u_t028_009/c3_w0_bl u_t028_009/c3_w0_br
+ u_t028_009/c3_w1_bl u_t028_009/c3_w1_br u_t028_009/c3_r0_rbl u_t028_009/c3_r1_rbl
+ u_t028_009/r0_w0_wl u_t028_009/r0_w1_wl u_t028_009/r0_r0_rwl u_t028_009/r0_r1_rwl
+ u_t028_009/r1_w0_wl u_t028_009/r1_w1_wl u_t028_009/r1_r0_rwl u_t028_009/r1_r1_rwl
+ u_t028_009/r2_w0_wl u_t028_009/r2_w1_wl u_t028_009/r2_r0_rwl u_t028_009/r2_r1_rwl
+ u_t028_009/r3_w0_wl u_t028_009/r3_w1_wl u_t028_009/r3_r0_rwl u_t028_009/r3_r1_rwl
+ VSS u_t028_009/VSS VSUBS detronyx_12t_2w2r_rc4_4x4_routed_5layer_direct
Xgf180mcu_as_sc_mcu7t3v3__inv_2_370 gf180mcu_as_sc_mcu7t3v3__inv_2_371/VDD gf180mcu_as_sc_mcu7t3v3__inv_2_371/VSS
+ VSS VSS gf180mcu_as_sc_mcu7t3v3__inv_2_371/VNW VSUBS gf180mcu_as_sc_mcu7t3v3__inv_2
Xgf180mcu_as_sc_mcu7t3v3__inv_2_392 VSS VSS VSS VSS gf180mcu_as_sc_mcu7t3v3__inv_2_450/VNW
+ VSUBS gf180mcu_as_sc_mcu7t3v3__inv_2
Xgf180mcu_as_sc_mcu7t3v3__inv_2_381 gf180mcu_as_sc_mcu7t3v3__nor2_2_4/VDD gf180mcu_as_sc_mcu7t3v3__nand3_2_8/VSS
+ VSS VSS gf180mcu_as_sc_mcu7t3v3__nor2_2_4/VNW VSUBS gf180mcu_as_sc_mcu7t3v3__inv_2
Xu_t027_031 u_t027_031/c0_w0_bl u_t027_031/c0_w0_br u_t027_031/c0_w1_bl u_t027_031/c0_w1_br
+ u_t027_031/c0_r0_rbl u_t027_031/c0_r1_rbl u_t027_031/c1_w0_bl u_t027_031/c1_w0_br
+ u_t027_031/c1_w1_bl u_t027_031/c1_w1_br u_t027_031/c1_r0_rbl u_t027_031/c1_r1_rbl
+ u_t027_031/c2_w0_bl u_t027_031/c2_w0_br u_t027_031/c2_w1_bl u_t027_031/c2_w1_br
+ u_t027_031/c2_r0_rbl u_t027_031/c2_r1_rbl u_t027_031/c3_w0_bl u_t027_031/c3_w0_br
+ u_t027_031/c3_w1_bl u_t027_031/c3_w1_br u_t027_031/c3_r0_rbl u_t027_031/c3_r1_rbl
+ u_t027_031/r0_w0_wl u_t027_031/r0_w1_wl u_t027_031/r0_r0_rwl u_t027_031/r0_r1_rwl
+ u_t027_031/r1_w0_wl u_t027_031/r1_w1_wl u_t027_031/r1_r0_rwl u_t027_031/r1_r1_rwl
+ u_t027_031/r2_w0_wl u_t027_031/r2_w1_wl u_t027_031/r2_r0_rwl u_t027_031/r2_r1_rwl
+ u_t027_031/r3_w0_wl u_t027_031/r3_w1_wl u_t027_031/r3_r0_rwl u_t027_031/r3_r1_rwl
+ VSS u_t027_031/VSS VSUBS detronyx_12t_2w2r_rc4_4x4_routed_5layer_direct
Xu_t027_020 u_t027_020/c0_w0_bl u_t027_020/c0_w0_br u_t027_020/c0_w1_bl u_t027_020/c0_w1_br
+ u_t027_020/c0_r0_rbl u_t027_020/c0_r1_rbl u_t027_020/c1_w0_bl u_t027_020/c1_w0_br
+ u_t027_020/c1_w1_bl u_t027_020/c1_w1_br u_t027_020/c1_r0_rbl u_t027_020/c1_r1_rbl
+ u_t027_020/c2_w0_bl u_t027_020/c2_w0_br u_t027_020/c2_w1_bl u_t027_020/c2_w1_br
+ u_t027_020/c2_r0_rbl u_t027_020/c2_r1_rbl u_t027_020/c3_w0_bl u_t027_020/c3_w0_br
+ u_t027_020/c3_w1_bl u_t027_020/c3_w1_br u_t027_020/c3_r0_rbl u_t027_020/c3_r1_rbl
+ u_t027_020/r0_w0_wl u_t027_020/r0_w1_wl u_t027_020/r0_r0_rwl u_t027_020/r0_r1_rwl
+ u_t027_020/r1_w0_wl u_t027_020/r1_w1_wl u_t027_020/r1_r0_rwl u_t027_020/r1_r1_rwl
+ u_t027_020/r2_w0_wl u_t027_020/r2_w1_wl u_t027_020/r2_r0_rwl u_t027_020/r2_r1_rwl
+ u_t027_020/r3_w0_wl u_t027_020/r3_w1_wl u_t027_020/r3_r0_rwl u_t027_020/r3_r1_rwl
+ u_t027_020/VDD u_t027_020/VSS VSUBS detronyx_12t_2w2r_rc4_4x4_routed_5layer_direct
Xu_t019_009 u_t019_009/c0_w0_bl u_t019_009/c0_w0_br u_t019_009/c0_w1_bl u_t019_009/c0_w1_br
+ u_t019_009/c0_r0_rbl u_t019_009/c0_r1_rbl u_t019_009/c1_w0_bl u_t019_009/c1_w0_br
+ u_t019_009/c1_w1_bl u_t019_009/c1_w1_br u_t019_009/c1_r0_rbl u_t019_009/c1_r1_rbl
+ u_t019_009/c2_w0_bl u_t019_009/c2_w0_br u_t019_009/c2_w1_bl u_t019_009/c2_w1_br
+ u_t019_009/c2_r0_rbl u_t019_009/c2_r1_rbl u_t019_009/c3_w0_bl u_t019_009/c3_w0_br
+ u_t019_009/c3_w1_bl u_t019_009/c3_w1_br u_t019_009/c3_r0_rbl u_t019_009/c3_r1_rbl
+ u_t019_009/r0_w0_wl u_t019_009/r0_w1_wl u_t019_009/r0_r0_rwl u_t019_009/r0_r1_rwl
+ u_t019_009/r1_w0_wl u_t019_009/r1_w1_wl u_t019_009/r1_r0_rwl u_t019_009/r1_r1_rwl
+ u_t019_009/r2_w0_wl u_t019_009/r2_w1_wl u_t019_009/r2_r0_rwl u_t019_009/r2_r1_rwl
+ u_t019_009/r3_w0_wl u_t019_009/r3_w1_wl u_t019_009/r3_r0_rwl u_t019_009/r3_r1_rwl
+ VSS u_t019_009/VSS VSUBS detronyx_12t_2w2r_rc4_4x4_routed_5layer_direct
Xu_t018_031 u_t018_031/c0_w0_bl u_t018_031/c0_w0_br u_t018_031/c0_w1_bl u_t018_031/c0_w1_br
+ u_t018_031/c0_r0_rbl u_t018_031/c0_r1_rbl u_t018_031/c1_w0_bl u_t018_031/c1_w0_br
+ u_t018_031/c1_w1_bl u_t018_031/c1_w1_br u_t018_031/c1_r0_rbl u_t018_031/c1_r1_rbl
+ u_t018_031/c2_w0_bl u_t018_031/c2_w0_br u_t018_031/c2_w1_bl u_t018_031/c2_w1_br
+ u_t018_031/c2_r0_rbl u_t018_031/c2_r1_rbl u_t018_031/c3_w0_bl u_t018_031/c3_w0_br
+ u_t018_031/c3_w1_bl u_t018_031/c3_w1_br u_t018_031/c3_r0_rbl u_t018_031/c3_r1_rbl
+ u_t018_031/r0_w0_wl u_t018_031/r0_w1_wl u_t018_031/r0_r0_rwl u_t018_031/r0_r1_rwl
+ u_t018_031/r1_w0_wl u_t018_031/r1_w1_wl u_t018_031/r1_r0_rwl u_t018_031/r1_r1_rwl
+ u_t018_031/r2_w0_wl u_t018_031/r2_w1_wl u_t018_031/r2_r0_rwl u_t018_031/r2_r1_rwl
+ u_t018_031/r3_w0_wl u_t018_031/r3_w1_wl u_t018_031/r3_r0_rwl u_t018_031/r3_r1_rwl
+ VSS u_t018_031/VSS VSUBS detronyx_12t_2w2r_rc4_4x4_routed_5layer_direct
Xu_t018_020 u_t018_020/c0_w0_bl u_t018_020/c0_w0_br u_t018_020/c0_w1_bl u_t018_020/c0_w1_br
+ u_t018_020/c0_r0_rbl u_t018_020/c0_r1_rbl u_t018_020/c1_w0_bl u_t018_020/c1_w0_br
+ u_t018_020/c1_w1_bl u_t018_020/c1_w1_br u_t018_020/c1_r0_rbl u_t018_020/c1_r1_rbl
+ u_t018_020/c2_w0_bl u_t018_020/c2_w0_br u_t018_020/c2_w1_bl u_t018_020/c2_w1_br
+ u_t018_020/c2_r0_rbl u_t018_020/c2_r1_rbl u_t018_020/c3_w0_bl u_t018_020/c3_w0_br
+ u_t018_020/c3_w1_bl u_t018_020/c3_w1_br u_t018_020/c3_r0_rbl u_t018_020/c3_r1_rbl
+ u_t018_020/r0_w0_wl u_t018_020/r0_w1_wl u_t018_020/r0_r0_rwl u_t018_020/r0_r1_rwl
+ u_t018_020/r1_w0_wl u_t018_020/r1_w1_wl u_t018_020/r1_r0_rwl u_t018_020/r1_r1_rwl
+ u_t018_020/r2_w0_wl u_t018_020/r2_w1_wl u_t018_020/r2_r0_rwl u_t018_020/r2_r1_rwl
+ u_t018_020/r3_w0_wl u_t018_020/r3_w1_wl u_t018_020/r3_r0_rwl u_t018_020/r3_r1_rwl
+ u_t018_020/VDD u_t018_020/VSS VSUBS detronyx_12t_2w2r_rc4_4x4_routed_5layer_direct
Xu_t009_031 u_t009_031/c0_w0_bl u_t009_031/c0_w0_br u_t009_031/c0_w1_bl u_t009_031/c0_w1_br
+ u_t009_031/c0_r0_rbl u_t009_031/c0_r1_rbl u_t009_031/c1_w0_bl u_t009_031/c1_w0_br
+ u_t009_031/c1_w1_bl u_t009_031/c1_w1_br u_t009_031/c1_r0_rbl u_t009_031/c1_r1_rbl
+ u_t009_031/c2_w0_bl u_t009_031/c2_w0_br u_t009_031/c2_w1_bl u_t009_031/c2_w1_br
+ u_t009_031/c2_r0_rbl u_t009_031/c2_r1_rbl u_t009_031/c3_w0_bl u_t009_031/c3_w0_br
+ u_t009_031/c3_w1_bl u_t009_031/c3_w1_br u_t009_031/c3_r0_rbl u_t009_031/c3_r1_rbl
+ u_t009_031/r0_w0_wl u_t009_031/r0_w1_wl u_t009_031/r0_r0_rwl u_t009_031/r0_r1_rwl
+ u_t009_031/r1_w0_wl u_t009_031/r1_w1_wl u_t009_031/r1_r0_rwl u_t009_031/r1_r1_rwl
+ u_t009_031/r2_w0_wl u_t009_031/r2_w1_wl u_t009_031/r2_r0_rwl u_t009_031/r2_r1_rwl
+ u_t009_031/r3_w0_wl u_t009_031/r3_w1_wl u_t009_031/r3_r0_rwl u_t009_031/r3_r1_rwl
+ VSS u_t009_031/VSS VSUBS detronyx_12t_2w2r_rc4_4x4_routed_5layer_direct
Xu_t009_020 u_t009_020/c0_w0_bl u_t009_020/c0_w0_br u_t009_020/c0_w1_bl u_t009_020/c0_w1_br
+ u_t009_020/c0_r0_rbl u_t009_020/c0_r1_rbl u_t009_020/c1_w0_bl u_t009_020/c1_w0_br
+ u_t009_020/c1_w1_bl u_t009_020/c1_w1_br u_t009_020/c1_r0_rbl u_t009_020/c1_r1_rbl
+ u_t009_020/c2_w0_bl u_t009_020/c2_w0_br u_t009_020/c2_w1_bl u_t009_020/c2_w1_br
+ u_t009_020/c2_r0_rbl u_t009_020/c2_r1_rbl u_t009_020/c3_w0_bl u_t009_020/c3_w0_br
+ u_t009_020/c3_w1_bl u_t009_020/c3_w1_br u_t009_020/c3_r0_rbl u_t009_020/c3_r1_rbl
+ u_t009_020/r0_w0_wl u_t009_020/r0_w1_wl u_t009_020/r0_r0_rwl u_t009_020/r0_r1_rwl
+ u_t009_020/r1_w0_wl u_t009_020/r1_w1_wl u_t009_020/r1_r0_rwl u_t009_020/r1_r1_rwl
+ u_t009_020/r2_w0_wl u_t009_020/r2_w1_wl u_t009_020/r2_r0_rwl u_t009_020/r2_r1_rwl
+ u_t009_020/r3_w0_wl u_t009_020/r3_w1_wl u_t009_020/r3_r0_rwl u_t009_020/r3_r1_rwl
+ u_t009_020/VDD u_t009_031/VSS VSUBS detronyx_12t_2w2r_rc4_4x4_routed_5layer_direct
Xgf180mcu_as_sc_mcu7t3v3__nand3_2_24 gf180mcu_as_sc_mcu7t3v3__nor2_2_8/VDD gf180mcu_as_sc_mcu7t3v3__nand3_2_32/VSS
+ VSS VSS VSS VSS gf180mcu_as_sc_mcu7t3v3__nor2_2_8/VNW VSUBS gf180mcu_as_sc_mcu7t3v3__nand3_2
Xgf180mcu_as_sc_mcu7t3v3__nand3_2_13 gf180mcu_as_sc_mcu7t3v3__nand3_2_5/VDD gf180mcu_as_sc_mcu7t3v3__nor2_2_6/VSS
+ VSS VSS VSS VSS gf180mcu_as_sc_mcu7t3v3__nand3_2_5/VNW VSUBS gf180mcu_as_sc_mcu7t3v3__nand3_2
Xu_t024_023 u_t024_023/c0_w0_bl u_t024_023/c0_w0_br u_t024_023/c0_w1_bl u_t024_023/c0_w1_br
+ u_t024_023/c0_r0_rbl u_t024_023/c0_r1_rbl u_t024_023/c1_w0_bl u_t024_023/c1_w0_br
+ u_t024_023/c1_w1_bl u_t024_023/c1_w1_br u_t024_023/c1_r0_rbl u_t024_023/c1_r1_rbl
+ u_t024_023/c2_w0_bl u_t024_023/c2_w0_br u_t024_023/c2_w1_bl u_t024_023/c2_w1_br
+ u_t024_023/c2_r0_rbl u_t024_023/c2_r1_rbl u_t024_023/c3_w0_bl u_t024_023/c3_w0_br
+ u_t024_023/c3_w1_bl u_t024_023/c3_w1_br u_t024_023/c3_r0_rbl u_t024_023/c3_r1_rbl
+ u_t024_023/r0_w0_wl u_t024_023/r0_w1_wl u_t024_023/r0_r0_rwl u_t024_023/r0_r1_rwl
+ u_t024_023/r1_w0_wl u_t024_023/r1_w1_wl u_t024_023/r1_r0_rwl u_t024_023/r1_r1_rwl
+ u_t024_023/r2_w0_wl u_t024_023/r2_w1_wl u_t024_023/r2_r0_rwl u_t024_023/r2_r1_rwl
+ u_t024_023/r3_w0_wl u_t024_023/r3_w1_wl u_t024_023/r3_r0_rwl u_t024_023/r3_r1_rwl
+ VSS u_t024_024/VSS VSUBS detronyx_12t_2w2r_rc4_4x4_routed_5layer_direct
Xu_t024_012 u_t024_012/c0_w0_bl u_t024_012/c0_w0_br u_t024_012/c0_w1_bl u_t024_012/c0_w1_br
+ u_t024_012/c0_r0_rbl u_t024_012/c0_r1_rbl u_t024_012/c1_w0_bl u_t024_012/c1_w0_br
+ u_t024_012/c1_w1_bl u_t024_012/c1_w1_br u_t024_012/c1_r0_rbl u_t024_012/c1_r1_rbl
+ u_t024_012/c2_w0_bl u_t024_012/c2_w0_br u_t024_012/c2_w1_bl u_t024_012/c2_w1_br
+ u_t024_012/c2_r0_rbl u_t024_012/c2_r1_rbl u_t024_012/c3_w0_bl u_t024_012/c3_w0_br
+ u_t024_012/c3_w1_bl u_t024_012/c3_w1_br u_t024_012/c3_r0_rbl u_t024_012/c3_r1_rbl
+ u_t024_012/r0_w0_wl u_t024_012/r0_w1_wl u_t024_012/r0_r0_rwl u_t024_012/r0_r1_rwl
+ u_t024_012/r1_w0_wl u_t024_012/r1_w1_wl u_t024_012/r1_r0_rwl u_t024_012/r1_r1_rwl
+ u_t024_012/r2_w0_wl u_t024_012/r2_w1_wl u_t024_012/r2_r0_rwl u_t024_012/r2_r1_rwl
+ u_t024_012/r3_w0_wl u_t024_012/r3_w1_wl u_t024_012/r3_r0_rwl u_t024_012/r3_r1_rwl
+ u_t025_012/VDD u_t024_012/VSS VSUBS detronyx_12t_2w2r_rc4_4x4_routed_5layer_direct
Xu_t024_001 u_t024_001/c0_w0_bl u_t024_001/c0_w0_br u_t024_001/c0_w1_bl u_t024_001/c0_w1_br
+ u_t024_001/c0_r0_rbl u_t024_001/c0_r1_rbl u_t024_001/c1_w0_bl u_t024_001/c1_w0_br
+ u_t024_001/c1_w1_bl u_t024_001/c1_w1_br u_t024_001/c1_r0_rbl u_t024_001/c1_r1_rbl
+ u_t024_001/c2_w0_bl u_t024_001/c2_w0_br u_t024_001/c2_w1_bl u_t024_001/c2_w1_br
+ u_t024_001/c2_r0_rbl u_t024_001/c2_r1_rbl u_t024_001/c3_w0_bl u_t024_001/c3_w0_br
+ u_t024_001/c3_w1_bl u_t024_001/c3_w1_br u_t024_001/c3_r0_rbl u_t024_001/c3_r1_rbl
+ u_t024_001/r0_w0_wl u_t024_001/r0_w1_wl u_t024_001/r0_r0_rwl u_t024_001/r0_r1_rwl
+ u_t024_001/r1_w0_wl u_t024_001/r1_w1_wl u_t024_001/r1_r0_rwl u_t024_001/r1_r1_rwl
+ u_t024_001/r2_w0_wl u_t024_001/r2_w1_wl u_t024_001/r2_r0_rwl u_t024_001/r2_r1_rwl
+ u_t024_001/r3_w0_wl u_t024_001/r3_w1_wl u_t024_001/r3_r0_rwl u_t024_001/r3_r1_rwl
+ VSS u_t024_002/VSS VSUBS detronyx_12t_2w2r_rc4_4x4_routed_5layer_direct
Xgf180mcu_as_sc_mcu7t3v3__inv_2_1633 gf180mcu_as_sc_mcu7t3v3__inv_2_1672/VDD VSS VSS
+ gf180mcu_as_sc_mcu7t3v3__inv_2_1675/Y gf180mcu_as_sc_mcu7t3v3__inv_2_1672/VNW VSUBS
+ gf180mcu_as_sc_mcu7t3v3__inv_2
Xgf180mcu_as_sc_mcu7t3v3__inv_2_1677 VSS gf180mcu_as_sc_mcu7t3v3__inv_2_1678/VDD gf180mcu_as_sc_mcu7t3v3__inv_2_1678/Y
+ VSS gf180mcu_as_sc_mcu7t3v3__inv_2_1677/VNW VSUBS gf180mcu_as_sc_mcu7t3v3__inv_2
Xgf180mcu_as_sc_mcu7t3v3__inv_2_1644 gf180mcu_as_sc_mcu7t3v3__inv_2_1678/VDD VSS gf180mcu_as_sc_mcu7t3v3__inv_2_1644/Y
+ gf180mcu_as_sc_mcu7t3v3__inv_2_1678/Y gf180mcu_as_sc_mcu7t3v3__inv_2_1678/VNW VSUBS
+ gf180mcu_as_sc_mcu7t3v3__inv_2
Xgf180mcu_as_sc_mcu7t3v3__inv_2_1666 VSS gf180mcu_as_sc_mcu7t3v3__inv_2_1667/VDD gf180mcu_as_sc_mcu7t3v3__inv_2_1682/Y
+ VSS gf180mcu_as_sc_mcu7t3v3__inv_2_1666/VNW VSUBS gf180mcu_as_sc_mcu7t3v3__inv_2
Xgf180mcu_as_sc_mcu7t3v3__inv_2_1611 VSS VSS gf180mcu_as_sc_mcu7t3v3__inv_2_1657/Y
+ gf180mcu_as_sc_mcu7t3v3__inv_2_1657/Y gf180mcu_as_sc_mcu7t3v3__inv_2_1655/VNW VSUBS
+ gf180mcu_as_sc_mcu7t3v3__inv_2
Xgf180mcu_as_sc_mcu7t3v3__inv_2_1655 VSS VSS gf180mcu_as_sc_mcu7t3v3__inv_2_1657/Y
+ VSS gf180mcu_as_sc_mcu7t3v3__inv_2_1655/VNW VSUBS gf180mcu_as_sc_mcu7t3v3__inv_2
Xgf180mcu_as_sc_mcu7t3v3__inv_2_1622 VSS VSS VSS gf180mcu_as_sc_mcu7t3v3__inv_2_1660/Y
+ gf180mcu_as_sc_mcu7t3v3__inv_2_1658/VNW VSUBS gf180mcu_as_sc_mcu7t3v3__inv_2
Xgf180mcu_as_sc_mcu7t3v3__inv_2_1600 gf180mcu_as_sc_mcu7t3v3__inv_2_1660/VDD VSS VSS
+ gf180mcu_as_sc_mcu7t3v3__inv_2_1660/Y gf180mcu_as_sc_mcu7t3v3__inv_2_1660/VNW VSUBS
+ gf180mcu_as_sc_mcu7t3v3__inv_2
Xgf180mcu_as_sc_mcu7t3v3__inv_2_1688 gf180mcu_as_sc_mcu7t3v3__inv_2_1688/VDD VSS VSS
+ VSS gf180mcu_as_sc_mcu7t3v3__inv_2_1688/VNW VSUBS gf180mcu_as_sc_mcu7t3v3__inv_2
Xgf180mcu_as_sc_mcu7t3v3__inv_2_1699 gf180mcu_as_sc_mcu7t3v3__inv_2_990/VSS VSS gf180mcu_as_sc_mcu7t3v3__inv_2_1699/Y
+ gf180mcu_as_sc_mcu7t3v3__inv_2_1700/Y gf180mcu_as_sc_mcu7t3v3__inv_2_1700/VNW VSUBS
+ gf180mcu_as_sc_mcu7t3v3__inv_2
Xu_t015_023 u_t015_023/c0_w0_bl u_t015_023/c0_w0_br u_t015_023/c0_w1_bl u_t015_023/c0_w1_br
+ u_t015_023/c0_r0_rbl u_t015_023/c0_r1_rbl u_t015_023/c1_w0_bl u_t015_023/c1_w0_br
+ u_t015_023/c1_w1_bl u_t015_023/c1_w1_br u_t015_023/c1_r0_rbl u_t015_023/c1_r1_rbl
+ u_t015_023/c2_w0_bl u_t015_023/c2_w0_br u_t015_023/c2_w1_bl u_t015_023/c2_w1_br
+ u_t015_023/c2_r0_rbl u_t015_023/c2_r1_rbl u_t015_023/c3_w0_bl u_t015_023/c3_w0_br
+ u_t015_023/c3_w1_bl u_t015_023/c3_w1_br u_t015_023/c3_r0_rbl u_t015_023/c3_r1_rbl
+ u_t015_023/r0_w0_wl u_t015_023/r0_w1_wl u_t015_023/r0_r0_rwl u_t015_023/r0_r1_rwl
+ u_t015_023/r1_w0_wl u_t015_023/r1_w1_wl u_t015_023/r1_r0_rwl u_t015_023/r1_r1_rwl
+ u_t015_023/r2_w0_wl u_t015_023/r2_w1_wl u_t015_023/r2_r0_rwl u_t015_023/r2_r1_rwl
+ u_t015_023/r3_w0_wl u_t015_023/r3_w1_wl u_t015_023/r3_r0_rwl u_t015_023/r3_r1_rwl
+ VSS u_t015_024/VSS VSUBS detronyx_12t_2w2r_rc4_4x4_routed_5layer_direct
Xu_t015_012 u_t015_012/c0_w0_bl u_t015_012/c0_w0_br u_t015_012/c0_w1_bl u_t015_012/c0_w1_br
+ u_t015_012/c0_r0_rbl u_t015_012/c0_r1_rbl u_t015_012/c1_w0_bl u_t015_012/c1_w0_br
+ u_t015_012/c1_w1_bl u_t015_012/c1_w1_br u_t015_012/c1_r0_rbl u_t015_012/c1_r1_rbl
+ u_t015_012/c2_w0_bl u_t015_012/c2_w0_br u_t015_012/c2_w1_bl u_t015_012/c2_w1_br
+ u_t015_012/c2_r0_rbl u_t015_012/c2_r1_rbl u_t015_012/c3_w0_bl u_t015_012/c3_w0_br
+ u_t015_012/c3_w1_bl u_t015_012/c3_w1_br u_t015_012/c3_r0_rbl u_t015_012/c3_r1_rbl
+ u_t015_012/r0_w0_wl u_t015_012/r0_w1_wl u_t015_012/r0_r0_rwl u_t015_012/r0_r1_rwl
+ u_t015_012/r1_w0_wl u_t015_012/r1_w1_wl u_t015_012/r1_r0_rwl u_t015_012/r1_r1_rwl
+ u_t015_012/r2_w0_wl u_t015_012/r2_w1_wl u_t015_012/r2_r0_rwl u_t015_012/r2_r1_rwl
+ u_t015_012/r3_w0_wl u_t015_012/r3_w1_wl u_t015_012/r3_r0_rwl u_t015_012/r3_r1_rwl
+ u_t015_012/VDD u_t015_012/VSS VSUBS detronyx_12t_2w2r_rc4_4x4_routed_5layer_direct
Xu_t015_001 u_t015_001/c0_w0_bl u_t015_001/c0_w0_br u_t015_001/c0_w1_bl u_t015_001/c0_w1_br
+ u_t015_001/c0_r0_rbl u_t015_001/c0_r1_rbl u_t015_001/c1_w0_bl u_t015_001/c1_w0_br
+ u_t015_001/c1_w1_bl u_t015_001/c1_w1_br u_t015_001/c1_r0_rbl u_t015_001/c1_r1_rbl
+ u_t015_001/c2_w0_bl u_t015_001/c2_w0_br u_t015_001/c2_w1_bl u_t015_001/c2_w1_br
+ u_t015_001/c2_r0_rbl u_t015_001/c2_r1_rbl u_t015_001/c3_w0_bl u_t015_001/c3_w0_br
+ u_t015_001/c3_w1_bl u_t015_001/c3_w1_br u_t015_001/c3_r0_rbl u_t015_001/c3_r1_rbl
+ u_t015_001/r0_w0_wl u_t015_001/r0_w1_wl u_t015_001/r0_r0_rwl u_t015_001/r0_r1_rwl
+ u_t015_001/r1_w0_wl u_t015_001/r1_w1_wl u_t015_001/r1_r0_rwl u_t015_001/r1_r1_rwl
+ u_t015_001/r2_w0_wl u_t015_001/r2_w1_wl u_t015_001/r2_r0_rwl u_t015_001/r2_r1_rwl
+ u_t015_001/r3_w0_wl u_t015_001/r3_w1_wl u_t015_001/r3_r0_rwl u_t015_001/r3_r1_rwl
+ VSS u_t015_002/VSS VSUBS detronyx_12t_2w2r_rc4_4x4_routed_5layer_direct
Xu_t030_026 u_t030_026/c0_w0_bl u_t030_026/c0_w0_br u_t030_026/c0_w1_bl u_t030_026/c0_w1_br
+ u_t030_026/c0_r0_rbl u_t030_026/c0_r1_rbl u_t030_026/c1_w0_bl u_t030_026/c1_w0_br
+ u_t030_026/c1_w1_bl u_t030_026/c1_w1_br u_t030_026/c1_r0_rbl u_t030_026/c1_r1_rbl
+ u_t030_026/c2_w0_bl u_t030_026/c2_w0_br u_t030_026/c2_w1_bl u_t030_026/c2_w1_br
+ u_t030_026/c2_r0_rbl u_t030_026/c2_r1_rbl u_t030_026/c3_w0_bl u_t030_026/c3_w0_br
+ u_t030_026/c3_w1_bl u_t030_026/c3_w1_br u_t030_026/c3_r0_rbl u_t030_026/c3_r1_rbl
+ u_t030_026/r0_w0_wl u_t030_026/r0_w1_wl u_t030_026/r0_r0_rwl u_t030_026/r0_r1_rwl
+ u_t030_026/r1_w0_wl u_t030_026/r1_w1_wl u_t030_026/r1_r0_rwl u_t030_026/r1_r1_rwl
+ u_t030_026/r2_w0_wl u_t030_026/r2_w1_wl u_t030_026/r2_r0_rwl u_t030_026/r2_r1_rwl
+ u_t030_026/r3_w0_wl u_t030_026/r3_w1_wl u_t030_026/r3_r0_rwl u_t030_026/r3_r1_rwl
+ u_t030_026/VDD u_t030_031/VSS VSUBS detronyx_12t_2w2r_rc4_4x4_routed_5layer_direct
Xu_t030_015 u_t030_015/c0_w0_bl u_t030_015/c0_w0_br u_t030_015/c0_w1_bl u_t030_015/c0_w1_br
+ u_t030_015/c0_r0_rbl u_t030_015/c0_r1_rbl u_t030_015/c1_w0_bl u_t030_015/c1_w0_br
+ u_t030_015/c1_w1_bl u_t030_015/c1_w1_br u_t030_015/c1_r0_rbl u_t030_015/c1_r1_rbl
+ u_t030_015/c2_w0_bl u_t030_015/c2_w0_br u_t030_015/c2_w1_bl u_t030_015/c2_w1_br
+ u_t030_015/c2_r0_rbl u_t030_015/c2_r1_rbl u_t030_015/c3_w0_bl u_t030_015/c3_w0_br
+ u_t030_015/c3_w1_bl u_t030_015/c3_w1_br u_t030_015/c3_r0_rbl u_t030_015/c3_r1_rbl
+ u_t030_015/r0_w0_wl u_t030_015/r0_w1_wl u_t030_015/r0_r0_rwl u_t030_015/r0_r1_rwl
+ u_t030_015/r1_w0_wl u_t030_015/r1_w1_wl u_t030_015/r1_r0_rwl u_t030_015/r1_r1_rwl
+ u_t030_015/r2_w0_wl u_t030_015/r2_w1_wl u_t030_015/r2_r0_rwl u_t030_015/r2_r1_rwl
+ u_t030_015/r3_w0_wl u_t030_015/r3_w1_wl u_t030_015/r3_r0_rwl u_t030_015/r3_r1_rwl
+ VSS u_t030_031/VSS VSUBS detronyx_12t_2w2r_rc4_4x4_routed_5layer_direct
Xu_t030_004 u_t030_004/c0_w0_bl u_t030_004/c0_w0_br u_t030_004/c0_w1_bl u_t030_004/c0_w1_br
+ u_t030_004/c0_r0_rbl u_t030_004/c0_r1_rbl u_t030_004/c1_w0_bl u_t030_004/c1_w0_br
+ u_t030_004/c1_w1_bl u_t030_004/c1_w1_br u_t030_004/c1_r0_rbl u_t030_004/c1_r1_rbl
+ u_t030_004/c2_w0_bl u_t030_004/c2_w0_br u_t030_004/c2_w1_bl u_t030_004/c2_w1_br
+ u_t030_004/c2_r0_rbl u_t030_004/c2_r1_rbl u_t030_004/c3_w0_bl u_t030_004/c3_w0_br
+ u_t030_004/c3_w1_bl u_t030_004/c3_w1_br u_t030_004/c3_r0_rbl u_t030_004/c3_r1_rbl
+ u_t030_004/r0_w0_wl u_t030_004/r0_w1_wl u_t030_004/r0_r0_rwl u_t030_004/r0_r1_rwl
+ u_t030_004/r1_w0_wl u_t030_004/r1_w1_wl u_t030_004/r1_r0_rwl u_t030_004/r1_r1_rwl
+ u_t030_004/r2_w0_wl u_t030_004/r2_w1_wl u_t030_004/r2_r0_rwl u_t030_004/r2_r1_rwl
+ u_t030_004/r3_w0_wl u_t030_004/r3_w1_wl u_t030_004/r3_r0_rwl u_t030_004/r3_r1_rwl
+ u_t030_004/VDD u_t030_031/VSS VSUBS detronyx_12t_2w2r_rc4_4x4_routed_5layer_direct
Xgf180mcu_as_sc_mcu7t3v3__nand4_2_449 gf180mcu_as_sc_mcu7t3v3__inv_2_1532/VSS gf180mcu_as_sc_mcu7t3v3__inv_2_1688/VDD
+ VSS VSS VSS VSS gf180mcu_as_sc_mcu7t3v3__nand4_2_449/Y gf180mcu_as_sc_mcu7t3v3__inv_2_1506/VNW
+ VSUBS gf180mcu_as_sc_mcu7t3v3__nand4_2
Xgf180mcu_as_sc_mcu7t3v3__nand4_2_438 gf180mcu_as_sc_mcu7t3v3__inv_2_1496/VDD VSS
+ VSS VSS VSS VSS VSS gf180mcu_as_sc_mcu7t3v3__inv_2_1496/VNW VSUBS gf180mcu_as_sc_mcu7t3v3__nand4_2
Xgf180mcu_as_sc_mcu7t3v3__inv_2_6 gf180mcu_as_sc_mcu7t3v3__inv_2_6/VSS gf180mcu_as_sc_mcu7t3v3__inv_2_6/VSS
+ gf180mcu_as_sc_mcu7t3v3__inv_2_8/A gf180mcu_as_sc_mcu7t3v3__inv_2_8/A gf180mcu_as_sc_mcu7t3v3__inv_2_6/VNW
+ VSUBS gf180mcu_as_sc_mcu7t3v3__inv_2
Xgf180mcu_as_sc_mcu7t3v3__nand4_2_427 VSS gf180mcu_as_sc_mcu7t3v3__inv_2_1694/VDD
+ VSS VSS VSS VSS gf180mcu_as_sc_mcu7t3v3__nand4_2_427/Y gf180mcu_as_sc_mcu7t3v3__inv_2_1413/VNW
+ VSUBS gf180mcu_as_sc_mcu7t3v3__nand4_2
Xgf180mcu_as_sc_mcu7t3v3__nand4_2_416 VSS VSS VSS VSS VSS VSS VSS gf180mcu_as_sc_mcu7t3v3__inv_2_1408/VNW
+ VSUBS gf180mcu_as_sc_mcu7t3v3__nand4_2
Xgf180mcu_as_sc_mcu7t3v3__nand4_2_405 VSS gf180mcu_as_sc_mcu7t3v3__inv_2_1393/VDD
+ VSS VSS VSS VSS VSS gf180mcu_as_sc_mcu7t3v3__inv_2_1392/VNW VSUBS gf180mcu_as_sc_mcu7t3v3__nand4_2
Xu_t021_026 u_t021_026/c0_w0_bl u_t021_026/c0_w0_br u_t021_026/c0_w1_bl u_t021_026/c0_w1_br
+ u_t021_026/c0_r0_rbl u_t021_026/c0_r1_rbl u_t021_026/c1_w0_bl u_t021_026/c1_w0_br
+ u_t021_026/c1_w1_bl u_t021_026/c1_w1_br u_t021_026/c1_r0_rbl u_t021_026/c1_r1_rbl
+ u_t021_026/c2_w0_bl u_t021_026/c2_w0_br u_t021_026/c2_w1_bl u_t021_026/c2_w1_br
+ u_t021_026/c2_r0_rbl u_t021_026/c2_r1_rbl u_t021_026/c3_w0_bl u_t021_026/c3_w0_br
+ u_t021_026/c3_w1_bl u_t021_026/c3_w1_br u_t021_026/c3_r0_rbl u_t021_026/c3_r1_rbl
+ u_t021_026/r0_w0_wl u_t021_026/r0_w1_wl u_t021_026/r0_r0_rwl u_t021_026/r0_r1_rwl
+ u_t021_026/r1_w0_wl u_t021_026/r1_w1_wl u_t021_026/r1_r0_rwl u_t021_026/r1_r1_rwl
+ u_t021_026/r2_w0_wl u_t021_026/r2_w1_wl u_t021_026/r2_r0_rwl u_t021_026/r2_r1_rwl
+ u_t021_026/r3_w0_wl u_t021_026/r3_w1_wl u_t021_026/r3_r0_rwl u_t021_026/r3_r1_rwl
+ u_t021_026/VDD u_t021_031/VSS VSUBS detronyx_12t_2w2r_rc4_4x4_routed_5layer_direct
Xu_t006_023 u_t006_023/c0_w0_bl u_t006_023/c0_w0_br u_t006_023/c0_w1_bl u_t006_023/c0_w1_br
+ u_t006_023/c0_r0_rbl u_t006_023/c0_r1_rbl u_t006_023/c1_w0_bl u_t006_023/c1_w0_br
+ u_t006_023/c1_w1_bl u_t006_023/c1_w1_br u_t006_023/c1_r0_rbl u_t006_023/c1_r1_rbl
+ u_t006_023/c2_w0_bl u_t006_023/c2_w0_br u_t006_023/c2_w1_bl u_t006_023/c2_w1_br
+ u_t006_023/c2_r0_rbl u_t006_023/c2_r1_rbl u_t006_023/c3_w0_bl u_t006_023/c3_w0_br
+ u_t006_023/c3_w1_bl u_t006_023/c3_w1_br u_t006_023/c3_r0_rbl u_t006_023/c3_r1_rbl
+ u_t006_023/r0_w0_wl u_t006_023/r0_w1_wl u_t006_023/r0_r0_rwl u_t006_023/r0_r1_rwl
+ u_t006_023/r1_w0_wl u_t006_023/r1_w1_wl u_t006_023/r1_r0_rwl u_t006_023/r1_r1_rwl
+ u_t006_023/r2_w0_wl u_t006_023/r2_w1_wl u_t006_023/r2_r0_rwl u_t006_023/r2_r1_rwl
+ u_t006_023/r3_w0_wl u_t006_023/r3_w1_wl u_t006_023/r3_r0_rwl u_t006_023/r3_r1_rwl
+ VSS u_t006_024/VSS VSUBS detronyx_12t_2w2r_rc4_4x4_routed_5layer_direct
Xu_t021_015 u_t021_015/c0_w0_bl u_t021_015/c0_w0_br u_t021_015/c0_w1_bl u_t021_015/c0_w1_br
+ u_t021_015/c0_r0_rbl u_t021_015/c0_r1_rbl u_t021_015/c1_w0_bl u_t021_015/c1_w0_br
+ u_t021_015/c1_w1_bl u_t021_015/c1_w1_br u_t021_015/c1_r0_rbl u_t021_015/c1_r1_rbl
+ u_t021_015/c2_w0_bl u_t021_015/c2_w0_br u_t021_015/c2_w1_bl u_t021_015/c2_w1_br
+ u_t021_015/c2_r0_rbl u_t021_015/c2_r1_rbl u_t021_015/c3_w0_bl u_t021_015/c3_w0_br
+ u_t021_015/c3_w1_bl u_t021_015/c3_w1_br u_t021_015/c3_r0_rbl u_t021_015/c3_r1_rbl
+ u_t021_015/r0_w0_wl u_t021_015/r0_w1_wl u_t021_015/r0_r0_rwl u_t021_015/r0_r1_rwl
+ u_t021_015/r1_w0_wl u_t021_015/r1_w1_wl u_t021_015/r1_r0_rwl u_t021_015/r1_r1_rwl
+ u_t021_015/r2_w0_wl u_t021_015/r2_w1_wl u_t021_015/r2_r0_rwl u_t021_015/r2_r1_rwl
+ u_t021_015/r3_w0_wl u_t021_015/r3_w1_wl u_t021_015/r3_r0_rwl u_t021_015/r3_r1_rwl
+ VSS u_t021_031/VSS VSUBS detronyx_12t_2w2r_rc4_4x4_routed_5layer_direct
Xu_t006_012 u_t006_012/c0_w0_bl u_t006_012/c0_w0_br u_t006_012/c0_w1_bl u_t006_012/c0_w1_br
+ u_t006_012/c0_r0_rbl u_t006_012/c0_r1_rbl u_t006_012/c1_w0_bl u_t006_012/c1_w0_br
+ u_t006_012/c1_w1_bl u_t006_012/c1_w1_br u_t006_012/c1_r0_rbl u_t006_012/c1_r1_rbl
+ u_t006_012/c2_w0_bl u_t006_012/c2_w0_br u_t006_012/c2_w1_bl u_t006_012/c2_w1_br
+ u_t006_012/c2_r0_rbl u_t006_012/c2_r1_rbl u_t006_012/c3_w0_bl u_t006_012/c3_w0_br
+ u_t006_012/c3_w1_bl u_t006_012/c3_w1_br u_t006_012/c3_r0_rbl u_t006_012/c3_r1_rbl
+ u_t006_012/r0_w0_wl u_t006_012/r0_w1_wl u_t006_012/r0_r0_rwl u_t006_012/r0_r1_rwl
+ u_t006_012/r1_w0_wl u_t006_012/r1_w1_wl u_t006_012/r1_r0_rwl u_t006_012/r1_r1_rwl
+ u_t006_012/r2_w0_wl u_t006_012/r2_w1_wl u_t006_012/r2_r0_rwl u_t006_012/r2_r1_rwl
+ u_t006_012/r3_w0_wl u_t006_012/r3_w1_wl u_t006_012/r3_r0_rwl u_t006_012/r3_r1_rwl
+ u_t006_012/VDD u_t006_012/VSS VSUBS detronyx_12t_2w2r_rc4_4x4_routed_5layer_direct
Xu_t021_004 u_t021_004/c0_w0_bl u_t021_004/c0_w0_br u_t021_004/c0_w1_bl u_t021_004/c0_w1_br
+ u_t021_004/c0_r0_rbl u_t021_004/c0_r1_rbl u_t021_004/c1_w0_bl u_t021_004/c1_w0_br
+ u_t021_004/c1_w1_bl u_t021_004/c1_w1_br u_t021_004/c1_r0_rbl u_t021_004/c1_r1_rbl
+ u_t021_004/c2_w0_bl u_t021_004/c2_w0_br u_t021_004/c2_w1_bl u_t021_004/c2_w1_br
+ u_t021_004/c2_r0_rbl u_t021_004/c2_r1_rbl u_t021_004/c3_w0_bl u_t021_004/c3_w0_br
+ u_t021_004/c3_w1_bl u_t021_004/c3_w1_br u_t021_004/c3_r0_rbl u_t021_004/c3_r1_rbl
+ u_t021_004/r0_w0_wl u_t021_004/r0_w1_wl u_t021_004/r0_r0_rwl u_t021_004/r0_r1_rwl
+ u_t021_004/r1_w0_wl u_t021_004/r1_w1_wl u_t021_004/r1_r0_rwl u_t021_004/r1_r1_rwl
+ u_t021_004/r2_w0_wl u_t021_004/r2_w1_wl u_t021_004/r2_r0_rwl u_t021_004/r2_r1_rwl
+ u_t021_004/r3_w0_wl u_t021_004/r3_w1_wl u_t021_004/r3_r0_rwl u_t021_004/r3_r1_rwl
+ u_t021_004/VDD u_t021_031/VSS VSUBS detronyx_12t_2w2r_rc4_4x4_routed_5layer_direct
Xu_t006_001 u_t006_001/c0_w0_bl u_t006_001/c0_w0_br u_t006_001/c0_w1_bl u_t006_001/c0_w1_br
+ u_t006_001/c0_r0_rbl u_t006_001/c0_r1_rbl u_t006_001/c1_w0_bl u_t006_001/c1_w0_br
+ u_t006_001/c1_w1_bl u_t006_001/c1_w1_br u_t006_001/c1_r0_rbl u_t006_001/c1_r1_rbl
+ u_t006_001/c2_w0_bl u_t006_001/c2_w0_br u_t006_001/c2_w1_bl u_t006_001/c2_w1_br
+ u_t006_001/c2_r0_rbl u_t006_001/c2_r1_rbl u_t006_001/c3_w0_bl u_t006_001/c3_w0_br
+ u_t006_001/c3_w1_bl u_t006_001/c3_w1_br u_t006_001/c3_r0_rbl u_t006_001/c3_r1_rbl
+ u_t006_001/r0_w0_wl u_t006_001/r0_w1_wl u_t006_001/r0_r0_rwl u_t006_001/r0_r1_rwl
+ u_t006_001/r1_w0_wl u_t006_001/r1_w1_wl u_t006_001/r1_r0_rwl u_t006_001/r1_r1_rwl
+ u_t006_001/r2_w0_wl u_t006_001/r2_w1_wl u_t006_001/r2_r0_rwl u_t006_001/r2_r1_rwl
+ u_t006_001/r3_w0_wl u_t006_001/r3_w1_wl u_t006_001/r3_r0_rwl u_t006_001/r3_r1_rwl
+ VSS u_t006_002/VSS VSUBS detronyx_12t_2w2r_rc4_4x4_routed_5layer_direct
Xu_t012_026 u_t012_026/c0_w0_bl u_t012_026/c0_w0_br u_t012_026/c0_w1_bl u_t012_026/c0_w1_br
+ u_t012_026/c0_r0_rbl u_t012_026/c0_r1_rbl u_t012_026/c1_w0_bl u_t012_026/c1_w0_br
+ u_t012_026/c1_w1_bl u_t012_026/c1_w1_br u_t012_026/c1_r0_rbl u_t012_026/c1_r1_rbl
+ u_t012_026/c2_w0_bl u_t012_026/c2_w0_br u_t012_026/c2_w1_bl u_t012_026/c2_w1_br
+ u_t012_026/c2_r0_rbl u_t012_026/c2_r1_rbl u_t012_026/c3_w0_bl u_t012_026/c3_w0_br
+ u_t012_026/c3_w1_bl u_t012_026/c3_w1_br u_t012_026/c3_r0_rbl u_t012_026/c3_r1_rbl
+ u_t012_026/r0_w0_wl u_t012_026/r0_w1_wl u_t012_026/r0_r0_rwl u_t012_026/r0_r1_rwl
+ u_t012_026/r1_w0_wl u_t012_026/r1_w1_wl u_t012_026/r1_r0_rwl u_t012_026/r1_r1_rwl
+ u_t012_026/r2_w0_wl u_t012_026/r2_w1_wl u_t012_026/r2_r0_rwl u_t012_026/r2_r1_rwl
+ u_t012_026/r3_w0_wl u_t012_026/r3_w1_wl u_t012_026/r3_r0_rwl u_t012_026/r3_r1_rwl
+ u_t012_026/VDD u_t012_031/VSS VSUBS detronyx_12t_2w2r_rc4_4x4_routed_5layer_direct
Xu_t012_015 u_t012_015/c0_w0_bl u_t012_015/c0_w0_br u_t012_015/c0_w1_bl u_t012_015/c0_w1_br
+ u_t012_015/c0_r0_rbl u_t012_015/c0_r1_rbl u_t012_015/c1_w0_bl u_t012_015/c1_w0_br
+ u_t012_015/c1_w1_bl u_t012_015/c1_w1_br u_t012_015/c1_r0_rbl u_t012_015/c1_r1_rbl
+ u_t012_015/c2_w0_bl u_t012_015/c2_w0_br u_t012_015/c2_w1_bl u_t012_015/c2_w1_br
+ u_t012_015/c2_r0_rbl u_t012_015/c2_r1_rbl u_t012_015/c3_w0_bl u_t012_015/c3_w0_br
+ u_t012_015/c3_w1_bl u_t012_015/c3_w1_br u_t012_015/c3_r0_rbl u_t012_015/c3_r1_rbl
+ u_t012_015/r0_w0_wl u_t012_015/r0_w1_wl u_t012_015/r0_r0_rwl u_t012_015/r0_r1_rwl
+ u_t012_015/r1_w0_wl u_t012_015/r1_w1_wl u_t012_015/r1_r0_rwl u_t012_015/r1_r1_rwl
+ u_t012_015/r2_w0_wl u_t012_015/r2_w1_wl u_t012_015/r2_r0_rwl u_t012_015/r2_r1_rwl
+ u_t012_015/r3_w0_wl u_t012_015/r3_w1_wl u_t012_015/r3_r0_rwl u_t012_015/r3_r1_rwl
+ VSS u_t012_031/VSS VSUBS detronyx_12t_2w2r_rc4_4x4_routed_5layer_direct
Xu_t012_004 u_t012_004/c0_w0_bl u_t012_004/c0_w0_br u_t012_004/c0_w1_bl u_t012_004/c0_w1_br
+ u_t012_004/c0_r0_rbl u_t012_004/c0_r1_rbl u_t012_004/c1_w0_bl u_t012_004/c1_w0_br
+ u_t012_004/c1_w1_bl u_t012_004/c1_w1_br u_t012_004/c1_r0_rbl u_t012_004/c1_r1_rbl
+ u_t012_004/c2_w0_bl u_t012_004/c2_w0_br u_t012_004/c2_w1_bl u_t012_004/c2_w1_br
+ u_t012_004/c2_r0_rbl u_t012_004/c2_r1_rbl u_t012_004/c3_w0_bl u_t012_004/c3_w0_br
+ u_t012_004/c3_w1_bl u_t012_004/c3_w1_br u_t012_004/c3_r0_rbl u_t012_004/c3_r1_rbl
+ u_t012_004/r0_w0_wl u_t012_004/r0_w1_wl u_t012_004/r0_r0_rwl u_t012_004/r0_r1_rwl
+ u_t012_004/r1_w0_wl u_t012_004/r1_w1_wl u_t012_004/r1_r0_rwl u_t012_004/r1_r1_rwl
+ u_t012_004/r2_w0_wl u_t012_004/r2_w1_wl u_t012_004/r2_r0_rwl u_t012_004/r2_r1_rwl
+ u_t012_004/r3_w0_wl u_t012_004/r3_w1_wl u_t012_004/r3_r0_rwl u_t012_004/r3_r1_rwl
+ u_t012_004/VDD u_t012_031/VSS VSUBS detronyx_12t_2w2r_rc4_4x4_routed_5layer_direct
Xgf180mcu_as_sc_mcu7t3v3__inv_2_1485 VSS gf180mcu_as_sc_mcu7t3v3__inv_2_1485/VSS VSS
+ VSS gf180mcu_as_sc_mcu7t3v3__inv_2_1485/VNW VSUBS gf180mcu_as_sc_mcu7t3v3__inv_2
Xgf180mcu_as_sc_mcu7t3v3__inv_2_1463 gf180mcu_as_sc_mcu7t3v3__inv_2_1485/VSS gf180mcu_as_sc_mcu7t3v3__inv_2_1468/VDD
+ VSS VSS gf180mcu_as_sc_mcu7t3v3__inv_2_1465/VNW VSUBS gf180mcu_as_sc_mcu7t3v3__inv_2
Xgf180mcu_as_sc_mcu7t3v3__inv_2_1474 VSS gf180mcu_as_sc_mcu7t3v3__inv_2_1480/VDD VSS
+ VSS gf180mcu_as_sc_mcu7t3v3__inv_2_1476/VNW VSUBS gf180mcu_as_sc_mcu7t3v3__inv_2
Xgf180mcu_as_sc_mcu7t3v3__inv_2_1496 gf180mcu_as_sc_mcu7t3v3__inv_2_1496/VDD VSS VSS
+ VSS gf180mcu_as_sc_mcu7t3v3__inv_2_1496/VNW VSUBS gf180mcu_as_sc_mcu7t3v3__inv_2
Xgf180mcu_as_sc_mcu7t3v3__inv_2_1430 gf180mcu_as_sc_mcu7t3v3__inv_2_1432/VDD VSS VSS
+ VSS gf180mcu_as_sc_mcu7t3v3__inv_2_1432/VNW VSUBS gf180mcu_as_sc_mcu7t3v3__inv_2
Xgf180mcu_as_sc_mcu7t3v3__inv_2_1441 VSS VSS VSS VSS gf180mcu_as_sc_mcu7t3v3__inv_2_1445/VNW
+ VSUBS gf180mcu_as_sc_mcu7t3v3__inv_2
Xgf180mcu_as_sc_mcu7t3v3__inv_2_1452 gf180mcu_as_sc_mcu7t3v3__inv_2_1499/VSS gf180mcu_as_sc_mcu7t3v3__inv_2_1457/VDD
+ gf180mcu_as_sc_mcu7t3v3__inv_2_1452/Y VSS gf180mcu_as_sc_mcu7t3v3__inv_2_1453/VNW
+ VSUBS gf180mcu_as_sc_mcu7t3v3__inv_2
Xu_t003_026 u_t003_026/c0_w0_bl u_t003_026/c0_w0_br u_t003_026/c0_w1_bl u_t003_026/c0_w1_br
+ u_t003_026/c0_r0_rbl u_t003_026/c0_r1_rbl u_t003_026/c1_w0_bl u_t003_026/c1_w0_br
+ u_t003_026/c1_w1_bl u_t003_026/c1_w1_br u_t003_026/c1_r0_rbl u_t003_026/c1_r1_rbl
+ u_t003_026/c2_w0_bl u_t003_026/c2_w0_br u_t003_026/c2_w1_bl u_t003_026/c2_w1_br
+ u_t003_026/c2_r0_rbl u_t003_026/c2_r1_rbl u_t003_026/c3_w0_bl u_t003_026/c3_w0_br
+ u_t003_026/c3_w1_bl u_t003_026/c3_w1_br u_t003_026/c3_r0_rbl u_t003_026/c3_r1_rbl
+ u_t003_026/r0_w0_wl u_t003_026/r0_w1_wl u_t003_026/r0_r0_rwl u_t003_026/r0_r1_rwl
+ u_t003_026/r1_w0_wl u_t003_026/r1_w1_wl u_t003_026/r1_r0_rwl u_t003_026/r1_r1_rwl
+ u_t003_026/r2_w0_wl u_t003_026/r2_w1_wl u_t003_026/r2_r0_rwl u_t003_026/r2_r1_rwl
+ u_t003_026/r3_w0_wl u_t003_026/r3_w1_wl u_t003_026/r3_r0_rwl u_t003_026/r3_r1_rwl
+ u_t004_026/VDD u_t003_026/VSS VSUBS detronyx_12t_2w2r_rc4_4x4_routed_5layer_direct
Xu_t003_015 u_t003_015/c0_w0_bl u_t003_015/c0_w0_br u_t003_015/c0_w1_bl u_t003_015/c0_w1_br
+ u_t003_015/c0_r0_rbl u_t003_015/c0_r1_rbl u_t003_015/c1_w0_bl u_t003_015/c1_w0_br
+ u_t003_015/c1_w1_bl u_t003_015/c1_w1_br u_t003_015/c1_r0_rbl u_t003_015/c1_r1_rbl
+ u_t003_015/c2_w0_bl u_t003_015/c2_w0_br u_t003_015/c2_w1_bl u_t003_015/c2_w1_br
+ u_t003_015/c2_r0_rbl u_t003_015/c2_r1_rbl u_t003_015/c3_w0_bl u_t003_015/c3_w0_br
+ u_t003_015/c3_w1_bl u_t003_015/c3_w1_br u_t003_015/c3_r0_rbl u_t003_015/c3_r1_rbl
+ u_t003_015/r0_w0_wl u_t003_015/r0_w1_wl u_t003_015/r0_r0_rwl u_t003_015/r0_r1_rwl
+ u_t003_015/r1_w0_wl u_t003_015/r1_w1_wl u_t003_015/r1_r0_rwl u_t003_015/r1_r1_rwl
+ u_t003_015/r2_w0_wl u_t003_015/r2_w1_wl u_t003_015/r2_r0_rwl u_t003_015/r2_r1_rwl
+ u_t003_015/r3_w0_wl u_t003_015/r3_w1_wl u_t003_015/r3_r0_rwl u_t003_015/r3_r1_rwl
+ VSS u_t003_017/VSS VSUBS detronyx_12t_2w2r_rc4_4x4_routed_5layer_direct
Xu_t003_004 u_t003_004/c0_w0_bl u_t003_004/c0_w0_br u_t003_004/c0_w1_bl u_t003_004/c0_w1_br
+ u_t003_004/c0_r0_rbl u_t003_004/c0_r1_rbl u_t003_004/c1_w0_bl u_t003_004/c1_w0_br
+ u_t003_004/c1_w1_bl u_t003_004/c1_w1_br u_t003_004/c1_r0_rbl u_t003_004/c1_r1_rbl
+ u_t003_004/c2_w0_bl u_t003_004/c2_w0_br u_t003_004/c2_w1_bl u_t003_004/c2_w1_br
+ u_t003_004/c2_r0_rbl u_t003_004/c2_r1_rbl u_t003_004/c3_w0_bl u_t003_004/c3_w0_br
+ u_t003_004/c3_w1_bl u_t003_004/c3_w1_br u_t003_004/c3_r0_rbl u_t003_004/c3_r1_rbl
+ u_t003_004/r0_w0_wl u_t003_004/r0_w1_wl u_t003_004/r0_r0_rwl u_t003_004/r0_r1_rwl
+ u_t003_004/r1_w0_wl u_t003_004/r1_w1_wl u_t003_004/r1_r0_rwl u_t003_004/r1_r1_rwl
+ u_t003_004/r2_w0_wl u_t003_004/r2_w1_wl u_t003_004/r2_r0_rwl u_t003_004/r2_r1_rwl
+ u_t003_004/r3_w0_wl u_t003_004/r3_w1_wl u_t003_004/r3_r0_rwl u_t003_004/r3_r1_rwl
+ u_t004_004/VDD u_t003_004/VSS VSUBS detronyx_12t_2w2r_rc4_4x4_routed_5layer_direct
Xgf180mcu_as_sc_mcu7t3v3__inv_2_936 VSS VSS VSS VSS gf180mcu_as_sc_mcu7t3v3__inv_2_936/VNW
+ VSUBS gf180mcu_as_sc_mcu7t3v3__inv_2
Xgf180mcu_as_sc_mcu7t3v3__inv_2_947 VSS VSS VSS VSS gf180mcu_as_sc_mcu7t3v3__inv_2_948/VNW
+ VSUBS gf180mcu_as_sc_mcu7t3v3__inv_2
Xgf180mcu_as_sc_mcu7t3v3__inv_2_903 VSS VSS VSS VSS gf180mcu_as_sc_mcu7t3v3__inv_2_905/VNW
+ VSUBS gf180mcu_as_sc_mcu7t3v3__inv_2
Xgf180mcu_as_sc_mcu7t3v3__inv_2_969 gf180mcu_as_sc_mcu7t3v3__inv_2_970/VDD VSS gf180mcu_as_sc_mcu7t3v3__inv_2_991/A
+ gf180mcu_as_sc_mcu7t3v3__inv_2_970/Y gf180mcu_as_sc_mcu7t3v3__inv_2_970/VNW VSUBS
+ gf180mcu_as_sc_mcu7t3v3__inv_2
Xgf180mcu_as_sc_mcu7t3v3__inv_2_958 gf180mcu_as_sc_mcu7t3v3__inv_2_987/VSS VSS gf180mcu_as_sc_mcu7t3v3__inv_2_958/Y
+ VSS gf180mcu_as_sc_mcu7t3v3__inv_2_958/VNW VSUBS gf180mcu_as_sc_mcu7t3v3__inv_2
Xgf180mcu_as_sc_mcu7t3v3__inv_2_914 VSS VSS VSS VSS gf180mcu_as_sc_mcu7t3v3__inv_2_914/VNW
+ VSUBS gf180mcu_as_sc_mcu7t3v3__inv_2
Xgf180mcu_as_sc_mcu7t3v3__inv_2_925 VSS VSS VSS VSS gf180mcu_as_sc_mcu7t3v3__inv_2_933/VNW
+ VSUBS gf180mcu_as_sc_mcu7t3v3__inv_2
Xgf180mcu_as_sc_mcu7t3v3__nand4_2_224 VSS VSS VSS VSS VSS VSS gf180mcu_as_sc_mcu7t3v3__nand4_2_224/Y
+ gf180mcu_as_sc_mcu7t3v3__inv_2_788/VNW VSUBS gf180mcu_as_sc_mcu7t3v3__nand4_2
Xgf180mcu_as_sc_mcu7t3v3__nand4_2_202 gf180mcu_as_sc_mcu7t3v3__inv_2_687/VDD VSS VSS
+ VSS VSS VSS VSS gf180mcu_as_sc_mcu7t3v3__inv_2_687/VNW VSUBS gf180mcu_as_sc_mcu7t3v3__nand4_2
Xgf180mcu_as_sc_mcu7t3v3__nand4_2_213 VSS VSS VSS VSS VSS VSS gf180mcu_as_sc_mcu7t3v3__nand4_2_213/Y
+ gf180mcu_as_sc_mcu7t3v3__inv_2_795/VNW VSUBS gf180mcu_as_sc_mcu7t3v3__nand4_2
Xgf180mcu_as_sc_mcu7t3v3__nand4_2_235 VSS VSS VSS VSS VSS VSS gf180mcu_as_sc_mcu7t3v3__nand4_2_235/Y
+ gf180mcu_as_sc_mcu7t3v3__inv_2_832/VNW VSUBS gf180mcu_as_sc_mcu7t3v3__nand4_2
Xgf180mcu_as_sc_mcu7t3v3__nand4_2_268 VSS VSS VSS VSS VSS VSS VSS gf180mcu_as_sc_mcu7t3v3__inv_2_924/VNW
+ VSUBS gf180mcu_as_sc_mcu7t3v3__nand4_2
Xgf180mcu_as_sc_mcu7t3v3__nand4_2_246 VSS VSS VSS VSS VSS VSS VSS gf180mcu_as_sc_mcu7t3v3__inv_2_813/VNW
+ VSUBS gf180mcu_as_sc_mcu7t3v3__nand4_2
Xgf180mcu_as_sc_mcu7t3v3__nand4_2_257 VSS VSS VSS VSS VSS VSS gf180mcu_as_sc_mcu7t3v3__nand4_2_257/Y
+ gf180mcu_as_sc_mcu7t3v3__inv_2_880/VNW VSUBS gf180mcu_as_sc_mcu7t3v3__nand4_2
Xgf180mcu_as_sc_mcu7t3v3__nand4_2_279 VSS VSS VSS VSS VSS VSS gf180mcu_as_sc_mcu7t3v3__nand4_2_279/Y
+ gf180mcu_as_sc_mcu7t3v3__inv_2_917/VNW VSUBS gf180mcu_as_sc_mcu7t3v3__nand4_2
Xu_t000_029 u_t000_029/c0_w0_bl u_t000_029/c0_w0_br u_t000_029/c0_w1_bl u_t000_029/c0_w1_br
+ u_t000_029/c0_r0_rbl u_t000_029/c0_r1_rbl u_t000_029/c1_w0_bl u_t000_029/c1_w0_br
+ u_t000_029/c1_w1_bl u_t000_029/c1_w1_br u_t000_029/c1_r0_rbl u_t000_029/c1_r1_rbl
+ u_t000_029/c2_w0_bl u_t000_029/c2_w0_br u_t000_029/c2_w1_bl u_t000_029/c2_w1_br
+ u_t000_029/c2_r0_rbl u_t000_029/c2_r1_rbl u_t000_029/c3_w0_bl u_t000_029/c3_w0_br
+ u_t000_029/c3_w1_bl u_t000_029/c3_w1_br u_t000_029/c3_r0_rbl u_t000_029/c3_r1_rbl
+ u_t000_029/r0_w0_wl u_t000_029/r0_w1_wl u_t000_029/r0_r0_rwl u_t000_029/r0_r1_rwl
+ u_t000_029/r1_w0_wl u_t000_029/r1_w1_wl u_t000_029/r1_r0_rwl u_t000_029/r1_r1_rwl
+ u_t000_029/r2_w0_wl u_t000_029/r2_w1_wl u_t000_029/r2_r0_rwl u_t000_029/r2_r1_rwl
+ u_t000_029/r3_w0_wl u_t000_029/r3_w1_wl u_t000_029/r3_r0_rwl u_t000_029/r3_r1_rwl
+ u_t000_029/VDD u_t000_031/VSS VSUBS detronyx_12t_2w2r_rc4_4x4_routed_5layer_direct
Xu_t000_018 u_t000_018/c0_w0_bl u_t000_018/c0_w0_br u_t000_018/c0_w1_bl u_t000_018/c0_w1_br
+ u_t000_018/c0_r0_rbl u_t000_018/c0_r1_rbl u_t000_018/c1_w0_bl u_t000_018/c1_w0_br
+ u_t000_018/c1_w1_bl u_t000_018/c1_w1_br u_t000_018/c1_r0_rbl u_t000_018/c1_r1_rbl
+ u_t000_018/c2_w0_bl u_t000_018/c2_w0_br u_t000_018/c2_w1_bl u_t000_018/c2_w1_br
+ u_t000_018/c2_r0_rbl u_t000_018/c2_r1_rbl u_t000_018/c3_w0_bl u_t000_018/c3_w0_br
+ u_t000_018/c3_w1_bl u_t000_018/c3_w1_br u_t000_018/c3_r0_rbl u_t000_018/c3_r1_rbl
+ u_t000_018/r0_w0_wl u_t000_018/r0_w1_wl u_t000_018/r0_r0_rwl u_t000_018/r0_r1_rwl
+ u_t000_018/r1_w0_wl u_t000_018/r1_w1_wl u_t000_018/r1_r0_rwl u_t000_018/r1_r1_rwl
+ u_t000_018/r2_w0_wl u_t000_018/r2_w1_wl u_t000_018/r2_r0_rwl u_t000_018/r2_r1_rwl
+ u_t000_018/r3_w0_wl u_t000_018/r3_w1_wl u_t000_018/r3_r0_rwl u_t000_018/r3_r1_rwl
+ u_t000_018/VDD u_t000_031/VSS VSUBS detronyx_12t_2w2r_rc4_4x4_routed_5layer_direct
Xu_t000_007 u_t000_007/c0_w0_bl u_t000_007/c0_w0_br u_t000_007/c0_w1_bl u_t000_007/c0_w1_br
+ u_t000_007/c0_r0_rbl u_t000_007/c0_r1_rbl u_t000_007/c1_w0_bl u_t000_007/c1_w0_br
+ u_t000_007/c1_w1_bl u_t000_007/c1_w1_br u_t000_007/c1_r0_rbl u_t000_007/c1_r1_rbl
+ u_t000_007/c2_w0_bl u_t000_007/c2_w0_br u_t000_007/c2_w1_bl u_t000_007/c2_w1_br
+ u_t000_007/c2_r0_rbl u_t000_007/c2_r1_rbl u_t000_007/c3_w0_bl u_t000_007/c3_w0_br
+ u_t000_007/c3_w1_bl u_t000_007/c3_w1_br u_t000_007/c3_r0_rbl u_t000_007/c3_r1_rbl
+ u_t000_007/r0_w0_wl u_t000_007/r0_w1_wl u_t000_007/r0_r0_rwl u_t000_007/r0_r1_rwl
+ u_t000_007/r1_w0_wl u_t000_007/r1_w1_wl u_t000_007/r1_r0_rwl u_t000_007/r1_r1_rwl
+ u_t000_007/r2_w0_wl u_t000_007/r2_w1_wl u_t000_007/r2_r0_rwl u_t000_007/r2_r1_rwl
+ u_t000_007/r3_w0_wl u_t000_007/r3_w1_wl u_t000_007/r3_r0_rwl u_t000_007/r3_r1_rwl
+ VSS u_t000_031/VSS VSUBS detronyx_12t_2w2r_rc4_4x4_routed_5layer_direct
Xgf180mcu_as_sc_mcu7t3v3__inv_2_1260 gf180mcu_as_sc_mcu7t3v3__nand3_2_31/VDD gf180mcu_as_sc_mcu7t3v3__nor2_2_8/VSS
+ VSS VSS gf180mcu_as_sc_mcu7t3v3__nand3_2_31/VNW VSUBS gf180mcu_as_sc_mcu7t3v3__inv_2
Xgf180mcu_as_sc_mcu7t3v3__inv_2_1271 gf180mcu_as_sc_mcu7t3v3__nand3_2_31/VDD gf180mcu_as_sc_mcu7t3v3__nand3_2_31/VSS
+ VSS VSS gf180mcu_as_sc_mcu7t3v3__nand3_2_31/VNW VSUBS gf180mcu_as_sc_mcu7t3v3__inv_2
Xgf180mcu_as_sc_mcu7t3v3__inv_2_1282 VSS VSS VSS VSS gf180mcu_as_sc_mcu7t3v3__inv_2_1282/VNW
+ VSUBS gf180mcu_as_sc_mcu7t3v3__inv_2
Xgf180mcu_as_sc_mcu7t3v3__inv_2_1293 gf180mcu_as_sc_mcu7t3v3__inv_2_1295/VDD VSS VSS
+ gf180mcu_as_sc_mcu7t3v3__inv_2_1294/Y gf180mcu_as_sc_mcu7t3v3__inv_2_1295/VNW VSUBS
+ gf180mcu_as_sc_mcu7t3v3__inv_2
Xgf180mcu_as_sc_mcu7t3v3__inv_2_700 gf180mcu_as_sc_mcu7t3v3__inv_2_738/VSS VSS gf180mcu_as_sc_mcu7t3v3__inv_2_700/Y
+ gf180mcu_as_sc_mcu7t3v3__inv_2_704/Y gf180mcu_as_sc_mcu7t3v3__inv_2_704/VNW VSUBS
+ gf180mcu_as_sc_mcu7t3v3__inv_2
Xgf180mcu_as_sc_mcu7t3v3__inv_2_711 gf180mcu_as_sc_mcu7t3v3__inv_2_711/VDD VSS gf180mcu_as_sc_mcu7t3v3__inv_2_711/Y
+ VSS gf180mcu_as_sc_mcu7t3v3__inv_2_711/VNW VSUBS gf180mcu_as_sc_mcu7t3v3__inv_2
Xgf180mcu_as_sc_mcu7t3v3__inv_2_766 VSS VSS gf180mcu_as_sc_mcu7t3v3__inv_2_766/Y VSS
+ gf180mcu_as_sc_mcu7t3v3__inv_2_768/VNW VSUBS gf180mcu_as_sc_mcu7t3v3__inv_2
Xgf180mcu_as_sc_mcu7t3v3__inv_2_755 VSS VSS VSS VSS gf180mcu_as_sc_mcu7t3v3__inv_2_756/VNW
+ VSUBS gf180mcu_as_sc_mcu7t3v3__inv_2
Xgf180mcu_as_sc_mcu7t3v3__inv_2_777 VSS VSS VSS VSS gf180mcu_as_sc_mcu7t3v3__inv_2_781/VNW
+ VSUBS gf180mcu_as_sc_mcu7t3v3__inv_2
Xgf180mcu_as_sc_mcu7t3v3__inv_2_744 VSS VSS VSS VSS gf180mcu_as_sc_mcu7t3v3__inv_2_745/VNW
+ VSUBS gf180mcu_as_sc_mcu7t3v3__inv_2
Xgf180mcu_as_sc_mcu7t3v3__inv_2_788 VSS VSS gf180mcu_as_sc_mcu7t3v3__inv_2_788/Y VSS
+ gf180mcu_as_sc_mcu7t3v3__inv_2_788/VNW VSUBS gf180mcu_as_sc_mcu7t3v3__inv_2
Xgf180mcu_as_sc_mcu7t3v3__inv_2_733 VSS VSS VSS gf180mcu_as_sc_mcu7t3v3__inv_2_737/A
+ gf180mcu_as_sc_mcu7t3v3__inv_2_735/VNW VSUBS gf180mcu_as_sc_mcu7t3v3__inv_2
Xgf180mcu_as_sc_mcu7t3v3__inv_2_722 gf180mcu_as_sc_mcu7t3v3__inv_2_723/VDD VSS gf180mcu_as_sc_mcu7t3v3__inv_2_732/Y
+ gf180mcu_as_sc_mcu7t3v3__inv_2_723/Y gf180mcu_as_sc_mcu7t3v3__inv_2_723/VNW VSUBS
+ gf180mcu_as_sc_mcu7t3v3__inv_2
Xgf180mcu_as_sc_mcu7t3v3__inv_2_799 VSS VSS VSS VSS gf180mcu_as_sc_mcu7t3v3__inv_2_800/VNW
+ VSUBS gf180mcu_as_sc_mcu7t3v3__inv_2
Xgf180mcu_as_sc_mcu7t3v3__inv_2_1090 VSS gf180mcu_as_sc_mcu7t3v3__inv_2_1096/VDD VSS
+ gf180mcu_as_sc_mcu7t3v3__inv_2_1094/A gf180mcu_as_sc_mcu7t3v3__inv_2_1092/VNW VSUBS
+ gf180mcu_as_sc_mcu7t3v3__inv_2
Xgf180mcu_as_sc_mcu7t3v3__nand4_2_2 gf180mcu_as_sc_mcu7t3v3__inv_2_6/VSS gf180mcu_as_sc_mcu7t3v3__inv_2_6/VSS
+ VSS VSS VSS VSS VSS gf180mcu_as_sc_mcu7t3v3__inv_2_6/VNW VSUBS gf180mcu_as_sc_mcu7t3v3__nand4_2
Xgf180mcu_as_sc_mcu7t3v3__inv_2_563 VSS gf180mcu_as_sc_mcu7t3v3__inv_2_572/VDD gf180mcu_as_sc_mcu7t3v3__inv_2_563/Y
+ gf180mcu_as_sc_mcu7t3v3__inv_2_635/Y gf180mcu_as_sc_mcu7t3v3__inv_2_565/VNW VSUBS
+ gf180mcu_as_sc_mcu7t3v3__inv_2
Xgf180mcu_as_sc_mcu7t3v3__inv_2_552 gf180mcu_as_sc_mcu7t3v3__nor2_2_5/VDD gf180mcu_as_sc_mcu7t3v3__nor2_2_5/VSS
+ VSS VSS gf180mcu_as_sc_mcu7t3v3__nor2_2_5/VNW VSUBS gf180mcu_as_sc_mcu7t3v3__inv_2
Xgf180mcu_as_sc_mcu7t3v3__inv_2_541 VSS VSS VSS VSS gf180mcu_as_sc_mcu7t3v3__inv_2_542/VNW
+ VSUBS gf180mcu_as_sc_mcu7t3v3__inv_2
Xgf180mcu_as_sc_mcu7t3v3__inv_2_530 VSS VSS gf180mcu_as_sc_mcu7t3v3__inv_2_530/Y VSS
+ gf180mcu_as_sc_mcu7t3v3__inv_2_530/VNW VSUBS gf180mcu_as_sc_mcu7t3v3__inv_2
Xgf180mcu_as_sc_mcu7t3v3__inv_2_574 gf180mcu_as_sc_mcu7t3v3__inv_2_576/VDD gf180mcu_as_sc_mcu7t3v3__inv_2_584/VDD
+ gf180mcu_as_sc_mcu7t3v3__inv_2_574/Y gf180mcu_as_sc_mcu7t3v3__inv_2_574/A gf180mcu_as_sc_mcu7t3v3__inv_2_576/VNW
+ VSUBS gf180mcu_as_sc_mcu7t3v3__inv_2
Xgf180mcu_as_sc_mcu7t3v3__inv_2_585 gf180mcu_as_sc_mcu7t3v3__inv_2_585/VDD gf180mcu_as_sc_mcu7t3v3__inv_2_585/VSS
+ gf180mcu_as_sc_mcu7t3v3__inv_2_585/Y VSS gf180mcu_as_sc_mcu7t3v3__inv_2_585/VNW
+ VSUBS gf180mcu_as_sc_mcu7t3v3__inv_2
Xgf180mcu_as_sc_mcu7t3v3__inv_2_596 gf180mcu_as_sc_mcu7t3v3__inv_2_597/VDD gf180mcu_as_sc_mcu7t3v3__inv_2_601/VDD
+ gf180mcu_as_sc_mcu7t3v3__inv_2_596/Y gf180mcu_as_sc_mcu7t3v3__inv_2_597/Y gf180mcu_as_sc_mcu7t3v3__inv_2_597/VNW
+ VSUBS gf180mcu_as_sc_mcu7t3v3__inv_2
Xgf180mcu_as_sc_mcu7t3v3__inv_2_393 VSS VSS gf180mcu_as_sc_mcu7t3v3__inv_2_393/Y VSS
+ gf180mcu_as_sc_mcu7t3v3__inv_2_395/VNW VSUBS gf180mcu_as_sc_mcu7t3v3__inv_2
Xgf180mcu_as_sc_mcu7t3v3__inv_2_382 gf180mcu_as_sc_mcu7t3v3__nor2_2_4/VDD gf180mcu_as_sc_mcu7t3v3__nor2_2_4/VSS
+ VSS VSS gf180mcu_as_sc_mcu7t3v3__nor2_2_4/VNW VSUBS gf180mcu_as_sc_mcu7t3v3__inv_2
Xgf180mcu_as_sc_mcu7t3v3__inv_2_371 gf180mcu_as_sc_mcu7t3v3__inv_2_371/VDD gf180mcu_as_sc_mcu7t3v3__inv_2_371/VSS
+ VSS VSS gf180mcu_as_sc_mcu7t3v3__inv_2_371/VNW VSUBS gf180mcu_as_sc_mcu7t3v3__inv_2
Xgf180mcu_as_sc_mcu7t3v3__inv_2_360 gf180mcu_as_sc_mcu7t3v3__inv_2_360/VDD gf180mcu_as_sc_mcu7t3v3__inv_2_361/VDD
+ gf180mcu_as_sc_mcu7t3v3__inv_2_361/Y VSS gf180mcu_as_sc_mcu7t3v3__inv_2_360/VNW
+ VSUBS gf180mcu_as_sc_mcu7t3v3__inv_2
Xu_t027_021 u_t027_021/c0_w0_bl u_t027_021/c0_w0_br u_t027_021/c0_w1_bl u_t027_021/c0_w1_br
+ u_t027_021/c0_r0_rbl u_t027_021/c0_r1_rbl u_t027_021/c1_w0_bl u_t027_021/c1_w0_br
+ u_t027_021/c1_w1_bl u_t027_021/c1_w1_br u_t027_021/c1_r0_rbl u_t027_021/c1_r1_rbl
+ u_t027_021/c2_w0_bl u_t027_021/c2_w0_br u_t027_021/c2_w1_bl u_t027_021/c2_w1_br
+ u_t027_021/c2_r0_rbl u_t027_021/c2_r1_rbl u_t027_021/c3_w0_bl u_t027_021/c3_w0_br
+ u_t027_021/c3_w1_bl u_t027_021/c3_w1_br u_t027_021/c3_r0_rbl u_t027_021/c3_r1_rbl
+ u_t027_021/r0_w0_wl u_t027_021/r0_w1_wl u_t027_021/r0_r0_rwl u_t027_021/r0_r1_rwl
+ u_t027_021/r1_w0_wl u_t027_021/r1_w1_wl u_t027_021/r1_r0_rwl u_t027_021/r1_r1_rwl
+ u_t027_021/r2_w0_wl u_t027_021/r2_w1_wl u_t027_021/r2_r0_rwl u_t027_021/r2_r1_rwl
+ u_t027_021/r3_w0_wl u_t027_021/r3_w1_wl u_t027_021/r3_r0_rwl u_t027_021/r3_r1_rwl
+ u_t027_021/VDD u_t027_024/VSS VSUBS detronyx_12t_2w2r_rc4_4x4_routed_5layer_direct
Xu_t027_010 u_t027_010/c0_w0_bl u_t027_010/c0_w0_br u_t027_010/c0_w1_bl u_t027_010/c0_w1_br
+ u_t027_010/c0_r0_rbl u_t027_010/c0_r1_rbl u_t027_010/c1_w0_bl u_t027_010/c1_w0_br
+ u_t027_010/c1_w1_bl u_t027_010/c1_w1_br u_t027_010/c1_r0_rbl u_t027_010/c1_r1_rbl
+ u_t027_010/c2_w0_bl u_t027_010/c2_w0_br u_t027_010/c2_w1_bl u_t027_010/c2_w1_br
+ u_t027_010/c2_r0_rbl u_t027_010/c2_r1_rbl u_t027_010/c3_w0_bl u_t027_010/c3_w0_br
+ u_t027_010/c3_w1_bl u_t027_010/c3_w1_br u_t027_010/c3_r0_rbl u_t027_010/c3_r1_rbl
+ u_t027_010/r0_w0_wl u_t027_010/r0_w1_wl u_t027_010/r0_r0_rwl u_t027_010/r0_r1_rwl
+ u_t027_010/r1_w0_wl u_t027_010/r1_w1_wl u_t027_010/r1_r0_rwl u_t027_010/r1_r1_rwl
+ u_t027_010/r2_w0_wl u_t027_010/r2_w1_wl u_t027_010/r2_r0_rwl u_t027_010/r2_r1_rwl
+ u_t027_010/r3_w0_wl u_t027_010/r3_w1_wl u_t027_010/r3_r0_rwl u_t027_010/r3_r1_rwl
+ VSS u_t027_010/VSS VSUBS detronyx_12t_2w2r_rc4_4x4_routed_5layer_direct
Xu_t018_010 u_t018_010/c0_w0_bl u_t018_010/c0_w0_br u_t018_010/c0_w1_bl u_t018_010/c0_w1_br
+ u_t018_010/c0_r0_rbl u_t018_010/c0_r1_rbl u_t018_010/c1_w0_bl u_t018_010/c1_w0_br
+ u_t018_010/c1_w1_bl u_t018_010/c1_w1_br u_t018_010/c1_r0_rbl u_t018_010/c1_r1_rbl
+ u_t018_010/c2_w0_bl u_t018_010/c2_w0_br u_t018_010/c2_w1_bl u_t018_010/c2_w1_br
+ u_t018_010/c2_r0_rbl u_t018_010/c2_r1_rbl u_t018_010/c3_w0_bl u_t018_010/c3_w0_br
+ u_t018_010/c3_w1_bl u_t018_010/c3_w1_br u_t018_010/c3_r0_rbl u_t018_010/c3_r1_rbl
+ u_t018_010/r0_w0_wl u_t018_010/r0_w1_wl u_t018_010/r0_r0_rwl u_t018_010/r0_r1_rwl
+ u_t018_010/r1_w0_wl u_t018_010/r1_w1_wl u_t018_010/r1_r0_rwl u_t018_010/r1_r1_rwl
+ u_t018_010/r2_w0_wl u_t018_010/r2_w1_wl u_t018_010/r2_r0_rwl u_t018_010/r2_r1_rwl
+ u_t018_010/r3_w0_wl u_t018_010/r3_w1_wl u_t018_010/r3_r0_rwl u_t018_010/r3_r1_rwl
+ VSS u_t018_010/VSS VSUBS detronyx_12t_2w2r_rc4_4x4_routed_5layer_direct
Xu_t018_021 u_t018_021/c0_w0_bl u_t018_021/c0_w0_br u_t018_021/c0_w1_bl u_t018_021/c0_w1_br
+ u_t018_021/c0_r0_rbl u_t018_021/c0_r1_rbl u_t018_021/c1_w0_bl u_t018_021/c1_w0_br
+ u_t018_021/c1_w1_bl u_t018_021/c1_w1_br u_t018_021/c1_r0_rbl u_t018_021/c1_r1_rbl
+ u_t018_021/c2_w0_bl u_t018_021/c2_w0_br u_t018_021/c2_w1_bl u_t018_021/c2_w1_br
+ u_t018_021/c2_r0_rbl u_t018_021/c2_r1_rbl u_t018_021/c3_w0_bl u_t018_021/c3_w0_br
+ u_t018_021/c3_w1_bl u_t018_021/c3_w1_br u_t018_021/c3_r0_rbl u_t018_021/c3_r1_rbl
+ u_t018_021/r0_w0_wl u_t018_021/r0_w1_wl u_t018_021/r0_r0_rwl u_t018_021/r0_r1_rwl
+ u_t018_021/r1_w0_wl u_t018_021/r1_w1_wl u_t018_021/r1_r0_rwl u_t018_021/r1_r1_rwl
+ u_t018_021/r2_w0_wl u_t018_021/r2_w1_wl u_t018_021/r2_r0_rwl u_t018_021/r2_r1_rwl
+ u_t018_021/r3_w0_wl u_t018_021/r3_w1_wl u_t018_021/r3_r0_rwl u_t018_021/r3_r1_rwl
+ u_t018_021/VDD u_t018_024/VSS VSUBS detronyx_12t_2w2r_rc4_4x4_routed_5layer_direct
Xu_t009_021 u_t009_021/c0_w0_bl u_t009_021/c0_w0_br u_t009_021/c0_w1_bl u_t009_021/c0_w1_br
+ u_t009_021/c0_r0_rbl u_t009_021/c0_r1_rbl u_t009_021/c1_w0_bl u_t009_021/c1_w0_br
+ u_t009_021/c1_w1_bl u_t009_021/c1_w1_br u_t009_021/c1_r0_rbl u_t009_021/c1_r1_rbl
+ u_t009_021/c2_w0_bl u_t009_021/c2_w0_br u_t009_021/c2_w1_bl u_t009_021/c2_w1_br
+ u_t009_021/c2_r0_rbl u_t009_021/c2_r1_rbl u_t009_021/c3_w0_bl u_t009_021/c3_w0_br
+ u_t009_021/c3_w1_bl u_t009_021/c3_w1_br u_t009_021/c3_r0_rbl u_t009_021/c3_r1_rbl
+ u_t009_021/r0_w0_wl u_t009_021/r0_w1_wl u_t009_021/r0_r0_rwl u_t009_021/r0_r1_rwl
+ u_t009_021/r1_w0_wl u_t009_021/r1_w1_wl u_t009_021/r1_r0_rwl u_t009_021/r1_r1_rwl
+ u_t009_021/r2_w0_wl u_t009_021/r2_w1_wl u_t009_021/r2_r0_rwl u_t009_021/r2_r1_rwl
+ u_t009_021/r3_w0_wl u_t009_021/r3_w1_wl u_t009_021/r3_r0_rwl u_t009_021/r3_r1_rwl
+ u_t009_021/VDD u_t009_031/VSS VSUBS detronyx_12t_2w2r_rc4_4x4_routed_5layer_direct
Xu_t009_010 u_t009_010/c0_w0_bl u_t009_010/c0_w0_br u_t009_010/c0_w1_bl u_t009_010/c0_w1_br
+ u_t009_010/c0_r0_rbl u_t009_010/c0_r1_rbl u_t009_010/c1_w0_bl u_t009_010/c1_w0_br
+ u_t009_010/c1_w1_bl u_t009_010/c1_w1_br u_t009_010/c1_r0_rbl u_t009_010/c1_r1_rbl
+ u_t009_010/c2_w0_bl u_t009_010/c2_w0_br u_t009_010/c2_w1_bl u_t009_010/c2_w1_br
+ u_t009_010/c2_r0_rbl u_t009_010/c2_r1_rbl u_t009_010/c3_w0_bl u_t009_010/c3_w0_br
+ u_t009_010/c3_w1_bl u_t009_010/c3_w1_br u_t009_010/c3_r0_rbl u_t009_010/c3_r1_rbl
+ u_t009_010/r0_w0_wl u_t009_010/r0_w1_wl u_t009_010/r0_r0_rwl u_t009_010/r0_r1_rwl
+ u_t009_010/r1_w0_wl u_t009_010/r1_w1_wl u_t009_010/r1_r0_rwl u_t009_010/r1_r1_rwl
+ u_t009_010/r2_w0_wl u_t009_010/r2_w1_wl u_t009_010/r2_r0_rwl u_t009_010/r2_r1_rwl
+ u_t009_010/r3_w0_wl u_t009_010/r3_w1_wl u_t009_010/r3_r0_rwl u_t009_010/r3_r1_rwl
+ VSS u_t009_031/VSS VSUBS detronyx_12t_2w2r_rc4_4x4_routed_5layer_direct
Xu_t024_002 u_t024_002/c0_w0_bl u_t024_002/c0_w0_br u_t024_002/c0_w1_bl u_t024_002/c0_w1_br
+ u_t024_002/c0_r0_rbl u_t024_002/c0_r1_rbl u_t024_002/c1_w0_bl u_t024_002/c1_w0_br
+ u_t024_002/c1_w1_bl u_t024_002/c1_w1_br u_t024_002/c1_r0_rbl u_t024_002/c1_r1_rbl
+ u_t024_002/c2_w0_bl u_t024_002/c2_w0_br u_t024_002/c2_w1_bl u_t024_002/c2_w1_br
+ u_t024_002/c2_r0_rbl u_t024_002/c2_r1_rbl u_t024_002/c3_w0_bl u_t024_002/c3_w0_br
+ u_t024_002/c3_w1_bl u_t024_002/c3_w1_br u_t024_002/c3_r0_rbl u_t024_002/c3_r1_rbl
+ u_t024_002/r0_w0_wl u_t024_002/r0_w1_wl u_t024_002/r0_r0_rwl u_t024_002/r0_r1_rwl
+ u_t024_002/r1_w0_wl u_t024_002/r1_w1_wl u_t024_002/r1_r0_rwl u_t024_002/r1_r1_rwl
+ u_t024_002/r2_w0_wl u_t024_002/r2_w1_wl u_t024_002/r2_r0_rwl u_t024_002/r2_r1_rwl
+ u_t024_002/r3_w0_wl u_t024_002/r3_w1_wl u_t024_002/r3_r0_rwl u_t024_002/r3_r1_rwl
+ VSS u_t024_002/VSS VSUBS detronyx_12t_2w2r_rc4_4x4_routed_5layer_direct
Xgf180mcu_as_sc_mcu7t3v3__nand3_2_25 gf180mcu_as_sc_mcu7t3v3__nor2_2_8/VDD gf180mcu_as_sc_mcu7t3v3__nor2_2_8/VSS
+ VSS VSS VSS VSS gf180mcu_as_sc_mcu7t3v3__nor2_2_8/VNW VSUBS gf180mcu_as_sc_mcu7t3v3__nand3_2
Xgf180mcu_as_sc_mcu7t3v3__nand3_2_14 gf180mcu_as_sc_mcu7t3v3__nor2_2_5/VDD gf180mcu_as_sc_mcu7t3v3__nor2_2_5/VSS
+ VSS VSS VSS VSS gf180mcu_as_sc_mcu7t3v3__nor2_2_5/VNW VSUBS gf180mcu_as_sc_mcu7t3v3__nand3_2
Xu_t024_024 u_t024_024/c0_w0_bl u_t024_024/c0_w0_br u_t024_024/c0_w1_bl u_t024_024/c0_w1_br
+ u_t024_024/c0_r0_rbl u_t024_024/c0_r1_rbl u_t024_024/c1_w0_bl u_t024_024/c1_w0_br
+ u_t024_024/c1_w1_bl u_t024_024/c1_w1_br u_t024_024/c1_r0_rbl u_t024_024/c1_r1_rbl
+ u_t024_024/c2_w0_bl u_t024_024/c2_w0_br u_t024_024/c2_w1_bl u_t024_024/c2_w1_br
+ u_t024_024/c2_r0_rbl u_t024_024/c2_r1_rbl u_t024_024/c3_w0_bl u_t024_024/c3_w0_br
+ u_t024_024/c3_w1_bl u_t024_024/c3_w1_br u_t024_024/c3_r0_rbl u_t024_024/c3_r1_rbl
+ u_t024_024/r0_w0_wl u_t024_024/r0_w1_wl u_t024_024/r0_r0_rwl u_t024_024/r0_r1_rwl
+ u_t024_024/r1_w0_wl u_t024_024/r1_w1_wl u_t024_024/r1_r0_rwl u_t024_024/r1_r1_rwl
+ u_t024_024/r2_w0_wl u_t024_024/r2_w1_wl u_t024_024/r2_r0_rwl u_t024_024/r2_r1_rwl
+ u_t024_024/r3_w0_wl u_t024_024/r3_w1_wl u_t024_024/r3_r0_rwl u_t024_024/r3_r1_rwl
+ VSS u_t024_024/VSS VSUBS detronyx_12t_2w2r_rc4_4x4_routed_5layer_direct
Xu_t024_013 u_t024_013/c0_w0_bl u_t024_013/c0_w0_br u_t024_013/c0_w1_bl u_t024_013/c0_w1_br
+ u_t024_013/c0_r0_rbl u_t024_013/c0_r1_rbl u_t024_013/c1_w0_bl u_t024_013/c1_w0_br
+ u_t024_013/c1_w1_bl u_t024_013/c1_w1_br u_t024_013/c1_r0_rbl u_t024_013/c1_r1_rbl
+ u_t024_013/c2_w0_bl u_t024_013/c2_w0_br u_t024_013/c2_w1_bl u_t024_013/c2_w1_br
+ u_t024_013/c2_r0_rbl u_t024_013/c2_r1_rbl u_t024_013/c3_w0_bl u_t024_013/c3_w0_br
+ u_t024_013/c3_w1_bl u_t024_013/c3_w1_br u_t024_013/c3_r0_rbl u_t024_013/c3_r1_rbl
+ u_t024_013/r0_w0_wl u_t024_013/r0_w1_wl u_t024_013/r0_r0_rwl u_t024_013/r0_r1_rwl
+ u_t024_013/r1_w0_wl u_t024_013/r1_w1_wl u_t024_013/r1_r0_rwl u_t024_013/r1_r1_rwl
+ u_t024_013/r2_w0_wl u_t024_013/r2_w1_wl u_t024_013/r2_r0_rwl u_t024_013/r2_r1_rwl
+ u_t024_013/r3_w0_wl u_t024_013/r3_w1_wl u_t024_013/r3_r0_rwl u_t024_013/r3_r1_rwl
+ u_t025_013/VDD u_t024_013/VSS VSUBS detronyx_12t_2w2r_rc4_4x4_routed_5layer_direct
Xgf180mcu_as_sc_mcu7t3v3__inv_2_1612 VSS gf180mcu_as_sc_mcu7t3v3__inv_2_1667/VDD VSS
+ gf180mcu_as_sc_mcu7t3v3__inv_2_1682/Y gf180mcu_as_sc_mcu7t3v3__inv_2_1666/VNW VSUBS
+ gf180mcu_as_sc_mcu7t3v3__inv_2
Xgf180mcu_as_sc_mcu7t3v3__inv_2_1601 gf180mcu_as_sc_mcu7t3v3__inv_2_1660/VDD VSS gf180mcu_as_sc_mcu7t3v3__inv_2_1601/Y
+ gf180mcu_as_sc_mcu7t3v3__inv_2_1660/Y gf180mcu_as_sc_mcu7t3v3__inv_2_1660/VNW VSUBS
+ gf180mcu_as_sc_mcu7t3v3__inv_2
Xgf180mcu_as_sc_mcu7t3v3__inv_2_190 gf180mcu_as_sc_mcu7t3v3__inv_2_192/VDD VSS VSS
+ VSS gf180mcu_as_sc_mcu7t3v3__inv_2_192/VNW VSUBS gf180mcu_as_sc_mcu7t3v3__inv_2
Xgf180mcu_as_sc_mcu7t3v3__inv_2_1645 gf180mcu_as_sc_mcu7t3v3__inv_2_1668/VDD gf180mcu_as_sc_mcu7t3v3__inv_2_1669/VDD
+ VSS gf180mcu_as_sc_mcu7t3v3__inv_2_1675/Y gf180mcu_as_sc_mcu7t3v3__inv_2_1668/VNW
+ VSUBS gf180mcu_as_sc_mcu7t3v3__inv_2
Xgf180mcu_as_sc_mcu7t3v3__inv_2_1634 gf180mcu_as_sc_mcu7t3v3__inv_2_1672/VDD VSS gf180mcu_as_sc_mcu7t3v3__inv_2_1675/Y
+ gf180mcu_as_sc_mcu7t3v3__inv_2_1675/Y gf180mcu_as_sc_mcu7t3v3__inv_2_1672/VNW VSUBS
+ gf180mcu_as_sc_mcu7t3v3__inv_2
Xgf180mcu_as_sc_mcu7t3v3__inv_2_1678 gf180mcu_as_sc_mcu7t3v3__inv_2_1678/VDD VSS gf180mcu_as_sc_mcu7t3v3__inv_2_1678/Y
+ VSS gf180mcu_as_sc_mcu7t3v3__inv_2_1678/VNW VSUBS gf180mcu_as_sc_mcu7t3v3__inv_2
Xgf180mcu_as_sc_mcu7t3v3__inv_2_1667 gf180mcu_as_sc_mcu7t3v3__inv_2_1667/VDD gf180mcu_as_sc_mcu7t3v3__inv_2_1667/VSS
+ gf180mcu_as_sc_mcu7t3v3__inv_2_1682/Y VSS gf180mcu_as_sc_mcu7t3v3__inv_2_1667/VNW
+ VSUBS gf180mcu_as_sc_mcu7t3v3__inv_2
Xgf180mcu_as_sc_mcu7t3v3__inv_2_1656 VSS gf180mcu_as_sc_mcu7t3v3__inv_2_1657/VDD gf180mcu_as_sc_mcu7t3v3__inv_2_1657/Y
+ VSS gf180mcu_as_sc_mcu7t3v3__inv_2_1656/VNW VSUBS gf180mcu_as_sc_mcu7t3v3__inv_2
Xgf180mcu_as_sc_mcu7t3v3__inv_2_1623 VSS VSS gf180mcu_as_sc_mcu7t3v3__inv_2_1660/Y
+ gf180mcu_as_sc_mcu7t3v3__inv_2_1660/Y gf180mcu_as_sc_mcu7t3v3__inv_2_1658/VNW VSUBS
+ gf180mcu_as_sc_mcu7t3v3__inv_2
Xgf180mcu_as_sc_mcu7t3v3__inv_2_1689 gf180mcu_as_sc_mcu7t3v3__inv_2_1691/VDD VSS VSS
+ gf180mcu_as_sc_mcu7t3v3__inv_2_1691/Y gf180mcu_as_sc_mcu7t3v3__inv_2_1691/VNW VSUBS
+ gf180mcu_as_sc_mcu7t3v3__inv_2
Xu_t015_024 u_t015_024/c0_w0_bl u_t015_024/c0_w0_br u_t015_024/c0_w1_bl u_t015_024/c0_w1_br
+ u_t015_024/c0_r0_rbl u_t015_024/c0_r1_rbl u_t015_024/c1_w0_bl u_t015_024/c1_w0_br
+ u_t015_024/c1_w1_bl u_t015_024/c1_w1_br u_t015_024/c1_r0_rbl u_t015_024/c1_r1_rbl
+ u_t015_024/c2_w0_bl u_t015_024/c2_w0_br u_t015_024/c2_w1_bl u_t015_024/c2_w1_br
+ u_t015_024/c2_r0_rbl u_t015_024/c2_r1_rbl u_t015_024/c3_w0_bl u_t015_024/c3_w0_br
+ u_t015_024/c3_w1_bl u_t015_024/c3_w1_br u_t015_024/c3_r0_rbl u_t015_024/c3_r1_rbl
+ u_t015_024/r0_w0_wl u_t015_024/r0_w1_wl u_t015_024/r0_r0_rwl u_t015_024/r0_r1_rwl
+ u_t015_024/r1_w0_wl u_t015_024/r1_w1_wl u_t015_024/r1_r0_rwl u_t015_024/r1_r1_rwl
+ u_t015_024/r2_w0_wl u_t015_024/r2_w1_wl u_t015_024/r2_r0_rwl u_t015_024/r2_r1_rwl
+ u_t015_024/r3_w0_wl u_t015_024/r3_w1_wl u_t015_024/r3_r0_rwl u_t015_024/r3_r1_rwl
+ VSS u_t015_024/VSS VSUBS detronyx_12t_2w2r_rc4_4x4_routed_5layer_direct
Xu_t015_013 u_t015_013/c0_w0_bl u_t015_013/c0_w0_br u_t015_013/c0_w1_bl u_t015_013/c0_w1_br
+ u_t015_013/c0_r0_rbl u_t015_013/c0_r1_rbl u_t015_013/c1_w0_bl u_t015_013/c1_w0_br
+ u_t015_013/c1_w1_bl u_t015_013/c1_w1_br u_t015_013/c1_r0_rbl u_t015_013/c1_r1_rbl
+ u_t015_013/c2_w0_bl u_t015_013/c2_w0_br u_t015_013/c2_w1_bl u_t015_013/c2_w1_br
+ u_t015_013/c2_r0_rbl u_t015_013/c2_r1_rbl u_t015_013/c3_w0_bl u_t015_013/c3_w0_br
+ u_t015_013/c3_w1_bl u_t015_013/c3_w1_br u_t015_013/c3_r0_rbl u_t015_013/c3_r1_rbl
+ u_t015_013/r0_w0_wl u_t015_013/r0_w1_wl u_t015_013/r0_r0_rwl u_t015_013/r0_r1_rwl
+ u_t015_013/r1_w0_wl u_t015_013/r1_w1_wl u_t015_013/r1_r0_rwl u_t015_013/r1_r1_rwl
+ u_t015_013/r2_w0_wl u_t015_013/r2_w1_wl u_t015_013/r2_r0_rwl u_t015_013/r2_r1_rwl
+ u_t015_013/r3_w0_wl u_t015_013/r3_w1_wl u_t015_013/r3_r0_rwl u_t015_013/r3_r1_rwl
+ u_t015_013/VDD u_t015_013/VSS VSUBS detronyx_12t_2w2r_rc4_4x4_routed_5layer_direct
Xu_t015_002 u_t015_002/c0_w0_bl u_t015_002/c0_w0_br u_t015_002/c0_w1_bl u_t015_002/c0_w1_br
+ u_t015_002/c0_r0_rbl u_t015_002/c0_r1_rbl u_t015_002/c1_w0_bl u_t015_002/c1_w0_br
+ u_t015_002/c1_w1_bl u_t015_002/c1_w1_br u_t015_002/c1_r0_rbl u_t015_002/c1_r1_rbl
+ u_t015_002/c2_w0_bl u_t015_002/c2_w0_br u_t015_002/c2_w1_bl u_t015_002/c2_w1_br
+ u_t015_002/c2_r0_rbl u_t015_002/c2_r1_rbl u_t015_002/c3_w0_bl u_t015_002/c3_w0_br
+ u_t015_002/c3_w1_bl u_t015_002/c3_w1_br u_t015_002/c3_r0_rbl u_t015_002/c3_r1_rbl
+ u_t015_002/r0_w0_wl u_t015_002/r0_w1_wl u_t015_002/r0_r0_rwl u_t015_002/r0_r1_rwl
+ u_t015_002/r1_w0_wl u_t015_002/r1_w1_wl u_t015_002/r1_r0_rwl u_t015_002/r1_r1_rwl
+ u_t015_002/r2_w0_wl u_t015_002/r2_w1_wl u_t015_002/r2_r0_rwl u_t015_002/r2_r1_rwl
+ u_t015_002/r3_w0_wl u_t015_002/r3_w1_wl u_t015_002/r3_r0_rwl u_t015_002/r3_r1_rwl
+ VSS u_t015_002/VSS VSUBS detronyx_12t_2w2r_rc4_4x4_routed_5layer_direct
Xu_t030_027 u_t030_027/c0_w0_bl u_t030_027/c0_w0_br u_t030_027/c0_w1_bl u_t030_027/c0_w1_br
+ u_t030_027/c0_r0_rbl u_t030_027/c0_r1_rbl u_t030_027/c1_w0_bl u_t030_027/c1_w0_br
+ u_t030_027/c1_w1_bl u_t030_027/c1_w1_br u_t030_027/c1_r0_rbl u_t030_027/c1_r1_rbl
+ u_t030_027/c2_w0_bl u_t030_027/c2_w0_br u_t030_027/c2_w1_bl u_t030_027/c2_w1_br
+ u_t030_027/c2_r0_rbl u_t030_027/c2_r1_rbl u_t030_027/c3_w0_bl u_t030_027/c3_w0_br
+ u_t030_027/c3_w1_bl u_t030_027/c3_w1_br u_t030_027/c3_r0_rbl u_t030_027/c3_r1_rbl
+ u_t030_027/r0_w0_wl u_t030_027/r0_w1_wl u_t030_027/r0_r0_rwl u_t030_027/r0_r1_rwl
+ u_t030_027/r1_w0_wl u_t030_027/r1_w1_wl u_t030_027/r1_r0_rwl u_t030_027/r1_r1_rwl
+ u_t030_027/r2_w0_wl u_t030_027/r2_w1_wl u_t030_027/r2_r0_rwl u_t030_027/r2_r1_rwl
+ u_t030_027/r3_w0_wl u_t030_027/r3_w1_wl u_t030_027/r3_r0_rwl u_t030_027/r3_r1_rwl
+ u_t030_027/VDD u_t030_031/VSS VSUBS detronyx_12t_2w2r_rc4_4x4_routed_5layer_direct
Xu_t030_016 u_t030_016/c0_w0_bl u_t030_016/c0_w0_br u_t030_016/c0_w1_bl u_t030_016/c0_w1_br
+ u_t030_016/c0_r0_rbl u_t030_016/c0_r1_rbl u_t030_016/c1_w0_bl u_t030_016/c1_w0_br
+ u_t030_016/c1_w1_bl u_t030_016/c1_w1_br u_t030_016/c1_r0_rbl u_t030_016/c1_r1_rbl
+ u_t030_016/c2_w0_bl u_t030_016/c2_w0_br u_t030_016/c2_w1_bl u_t030_016/c2_w1_br
+ u_t030_016/c2_r0_rbl u_t030_016/c2_r1_rbl u_t030_016/c3_w0_bl u_t030_016/c3_w0_br
+ u_t030_016/c3_w1_bl u_t030_016/c3_w1_br u_t030_016/c3_r0_rbl u_t030_016/c3_r1_rbl
+ u_t030_016/r0_w0_wl u_t030_016/r0_w1_wl u_t030_016/r0_r0_rwl u_t030_016/r0_r1_rwl
+ u_t030_016/r1_w0_wl u_t030_016/r1_w1_wl u_t030_016/r1_r0_rwl u_t030_016/r1_r1_rwl
+ u_t030_016/r2_w0_wl u_t030_016/r2_w1_wl u_t030_016/r2_r0_rwl u_t030_016/r2_r1_rwl
+ u_t030_016/r3_w0_wl u_t030_016/r3_w1_wl u_t030_016/r3_r0_rwl u_t030_016/r3_r1_rwl
+ VSS u_t030_031/VSS VSUBS detronyx_12t_2w2r_rc4_4x4_routed_5layer_direct
Xu_t030_005 u_t030_005/c0_w0_bl u_t030_005/c0_w0_br u_t030_005/c0_w1_bl u_t030_005/c0_w1_br
+ u_t030_005/c0_r0_rbl u_t030_005/c0_r1_rbl u_t030_005/c1_w0_bl u_t030_005/c1_w0_br
+ u_t030_005/c1_w1_bl u_t030_005/c1_w1_br u_t030_005/c1_r0_rbl u_t030_005/c1_r1_rbl
+ u_t030_005/c2_w0_bl u_t030_005/c2_w0_br u_t030_005/c2_w1_bl u_t030_005/c2_w1_br
+ u_t030_005/c2_r0_rbl u_t030_005/c2_r1_rbl u_t030_005/c3_w0_bl u_t030_005/c3_w0_br
+ u_t030_005/c3_w1_bl u_t030_005/c3_w1_br u_t030_005/c3_r0_rbl u_t030_005/c3_r1_rbl
+ u_t030_005/r0_w0_wl u_t030_005/r0_w1_wl u_t030_005/r0_r0_rwl u_t030_005/r0_r1_rwl
+ u_t030_005/r1_w0_wl u_t030_005/r1_w1_wl u_t030_005/r1_r0_rwl u_t030_005/r1_r1_rwl
+ u_t030_005/r2_w0_wl u_t030_005/r2_w1_wl u_t030_005/r2_r0_rwl u_t030_005/r2_r1_rwl
+ u_t030_005/r3_w0_wl u_t030_005/r3_w1_wl u_t030_005/r3_r0_rwl u_t030_005/r3_r1_rwl
+ u_t030_005/VDD u_t030_031/VSS VSUBS detronyx_12t_2w2r_rc4_4x4_routed_5layer_direct
Xgf180mcu_as_sc_mcu7t3v3__nand4_2_406 VSS gf180mcu_as_sc_mcu7t3v3__inv_2_1387/VDD
+ VSS VSS VSS VSS VSS gf180mcu_as_sc_mcu7t3v3__inv_2_1386/VNW VSUBS gf180mcu_as_sc_mcu7t3v3__nand4_2
Xgf180mcu_as_sc_mcu7t3v3__nand4_2_417 VSS gf180mcu_as_sc_mcu7t3v3__inv_2_1416/VDD
+ VSS VSS VSS VSS gf180mcu_as_sc_mcu7t3v3__nand4_2_417/Y gf180mcu_as_sc_mcu7t3v3__inv_2_1412/VNW
+ VSUBS gf180mcu_as_sc_mcu7t3v3__nand4_2
Xu_t006_002 u_t006_002/c0_w0_bl u_t006_002/c0_w0_br u_t006_002/c0_w1_bl u_t006_002/c0_w1_br
+ u_t006_002/c0_r0_rbl u_t006_002/c0_r1_rbl u_t006_002/c1_w0_bl u_t006_002/c1_w0_br
+ u_t006_002/c1_w1_bl u_t006_002/c1_w1_br u_t006_002/c1_r0_rbl u_t006_002/c1_r1_rbl
+ u_t006_002/c2_w0_bl u_t006_002/c2_w0_br u_t006_002/c2_w1_bl u_t006_002/c2_w1_br
+ u_t006_002/c2_r0_rbl u_t006_002/c2_r1_rbl u_t006_002/c3_w0_bl u_t006_002/c3_w0_br
+ u_t006_002/c3_w1_bl u_t006_002/c3_w1_br u_t006_002/c3_r0_rbl u_t006_002/c3_r1_rbl
+ u_t006_002/r0_w0_wl u_t006_002/r0_w1_wl u_t006_002/r0_r0_rwl u_t006_002/r0_r1_rwl
+ u_t006_002/r1_w0_wl u_t006_002/r1_w1_wl u_t006_002/r1_r0_rwl u_t006_002/r1_r1_rwl
+ u_t006_002/r2_w0_wl u_t006_002/r2_w1_wl u_t006_002/r2_r0_rwl u_t006_002/r2_r1_rwl
+ u_t006_002/r3_w0_wl u_t006_002/r3_w1_wl u_t006_002/r3_r0_rwl u_t006_002/r3_r1_rwl
+ VSS u_t006_002/VSS VSUBS detronyx_12t_2w2r_rc4_4x4_routed_5layer_direct
Xgf180mcu_as_sc_mcu7t3v3__inv_2_7 gf180mcu_as_sc_mcu7t3v3__inv_2_8/VDD gf180mcu_as_sc_mcu7t3v3__inv_2_8/VSS
+ VSS gf180mcu_as_sc_mcu7t3v3__inv_2_8/A gf180mcu_as_sc_mcu7t3v3__inv_2_8/VNW VSUBS
+ gf180mcu_as_sc_mcu7t3v3__inv_2
Xgf180mcu_as_sc_mcu7t3v3__nand4_2_428 gf180mcu_as_sc_mcu7t3v3__inv_2_1502/VSS VSS
+ VSS VSS VSS VSS gf180mcu_as_sc_mcu7t3v3__nand4_2_428/Y gf180mcu_as_sc_mcu7t3v3__inv_2_1429/VNW
+ VSUBS gf180mcu_as_sc_mcu7t3v3__nand4_2
Xgf180mcu_as_sc_mcu7t3v3__nand4_2_439 VSS gf180mcu_as_sc_mcu7t3v3__inv_2_1499/VSS
+ VSS VSS VSS VSS VSS gf180mcu_as_sc_mcu7t3v3__inv_2_1499/VNW VSUBS gf180mcu_as_sc_mcu7t3v3__nand4_2
Xu_t021_027 u_t021_027/c0_w0_bl u_t021_027/c0_w0_br u_t021_027/c0_w1_bl u_t021_027/c0_w1_br
+ u_t021_027/c0_r0_rbl u_t021_027/c0_r1_rbl u_t021_027/c1_w0_bl u_t021_027/c1_w0_br
+ u_t021_027/c1_w1_bl u_t021_027/c1_w1_br u_t021_027/c1_r0_rbl u_t021_027/c1_r1_rbl
+ u_t021_027/c2_w0_bl u_t021_027/c2_w0_br u_t021_027/c2_w1_bl u_t021_027/c2_w1_br
+ u_t021_027/c2_r0_rbl u_t021_027/c2_r1_rbl u_t021_027/c3_w0_bl u_t021_027/c3_w0_br
+ u_t021_027/c3_w1_bl u_t021_027/c3_w1_br u_t021_027/c3_r0_rbl u_t021_027/c3_r1_rbl
+ u_t021_027/r0_w0_wl u_t021_027/r0_w1_wl u_t021_027/r0_r0_rwl u_t021_027/r0_r1_rwl
+ u_t021_027/r1_w0_wl u_t021_027/r1_w1_wl u_t021_027/r1_r0_rwl u_t021_027/r1_r1_rwl
+ u_t021_027/r2_w0_wl u_t021_027/r2_w1_wl u_t021_027/r2_r0_rwl u_t021_027/r2_r1_rwl
+ u_t021_027/r3_w0_wl u_t021_027/r3_w1_wl u_t021_027/r3_r0_rwl u_t021_027/r3_r1_rwl
+ u_t021_027/VDD u_t021_031/VSS VSUBS detronyx_12t_2w2r_rc4_4x4_routed_5layer_direct
Xu_t006_024 u_t006_024/c0_w0_bl u_t006_024/c0_w0_br u_t006_024/c0_w1_bl u_t006_024/c0_w1_br
+ u_t006_024/c0_r0_rbl u_t006_024/c0_r1_rbl u_t006_024/c1_w0_bl u_t006_024/c1_w0_br
+ u_t006_024/c1_w1_bl u_t006_024/c1_w1_br u_t006_024/c1_r0_rbl u_t006_024/c1_r1_rbl
+ u_t006_024/c2_w0_bl u_t006_024/c2_w0_br u_t006_024/c2_w1_bl u_t006_024/c2_w1_br
+ u_t006_024/c2_r0_rbl u_t006_024/c2_r1_rbl u_t006_024/c3_w0_bl u_t006_024/c3_w0_br
+ u_t006_024/c3_w1_bl u_t006_024/c3_w1_br u_t006_024/c3_r0_rbl u_t006_024/c3_r1_rbl
+ u_t006_024/r0_w0_wl u_t006_024/r0_w1_wl u_t006_024/r0_r0_rwl u_t006_024/r0_r1_rwl
+ u_t006_024/r1_w0_wl u_t006_024/r1_w1_wl u_t006_024/r1_r0_rwl u_t006_024/r1_r1_rwl
+ u_t006_024/r2_w0_wl u_t006_024/r2_w1_wl u_t006_024/r2_r0_rwl u_t006_024/r2_r1_rwl
+ u_t006_024/r3_w0_wl u_t006_024/r3_w1_wl u_t006_024/r3_r0_rwl u_t006_024/r3_r1_rwl
+ VSS u_t006_024/VSS VSUBS detronyx_12t_2w2r_rc4_4x4_routed_5layer_direct
Xu_t021_016 u_t021_016/c0_w0_bl u_t021_016/c0_w0_br u_t021_016/c0_w1_bl u_t021_016/c0_w1_br
+ u_t021_016/c0_r0_rbl u_t021_016/c0_r1_rbl u_t021_016/c1_w0_bl u_t021_016/c1_w0_br
+ u_t021_016/c1_w1_bl u_t021_016/c1_w1_br u_t021_016/c1_r0_rbl u_t021_016/c1_r1_rbl
+ u_t021_016/c2_w0_bl u_t021_016/c2_w0_br u_t021_016/c2_w1_bl u_t021_016/c2_w1_br
+ u_t021_016/c2_r0_rbl u_t021_016/c2_r1_rbl u_t021_016/c3_w0_bl u_t021_016/c3_w0_br
+ u_t021_016/c3_w1_bl u_t021_016/c3_w1_br u_t021_016/c3_r0_rbl u_t021_016/c3_r1_rbl
+ u_t021_016/r0_w0_wl u_t021_016/r0_w1_wl u_t021_016/r0_r0_rwl u_t021_016/r0_r1_rwl
+ u_t021_016/r1_w0_wl u_t021_016/r1_w1_wl u_t021_016/r1_r0_rwl u_t021_016/r1_r1_rwl
+ u_t021_016/r2_w0_wl u_t021_016/r2_w1_wl u_t021_016/r2_r0_rwl u_t021_016/r2_r1_rwl
+ u_t021_016/r3_w0_wl u_t021_016/r3_w1_wl u_t021_016/r3_r0_rwl u_t021_016/r3_r1_rwl
+ VSS u_t021_031/VSS VSUBS detronyx_12t_2w2r_rc4_4x4_routed_5layer_direct
Xu_t006_013 u_t006_013/c0_w0_bl u_t006_013/c0_w0_br u_t006_013/c0_w1_bl u_t006_013/c0_w1_br
+ u_t006_013/c0_r0_rbl u_t006_013/c0_r1_rbl u_t006_013/c1_w0_bl u_t006_013/c1_w0_br
+ u_t006_013/c1_w1_bl u_t006_013/c1_w1_br u_t006_013/c1_r0_rbl u_t006_013/c1_r1_rbl
+ u_t006_013/c2_w0_bl u_t006_013/c2_w0_br u_t006_013/c2_w1_bl u_t006_013/c2_w1_br
+ u_t006_013/c2_r0_rbl u_t006_013/c2_r1_rbl u_t006_013/c3_w0_bl u_t006_013/c3_w0_br
+ u_t006_013/c3_w1_bl u_t006_013/c3_w1_br u_t006_013/c3_r0_rbl u_t006_013/c3_r1_rbl
+ u_t006_013/r0_w0_wl u_t006_013/r0_w1_wl u_t006_013/r0_r0_rwl u_t006_013/r0_r1_rwl
+ u_t006_013/r1_w0_wl u_t006_013/r1_w1_wl u_t006_013/r1_r0_rwl u_t006_013/r1_r1_rwl
+ u_t006_013/r2_w0_wl u_t006_013/r2_w1_wl u_t006_013/r2_r0_rwl u_t006_013/r2_r1_rwl
+ u_t006_013/r3_w0_wl u_t006_013/r3_w1_wl u_t006_013/r3_r0_rwl u_t006_013/r3_r1_rwl
+ u_t006_013/VDD u_t006_013/VSS VSUBS detronyx_12t_2w2r_rc4_4x4_routed_5layer_direct
Xu_t021_005 u_t021_005/c0_w0_bl u_t021_005/c0_w0_br u_t021_005/c0_w1_bl u_t021_005/c0_w1_br
+ u_t021_005/c0_r0_rbl u_t021_005/c0_r1_rbl u_t021_005/c1_w0_bl u_t021_005/c1_w0_br
+ u_t021_005/c1_w1_bl u_t021_005/c1_w1_br u_t021_005/c1_r0_rbl u_t021_005/c1_r1_rbl
+ u_t021_005/c2_w0_bl u_t021_005/c2_w0_br u_t021_005/c2_w1_bl u_t021_005/c2_w1_br
+ u_t021_005/c2_r0_rbl u_t021_005/c2_r1_rbl u_t021_005/c3_w0_bl u_t021_005/c3_w0_br
+ u_t021_005/c3_w1_bl u_t021_005/c3_w1_br u_t021_005/c3_r0_rbl u_t021_005/c3_r1_rbl
+ u_t021_005/r0_w0_wl u_t021_005/r0_w1_wl u_t021_005/r0_r0_rwl u_t021_005/r0_r1_rwl
+ u_t021_005/r1_w0_wl u_t021_005/r1_w1_wl u_t021_005/r1_r0_rwl u_t021_005/r1_r1_rwl
+ u_t021_005/r2_w0_wl u_t021_005/r2_w1_wl u_t021_005/r2_r0_rwl u_t021_005/r2_r1_rwl
+ u_t021_005/r3_w0_wl u_t021_005/r3_w1_wl u_t021_005/r3_r0_rwl u_t021_005/r3_r1_rwl
+ u_t021_005/VDD u_t021_031/VSS VSUBS detronyx_12t_2w2r_rc4_4x4_routed_5layer_direct
Xu_t012_027 u_t012_027/c0_w0_bl u_t012_027/c0_w0_br u_t012_027/c0_w1_bl u_t012_027/c0_w1_br
+ u_t012_027/c0_r0_rbl u_t012_027/c0_r1_rbl u_t012_027/c1_w0_bl u_t012_027/c1_w0_br
+ u_t012_027/c1_w1_bl u_t012_027/c1_w1_br u_t012_027/c1_r0_rbl u_t012_027/c1_r1_rbl
+ u_t012_027/c2_w0_bl u_t012_027/c2_w0_br u_t012_027/c2_w1_bl u_t012_027/c2_w1_br
+ u_t012_027/c2_r0_rbl u_t012_027/c2_r1_rbl u_t012_027/c3_w0_bl u_t012_027/c3_w0_br
+ u_t012_027/c3_w1_bl u_t012_027/c3_w1_br u_t012_027/c3_r0_rbl u_t012_027/c3_r1_rbl
+ u_t012_027/r0_w0_wl u_t012_027/r0_w1_wl u_t012_027/r0_r0_rwl u_t012_027/r0_r1_rwl
+ u_t012_027/r1_w0_wl u_t012_027/r1_w1_wl u_t012_027/r1_r0_rwl u_t012_027/r1_r1_rwl
+ u_t012_027/r2_w0_wl u_t012_027/r2_w1_wl u_t012_027/r2_r0_rwl u_t012_027/r2_r1_rwl
+ u_t012_027/r3_w0_wl u_t012_027/r3_w1_wl u_t012_027/r3_r0_rwl u_t012_027/r3_r1_rwl
+ u_t012_027/VDD u_t012_031/VSS VSUBS detronyx_12t_2w2r_rc4_4x4_routed_5layer_direct
Xu_t012_016 u_t012_016/c0_w0_bl u_t012_016/c0_w0_br u_t012_016/c0_w1_bl u_t012_016/c0_w1_br
+ u_t012_016/c0_r0_rbl u_t012_016/c0_r1_rbl u_t012_016/c1_w0_bl u_t012_016/c1_w0_br
+ u_t012_016/c1_w1_bl u_t012_016/c1_w1_br u_t012_016/c1_r0_rbl u_t012_016/c1_r1_rbl
+ u_t012_016/c2_w0_bl u_t012_016/c2_w0_br u_t012_016/c2_w1_bl u_t012_016/c2_w1_br
+ u_t012_016/c2_r0_rbl u_t012_016/c2_r1_rbl u_t012_016/c3_w0_bl u_t012_016/c3_w0_br
+ u_t012_016/c3_w1_bl u_t012_016/c3_w1_br u_t012_016/c3_r0_rbl u_t012_016/c3_r1_rbl
+ u_t012_016/r0_w0_wl u_t012_016/r0_w1_wl u_t012_016/r0_r0_rwl u_t012_016/r0_r1_rwl
+ u_t012_016/r1_w0_wl u_t012_016/r1_w1_wl u_t012_016/r1_r0_rwl u_t012_016/r1_r1_rwl
+ u_t012_016/r2_w0_wl u_t012_016/r2_w1_wl u_t012_016/r2_r0_rwl u_t012_016/r2_r1_rwl
+ u_t012_016/r3_w0_wl u_t012_016/r3_w1_wl u_t012_016/r3_r0_rwl u_t012_016/r3_r1_rwl
+ VSS u_t012_031/VSS VSUBS detronyx_12t_2w2r_rc4_4x4_routed_5layer_direct
Xu_t012_005 u_t012_005/c0_w0_bl u_t012_005/c0_w0_br u_t012_005/c0_w1_bl u_t012_005/c0_w1_br
+ u_t012_005/c0_r0_rbl u_t012_005/c0_r1_rbl u_t012_005/c1_w0_bl u_t012_005/c1_w0_br
+ u_t012_005/c1_w1_bl u_t012_005/c1_w1_br u_t012_005/c1_r0_rbl u_t012_005/c1_r1_rbl
+ u_t012_005/c2_w0_bl u_t012_005/c2_w0_br u_t012_005/c2_w1_bl u_t012_005/c2_w1_br
+ u_t012_005/c2_r0_rbl u_t012_005/c2_r1_rbl u_t012_005/c3_w0_bl u_t012_005/c3_w0_br
+ u_t012_005/c3_w1_bl u_t012_005/c3_w1_br u_t012_005/c3_r0_rbl u_t012_005/c3_r1_rbl
+ u_t012_005/r0_w0_wl u_t012_005/r0_w1_wl u_t012_005/r0_r0_rwl u_t012_005/r0_r1_rwl
+ u_t012_005/r1_w0_wl u_t012_005/r1_w1_wl u_t012_005/r1_r0_rwl u_t012_005/r1_r1_rwl
+ u_t012_005/r2_w0_wl u_t012_005/r2_w1_wl u_t012_005/r2_r0_rwl u_t012_005/r2_r1_rwl
+ u_t012_005/r3_w0_wl u_t012_005/r3_w1_wl u_t012_005/r3_r0_rwl u_t012_005/r3_r1_rwl
+ u_t012_005/VDD u_t012_031/VSS VSUBS detronyx_12t_2w2r_rc4_4x4_routed_5layer_direct
Xgf180mcu_as_sc_mcu7t3v3__inv_2_1442 gf180mcu_as_sc_mcu7t3v3__inv_2_1444/VDD VSS VSS
+ VSS gf180mcu_as_sc_mcu7t3v3__inv_2_1444/VNW VSUBS gf180mcu_as_sc_mcu7t3v3__inv_2
Xgf180mcu_as_sc_mcu7t3v3__inv_2_1431 gf180mcu_as_sc_mcu7t3v3__inv_2_1432/VDD VSS VSS
+ VSS gf180mcu_as_sc_mcu7t3v3__inv_2_1432/VNW VSUBS gf180mcu_as_sc_mcu7t3v3__inv_2
Xgf180mcu_as_sc_mcu7t3v3__inv_2_1420 gf180mcu_as_sc_mcu7t3v3__inv_2_1420/VDD VSS VSS
+ VSS gf180mcu_as_sc_mcu7t3v3__inv_2_1420/VNW VSUBS gf180mcu_as_sc_mcu7t3v3__inv_2
Xgf180mcu_as_sc_mcu7t3v3__inv_2_1453 gf180mcu_as_sc_mcu7t3v3__inv_2_1499/VSS gf180mcu_as_sc_mcu7t3v3__inv_2_1457/VDD
+ gf180mcu_as_sc_mcu7t3v3__inv_2_1453/Y VSS gf180mcu_as_sc_mcu7t3v3__inv_2_1453/VNW
+ VSUBS gf180mcu_as_sc_mcu7t3v3__inv_2
Xgf180mcu_as_sc_mcu7t3v3__inv_2_1497 gf180mcu_as_sc_mcu7t3v3__inv_2_1497/VDD gf180mcu_as_sc_mcu7t3v3__inv_2_1497/VSS
+ gf180mcu_as_sc_mcu7t3v3__inv_2_1497/Y VSS gf180mcu_as_sc_mcu7t3v3__inv_2_1497/VNW
+ VSUBS gf180mcu_as_sc_mcu7t3v3__inv_2
Xgf180mcu_as_sc_mcu7t3v3__inv_2_1464 gf180mcu_as_sc_mcu7t3v3__inv_2_1485/VSS gf180mcu_as_sc_mcu7t3v3__inv_2_1468/VDD
+ gf180mcu_as_sc_mcu7t3v3__inv_2_1464/Y VSS gf180mcu_as_sc_mcu7t3v3__inv_2_1465/VNW
+ VSUBS gf180mcu_as_sc_mcu7t3v3__inv_2
Xgf180mcu_as_sc_mcu7t3v3__inv_2_1475 VSS gf180mcu_as_sc_mcu7t3v3__inv_2_1480/VDD gf180mcu_as_sc_mcu7t3v3__inv_2_1475/Y
+ VSS gf180mcu_as_sc_mcu7t3v3__inv_2_1476/VNW VSUBS gf180mcu_as_sc_mcu7t3v3__inv_2
Xgf180mcu_as_sc_mcu7t3v3__inv_2_1486 VSS gf180mcu_as_sc_mcu7t3v3__inv_2_1492/VDD VSS
+ VSS gf180mcu_as_sc_mcu7t3v3__inv_2_1488/VNW VSUBS gf180mcu_as_sc_mcu7t3v3__inv_2
Xgf180mcu_as_sc_mcu7t3v3__inv_2_904 VSS VSS VSS VSS gf180mcu_as_sc_mcu7t3v3__inv_2_905/VNW
+ VSUBS gf180mcu_as_sc_mcu7t3v3__inv_2
Xu_t003_027 u_t003_027/c0_w0_bl u_t003_027/c0_w0_br u_t003_027/c0_w1_bl u_t003_027/c0_w1_br
+ u_t003_027/c0_r0_rbl u_t003_027/c0_r1_rbl u_t003_027/c1_w0_bl u_t003_027/c1_w0_br
+ u_t003_027/c1_w1_bl u_t003_027/c1_w1_br u_t003_027/c1_r0_rbl u_t003_027/c1_r1_rbl
+ u_t003_027/c2_w0_bl u_t003_027/c2_w0_br u_t003_027/c2_w1_bl u_t003_027/c2_w1_br
+ u_t003_027/c2_r0_rbl u_t003_027/c2_r1_rbl u_t003_027/c3_w0_bl u_t003_027/c3_w0_br
+ u_t003_027/c3_w1_bl u_t003_027/c3_w1_br u_t003_027/c3_r0_rbl u_t003_027/c3_r1_rbl
+ u_t003_027/r0_w0_wl u_t003_027/r0_w1_wl u_t003_027/r0_r0_rwl u_t003_027/r0_r1_rwl
+ u_t003_027/r1_w0_wl u_t003_027/r1_w1_wl u_t003_027/r1_r0_rwl u_t003_027/r1_r1_rwl
+ u_t003_027/r2_w0_wl u_t003_027/r2_w1_wl u_t003_027/r2_r0_rwl u_t003_027/r2_r1_rwl
+ u_t003_027/r3_w0_wl u_t003_027/r3_w1_wl u_t003_027/r3_r0_rwl u_t003_027/r3_r1_rwl
+ u_t004_027/VDD u_t003_027/VSS VSUBS detronyx_12t_2w2r_rc4_4x4_routed_5layer_direct
Xu_t003_016 u_t003_016/c0_w0_bl u_t003_016/c0_w0_br u_t003_016/c0_w1_bl u_t003_016/c0_w1_br
+ u_t003_016/c0_r0_rbl u_t003_016/c0_r1_rbl u_t003_016/c1_w0_bl u_t003_016/c1_w0_br
+ u_t003_016/c1_w1_bl u_t003_016/c1_w1_br u_t003_016/c1_r0_rbl u_t003_016/c1_r1_rbl
+ u_t003_016/c2_w0_bl u_t003_016/c2_w0_br u_t003_016/c2_w1_bl u_t003_016/c2_w1_br
+ u_t003_016/c2_r0_rbl u_t003_016/c2_r1_rbl u_t003_016/c3_w0_bl u_t003_016/c3_w0_br
+ u_t003_016/c3_w1_bl u_t003_016/c3_w1_br u_t003_016/c3_r0_rbl u_t003_016/c3_r1_rbl
+ u_t003_016/r0_w0_wl u_t003_016/r0_w1_wl u_t003_016/r0_r0_rwl u_t003_016/r0_r1_rwl
+ u_t003_016/r1_w0_wl u_t003_016/r1_w1_wl u_t003_016/r1_r0_rwl u_t003_016/r1_r1_rwl
+ u_t003_016/r2_w0_wl u_t003_016/r2_w1_wl u_t003_016/r2_r0_rwl u_t003_016/r2_r1_rwl
+ u_t003_016/r3_w0_wl u_t003_016/r3_w1_wl u_t003_016/r3_r0_rwl u_t003_016/r3_r1_rwl
+ VSS u_t003_017/VSS VSUBS detronyx_12t_2w2r_rc4_4x4_routed_5layer_direct
Xu_t003_005 u_t003_005/c0_w0_bl u_t003_005/c0_w0_br u_t003_005/c0_w1_bl u_t003_005/c0_w1_br
+ u_t003_005/c0_r0_rbl u_t003_005/c0_r1_rbl u_t003_005/c1_w0_bl u_t003_005/c1_w0_br
+ u_t003_005/c1_w1_bl u_t003_005/c1_w1_br u_t003_005/c1_r0_rbl u_t003_005/c1_r1_rbl
+ u_t003_005/c2_w0_bl u_t003_005/c2_w0_br u_t003_005/c2_w1_bl u_t003_005/c2_w1_br
+ u_t003_005/c2_r0_rbl u_t003_005/c2_r1_rbl u_t003_005/c3_w0_bl u_t003_005/c3_w0_br
+ u_t003_005/c3_w1_bl u_t003_005/c3_w1_br u_t003_005/c3_r0_rbl u_t003_005/c3_r1_rbl
+ u_t003_005/r0_w0_wl u_t003_005/r0_w1_wl u_t003_005/r0_r0_rwl u_t003_005/r0_r1_rwl
+ u_t003_005/r1_w0_wl u_t003_005/r1_w1_wl u_t003_005/r1_r0_rwl u_t003_005/r1_r1_rwl
+ u_t003_005/r2_w0_wl u_t003_005/r2_w1_wl u_t003_005/r2_r0_rwl u_t003_005/r2_r1_rwl
+ u_t003_005/r3_w0_wl u_t003_005/r3_w1_wl u_t003_005/r3_r0_rwl u_t003_005/r3_r1_rwl
+ u_t004_005/VDD u_t003_005/VSS VSUBS detronyx_12t_2w2r_rc4_4x4_routed_5layer_direct
Xgf180mcu_as_sc_mcu7t3v3__inv_2_937 VSS VSS VSS VSS gf180mcu_as_sc_mcu7t3v3__inv_2_945/VNW
+ VSUBS gf180mcu_as_sc_mcu7t3v3__inv_2
Xgf180mcu_as_sc_mcu7t3v3__inv_2_926 VSS VSS VSS VSS gf180mcu_as_sc_mcu7t3v3__inv_2_928/VNW
+ VSUBS gf180mcu_as_sc_mcu7t3v3__inv_2
Xgf180mcu_as_sc_mcu7t3v3__inv_2_948 VSS VSS VSS VSS gf180mcu_as_sc_mcu7t3v3__inv_2_948/VNW
+ VSUBS gf180mcu_as_sc_mcu7t3v3__inv_2
Xgf180mcu_as_sc_mcu7t3v3__inv_2_959 gf180mcu_as_sc_mcu7t3v3__inv_2_967/VDD VSS VSS
+ gf180mcu_as_sc_mcu7t3v3__inv_2_997/Y gf180mcu_as_sc_mcu7t3v3__inv_2_967/VNW VSUBS
+ gf180mcu_as_sc_mcu7t3v3__inv_2
Xgf180mcu_as_sc_mcu7t3v3__inv_2_915 VSS VSS VSS VSS gf180mcu_as_sc_mcu7t3v3__inv_2_917/VNW
+ VSUBS gf180mcu_as_sc_mcu7t3v3__inv_2
Xgf180mcu_as_sc_mcu7t3v3__nand4_2_269 VSS VSS VSS VSS VSS VSS gf180mcu_as_sc_mcu7t3v3__nand4_2_269/Y
+ gf180mcu_as_sc_mcu7t3v3__inv_2_928/VNW VSUBS gf180mcu_as_sc_mcu7t3v3__nand4_2
Xgf180mcu_as_sc_mcu7t3v3__nand4_2_225 VSS VSS VSS VSS VSS VSS VSS gf180mcu_as_sc_mcu7t3v3__inv_2_792/VNW
+ VSUBS gf180mcu_as_sc_mcu7t3v3__nand4_2
Xgf180mcu_as_sc_mcu7t3v3__nand4_2_203 VSS gf180mcu_as_sc_mcu7t3v3__inv_2_647/VDD VSS
+ VSS VSS VSS VSS gf180mcu_as_sc_mcu7t3v3__inv_2_643/VNW VSUBS gf180mcu_as_sc_mcu7t3v3__nand4_2
Xgf180mcu_as_sc_mcu7t3v3__nand4_2_214 VSS VSS VSS VSS VSS VSS gf180mcu_as_sc_mcu7t3v3__nand4_2_214/Y
+ gf180mcu_as_sc_mcu7t3v3__inv_2_846/VNW VSUBS gf180mcu_as_sc_mcu7t3v3__nand4_2
Xgf180mcu_as_sc_mcu7t3v3__nand4_2_247 VSS VSS VSS VSS VSS VSS gf180mcu_as_sc_mcu7t3v3__nand4_2_247/Y
+ gf180mcu_as_sc_mcu7t3v3__inv_2_833/VNW VSUBS gf180mcu_as_sc_mcu7t3v3__nand4_2
Xgf180mcu_as_sc_mcu7t3v3__nand4_2_236 VSS VSS VSS VSS VSS VSS VSS gf180mcu_as_sc_mcu7t3v3__inv_2_836/VNW
+ VSUBS gf180mcu_as_sc_mcu7t3v3__nand4_2
Xgf180mcu_as_sc_mcu7t3v3__nand4_2_258 VSS VSS VSS VSS VSS VSS VSS gf180mcu_as_sc_mcu7t3v3__inv_2_884/VNW
+ VSUBS gf180mcu_as_sc_mcu7t3v3__nand4_2
Xu_t000_019 u_t000_019/c0_w0_bl u_t000_019/c0_w0_br u_t000_019/c0_w1_bl u_t000_019/c0_w1_br
+ u_t000_019/c0_r0_rbl u_t000_019/c0_r1_rbl u_t000_019/c1_w0_bl u_t000_019/c1_w0_br
+ u_t000_019/c1_w1_bl u_t000_019/c1_w1_br u_t000_019/c1_r0_rbl u_t000_019/c1_r1_rbl
+ u_t000_019/c2_w0_bl u_t000_019/c2_w0_br u_t000_019/c2_w1_bl u_t000_019/c2_w1_br
+ u_t000_019/c2_r0_rbl u_t000_019/c2_r1_rbl u_t000_019/c3_w0_bl u_t000_019/c3_w0_br
+ u_t000_019/c3_w1_bl u_t000_019/c3_w1_br u_t000_019/c3_r0_rbl u_t000_019/c3_r1_rbl
+ u_t000_019/r0_w0_wl u_t000_019/r0_w1_wl u_t000_019/r0_r0_rwl u_t000_019/r0_r1_rwl
+ u_t000_019/r1_w0_wl u_t000_019/r1_w1_wl u_t000_019/r1_r0_rwl u_t000_019/r1_r1_rwl
+ u_t000_019/r2_w0_wl u_t000_019/r2_w1_wl u_t000_019/r2_r0_rwl u_t000_019/r2_r1_rwl
+ u_t000_019/r3_w0_wl u_t000_019/r3_w1_wl u_t000_019/r3_r0_rwl u_t000_019/r3_r1_rwl
+ u_t000_019/VDD u_t000_031/VSS VSUBS detronyx_12t_2w2r_rc4_4x4_routed_5layer_direct
Xu_t000_008 u_t000_008/c0_w0_bl u_t000_008/c0_w0_br u_t000_008/c0_w1_bl u_t000_008/c0_w1_br
+ u_t000_008/c0_r0_rbl u_t000_008/c0_r1_rbl u_t000_008/c1_w0_bl u_t000_008/c1_w0_br
+ u_t000_008/c1_w1_bl u_t000_008/c1_w1_br u_t000_008/c1_r0_rbl u_t000_008/c1_r1_rbl
+ u_t000_008/c2_w0_bl u_t000_008/c2_w0_br u_t000_008/c2_w1_bl u_t000_008/c2_w1_br
+ u_t000_008/c2_r0_rbl u_t000_008/c2_r1_rbl u_t000_008/c3_w0_bl u_t000_008/c3_w0_br
+ u_t000_008/c3_w1_bl u_t000_008/c3_w1_br u_t000_008/c3_r0_rbl u_t000_008/c3_r1_rbl
+ u_t000_008/r0_w0_wl u_t000_008/r0_w1_wl u_t000_008/r0_r0_rwl u_t000_008/r0_r1_rwl
+ u_t000_008/r1_w0_wl u_t000_008/r1_w1_wl u_t000_008/r1_r0_rwl u_t000_008/r1_r1_rwl
+ u_t000_008/r2_w0_wl u_t000_008/r2_w1_wl u_t000_008/r2_r0_rwl u_t000_008/r2_r1_rwl
+ u_t000_008/r3_w0_wl u_t000_008/r3_w1_wl u_t000_008/r3_r0_rwl u_t000_008/r3_r1_rwl
+ VSS u_t000_031/VSS VSUBS detronyx_12t_2w2r_rc4_4x4_routed_5layer_direct
Xgf180mcu_as_sc_mcu7t3v3__inv_2_1272 gf180mcu_as_sc_mcu7t3v3__nor2_2_8/VDD gf180mcu_as_sc_mcu7t3v3__nand3_2_32/VSS
+ VSS VSS gf180mcu_as_sc_mcu7t3v3__nor2_2_8/VNW VSUBS gf180mcu_as_sc_mcu7t3v3__inv_2
Xgf180mcu_as_sc_mcu7t3v3__inv_2_1250 gf180mcu_as_sc_mcu7t3v3__nor2_2_8/VDD gf180mcu_as_sc_mcu7t3v3__nand3_2_32/VSS
+ VSS VSS gf180mcu_as_sc_mcu7t3v3__nor2_2_8/VNW VSUBS gf180mcu_as_sc_mcu7t3v3__inv_2
Xgf180mcu_as_sc_mcu7t3v3__inv_2_1261 gf180mcu_as_sc_mcu7t3v3__nand3_2_31/VDD gf180mcu_as_sc_mcu7t3v3__nand3_2_31/VSS
+ VSS VSS gf180mcu_as_sc_mcu7t3v3__nand3_2_31/VNW VSUBS gf180mcu_as_sc_mcu7t3v3__inv_2
Xgf180mcu_as_sc_mcu7t3v3__inv_2_1283 VSS VSS VSS VSS gf180mcu_as_sc_mcu7t3v3__inv_2_1284/VNW
+ VSUBS gf180mcu_as_sc_mcu7t3v3__inv_2
Xgf180mcu_as_sc_mcu7t3v3__inv_2_1294 gf180mcu_as_sc_mcu7t3v3__inv_2_1295/VDD VSS gf180mcu_as_sc_mcu7t3v3__inv_2_1294/Y
+ gf180mcu_as_sc_mcu7t3v3__inv_2_1295/Y gf180mcu_as_sc_mcu7t3v3__inv_2_1295/VNW VSUBS
+ gf180mcu_as_sc_mcu7t3v3__inv_2
Xgf180mcu_as_sc_mcu7t3v3__inv_2_745 VSS VSS VSS VSS gf180mcu_as_sc_mcu7t3v3__inv_2_745/VNW
+ VSUBS gf180mcu_as_sc_mcu7t3v3__inv_2
Xgf180mcu_as_sc_mcu7t3v3__inv_2_712 VSS VSS VSS gf180mcu_as_sc_mcu7t3v3__inv_2_716/Y
+ gf180mcu_as_sc_mcu7t3v3__inv_2_720/VNW VSUBS gf180mcu_as_sc_mcu7t3v3__inv_2
Xgf180mcu_as_sc_mcu7t3v3__inv_2_734 VSS VSS gf180mcu_as_sc_mcu7t3v3__inv_2_737/A gf180mcu_as_sc_mcu7t3v3__inv_2_735/Y
+ gf180mcu_as_sc_mcu7t3v3__inv_2_735/VNW VSUBS gf180mcu_as_sc_mcu7t3v3__inv_2
Xgf180mcu_as_sc_mcu7t3v3__inv_2_723 gf180mcu_as_sc_mcu7t3v3__inv_2_723/VDD VSS gf180mcu_as_sc_mcu7t3v3__inv_2_723/Y
+ VSS gf180mcu_as_sc_mcu7t3v3__inv_2_723/VNW VSUBS gf180mcu_as_sc_mcu7t3v3__inv_2
Xgf180mcu_as_sc_mcu7t3v3__inv_2_701 gf180mcu_as_sc_mcu7t3v3__inv_2_724/VSS gf180mcu_as_sc_mcu7t3v3__inv_2_711/VDD
+ gf180mcu_as_sc_mcu7t3v3__inv_2_701/Y gf180mcu_as_sc_mcu7t3v3__inv_2_732/Y gf180mcu_as_sc_mcu7t3v3__inv_2_703/VNW
+ VSUBS gf180mcu_as_sc_mcu7t3v3__inv_2
Xgf180mcu_as_sc_mcu7t3v3__inv_2_767 VSS VSS VSS VSS gf180mcu_as_sc_mcu7t3v3__inv_2_768/VNW
+ VSUBS gf180mcu_as_sc_mcu7t3v3__inv_2
Xgf180mcu_as_sc_mcu7t3v3__inv_2_756 VSS VSS gf180mcu_as_sc_mcu7t3v3__inv_2_756/Y VSS
+ gf180mcu_as_sc_mcu7t3v3__inv_2_756/VNW VSUBS gf180mcu_as_sc_mcu7t3v3__inv_2
Xgf180mcu_as_sc_mcu7t3v3__inv_2_789 VSS VSS gf180mcu_as_sc_mcu7t3v3__inv_2_789/Y VSS
+ gf180mcu_as_sc_mcu7t3v3__inv_2_789/VNW VSUBS gf180mcu_as_sc_mcu7t3v3__inv_2
Xgf180mcu_as_sc_mcu7t3v3__inv_2_778 VSS VSS gf180mcu_as_sc_mcu7t3v3__inv_2_778/Y VSS
+ gf180mcu_as_sc_mcu7t3v3__inv_2_780/VNW VSUBS gf180mcu_as_sc_mcu7t3v3__inv_2
Xgf180mcu_as_sc_mcu7t3v3__inv_2_1080 gf180mcu_as_sc_mcu7t3v3__inv_2_1080/VDD gf180mcu_as_sc_mcu7t3v3__inv_2_1084/VDD
+ gf180mcu_as_sc_mcu7t3v3__inv_2_1080/Y VSS gf180mcu_as_sc_mcu7t3v3__inv_2_1080/VNW
+ VSUBS gf180mcu_as_sc_mcu7t3v3__inv_2
Xgf180mcu_as_sc_mcu7t3v3__inv_2_1091 VSS gf180mcu_as_sc_mcu7t3v3__inv_2_1096/VDD gf180mcu_as_sc_mcu7t3v3__inv_2_1091/Y
+ gf180mcu_as_sc_mcu7t3v3__inv_2_1092/Y gf180mcu_as_sc_mcu7t3v3__inv_2_1092/VNW VSUBS
+ gf180mcu_as_sc_mcu7t3v3__inv_2
Xgf180mcu_as_sc_mcu7t3v3__nand4_2_3 gf180mcu_as_sc_mcu7t3v3__inv_2_0/VSS gf180mcu_as_sc_mcu7t3v3__inv_2_6/VSS
+ VSS VSS VSS VSS VSS gf180mcu_as_sc_mcu7t3v3__inv_2_58/VNW VSUBS gf180mcu_as_sc_mcu7t3v3__nand4_2
Xgf180mcu_as_sc_mcu7t3v3__inv_2_531 VSS VSS gf180mcu_as_sc_mcu7t3v3__inv_2_531/Y VSS
+ gf180mcu_as_sc_mcu7t3v3__inv_2_531/VNW VSUBS gf180mcu_as_sc_mcu7t3v3__inv_2
Xgf180mcu_as_sc_mcu7t3v3__inv_2_586 VSS gf180mcu_as_sc_mcu7t3v3__inv_2_636/VSS gf180mcu_as_sc_mcu7t3v3__inv_2_586/Y
+ gf180mcu_as_sc_mcu7t3v3__inv_2_631/A gf180mcu_as_sc_mcu7t3v3__inv_2_594/VNW VSUBS
+ gf180mcu_as_sc_mcu7t3v3__inv_2
Xgf180mcu_as_sc_mcu7t3v3__inv_2_564 VSS gf180mcu_as_sc_mcu7t3v3__inv_2_572/VDD gf180mcu_as_sc_mcu7t3v3__inv_2_564/Y
+ gf180mcu_as_sc_mcu7t3v3__inv_2_565/Y gf180mcu_as_sc_mcu7t3v3__inv_2_565/VNW VSUBS
+ gf180mcu_as_sc_mcu7t3v3__inv_2
Xgf180mcu_as_sc_mcu7t3v3__inv_2_575 gf180mcu_as_sc_mcu7t3v3__inv_2_576/VDD gf180mcu_as_sc_mcu7t3v3__inv_2_584/VDD
+ gf180mcu_as_sc_mcu7t3v3__inv_2_575/Y gf180mcu_as_sc_mcu7t3v3__inv_2_576/Y gf180mcu_as_sc_mcu7t3v3__inv_2_576/VNW
+ VSUBS gf180mcu_as_sc_mcu7t3v3__inv_2
Xgf180mcu_as_sc_mcu7t3v3__inv_2_553 gf180mcu_as_sc_mcu7t3v3__nor2_2_5/VDD gf180mcu_as_sc_mcu7t3v3__nand3_2_8/VSS
+ VSS VSS gf180mcu_as_sc_mcu7t3v3__nor2_2_5/VNW VSUBS gf180mcu_as_sc_mcu7t3v3__inv_2
Xgf180mcu_as_sc_mcu7t3v3__inv_2_597 gf180mcu_as_sc_mcu7t3v3__inv_2_597/VDD gf180mcu_as_sc_mcu7t3v3__inv_2_601/VDD
+ gf180mcu_as_sc_mcu7t3v3__inv_2_597/Y VSS gf180mcu_as_sc_mcu7t3v3__inv_2_597/VNW
+ VSUBS gf180mcu_as_sc_mcu7t3v3__inv_2
Xgf180mcu_as_sc_mcu7t3v3__inv_2_542 VSS VSS gf180mcu_as_sc_mcu7t3v3__inv_2_542/Y VSS
+ gf180mcu_as_sc_mcu7t3v3__inv_2_542/VNW VSUBS gf180mcu_as_sc_mcu7t3v3__inv_2
Xgf180mcu_as_sc_mcu7t3v3__inv_2_520 VSS VSS VSS VSS gf180mcu_as_sc_mcu7t3v3__inv_2_522/VNW
+ VSUBS gf180mcu_as_sc_mcu7t3v3__inv_2
Xgf180mcu_as_sc_mcu7t3v3__inv_2_394 VSS VSS VSS VSS gf180mcu_as_sc_mcu7t3v3__inv_2_395/VNW
+ VSUBS gf180mcu_as_sc_mcu7t3v3__inv_2
Xgf180mcu_as_sc_mcu7t3v3__inv_2_372 gf180mcu_as_sc_mcu7t3v3__nor2_2_6/VDD gf180mcu_as_sc_mcu7t3v3__nand3_2_3/VSS
+ VSS VSS gf180mcu_as_sc_mcu7t3v3__nor2_2_6/VNW VSUBS gf180mcu_as_sc_mcu7t3v3__inv_2
Xgf180mcu_as_sc_mcu7t3v3__inv_2_383 gf180mcu_as_sc_mcu7t3v3__nand3_2_5/VDD gf180mcu_as_sc_mcu7t3v3__nor2_2_4/VSS
+ VSS VSS gf180mcu_as_sc_mcu7t3v3__nand3_2_5/VNW VSUBS gf180mcu_as_sc_mcu7t3v3__inv_2
Xgf180mcu_as_sc_mcu7t3v3__inv_2_350 gf180mcu_as_sc_mcu7t3v3__inv_2_350/VDD gf180mcu_as_sc_mcu7t3v3__inv_2_351/VDD
+ gf180mcu_as_sc_mcu7t3v3__inv_2_66/Y VSS gf180mcu_as_sc_mcu7t3v3__inv_2_350/VNW VSUBS
+ gf180mcu_as_sc_mcu7t3v3__inv_2
Xgf180mcu_as_sc_mcu7t3v3__inv_2_361 gf180mcu_as_sc_mcu7t3v3__inv_2_361/VDD gf180mcu_as_sc_mcu7t3v3__inv_2_363/VDD
+ gf180mcu_as_sc_mcu7t3v3__inv_2_361/Y VSS gf180mcu_as_sc_mcu7t3v3__inv_2_361/VNW
+ VSUBS gf180mcu_as_sc_mcu7t3v3__inv_2
Xu_t027_022 u_t027_022/c0_w0_bl u_t027_022/c0_w0_br u_t027_022/c0_w1_bl u_t027_022/c0_w1_br
+ u_t027_022/c0_r0_rbl u_t027_022/c0_r1_rbl u_t027_022/c1_w0_bl u_t027_022/c1_w0_br
+ u_t027_022/c1_w1_bl u_t027_022/c1_w1_br u_t027_022/c1_r0_rbl u_t027_022/c1_r1_rbl
+ u_t027_022/c2_w0_bl u_t027_022/c2_w0_br u_t027_022/c2_w1_bl u_t027_022/c2_w1_br
+ u_t027_022/c2_r0_rbl u_t027_022/c2_r1_rbl u_t027_022/c3_w0_bl u_t027_022/c3_w0_br
+ u_t027_022/c3_w1_bl u_t027_022/c3_w1_br u_t027_022/c3_r0_rbl u_t027_022/c3_r1_rbl
+ u_t027_022/r0_w0_wl u_t027_022/r0_w1_wl u_t027_022/r0_r0_rwl u_t027_022/r0_r1_rwl
+ u_t027_022/r1_w0_wl u_t027_022/r1_w1_wl u_t027_022/r1_r0_rwl u_t027_022/r1_r1_rwl
+ u_t027_022/r2_w0_wl u_t027_022/r2_w1_wl u_t027_022/r2_r0_rwl u_t027_022/r2_r1_rwl
+ u_t027_022/r3_w0_wl u_t027_022/r3_w1_wl u_t027_022/r3_r0_rwl u_t027_022/r3_r1_rwl
+ VSS u_t027_024/VSS VSUBS detronyx_12t_2w2r_rc4_4x4_routed_5layer_direct
Xu_t027_011 u_t027_011/c0_w0_bl u_t027_011/c0_w0_br u_t027_011/c0_w1_bl u_t027_011/c0_w1_br
+ u_t027_011/c0_r0_rbl u_t027_011/c0_r1_rbl u_t027_011/c1_w0_bl u_t027_011/c1_w0_br
+ u_t027_011/c1_w1_bl u_t027_011/c1_w1_br u_t027_011/c1_r0_rbl u_t027_011/c1_r1_rbl
+ u_t027_011/c2_w0_bl u_t027_011/c2_w0_br u_t027_011/c2_w1_bl u_t027_011/c2_w1_br
+ u_t027_011/c2_r0_rbl u_t027_011/c2_r1_rbl u_t027_011/c3_w0_bl u_t027_011/c3_w0_br
+ u_t027_011/c3_w1_bl u_t027_011/c3_w1_br u_t027_011/c3_r0_rbl u_t027_011/c3_r1_rbl
+ u_t027_011/r0_w0_wl u_t027_011/r0_w1_wl u_t027_011/r0_r0_rwl u_t027_011/r0_r1_rwl
+ u_t027_011/r1_w0_wl u_t027_011/r1_w1_wl u_t027_011/r1_r0_rwl u_t027_011/r1_r1_rwl
+ u_t027_011/r2_w0_wl u_t027_011/r2_w1_wl u_t027_011/r2_r0_rwl u_t027_011/r2_r1_rwl
+ u_t027_011/r3_w0_wl u_t027_011/r3_w1_wl u_t027_011/r3_r0_rwl u_t027_011/r3_r1_rwl
+ u_t027_011/VDD u_t027_011/VSS VSUBS detronyx_12t_2w2r_rc4_4x4_routed_5layer_direct
Xu_t027_000 u_t027_000/c0_w0_bl u_t027_000/c0_w0_br u_t027_000/c0_w1_bl u_t027_000/c0_w1_br
+ u_t027_000/c0_r0_rbl u_t027_000/c0_r1_rbl u_t027_000/c1_w0_bl u_t027_000/c1_w0_br
+ u_t027_000/c1_w1_bl u_t027_000/c1_w1_br u_t027_000/c1_r0_rbl u_t027_000/c1_r1_rbl
+ u_t027_000/c2_w0_bl u_t027_000/c2_w0_br u_t027_000/c2_w1_bl u_t027_000/c2_w1_br
+ u_t027_000/c2_r0_rbl u_t027_000/c2_r1_rbl u_t027_000/c3_w0_bl u_t027_000/c3_w0_br
+ u_t027_000/c3_w1_bl u_t027_000/c3_w1_br u_t027_000/c3_r0_rbl u_t027_000/c3_r1_rbl
+ u_t027_000/r0_w0_wl u_t027_000/r0_w1_wl u_t027_000/r0_r0_rwl u_t027_000/r0_r1_rwl
+ u_t027_000/r1_w0_wl u_t027_000/r1_w1_wl u_t027_000/r1_r0_rwl u_t027_000/r1_r1_rwl
+ u_t027_000/r2_w0_wl u_t027_000/r2_w1_wl u_t027_000/r2_r0_rwl u_t027_000/r2_r1_rwl
+ u_t027_000/r3_w0_wl u_t027_000/r3_w1_wl u_t027_000/r3_r0_rwl u_t027_000/r3_r1_rwl
+ VSS u_t027_002/VSS VSUBS detronyx_12t_2w2r_rc4_4x4_routed_5layer_direct
Xu_t018_022 u_t018_022/c0_w0_bl u_t018_022/c0_w0_br u_t018_022/c0_w1_bl u_t018_022/c0_w1_br
+ u_t018_022/c0_r0_rbl u_t018_022/c0_r1_rbl u_t018_022/c1_w0_bl u_t018_022/c1_w0_br
+ u_t018_022/c1_w1_bl u_t018_022/c1_w1_br u_t018_022/c1_r0_rbl u_t018_022/c1_r1_rbl
+ u_t018_022/c2_w0_bl u_t018_022/c2_w0_br u_t018_022/c2_w1_bl u_t018_022/c2_w1_br
+ u_t018_022/c2_r0_rbl u_t018_022/c2_r1_rbl u_t018_022/c3_w0_bl u_t018_022/c3_w0_br
+ u_t018_022/c3_w1_bl u_t018_022/c3_w1_br u_t018_022/c3_r0_rbl u_t018_022/c3_r1_rbl
+ u_t018_022/r0_w0_wl u_t018_022/r0_w1_wl u_t018_022/r0_r0_rwl u_t018_022/r0_r1_rwl
+ u_t018_022/r1_w0_wl u_t018_022/r1_w1_wl u_t018_022/r1_r0_rwl u_t018_022/r1_r1_rwl
+ u_t018_022/r2_w0_wl u_t018_022/r2_w1_wl u_t018_022/r2_r0_rwl u_t018_022/r2_r1_rwl
+ u_t018_022/r3_w0_wl u_t018_022/r3_w1_wl u_t018_022/r3_r0_rwl u_t018_022/r3_r1_rwl
+ VSS u_t018_024/VSS VSUBS detronyx_12t_2w2r_rc4_4x4_routed_5layer_direct
Xu_t018_011 u_t018_011/c0_w0_bl u_t018_011/c0_w0_br u_t018_011/c0_w1_bl u_t018_011/c0_w1_br
+ u_t018_011/c0_r0_rbl u_t018_011/c0_r1_rbl u_t018_011/c1_w0_bl u_t018_011/c1_w0_br
+ u_t018_011/c1_w1_bl u_t018_011/c1_w1_br u_t018_011/c1_r0_rbl u_t018_011/c1_r1_rbl
+ u_t018_011/c2_w0_bl u_t018_011/c2_w0_br u_t018_011/c2_w1_bl u_t018_011/c2_w1_br
+ u_t018_011/c2_r0_rbl u_t018_011/c2_r1_rbl u_t018_011/c3_w0_bl u_t018_011/c3_w0_br
+ u_t018_011/c3_w1_bl u_t018_011/c3_w1_br u_t018_011/c3_r0_rbl u_t018_011/c3_r1_rbl
+ u_t018_011/r0_w0_wl u_t018_011/r0_w1_wl u_t018_011/r0_r0_rwl u_t018_011/r0_r1_rwl
+ u_t018_011/r1_w0_wl u_t018_011/r1_w1_wl u_t018_011/r1_r0_rwl u_t018_011/r1_r1_rwl
+ u_t018_011/r2_w0_wl u_t018_011/r2_w1_wl u_t018_011/r2_r0_rwl u_t018_011/r2_r1_rwl
+ u_t018_011/r3_w0_wl u_t018_011/r3_w1_wl u_t018_011/r3_r0_rwl u_t018_011/r3_r1_rwl
+ u_t018_011/VDD u_t018_011/VSS VSUBS detronyx_12t_2w2r_rc4_4x4_routed_5layer_direct
Xu_t018_000 u_t018_000/c0_w0_bl u_t018_000/c0_w0_br u_t018_000/c0_w1_bl u_t018_000/c0_w1_br
+ u_t018_000/c0_r0_rbl u_t018_000/c0_r1_rbl u_t018_000/c1_w0_bl u_t018_000/c1_w0_br
+ u_t018_000/c1_w1_bl u_t018_000/c1_w1_br u_t018_000/c1_r0_rbl u_t018_000/c1_r1_rbl
+ u_t018_000/c2_w0_bl u_t018_000/c2_w0_br u_t018_000/c2_w1_bl u_t018_000/c2_w1_br
+ u_t018_000/c2_r0_rbl u_t018_000/c2_r1_rbl u_t018_000/c3_w0_bl u_t018_000/c3_w0_br
+ u_t018_000/c3_w1_bl u_t018_000/c3_w1_br u_t018_000/c3_r0_rbl u_t018_000/c3_r1_rbl
+ u_t018_000/r0_w0_wl u_t018_000/r0_w1_wl u_t018_000/r0_r0_rwl u_t018_000/r0_r1_rwl
+ u_t018_000/r1_w0_wl u_t018_000/r1_w1_wl u_t018_000/r1_r0_rwl u_t018_000/r1_r1_rwl
+ u_t018_000/r2_w0_wl u_t018_000/r2_w1_wl u_t018_000/r2_r0_rwl u_t018_000/r2_r1_rwl
+ u_t018_000/r3_w0_wl u_t018_000/r3_w1_wl u_t018_000/r3_r0_rwl u_t018_000/r3_r1_rwl
+ VSS u_t018_002/VSS VSUBS detronyx_12t_2w2r_rc4_4x4_routed_5layer_direct
Xu_t024_025 u_t024_025/c0_w0_bl u_t024_025/c0_w0_br u_t024_025/c0_w1_bl u_t024_025/c0_w1_br
+ u_t024_025/c0_r0_rbl u_t024_025/c0_r1_rbl u_t024_025/c1_w0_bl u_t024_025/c1_w0_br
+ u_t024_025/c1_w1_bl u_t024_025/c1_w1_br u_t024_025/c1_r0_rbl u_t024_025/c1_r1_rbl
+ u_t024_025/c2_w0_bl u_t024_025/c2_w0_br u_t024_025/c2_w1_bl u_t024_025/c2_w1_br
+ u_t024_025/c2_r0_rbl u_t024_025/c2_r1_rbl u_t024_025/c3_w0_bl u_t024_025/c3_w0_br
+ u_t024_025/c3_w1_bl u_t024_025/c3_w1_br u_t024_025/c3_r0_rbl u_t024_025/c3_r1_rbl
+ u_t024_025/r0_w0_wl u_t024_025/r0_w1_wl u_t024_025/r0_r0_rwl u_t024_025/r0_r1_rwl
+ u_t024_025/r1_w0_wl u_t024_025/r1_w1_wl u_t024_025/r1_r0_rwl u_t024_025/r1_r1_rwl
+ u_t024_025/r2_w0_wl u_t024_025/r2_w1_wl u_t024_025/r2_r0_rwl u_t024_025/r2_r1_rwl
+ u_t024_025/r3_w0_wl u_t024_025/r3_w1_wl u_t024_025/r3_r0_rwl u_t024_025/r3_r1_rwl
+ VSS u_t024_025/VSS VSUBS detronyx_12t_2w2r_rc4_4x4_routed_5layer_direct
Xu_t009_022 u_t009_022/c0_w0_bl u_t009_022/c0_w0_br u_t009_022/c0_w1_bl u_t009_022/c0_w1_br
+ u_t009_022/c0_r0_rbl u_t009_022/c0_r1_rbl u_t009_022/c1_w0_bl u_t009_022/c1_w0_br
+ u_t009_022/c1_w1_bl u_t009_022/c1_w1_br u_t009_022/c1_r0_rbl u_t009_022/c1_r1_rbl
+ u_t009_022/c2_w0_bl u_t009_022/c2_w0_br u_t009_022/c2_w1_bl u_t009_022/c2_w1_br
+ u_t009_022/c2_r0_rbl u_t009_022/c2_r1_rbl u_t009_022/c3_w0_bl u_t009_022/c3_w0_br
+ u_t009_022/c3_w1_bl u_t009_022/c3_w1_br u_t009_022/c3_r0_rbl u_t009_022/c3_r1_rbl
+ u_t009_022/r0_w0_wl u_t009_022/r0_w1_wl u_t009_022/r0_r0_rwl u_t009_022/r0_r1_rwl
+ u_t009_022/r1_w0_wl u_t009_022/r1_w1_wl u_t009_022/r1_r0_rwl u_t009_022/r1_r1_rwl
+ u_t009_022/r2_w0_wl u_t009_022/r2_w1_wl u_t009_022/r2_r0_rwl u_t009_022/r2_r1_rwl
+ u_t009_022/r3_w0_wl u_t009_022/r3_w1_wl u_t009_022/r3_r0_rwl u_t009_022/r3_r1_rwl
+ VSS u_t009_031/VSS VSUBS detronyx_12t_2w2r_rc4_4x4_routed_5layer_direct
Xu_t024_014 u_t024_014/c0_w0_bl u_t024_014/c0_w0_br u_t024_014/c0_w1_bl u_t024_014/c0_w1_br
+ u_t024_014/c0_r0_rbl u_t024_014/c0_r1_rbl u_t024_014/c1_w0_bl u_t024_014/c1_w0_br
+ u_t024_014/c1_w1_bl u_t024_014/c1_w1_br u_t024_014/c1_r0_rbl u_t024_014/c1_r1_rbl
+ u_t024_014/c2_w0_bl u_t024_014/c2_w0_br u_t024_014/c2_w1_bl u_t024_014/c2_w1_br
+ u_t024_014/c2_r0_rbl u_t024_014/c2_r1_rbl u_t024_014/c3_w0_bl u_t024_014/c3_w0_br
+ u_t024_014/c3_w1_bl u_t024_014/c3_w1_br u_t024_014/c3_r0_rbl u_t024_014/c3_r1_rbl
+ u_t024_014/r0_w0_wl u_t024_014/r0_w1_wl u_t024_014/r0_r0_rwl u_t024_014/r0_r1_rwl
+ u_t024_014/r1_w0_wl u_t024_014/r1_w1_wl u_t024_014/r1_r0_rwl u_t024_014/r1_r1_rwl
+ u_t024_014/r2_w0_wl u_t024_014/r2_w1_wl u_t024_014/r2_r0_rwl u_t024_014/r2_r1_rwl
+ u_t024_014/r3_w0_wl u_t024_014/r3_w1_wl u_t024_014/r3_r0_rwl u_t024_014/r3_r1_rwl
+ u_t025_014/VDD u_t024_017/VSS VSUBS detronyx_12t_2w2r_rc4_4x4_routed_5layer_direct
Xu_t009_011 u_t009_011/c0_w0_bl u_t009_011/c0_w0_br u_t009_011/c0_w1_bl u_t009_011/c0_w1_br
+ u_t009_011/c0_r0_rbl u_t009_011/c0_r1_rbl u_t009_011/c1_w0_bl u_t009_011/c1_w0_br
+ u_t009_011/c1_w1_bl u_t009_011/c1_w1_br u_t009_011/c1_r0_rbl u_t009_011/c1_r1_rbl
+ u_t009_011/c2_w0_bl u_t009_011/c2_w0_br u_t009_011/c2_w1_bl u_t009_011/c2_w1_br
+ u_t009_011/c2_r0_rbl u_t009_011/c2_r1_rbl u_t009_011/c3_w0_bl u_t009_011/c3_w0_br
+ u_t009_011/c3_w1_bl u_t009_011/c3_w1_br u_t009_011/c3_r0_rbl u_t009_011/c3_r1_rbl
+ u_t009_011/r0_w0_wl u_t009_011/r0_w1_wl u_t009_011/r0_r0_rwl u_t009_011/r0_r1_rwl
+ u_t009_011/r1_w0_wl u_t009_011/r1_w1_wl u_t009_011/r1_r0_rwl u_t009_011/r1_r1_rwl
+ u_t009_011/r2_w0_wl u_t009_011/r2_w1_wl u_t009_011/r2_r0_rwl u_t009_011/r2_r1_rwl
+ u_t009_011/r3_w0_wl u_t009_011/r3_w1_wl u_t009_011/r3_r0_rwl u_t009_011/r3_r1_rwl
+ u_t009_011/VDD u_t009_031/VSS VSUBS detronyx_12t_2w2r_rc4_4x4_routed_5layer_direct
Xu_t024_003 u_t024_003/c0_w0_bl u_t024_003/c0_w0_br u_t024_003/c0_w1_bl u_t024_003/c0_w1_br
+ u_t024_003/c0_r0_rbl u_t024_003/c0_r1_rbl u_t024_003/c1_w0_bl u_t024_003/c1_w0_br
+ u_t024_003/c1_w1_bl u_t024_003/c1_w1_br u_t024_003/c1_r0_rbl u_t024_003/c1_r1_rbl
+ u_t024_003/c2_w0_bl u_t024_003/c2_w0_br u_t024_003/c2_w1_bl u_t024_003/c2_w1_br
+ u_t024_003/c2_r0_rbl u_t024_003/c2_r1_rbl u_t024_003/c3_w0_bl u_t024_003/c3_w0_br
+ u_t024_003/c3_w1_bl u_t024_003/c3_w1_br u_t024_003/c3_r0_rbl u_t024_003/c3_r1_rbl
+ u_t024_003/r0_w0_wl u_t024_003/r0_w1_wl u_t024_003/r0_r0_rwl u_t024_003/r0_r1_rwl
+ u_t024_003/r1_w0_wl u_t024_003/r1_w1_wl u_t024_003/r1_r0_rwl u_t024_003/r1_r1_rwl
+ u_t024_003/r2_w0_wl u_t024_003/r2_w1_wl u_t024_003/r2_r0_rwl u_t024_003/r2_r1_rwl
+ u_t024_003/r3_w0_wl u_t024_003/r3_w1_wl u_t024_003/r3_r0_rwl u_t024_003/r3_r1_rwl
+ u_t025_003/VDD u_t024_003/VSS VSUBS detronyx_12t_2w2r_rc4_4x4_routed_5layer_direct
Xu_t009_000 u_t009_000/c0_w0_bl u_t009_000/c0_w0_br u_t009_000/c0_w1_bl u_t009_000/c0_w1_br
+ u_t009_000/c0_r0_rbl u_t009_000/c0_r1_rbl u_t009_000/c1_w0_bl u_t009_000/c1_w0_br
+ u_t009_000/c1_w1_bl u_t009_000/c1_w1_br u_t009_000/c1_r0_rbl u_t009_000/c1_r1_rbl
+ u_t009_000/c2_w0_bl u_t009_000/c2_w0_br u_t009_000/c2_w1_bl u_t009_000/c2_w1_br
+ u_t009_000/c2_r0_rbl u_t009_000/c2_r1_rbl u_t009_000/c3_w0_bl u_t009_000/c3_w0_br
+ u_t009_000/c3_w1_bl u_t009_000/c3_w1_br u_t009_000/c3_r0_rbl u_t009_000/c3_r1_rbl
+ u_t009_000/r0_w0_wl u_t009_000/r0_w1_wl u_t009_000/r0_r0_rwl u_t009_000/r0_r1_rwl
+ u_t009_000/r1_w0_wl u_t009_000/r1_w1_wl u_t009_000/r1_r0_rwl u_t009_000/r1_r1_rwl
+ u_t009_000/r2_w0_wl u_t009_000/r2_w1_wl u_t009_000/r2_r0_rwl u_t009_000/r2_r1_rwl
+ u_t009_000/r3_w0_wl u_t009_000/r3_w1_wl u_t009_000/r3_r0_rwl u_t009_000/r3_r1_rwl
+ VSS u_t009_031/VSS VSUBS detronyx_12t_2w2r_rc4_4x4_routed_5layer_direct
Xgf180mcu_as_sc_mcu7t3v3__nand3_2_26 gf180mcu_as_sc_mcu7t3v3__nand3_2_31/VDD gf180mcu_as_sc_mcu7t3v3__nor2_2_8/VSS
+ VSS VSS VSS VSS gf180mcu_as_sc_mcu7t3v3__nand3_2_31/VNW VSUBS gf180mcu_as_sc_mcu7t3v3__nand3_2
Xgf180mcu_as_sc_mcu7t3v3__nand3_2_15 gf180mcu_as_sc_mcu7t3v3__nor2_2_5/VDD gf180mcu_as_sc_mcu7t3v3__nand3_2_8/VSS
+ VSS VSS VSS VSS gf180mcu_as_sc_mcu7t3v3__nor2_2_5/VNW VSUBS gf180mcu_as_sc_mcu7t3v3__nand3_2
Xgf180mcu_as_sc_mcu7t3v3__inv_2_1635 VSS gf180mcu_as_sc_mcu7t3v3__inv_2_1678/VDD gf180mcu_as_sc_mcu7t3v3__inv_2_1635/Y
+ gf180mcu_as_sc_mcu7t3v3__inv_2_1678/Y gf180mcu_as_sc_mcu7t3v3__inv_2_1677/VNW VSUBS
+ gf180mcu_as_sc_mcu7t3v3__inv_2
Xgf180mcu_as_sc_mcu7t3v3__inv_2_1613 VSS gf180mcu_as_sc_mcu7t3v3__inv_2_1667/VDD gf180mcu_as_sc_mcu7t3v3__inv_2_1613/Y
+ gf180mcu_as_sc_mcu7t3v3__inv_2_1682/Y gf180mcu_as_sc_mcu7t3v3__inv_2_1666/VNW VSUBS
+ gf180mcu_as_sc_mcu7t3v3__inv_2
Xgf180mcu_as_sc_mcu7t3v3__inv_2_1602 gf180mcu_as_sc_mcu7t3v3__inv_2_1653/VDD gf180mcu_as_sc_mcu7t3v3__inv_2_1654/VDD
+ VSS gf180mcu_as_sc_mcu7t3v3__inv_2_1682/Y gf180mcu_as_sc_mcu7t3v3__inv_2_1653/VNW
+ VSUBS gf180mcu_as_sc_mcu7t3v3__inv_2
Xgf180mcu_as_sc_mcu7t3v3__inv_2_1624 gf180mcu_as_sc_mcu7t3v3__inv_2_1663/VDD gf180mcu_as_sc_mcu7t3v3__inv_2_1685/VDD
+ VSS gf180mcu_as_sc_mcu7t3v3__inv_2_1685/Y gf180mcu_as_sc_mcu7t3v3__inv_2_1663/VNW
+ VSUBS gf180mcu_as_sc_mcu7t3v3__inv_2
Xgf180mcu_as_sc_mcu7t3v3__inv_2_180 VSS gf180mcu_as_sc_mcu7t3v3__inv_2_184/VDD gf180mcu_as_sc_mcu7t3v3__inv_2_180/Y
+ VSS gf180mcu_as_sc_mcu7t3v3__inv_2_180/VNW VSUBS gf180mcu_as_sc_mcu7t3v3__inv_2
Xgf180mcu_as_sc_mcu7t3v3__inv_2_191 gf180mcu_as_sc_mcu7t3v3__inv_2_192/VDD VSS VSS
+ VSS gf180mcu_as_sc_mcu7t3v3__inv_2_192/VNW VSUBS gf180mcu_as_sc_mcu7t3v3__inv_2
Xgf180mcu_as_sc_mcu7t3v3__inv_2_1646 gf180mcu_as_sc_mcu7t3v3__inv_2_1668/VDD gf180mcu_as_sc_mcu7t3v3__inv_2_1669/VDD
+ gf180mcu_as_sc_mcu7t3v3__inv_2_1646/Y gf180mcu_as_sc_mcu7t3v3__inv_2_1675/Y gf180mcu_as_sc_mcu7t3v3__inv_2_1668/VNW
+ VSUBS gf180mcu_as_sc_mcu7t3v3__inv_2
Xgf180mcu_as_sc_mcu7t3v3__inv_2_1668 gf180mcu_as_sc_mcu7t3v3__inv_2_1668/VDD gf180mcu_as_sc_mcu7t3v3__inv_2_1669/VDD
+ gf180mcu_as_sc_mcu7t3v3__inv_2_1675/Y VSS gf180mcu_as_sc_mcu7t3v3__inv_2_1668/VNW
+ VSUBS gf180mcu_as_sc_mcu7t3v3__inv_2
Xgf180mcu_as_sc_mcu7t3v3__inv_2_1679 VSS VSS gf180mcu_as_sc_mcu7t3v3__inv_2_1682/Y
+ VSS gf180mcu_as_sc_mcu7t3v3__inv_2_1679/VNW VSUBS gf180mcu_as_sc_mcu7t3v3__inv_2
Xgf180mcu_as_sc_mcu7t3v3__inv_2_1657 gf180mcu_as_sc_mcu7t3v3__inv_2_1657/VDD VSS gf180mcu_as_sc_mcu7t3v3__inv_2_1657/Y
+ VSS gf180mcu_as_sc_mcu7t3v3__inv_2_1657/VNW VSUBS gf180mcu_as_sc_mcu7t3v3__inv_2
Xu_t030_028 u_t030_028/c0_w0_bl u_t030_028/c0_w0_br u_t030_028/c0_w1_bl u_t030_028/c0_w1_br
+ u_t030_028/c0_r0_rbl u_t030_028/c0_r1_rbl u_t030_028/c1_w0_bl u_t030_028/c1_w0_br
+ u_t030_028/c1_w1_bl u_t030_028/c1_w1_br u_t030_028/c1_r0_rbl u_t030_028/c1_r1_rbl
+ u_t030_028/c2_w0_bl u_t030_028/c2_w0_br u_t030_028/c2_w1_bl u_t030_028/c2_w1_br
+ u_t030_028/c2_r0_rbl u_t030_028/c2_r1_rbl u_t030_028/c3_w0_bl u_t030_028/c3_w0_br
+ u_t030_028/c3_w1_bl u_t030_028/c3_w1_br u_t030_028/c3_r0_rbl u_t030_028/c3_r1_rbl
+ u_t030_028/r0_w0_wl u_t030_028/r0_w1_wl u_t030_028/r0_r0_rwl u_t030_028/r0_r1_rwl
+ u_t030_028/r1_w0_wl u_t030_028/r1_w1_wl u_t030_028/r1_r0_rwl u_t030_028/r1_r1_rwl
+ u_t030_028/r2_w0_wl u_t030_028/r2_w1_wl u_t030_028/r2_r0_rwl u_t030_028/r2_r1_rwl
+ u_t030_028/r3_w0_wl u_t030_028/r3_w1_wl u_t030_028/r3_r0_rwl u_t030_028/r3_r1_rwl
+ u_t030_028/VDD u_t030_031/VSS VSUBS detronyx_12t_2w2r_rc4_4x4_routed_5layer_direct
Xu_t015_025 u_t015_025/c0_w0_bl u_t015_025/c0_w0_br u_t015_025/c0_w1_bl u_t015_025/c0_w1_br
+ u_t015_025/c0_r0_rbl u_t015_025/c0_r1_rbl u_t015_025/c1_w0_bl u_t015_025/c1_w0_br
+ u_t015_025/c1_w1_bl u_t015_025/c1_w1_br u_t015_025/c1_r0_rbl u_t015_025/c1_r1_rbl
+ u_t015_025/c2_w0_bl u_t015_025/c2_w0_br u_t015_025/c2_w1_bl u_t015_025/c2_w1_br
+ u_t015_025/c2_r0_rbl u_t015_025/c2_r1_rbl u_t015_025/c3_w0_bl u_t015_025/c3_w0_br
+ u_t015_025/c3_w1_bl u_t015_025/c3_w1_br u_t015_025/c3_r0_rbl u_t015_025/c3_r1_rbl
+ u_t015_025/r0_w0_wl u_t015_025/r0_w1_wl u_t015_025/r0_r0_rwl u_t015_025/r0_r1_rwl
+ u_t015_025/r1_w0_wl u_t015_025/r1_w1_wl u_t015_025/r1_r0_rwl u_t015_025/r1_r1_rwl
+ u_t015_025/r2_w0_wl u_t015_025/r2_w1_wl u_t015_025/r2_r0_rwl u_t015_025/r2_r1_rwl
+ u_t015_025/r3_w0_wl u_t015_025/r3_w1_wl u_t015_025/r3_r0_rwl u_t015_025/r3_r1_rwl
+ VSS u_t015_025/VSS VSUBS detronyx_12t_2w2r_rc4_4x4_routed_5layer_direct
Xu_t030_017 u_t030_017/c0_w0_bl u_t030_017/c0_w0_br u_t030_017/c0_w1_bl u_t030_017/c0_w1_br
+ u_t030_017/c0_r0_rbl u_t030_017/c0_r1_rbl u_t030_017/c1_w0_bl u_t030_017/c1_w0_br
+ u_t030_017/c1_w1_bl u_t030_017/c1_w1_br u_t030_017/c1_r0_rbl u_t030_017/c1_r1_rbl
+ u_t030_017/c2_w0_bl u_t030_017/c2_w0_br u_t030_017/c2_w1_bl u_t030_017/c2_w1_br
+ u_t030_017/c2_r0_rbl u_t030_017/c2_r1_rbl u_t030_017/c3_w0_bl u_t030_017/c3_w0_br
+ u_t030_017/c3_w1_bl u_t030_017/c3_w1_br u_t030_017/c3_r0_rbl u_t030_017/c3_r1_rbl
+ u_t030_017/r0_w0_wl u_t030_017/r0_w1_wl u_t030_017/r0_r0_rwl u_t030_017/r0_r1_rwl
+ u_t030_017/r1_w0_wl u_t030_017/r1_w1_wl u_t030_017/r1_r0_rwl u_t030_017/r1_r1_rwl
+ u_t030_017/r2_w0_wl u_t030_017/r2_w1_wl u_t030_017/r2_r0_rwl u_t030_017/r2_r1_rwl
+ u_t030_017/r3_w0_wl u_t030_017/r3_w1_wl u_t030_017/r3_r0_rwl u_t030_017/r3_r1_rwl
+ VSS u_t030_031/VSS VSUBS detronyx_12t_2w2r_rc4_4x4_routed_5layer_direct
Xu_t015_014 u_t015_014/c0_w0_bl u_t015_014/c0_w0_br u_t015_014/c0_w1_bl u_t015_014/c0_w1_br
+ u_t015_014/c0_r0_rbl u_t015_014/c0_r1_rbl u_t015_014/c1_w0_bl u_t015_014/c1_w0_br
+ u_t015_014/c1_w1_bl u_t015_014/c1_w1_br u_t015_014/c1_r0_rbl u_t015_014/c1_r1_rbl
+ u_t015_014/c2_w0_bl u_t015_014/c2_w0_br u_t015_014/c2_w1_bl u_t015_014/c2_w1_br
+ u_t015_014/c2_r0_rbl u_t015_014/c2_r1_rbl u_t015_014/c3_w0_bl u_t015_014/c3_w0_br
+ u_t015_014/c3_w1_bl u_t015_014/c3_w1_br u_t015_014/c3_r0_rbl u_t015_014/c3_r1_rbl
+ u_t015_014/r0_w0_wl u_t015_014/r0_w1_wl u_t015_014/r0_r0_rwl u_t015_014/r0_r1_rwl
+ u_t015_014/r1_w0_wl u_t015_014/r1_w1_wl u_t015_014/r1_r0_rwl u_t015_014/r1_r1_rwl
+ u_t015_014/r2_w0_wl u_t015_014/r2_w1_wl u_t015_014/r2_r0_rwl u_t015_014/r2_r1_rwl
+ u_t015_014/r3_w0_wl u_t015_014/r3_w1_wl u_t015_014/r3_r0_rwl u_t015_014/r3_r1_rwl
+ u_t015_014/VDD u_t015_017/VSS VSUBS detronyx_12t_2w2r_rc4_4x4_routed_5layer_direct
Xu_t030_006 u_t030_006/c0_w0_bl u_t030_006/c0_w0_br u_t030_006/c0_w1_bl u_t030_006/c0_w1_br
+ u_t030_006/c0_r0_rbl u_t030_006/c0_r1_rbl u_t030_006/c1_w0_bl u_t030_006/c1_w0_br
+ u_t030_006/c1_w1_bl u_t030_006/c1_w1_br u_t030_006/c1_r0_rbl u_t030_006/c1_r1_rbl
+ u_t030_006/c2_w0_bl u_t030_006/c2_w0_br u_t030_006/c2_w1_bl u_t030_006/c2_w1_br
+ u_t030_006/c2_r0_rbl u_t030_006/c2_r1_rbl u_t030_006/c3_w0_bl u_t030_006/c3_w0_br
+ u_t030_006/c3_w1_bl u_t030_006/c3_w1_br u_t030_006/c3_r0_rbl u_t030_006/c3_r1_rbl
+ u_t030_006/r0_w0_wl u_t030_006/r0_w1_wl u_t030_006/r0_r0_rwl u_t030_006/r0_r1_rwl
+ u_t030_006/r1_w0_wl u_t030_006/r1_w1_wl u_t030_006/r1_r0_rwl u_t030_006/r1_r1_rwl
+ u_t030_006/r2_w0_wl u_t030_006/r2_w1_wl u_t030_006/r2_r0_rwl u_t030_006/r2_r1_rwl
+ u_t030_006/r3_w0_wl u_t030_006/r3_w1_wl u_t030_006/r3_r0_rwl u_t030_006/r3_r1_rwl
+ u_t030_006/VDD u_t030_031/VSS VSUBS detronyx_12t_2w2r_rc4_4x4_routed_5layer_direct
Xu_t015_003 u_t015_003/c0_w0_bl u_t015_003/c0_w0_br u_t015_003/c0_w1_bl u_t015_003/c0_w1_br
+ u_t015_003/c0_r0_rbl u_t015_003/c0_r1_rbl u_t015_003/c1_w0_bl u_t015_003/c1_w0_br
+ u_t015_003/c1_w1_bl u_t015_003/c1_w1_br u_t015_003/c1_r0_rbl u_t015_003/c1_r1_rbl
+ u_t015_003/c2_w0_bl u_t015_003/c2_w0_br u_t015_003/c2_w1_bl u_t015_003/c2_w1_br
+ u_t015_003/c2_r0_rbl u_t015_003/c2_r1_rbl u_t015_003/c3_w0_bl u_t015_003/c3_w0_br
+ u_t015_003/c3_w1_bl u_t015_003/c3_w1_br u_t015_003/c3_r0_rbl u_t015_003/c3_r1_rbl
+ u_t015_003/r0_w0_wl u_t015_003/r0_w1_wl u_t015_003/r0_r0_rwl u_t015_003/r0_r1_rwl
+ u_t015_003/r1_w0_wl u_t015_003/r1_w1_wl u_t015_003/r1_r0_rwl u_t015_003/r1_r1_rwl
+ u_t015_003/r2_w0_wl u_t015_003/r2_w1_wl u_t015_003/r2_r0_rwl u_t015_003/r2_r1_rwl
+ u_t015_003/r3_w0_wl u_t015_003/r3_w1_wl u_t015_003/r3_r0_rwl u_t015_003/r3_r1_rwl
+ u_t015_003/VDD u_t015_003/VSS VSUBS detronyx_12t_2w2r_rc4_4x4_routed_5layer_direct
Xgf180mcu_as_sc_mcu7t3v3__nand4_2_418 gf180mcu_as_sc_mcu7t3v3__inv_2_1416/VDD gf180mcu_as_sc_mcu7t3v3__inv_2_1420/VDD
+ VSS VSS VSS VSS gf180mcu_as_sc_mcu7t3v3__nand4_2_418/Y gf180mcu_as_sc_mcu7t3v3__inv_2_1416/VNW
+ VSUBS gf180mcu_as_sc_mcu7t3v3__nand4_2
Xgf180mcu_as_sc_mcu7t3v3__nand4_2_429 VSS VSS VSS VSS VSS VSS VSS gf180mcu_as_sc_mcu7t3v3__inv_2_1445/VNW
+ VSUBS gf180mcu_as_sc_mcu7t3v3__nand4_2
Xgf180mcu_as_sc_mcu7t3v3__nand4_2_407 gf180mcu_as_sc_mcu7t3v3__inv_2_1394/VDD VSS
+ VSS VSS VSS VSS VSS gf180mcu_as_sc_mcu7t3v3__inv_2_1394/VNW VSUBS gf180mcu_as_sc_mcu7t3v3__nand4_2
Xu_t006_025 u_t006_025/c0_w0_bl u_t006_025/c0_w0_br u_t006_025/c0_w1_bl u_t006_025/c0_w1_br
+ u_t006_025/c0_r0_rbl u_t006_025/c0_r1_rbl u_t006_025/c1_w0_bl u_t006_025/c1_w0_br
+ u_t006_025/c1_w1_bl u_t006_025/c1_w1_br u_t006_025/c1_r0_rbl u_t006_025/c1_r1_rbl
+ u_t006_025/c2_w0_bl u_t006_025/c2_w0_br u_t006_025/c2_w1_bl u_t006_025/c2_w1_br
+ u_t006_025/c2_r0_rbl u_t006_025/c2_r1_rbl u_t006_025/c3_w0_bl u_t006_025/c3_w0_br
+ u_t006_025/c3_w1_bl u_t006_025/c3_w1_br u_t006_025/c3_r0_rbl u_t006_025/c3_r1_rbl
+ u_t006_025/r0_w0_wl u_t006_025/r0_w1_wl u_t006_025/r0_r0_rwl u_t006_025/r0_r1_rwl
+ u_t006_025/r1_w0_wl u_t006_025/r1_w1_wl u_t006_025/r1_r0_rwl u_t006_025/r1_r1_rwl
+ u_t006_025/r2_w0_wl u_t006_025/r2_w1_wl u_t006_025/r2_r0_rwl u_t006_025/r2_r1_rwl
+ u_t006_025/r3_w0_wl u_t006_025/r3_w1_wl u_t006_025/r3_r0_rwl u_t006_025/r3_r1_rwl
+ VSS u_t006_025/VSS VSUBS detronyx_12t_2w2r_rc4_4x4_routed_5layer_direct
Xu_t006_014 u_t006_014/c0_w0_bl u_t006_014/c0_w0_br u_t006_014/c0_w1_bl u_t006_014/c0_w1_br
+ u_t006_014/c0_r0_rbl u_t006_014/c0_r1_rbl u_t006_014/c1_w0_bl u_t006_014/c1_w0_br
+ u_t006_014/c1_w1_bl u_t006_014/c1_w1_br u_t006_014/c1_r0_rbl u_t006_014/c1_r1_rbl
+ u_t006_014/c2_w0_bl u_t006_014/c2_w0_br u_t006_014/c2_w1_bl u_t006_014/c2_w1_br
+ u_t006_014/c2_r0_rbl u_t006_014/c2_r1_rbl u_t006_014/c3_w0_bl u_t006_014/c3_w0_br
+ u_t006_014/c3_w1_bl u_t006_014/c3_w1_br u_t006_014/c3_r0_rbl u_t006_014/c3_r1_rbl
+ u_t006_014/r0_w0_wl u_t006_014/r0_w1_wl u_t006_014/r0_r0_rwl u_t006_014/r0_r1_rwl
+ u_t006_014/r1_w0_wl u_t006_014/r1_w1_wl u_t006_014/r1_r0_rwl u_t006_014/r1_r1_rwl
+ u_t006_014/r2_w0_wl u_t006_014/r2_w1_wl u_t006_014/r2_r0_rwl u_t006_014/r2_r1_rwl
+ u_t006_014/r3_w0_wl u_t006_014/r3_w1_wl u_t006_014/r3_r0_rwl u_t006_014/r3_r1_rwl
+ u_t006_014/VDD u_t006_017/VSS VSUBS detronyx_12t_2w2r_rc4_4x4_routed_5layer_direct
Xu_t006_003 u_t006_003/c0_w0_bl u_t006_003/c0_w0_br u_t006_003/c0_w1_bl u_t006_003/c0_w1_br
+ u_t006_003/c0_r0_rbl u_t006_003/c0_r1_rbl u_t006_003/c1_w0_bl u_t006_003/c1_w0_br
+ u_t006_003/c1_w1_bl u_t006_003/c1_w1_br u_t006_003/c1_r0_rbl u_t006_003/c1_r1_rbl
+ u_t006_003/c2_w0_bl u_t006_003/c2_w0_br u_t006_003/c2_w1_bl u_t006_003/c2_w1_br
+ u_t006_003/c2_r0_rbl u_t006_003/c2_r1_rbl u_t006_003/c3_w0_bl u_t006_003/c3_w0_br
+ u_t006_003/c3_w1_bl u_t006_003/c3_w1_br u_t006_003/c3_r0_rbl u_t006_003/c3_r1_rbl
+ u_t006_003/r0_w0_wl u_t006_003/r0_w1_wl u_t006_003/r0_r0_rwl u_t006_003/r0_r1_rwl
+ u_t006_003/r1_w0_wl u_t006_003/r1_w1_wl u_t006_003/r1_r0_rwl u_t006_003/r1_r1_rwl
+ u_t006_003/r2_w0_wl u_t006_003/r2_w1_wl u_t006_003/r2_r0_rwl u_t006_003/r2_r1_rwl
+ u_t006_003/r3_w0_wl u_t006_003/r3_w1_wl u_t006_003/r3_r0_rwl u_t006_003/r3_r1_rwl
+ u_t006_003/VDD u_t006_003/VSS VSUBS detronyx_12t_2w2r_rc4_4x4_routed_5layer_direct
Xgf180mcu_as_sc_mcu7t3v3__inv_2_8 gf180mcu_as_sc_mcu7t3v3__inv_2_8/VDD gf180mcu_as_sc_mcu7t3v3__inv_2_8/VSS
+ gf180mcu_as_sc_mcu7t3v3__inv_2_8/Y gf180mcu_as_sc_mcu7t3v3__inv_2_8/A gf180mcu_as_sc_mcu7t3v3__inv_2_8/VNW
+ VSUBS gf180mcu_as_sc_mcu7t3v3__inv_2
Xu_t021_028 u_t021_028/c0_w0_bl u_t021_028/c0_w0_br u_t021_028/c0_w1_bl u_t021_028/c0_w1_br
+ u_t021_028/c0_r0_rbl u_t021_028/c0_r1_rbl u_t021_028/c1_w0_bl u_t021_028/c1_w0_br
+ u_t021_028/c1_w1_bl u_t021_028/c1_w1_br u_t021_028/c1_r0_rbl u_t021_028/c1_r1_rbl
+ u_t021_028/c2_w0_bl u_t021_028/c2_w0_br u_t021_028/c2_w1_bl u_t021_028/c2_w1_br
+ u_t021_028/c2_r0_rbl u_t021_028/c2_r1_rbl u_t021_028/c3_w0_bl u_t021_028/c3_w0_br
+ u_t021_028/c3_w1_bl u_t021_028/c3_w1_br u_t021_028/c3_r0_rbl u_t021_028/c3_r1_rbl
+ u_t021_028/r0_w0_wl u_t021_028/r0_w1_wl u_t021_028/r0_r0_rwl u_t021_028/r0_r1_rwl
+ u_t021_028/r1_w0_wl u_t021_028/r1_w1_wl u_t021_028/r1_r0_rwl u_t021_028/r1_r1_rwl
+ u_t021_028/r2_w0_wl u_t021_028/r2_w1_wl u_t021_028/r2_r0_rwl u_t021_028/r2_r1_rwl
+ u_t021_028/r3_w0_wl u_t021_028/r3_w1_wl u_t021_028/r3_r0_rwl u_t021_028/r3_r1_rwl
+ u_t021_028/VDD u_t021_031/VSS VSUBS detronyx_12t_2w2r_rc4_4x4_routed_5layer_direct
Xu_t021_017 u_t021_017/c0_w0_bl u_t021_017/c0_w0_br u_t021_017/c0_w1_bl u_t021_017/c0_w1_br
+ u_t021_017/c0_r0_rbl u_t021_017/c0_r1_rbl u_t021_017/c1_w0_bl u_t021_017/c1_w0_br
+ u_t021_017/c1_w1_bl u_t021_017/c1_w1_br u_t021_017/c1_r0_rbl u_t021_017/c1_r1_rbl
+ u_t021_017/c2_w0_bl u_t021_017/c2_w0_br u_t021_017/c2_w1_bl u_t021_017/c2_w1_br
+ u_t021_017/c2_r0_rbl u_t021_017/c2_r1_rbl u_t021_017/c3_w0_bl u_t021_017/c3_w0_br
+ u_t021_017/c3_w1_bl u_t021_017/c3_w1_br u_t021_017/c3_r0_rbl u_t021_017/c3_r1_rbl
+ u_t021_017/r0_w0_wl u_t021_017/r0_w1_wl u_t021_017/r0_r0_rwl u_t021_017/r0_r1_rwl
+ u_t021_017/r1_w0_wl u_t021_017/r1_w1_wl u_t021_017/r1_r0_rwl u_t021_017/r1_r1_rwl
+ u_t021_017/r2_w0_wl u_t021_017/r2_w1_wl u_t021_017/r2_r0_rwl u_t021_017/r2_r1_rwl
+ u_t021_017/r3_w0_wl u_t021_017/r3_w1_wl u_t021_017/r3_r0_rwl u_t021_017/r3_r1_rwl
+ VSS u_t021_031/VSS VSUBS detronyx_12t_2w2r_rc4_4x4_routed_5layer_direct
Xu_t021_006 u_t021_006/c0_w0_bl u_t021_006/c0_w0_br u_t021_006/c0_w1_bl u_t021_006/c0_w1_br
+ u_t021_006/c0_r0_rbl u_t021_006/c0_r1_rbl u_t021_006/c1_w0_bl u_t021_006/c1_w0_br
+ u_t021_006/c1_w1_bl u_t021_006/c1_w1_br u_t021_006/c1_r0_rbl u_t021_006/c1_r1_rbl
+ u_t021_006/c2_w0_bl u_t021_006/c2_w0_br u_t021_006/c2_w1_bl u_t021_006/c2_w1_br
+ u_t021_006/c2_r0_rbl u_t021_006/c2_r1_rbl u_t021_006/c3_w0_bl u_t021_006/c3_w0_br
+ u_t021_006/c3_w1_bl u_t021_006/c3_w1_br u_t021_006/c3_r0_rbl u_t021_006/c3_r1_rbl
+ u_t021_006/r0_w0_wl u_t021_006/r0_w1_wl u_t021_006/r0_r0_rwl u_t021_006/r0_r1_rwl
+ u_t021_006/r1_w0_wl u_t021_006/r1_w1_wl u_t021_006/r1_r0_rwl u_t021_006/r1_r1_rwl
+ u_t021_006/r2_w0_wl u_t021_006/r2_w1_wl u_t021_006/r2_r0_rwl u_t021_006/r2_r1_rwl
+ u_t021_006/r3_w0_wl u_t021_006/r3_w1_wl u_t021_006/r3_r0_rwl u_t021_006/r3_r1_rwl
+ u_t021_006/VDD u_t021_031/VSS VSUBS detronyx_12t_2w2r_rc4_4x4_routed_5layer_direct
Xu_t012_028 u_t012_028/c0_w0_bl u_t012_028/c0_w0_br u_t012_028/c0_w1_bl u_t012_028/c0_w1_br
+ u_t012_028/c0_r0_rbl u_t012_028/c0_r1_rbl u_t012_028/c1_w0_bl u_t012_028/c1_w0_br
+ u_t012_028/c1_w1_bl u_t012_028/c1_w1_br u_t012_028/c1_r0_rbl u_t012_028/c1_r1_rbl
+ u_t012_028/c2_w0_bl u_t012_028/c2_w0_br u_t012_028/c2_w1_bl u_t012_028/c2_w1_br
+ u_t012_028/c2_r0_rbl u_t012_028/c2_r1_rbl u_t012_028/c3_w0_bl u_t012_028/c3_w0_br
+ u_t012_028/c3_w1_bl u_t012_028/c3_w1_br u_t012_028/c3_r0_rbl u_t012_028/c3_r1_rbl
+ u_t012_028/r0_w0_wl u_t012_028/r0_w1_wl u_t012_028/r0_r0_rwl u_t012_028/r0_r1_rwl
+ u_t012_028/r1_w0_wl u_t012_028/r1_w1_wl u_t012_028/r1_r0_rwl u_t012_028/r1_r1_rwl
+ u_t012_028/r2_w0_wl u_t012_028/r2_w1_wl u_t012_028/r2_r0_rwl u_t012_028/r2_r1_rwl
+ u_t012_028/r3_w0_wl u_t012_028/r3_w1_wl u_t012_028/r3_r0_rwl u_t012_028/r3_r1_rwl
+ u_t012_028/VDD u_t012_031/VSS VSUBS detronyx_12t_2w2r_rc4_4x4_routed_5layer_direct
Xu_t012_017 u_t012_017/c0_w0_bl u_t012_017/c0_w0_br u_t012_017/c0_w1_bl u_t012_017/c0_w1_br
+ u_t012_017/c0_r0_rbl u_t012_017/c0_r1_rbl u_t012_017/c1_w0_bl u_t012_017/c1_w0_br
+ u_t012_017/c1_w1_bl u_t012_017/c1_w1_br u_t012_017/c1_r0_rbl u_t012_017/c1_r1_rbl
+ u_t012_017/c2_w0_bl u_t012_017/c2_w0_br u_t012_017/c2_w1_bl u_t012_017/c2_w1_br
+ u_t012_017/c2_r0_rbl u_t012_017/c2_r1_rbl u_t012_017/c3_w0_bl u_t012_017/c3_w0_br
+ u_t012_017/c3_w1_bl u_t012_017/c3_w1_br u_t012_017/c3_r0_rbl u_t012_017/c3_r1_rbl
+ u_t012_017/r0_w0_wl u_t012_017/r0_w1_wl u_t012_017/r0_r0_rwl u_t012_017/r0_r1_rwl
+ u_t012_017/r1_w0_wl u_t012_017/r1_w1_wl u_t012_017/r1_r0_rwl u_t012_017/r1_r1_rwl
+ u_t012_017/r2_w0_wl u_t012_017/r2_w1_wl u_t012_017/r2_r0_rwl u_t012_017/r2_r1_rwl
+ u_t012_017/r3_w0_wl u_t012_017/r3_w1_wl u_t012_017/r3_r0_rwl u_t012_017/r3_r1_rwl
+ VSS u_t012_031/VSS VSUBS detronyx_12t_2w2r_rc4_4x4_routed_5layer_direct
Xu_t012_006 u_t012_006/c0_w0_bl u_t012_006/c0_w0_br u_t012_006/c0_w1_bl u_t012_006/c0_w1_br
+ u_t012_006/c0_r0_rbl u_t012_006/c0_r1_rbl u_t012_006/c1_w0_bl u_t012_006/c1_w0_br
+ u_t012_006/c1_w1_bl u_t012_006/c1_w1_br u_t012_006/c1_r0_rbl u_t012_006/c1_r1_rbl
+ u_t012_006/c2_w0_bl u_t012_006/c2_w0_br u_t012_006/c2_w1_bl u_t012_006/c2_w1_br
+ u_t012_006/c2_r0_rbl u_t012_006/c2_r1_rbl u_t012_006/c3_w0_bl u_t012_006/c3_w0_br
+ u_t012_006/c3_w1_bl u_t012_006/c3_w1_br u_t012_006/c3_r0_rbl u_t012_006/c3_r1_rbl
+ u_t012_006/r0_w0_wl u_t012_006/r0_w1_wl u_t012_006/r0_r0_rwl u_t012_006/r0_r1_rwl
+ u_t012_006/r1_w0_wl u_t012_006/r1_w1_wl u_t012_006/r1_r0_rwl u_t012_006/r1_r1_rwl
+ u_t012_006/r2_w0_wl u_t012_006/r2_w1_wl u_t012_006/r2_r0_rwl u_t012_006/r2_r1_rwl
+ u_t012_006/r3_w0_wl u_t012_006/r3_w1_wl u_t012_006/r3_r0_rwl u_t012_006/r3_r1_rwl
+ u_t012_006/VDD u_t012_031/VSS VSUBS detronyx_12t_2w2r_rc4_4x4_routed_5layer_direct
Xgf180mcu_as_sc_mcu7t3v3__inv_2_1454 gf180mcu_as_sc_mcu7t3v3__inv_2_1497/VSS VSS VSS
+ VSS gf180mcu_as_sc_mcu7t3v3__inv_2_1462/VNW VSUBS gf180mcu_as_sc_mcu7t3v3__inv_2
Xgf180mcu_as_sc_mcu7t3v3__inv_2_1465 gf180mcu_as_sc_mcu7t3v3__inv_2_1485/VSS gf180mcu_as_sc_mcu7t3v3__inv_2_1468/VDD
+ gf180mcu_as_sc_mcu7t3v3__inv_2_1465/Y VSS gf180mcu_as_sc_mcu7t3v3__inv_2_1465/VNW
+ VSUBS gf180mcu_as_sc_mcu7t3v3__inv_2
Xgf180mcu_as_sc_mcu7t3v3__inv_2_1476 VSS gf180mcu_as_sc_mcu7t3v3__inv_2_1480/VDD gf180mcu_as_sc_mcu7t3v3__inv_2_1476/Y
+ VSS gf180mcu_as_sc_mcu7t3v3__inv_2_1476/VNW VSUBS gf180mcu_as_sc_mcu7t3v3__inv_2
Xgf180mcu_as_sc_mcu7t3v3__inv_2_1487 VSS gf180mcu_as_sc_mcu7t3v3__inv_2_1492/VDD gf180mcu_as_sc_mcu7t3v3__inv_2_1487/Y
+ VSS gf180mcu_as_sc_mcu7t3v3__inv_2_1488/VNW VSUBS gf180mcu_as_sc_mcu7t3v3__inv_2
Xgf180mcu_as_sc_mcu7t3v3__inv_2_1443 gf180mcu_as_sc_mcu7t3v3__inv_2_1444/VDD VSS gf180mcu_as_sc_mcu7t3v3__inv_2_1443/Y
+ VSS gf180mcu_as_sc_mcu7t3v3__inv_2_1444/VNW VSUBS gf180mcu_as_sc_mcu7t3v3__inv_2
Xgf180mcu_as_sc_mcu7t3v3__inv_2_1432 gf180mcu_as_sc_mcu7t3v3__inv_2_1432/VDD VSS VSS
+ VSS gf180mcu_as_sc_mcu7t3v3__inv_2_1432/VNW VSUBS gf180mcu_as_sc_mcu7t3v3__inv_2
Xgf180mcu_as_sc_mcu7t3v3__inv_2_1410 VSS gf180mcu_as_sc_mcu7t3v3__inv_2_1416/VDD VSS
+ VSS gf180mcu_as_sc_mcu7t3v3__inv_2_1412/VNW VSUBS gf180mcu_as_sc_mcu7t3v3__inv_2
Xgf180mcu_as_sc_mcu7t3v3__inv_2_1421 gf180mcu_as_sc_mcu7t3v3__inv_2_1502/VSS VSS VSS
+ VSS gf180mcu_as_sc_mcu7t3v3__inv_2_1429/VNW VSUBS gf180mcu_as_sc_mcu7t3v3__inv_2
Xgf180mcu_as_sc_mcu7t3v3__inv_2_1498 VSS gf180mcu_as_sc_mcu7t3v3__inv_2_1499/VSS VSS
+ VSS gf180mcu_as_sc_mcu7t3v3__inv_2_1499/VNW VSUBS gf180mcu_as_sc_mcu7t3v3__inv_2
Xgf180mcu_as_sc_mcu7t3v3__inv_2_927 VSS VSS VSS VSS gf180mcu_as_sc_mcu7t3v3__inv_2_928/VNW
+ VSUBS gf180mcu_as_sc_mcu7t3v3__inv_2
Xgf180mcu_as_sc_mcu7t3v3__inv_2_905 VSS VSS gf180mcu_as_sc_mcu7t3v3__inv_2_905/Y VSS
+ gf180mcu_as_sc_mcu7t3v3__inv_2_905/VNW VSUBS gf180mcu_as_sc_mcu7t3v3__inv_2
Xgf180mcu_as_sc_mcu7t3v3__inv_2_916 VSS VSS VSS VSS gf180mcu_as_sc_mcu7t3v3__inv_2_917/VNW
+ VSUBS gf180mcu_as_sc_mcu7t3v3__inv_2
Xu_t003_028 u_t003_028/c0_w0_bl u_t003_028/c0_w0_br u_t003_028/c0_w1_bl u_t003_028/c0_w1_br
+ u_t003_028/c0_r0_rbl u_t003_028/c0_r1_rbl u_t003_028/c1_w0_bl u_t003_028/c1_w0_br
+ u_t003_028/c1_w1_bl u_t003_028/c1_w1_br u_t003_028/c1_r0_rbl u_t003_028/c1_r1_rbl
+ u_t003_028/c2_w0_bl u_t003_028/c2_w0_br u_t003_028/c2_w1_bl u_t003_028/c2_w1_br
+ u_t003_028/c2_r0_rbl u_t003_028/c2_r1_rbl u_t003_028/c3_w0_bl u_t003_028/c3_w0_br
+ u_t003_028/c3_w1_bl u_t003_028/c3_w1_br u_t003_028/c3_r0_rbl u_t003_028/c3_r1_rbl
+ u_t003_028/r0_w0_wl u_t003_028/r0_w1_wl u_t003_028/r0_r0_rwl u_t003_028/r0_r1_rwl
+ u_t003_028/r1_w0_wl u_t003_028/r1_w1_wl u_t003_028/r1_r0_rwl u_t003_028/r1_r1_rwl
+ u_t003_028/r2_w0_wl u_t003_028/r2_w1_wl u_t003_028/r2_r0_rwl u_t003_028/r2_r1_rwl
+ u_t003_028/r3_w0_wl u_t003_028/r3_w1_wl u_t003_028/r3_r0_rwl u_t003_028/r3_r1_rwl
+ u_t004_028/VDD u_t003_028/VSS VSUBS detronyx_12t_2w2r_rc4_4x4_routed_5layer_direct
Xu_t003_017 u_t003_017/c0_w0_bl u_t003_017/c0_w0_br u_t003_017/c0_w1_bl u_t003_017/c0_w1_br
+ u_t003_017/c0_r0_rbl u_t003_017/c0_r1_rbl u_t003_017/c1_w0_bl u_t003_017/c1_w0_br
+ u_t003_017/c1_w1_bl u_t003_017/c1_w1_br u_t003_017/c1_r0_rbl u_t003_017/c1_r1_rbl
+ u_t003_017/c2_w0_bl u_t003_017/c2_w0_br u_t003_017/c2_w1_bl u_t003_017/c2_w1_br
+ u_t003_017/c2_r0_rbl u_t003_017/c2_r1_rbl u_t003_017/c3_w0_bl u_t003_017/c3_w0_br
+ u_t003_017/c3_w1_bl u_t003_017/c3_w1_br u_t003_017/c3_r0_rbl u_t003_017/c3_r1_rbl
+ u_t003_017/r0_w0_wl u_t003_017/r0_w1_wl u_t003_017/r0_r0_rwl u_t003_017/r0_r1_rwl
+ u_t003_017/r1_w0_wl u_t003_017/r1_w1_wl u_t003_017/r1_r0_rwl u_t003_017/r1_r1_rwl
+ u_t003_017/r2_w0_wl u_t003_017/r2_w1_wl u_t003_017/r2_r0_rwl u_t003_017/r2_r1_rwl
+ u_t003_017/r3_w0_wl u_t003_017/r3_w1_wl u_t003_017/r3_r0_rwl u_t003_017/r3_r1_rwl
+ VSS u_t003_017/VSS VSUBS detronyx_12t_2w2r_rc4_4x4_routed_5layer_direct
Xu_t003_006 u_t003_006/c0_w0_bl u_t003_006/c0_w0_br u_t003_006/c0_w1_bl u_t003_006/c0_w1_br
+ u_t003_006/c0_r0_rbl u_t003_006/c0_r1_rbl u_t003_006/c1_w0_bl u_t003_006/c1_w0_br
+ u_t003_006/c1_w1_bl u_t003_006/c1_w1_br u_t003_006/c1_r0_rbl u_t003_006/c1_r1_rbl
+ u_t003_006/c2_w0_bl u_t003_006/c2_w0_br u_t003_006/c2_w1_bl u_t003_006/c2_w1_br
+ u_t003_006/c2_r0_rbl u_t003_006/c2_r1_rbl u_t003_006/c3_w0_bl u_t003_006/c3_w0_br
+ u_t003_006/c3_w1_bl u_t003_006/c3_w1_br u_t003_006/c3_r0_rbl u_t003_006/c3_r1_rbl
+ u_t003_006/r0_w0_wl u_t003_006/r0_w1_wl u_t003_006/r0_r0_rwl u_t003_006/r0_r1_rwl
+ u_t003_006/r1_w0_wl u_t003_006/r1_w1_wl u_t003_006/r1_r0_rwl u_t003_006/r1_r1_rwl
+ u_t003_006/r2_w0_wl u_t003_006/r2_w1_wl u_t003_006/r2_r0_rwl u_t003_006/r2_r1_rwl
+ u_t003_006/r3_w0_wl u_t003_006/r3_w1_wl u_t003_006/r3_r0_rwl u_t003_006/r3_r1_rwl
+ u_t004_006/VDD u_t003_009/VSS VSUBS detronyx_12t_2w2r_rc4_4x4_routed_5layer_direct
Xgf180mcu_as_sc_mcu7t3v3__inv_2_949 VSS VSS gf180mcu_as_sc_mcu7t3v3__inv_2_949/Y VSS
+ gf180mcu_as_sc_mcu7t3v3__inv_2_949/VNW VSUBS gf180mcu_as_sc_mcu7t3v3__inv_2
Xgf180mcu_as_sc_mcu7t3v3__inv_2_938 VSS VSS VSS VSS gf180mcu_as_sc_mcu7t3v3__inv_2_940/VNW
+ VSUBS gf180mcu_as_sc_mcu7t3v3__inv_2
Xgf180mcu_as_sc_mcu7t3v3__nand4_2_248 gf180mcu_as_sc_mcu7t3v3__inv_2_849/VDD gf180mcu_as_sc_mcu7t3v3__inv_2_849/VSS
+ VSS VSS VSS VSS VSS gf180mcu_as_sc_mcu7t3v3__inv_2_849/VNW VSUBS gf180mcu_as_sc_mcu7t3v3__nand4_2
Xgf180mcu_as_sc_mcu7t3v3__nand4_2_215 VSS VSS VSS VSS VSS VSS VSS gf180mcu_as_sc_mcu7t3v3__inv_2_752/VNW
+ VSUBS gf180mcu_as_sc_mcu7t3v3__nand4_2
Xgf180mcu_as_sc_mcu7t3v3__nand4_2_226 VSS VSS VSS VSS VSS VSS VSS gf180mcu_as_sc_mcu7t3v3__inv_2_745/VNW
+ VSUBS gf180mcu_as_sc_mcu7t3v3__nand4_2
Xgf180mcu_as_sc_mcu7t3v3__nand4_2_204 gf180mcu_as_sc_mcu7t3v3__inv_2_647/VDD gf180mcu_as_sc_mcu7t3v3__inv_2_651/VDD
+ VSS VSS VSS VSS VSS gf180mcu_as_sc_mcu7t3v3__inv_2_647/VNW VSUBS gf180mcu_as_sc_mcu7t3v3__nand4_2
Xgf180mcu_as_sc_mcu7t3v3__nand4_2_237 VSS VSS VSS VSS VSS VSS gf180mcu_as_sc_mcu7t3v3__nand4_2_237/Y
+ gf180mcu_as_sc_mcu7t3v3__inv_2_840/VNW VSUBS gf180mcu_as_sc_mcu7t3v3__nand4_2
Xgf180mcu_as_sc_mcu7t3v3__nand4_2_259 VSS VSS VSS VSS VSS VSS VSS gf180mcu_as_sc_mcu7t3v3__inv_2_888/VNW
+ VSUBS gf180mcu_as_sc_mcu7t3v3__nand4_2
Xu_t000_009 u_t000_009/c0_w0_bl u_t000_009/c0_w0_br u_t000_009/c0_w1_bl u_t000_009/c0_w1_br
+ u_t000_009/c0_r0_rbl u_t000_009/c0_r1_rbl u_t000_009/c1_w0_bl u_t000_009/c1_w0_br
+ u_t000_009/c1_w1_bl u_t000_009/c1_w1_br u_t000_009/c1_r0_rbl u_t000_009/c1_r1_rbl
+ u_t000_009/c2_w0_bl u_t000_009/c2_w0_br u_t000_009/c2_w1_bl u_t000_009/c2_w1_br
+ u_t000_009/c2_r0_rbl u_t000_009/c2_r1_rbl u_t000_009/c3_w0_bl u_t000_009/c3_w0_br
+ u_t000_009/c3_w1_bl u_t000_009/c3_w1_br u_t000_009/c3_r0_rbl u_t000_009/c3_r1_rbl
+ u_t000_009/r0_w0_wl u_t000_009/r0_w1_wl u_t000_009/r0_r0_rwl u_t000_009/r0_r1_rwl
+ u_t000_009/r1_w0_wl u_t000_009/r1_w1_wl u_t000_009/r1_r0_rwl u_t000_009/r1_r1_rwl
+ u_t000_009/r2_w0_wl u_t000_009/r2_w1_wl u_t000_009/r2_r0_rwl u_t000_009/r2_r1_rwl
+ u_t000_009/r3_w0_wl u_t000_009/r3_w1_wl u_t000_009/r3_r0_rwl u_t000_009/r3_r1_rwl
+ VSS u_t000_031/VSS VSUBS detronyx_12t_2w2r_rc4_4x4_routed_5layer_direct
Xgf180mcu_as_sc_mcu7t3v3__inv_2_1262 gf180mcu_as_sc_mcu7t3v3__nor2_2_8/VDD gf180mcu_as_sc_mcu7t3v3__nand3_2_32/VSS
+ VSS VSS gf180mcu_as_sc_mcu7t3v3__nor2_2_8/VNW VSUBS gf180mcu_as_sc_mcu7t3v3__inv_2
Xgf180mcu_as_sc_mcu7t3v3__inv_2_1251 gf180mcu_as_sc_mcu7t3v3__nor2_2_8/VDD gf180mcu_as_sc_mcu7t3v3__nor2_2_8/VSS
+ VSS VSS gf180mcu_as_sc_mcu7t3v3__nor2_2_8/VNW VSUBS gf180mcu_as_sc_mcu7t3v3__inv_2
Xgf180mcu_as_sc_mcu7t3v3__inv_2_1284 VSS VSS VSS VSS gf180mcu_as_sc_mcu7t3v3__inv_2_1284/VNW
+ VSUBS gf180mcu_as_sc_mcu7t3v3__inv_2
Xgf180mcu_as_sc_mcu7t3v3__inv_2_1273 VSS VSS VSS VSS gf180mcu_as_sc_mcu7t3v3__inv_2_1285/VNW
+ VSUBS gf180mcu_as_sc_mcu7t3v3__inv_2
Xgf180mcu_as_sc_mcu7t3v3__inv_2_1240 VSS VSS VSS VSS gf180mcu_as_sc_mcu7t3v3__inv_2_1241/VNW
+ VSUBS gf180mcu_as_sc_mcu7t3v3__inv_2
Xgf180mcu_as_sc_mcu7t3v3__inv_2_1295 gf180mcu_as_sc_mcu7t3v3__inv_2_1295/VDD VSS gf180mcu_as_sc_mcu7t3v3__inv_2_1295/Y
+ VSS gf180mcu_as_sc_mcu7t3v3__inv_2_1295/VNW VSUBS gf180mcu_as_sc_mcu7t3v3__inv_2
Xgf180mcu_as_sc_mcu7t3v3__inv_2_768 VSS VSS VSS VSS gf180mcu_as_sc_mcu7t3v3__inv_2_768/VNW
+ VSUBS gf180mcu_as_sc_mcu7t3v3__inv_2
Xgf180mcu_as_sc_mcu7t3v3__inv_2_746 VSS VSS gf180mcu_as_sc_mcu7t3v3__inv_2_746/Y VSS
+ gf180mcu_as_sc_mcu7t3v3__inv_2_789/VNW VSUBS gf180mcu_as_sc_mcu7t3v3__inv_2
Xgf180mcu_as_sc_mcu7t3v3__inv_2_757 VSS VSS gf180mcu_as_sc_mcu7t3v3__inv_2_757/Y VSS
+ gf180mcu_as_sc_mcu7t3v3__inv_2_765/VNW VSUBS gf180mcu_as_sc_mcu7t3v3__inv_2
Xgf180mcu_as_sc_mcu7t3v3__inv_2_779 VSS VSS VSS VSS gf180mcu_as_sc_mcu7t3v3__inv_2_780/VNW
+ VSUBS gf180mcu_as_sc_mcu7t3v3__inv_2
Xgf180mcu_as_sc_mcu7t3v3__inv_2_735 VSS VSS gf180mcu_as_sc_mcu7t3v3__inv_2_735/Y VSS
+ gf180mcu_as_sc_mcu7t3v3__inv_2_735/VNW VSUBS gf180mcu_as_sc_mcu7t3v3__inv_2
Xgf180mcu_as_sc_mcu7t3v3__inv_2_713 VSS gf180mcu_as_sc_mcu7t3v3__inv_2_719/VDD gf180mcu_as_sc_mcu7t3v3__inv_2_713/Y
+ gf180mcu_as_sc_mcu7t3v3__inv_2_732/Y gf180mcu_as_sc_mcu7t3v3__inv_2_715/VNW VSUBS
+ gf180mcu_as_sc_mcu7t3v3__inv_2
Xgf180mcu_as_sc_mcu7t3v3__inv_2_702 gf180mcu_as_sc_mcu7t3v3__inv_2_724/VSS gf180mcu_as_sc_mcu7t3v3__inv_2_711/VDD
+ gf180mcu_as_sc_mcu7t3v3__inv_2_702/Y gf180mcu_as_sc_mcu7t3v3__inv_2_703/Y gf180mcu_as_sc_mcu7t3v3__inv_2_703/VNW
+ VSUBS gf180mcu_as_sc_mcu7t3v3__inv_2
Xgf180mcu_as_sc_mcu7t3v3__inv_2_724 VSS gf180mcu_as_sc_mcu7t3v3__inv_2_724/VSS gf180mcu_as_sc_mcu7t3v3__inv_2_724/Y
+ gf180mcu_as_sc_mcu7t3v3__inv_2_724/A gf180mcu_as_sc_mcu7t3v3__inv_2_724/VNW VSUBS
+ gf180mcu_as_sc_mcu7t3v3__inv_2
Xgf180mcu_as_sc_mcu7t3v3__inv_2_1070 gf180mcu_as_sc_mcu7t3v3__inv_2_1072/VDD VSS VSS
+ gf180mcu_as_sc_mcu7t3v3__inv_2_1144/A gf180mcu_as_sc_mcu7t3v3__inv_2_1072/VNW VSUBS
+ gf180mcu_as_sc_mcu7t3v3__inv_2
Xgf180mcu_as_sc_mcu7t3v3__inv_2_1092 VSS gf180mcu_as_sc_mcu7t3v3__inv_2_1096/VDD gf180mcu_as_sc_mcu7t3v3__inv_2_1092/Y
+ VSS gf180mcu_as_sc_mcu7t3v3__inv_2_1092/VNW VSUBS gf180mcu_as_sc_mcu7t3v3__inv_2
Xgf180mcu_as_sc_mcu7t3v3__inv_2_1081 VSS gf180mcu_as_sc_mcu7t3v3__inv_2_1089/VSS VSS
+ gf180mcu_as_sc_mcu7t3v3__inv_2_1294/Y gf180mcu_as_sc_mcu7t3v3__inv_2_1089/VNW VSUBS
+ gf180mcu_as_sc_mcu7t3v3__inv_2
Xgf180mcu_as_sc_mcu7t3v3__nand4_2_4 gf180mcu_as_sc_mcu7t3v3__inv_2_6/VSS gf180mcu_as_sc_mcu7t3v3__inv_2_8/VDD
+ VSS VSS VSS VSS VSS gf180mcu_as_sc_mcu7t3v3__inv_2_4/VNW VSUBS gf180mcu_as_sc_mcu7t3v3__nand4_2
Xgf180mcu_as_sc_mcu7t3v3__inv_2_543 VSS VSS VSS VSS gf180mcu_as_sc_mcu7t3v3__inv_2_547/VNW
+ VSUBS gf180mcu_as_sc_mcu7t3v3__inv_2
Xgf180mcu_as_sc_mcu7t3v3__inv_2_565 VSS gf180mcu_as_sc_mcu7t3v3__inv_2_572/VDD gf180mcu_as_sc_mcu7t3v3__inv_2_565/Y
+ VSS gf180mcu_as_sc_mcu7t3v3__inv_2_565/VNW VSUBS gf180mcu_as_sc_mcu7t3v3__inv_2
Xgf180mcu_as_sc_mcu7t3v3__inv_2_576 gf180mcu_as_sc_mcu7t3v3__inv_2_576/VDD gf180mcu_as_sc_mcu7t3v3__inv_2_584/VDD
+ gf180mcu_as_sc_mcu7t3v3__inv_2_576/Y VSS gf180mcu_as_sc_mcu7t3v3__inv_2_576/VNW
+ VSUBS gf180mcu_as_sc_mcu7t3v3__inv_2
Xgf180mcu_as_sc_mcu7t3v3__inv_2_554 gf180mcu_as_sc_mcu7t3v3__nor2_2_4/VDD gf180mcu_as_sc_mcu7t3v3__nand3_2_8/VSS
+ VSS VSS gf180mcu_as_sc_mcu7t3v3__nor2_2_4/VNW VSUBS gf180mcu_as_sc_mcu7t3v3__inv_2
Xgf180mcu_as_sc_mcu7t3v3__inv_2_510 VSS VSS gf180mcu_as_sc_mcu7t3v3__inv_2_510/Y VSS
+ gf180mcu_as_sc_mcu7t3v3__inv_2_510/VNW VSUBS gf180mcu_as_sc_mcu7t3v3__inv_2
Xgf180mcu_as_sc_mcu7t3v3__inv_2_587 gf180mcu_as_sc_mcu7t3v3__inv_2_633/VSS VSS gf180mcu_as_sc_mcu7t3v3__inv_2_587/Y
+ gf180mcu_as_sc_mcu7t3v3__inv_2_631/A gf180mcu_as_sc_mcu7t3v3__inv_2_589/VNW VSUBS
+ gf180mcu_as_sc_mcu7t3v3__inv_2
Xgf180mcu_as_sc_mcu7t3v3__inv_2_532 VSS VSS gf180mcu_as_sc_mcu7t3v3__inv_2_532/Y VSS
+ gf180mcu_as_sc_mcu7t3v3__inv_2_534/VNW VSUBS gf180mcu_as_sc_mcu7t3v3__inv_2
Xgf180mcu_as_sc_mcu7t3v3__inv_2_521 VSS VSS VSS VSS gf180mcu_as_sc_mcu7t3v3__inv_2_522/VNW
+ VSUBS gf180mcu_as_sc_mcu7t3v3__inv_2
Xgf180mcu_as_sc_mcu7t3v3__inv_2_598 gf180mcu_as_sc_mcu7t3v3__inv_2_849/VSS gf180mcu_as_sc_mcu7t3v3__inv_2_630/VDD
+ gf180mcu_as_sc_mcu7t3v3__inv_2_598/Y gf180mcu_as_sc_mcu7t3v3__inv_2_848/Y gf180mcu_as_sc_mcu7t3v3__inv_2_617/VNW
+ VSUBS gf180mcu_as_sc_mcu7t3v3__inv_2
Xgf180mcu_as_sc_mcu7t3v3__inv_2_395 VSS VSS VSS VSS gf180mcu_as_sc_mcu7t3v3__inv_2_395/VNW
+ VSUBS gf180mcu_as_sc_mcu7t3v3__inv_2
Xgf180mcu_as_sc_mcu7t3v3__inv_2_373 gf180mcu_as_sc_mcu7t3v3__nor2_2_4/VDD gf180mcu_as_sc_mcu7t3v3__nor2_2_4/VSS
+ gf180mcu_as_sc_mcu7t3v3__inv_2_373/Y VSS gf180mcu_as_sc_mcu7t3v3__nor2_2_4/VNW VSUBS
+ gf180mcu_as_sc_mcu7t3v3__inv_2
Xgf180mcu_as_sc_mcu7t3v3__inv_2_384 gf180mcu_as_sc_mcu7t3v3__nand3_2_5/VDD gf180mcu_as_sc_mcu7t3v3__nor2_2_6/VSS
+ VSS VSS gf180mcu_as_sc_mcu7t3v3__nand3_2_5/VNW VSUBS gf180mcu_as_sc_mcu7t3v3__inv_2
Xgf180mcu_as_sc_mcu7t3v3__inv_2_351 gf180mcu_as_sc_mcu7t3v3__inv_2_351/VDD VSS gf180mcu_as_sc_mcu7t3v3__inv_2_66/Y
+ VSS gf180mcu_as_sc_mcu7t3v3__inv_2_351/VNW VSUBS gf180mcu_as_sc_mcu7t3v3__inv_2
Xgf180mcu_as_sc_mcu7t3v3__inv_2_362 gf180mcu_as_sc_mcu7t3v3__inv_2_363/VDD gf180mcu_as_sc_mcu7t3v3__inv_2_363/VDD
+ gf180mcu_as_sc_mcu7t3v3__inv_2_364/Y VSS gf180mcu_as_sc_mcu7t3v3__inv_2_362/VNW
+ VSUBS gf180mcu_as_sc_mcu7t3v3__inv_2
Xgf180mcu_as_sc_mcu7t3v3__inv_2_340 VSS gf180mcu_as_sc_mcu7t3v3__inv_2_341/VDD gf180mcu_as_sc_mcu7t3v3__inv_2_341/Y
+ VSS gf180mcu_as_sc_mcu7t3v3__inv_2_340/VNW VSUBS gf180mcu_as_sc_mcu7t3v3__inv_2
Xu_t027_001 u_t027_001/c0_w0_bl u_t027_001/c0_w0_br u_t027_001/c0_w1_bl u_t027_001/c0_w1_br
+ u_t027_001/c0_r0_rbl u_t027_001/c0_r1_rbl u_t027_001/c1_w0_bl u_t027_001/c1_w0_br
+ u_t027_001/c1_w1_bl u_t027_001/c1_w1_br u_t027_001/c1_r0_rbl u_t027_001/c1_r1_rbl
+ u_t027_001/c2_w0_bl u_t027_001/c2_w0_br u_t027_001/c2_w1_bl u_t027_001/c2_w1_br
+ u_t027_001/c2_r0_rbl u_t027_001/c2_r1_rbl u_t027_001/c3_w0_bl u_t027_001/c3_w0_br
+ u_t027_001/c3_w1_bl u_t027_001/c3_w1_br u_t027_001/c3_r0_rbl u_t027_001/c3_r1_rbl
+ u_t027_001/r0_w0_wl u_t027_001/r0_w1_wl u_t027_001/r0_r0_rwl u_t027_001/r0_r1_rwl
+ u_t027_001/r1_w0_wl u_t027_001/r1_w1_wl u_t027_001/r1_r0_rwl u_t027_001/r1_r1_rwl
+ u_t027_001/r2_w0_wl u_t027_001/r2_w1_wl u_t027_001/r2_r0_rwl u_t027_001/r2_r1_rwl
+ u_t027_001/r3_w0_wl u_t027_001/r3_w1_wl u_t027_001/r3_r0_rwl u_t027_001/r3_r1_rwl
+ VSS u_t027_002/VSS VSUBS detronyx_12t_2w2r_rc4_4x4_routed_5layer_direct
Xu_t027_023 u_t027_023/c0_w0_bl u_t027_023/c0_w0_br u_t027_023/c0_w1_bl u_t027_023/c0_w1_br
+ u_t027_023/c0_r0_rbl u_t027_023/c0_r1_rbl u_t027_023/c1_w0_bl u_t027_023/c1_w0_br
+ u_t027_023/c1_w1_bl u_t027_023/c1_w1_br u_t027_023/c1_r0_rbl u_t027_023/c1_r1_rbl
+ u_t027_023/c2_w0_bl u_t027_023/c2_w0_br u_t027_023/c2_w1_bl u_t027_023/c2_w1_br
+ u_t027_023/c2_r0_rbl u_t027_023/c2_r1_rbl u_t027_023/c3_w0_bl u_t027_023/c3_w0_br
+ u_t027_023/c3_w1_bl u_t027_023/c3_w1_br u_t027_023/c3_r0_rbl u_t027_023/c3_r1_rbl
+ u_t027_023/r0_w0_wl u_t027_023/r0_w1_wl u_t027_023/r0_r0_rwl u_t027_023/r0_r1_rwl
+ u_t027_023/r1_w0_wl u_t027_023/r1_w1_wl u_t027_023/r1_r0_rwl u_t027_023/r1_r1_rwl
+ u_t027_023/r2_w0_wl u_t027_023/r2_w1_wl u_t027_023/r2_r0_rwl u_t027_023/r2_r1_rwl
+ u_t027_023/r3_w0_wl u_t027_023/r3_w1_wl u_t027_023/r3_r0_rwl u_t027_023/r3_r1_rwl
+ VSS u_t027_024/VSS VSUBS detronyx_12t_2w2r_rc4_4x4_routed_5layer_direct
Xu_t027_012 u_t027_012/c0_w0_bl u_t027_012/c0_w0_br u_t027_012/c0_w1_bl u_t027_012/c0_w1_br
+ u_t027_012/c0_r0_rbl u_t027_012/c0_r1_rbl u_t027_012/c1_w0_bl u_t027_012/c1_w0_br
+ u_t027_012/c1_w1_bl u_t027_012/c1_w1_br u_t027_012/c1_r0_rbl u_t027_012/c1_r1_rbl
+ u_t027_012/c2_w0_bl u_t027_012/c2_w0_br u_t027_012/c2_w1_bl u_t027_012/c2_w1_br
+ u_t027_012/c2_r0_rbl u_t027_012/c2_r1_rbl u_t027_012/c3_w0_bl u_t027_012/c3_w0_br
+ u_t027_012/c3_w1_bl u_t027_012/c3_w1_br u_t027_012/c3_r0_rbl u_t027_012/c3_r1_rbl
+ u_t027_012/r0_w0_wl u_t027_012/r0_w1_wl u_t027_012/r0_r0_rwl u_t027_012/r0_r1_rwl
+ u_t027_012/r1_w0_wl u_t027_012/r1_w1_wl u_t027_012/r1_r0_rwl u_t027_012/r1_r1_rwl
+ u_t027_012/r2_w0_wl u_t027_012/r2_w1_wl u_t027_012/r2_r0_rwl u_t027_012/r2_r1_rwl
+ u_t027_012/r3_w0_wl u_t027_012/r3_w1_wl u_t027_012/r3_r0_rwl u_t027_012/r3_r1_rwl
+ u_t027_012/VDD u_t027_012/VSS VSUBS detronyx_12t_2w2r_rc4_4x4_routed_5layer_direct
Xu_t018_023 u_t018_023/c0_w0_bl u_t018_023/c0_w0_br u_t018_023/c0_w1_bl u_t018_023/c0_w1_br
+ u_t018_023/c0_r0_rbl u_t018_023/c0_r1_rbl u_t018_023/c1_w0_bl u_t018_023/c1_w0_br
+ u_t018_023/c1_w1_bl u_t018_023/c1_w1_br u_t018_023/c1_r0_rbl u_t018_023/c1_r1_rbl
+ u_t018_023/c2_w0_bl u_t018_023/c2_w0_br u_t018_023/c2_w1_bl u_t018_023/c2_w1_br
+ u_t018_023/c2_r0_rbl u_t018_023/c2_r1_rbl u_t018_023/c3_w0_bl u_t018_023/c3_w0_br
+ u_t018_023/c3_w1_bl u_t018_023/c3_w1_br u_t018_023/c3_r0_rbl u_t018_023/c3_r1_rbl
+ u_t018_023/r0_w0_wl u_t018_023/r0_w1_wl u_t018_023/r0_r0_rwl u_t018_023/r0_r1_rwl
+ u_t018_023/r1_w0_wl u_t018_023/r1_w1_wl u_t018_023/r1_r0_rwl u_t018_023/r1_r1_rwl
+ u_t018_023/r2_w0_wl u_t018_023/r2_w1_wl u_t018_023/r2_r0_rwl u_t018_023/r2_r1_rwl
+ u_t018_023/r3_w0_wl u_t018_023/r3_w1_wl u_t018_023/r3_r0_rwl u_t018_023/r3_r1_rwl
+ VSS u_t018_024/VSS VSUBS detronyx_12t_2w2r_rc4_4x4_routed_5layer_direct
Xu_t018_012 u_t018_012/c0_w0_bl u_t018_012/c0_w0_br u_t018_012/c0_w1_bl u_t018_012/c0_w1_br
+ u_t018_012/c0_r0_rbl u_t018_012/c0_r1_rbl u_t018_012/c1_w0_bl u_t018_012/c1_w0_br
+ u_t018_012/c1_w1_bl u_t018_012/c1_w1_br u_t018_012/c1_r0_rbl u_t018_012/c1_r1_rbl
+ u_t018_012/c2_w0_bl u_t018_012/c2_w0_br u_t018_012/c2_w1_bl u_t018_012/c2_w1_br
+ u_t018_012/c2_r0_rbl u_t018_012/c2_r1_rbl u_t018_012/c3_w0_bl u_t018_012/c3_w0_br
+ u_t018_012/c3_w1_bl u_t018_012/c3_w1_br u_t018_012/c3_r0_rbl u_t018_012/c3_r1_rbl
+ u_t018_012/r0_w0_wl u_t018_012/r0_w1_wl u_t018_012/r0_r0_rwl u_t018_012/r0_r1_rwl
+ u_t018_012/r1_w0_wl u_t018_012/r1_w1_wl u_t018_012/r1_r0_rwl u_t018_012/r1_r1_rwl
+ u_t018_012/r2_w0_wl u_t018_012/r2_w1_wl u_t018_012/r2_r0_rwl u_t018_012/r2_r1_rwl
+ u_t018_012/r3_w0_wl u_t018_012/r3_w1_wl u_t018_012/r3_r0_rwl u_t018_012/r3_r1_rwl
+ u_t018_012/VDD u_t018_012/VSS VSUBS detronyx_12t_2w2r_rc4_4x4_routed_5layer_direct
Xu_t018_001 u_t018_001/c0_w0_bl u_t018_001/c0_w0_br u_t018_001/c0_w1_bl u_t018_001/c0_w1_br
+ u_t018_001/c0_r0_rbl u_t018_001/c0_r1_rbl u_t018_001/c1_w0_bl u_t018_001/c1_w0_br
+ u_t018_001/c1_w1_bl u_t018_001/c1_w1_br u_t018_001/c1_r0_rbl u_t018_001/c1_r1_rbl
+ u_t018_001/c2_w0_bl u_t018_001/c2_w0_br u_t018_001/c2_w1_bl u_t018_001/c2_w1_br
+ u_t018_001/c2_r0_rbl u_t018_001/c2_r1_rbl u_t018_001/c3_w0_bl u_t018_001/c3_w0_br
+ u_t018_001/c3_w1_bl u_t018_001/c3_w1_br u_t018_001/c3_r0_rbl u_t018_001/c3_r1_rbl
+ u_t018_001/r0_w0_wl u_t018_001/r0_w1_wl u_t018_001/r0_r0_rwl u_t018_001/r0_r1_rwl
+ u_t018_001/r1_w0_wl u_t018_001/r1_w1_wl u_t018_001/r1_r0_rwl u_t018_001/r1_r1_rwl
+ u_t018_001/r2_w0_wl u_t018_001/r2_w1_wl u_t018_001/r2_r0_rwl u_t018_001/r2_r1_rwl
+ u_t018_001/r3_w0_wl u_t018_001/r3_w1_wl u_t018_001/r3_r0_rwl u_t018_001/r3_r1_rwl
+ VSS u_t018_002/VSS VSUBS detronyx_12t_2w2r_rc4_4x4_routed_5layer_direct
Xu_t009_001 u_t009_001/c0_w0_bl u_t009_001/c0_w0_br u_t009_001/c0_w1_bl u_t009_001/c0_w1_br
+ u_t009_001/c0_r0_rbl u_t009_001/c0_r1_rbl u_t009_001/c1_w0_bl u_t009_001/c1_w0_br
+ u_t009_001/c1_w1_bl u_t009_001/c1_w1_br u_t009_001/c1_r0_rbl u_t009_001/c1_r1_rbl
+ u_t009_001/c2_w0_bl u_t009_001/c2_w0_br u_t009_001/c2_w1_bl u_t009_001/c2_w1_br
+ u_t009_001/c2_r0_rbl u_t009_001/c2_r1_rbl u_t009_001/c3_w0_bl u_t009_001/c3_w0_br
+ u_t009_001/c3_w1_bl u_t009_001/c3_w1_br u_t009_001/c3_r0_rbl u_t009_001/c3_r1_rbl
+ u_t009_001/r0_w0_wl u_t009_001/r0_w1_wl u_t009_001/r0_r0_rwl u_t009_001/r0_r1_rwl
+ u_t009_001/r1_w0_wl u_t009_001/r1_w1_wl u_t009_001/r1_r0_rwl u_t009_001/r1_r1_rwl
+ u_t009_001/r2_w0_wl u_t009_001/r2_w1_wl u_t009_001/r2_r0_rwl u_t009_001/r2_r1_rwl
+ u_t009_001/r3_w0_wl u_t009_001/r3_w1_wl u_t009_001/r3_r0_rwl u_t009_001/r3_r1_rwl
+ VSS u_t009_031/VSS VSUBS detronyx_12t_2w2r_rc4_4x4_routed_5layer_direct
Xu_t024_026 u_t024_026/c0_w0_bl u_t024_026/c0_w0_br u_t024_026/c0_w1_bl u_t024_026/c0_w1_br
+ u_t024_026/c0_r0_rbl u_t024_026/c0_r1_rbl u_t024_026/c1_w0_bl u_t024_026/c1_w0_br
+ u_t024_026/c1_w1_bl u_t024_026/c1_w1_br u_t024_026/c1_r0_rbl u_t024_026/c1_r1_rbl
+ u_t024_026/c2_w0_bl u_t024_026/c2_w0_br u_t024_026/c2_w1_bl u_t024_026/c2_w1_br
+ u_t024_026/c2_r0_rbl u_t024_026/c2_r1_rbl u_t024_026/c3_w0_bl u_t024_026/c3_w0_br
+ u_t024_026/c3_w1_bl u_t024_026/c3_w1_br u_t024_026/c3_r0_rbl u_t024_026/c3_r1_rbl
+ u_t024_026/r0_w0_wl u_t024_026/r0_w1_wl u_t024_026/r0_r0_rwl u_t024_026/r0_r1_rwl
+ u_t024_026/r1_w0_wl u_t024_026/r1_w1_wl u_t024_026/r1_r0_rwl u_t024_026/r1_r1_rwl
+ u_t024_026/r2_w0_wl u_t024_026/r2_w1_wl u_t024_026/r2_r0_rwl u_t024_026/r2_r1_rwl
+ u_t024_026/r3_w0_wl u_t024_026/r3_w1_wl u_t024_026/r3_r0_rwl u_t024_026/r3_r1_rwl
+ u_t025_026/VDD u_t024_026/VSS VSUBS detronyx_12t_2w2r_rc4_4x4_routed_5layer_direct
Xu_t009_023 u_t009_023/c0_w0_bl u_t009_023/c0_w0_br u_t009_023/c0_w1_bl u_t009_023/c0_w1_br
+ u_t009_023/c0_r0_rbl u_t009_023/c0_r1_rbl u_t009_023/c1_w0_bl u_t009_023/c1_w0_br
+ u_t009_023/c1_w1_bl u_t009_023/c1_w1_br u_t009_023/c1_r0_rbl u_t009_023/c1_r1_rbl
+ u_t009_023/c2_w0_bl u_t009_023/c2_w0_br u_t009_023/c2_w1_bl u_t009_023/c2_w1_br
+ u_t009_023/c2_r0_rbl u_t009_023/c2_r1_rbl u_t009_023/c3_w0_bl u_t009_023/c3_w0_br
+ u_t009_023/c3_w1_bl u_t009_023/c3_w1_br u_t009_023/c3_r0_rbl u_t009_023/c3_r1_rbl
+ u_t009_023/r0_w0_wl u_t009_023/r0_w1_wl u_t009_023/r0_r0_rwl u_t009_023/r0_r1_rwl
+ u_t009_023/r1_w0_wl u_t009_023/r1_w1_wl u_t009_023/r1_r0_rwl u_t009_023/r1_r1_rwl
+ u_t009_023/r2_w0_wl u_t009_023/r2_w1_wl u_t009_023/r2_r0_rwl u_t009_023/r2_r1_rwl
+ u_t009_023/r3_w0_wl u_t009_023/r3_w1_wl u_t009_023/r3_r0_rwl u_t009_023/r3_r1_rwl
+ VSS u_t009_031/VSS VSUBS detronyx_12t_2w2r_rc4_4x4_routed_5layer_direct
Xu_t024_015 u_t024_015/c0_w0_bl u_t024_015/c0_w0_br u_t024_015/c0_w1_bl u_t024_015/c0_w1_br
+ u_t024_015/c0_r0_rbl u_t024_015/c0_r1_rbl u_t024_015/c1_w0_bl u_t024_015/c1_w0_br
+ u_t024_015/c1_w1_bl u_t024_015/c1_w1_br u_t024_015/c1_r0_rbl u_t024_015/c1_r1_rbl
+ u_t024_015/c2_w0_bl u_t024_015/c2_w0_br u_t024_015/c2_w1_bl u_t024_015/c2_w1_br
+ u_t024_015/c2_r0_rbl u_t024_015/c2_r1_rbl u_t024_015/c3_w0_bl u_t024_015/c3_w0_br
+ u_t024_015/c3_w1_bl u_t024_015/c3_w1_br u_t024_015/c3_r0_rbl u_t024_015/c3_r1_rbl
+ u_t024_015/r0_w0_wl u_t024_015/r0_w1_wl u_t024_015/r0_r0_rwl u_t024_015/r0_r1_rwl
+ u_t024_015/r1_w0_wl u_t024_015/r1_w1_wl u_t024_015/r1_r0_rwl u_t024_015/r1_r1_rwl
+ u_t024_015/r2_w0_wl u_t024_015/r2_w1_wl u_t024_015/r2_r0_rwl u_t024_015/r2_r1_rwl
+ u_t024_015/r3_w0_wl u_t024_015/r3_w1_wl u_t024_015/r3_r0_rwl u_t024_015/r3_r1_rwl
+ VSS u_t024_017/VSS VSUBS detronyx_12t_2w2r_rc4_4x4_routed_5layer_direct
Xu_t009_012 u_t009_012/c0_w0_bl u_t009_012/c0_w0_br u_t009_012/c0_w1_bl u_t009_012/c0_w1_br
+ u_t009_012/c0_r0_rbl u_t009_012/c0_r1_rbl u_t009_012/c1_w0_bl u_t009_012/c1_w0_br
+ u_t009_012/c1_w1_bl u_t009_012/c1_w1_br u_t009_012/c1_r0_rbl u_t009_012/c1_r1_rbl
+ u_t009_012/c2_w0_bl u_t009_012/c2_w0_br u_t009_012/c2_w1_bl u_t009_012/c2_w1_br
+ u_t009_012/c2_r0_rbl u_t009_012/c2_r1_rbl u_t009_012/c3_w0_bl u_t009_012/c3_w0_br
+ u_t009_012/c3_w1_bl u_t009_012/c3_w1_br u_t009_012/c3_r0_rbl u_t009_012/c3_r1_rbl
+ u_t009_012/r0_w0_wl u_t009_012/r0_w1_wl u_t009_012/r0_r0_rwl u_t009_012/r0_r1_rwl
+ u_t009_012/r1_w0_wl u_t009_012/r1_w1_wl u_t009_012/r1_r0_rwl u_t009_012/r1_r1_rwl
+ u_t009_012/r2_w0_wl u_t009_012/r2_w1_wl u_t009_012/r2_r0_rwl u_t009_012/r2_r1_rwl
+ u_t009_012/r3_w0_wl u_t009_012/r3_w1_wl u_t009_012/r3_r0_rwl u_t009_012/r3_r1_rwl
+ u_t009_012/VDD u_t009_031/VSS VSUBS detronyx_12t_2w2r_rc4_4x4_routed_5layer_direct
Xu_t024_004 u_t024_004/c0_w0_bl u_t024_004/c0_w0_br u_t024_004/c0_w1_bl u_t024_004/c0_w1_br
+ u_t024_004/c0_r0_rbl u_t024_004/c0_r1_rbl u_t024_004/c1_w0_bl u_t024_004/c1_w0_br
+ u_t024_004/c1_w1_bl u_t024_004/c1_w1_br u_t024_004/c1_r0_rbl u_t024_004/c1_r1_rbl
+ u_t024_004/c2_w0_bl u_t024_004/c2_w0_br u_t024_004/c2_w1_bl u_t024_004/c2_w1_br
+ u_t024_004/c2_r0_rbl u_t024_004/c2_r1_rbl u_t024_004/c3_w0_bl u_t024_004/c3_w0_br
+ u_t024_004/c3_w1_bl u_t024_004/c3_w1_br u_t024_004/c3_r0_rbl u_t024_004/c3_r1_rbl
+ u_t024_004/r0_w0_wl u_t024_004/r0_w1_wl u_t024_004/r0_r0_rwl u_t024_004/r0_r1_rwl
+ u_t024_004/r1_w0_wl u_t024_004/r1_w1_wl u_t024_004/r1_r0_rwl u_t024_004/r1_r1_rwl
+ u_t024_004/r2_w0_wl u_t024_004/r2_w1_wl u_t024_004/r2_r0_rwl u_t024_004/r2_r1_rwl
+ u_t024_004/r3_w0_wl u_t024_004/r3_w1_wl u_t024_004/r3_r0_rwl u_t024_004/r3_r1_rwl
+ u_t025_004/VDD u_t024_004/VSS VSUBS detronyx_12t_2w2r_rc4_4x4_routed_5layer_direct
Xgf180mcu_as_sc_mcu7t3v3__nand3_2_27 gf180mcu_as_sc_mcu7t3v3__nand3_2_31/VDD gf180mcu_as_sc_mcu7t3v3__nand3_2_31/VSS
+ VSS VSS VSS VSS gf180mcu_as_sc_mcu7t3v3__nand3_2_31/VNW VSUBS gf180mcu_as_sc_mcu7t3v3__nand3_2
Xgf180mcu_as_sc_mcu7t3v3__nand3_2_16 gf180mcu_as_sc_mcu7t3v3__nor2_2_4/VDD gf180mcu_as_sc_mcu7t3v3__nand3_2_8/VSS
+ VSS VSS VSS VSS gf180mcu_as_sc_mcu7t3v3__nor2_2_4/VNW VSUBS gf180mcu_as_sc_mcu7t3v3__nand3_2
Xgf180mcu_as_sc_mcu7t3v3__inv_2_170 gf180mcu_as_sc_mcu7t3v3__inv_2_260/VSS gf180mcu_as_sc_mcu7t3v3__inv_2_205/VDD
+ gf180mcu_as_sc_mcu7t3v3__inv_2_170/Y VSS gf180mcu_as_sc_mcu7t3v3__inv_2_174/VNW
+ VSUBS gf180mcu_as_sc_mcu7t3v3__inv_2
Xgf180mcu_as_sc_mcu7t3v3__inv_2_1669 gf180mcu_as_sc_mcu7t3v3__inv_2_1669/VDD VSS gf180mcu_as_sc_mcu7t3v3__inv_2_1675/Y
+ VSS gf180mcu_as_sc_mcu7t3v3__inv_2_1669/VNW VSUBS gf180mcu_as_sc_mcu7t3v3__inv_2
Xgf180mcu_as_sc_mcu7t3v3__inv_2_1636 VSS gf180mcu_as_sc_mcu7t3v3__inv_2_1674/VDD VSS
+ gf180mcu_as_sc_mcu7t3v3__inv_2_1675/Y gf180mcu_as_sc_mcu7t3v3__inv_2_1673/VNW VSUBS
+ gf180mcu_as_sc_mcu7t3v3__inv_2
Xgf180mcu_as_sc_mcu7t3v3__inv_2_1647 VSS VSS VSS gf180mcu_as_sc_mcu7t3v3__inv_2_1678/Y
+ gf180mcu_as_sc_mcu7t3v3__inv_2_1676/VNW VSUBS gf180mcu_as_sc_mcu7t3v3__inv_2
Xgf180mcu_as_sc_mcu7t3v3__inv_2_1603 gf180mcu_as_sc_mcu7t3v3__inv_2_1653/VDD gf180mcu_as_sc_mcu7t3v3__inv_2_1654/VDD
+ gf180mcu_as_sc_mcu7t3v3__inv_2_1603/Y gf180mcu_as_sc_mcu7t3v3__inv_2_1682/Y gf180mcu_as_sc_mcu7t3v3__inv_2_1653/VNW
+ VSUBS gf180mcu_as_sc_mcu7t3v3__inv_2
Xgf180mcu_as_sc_mcu7t3v3__inv_2_1614 VSS gf180mcu_as_sc_mcu7t3v3__inv_2_1657/VDD VSS
+ gf180mcu_as_sc_mcu7t3v3__inv_2_1657/Y gf180mcu_as_sc_mcu7t3v3__inv_2_1656/VNW VSUBS
+ gf180mcu_as_sc_mcu7t3v3__inv_2
Xgf180mcu_as_sc_mcu7t3v3__inv_2_1658 VSS VSS gf180mcu_as_sc_mcu7t3v3__inv_2_1660/Y
+ VSS gf180mcu_as_sc_mcu7t3v3__inv_2_1658/VNW VSUBS gf180mcu_as_sc_mcu7t3v3__inv_2
Xgf180mcu_as_sc_mcu7t3v3__inv_2_1625 gf180mcu_as_sc_mcu7t3v3__inv_2_1663/VDD gf180mcu_as_sc_mcu7t3v3__inv_2_1685/VDD
+ gf180mcu_as_sc_mcu7t3v3__inv_2_1625/Y gf180mcu_as_sc_mcu7t3v3__inv_2_1685/Y gf180mcu_as_sc_mcu7t3v3__inv_2_1663/VNW
+ VSUBS gf180mcu_as_sc_mcu7t3v3__inv_2
Xgf180mcu_as_sc_mcu7t3v3__inv_2_192 gf180mcu_as_sc_mcu7t3v3__inv_2_192/VDD VSS VSS
+ VSS gf180mcu_as_sc_mcu7t3v3__inv_2_192/VNW VSUBS gf180mcu_as_sc_mcu7t3v3__inv_2
Xgf180mcu_as_sc_mcu7t3v3__inv_2_181 VSS gf180mcu_as_sc_mcu7t3v3__inv_2_188/VDD VSS
+ VSS gf180mcu_as_sc_mcu7t3v3__inv_2_181/VNW VSUBS gf180mcu_as_sc_mcu7t3v3__inv_2
Xu_t030_029 u_t030_029/c0_w0_bl u_t030_029/c0_w0_br u_t030_029/c0_w1_bl u_t030_029/c0_w1_br
+ u_t030_029/c0_r0_rbl u_t030_029/c0_r1_rbl u_t030_029/c1_w0_bl u_t030_029/c1_w0_br
+ u_t030_029/c1_w1_bl u_t030_029/c1_w1_br u_t030_029/c1_r0_rbl u_t030_029/c1_r1_rbl
+ u_t030_029/c2_w0_bl u_t030_029/c2_w0_br u_t030_029/c2_w1_bl u_t030_029/c2_w1_br
+ u_t030_029/c2_r0_rbl u_t030_029/c2_r1_rbl u_t030_029/c3_w0_bl u_t030_029/c3_w0_br
+ u_t030_029/c3_w1_bl u_t030_029/c3_w1_br u_t030_029/c3_r0_rbl u_t030_029/c3_r1_rbl
+ u_t030_029/r0_w0_wl u_t030_029/r0_w1_wl u_t030_029/r0_r0_rwl u_t030_029/r0_r1_rwl
+ u_t030_029/r1_w0_wl u_t030_029/r1_w1_wl u_t030_029/r1_r0_rwl u_t030_029/r1_r1_rwl
+ u_t030_029/r2_w0_wl u_t030_029/r2_w1_wl u_t030_029/r2_r0_rwl u_t030_029/r2_r1_rwl
+ u_t030_029/r3_w0_wl u_t030_029/r3_w1_wl u_t030_029/r3_r0_rwl u_t030_029/r3_r1_rwl
+ u_t030_029/VDD u_t030_031/VSS VSUBS detronyx_12t_2w2r_rc4_4x4_routed_5layer_direct
Xu_t015_026 u_t015_026/c0_w0_bl u_t015_026/c0_w0_br u_t015_026/c0_w1_bl u_t015_026/c0_w1_br
+ u_t015_026/c0_r0_rbl u_t015_026/c0_r1_rbl u_t015_026/c1_w0_bl u_t015_026/c1_w0_br
+ u_t015_026/c1_w1_bl u_t015_026/c1_w1_br u_t015_026/c1_r0_rbl u_t015_026/c1_r1_rbl
+ u_t015_026/c2_w0_bl u_t015_026/c2_w0_br u_t015_026/c2_w1_bl u_t015_026/c2_w1_br
+ u_t015_026/c2_r0_rbl u_t015_026/c2_r1_rbl u_t015_026/c3_w0_bl u_t015_026/c3_w0_br
+ u_t015_026/c3_w1_bl u_t015_026/c3_w1_br u_t015_026/c3_r0_rbl u_t015_026/c3_r1_rbl
+ u_t015_026/r0_w0_wl u_t015_026/r0_w1_wl u_t015_026/r0_r0_rwl u_t015_026/r0_r1_rwl
+ u_t015_026/r1_w0_wl u_t015_026/r1_w1_wl u_t015_026/r1_r0_rwl u_t015_026/r1_r1_rwl
+ u_t015_026/r2_w0_wl u_t015_026/r2_w1_wl u_t015_026/r2_r0_rwl u_t015_026/r2_r1_rwl
+ u_t015_026/r3_w0_wl u_t015_026/r3_w1_wl u_t015_026/r3_r0_rwl u_t015_026/r3_r1_rwl
+ u_t015_026/VDD u_t015_026/VSS VSUBS detronyx_12t_2w2r_rc4_4x4_routed_5layer_direct
Xu_t030_018 u_t030_018/c0_w0_bl u_t030_018/c0_w0_br u_t030_018/c0_w1_bl u_t030_018/c0_w1_br
+ u_t030_018/c0_r0_rbl u_t030_018/c0_r1_rbl u_t030_018/c1_w0_bl u_t030_018/c1_w0_br
+ u_t030_018/c1_w1_bl u_t030_018/c1_w1_br u_t030_018/c1_r0_rbl u_t030_018/c1_r1_rbl
+ u_t030_018/c2_w0_bl u_t030_018/c2_w0_br u_t030_018/c2_w1_bl u_t030_018/c2_w1_br
+ u_t030_018/c2_r0_rbl u_t030_018/c2_r1_rbl u_t030_018/c3_w0_bl u_t030_018/c3_w0_br
+ u_t030_018/c3_w1_bl u_t030_018/c3_w1_br u_t030_018/c3_r0_rbl u_t030_018/c3_r1_rbl
+ u_t030_018/r0_w0_wl u_t030_018/r0_w1_wl u_t030_018/r0_r0_rwl u_t030_018/r0_r1_rwl
+ u_t030_018/r1_w0_wl u_t030_018/r1_w1_wl u_t030_018/r1_r0_rwl u_t030_018/r1_r1_rwl
+ u_t030_018/r2_w0_wl u_t030_018/r2_w1_wl u_t030_018/r2_r0_rwl u_t030_018/r2_r1_rwl
+ u_t030_018/r3_w0_wl u_t030_018/r3_w1_wl u_t030_018/r3_r0_rwl u_t030_018/r3_r1_rwl
+ u_t030_018/VDD u_t030_031/VSS VSUBS detronyx_12t_2w2r_rc4_4x4_routed_5layer_direct
Xu_t015_015 u_t015_015/c0_w0_bl u_t015_015/c0_w0_br u_t015_015/c0_w1_bl u_t015_015/c0_w1_br
+ u_t015_015/c0_r0_rbl u_t015_015/c0_r1_rbl u_t015_015/c1_w0_bl u_t015_015/c1_w0_br
+ u_t015_015/c1_w1_bl u_t015_015/c1_w1_br u_t015_015/c1_r0_rbl u_t015_015/c1_r1_rbl
+ u_t015_015/c2_w0_bl u_t015_015/c2_w0_br u_t015_015/c2_w1_bl u_t015_015/c2_w1_br
+ u_t015_015/c2_r0_rbl u_t015_015/c2_r1_rbl u_t015_015/c3_w0_bl u_t015_015/c3_w0_br
+ u_t015_015/c3_w1_bl u_t015_015/c3_w1_br u_t015_015/c3_r0_rbl u_t015_015/c3_r1_rbl
+ u_t015_015/r0_w0_wl u_t015_015/r0_w1_wl u_t015_015/r0_r0_rwl u_t015_015/r0_r1_rwl
+ u_t015_015/r1_w0_wl u_t015_015/r1_w1_wl u_t015_015/r1_r0_rwl u_t015_015/r1_r1_rwl
+ u_t015_015/r2_w0_wl u_t015_015/r2_w1_wl u_t015_015/r2_r0_rwl u_t015_015/r2_r1_rwl
+ u_t015_015/r3_w0_wl u_t015_015/r3_w1_wl u_t015_015/r3_r0_rwl u_t015_015/r3_r1_rwl
+ VSS u_t015_017/VSS VSUBS detronyx_12t_2w2r_rc4_4x4_routed_5layer_direct
Xu_t030_007 u_t030_007/c0_w0_bl u_t030_007/c0_w0_br u_t030_007/c0_w1_bl u_t030_007/c0_w1_br
+ u_t030_007/c0_r0_rbl u_t030_007/c0_r1_rbl u_t030_007/c1_w0_bl u_t030_007/c1_w0_br
+ u_t030_007/c1_w1_bl u_t030_007/c1_w1_br u_t030_007/c1_r0_rbl u_t030_007/c1_r1_rbl
+ u_t030_007/c2_w0_bl u_t030_007/c2_w0_br u_t030_007/c2_w1_bl u_t030_007/c2_w1_br
+ u_t030_007/c2_r0_rbl u_t030_007/c2_r1_rbl u_t030_007/c3_w0_bl u_t030_007/c3_w0_br
+ u_t030_007/c3_w1_bl u_t030_007/c3_w1_br u_t030_007/c3_r0_rbl u_t030_007/c3_r1_rbl
+ u_t030_007/r0_w0_wl u_t030_007/r0_w1_wl u_t030_007/r0_r0_rwl u_t030_007/r0_r1_rwl
+ u_t030_007/r1_w0_wl u_t030_007/r1_w1_wl u_t030_007/r1_r0_rwl u_t030_007/r1_r1_rwl
+ u_t030_007/r2_w0_wl u_t030_007/r2_w1_wl u_t030_007/r2_r0_rwl u_t030_007/r2_r1_rwl
+ u_t030_007/r3_w0_wl u_t030_007/r3_w1_wl u_t030_007/r3_r0_rwl u_t030_007/r3_r1_rwl
+ VSS u_t030_031/VSS VSUBS detronyx_12t_2w2r_rc4_4x4_routed_5layer_direct
Xu_t015_004 u_t015_004/c0_w0_bl u_t015_004/c0_w0_br u_t015_004/c0_w1_bl u_t015_004/c0_w1_br
+ u_t015_004/c0_r0_rbl u_t015_004/c0_r1_rbl u_t015_004/c1_w0_bl u_t015_004/c1_w0_br
+ u_t015_004/c1_w1_bl u_t015_004/c1_w1_br u_t015_004/c1_r0_rbl u_t015_004/c1_r1_rbl
+ u_t015_004/c2_w0_bl u_t015_004/c2_w0_br u_t015_004/c2_w1_bl u_t015_004/c2_w1_br
+ u_t015_004/c2_r0_rbl u_t015_004/c2_r1_rbl u_t015_004/c3_w0_bl u_t015_004/c3_w0_br
+ u_t015_004/c3_w1_bl u_t015_004/c3_w1_br u_t015_004/c3_r0_rbl u_t015_004/c3_r1_rbl
+ u_t015_004/r0_w0_wl u_t015_004/r0_w1_wl u_t015_004/r0_r0_rwl u_t015_004/r0_r1_rwl
+ u_t015_004/r1_w0_wl u_t015_004/r1_w1_wl u_t015_004/r1_r0_rwl u_t015_004/r1_r1_rwl
+ u_t015_004/r2_w0_wl u_t015_004/r2_w1_wl u_t015_004/r2_r0_rwl u_t015_004/r2_r1_rwl
+ u_t015_004/r3_w0_wl u_t015_004/r3_w1_wl u_t015_004/r3_r0_rwl u_t015_004/r3_r1_rwl
+ u_t015_004/VDD u_t015_004/VSS VSUBS detronyx_12t_2w2r_rc4_4x4_routed_5layer_direct
Xgf180mcu_as_sc_mcu7t3v3__nand4_2_408 gf180mcu_as_sc_mcu7t3v3__inv_2_1383/VDD gf180mcu_as_sc_mcu7t3v3__inv_2_1384/VDD
+ VSS VSS VSS VSS VSS gf180mcu_as_sc_mcu7t3v3__inv_2_1383/VNW VSUBS gf180mcu_as_sc_mcu7t3v3__nand4_2
Xgf180mcu_as_sc_mcu7t3v3__nand4_2_419 gf180mcu_as_sc_mcu7t3v3__inv_2_1420/VDD VSS
+ VSS VSS VSS VSS VSS gf180mcu_as_sc_mcu7t3v3__inv_2_1420/VNW VSUBS gf180mcu_as_sc_mcu7t3v3__nand4_2
Xu_t006_026 u_t006_026/c0_w0_bl u_t006_026/c0_w0_br u_t006_026/c0_w1_bl u_t006_026/c0_w1_br
+ u_t006_026/c0_r0_rbl u_t006_026/c0_r1_rbl u_t006_026/c1_w0_bl u_t006_026/c1_w0_br
+ u_t006_026/c1_w1_bl u_t006_026/c1_w1_br u_t006_026/c1_r0_rbl u_t006_026/c1_r1_rbl
+ u_t006_026/c2_w0_bl u_t006_026/c2_w0_br u_t006_026/c2_w1_bl u_t006_026/c2_w1_br
+ u_t006_026/c2_r0_rbl u_t006_026/c2_r1_rbl u_t006_026/c3_w0_bl u_t006_026/c3_w0_br
+ u_t006_026/c3_w1_bl u_t006_026/c3_w1_br u_t006_026/c3_r0_rbl u_t006_026/c3_r1_rbl
+ u_t006_026/r0_w0_wl u_t006_026/r0_w1_wl u_t006_026/r0_r0_rwl u_t006_026/r0_r1_rwl
+ u_t006_026/r1_w0_wl u_t006_026/r1_w1_wl u_t006_026/r1_r0_rwl u_t006_026/r1_r1_rwl
+ u_t006_026/r2_w0_wl u_t006_026/r2_w1_wl u_t006_026/r2_r0_rwl u_t006_026/r2_r1_rwl
+ u_t006_026/r3_w0_wl u_t006_026/r3_w1_wl u_t006_026/r3_r0_rwl u_t006_026/r3_r1_rwl
+ u_t006_026/VDD u_t006_026/VSS VSUBS detronyx_12t_2w2r_rc4_4x4_routed_5layer_direct
Xu_t006_015 u_t006_015/c0_w0_bl u_t006_015/c0_w0_br u_t006_015/c0_w1_bl u_t006_015/c0_w1_br
+ u_t006_015/c0_r0_rbl u_t006_015/c0_r1_rbl u_t006_015/c1_w0_bl u_t006_015/c1_w0_br
+ u_t006_015/c1_w1_bl u_t006_015/c1_w1_br u_t006_015/c1_r0_rbl u_t006_015/c1_r1_rbl
+ u_t006_015/c2_w0_bl u_t006_015/c2_w0_br u_t006_015/c2_w1_bl u_t006_015/c2_w1_br
+ u_t006_015/c2_r0_rbl u_t006_015/c2_r1_rbl u_t006_015/c3_w0_bl u_t006_015/c3_w0_br
+ u_t006_015/c3_w1_bl u_t006_015/c3_w1_br u_t006_015/c3_r0_rbl u_t006_015/c3_r1_rbl
+ u_t006_015/r0_w0_wl u_t006_015/r0_w1_wl u_t006_015/r0_r0_rwl u_t006_015/r0_r1_rwl
+ u_t006_015/r1_w0_wl u_t006_015/r1_w1_wl u_t006_015/r1_r0_rwl u_t006_015/r1_r1_rwl
+ u_t006_015/r2_w0_wl u_t006_015/r2_w1_wl u_t006_015/r2_r0_rwl u_t006_015/r2_r1_rwl
+ u_t006_015/r3_w0_wl u_t006_015/r3_w1_wl u_t006_015/r3_r0_rwl u_t006_015/r3_r1_rwl
+ VSS u_t006_017/VSS VSUBS detronyx_12t_2w2r_rc4_4x4_routed_5layer_direct
Xu_t006_004 u_t006_004/c0_w0_bl u_t006_004/c0_w0_br u_t006_004/c0_w1_bl u_t006_004/c0_w1_br
+ u_t006_004/c0_r0_rbl u_t006_004/c0_r1_rbl u_t006_004/c1_w0_bl u_t006_004/c1_w0_br
+ u_t006_004/c1_w1_bl u_t006_004/c1_w1_br u_t006_004/c1_r0_rbl u_t006_004/c1_r1_rbl
+ u_t006_004/c2_w0_bl u_t006_004/c2_w0_br u_t006_004/c2_w1_bl u_t006_004/c2_w1_br
+ u_t006_004/c2_r0_rbl u_t006_004/c2_r1_rbl u_t006_004/c3_w0_bl u_t006_004/c3_w0_br
+ u_t006_004/c3_w1_bl u_t006_004/c3_w1_br u_t006_004/c3_r0_rbl u_t006_004/c3_r1_rbl
+ u_t006_004/r0_w0_wl u_t006_004/r0_w1_wl u_t006_004/r0_r0_rwl u_t006_004/r0_r1_rwl
+ u_t006_004/r1_w0_wl u_t006_004/r1_w1_wl u_t006_004/r1_r0_rwl u_t006_004/r1_r1_rwl
+ u_t006_004/r2_w0_wl u_t006_004/r2_w1_wl u_t006_004/r2_r0_rwl u_t006_004/r2_r1_rwl
+ u_t006_004/r3_w0_wl u_t006_004/r3_w1_wl u_t006_004/r3_r0_rwl u_t006_004/r3_r1_rwl
+ u_t006_004/VDD u_t006_004/VSS VSUBS detronyx_12t_2w2r_rc4_4x4_routed_5layer_direct
Xgf180mcu_as_sc_mcu7t3v3__nand2_2_60 gf180mcu_as_sc_mcu7t3v3__nor2_2_8/VDD gf180mcu_as_sc_mcu7t3v3__nor2_2_8/VSS
+ VSS VSS VSS gf180mcu_as_sc_mcu7t3v3__nor2_2_8/VNW VSUBS gf180mcu_as_sc_mcu7t3v3__nand2_2
Xgf180mcu_as_sc_mcu7t3v3__inv_2_9 gf180mcu_as_sc_mcu7t3v3__inv_2_9/VSS gf180mcu_as_sc_mcu7t3v3__inv_2_9/VSS
+ VSS gf180mcu_as_sc_mcu7t3v3__inv_2_9/A gf180mcu_as_sc_mcu7t3v3__inv_2_9/VNW VSUBS
+ gf180mcu_as_sc_mcu7t3v3__inv_2
Xu_t021_029 u_t021_029/c0_w0_bl u_t021_029/c0_w0_br u_t021_029/c0_w1_bl u_t021_029/c0_w1_br
+ u_t021_029/c0_r0_rbl u_t021_029/c0_r1_rbl u_t021_029/c1_w0_bl u_t021_029/c1_w0_br
+ u_t021_029/c1_w1_bl u_t021_029/c1_w1_br u_t021_029/c1_r0_rbl u_t021_029/c1_r1_rbl
+ u_t021_029/c2_w0_bl u_t021_029/c2_w0_br u_t021_029/c2_w1_bl u_t021_029/c2_w1_br
+ u_t021_029/c2_r0_rbl u_t021_029/c2_r1_rbl u_t021_029/c3_w0_bl u_t021_029/c3_w0_br
+ u_t021_029/c3_w1_bl u_t021_029/c3_w1_br u_t021_029/c3_r0_rbl u_t021_029/c3_r1_rbl
+ u_t021_029/r0_w0_wl u_t021_029/r0_w1_wl u_t021_029/r0_r0_rwl u_t021_029/r0_r1_rwl
+ u_t021_029/r1_w0_wl u_t021_029/r1_w1_wl u_t021_029/r1_r0_rwl u_t021_029/r1_r1_rwl
+ u_t021_029/r2_w0_wl u_t021_029/r2_w1_wl u_t021_029/r2_r0_rwl u_t021_029/r2_r1_rwl
+ u_t021_029/r3_w0_wl u_t021_029/r3_w1_wl u_t021_029/r3_r0_rwl u_t021_029/r3_r1_rwl
+ u_t021_029/VDD u_t021_031/VSS VSUBS detronyx_12t_2w2r_rc4_4x4_routed_5layer_direct
Xu_t021_018 u_t021_018/c0_w0_bl u_t021_018/c0_w0_br u_t021_018/c0_w1_bl u_t021_018/c0_w1_br
+ u_t021_018/c0_r0_rbl u_t021_018/c0_r1_rbl u_t021_018/c1_w0_bl u_t021_018/c1_w0_br
+ u_t021_018/c1_w1_bl u_t021_018/c1_w1_br u_t021_018/c1_r0_rbl u_t021_018/c1_r1_rbl
+ u_t021_018/c2_w0_bl u_t021_018/c2_w0_br u_t021_018/c2_w1_bl u_t021_018/c2_w1_br
+ u_t021_018/c2_r0_rbl u_t021_018/c2_r1_rbl u_t021_018/c3_w0_bl u_t021_018/c3_w0_br
+ u_t021_018/c3_w1_bl u_t021_018/c3_w1_br u_t021_018/c3_r0_rbl u_t021_018/c3_r1_rbl
+ u_t021_018/r0_w0_wl u_t021_018/r0_w1_wl u_t021_018/r0_r0_rwl u_t021_018/r0_r1_rwl
+ u_t021_018/r1_w0_wl u_t021_018/r1_w1_wl u_t021_018/r1_r0_rwl u_t021_018/r1_r1_rwl
+ u_t021_018/r2_w0_wl u_t021_018/r2_w1_wl u_t021_018/r2_r0_rwl u_t021_018/r2_r1_rwl
+ u_t021_018/r3_w0_wl u_t021_018/r3_w1_wl u_t021_018/r3_r0_rwl u_t021_018/r3_r1_rwl
+ u_t021_018/VDD u_t021_031/VSS VSUBS detronyx_12t_2w2r_rc4_4x4_routed_5layer_direct
Xu_t021_007 u_t021_007/c0_w0_bl u_t021_007/c0_w0_br u_t021_007/c0_w1_bl u_t021_007/c0_w1_br
+ u_t021_007/c0_r0_rbl u_t021_007/c0_r1_rbl u_t021_007/c1_w0_bl u_t021_007/c1_w0_br
+ u_t021_007/c1_w1_bl u_t021_007/c1_w1_br u_t021_007/c1_r0_rbl u_t021_007/c1_r1_rbl
+ u_t021_007/c2_w0_bl u_t021_007/c2_w0_br u_t021_007/c2_w1_bl u_t021_007/c2_w1_br
+ u_t021_007/c2_r0_rbl u_t021_007/c2_r1_rbl u_t021_007/c3_w0_bl u_t021_007/c3_w0_br
+ u_t021_007/c3_w1_bl u_t021_007/c3_w1_br u_t021_007/c3_r0_rbl u_t021_007/c3_r1_rbl
+ u_t021_007/r0_w0_wl u_t021_007/r0_w1_wl u_t021_007/r0_r0_rwl u_t021_007/r0_r1_rwl
+ u_t021_007/r1_w0_wl u_t021_007/r1_w1_wl u_t021_007/r1_r0_rwl u_t021_007/r1_r1_rwl
+ u_t021_007/r2_w0_wl u_t021_007/r2_w1_wl u_t021_007/r2_r0_rwl u_t021_007/r2_r1_rwl
+ u_t021_007/r3_w0_wl u_t021_007/r3_w1_wl u_t021_007/r3_r0_rwl u_t021_007/r3_r1_rwl
+ VSS u_t021_031/VSS VSUBS detronyx_12t_2w2r_rc4_4x4_routed_5layer_direct
Xu_t012_029 u_t012_029/c0_w0_bl u_t012_029/c0_w0_br u_t012_029/c0_w1_bl u_t012_029/c0_w1_br
+ u_t012_029/c0_r0_rbl u_t012_029/c0_r1_rbl u_t012_029/c1_w0_bl u_t012_029/c1_w0_br
+ u_t012_029/c1_w1_bl u_t012_029/c1_w1_br u_t012_029/c1_r0_rbl u_t012_029/c1_r1_rbl
+ u_t012_029/c2_w0_bl u_t012_029/c2_w0_br u_t012_029/c2_w1_bl u_t012_029/c2_w1_br
+ u_t012_029/c2_r0_rbl u_t012_029/c2_r1_rbl u_t012_029/c3_w0_bl u_t012_029/c3_w0_br
+ u_t012_029/c3_w1_bl u_t012_029/c3_w1_br u_t012_029/c3_r0_rbl u_t012_029/c3_r1_rbl
+ u_t012_029/r0_w0_wl u_t012_029/r0_w1_wl u_t012_029/r0_r0_rwl u_t012_029/r0_r1_rwl
+ u_t012_029/r1_w0_wl u_t012_029/r1_w1_wl u_t012_029/r1_r0_rwl u_t012_029/r1_r1_rwl
+ u_t012_029/r2_w0_wl u_t012_029/r2_w1_wl u_t012_029/r2_r0_rwl u_t012_029/r2_r1_rwl
+ u_t012_029/r3_w0_wl u_t012_029/r3_w1_wl u_t012_029/r3_r0_rwl u_t012_029/r3_r1_rwl
+ u_t012_029/VDD u_t012_031/VSS VSUBS detronyx_12t_2w2r_rc4_4x4_routed_5layer_direct
Xu_t012_018 u_t012_018/c0_w0_bl u_t012_018/c0_w0_br u_t012_018/c0_w1_bl u_t012_018/c0_w1_br
+ u_t012_018/c0_r0_rbl u_t012_018/c0_r1_rbl u_t012_018/c1_w0_bl u_t012_018/c1_w0_br
+ u_t012_018/c1_w1_bl u_t012_018/c1_w1_br u_t012_018/c1_r0_rbl u_t012_018/c1_r1_rbl
+ u_t012_018/c2_w0_bl u_t012_018/c2_w0_br u_t012_018/c2_w1_bl u_t012_018/c2_w1_br
+ u_t012_018/c2_r0_rbl u_t012_018/c2_r1_rbl u_t012_018/c3_w0_bl u_t012_018/c3_w0_br
+ u_t012_018/c3_w1_bl u_t012_018/c3_w1_br u_t012_018/c3_r0_rbl u_t012_018/c3_r1_rbl
+ u_t012_018/r0_w0_wl u_t012_018/r0_w1_wl u_t012_018/r0_r0_rwl u_t012_018/r0_r1_rwl
+ u_t012_018/r1_w0_wl u_t012_018/r1_w1_wl u_t012_018/r1_r0_rwl u_t012_018/r1_r1_rwl
+ u_t012_018/r2_w0_wl u_t012_018/r2_w1_wl u_t012_018/r2_r0_rwl u_t012_018/r2_r1_rwl
+ u_t012_018/r3_w0_wl u_t012_018/r3_w1_wl u_t012_018/r3_r0_rwl u_t012_018/r3_r1_rwl
+ u_t012_018/VDD u_t012_031/VSS VSUBS detronyx_12t_2w2r_rc4_4x4_routed_5layer_direct
Xu_t012_007 u_t012_007/c0_w0_bl u_t012_007/c0_w0_br u_t012_007/c0_w1_bl u_t012_007/c0_w1_br
+ u_t012_007/c0_r0_rbl u_t012_007/c0_r1_rbl u_t012_007/c1_w0_bl u_t012_007/c1_w0_br
+ u_t012_007/c1_w1_bl u_t012_007/c1_w1_br u_t012_007/c1_r0_rbl u_t012_007/c1_r1_rbl
+ u_t012_007/c2_w0_bl u_t012_007/c2_w0_br u_t012_007/c2_w1_bl u_t012_007/c2_w1_br
+ u_t012_007/c2_r0_rbl u_t012_007/c2_r1_rbl u_t012_007/c3_w0_bl u_t012_007/c3_w0_br
+ u_t012_007/c3_w1_bl u_t012_007/c3_w1_br u_t012_007/c3_r0_rbl u_t012_007/c3_r1_rbl
+ u_t012_007/r0_w0_wl u_t012_007/r0_w1_wl u_t012_007/r0_r0_rwl u_t012_007/r0_r1_rwl
+ u_t012_007/r1_w0_wl u_t012_007/r1_w1_wl u_t012_007/r1_r0_rwl u_t012_007/r1_r1_rwl
+ u_t012_007/r2_w0_wl u_t012_007/r2_w1_wl u_t012_007/r2_r0_rwl u_t012_007/r2_r1_rwl
+ u_t012_007/r3_w0_wl u_t012_007/r3_w1_wl u_t012_007/r3_r0_rwl u_t012_007/r3_r1_rwl
+ VSS u_t012_031/VSS VSUBS detronyx_12t_2w2r_rc4_4x4_routed_5layer_direct
Xgf180mcu_as_sc_mcu7t3v3__inv_2_1477 VSS gf180mcu_as_sc_mcu7t3v3__inv_2_1497/VDD VSS
+ VSS gf180mcu_as_sc_mcu7t3v3__inv_2_1481/VNW VSUBS gf180mcu_as_sc_mcu7t3v3__inv_2
Xgf180mcu_as_sc_mcu7t3v3__inv_2_1400 gf180mcu_as_sc_mcu7t3v3__inv_2_1400/VDD gf180mcu_as_sc_mcu7t3v3__inv_2_1400/VSS
+ gf180mcu_as_sc_mcu7t3v3__inv_2_1685/Y VSS gf180mcu_as_sc_mcu7t3v3__inv_2_1400/VNW
+ VSUBS gf180mcu_as_sc_mcu7t3v3__inv_2
Xgf180mcu_as_sc_mcu7t3v3__inv_2_1466 gf180mcu_as_sc_mcu7t3v3__inv_2_1468/VDD VSS VSS
+ VSS gf180mcu_as_sc_mcu7t3v3__inv_2_1468/VNW VSUBS gf180mcu_as_sc_mcu7t3v3__inv_2
Xgf180mcu_as_sc_mcu7t3v3__inv_2_1488 VSS gf180mcu_as_sc_mcu7t3v3__inv_2_1492/VDD gf180mcu_as_sc_mcu7t3v3__inv_2_1488/Y
+ VSS gf180mcu_as_sc_mcu7t3v3__inv_2_1488/VNW VSUBS gf180mcu_as_sc_mcu7t3v3__inv_2
Xgf180mcu_as_sc_mcu7t3v3__inv_2_1444 gf180mcu_as_sc_mcu7t3v3__inv_2_1444/VDD VSS gf180mcu_as_sc_mcu7t3v3__inv_2_1444/Y
+ VSS gf180mcu_as_sc_mcu7t3v3__inv_2_1444/VNW VSUBS gf180mcu_as_sc_mcu7t3v3__inv_2
Xgf180mcu_as_sc_mcu7t3v3__inv_2_1422 VSS gf180mcu_as_sc_mcu7t3v3__inv_2_1428/VDD VSS
+ VSS gf180mcu_as_sc_mcu7t3v3__inv_2_1424/VNW VSUBS gf180mcu_as_sc_mcu7t3v3__inv_2
Xgf180mcu_as_sc_mcu7t3v3__inv_2_1411 VSS gf180mcu_as_sc_mcu7t3v3__inv_2_1416/VDD gf180mcu_as_sc_mcu7t3v3__inv_2_1411/Y
+ VSS gf180mcu_as_sc_mcu7t3v3__inv_2_1412/VNW VSUBS gf180mcu_as_sc_mcu7t3v3__inv_2
Xgf180mcu_as_sc_mcu7t3v3__inv_2_1433 VSS gf180mcu_as_sc_mcu7t3v3__inv_2_1433/VSS gf180mcu_as_sc_mcu7t3v3__inv_2_1433/Y
+ VSS gf180mcu_as_sc_mcu7t3v3__inv_2_1433/VNW VSUBS gf180mcu_as_sc_mcu7t3v3__inv_2
Xgf180mcu_as_sc_mcu7t3v3__inv_2_1455 gf180mcu_as_sc_mcu7t3v3__inv_2_1457/VDD VSS VSS
+ VSS gf180mcu_as_sc_mcu7t3v3__inv_2_1457/VNW VSUBS gf180mcu_as_sc_mcu7t3v3__inv_2
Xgf180mcu_as_sc_mcu7t3v3__inv_2_1499 VSS gf180mcu_as_sc_mcu7t3v3__inv_2_1499/VSS VSS
+ VSS gf180mcu_as_sc_mcu7t3v3__inv_2_1499/VNW VSUBS gf180mcu_as_sc_mcu7t3v3__inv_2
Xgf180mcu_as_sc_mcu7t3v3__inv_2_928 VSS VSS gf180mcu_as_sc_mcu7t3v3__inv_2_928/Y VSS
+ gf180mcu_as_sc_mcu7t3v3__inv_2_928/VNW VSUBS gf180mcu_as_sc_mcu7t3v3__inv_2
Xgf180mcu_as_sc_mcu7t3v3__inv_2_939 VSS VSS VSS VSS gf180mcu_as_sc_mcu7t3v3__inv_2_940/VNW
+ VSUBS gf180mcu_as_sc_mcu7t3v3__inv_2
Xgf180mcu_as_sc_mcu7t3v3__inv_2_906 VSS VSS VSS VSS gf180mcu_as_sc_mcu7t3v3__inv_2_914/VNW
+ VSUBS gf180mcu_as_sc_mcu7t3v3__inv_2
Xgf180mcu_as_sc_mcu7t3v3__inv_2_917 VSS VSS gf180mcu_as_sc_mcu7t3v3__inv_2_917/Y VSS
+ gf180mcu_as_sc_mcu7t3v3__inv_2_917/VNW VSUBS gf180mcu_as_sc_mcu7t3v3__inv_2
Xu_t003_029 u_t003_029/c0_w0_bl u_t003_029/c0_w0_br u_t003_029/c0_w1_bl u_t003_029/c0_w1_br
+ u_t003_029/c0_r0_rbl u_t003_029/c0_r1_rbl u_t003_029/c1_w0_bl u_t003_029/c1_w0_br
+ u_t003_029/c1_w1_bl u_t003_029/c1_w1_br u_t003_029/c1_r0_rbl u_t003_029/c1_r1_rbl
+ u_t003_029/c2_w0_bl u_t003_029/c2_w0_br u_t003_029/c2_w1_bl u_t003_029/c2_w1_br
+ u_t003_029/c2_r0_rbl u_t003_029/c2_r1_rbl u_t003_029/c3_w0_bl u_t003_029/c3_w0_br
+ u_t003_029/c3_w1_bl u_t003_029/c3_w1_br u_t003_029/c3_r0_rbl u_t003_029/c3_r1_rbl
+ u_t003_029/r0_w0_wl u_t003_029/r0_w1_wl u_t003_029/r0_r0_rwl u_t003_029/r0_r1_rwl
+ u_t003_029/r1_w0_wl u_t003_029/r1_w1_wl u_t003_029/r1_r0_rwl u_t003_029/r1_r1_rwl
+ u_t003_029/r2_w0_wl u_t003_029/r2_w1_wl u_t003_029/r2_r0_rwl u_t003_029/r2_r1_rwl
+ u_t003_029/r3_w0_wl u_t003_029/r3_w1_wl u_t003_029/r3_r0_rwl u_t003_029/r3_r1_rwl
+ u_t004_029/VDD u_t003_031/VSS VSUBS detronyx_12t_2w2r_rc4_4x4_routed_5layer_direct
Xu_t003_018 u_t003_018/c0_w0_bl u_t003_018/c0_w0_br u_t003_018/c0_w1_bl u_t003_018/c0_w1_br
+ u_t003_018/c0_r0_rbl u_t003_018/c0_r1_rbl u_t003_018/c1_w0_bl u_t003_018/c1_w0_br
+ u_t003_018/c1_w1_bl u_t003_018/c1_w1_br u_t003_018/c1_r0_rbl u_t003_018/c1_r1_rbl
+ u_t003_018/c2_w0_bl u_t003_018/c2_w0_br u_t003_018/c2_w1_bl u_t003_018/c2_w1_br
+ u_t003_018/c2_r0_rbl u_t003_018/c2_r1_rbl u_t003_018/c3_w0_bl u_t003_018/c3_w0_br
+ u_t003_018/c3_w1_bl u_t003_018/c3_w1_br u_t003_018/c3_r0_rbl u_t003_018/c3_r1_rbl
+ u_t003_018/r0_w0_wl u_t003_018/r0_w1_wl u_t003_018/r0_r0_rwl u_t003_018/r0_r1_rwl
+ u_t003_018/r1_w0_wl u_t003_018/r1_w1_wl u_t003_018/r1_r0_rwl u_t003_018/r1_r1_rwl
+ u_t003_018/r2_w0_wl u_t003_018/r2_w1_wl u_t003_018/r2_r0_rwl u_t003_018/r2_r1_rwl
+ u_t003_018/r3_w0_wl u_t003_018/r3_w1_wl u_t003_018/r3_r0_rwl u_t003_018/r3_r1_rwl
+ u_t004_018/VDD u_t003_018/VSS VSUBS detronyx_12t_2w2r_rc4_4x4_routed_5layer_direct
Xu_t003_007 u_t003_007/c0_w0_bl u_t003_007/c0_w0_br u_t003_007/c0_w1_bl u_t003_007/c0_w1_br
+ u_t003_007/c0_r0_rbl u_t003_007/c0_r1_rbl u_t003_007/c1_w0_bl u_t003_007/c1_w0_br
+ u_t003_007/c1_w1_bl u_t003_007/c1_w1_br u_t003_007/c1_r0_rbl u_t003_007/c1_r1_rbl
+ u_t003_007/c2_w0_bl u_t003_007/c2_w0_br u_t003_007/c2_w1_bl u_t003_007/c2_w1_br
+ u_t003_007/c2_r0_rbl u_t003_007/c2_r1_rbl u_t003_007/c3_w0_bl u_t003_007/c3_w0_br
+ u_t003_007/c3_w1_bl u_t003_007/c3_w1_br u_t003_007/c3_r0_rbl u_t003_007/c3_r1_rbl
+ u_t003_007/r0_w0_wl u_t003_007/r0_w1_wl u_t003_007/r0_r0_rwl u_t003_007/r0_r1_rwl
+ u_t003_007/r1_w0_wl u_t003_007/r1_w1_wl u_t003_007/r1_r0_rwl u_t003_007/r1_r1_rwl
+ u_t003_007/r2_w0_wl u_t003_007/r2_w1_wl u_t003_007/r2_r0_rwl u_t003_007/r2_r1_rwl
+ u_t003_007/r3_w0_wl u_t003_007/r3_w1_wl u_t003_007/r3_r0_rwl u_t003_007/r3_r1_rwl
+ VSS u_t003_009/VSS VSUBS detronyx_12t_2w2r_rc4_4x4_routed_5layer_direct
Xgf180mcu_as_sc_mcu7t3v3__nand4_2_249 VSS VSS VSS VSS VSS VSS VSS gf180mcu_as_sc_mcu7t3v3__inv_2_852/VNW
+ VSUBS gf180mcu_as_sc_mcu7t3v3__nand4_2
Xgf180mcu_as_sc_mcu7t3v3__nand4_2_216 VSS VSS VSS VSS VSS VSS gf180mcu_as_sc_mcu7t3v3__nand4_2_216/Y
+ gf180mcu_as_sc_mcu7t3v3__inv_2_756/VNW VSUBS gf180mcu_as_sc_mcu7t3v3__nand4_2
Xgf180mcu_as_sc_mcu7t3v3__nand4_2_227 VSS VSS VSS VSS VSS VSS gf180mcu_as_sc_mcu7t3v3__nand4_2_227/Y
+ gf180mcu_as_sc_mcu7t3v3__inv_2_749/VNW VSUBS gf180mcu_as_sc_mcu7t3v3__nand4_2
Xgf180mcu_as_sc_mcu7t3v3__nand4_2_205 gf180mcu_as_sc_mcu7t3v3__inv_2_651/VDD VSS VSS
+ VSS VSS VSS VSS gf180mcu_as_sc_mcu7t3v3__inv_2_651/VNW VSUBS gf180mcu_as_sc_mcu7t3v3__nand4_2
Xgf180mcu_as_sc_mcu7t3v3__nand4_2_238 VSS VSS VSS VSS VSS VSS gf180mcu_as_sc_mcu7t3v3__nand4_2_238/Y
+ gf180mcu_as_sc_mcu7t3v3__inv_2_843/VNW VSUBS gf180mcu_as_sc_mcu7t3v3__nand4_2
Xgf180mcu_as_sc_mcu7t3v3__inv_2_1263 gf180mcu_as_sc_mcu7t3v3__nor2_2_8/VDD gf180mcu_as_sc_mcu7t3v3__nor2_2_8/VSS
+ VSS VSS gf180mcu_as_sc_mcu7t3v3__nor2_2_8/VNW VSUBS gf180mcu_as_sc_mcu7t3v3__inv_2
Xgf180mcu_as_sc_mcu7t3v3__inv_2_1252 gf180mcu_as_sc_mcu7t3v3__nand3_2_31/VDD gf180mcu_as_sc_mcu7t3v3__nor2_2_8/VSS
+ VSS VSS gf180mcu_as_sc_mcu7t3v3__nand3_2_31/VNW VSUBS gf180mcu_as_sc_mcu7t3v3__inv_2
Xgf180mcu_as_sc_mcu7t3v3__inv_2_1274 VSS VSS VSS VSS gf180mcu_as_sc_mcu7t3v3__inv_2_1282/VNW
+ VSUBS gf180mcu_as_sc_mcu7t3v3__inv_2
Xgf180mcu_as_sc_mcu7t3v3__inv_2_1285 VSS VSS VSS VSS gf180mcu_as_sc_mcu7t3v3__inv_2_1285/VNW
+ VSUBS gf180mcu_as_sc_mcu7t3v3__inv_2
Xgf180mcu_as_sc_mcu7t3v3__inv_2_1230 VSS VSS gf180mcu_as_sc_mcu7t3v3__inv_2_1230/Y
+ VSS gf180mcu_as_sc_mcu7t3v3__inv_2_1247/VNW VSUBS gf180mcu_as_sc_mcu7t3v3__inv_2
Xgf180mcu_as_sc_mcu7t3v3__inv_2_1241 VSS VSS VSS VSS gf180mcu_as_sc_mcu7t3v3__inv_2_1241/VNW
+ VSUBS gf180mcu_as_sc_mcu7t3v3__inv_2
Xgf180mcu_as_sc_mcu7t3v3__inv_2_1296 VSS VSS VSS VSS gf180mcu_as_sc_mcu7t3v3__inv_2_1298/VNW
+ VSUBS gf180mcu_as_sc_mcu7t3v3__inv_2
Xgf180mcu_as_sc_mcu7t3v3__inv_2_758 VSS VSS gf180mcu_as_sc_mcu7t3v3__inv_2_758/Y VSS
+ gf180mcu_as_sc_mcu7t3v3__inv_2_760/VNW VSUBS gf180mcu_as_sc_mcu7t3v3__inv_2
Xgf180mcu_as_sc_mcu7t3v3__inv_2_769 VSS VSS gf180mcu_as_sc_mcu7t3v3__inv_2_769/Y VSS
+ gf180mcu_as_sc_mcu7t3v3__inv_2_785/VNW VSUBS gf180mcu_as_sc_mcu7t3v3__inv_2
Xgf180mcu_as_sc_mcu7t3v3__inv_2_747 VSS VSS gf180mcu_as_sc_mcu7t3v3__inv_2_747/Y VSS
+ gf180mcu_as_sc_mcu7t3v3__inv_2_749/VNW VSUBS gf180mcu_as_sc_mcu7t3v3__inv_2
Xgf180mcu_as_sc_mcu7t3v3__inv_2_725 VSS gf180mcu_as_sc_mcu7t3v3__inv_2_727/VSS gf180mcu_as_sc_mcu7t3v3__inv_2_725/Y
+ gf180mcu_as_sc_mcu7t3v3__inv_2_732/Y gf180mcu_as_sc_mcu7t3v3__inv_2_727/VNW VSUBS
+ gf180mcu_as_sc_mcu7t3v3__inv_2
Xgf180mcu_as_sc_mcu7t3v3__inv_2_714 VSS gf180mcu_as_sc_mcu7t3v3__inv_2_719/VDD gf180mcu_as_sc_mcu7t3v3__inv_2_714/Y
+ gf180mcu_as_sc_mcu7t3v3__inv_2_715/Y gf180mcu_as_sc_mcu7t3v3__inv_2_715/VNW VSUBS
+ gf180mcu_as_sc_mcu7t3v3__inv_2
Xgf180mcu_as_sc_mcu7t3v3__inv_2_703 gf180mcu_as_sc_mcu7t3v3__inv_2_724/VSS gf180mcu_as_sc_mcu7t3v3__inv_2_711/VDD
+ gf180mcu_as_sc_mcu7t3v3__inv_2_703/Y VSS gf180mcu_as_sc_mcu7t3v3__inv_2_703/VNW
+ VSUBS gf180mcu_as_sc_mcu7t3v3__inv_2
Xgf180mcu_as_sc_mcu7t3v3__inv_2_736 VSS VSS gf180mcu_as_sc_mcu7t3v3__inv_2_736/Y VSS
+ gf180mcu_as_sc_mcu7t3v3__inv_2_736/VNW VSUBS gf180mcu_as_sc_mcu7t3v3__inv_2
Xgf180mcu_as_sc_mcu7t3v3__inv_2_1060 VSS gf180mcu_as_sc_mcu7t3v3__inv_2_1064/VDD gf180mcu_as_sc_mcu7t3v3__inv_2_1060/Y
+ VSS gf180mcu_as_sc_mcu7t3v3__inv_2_1060/VNW VSUBS gf180mcu_as_sc_mcu7t3v3__inv_2
Xgf180mcu_as_sc_mcu7t3v3__inv_2_1071 gf180mcu_as_sc_mcu7t3v3__inv_2_1072/VDD VSS gf180mcu_as_sc_mcu7t3v3__inv_2_1144/A
+ gf180mcu_as_sc_mcu7t3v3__inv_2_1072/Y gf180mcu_as_sc_mcu7t3v3__inv_2_1072/VNW VSUBS
+ gf180mcu_as_sc_mcu7t3v3__inv_2
Xgf180mcu_as_sc_mcu7t3v3__inv_2_90 gf180mcu_as_sc_mcu7t3v3__inv_2_91/VDD gf180mcu_as_sc_mcu7t3v3__inv_2_95/VDD
+ gf180mcu_as_sc_mcu7t3v3__inv_2_90/Y VSS gf180mcu_as_sc_mcu7t3v3__inv_2_91/VNW VSUBS
+ gf180mcu_as_sc_mcu7t3v3__inv_2
Xgf180mcu_as_sc_mcu7t3v3__inv_2_1093 gf180mcu_as_sc_mcu7t3v3__inv_2_1105/VSS VSS gf180mcu_as_sc_mcu7t3v3__inv_2_1144/A
+ gf180mcu_as_sc_mcu7t3v3__inv_2_1093/A gf180mcu_as_sc_mcu7t3v3__inv_2_1093/VNW VSUBS
+ gf180mcu_as_sc_mcu7t3v3__inv_2
Xgf180mcu_as_sc_mcu7t3v3__inv_2_1082 gf180mcu_as_sc_mcu7t3v3__inv_2_1084/VDD VSS VSS
+ gf180mcu_as_sc_mcu7t3v3__inv_2_1144/A gf180mcu_as_sc_mcu7t3v3__inv_2_1084/VNW VSUBS
+ gf180mcu_as_sc_mcu7t3v3__inv_2
Xgf180mcu_as_sc_mcu7t3v3__nand4_2_5 gf180mcu_as_sc_mcu7t3v3__inv_2_2/VDD gf180mcu_as_sc_mcu7t3v3__inv_2_9/VSS
+ VSS VSS VSS VSS VSS gf180mcu_as_sc_mcu7t3v3__inv_2_2/VNW VSUBS gf180mcu_as_sc_mcu7t3v3__nand4_2
Xgf180mcu_as_sc_mcu7t3v3__inv_2_500 VSS VSS gf180mcu_as_sc_mcu7t3v3__inv_2_500/Y VSS
+ gf180mcu_as_sc_mcu7t3v3__inv_2_502/VNW VSUBS gf180mcu_as_sc_mcu7t3v3__inv_2
Xgf180mcu_as_sc_mcu7t3v3__inv_2_511 VSS VSS gf180mcu_as_sc_mcu7t3v3__inv_2_511/Y VSS
+ gf180mcu_as_sc_mcu7t3v3__inv_2_511/VNW VSUBS gf180mcu_as_sc_mcu7t3v3__inv_2
Xgf180mcu_as_sc_mcu7t3v3__inv_2_566 gf180mcu_as_sc_mcu7t3v3__inv_2_585/VDD gf180mcu_as_sc_mcu7t3v3__inv_2_585/VSS
+ gf180mcu_as_sc_mcu7t3v3__inv_2_566/Y VSS gf180mcu_as_sc_mcu7t3v3__inv_2_585/VNW
+ VSUBS gf180mcu_as_sc_mcu7t3v3__inv_2
Xgf180mcu_as_sc_mcu7t3v3__inv_2_577 gf180mcu_as_sc_mcu7t3v3__inv_2_585/VSS VSS VSS
+ gf180mcu_as_sc_mcu7t3v3__inv_2_581/Y gf180mcu_as_sc_mcu7t3v3__inv_2_581/VNW VSUBS
+ gf180mcu_as_sc_mcu7t3v3__inv_2
Xgf180mcu_as_sc_mcu7t3v3__inv_2_555 gf180mcu_as_sc_mcu7t3v3__nor2_2_4/VDD gf180mcu_as_sc_mcu7t3v3__nor2_2_4/VSS
+ VSS VSS gf180mcu_as_sc_mcu7t3v3__nor2_2_4/VNW VSUBS gf180mcu_as_sc_mcu7t3v3__inv_2
Xgf180mcu_as_sc_mcu7t3v3__inv_2_599 gf180mcu_as_sc_mcu7t3v3__inv_2_601/VDD VSS gf180mcu_as_sc_mcu7t3v3__inv_2_599/Y
+ gf180mcu_as_sc_mcu7t3v3__inv_2_631/A gf180mcu_as_sc_mcu7t3v3__inv_2_601/VNW VSUBS
+ gf180mcu_as_sc_mcu7t3v3__inv_2
Xgf180mcu_as_sc_mcu7t3v3__inv_2_588 gf180mcu_as_sc_mcu7t3v3__inv_2_633/VSS VSS gf180mcu_as_sc_mcu7t3v3__inv_2_631/A
+ gf180mcu_as_sc_mcu7t3v3__inv_2_589/Y gf180mcu_as_sc_mcu7t3v3__inv_2_589/VNW VSUBS
+ gf180mcu_as_sc_mcu7t3v3__inv_2
Xgf180mcu_as_sc_mcu7t3v3__inv_2_544 VSS VSS gf180mcu_as_sc_mcu7t3v3__inv_2_544/Y VSS
+ gf180mcu_as_sc_mcu7t3v3__inv_2_546/VNW VSUBS gf180mcu_as_sc_mcu7t3v3__inv_2
Xgf180mcu_as_sc_mcu7t3v3__inv_2_533 VSS VSS VSS VSS gf180mcu_as_sc_mcu7t3v3__inv_2_534/VNW
+ VSUBS gf180mcu_as_sc_mcu7t3v3__inv_2
Xgf180mcu_as_sc_mcu7t3v3__inv_2_522 VSS VSS gf180mcu_as_sc_mcu7t3v3__inv_2_522/Y VSS
+ gf180mcu_as_sc_mcu7t3v3__inv_2_522/VNW VSUBS gf180mcu_as_sc_mcu7t3v3__inv_2
Xgf180mcu_as_sc_mcu7t3v3__inv_2_352 VSS gf180mcu_as_sc_mcu7t3v3__inv_2_353/VDD gf180mcu_as_sc_mcu7t3v3__inv_2_66/Y
+ VSS gf180mcu_as_sc_mcu7t3v3__inv_2_352/VNW VSUBS gf180mcu_as_sc_mcu7t3v3__inv_2
Xgf180mcu_as_sc_mcu7t3v3__inv_2_341 gf180mcu_as_sc_mcu7t3v3__inv_2_341/VDD VSS gf180mcu_as_sc_mcu7t3v3__inv_2_341/Y
+ VSS gf180mcu_as_sc_mcu7t3v3__inv_2_341/VNW VSUBS gf180mcu_as_sc_mcu7t3v3__inv_2
Xgf180mcu_as_sc_mcu7t3v3__inv_2_330 VSS gf180mcu_as_sc_mcu7t3v3__inv_2_331/VDD gf180mcu_as_sc_mcu7t3v3__inv_2_338/Y
+ VSS gf180mcu_as_sc_mcu7t3v3__inv_2_330/VNW VSUBS gf180mcu_as_sc_mcu7t3v3__inv_2
Xgf180mcu_as_sc_mcu7t3v3__inv_2_396 VSS VSS gf180mcu_as_sc_mcu7t3v3__inv_2_396/Y VSS
+ gf180mcu_as_sc_mcu7t3v3__inv_2_398/VNW VSUBS gf180mcu_as_sc_mcu7t3v3__inv_2
Xgf180mcu_as_sc_mcu7t3v3__inv_2_385 gf180mcu_as_sc_mcu7t3v3__nor2_2_6/VDD gf180mcu_as_sc_mcu7t3v3__nor2_2_6/VSS
+ VSS VSS gf180mcu_as_sc_mcu7t3v3__nor2_2_6/VNW VSUBS gf180mcu_as_sc_mcu7t3v3__inv_2
Xgf180mcu_as_sc_mcu7t3v3__inv_2_374 gf180mcu_as_sc_mcu7t3v3__nand3_2_5/VDD gf180mcu_as_sc_mcu7t3v3__nor2_2_4/VSS
+ VSS VSS gf180mcu_as_sc_mcu7t3v3__nand3_2_5/VNW VSUBS gf180mcu_as_sc_mcu7t3v3__inv_2
Xgf180mcu_as_sc_mcu7t3v3__inv_2_363 gf180mcu_as_sc_mcu7t3v3__inv_2_363/VDD gf180mcu_as_sc_mcu7t3v3__inv_2_364/VDD
+ gf180mcu_as_sc_mcu7t3v3__inv_2_364/Y VSS gf180mcu_as_sc_mcu7t3v3__inv_2_363/VNW
+ VSUBS gf180mcu_as_sc_mcu7t3v3__inv_2
Xu_t027_024 u_t027_024/c0_w0_bl u_t027_024/c0_w0_br u_t027_024/c0_w1_bl u_t027_024/c0_w1_br
+ u_t027_024/c0_r0_rbl u_t027_024/c0_r1_rbl u_t027_024/c1_w0_bl u_t027_024/c1_w0_br
+ u_t027_024/c1_w1_bl u_t027_024/c1_w1_br u_t027_024/c1_r0_rbl u_t027_024/c1_r1_rbl
+ u_t027_024/c2_w0_bl u_t027_024/c2_w0_br u_t027_024/c2_w1_bl u_t027_024/c2_w1_br
+ u_t027_024/c2_r0_rbl u_t027_024/c2_r1_rbl u_t027_024/c3_w0_bl u_t027_024/c3_w0_br
+ u_t027_024/c3_w1_bl u_t027_024/c3_w1_br u_t027_024/c3_r0_rbl u_t027_024/c3_r1_rbl
+ u_t027_024/r0_w0_wl u_t027_024/r0_w1_wl u_t027_024/r0_r0_rwl u_t027_024/r0_r1_rwl
+ u_t027_024/r1_w0_wl u_t027_024/r1_w1_wl u_t027_024/r1_r0_rwl u_t027_024/r1_r1_rwl
+ u_t027_024/r2_w0_wl u_t027_024/r2_w1_wl u_t027_024/r2_r0_rwl u_t027_024/r2_r1_rwl
+ u_t027_024/r3_w0_wl u_t027_024/r3_w1_wl u_t027_024/r3_r0_rwl u_t027_024/r3_r1_rwl
+ VSS u_t027_024/VSS VSUBS detronyx_12t_2w2r_rc4_4x4_routed_5layer_direct
Xu_t027_013 u_t027_013/c0_w0_bl u_t027_013/c0_w0_br u_t027_013/c0_w1_bl u_t027_013/c0_w1_br
+ u_t027_013/c0_r0_rbl u_t027_013/c0_r1_rbl u_t027_013/c1_w0_bl u_t027_013/c1_w0_br
+ u_t027_013/c1_w1_bl u_t027_013/c1_w1_br u_t027_013/c1_r0_rbl u_t027_013/c1_r1_rbl
+ u_t027_013/c2_w0_bl u_t027_013/c2_w0_br u_t027_013/c2_w1_bl u_t027_013/c2_w1_br
+ u_t027_013/c2_r0_rbl u_t027_013/c2_r1_rbl u_t027_013/c3_w0_bl u_t027_013/c3_w0_br
+ u_t027_013/c3_w1_bl u_t027_013/c3_w1_br u_t027_013/c3_r0_rbl u_t027_013/c3_r1_rbl
+ u_t027_013/r0_w0_wl u_t027_013/r0_w1_wl u_t027_013/r0_r0_rwl u_t027_013/r0_r1_rwl
+ u_t027_013/r1_w0_wl u_t027_013/r1_w1_wl u_t027_013/r1_r0_rwl u_t027_013/r1_r1_rwl
+ u_t027_013/r2_w0_wl u_t027_013/r2_w1_wl u_t027_013/r2_r0_rwl u_t027_013/r2_r1_rwl
+ u_t027_013/r3_w0_wl u_t027_013/r3_w1_wl u_t027_013/r3_r0_rwl u_t027_013/r3_r1_rwl
+ u_t027_013/VDD u_t027_013/VSS VSUBS detronyx_12t_2w2r_rc4_4x4_routed_5layer_direct
Xu_t027_002 u_t027_002/c0_w0_bl u_t027_002/c0_w0_br u_t027_002/c0_w1_bl u_t027_002/c0_w1_br
+ u_t027_002/c0_r0_rbl u_t027_002/c0_r1_rbl u_t027_002/c1_w0_bl u_t027_002/c1_w0_br
+ u_t027_002/c1_w1_bl u_t027_002/c1_w1_br u_t027_002/c1_r0_rbl u_t027_002/c1_r1_rbl
+ u_t027_002/c2_w0_bl u_t027_002/c2_w0_br u_t027_002/c2_w1_bl u_t027_002/c2_w1_br
+ u_t027_002/c2_r0_rbl u_t027_002/c2_r1_rbl u_t027_002/c3_w0_bl u_t027_002/c3_w0_br
+ u_t027_002/c3_w1_bl u_t027_002/c3_w1_br u_t027_002/c3_r0_rbl u_t027_002/c3_r1_rbl
+ u_t027_002/r0_w0_wl u_t027_002/r0_w1_wl u_t027_002/r0_r0_rwl u_t027_002/r0_r1_rwl
+ u_t027_002/r1_w0_wl u_t027_002/r1_w1_wl u_t027_002/r1_r0_rwl u_t027_002/r1_r1_rwl
+ u_t027_002/r2_w0_wl u_t027_002/r2_w1_wl u_t027_002/r2_r0_rwl u_t027_002/r2_r1_rwl
+ u_t027_002/r3_w0_wl u_t027_002/r3_w1_wl u_t027_002/r3_r0_rwl u_t027_002/r3_r1_rwl
+ VSS u_t027_002/VSS VSUBS detronyx_12t_2w2r_rc4_4x4_routed_5layer_direct
Xu_t018_024 u_t018_024/c0_w0_bl u_t018_024/c0_w0_br u_t018_024/c0_w1_bl u_t018_024/c0_w1_br
+ u_t018_024/c0_r0_rbl u_t018_024/c0_r1_rbl u_t018_024/c1_w0_bl u_t018_024/c1_w0_br
+ u_t018_024/c1_w1_bl u_t018_024/c1_w1_br u_t018_024/c1_r0_rbl u_t018_024/c1_r1_rbl
+ u_t018_024/c2_w0_bl u_t018_024/c2_w0_br u_t018_024/c2_w1_bl u_t018_024/c2_w1_br
+ u_t018_024/c2_r0_rbl u_t018_024/c2_r1_rbl u_t018_024/c3_w0_bl u_t018_024/c3_w0_br
+ u_t018_024/c3_w1_bl u_t018_024/c3_w1_br u_t018_024/c3_r0_rbl u_t018_024/c3_r1_rbl
+ u_t018_024/r0_w0_wl u_t018_024/r0_w1_wl u_t018_024/r0_r0_rwl u_t018_024/r0_r1_rwl
+ u_t018_024/r1_w0_wl u_t018_024/r1_w1_wl u_t018_024/r1_r0_rwl u_t018_024/r1_r1_rwl
+ u_t018_024/r2_w0_wl u_t018_024/r2_w1_wl u_t018_024/r2_r0_rwl u_t018_024/r2_r1_rwl
+ u_t018_024/r3_w0_wl u_t018_024/r3_w1_wl u_t018_024/r3_r0_rwl u_t018_024/r3_r1_rwl
+ VSS u_t018_024/VSS VSUBS detronyx_12t_2w2r_rc4_4x4_routed_5layer_direct
Xu_t018_013 u_t018_013/c0_w0_bl u_t018_013/c0_w0_br u_t018_013/c0_w1_bl u_t018_013/c0_w1_br
+ u_t018_013/c0_r0_rbl u_t018_013/c0_r1_rbl u_t018_013/c1_w0_bl u_t018_013/c1_w0_br
+ u_t018_013/c1_w1_bl u_t018_013/c1_w1_br u_t018_013/c1_r0_rbl u_t018_013/c1_r1_rbl
+ u_t018_013/c2_w0_bl u_t018_013/c2_w0_br u_t018_013/c2_w1_bl u_t018_013/c2_w1_br
+ u_t018_013/c2_r0_rbl u_t018_013/c2_r1_rbl u_t018_013/c3_w0_bl u_t018_013/c3_w0_br
+ u_t018_013/c3_w1_bl u_t018_013/c3_w1_br u_t018_013/c3_r0_rbl u_t018_013/c3_r1_rbl
+ u_t018_013/r0_w0_wl u_t018_013/r0_w1_wl u_t018_013/r0_r0_rwl u_t018_013/r0_r1_rwl
+ u_t018_013/r1_w0_wl u_t018_013/r1_w1_wl u_t018_013/r1_r0_rwl u_t018_013/r1_r1_rwl
+ u_t018_013/r2_w0_wl u_t018_013/r2_w1_wl u_t018_013/r2_r0_rwl u_t018_013/r2_r1_rwl
+ u_t018_013/r3_w0_wl u_t018_013/r3_w1_wl u_t018_013/r3_r0_rwl u_t018_013/r3_r1_rwl
+ u_t018_013/VDD u_t018_013/VSS VSUBS detronyx_12t_2w2r_rc4_4x4_routed_5layer_direct
Xu_t018_002 u_t018_002/c0_w0_bl u_t018_002/c0_w0_br u_t018_002/c0_w1_bl u_t018_002/c0_w1_br
+ u_t018_002/c0_r0_rbl u_t018_002/c0_r1_rbl u_t018_002/c1_w0_bl u_t018_002/c1_w0_br
+ u_t018_002/c1_w1_bl u_t018_002/c1_w1_br u_t018_002/c1_r0_rbl u_t018_002/c1_r1_rbl
+ u_t018_002/c2_w0_bl u_t018_002/c2_w0_br u_t018_002/c2_w1_bl u_t018_002/c2_w1_br
+ u_t018_002/c2_r0_rbl u_t018_002/c2_r1_rbl u_t018_002/c3_w0_bl u_t018_002/c3_w0_br
+ u_t018_002/c3_w1_bl u_t018_002/c3_w1_br u_t018_002/c3_r0_rbl u_t018_002/c3_r1_rbl
+ u_t018_002/r0_w0_wl u_t018_002/r0_w1_wl u_t018_002/r0_r0_rwl u_t018_002/r0_r1_rwl
+ u_t018_002/r1_w0_wl u_t018_002/r1_w1_wl u_t018_002/r1_r0_rwl u_t018_002/r1_r1_rwl
+ u_t018_002/r2_w0_wl u_t018_002/r2_w1_wl u_t018_002/r2_r0_rwl u_t018_002/r2_r1_rwl
+ u_t018_002/r3_w0_wl u_t018_002/r3_w1_wl u_t018_002/r3_r0_rwl u_t018_002/r3_r1_rwl
+ VSS u_t018_002/VSS VSUBS detronyx_12t_2w2r_rc4_4x4_routed_5layer_direct
Xu_t009_024 u_t009_024/c0_w0_bl u_t009_024/c0_w0_br u_t009_024/c0_w1_bl u_t009_024/c0_w1_br
+ u_t009_024/c0_r0_rbl u_t009_024/c0_r1_rbl u_t009_024/c1_w0_bl u_t009_024/c1_w0_br
+ u_t009_024/c1_w1_bl u_t009_024/c1_w1_br u_t009_024/c1_r0_rbl u_t009_024/c1_r1_rbl
+ u_t009_024/c2_w0_bl u_t009_024/c2_w0_br u_t009_024/c2_w1_bl u_t009_024/c2_w1_br
+ u_t009_024/c2_r0_rbl u_t009_024/c2_r1_rbl u_t009_024/c3_w0_bl u_t009_024/c3_w0_br
+ u_t009_024/c3_w1_bl u_t009_024/c3_w1_br u_t009_024/c3_r0_rbl u_t009_024/c3_r1_rbl
+ u_t009_024/r0_w0_wl u_t009_024/r0_w1_wl u_t009_024/r0_r0_rwl u_t009_024/r0_r1_rwl
+ u_t009_024/r1_w0_wl u_t009_024/r1_w1_wl u_t009_024/r1_r0_rwl u_t009_024/r1_r1_rwl
+ u_t009_024/r2_w0_wl u_t009_024/r2_w1_wl u_t009_024/r2_r0_rwl u_t009_024/r2_r1_rwl
+ u_t009_024/r3_w0_wl u_t009_024/r3_w1_wl u_t009_024/r3_r0_rwl u_t009_024/r3_r1_rwl
+ VSS u_t009_031/VSS VSUBS detronyx_12t_2w2r_rc4_4x4_routed_5layer_direct
Xu_t009_013 u_t009_013/c0_w0_bl u_t009_013/c0_w0_br u_t009_013/c0_w1_bl u_t009_013/c0_w1_br
+ u_t009_013/c0_r0_rbl u_t009_013/c0_r1_rbl u_t009_013/c1_w0_bl u_t009_013/c1_w0_br
+ u_t009_013/c1_w1_bl u_t009_013/c1_w1_br u_t009_013/c1_r0_rbl u_t009_013/c1_r1_rbl
+ u_t009_013/c2_w0_bl u_t009_013/c2_w0_br u_t009_013/c2_w1_bl u_t009_013/c2_w1_br
+ u_t009_013/c2_r0_rbl u_t009_013/c2_r1_rbl u_t009_013/c3_w0_bl u_t009_013/c3_w0_br
+ u_t009_013/c3_w1_bl u_t009_013/c3_w1_br u_t009_013/c3_r0_rbl u_t009_013/c3_r1_rbl
+ u_t009_013/r0_w0_wl u_t009_013/r0_w1_wl u_t009_013/r0_r0_rwl u_t009_013/r0_r1_rwl
+ u_t009_013/r1_w0_wl u_t009_013/r1_w1_wl u_t009_013/r1_r0_rwl u_t009_013/r1_r1_rwl
+ u_t009_013/r2_w0_wl u_t009_013/r2_w1_wl u_t009_013/r2_r0_rwl u_t009_013/r2_r1_rwl
+ u_t009_013/r3_w0_wl u_t009_013/r3_w1_wl u_t009_013/r3_r0_rwl u_t009_013/r3_r1_rwl
+ u_t009_013/VDD u_t009_031/VSS VSUBS detronyx_12t_2w2r_rc4_4x4_routed_5layer_direct
Xu_t009_002 u_t009_002/c0_w0_bl u_t009_002/c0_w0_br u_t009_002/c0_w1_bl u_t009_002/c0_w1_br
+ u_t009_002/c0_r0_rbl u_t009_002/c0_r1_rbl u_t009_002/c1_w0_bl u_t009_002/c1_w0_br
+ u_t009_002/c1_w1_bl u_t009_002/c1_w1_br u_t009_002/c1_r0_rbl u_t009_002/c1_r1_rbl
+ u_t009_002/c2_w0_bl u_t009_002/c2_w0_br u_t009_002/c2_w1_bl u_t009_002/c2_w1_br
+ u_t009_002/c2_r0_rbl u_t009_002/c2_r1_rbl u_t009_002/c3_w0_bl u_t009_002/c3_w0_br
+ u_t009_002/c3_w1_bl u_t009_002/c3_w1_br u_t009_002/c3_r0_rbl u_t009_002/c3_r1_rbl
+ u_t009_002/r0_w0_wl u_t009_002/r0_w1_wl u_t009_002/r0_r0_rwl u_t009_002/r0_r1_rwl
+ u_t009_002/r1_w0_wl u_t009_002/r1_w1_wl u_t009_002/r1_r0_rwl u_t009_002/r1_r1_rwl
+ u_t009_002/r2_w0_wl u_t009_002/r2_w1_wl u_t009_002/r2_r0_rwl u_t009_002/r2_r1_rwl
+ u_t009_002/r3_w0_wl u_t009_002/r3_w1_wl u_t009_002/r3_r0_rwl u_t009_002/r3_r1_rwl
+ VSS u_t009_031/VSS VSUBS detronyx_12t_2w2r_rc4_4x4_routed_5layer_direct
Xgf180mcu_as_sc_mcu7t3v3__nand3_2_28 gf180mcu_as_sc_mcu7t3v3__nor2_2_8/VDD gf180mcu_as_sc_mcu7t3v3__nand3_2_32/VSS
+ VSS VSS VSS VSS gf180mcu_as_sc_mcu7t3v3__nor2_2_8/VNW VSUBS gf180mcu_as_sc_mcu7t3v3__nand3_2
Xgf180mcu_as_sc_mcu7t3v3__nand3_2_17 gf180mcu_as_sc_mcu7t3v3__nor2_2_4/VDD gf180mcu_as_sc_mcu7t3v3__nor2_2_4/VSS
+ VSS VSS VSS VSS gf180mcu_as_sc_mcu7t3v3__nor2_2_4/VNW VSUBS gf180mcu_as_sc_mcu7t3v3__nand3_2
Xu_t024_027 u_t024_027/c0_w0_bl u_t024_027/c0_w0_br u_t024_027/c0_w1_bl u_t024_027/c0_w1_br
+ u_t024_027/c0_r0_rbl u_t024_027/c0_r1_rbl u_t024_027/c1_w0_bl u_t024_027/c1_w0_br
+ u_t024_027/c1_w1_bl u_t024_027/c1_w1_br u_t024_027/c1_r0_rbl u_t024_027/c1_r1_rbl
+ u_t024_027/c2_w0_bl u_t024_027/c2_w0_br u_t024_027/c2_w1_bl u_t024_027/c2_w1_br
+ u_t024_027/c2_r0_rbl u_t024_027/c2_r1_rbl u_t024_027/c3_w0_bl u_t024_027/c3_w0_br
+ u_t024_027/c3_w1_bl u_t024_027/c3_w1_br u_t024_027/c3_r0_rbl u_t024_027/c3_r1_rbl
+ u_t024_027/r0_w0_wl u_t024_027/r0_w1_wl u_t024_027/r0_r0_rwl u_t024_027/r0_r1_rwl
+ u_t024_027/r1_w0_wl u_t024_027/r1_w1_wl u_t024_027/r1_r0_rwl u_t024_027/r1_r1_rwl
+ u_t024_027/r2_w0_wl u_t024_027/r2_w1_wl u_t024_027/r2_r0_rwl u_t024_027/r2_r1_rwl
+ u_t024_027/r3_w0_wl u_t024_027/r3_w1_wl u_t024_027/r3_r0_rwl u_t024_027/r3_r1_rwl
+ u_t025_027/VDD u_t024_027/VSS VSUBS detronyx_12t_2w2r_rc4_4x4_routed_5layer_direct
Xu_t024_016 u_t024_016/c0_w0_bl u_t024_016/c0_w0_br u_t024_016/c0_w1_bl u_t024_016/c0_w1_br
+ u_t024_016/c0_r0_rbl u_t024_016/c0_r1_rbl u_t024_016/c1_w0_bl u_t024_016/c1_w0_br
+ u_t024_016/c1_w1_bl u_t024_016/c1_w1_br u_t024_016/c1_r0_rbl u_t024_016/c1_r1_rbl
+ u_t024_016/c2_w0_bl u_t024_016/c2_w0_br u_t024_016/c2_w1_bl u_t024_016/c2_w1_br
+ u_t024_016/c2_r0_rbl u_t024_016/c2_r1_rbl u_t024_016/c3_w0_bl u_t024_016/c3_w0_br
+ u_t024_016/c3_w1_bl u_t024_016/c3_w1_br u_t024_016/c3_r0_rbl u_t024_016/c3_r1_rbl
+ u_t024_016/r0_w0_wl u_t024_016/r0_w1_wl u_t024_016/r0_r0_rwl u_t024_016/r0_r1_rwl
+ u_t024_016/r1_w0_wl u_t024_016/r1_w1_wl u_t024_016/r1_r0_rwl u_t024_016/r1_r1_rwl
+ u_t024_016/r2_w0_wl u_t024_016/r2_w1_wl u_t024_016/r2_r0_rwl u_t024_016/r2_r1_rwl
+ u_t024_016/r3_w0_wl u_t024_016/r3_w1_wl u_t024_016/r3_r0_rwl u_t024_016/r3_r1_rwl
+ VSS u_t024_017/VSS VSUBS detronyx_12t_2w2r_rc4_4x4_routed_5layer_direct
Xu_t024_005 u_t024_005/c0_w0_bl u_t024_005/c0_w0_br u_t024_005/c0_w1_bl u_t024_005/c0_w1_br
+ u_t024_005/c0_r0_rbl u_t024_005/c0_r1_rbl u_t024_005/c1_w0_bl u_t024_005/c1_w0_br
+ u_t024_005/c1_w1_bl u_t024_005/c1_w1_br u_t024_005/c1_r0_rbl u_t024_005/c1_r1_rbl
+ u_t024_005/c2_w0_bl u_t024_005/c2_w0_br u_t024_005/c2_w1_bl u_t024_005/c2_w1_br
+ u_t024_005/c2_r0_rbl u_t024_005/c2_r1_rbl u_t024_005/c3_w0_bl u_t024_005/c3_w0_br
+ u_t024_005/c3_w1_bl u_t024_005/c3_w1_br u_t024_005/c3_r0_rbl u_t024_005/c3_r1_rbl
+ u_t024_005/r0_w0_wl u_t024_005/r0_w1_wl u_t024_005/r0_r0_rwl u_t024_005/r0_r1_rwl
+ u_t024_005/r1_w0_wl u_t024_005/r1_w1_wl u_t024_005/r1_r0_rwl u_t024_005/r1_r1_rwl
+ u_t024_005/r2_w0_wl u_t024_005/r2_w1_wl u_t024_005/r2_r0_rwl u_t024_005/r2_r1_rwl
+ u_t024_005/r3_w0_wl u_t024_005/r3_w1_wl u_t024_005/r3_r0_rwl u_t024_005/r3_r1_rwl
+ u_t025_005/VDD u_t024_005/VSS VSUBS detronyx_12t_2w2r_rc4_4x4_routed_5layer_direct
Xgf180mcu_as_sc_mcu7t3v3__inv_2_182 gf180mcu_as_sc_mcu7t3v3__inv_2_184/VDD gf180mcu_as_sc_mcu7t3v3__inv_2_200/VDD
+ VSS VSS gf180mcu_as_sc_mcu7t3v3__inv_2_184/VNW VSUBS gf180mcu_as_sc_mcu7t3v3__inv_2
Xgf180mcu_as_sc_mcu7t3v3__inv_2_193 VSS VSS VSS VSS gf180mcu_as_sc_mcu7t3v3__inv_2_193/VNW
+ VSUBS gf180mcu_as_sc_mcu7t3v3__inv_2
Xgf180mcu_as_sc_mcu7t3v3__inv_2_171 VSS gf180mcu_as_sc_mcu7t3v3__inv_2_177/VDD VSS
+ VSS gf180mcu_as_sc_mcu7t3v3__inv_2_173/VNW VSUBS gf180mcu_as_sc_mcu7t3v3__inv_2
Xgf180mcu_as_sc_mcu7t3v3__inv_2_160 gf180mcu_as_sc_mcu7t3v3__inv_2_196/VSS gf180mcu_as_sc_mcu7t3v3__inv_2_165/VDD
+ gf180mcu_as_sc_mcu7t3v3__inv_2_160/Y VSS gf180mcu_as_sc_mcu7t3v3__inv_2_161/VNW
+ VSUBS gf180mcu_as_sc_mcu7t3v3__inv_2
Xgf180mcu_as_sc_mcu7t3v3__inv_2_1648 gf180mcu_as_sc_mcu7t3v3__inv_2_1669/VDD VSS VSS
+ gf180mcu_as_sc_mcu7t3v3__inv_2_1675/Y gf180mcu_as_sc_mcu7t3v3__inv_2_1669/VNW VSUBS
+ gf180mcu_as_sc_mcu7t3v3__inv_2
Xgf180mcu_as_sc_mcu7t3v3__inv_2_1637 VSS gf180mcu_as_sc_mcu7t3v3__inv_2_1674/VDD gf180mcu_as_sc_mcu7t3v3__inv_2_1675/Y
+ gf180mcu_as_sc_mcu7t3v3__inv_2_1675/Y gf180mcu_as_sc_mcu7t3v3__inv_2_1673/VNW VSUBS
+ gf180mcu_as_sc_mcu7t3v3__inv_2
Xgf180mcu_as_sc_mcu7t3v3__inv_2_1604 gf180mcu_as_sc_mcu7t3v3__inv_2_1682/VSS gf180mcu_as_sc_mcu7t3v3__inv_2_1665/VDD
+ VSS gf180mcu_as_sc_mcu7t3v3__inv_2_1682/Y gf180mcu_as_sc_mcu7t3v3__inv_2_1664/VNW
+ VSUBS gf180mcu_as_sc_mcu7t3v3__inv_2
Xgf180mcu_as_sc_mcu7t3v3__inv_2_1615 VSS gf180mcu_as_sc_mcu7t3v3__inv_2_1657/VDD gf180mcu_as_sc_mcu7t3v3__inv_2_1615/Y
+ gf180mcu_as_sc_mcu7t3v3__inv_2_1657/Y gf180mcu_as_sc_mcu7t3v3__inv_2_1656/VNW VSUBS
+ gf180mcu_as_sc_mcu7t3v3__inv_2
Xgf180mcu_as_sc_mcu7t3v3__inv_2_1626 VSS gf180mcu_as_sc_mcu7t3v3__inv_2_1660/VDD VSS
+ gf180mcu_as_sc_mcu7t3v3__inv_2_1660/Y gf180mcu_as_sc_mcu7t3v3__inv_2_1659/VNW VSUBS
+ gf180mcu_as_sc_mcu7t3v3__inv_2
Xgf180mcu_as_sc_mcu7t3v3__inv_2_1659 VSS gf180mcu_as_sc_mcu7t3v3__inv_2_1660/VDD gf180mcu_as_sc_mcu7t3v3__inv_2_1660/Y
+ VSS gf180mcu_as_sc_mcu7t3v3__inv_2_1659/VNW VSUBS gf180mcu_as_sc_mcu7t3v3__inv_2
Xu_t015_027 u_t015_027/c0_w0_bl u_t015_027/c0_w0_br u_t015_027/c0_w1_bl u_t015_027/c0_w1_br
+ u_t015_027/c0_r0_rbl u_t015_027/c0_r1_rbl u_t015_027/c1_w0_bl u_t015_027/c1_w0_br
+ u_t015_027/c1_w1_bl u_t015_027/c1_w1_br u_t015_027/c1_r0_rbl u_t015_027/c1_r1_rbl
+ u_t015_027/c2_w0_bl u_t015_027/c2_w0_br u_t015_027/c2_w1_bl u_t015_027/c2_w1_br
+ u_t015_027/c2_r0_rbl u_t015_027/c2_r1_rbl u_t015_027/c3_w0_bl u_t015_027/c3_w0_br
+ u_t015_027/c3_w1_bl u_t015_027/c3_w1_br u_t015_027/c3_r0_rbl u_t015_027/c3_r1_rbl
+ u_t015_027/r0_w0_wl u_t015_027/r0_w1_wl u_t015_027/r0_r0_rwl u_t015_027/r0_r1_rwl
+ u_t015_027/r1_w0_wl u_t015_027/r1_w1_wl u_t015_027/r1_r0_rwl u_t015_027/r1_r1_rwl
+ u_t015_027/r2_w0_wl u_t015_027/r2_w1_wl u_t015_027/r2_r0_rwl u_t015_027/r2_r1_rwl
+ u_t015_027/r3_w0_wl u_t015_027/r3_w1_wl u_t015_027/r3_r0_rwl u_t015_027/r3_r1_rwl
+ u_t015_027/VDD u_t015_027/VSS VSUBS detronyx_12t_2w2r_rc4_4x4_routed_5layer_direct
Xu_t015_016 u_t015_016/c0_w0_bl u_t015_016/c0_w0_br u_t015_016/c0_w1_bl u_t015_016/c0_w1_br
+ u_t015_016/c0_r0_rbl u_t015_016/c0_r1_rbl u_t015_016/c1_w0_bl u_t015_016/c1_w0_br
+ u_t015_016/c1_w1_bl u_t015_016/c1_w1_br u_t015_016/c1_r0_rbl u_t015_016/c1_r1_rbl
+ u_t015_016/c2_w0_bl u_t015_016/c2_w0_br u_t015_016/c2_w1_bl u_t015_016/c2_w1_br
+ u_t015_016/c2_r0_rbl u_t015_016/c2_r1_rbl u_t015_016/c3_w0_bl u_t015_016/c3_w0_br
+ u_t015_016/c3_w1_bl u_t015_016/c3_w1_br u_t015_016/c3_r0_rbl u_t015_016/c3_r1_rbl
+ u_t015_016/r0_w0_wl u_t015_016/r0_w1_wl u_t015_016/r0_r0_rwl u_t015_016/r0_r1_rwl
+ u_t015_016/r1_w0_wl u_t015_016/r1_w1_wl u_t015_016/r1_r0_rwl u_t015_016/r1_r1_rwl
+ u_t015_016/r2_w0_wl u_t015_016/r2_w1_wl u_t015_016/r2_r0_rwl u_t015_016/r2_r1_rwl
+ u_t015_016/r3_w0_wl u_t015_016/r3_w1_wl u_t015_016/r3_r0_rwl u_t015_016/r3_r1_rwl
+ VSS u_t015_017/VSS VSUBS detronyx_12t_2w2r_rc4_4x4_routed_5layer_direct
Xu_t015_005 u_t015_005/c0_w0_bl u_t015_005/c0_w0_br u_t015_005/c0_w1_bl u_t015_005/c0_w1_br
+ u_t015_005/c0_r0_rbl u_t015_005/c0_r1_rbl u_t015_005/c1_w0_bl u_t015_005/c1_w0_br
+ u_t015_005/c1_w1_bl u_t015_005/c1_w1_br u_t015_005/c1_r0_rbl u_t015_005/c1_r1_rbl
+ u_t015_005/c2_w0_bl u_t015_005/c2_w0_br u_t015_005/c2_w1_bl u_t015_005/c2_w1_br
+ u_t015_005/c2_r0_rbl u_t015_005/c2_r1_rbl u_t015_005/c3_w0_bl u_t015_005/c3_w0_br
+ u_t015_005/c3_w1_bl u_t015_005/c3_w1_br u_t015_005/c3_r0_rbl u_t015_005/c3_r1_rbl
+ u_t015_005/r0_w0_wl u_t015_005/r0_w1_wl u_t015_005/r0_r0_rwl u_t015_005/r0_r1_rwl
+ u_t015_005/r1_w0_wl u_t015_005/r1_w1_wl u_t015_005/r1_r0_rwl u_t015_005/r1_r1_rwl
+ u_t015_005/r2_w0_wl u_t015_005/r2_w1_wl u_t015_005/r2_r0_rwl u_t015_005/r2_r1_rwl
+ u_t015_005/r3_w0_wl u_t015_005/r3_w1_wl u_t015_005/r3_r0_rwl u_t015_005/r3_r1_rwl
+ u_t015_005/VDD u_t015_005/VSS VSUBS detronyx_12t_2w2r_rc4_4x4_routed_5layer_direct
Xu_t030_019 u_t030_019/c0_w0_bl u_t030_019/c0_w0_br u_t030_019/c0_w1_bl u_t030_019/c0_w1_br
+ u_t030_019/c0_r0_rbl u_t030_019/c0_r1_rbl u_t030_019/c1_w0_bl u_t030_019/c1_w0_br
+ u_t030_019/c1_w1_bl u_t030_019/c1_w1_br u_t030_019/c1_r0_rbl u_t030_019/c1_r1_rbl
+ u_t030_019/c2_w0_bl u_t030_019/c2_w0_br u_t030_019/c2_w1_bl u_t030_019/c2_w1_br
+ u_t030_019/c2_r0_rbl u_t030_019/c2_r1_rbl u_t030_019/c3_w0_bl u_t030_019/c3_w0_br
+ u_t030_019/c3_w1_bl u_t030_019/c3_w1_br u_t030_019/c3_r0_rbl u_t030_019/c3_r1_rbl
+ u_t030_019/r0_w0_wl u_t030_019/r0_w1_wl u_t030_019/r0_r0_rwl u_t030_019/r0_r1_rwl
+ u_t030_019/r1_w0_wl u_t030_019/r1_w1_wl u_t030_019/r1_r0_rwl u_t030_019/r1_r1_rwl
+ u_t030_019/r2_w0_wl u_t030_019/r2_w1_wl u_t030_019/r2_r0_rwl u_t030_019/r2_r1_rwl
+ u_t030_019/r3_w0_wl u_t030_019/r3_w1_wl u_t030_019/r3_r0_rwl u_t030_019/r3_r1_rwl
+ u_t030_019/VDD u_t030_031/VSS VSUBS detronyx_12t_2w2r_rc4_4x4_routed_5layer_direct
Xu_t030_008 u_t030_008/c0_w0_bl u_t030_008/c0_w0_br u_t030_008/c0_w1_bl u_t030_008/c0_w1_br
+ u_t030_008/c0_r0_rbl u_t030_008/c0_r1_rbl u_t030_008/c1_w0_bl u_t030_008/c1_w0_br
+ u_t030_008/c1_w1_bl u_t030_008/c1_w1_br u_t030_008/c1_r0_rbl u_t030_008/c1_r1_rbl
+ u_t030_008/c2_w0_bl u_t030_008/c2_w0_br u_t030_008/c2_w1_bl u_t030_008/c2_w1_br
+ u_t030_008/c2_r0_rbl u_t030_008/c2_r1_rbl u_t030_008/c3_w0_bl u_t030_008/c3_w0_br
+ u_t030_008/c3_w1_bl u_t030_008/c3_w1_br u_t030_008/c3_r0_rbl u_t030_008/c3_r1_rbl
+ u_t030_008/r0_w0_wl u_t030_008/r0_w1_wl u_t030_008/r0_r0_rwl u_t030_008/r0_r1_rwl
+ u_t030_008/r1_w0_wl u_t030_008/r1_w1_wl u_t030_008/r1_r0_rwl u_t030_008/r1_r1_rwl
+ u_t030_008/r2_w0_wl u_t030_008/r2_w1_wl u_t030_008/r2_r0_rwl u_t030_008/r2_r1_rwl
+ u_t030_008/r3_w0_wl u_t030_008/r3_w1_wl u_t030_008/r3_r0_rwl u_t030_008/r3_r1_rwl
+ VSS u_t030_031/VSS VSUBS detronyx_12t_2w2r_rc4_4x4_routed_5layer_direct
Xgf180mcu_as_sc_mcu7t3v3__nand4_2_409 VSS gf180mcu_as_sc_mcu7t3v3__inv_2_1390/VDD
+ VSS VSS VSS VSS VSS gf180mcu_as_sc_mcu7t3v3__inv_2_1389/VNW VSUBS gf180mcu_as_sc_mcu7t3v3__nand4_2
Xu_t006_027 u_t006_027/c0_w0_bl u_t006_027/c0_w0_br u_t006_027/c0_w1_bl u_t006_027/c0_w1_br
+ u_t006_027/c0_r0_rbl u_t006_027/c0_r1_rbl u_t006_027/c1_w0_bl u_t006_027/c1_w0_br
+ u_t006_027/c1_w1_bl u_t006_027/c1_w1_br u_t006_027/c1_r0_rbl u_t006_027/c1_r1_rbl
+ u_t006_027/c2_w0_bl u_t006_027/c2_w0_br u_t006_027/c2_w1_bl u_t006_027/c2_w1_br
+ u_t006_027/c2_r0_rbl u_t006_027/c2_r1_rbl u_t006_027/c3_w0_bl u_t006_027/c3_w0_br
+ u_t006_027/c3_w1_bl u_t006_027/c3_w1_br u_t006_027/c3_r0_rbl u_t006_027/c3_r1_rbl
+ u_t006_027/r0_w0_wl u_t006_027/r0_w1_wl u_t006_027/r0_r0_rwl u_t006_027/r0_r1_rwl
+ u_t006_027/r1_w0_wl u_t006_027/r1_w1_wl u_t006_027/r1_r0_rwl u_t006_027/r1_r1_rwl
+ u_t006_027/r2_w0_wl u_t006_027/r2_w1_wl u_t006_027/r2_r0_rwl u_t006_027/r2_r1_rwl
+ u_t006_027/r3_w0_wl u_t006_027/r3_w1_wl u_t006_027/r3_r0_rwl u_t006_027/r3_r1_rwl
+ u_t006_027/VDD u_t006_027/VSS VSUBS detronyx_12t_2w2r_rc4_4x4_routed_5layer_direct
Xu_t021_019 u_t021_019/c0_w0_bl u_t021_019/c0_w0_br u_t021_019/c0_w1_bl u_t021_019/c0_w1_br
+ u_t021_019/c0_r0_rbl u_t021_019/c0_r1_rbl u_t021_019/c1_w0_bl u_t021_019/c1_w0_br
+ u_t021_019/c1_w1_bl u_t021_019/c1_w1_br u_t021_019/c1_r0_rbl u_t021_019/c1_r1_rbl
+ u_t021_019/c2_w0_bl u_t021_019/c2_w0_br u_t021_019/c2_w1_bl u_t021_019/c2_w1_br
+ u_t021_019/c2_r0_rbl u_t021_019/c2_r1_rbl u_t021_019/c3_w0_bl u_t021_019/c3_w0_br
+ u_t021_019/c3_w1_bl u_t021_019/c3_w1_br u_t021_019/c3_r0_rbl u_t021_019/c3_r1_rbl
+ u_t021_019/r0_w0_wl u_t021_019/r0_w1_wl u_t021_019/r0_r0_rwl u_t021_019/r0_r1_rwl
+ u_t021_019/r1_w0_wl u_t021_019/r1_w1_wl u_t021_019/r1_r0_rwl u_t021_019/r1_r1_rwl
+ u_t021_019/r2_w0_wl u_t021_019/r2_w1_wl u_t021_019/r2_r0_rwl u_t021_019/r2_r1_rwl
+ u_t021_019/r3_w0_wl u_t021_019/r3_w1_wl u_t021_019/r3_r0_rwl u_t021_019/r3_r1_rwl
+ u_t021_019/VDD u_t021_031/VSS VSUBS detronyx_12t_2w2r_rc4_4x4_routed_5layer_direct
Xu_t006_016 u_t006_016/c0_w0_bl u_t006_016/c0_w0_br u_t006_016/c0_w1_bl u_t006_016/c0_w1_br
+ u_t006_016/c0_r0_rbl u_t006_016/c0_r1_rbl u_t006_016/c1_w0_bl u_t006_016/c1_w0_br
+ u_t006_016/c1_w1_bl u_t006_016/c1_w1_br u_t006_016/c1_r0_rbl u_t006_016/c1_r1_rbl
+ u_t006_016/c2_w0_bl u_t006_016/c2_w0_br u_t006_016/c2_w1_bl u_t006_016/c2_w1_br
+ u_t006_016/c2_r0_rbl u_t006_016/c2_r1_rbl u_t006_016/c3_w0_bl u_t006_016/c3_w0_br
+ u_t006_016/c3_w1_bl u_t006_016/c3_w1_br u_t006_016/c3_r0_rbl u_t006_016/c3_r1_rbl
+ u_t006_016/r0_w0_wl u_t006_016/r0_w1_wl u_t006_016/r0_r0_rwl u_t006_016/r0_r1_rwl
+ u_t006_016/r1_w0_wl u_t006_016/r1_w1_wl u_t006_016/r1_r0_rwl u_t006_016/r1_r1_rwl
+ u_t006_016/r2_w0_wl u_t006_016/r2_w1_wl u_t006_016/r2_r0_rwl u_t006_016/r2_r1_rwl
+ u_t006_016/r3_w0_wl u_t006_016/r3_w1_wl u_t006_016/r3_r0_rwl u_t006_016/r3_r1_rwl
+ VSS u_t006_017/VSS VSUBS detronyx_12t_2w2r_rc4_4x4_routed_5layer_direct
Xu_t021_008 u_t021_008/c0_w0_bl u_t021_008/c0_w0_br u_t021_008/c0_w1_bl u_t021_008/c0_w1_br
+ u_t021_008/c0_r0_rbl u_t021_008/c0_r1_rbl u_t021_008/c1_w0_bl u_t021_008/c1_w0_br
+ u_t021_008/c1_w1_bl u_t021_008/c1_w1_br u_t021_008/c1_r0_rbl u_t021_008/c1_r1_rbl
+ u_t021_008/c2_w0_bl u_t021_008/c2_w0_br u_t021_008/c2_w1_bl u_t021_008/c2_w1_br
+ u_t021_008/c2_r0_rbl u_t021_008/c2_r1_rbl u_t021_008/c3_w0_bl u_t021_008/c3_w0_br
+ u_t021_008/c3_w1_bl u_t021_008/c3_w1_br u_t021_008/c3_r0_rbl u_t021_008/c3_r1_rbl
+ u_t021_008/r0_w0_wl u_t021_008/r0_w1_wl u_t021_008/r0_r0_rwl u_t021_008/r0_r1_rwl
+ u_t021_008/r1_w0_wl u_t021_008/r1_w1_wl u_t021_008/r1_r0_rwl u_t021_008/r1_r1_rwl
+ u_t021_008/r2_w0_wl u_t021_008/r2_w1_wl u_t021_008/r2_r0_rwl u_t021_008/r2_r1_rwl
+ u_t021_008/r3_w0_wl u_t021_008/r3_w1_wl u_t021_008/r3_r0_rwl u_t021_008/r3_r1_rwl
+ VSS u_t021_031/VSS VSUBS detronyx_12t_2w2r_rc4_4x4_routed_5layer_direct
Xu_t006_005 u_t006_005/c0_w0_bl u_t006_005/c0_w0_br u_t006_005/c0_w1_bl u_t006_005/c0_w1_br
+ u_t006_005/c0_r0_rbl u_t006_005/c0_r1_rbl u_t006_005/c1_w0_bl u_t006_005/c1_w0_br
+ u_t006_005/c1_w1_bl u_t006_005/c1_w1_br u_t006_005/c1_r0_rbl u_t006_005/c1_r1_rbl
+ u_t006_005/c2_w0_bl u_t006_005/c2_w0_br u_t006_005/c2_w1_bl u_t006_005/c2_w1_br
+ u_t006_005/c2_r0_rbl u_t006_005/c2_r1_rbl u_t006_005/c3_w0_bl u_t006_005/c3_w0_br
+ u_t006_005/c3_w1_bl u_t006_005/c3_w1_br u_t006_005/c3_r0_rbl u_t006_005/c3_r1_rbl
+ u_t006_005/r0_w0_wl u_t006_005/r0_w1_wl u_t006_005/r0_r0_rwl u_t006_005/r0_r1_rwl
+ u_t006_005/r1_w0_wl u_t006_005/r1_w1_wl u_t006_005/r1_r0_rwl u_t006_005/r1_r1_rwl
+ u_t006_005/r2_w0_wl u_t006_005/r2_w1_wl u_t006_005/r2_r0_rwl u_t006_005/r2_r1_rwl
+ u_t006_005/r3_w0_wl u_t006_005/r3_w1_wl u_t006_005/r3_r0_rwl u_t006_005/r3_r1_rwl
+ u_t006_005/VDD u_t006_005/VSS VSUBS detronyx_12t_2w2r_rc4_4x4_routed_5layer_direct
Xgf180mcu_as_sc_mcu7t3v3__nand2_2_50 gf180mcu_as_sc_mcu7t3v3__nor2_2_8/VDD gf180mcu_as_sc_mcu7t3v3__nor2_2_8/VSS
+ VSS VSS VSS gf180mcu_as_sc_mcu7t3v3__nor2_2_8/VNW VSUBS gf180mcu_as_sc_mcu7t3v3__nand2_2
Xgf180mcu_as_sc_mcu7t3v3__nand2_2_61 gf180mcu_as_sc_mcu7t3v3__nand3_2_31/VDD gf180mcu_as_sc_mcu7t3v3__nor2_2_8/VSS
+ VSS VSS VSS gf180mcu_as_sc_mcu7t3v3__nand3_2_31/VNW VSUBS gf180mcu_as_sc_mcu7t3v3__nand2_2
Xu_t020_030 u_t020_030/c0_w0_bl u_t020_030/c0_w0_br u_t020_030/c0_w1_bl u_t020_030/c0_w1_br
+ u_t020_030/c0_r0_rbl u_t020_030/c0_r1_rbl u_t020_030/c1_w0_bl u_t020_030/c1_w0_br
+ u_t020_030/c1_w1_bl u_t020_030/c1_w1_br u_t020_030/c1_r0_rbl u_t020_030/c1_r1_rbl
+ u_t020_030/c2_w0_bl u_t020_030/c2_w0_br u_t020_030/c2_w1_bl u_t020_030/c2_w1_br
+ u_t020_030/c2_r0_rbl u_t020_030/c2_r1_rbl u_t020_030/c3_w0_bl u_t020_030/c3_w0_br
+ u_t020_030/c3_w1_bl u_t020_030/c3_w1_br u_t020_030/c3_r0_rbl u_t020_030/c3_r1_rbl
+ u_t020_030/r0_w0_wl u_t020_030/r0_w1_wl u_t020_030/r0_r0_rwl u_t020_030/r0_r1_rwl
+ u_t020_030/r1_w0_wl u_t020_030/r1_w1_wl u_t020_030/r1_r0_rwl u_t020_030/r1_r1_rwl
+ u_t020_030/r2_w0_wl u_t020_030/r2_w1_wl u_t020_030/r2_r0_rwl u_t020_030/r2_r1_rwl
+ u_t020_030/r3_w0_wl u_t020_030/r3_w1_wl u_t020_030/r3_r0_rwl u_t020_030/r3_r1_rwl
+ VSS u_t020_031/VSS VSUBS detronyx_12t_2w2r_rc4_4x4_routed_5layer_direct
Xu_t012_019 u_t012_019/c0_w0_bl u_t012_019/c0_w0_br u_t012_019/c0_w1_bl u_t012_019/c0_w1_br
+ u_t012_019/c0_r0_rbl u_t012_019/c0_r1_rbl u_t012_019/c1_w0_bl u_t012_019/c1_w0_br
+ u_t012_019/c1_w1_bl u_t012_019/c1_w1_br u_t012_019/c1_r0_rbl u_t012_019/c1_r1_rbl
+ u_t012_019/c2_w0_bl u_t012_019/c2_w0_br u_t012_019/c2_w1_bl u_t012_019/c2_w1_br
+ u_t012_019/c2_r0_rbl u_t012_019/c2_r1_rbl u_t012_019/c3_w0_bl u_t012_019/c3_w0_br
+ u_t012_019/c3_w1_bl u_t012_019/c3_w1_br u_t012_019/c3_r0_rbl u_t012_019/c3_r1_rbl
+ u_t012_019/r0_w0_wl u_t012_019/r0_w1_wl u_t012_019/r0_r0_rwl u_t012_019/r0_r1_rwl
+ u_t012_019/r1_w0_wl u_t012_019/r1_w1_wl u_t012_019/r1_r0_rwl u_t012_019/r1_r1_rwl
+ u_t012_019/r2_w0_wl u_t012_019/r2_w1_wl u_t012_019/r2_r0_rwl u_t012_019/r2_r1_rwl
+ u_t012_019/r3_w0_wl u_t012_019/r3_w1_wl u_t012_019/r3_r0_rwl u_t012_019/r3_r1_rwl
+ u_t012_019/VDD u_t012_031/VSS VSUBS detronyx_12t_2w2r_rc4_4x4_routed_5layer_direct
Xu_t012_008 u_t012_008/c0_w0_bl u_t012_008/c0_w0_br u_t012_008/c0_w1_bl u_t012_008/c0_w1_br
+ u_t012_008/c0_r0_rbl u_t012_008/c0_r1_rbl u_t012_008/c1_w0_bl u_t012_008/c1_w0_br
+ u_t012_008/c1_w1_bl u_t012_008/c1_w1_br u_t012_008/c1_r0_rbl u_t012_008/c1_r1_rbl
+ u_t012_008/c2_w0_bl u_t012_008/c2_w0_br u_t012_008/c2_w1_bl u_t012_008/c2_w1_br
+ u_t012_008/c2_r0_rbl u_t012_008/c2_r1_rbl u_t012_008/c3_w0_bl u_t012_008/c3_w0_br
+ u_t012_008/c3_w1_bl u_t012_008/c3_w1_br u_t012_008/c3_r0_rbl u_t012_008/c3_r1_rbl
+ u_t012_008/r0_w0_wl u_t012_008/r0_w1_wl u_t012_008/r0_r0_rwl u_t012_008/r0_r1_rwl
+ u_t012_008/r1_w0_wl u_t012_008/r1_w1_wl u_t012_008/r1_r0_rwl u_t012_008/r1_r1_rwl
+ u_t012_008/r2_w0_wl u_t012_008/r2_w1_wl u_t012_008/r2_r0_rwl u_t012_008/r2_r1_rwl
+ u_t012_008/r3_w0_wl u_t012_008/r3_w1_wl u_t012_008/r3_r0_rwl u_t012_008/r3_r1_rwl
+ VSS u_t012_031/VSS VSUBS detronyx_12t_2w2r_rc4_4x4_routed_5layer_direct
Xgf180mcu_as_sc_mcu7t3v3__inv_2_1401 VSS gf180mcu_as_sc_mcu7t3v3__inv_2_1433/VSS gf180mcu_as_sc_mcu7t3v3__inv_2_1401/Y
+ VSS gf180mcu_as_sc_mcu7t3v3__inv_2_1433/VNW VSUBS gf180mcu_as_sc_mcu7t3v3__inv_2
Xgf180mcu_as_sc_mcu7t3v3__inv_2_1489 gf180mcu_as_sc_mcu7t3v3__inv_2_1497/VDD gf180mcu_as_sc_mcu7t3v3__inv_2_1497/VSS
+ VSS VSS gf180mcu_as_sc_mcu7t3v3__inv_2_1497/VNW VSUBS gf180mcu_as_sc_mcu7t3v3__inv_2
Xgf180mcu_as_sc_mcu7t3v3__inv_2_1467 gf180mcu_as_sc_mcu7t3v3__inv_2_1468/VDD VSS gf180mcu_as_sc_mcu7t3v3__inv_2_1467/Y
+ VSS gf180mcu_as_sc_mcu7t3v3__inv_2_1468/VNW VSUBS gf180mcu_as_sc_mcu7t3v3__inv_2
Xgf180mcu_as_sc_mcu7t3v3__inv_2_1478 gf180mcu_as_sc_mcu7t3v3__inv_2_1480/VDD VSS VSS
+ VSS gf180mcu_as_sc_mcu7t3v3__inv_2_1480/VNW VSUBS gf180mcu_as_sc_mcu7t3v3__inv_2
Xgf180mcu_as_sc_mcu7t3v3__inv_2_1434 VSS gf180mcu_as_sc_mcu7t3v3__inv_2_1440/VDD VSS
+ VSS gf180mcu_as_sc_mcu7t3v3__inv_2_1436/VNW VSUBS gf180mcu_as_sc_mcu7t3v3__inv_2
Xgf180mcu_as_sc_mcu7t3v3__inv_2_1423 VSS gf180mcu_as_sc_mcu7t3v3__inv_2_1428/VDD VSS
+ VSS gf180mcu_as_sc_mcu7t3v3__inv_2_1424/VNW VSUBS gf180mcu_as_sc_mcu7t3v3__inv_2
Xgf180mcu_as_sc_mcu7t3v3__inv_2_1412 VSS gf180mcu_as_sc_mcu7t3v3__inv_2_1416/VDD gf180mcu_as_sc_mcu7t3v3__inv_2_1412/Y
+ VSS gf180mcu_as_sc_mcu7t3v3__inv_2_1412/VNW VSUBS gf180mcu_as_sc_mcu7t3v3__inv_2
Xgf180mcu_as_sc_mcu7t3v3__inv_2_1445 VSS VSS VSS VSS gf180mcu_as_sc_mcu7t3v3__inv_2_1445/VNW
+ VSUBS gf180mcu_as_sc_mcu7t3v3__inv_2
Xgf180mcu_as_sc_mcu7t3v3__inv_2_1456 gf180mcu_as_sc_mcu7t3v3__inv_2_1457/VDD VSS VSS
+ VSS gf180mcu_as_sc_mcu7t3v3__inv_2_1457/VNW VSUBS gf180mcu_as_sc_mcu7t3v3__inv_2
Xu_t003_008 u_t003_008/c0_w0_bl u_t003_008/c0_w0_br u_t003_008/c0_w1_bl u_t003_008/c0_w1_br
+ u_t003_008/c0_r0_rbl u_t003_008/c0_r1_rbl u_t003_008/c1_w0_bl u_t003_008/c1_w0_br
+ u_t003_008/c1_w1_bl u_t003_008/c1_w1_br u_t003_008/c1_r0_rbl u_t003_008/c1_r1_rbl
+ u_t003_008/c2_w0_bl u_t003_008/c2_w0_br u_t003_008/c2_w1_bl u_t003_008/c2_w1_br
+ u_t003_008/c2_r0_rbl u_t003_008/c2_r1_rbl u_t003_008/c3_w0_bl u_t003_008/c3_w0_br
+ u_t003_008/c3_w1_bl u_t003_008/c3_w1_br u_t003_008/c3_r0_rbl u_t003_008/c3_r1_rbl
+ u_t003_008/r0_w0_wl u_t003_008/r0_w1_wl u_t003_008/r0_r0_rwl u_t003_008/r0_r1_rwl
+ u_t003_008/r1_w0_wl u_t003_008/r1_w1_wl u_t003_008/r1_r0_rwl u_t003_008/r1_r1_rwl
+ u_t003_008/r2_w0_wl u_t003_008/r2_w1_wl u_t003_008/r2_r0_rwl u_t003_008/r2_r1_rwl
+ u_t003_008/r3_w0_wl u_t003_008/r3_w1_wl u_t003_008/r3_r0_rwl u_t003_008/r3_r1_rwl
+ VSS u_t003_009/VSS VSUBS detronyx_12t_2w2r_rc4_4x4_routed_5layer_direct
Xgf180mcu_as_sc_mcu7t3v3__inv_2_918 VSS VSS VSS VSS gf180mcu_as_sc_mcu7t3v3__inv_2_920/VNW
+ VSUBS gf180mcu_as_sc_mcu7t3v3__inv_2
Xgf180mcu_as_sc_mcu7t3v3__inv_2_929 VSS VSS VSS VSS gf180mcu_as_sc_mcu7t3v3__inv_2_933/VNW
+ VSUBS gf180mcu_as_sc_mcu7t3v3__inv_2
Xgf180mcu_as_sc_mcu7t3v3__inv_2_907 VSS VSS VSS VSS gf180mcu_as_sc_mcu7t3v3__inv_2_909/VNW
+ VSUBS gf180mcu_as_sc_mcu7t3v3__inv_2
Xu_t011_030 u_t011_030/c0_w0_bl u_t011_030/c0_w0_br u_t011_030/c0_w1_bl u_t011_030/c0_w1_br
+ u_t011_030/c0_r0_rbl u_t011_030/c0_r1_rbl u_t011_030/c1_w0_bl u_t011_030/c1_w0_br
+ u_t011_030/c1_w1_bl u_t011_030/c1_w1_br u_t011_030/c1_r0_rbl u_t011_030/c1_r1_rbl
+ u_t011_030/c2_w0_bl u_t011_030/c2_w0_br u_t011_030/c2_w1_bl u_t011_030/c2_w1_br
+ u_t011_030/c2_r0_rbl u_t011_030/c2_r1_rbl u_t011_030/c3_w0_bl u_t011_030/c3_w0_br
+ u_t011_030/c3_w1_bl u_t011_030/c3_w1_br u_t011_030/c3_r0_rbl u_t011_030/c3_r1_rbl
+ u_t011_030/r0_w0_wl u_t011_030/r0_w1_wl u_t011_030/r0_r0_rwl u_t011_030/r0_r1_rwl
+ u_t011_030/r1_w0_wl u_t011_030/r1_w1_wl u_t011_030/r1_r0_rwl u_t011_030/r1_r1_rwl
+ u_t011_030/r2_w0_wl u_t011_030/r2_w1_wl u_t011_030/r2_r0_rwl u_t011_030/r2_r1_rwl
+ u_t011_030/r3_w0_wl u_t011_030/r3_w1_wl u_t011_030/r3_r0_rwl u_t011_030/r3_r1_rwl
+ VSS u_t011_031/VSS VSUBS detronyx_12t_2w2r_rc4_4x4_routed_5layer_direct
Xu_t003_019 u_t003_019/c0_w0_bl u_t003_019/c0_w0_br u_t003_019/c0_w1_bl u_t003_019/c0_w1_br
+ u_t003_019/c0_r0_rbl u_t003_019/c0_r1_rbl u_t003_019/c1_w0_bl u_t003_019/c1_w0_br
+ u_t003_019/c1_w1_bl u_t003_019/c1_w1_br u_t003_019/c1_r0_rbl u_t003_019/c1_r1_rbl
+ u_t003_019/c2_w0_bl u_t003_019/c2_w0_br u_t003_019/c2_w1_bl u_t003_019/c2_w1_br
+ u_t003_019/c2_r0_rbl u_t003_019/c2_r1_rbl u_t003_019/c3_w0_bl u_t003_019/c3_w0_br
+ u_t003_019/c3_w1_bl u_t003_019/c3_w1_br u_t003_019/c3_r0_rbl u_t003_019/c3_r1_rbl
+ u_t003_019/r0_w0_wl u_t003_019/r0_w1_wl u_t003_019/r0_r0_rwl u_t003_019/r0_r1_rwl
+ u_t003_019/r1_w0_wl u_t003_019/r1_w1_wl u_t003_019/r1_r0_rwl u_t003_019/r1_r1_rwl
+ u_t003_019/r2_w0_wl u_t003_019/r2_w1_wl u_t003_019/r2_r0_rwl u_t003_019/r2_r1_rwl
+ u_t003_019/r3_w0_wl u_t003_019/r3_w1_wl u_t003_019/r3_r0_rwl u_t003_019/r3_r1_rwl
+ u_t004_019/VDD u_t003_019/VSS VSUBS detronyx_12t_2w2r_rc4_4x4_routed_5layer_direct
Xgf180mcu_as_sc_mcu7t3v3__nand4_2_217 VSS VSS VSS VSS VSS VSS gf180mcu_as_sc_mcu7t3v3__nand4_2_217/Y
+ gf180mcu_as_sc_mcu7t3v3__inv_2_760/VNW VSUBS gf180mcu_as_sc_mcu7t3v3__nand4_2
Xgf180mcu_as_sc_mcu7t3v3__nand4_2_206 VSS gf180mcu_as_sc_mcu7t3v3__inv_2_659/VDD VSS
+ VSS VSS VSS VSS gf180mcu_as_sc_mcu7t3v3__inv_2_655/VNW VSUBS gf180mcu_as_sc_mcu7t3v3__nand4_2
Xgf180mcu_as_sc_mcu7t3v3__nand4_2_228 VSS VSS VSS VSS VSS VSS gf180mcu_as_sc_mcu7t3v3__nand4_2_228/Y
+ gf180mcu_as_sc_mcu7t3v3__inv_2_765/VNW VSUBS gf180mcu_as_sc_mcu7t3v3__nand4_2
Xgf180mcu_as_sc_mcu7t3v3__nand4_2_239 VSS VSS VSS VSS VSS VSS VSS gf180mcu_as_sc_mcu7t3v3__inv_2_800/VNW
+ VSUBS gf180mcu_as_sc_mcu7t3v3__nand4_2
Xu_t002_030 u_t002_030/c0_w0_bl u_t002_030/c0_w0_br u_t002_030/c0_w1_bl u_t002_030/c0_w1_br
+ u_t002_030/c0_r0_rbl u_t002_030/c0_r1_rbl u_t002_030/c1_w0_bl u_t002_030/c1_w0_br
+ u_t002_030/c1_w1_bl u_t002_030/c1_w1_br u_t002_030/c1_r0_rbl u_t002_030/c1_r1_rbl
+ u_t002_030/c2_w0_bl u_t002_030/c2_w0_br u_t002_030/c2_w1_bl u_t002_030/c2_w1_br
+ u_t002_030/c2_r0_rbl u_t002_030/c2_r1_rbl u_t002_030/c3_w0_bl u_t002_030/c3_w0_br
+ u_t002_030/c3_w1_bl u_t002_030/c3_w1_br u_t002_030/c3_r0_rbl u_t002_030/c3_r1_rbl
+ u_t002_030/r0_w0_wl u_t002_030/r0_w1_wl u_t002_030/r0_r0_rwl u_t002_030/r0_r1_rwl
+ u_t002_030/r1_w0_wl u_t002_030/r1_w1_wl u_t002_030/r1_r0_rwl u_t002_030/r1_r1_rwl
+ u_t002_030/r2_w0_wl u_t002_030/r2_w1_wl u_t002_030/r2_r0_rwl u_t002_030/r2_r1_rwl
+ u_t002_030/r3_w0_wl u_t002_030/r3_w1_wl u_t002_030/r3_r0_rwl u_t002_030/r3_r1_rwl
+ VSS u_t002_031/VSS VSUBS detronyx_12t_2w2r_rc4_4x4_routed_5layer_direct
Xgf180mcu_as_sc_mcu7t3v3__inv_2_1253 gf180mcu_as_sc_mcu7t3v3__nand3_2_31/VDD gf180mcu_as_sc_mcu7t3v3__nand3_2_31/VSS
+ VSS VSS gf180mcu_as_sc_mcu7t3v3__nand3_2_31/VNW VSUBS gf180mcu_as_sc_mcu7t3v3__inv_2
Xgf180mcu_as_sc_mcu7t3v3__inv_2_1220 gf180mcu_as_sc_mcu7t3v3__nand3_2_31/VDD gf180mcu_as_sc_mcu7t3v3__nand3_2_31/VSS
+ gf180mcu_as_sc_mcu7t3v3__inv_2_1220/Y VSS gf180mcu_as_sc_mcu7t3v3__nand3_2_31/VNW
+ VSUBS gf180mcu_as_sc_mcu7t3v3__inv_2
Xgf180mcu_as_sc_mcu7t3v3__inv_2_1242 VSS VSS VSS VSS gf180mcu_as_sc_mcu7t3v3__inv_2_1244/VNW
+ VSUBS gf180mcu_as_sc_mcu7t3v3__inv_2
Xgf180mcu_as_sc_mcu7t3v3__inv_2_1231 VSS VSS VSS VSS gf180mcu_as_sc_mcu7t3v3__inv_2_1245/VNW
+ VSUBS gf180mcu_as_sc_mcu7t3v3__inv_2
Xgf180mcu_as_sc_mcu7t3v3__inv_2_1286 gf180mcu_as_sc_mcu7t3v3__nor2_2_8/VDD gf180mcu_as_sc_mcu7t3v3__nand3_2_32/VSS
+ VSS VSS gf180mcu_as_sc_mcu7t3v3__nor2_2_8/VNW VSUBS gf180mcu_as_sc_mcu7t3v3__inv_2
Xgf180mcu_as_sc_mcu7t3v3__inv_2_1264 gf180mcu_as_sc_mcu7t3v3__nand3_2_31/VDD gf180mcu_as_sc_mcu7t3v3__nor2_2_8/VSS
+ VSS VSS gf180mcu_as_sc_mcu7t3v3__nand3_2_31/VNW VSUBS gf180mcu_as_sc_mcu7t3v3__inv_2
Xgf180mcu_as_sc_mcu7t3v3__inv_2_1275 VSS VSS VSS VSS gf180mcu_as_sc_mcu7t3v3__inv_2_1277/VNW
+ VSUBS gf180mcu_as_sc_mcu7t3v3__inv_2
Xgf180mcu_as_sc_mcu7t3v3__inv_2_1297 VSS VSS VSS VSS gf180mcu_as_sc_mcu7t3v3__inv_2_1298/VNW
+ VSUBS gf180mcu_as_sc_mcu7t3v3__inv_2
Xgf180mcu_as_sc_mcu7t3v3__inv_2_759 VSS VSS VSS VSS gf180mcu_as_sc_mcu7t3v3__inv_2_760/VNW
+ VSUBS gf180mcu_as_sc_mcu7t3v3__inv_2
Xgf180mcu_as_sc_mcu7t3v3__inv_2_748 VSS VSS VSS VSS gf180mcu_as_sc_mcu7t3v3__inv_2_749/VNW
+ VSUBS gf180mcu_as_sc_mcu7t3v3__inv_2
Xgf180mcu_as_sc_mcu7t3v3__inv_2_704 gf180mcu_as_sc_mcu7t3v3__inv_2_738/VSS VSS gf180mcu_as_sc_mcu7t3v3__inv_2_704/Y
+ VSS gf180mcu_as_sc_mcu7t3v3__inv_2_704/VNW VSUBS gf180mcu_as_sc_mcu7t3v3__inv_2
Xgf180mcu_as_sc_mcu7t3v3__inv_2_737 VSS gf180mcu_as_sc_mcu7t3v3__inv_2_738/VSS gf180mcu_as_sc_mcu7t3v3__inv_2_737/Y
+ gf180mcu_as_sc_mcu7t3v3__inv_2_737/A gf180mcu_as_sc_mcu7t3v3__inv_2_738/VNW VSUBS
+ gf180mcu_as_sc_mcu7t3v3__inv_2
Xgf180mcu_as_sc_mcu7t3v3__inv_2_726 VSS gf180mcu_as_sc_mcu7t3v3__inv_2_727/VSS gf180mcu_as_sc_mcu7t3v3__inv_2_732/Y
+ gf180mcu_as_sc_mcu7t3v3__inv_2_727/Y gf180mcu_as_sc_mcu7t3v3__inv_2_727/VNW VSUBS
+ gf180mcu_as_sc_mcu7t3v3__inv_2
Xgf180mcu_as_sc_mcu7t3v3__inv_2_715 VSS gf180mcu_as_sc_mcu7t3v3__inv_2_719/VDD gf180mcu_as_sc_mcu7t3v3__inv_2_715/Y
+ VSS gf180mcu_as_sc_mcu7t3v3__inv_2_715/VNW VSUBS gf180mcu_as_sc_mcu7t3v3__inv_2
Xgf180mcu_as_sc_mcu7t3v3__inv_2_1061 gf180mcu_as_sc_mcu7t3v3__inv_2_1105/VSS VSS gf180mcu_as_sc_mcu7t3v3__inv_2_1093/A
+ VSS gf180mcu_as_sc_mcu7t3v3__inv_2_1093/VNW VSUBS gf180mcu_as_sc_mcu7t3v3__inv_2
Xgf180mcu_as_sc_mcu7t3v3__inv_2_1072 gf180mcu_as_sc_mcu7t3v3__inv_2_1072/VDD VSS gf180mcu_as_sc_mcu7t3v3__inv_2_1072/Y
+ VSS gf180mcu_as_sc_mcu7t3v3__inv_2_1072/VNW VSUBS gf180mcu_as_sc_mcu7t3v3__inv_2
Xgf180mcu_as_sc_mcu7t3v3__inv_2_1083 gf180mcu_as_sc_mcu7t3v3__inv_2_1084/VDD VSS gf180mcu_as_sc_mcu7t3v3__inv_2_1083/Y
+ gf180mcu_as_sc_mcu7t3v3__inv_2_1084/Y gf180mcu_as_sc_mcu7t3v3__inv_2_1084/VNW VSUBS
+ gf180mcu_as_sc_mcu7t3v3__inv_2
Xgf180mcu_as_sc_mcu7t3v3__inv_2_1094 gf180mcu_as_sc_mcu7t3v3__inv_2_1096/VDD VSS VSS
+ gf180mcu_as_sc_mcu7t3v3__inv_2_1094/A gf180mcu_as_sc_mcu7t3v3__inv_2_1096/VNW VSUBS
+ gf180mcu_as_sc_mcu7t3v3__inv_2
Xgf180mcu_as_sc_mcu7t3v3__inv_2_80 gf180mcu_as_sc_mcu7t3v3__inv_2_96/VDD gf180mcu_as_sc_mcu7t3v3__inv_2_96/VDD
+ VSS VSS gf180mcu_as_sc_mcu7t3v3__inv_2_84/VNW VSUBS gf180mcu_as_sc_mcu7t3v3__inv_2
Xgf180mcu_as_sc_mcu7t3v3__inv_2_91 gf180mcu_as_sc_mcu7t3v3__inv_2_91/VDD gf180mcu_as_sc_mcu7t3v3__inv_2_95/VDD
+ gf180mcu_as_sc_mcu7t3v3__inv_2_91/Y VSS gf180mcu_as_sc_mcu7t3v3__inv_2_91/VNW VSUBS
+ gf180mcu_as_sc_mcu7t3v3__inv_2
Xgf180mcu_as_sc_mcu7t3v3__inv_2_1050 VSS gf180mcu_as_sc_mcu7t3v3__inv_2_1056/VDD gf180mcu_as_sc_mcu7t3v3__inv_2_1050/Y
+ VSS gf180mcu_as_sc_mcu7t3v3__inv_2_1050/VNW VSUBS gf180mcu_as_sc_mcu7t3v3__inv_2
Xgf180mcu_as_sc_mcu7t3v3__nand4_2_6 gf180mcu_as_sc_mcu7t3v3__inv_2_8/VDD gf180mcu_as_sc_mcu7t3v3__inv_2_8/VSS
+ VSS VSS VSS VSS VSS gf180mcu_as_sc_mcu7t3v3__inv_2_8/VNW VSUBS gf180mcu_as_sc_mcu7t3v3__nand4_2
Xgf180mcu_as_sc_mcu7t3v3__inv_2_523 VSS VSS gf180mcu_as_sc_mcu7t3v3__inv_2_523/Y VSS
+ gf180mcu_as_sc_mcu7t3v3__inv_2_531/VNW VSUBS gf180mcu_as_sc_mcu7t3v3__inv_2
Xgf180mcu_as_sc_mcu7t3v3__inv_2_512 VSS VSS gf180mcu_as_sc_mcu7t3v3__inv_2_512/Y VSS
+ gf180mcu_as_sc_mcu7t3v3__inv_2_514/VNW VSUBS gf180mcu_as_sc_mcu7t3v3__inv_2
Xgf180mcu_as_sc_mcu7t3v3__inv_2_501 VSS VSS VSS VSS gf180mcu_as_sc_mcu7t3v3__inv_2_502/VNW
+ VSUBS gf180mcu_as_sc_mcu7t3v3__inv_2
Xgf180mcu_as_sc_mcu7t3v3__inv_2_545 VSS VSS VSS VSS gf180mcu_as_sc_mcu7t3v3__inv_2_546/VNW
+ VSUBS gf180mcu_as_sc_mcu7t3v3__inv_2
Xgf180mcu_as_sc_mcu7t3v3__inv_2_534 VSS VSS gf180mcu_as_sc_mcu7t3v3__inv_2_534/Y VSS
+ gf180mcu_as_sc_mcu7t3v3__inv_2_534/VNW VSUBS gf180mcu_as_sc_mcu7t3v3__inv_2
Xgf180mcu_as_sc_mcu7t3v3__inv_2_556 VSS VSS VSS VSS gf180mcu_as_sc_mcu7t3v3__inv_2_558/VNW
+ VSUBS gf180mcu_as_sc_mcu7t3v3__inv_2
Xgf180mcu_as_sc_mcu7t3v3__inv_2_567 gf180mcu_as_sc_mcu7t3v3__inv_2_572/VDD gf180mcu_as_sc_mcu7t3v3__inv_2_572/VDD
+ gf180mcu_as_sc_mcu7t3v3__inv_2_567/Y gf180mcu_as_sc_mcu7t3v3__inv_2_574/A gf180mcu_as_sc_mcu7t3v3__inv_2_569/VNW
+ VSUBS gf180mcu_as_sc_mcu7t3v3__inv_2
Xgf180mcu_as_sc_mcu7t3v3__inv_2_578 gf180mcu_as_sc_mcu7t3v3__inv_2_584/VDD gf180mcu_as_sc_mcu7t3v3__inv_2_584/VDD
+ gf180mcu_as_sc_mcu7t3v3__inv_2_578/Y VSS gf180mcu_as_sc_mcu7t3v3__inv_2_580/VNW
+ VSUBS gf180mcu_as_sc_mcu7t3v3__inv_2
Xgf180mcu_as_sc_mcu7t3v3__inv_2_589 gf180mcu_as_sc_mcu7t3v3__inv_2_633/VSS VSS gf180mcu_as_sc_mcu7t3v3__inv_2_589/Y
+ VSS gf180mcu_as_sc_mcu7t3v3__inv_2_589/VNW VSUBS gf180mcu_as_sc_mcu7t3v3__inv_2
Xgf180mcu_as_sc_mcu7t3v3__inv_2_386 gf180mcu_as_sc_mcu7t3v3__nor2_2_6/VDD gf180mcu_as_sc_mcu7t3v3__nand3_2_3/VSS
+ VSS VSS gf180mcu_as_sc_mcu7t3v3__nor2_2_6/VNW VSUBS gf180mcu_as_sc_mcu7t3v3__inv_2
Xgf180mcu_as_sc_mcu7t3v3__inv_2_375 gf180mcu_as_sc_mcu7t3v3__nand3_2_5/VDD gf180mcu_as_sc_mcu7t3v3__nor2_2_6/VSS
+ VSS VSS gf180mcu_as_sc_mcu7t3v3__nand3_2_5/VNW VSUBS gf180mcu_as_sc_mcu7t3v3__inv_2
Xgf180mcu_as_sc_mcu7t3v3__inv_2_353 gf180mcu_as_sc_mcu7t3v3__inv_2_353/VDD gf180mcu_as_sc_mcu7t3v3__inv_2_368/VDD
+ gf180mcu_as_sc_mcu7t3v3__inv_2_66/Y VSS gf180mcu_as_sc_mcu7t3v3__inv_2_353/VNW VSUBS
+ gf180mcu_as_sc_mcu7t3v3__inv_2
Xgf180mcu_as_sc_mcu7t3v3__inv_2_364 gf180mcu_as_sc_mcu7t3v3__inv_2_364/VDD VSS gf180mcu_as_sc_mcu7t3v3__inv_2_364/Y
+ VSS gf180mcu_as_sc_mcu7t3v3__inv_2_364/VNW VSUBS gf180mcu_as_sc_mcu7t3v3__inv_2
Xgf180mcu_as_sc_mcu7t3v3__inv_2_342 VSS VSS gf180mcu_as_sc_mcu7t3v3__inv_2_344/Y VSS
+ gf180mcu_as_sc_mcu7t3v3__inv_2_342/VNW VSUBS gf180mcu_as_sc_mcu7t3v3__inv_2
Xgf180mcu_as_sc_mcu7t3v3__inv_2_320 gf180mcu_as_sc_mcu7t3v3__inv_2_337/VDD gf180mcu_as_sc_mcu7t3v3__inv_2_338/VDD
+ gf180mcu_as_sc_mcu7t3v3__inv_2_320/Y gf180mcu_as_sc_mcu7t3v3__inv_2_338/Y gf180mcu_as_sc_mcu7t3v3__inv_2_337/VNW
+ VSUBS gf180mcu_as_sc_mcu7t3v3__inv_2
Xgf180mcu_as_sc_mcu7t3v3__inv_2_331 gf180mcu_as_sc_mcu7t3v3__inv_2_331/VDD gf180mcu_as_sc_mcu7t3v3__inv_2_332/VDD
+ gf180mcu_as_sc_mcu7t3v3__inv_2_338/Y VSS gf180mcu_as_sc_mcu7t3v3__inv_2_331/VNW
+ VSUBS gf180mcu_as_sc_mcu7t3v3__inv_2
Xgf180mcu_as_sc_mcu7t3v3__inv_2_397 VSS VSS VSS VSS gf180mcu_as_sc_mcu7t3v3__inv_2_398/VNW
+ VSUBS gf180mcu_as_sc_mcu7t3v3__inv_2
Xu_t027_025 u_t027_025/c0_w0_bl u_t027_025/c0_w0_br u_t027_025/c0_w1_bl u_t027_025/c0_w1_br
+ u_t027_025/c0_r0_rbl u_t027_025/c0_r1_rbl u_t027_025/c1_w0_bl u_t027_025/c1_w0_br
+ u_t027_025/c1_w1_bl u_t027_025/c1_w1_br u_t027_025/c1_r0_rbl u_t027_025/c1_r1_rbl
+ u_t027_025/c2_w0_bl u_t027_025/c2_w0_br u_t027_025/c2_w1_bl u_t027_025/c2_w1_br
+ u_t027_025/c2_r0_rbl u_t027_025/c2_r1_rbl u_t027_025/c3_w0_bl u_t027_025/c3_w0_br
+ u_t027_025/c3_w1_bl u_t027_025/c3_w1_br u_t027_025/c3_r0_rbl u_t027_025/c3_r1_rbl
+ u_t027_025/r0_w0_wl u_t027_025/r0_w1_wl u_t027_025/r0_r0_rwl u_t027_025/r0_r1_rwl
+ u_t027_025/r1_w0_wl u_t027_025/r1_w1_wl u_t027_025/r1_r0_rwl u_t027_025/r1_r1_rwl
+ u_t027_025/r2_w0_wl u_t027_025/r2_w1_wl u_t027_025/r2_r0_rwl u_t027_025/r2_r1_rwl
+ u_t027_025/r3_w0_wl u_t027_025/r3_w1_wl u_t027_025/r3_r0_rwl u_t027_025/r3_r1_rwl
+ VSS u_t027_025/VSS VSUBS detronyx_12t_2w2r_rc4_4x4_routed_5layer_direct
Xu_t027_014 u_t027_014/c0_w0_bl u_t027_014/c0_w0_br u_t027_014/c0_w1_bl u_t027_014/c0_w1_br
+ u_t027_014/c0_r0_rbl u_t027_014/c0_r1_rbl u_t027_014/c1_w0_bl u_t027_014/c1_w0_br
+ u_t027_014/c1_w1_bl u_t027_014/c1_w1_br u_t027_014/c1_r0_rbl u_t027_014/c1_r1_rbl
+ u_t027_014/c2_w0_bl u_t027_014/c2_w0_br u_t027_014/c2_w1_bl u_t027_014/c2_w1_br
+ u_t027_014/c2_r0_rbl u_t027_014/c2_r1_rbl u_t027_014/c3_w0_bl u_t027_014/c3_w0_br
+ u_t027_014/c3_w1_bl u_t027_014/c3_w1_br u_t027_014/c3_r0_rbl u_t027_014/c3_r1_rbl
+ u_t027_014/r0_w0_wl u_t027_014/r0_w1_wl u_t027_014/r0_r0_rwl u_t027_014/r0_r1_rwl
+ u_t027_014/r1_w0_wl u_t027_014/r1_w1_wl u_t027_014/r1_r0_rwl u_t027_014/r1_r1_rwl
+ u_t027_014/r2_w0_wl u_t027_014/r2_w1_wl u_t027_014/r2_r0_rwl u_t027_014/r2_r1_rwl
+ u_t027_014/r3_w0_wl u_t027_014/r3_w1_wl u_t027_014/r3_r0_rwl u_t027_014/r3_r1_rwl
+ u_t027_014/VDD u_t027_017/VSS VSUBS detronyx_12t_2w2r_rc4_4x4_routed_5layer_direct
Xu_t027_003 u_t027_003/c0_w0_bl u_t027_003/c0_w0_br u_t027_003/c0_w1_bl u_t027_003/c0_w1_br
+ u_t027_003/c0_r0_rbl u_t027_003/c0_r1_rbl u_t027_003/c1_w0_bl u_t027_003/c1_w0_br
+ u_t027_003/c1_w1_bl u_t027_003/c1_w1_br u_t027_003/c1_r0_rbl u_t027_003/c1_r1_rbl
+ u_t027_003/c2_w0_bl u_t027_003/c2_w0_br u_t027_003/c2_w1_bl u_t027_003/c2_w1_br
+ u_t027_003/c2_r0_rbl u_t027_003/c2_r1_rbl u_t027_003/c3_w0_bl u_t027_003/c3_w0_br
+ u_t027_003/c3_w1_bl u_t027_003/c3_w1_br u_t027_003/c3_r0_rbl u_t027_003/c3_r1_rbl
+ u_t027_003/r0_w0_wl u_t027_003/r0_w1_wl u_t027_003/r0_r0_rwl u_t027_003/r0_r1_rwl
+ u_t027_003/r1_w0_wl u_t027_003/r1_w1_wl u_t027_003/r1_r0_rwl u_t027_003/r1_r1_rwl
+ u_t027_003/r2_w0_wl u_t027_003/r2_w1_wl u_t027_003/r2_r0_rwl u_t027_003/r2_r1_rwl
+ u_t027_003/r3_w0_wl u_t027_003/r3_w1_wl u_t027_003/r3_r0_rwl u_t027_003/r3_r1_rwl
+ u_t027_003/VDD u_t027_003/VSS VSUBS detronyx_12t_2w2r_rc4_4x4_routed_5layer_direct
Xu_t018_025 u_t018_025/c0_w0_bl u_t018_025/c0_w0_br u_t018_025/c0_w1_bl u_t018_025/c0_w1_br
+ u_t018_025/c0_r0_rbl u_t018_025/c0_r1_rbl u_t018_025/c1_w0_bl u_t018_025/c1_w0_br
+ u_t018_025/c1_w1_bl u_t018_025/c1_w1_br u_t018_025/c1_r0_rbl u_t018_025/c1_r1_rbl
+ u_t018_025/c2_w0_bl u_t018_025/c2_w0_br u_t018_025/c2_w1_bl u_t018_025/c2_w1_br
+ u_t018_025/c2_r0_rbl u_t018_025/c2_r1_rbl u_t018_025/c3_w0_bl u_t018_025/c3_w0_br
+ u_t018_025/c3_w1_bl u_t018_025/c3_w1_br u_t018_025/c3_r0_rbl u_t018_025/c3_r1_rbl
+ u_t018_025/r0_w0_wl u_t018_025/r0_w1_wl u_t018_025/r0_r0_rwl u_t018_025/r0_r1_rwl
+ u_t018_025/r1_w0_wl u_t018_025/r1_w1_wl u_t018_025/r1_r0_rwl u_t018_025/r1_r1_rwl
+ u_t018_025/r2_w0_wl u_t018_025/r2_w1_wl u_t018_025/r2_r0_rwl u_t018_025/r2_r1_rwl
+ u_t018_025/r3_w0_wl u_t018_025/r3_w1_wl u_t018_025/r3_r0_rwl u_t018_025/r3_r1_rwl
+ VSS u_t018_025/VSS VSUBS detronyx_12t_2w2r_rc4_4x4_routed_5layer_direct
Xu_t018_014 u_t018_014/c0_w0_bl u_t018_014/c0_w0_br u_t018_014/c0_w1_bl u_t018_014/c0_w1_br
+ u_t018_014/c0_r0_rbl u_t018_014/c0_r1_rbl u_t018_014/c1_w0_bl u_t018_014/c1_w0_br
+ u_t018_014/c1_w1_bl u_t018_014/c1_w1_br u_t018_014/c1_r0_rbl u_t018_014/c1_r1_rbl
+ u_t018_014/c2_w0_bl u_t018_014/c2_w0_br u_t018_014/c2_w1_bl u_t018_014/c2_w1_br
+ u_t018_014/c2_r0_rbl u_t018_014/c2_r1_rbl u_t018_014/c3_w0_bl u_t018_014/c3_w0_br
+ u_t018_014/c3_w1_bl u_t018_014/c3_w1_br u_t018_014/c3_r0_rbl u_t018_014/c3_r1_rbl
+ u_t018_014/r0_w0_wl u_t018_014/r0_w1_wl u_t018_014/r0_r0_rwl u_t018_014/r0_r1_rwl
+ u_t018_014/r1_w0_wl u_t018_014/r1_w1_wl u_t018_014/r1_r0_rwl u_t018_014/r1_r1_rwl
+ u_t018_014/r2_w0_wl u_t018_014/r2_w1_wl u_t018_014/r2_r0_rwl u_t018_014/r2_r1_rwl
+ u_t018_014/r3_w0_wl u_t018_014/r3_w1_wl u_t018_014/r3_r0_rwl u_t018_014/r3_r1_rwl
+ u_t018_014/VDD u_t018_017/VSS VSUBS detronyx_12t_2w2r_rc4_4x4_routed_5layer_direct
Xu_t018_003 u_t018_003/c0_w0_bl u_t018_003/c0_w0_br u_t018_003/c0_w1_bl u_t018_003/c0_w1_br
+ u_t018_003/c0_r0_rbl u_t018_003/c0_r1_rbl u_t018_003/c1_w0_bl u_t018_003/c1_w0_br
+ u_t018_003/c1_w1_bl u_t018_003/c1_w1_br u_t018_003/c1_r0_rbl u_t018_003/c1_r1_rbl
+ u_t018_003/c2_w0_bl u_t018_003/c2_w0_br u_t018_003/c2_w1_bl u_t018_003/c2_w1_br
+ u_t018_003/c2_r0_rbl u_t018_003/c2_r1_rbl u_t018_003/c3_w0_bl u_t018_003/c3_w0_br
+ u_t018_003/c3_w1_bl u_t018_003/c3_w1_br u_t018_003/c3_r0_rbl u_t018_003/c3_r1_rbl
+ u_t018_003/r0_w0_wl u_t018_003/r0_w1_wl u_t018_003/r0_r0_rwl u_t018_003/r0_r1_rwl
+ u_t018_003/r1_w0_wl u_t018_003/r1_w1_wl u_t018_003/r1_r0_rwl u_t018_003/r1_r1_rwl
+ u_t018_003/r2_w0_wl u_t018_003/r2_w1_wl u_t018_003/r2_r0_rwl u_t018_003/r2_r1_rwl
+ u_t018_003/r3_w0_wl u_t018_003/r3_w1_wl u_t018_003/r3_r0_rwl u_t018_003/r3_r1_rwl
+ u_t018_003/VDD u_t018_003/VSS VSUBS detronyx_12t_2w2r_rc4_4x4_routed_5layer_direct
Xu_t009_025 u_t009_025/c0_w0_bl u_t009_025/c0_w0_br u_t009_025/c0_w1_bl u_t009_025/c0_w1_br
+ u_t009_025/c0_r0_rbl u_t009_025/c0_r1_rbl u_t009_025/c1_w0_bl u_t009_025/c1_w0_br
+ u_t009_025/c1_w1_bl u_t009_025/c1_w1_br u_t009_025/c1_r0_rbl u_t009_025/c1_r1_rbl
+ u_t009_025/c2_w0_bl u_t009_025/c2_w0_br u_t009_025/c2_w1_bl u_t009_025/c2_w1_br
+ u_t009_025/c2_r0_rbl u_t009_025/c2_r1_rbl u_t009_025/c3_w0_bl u_t009_025/c3_w0_br
+ u_t009_025/c3_w1_bl u_t009_025/c3_w1_br u_t009_025/c3_r0_rbl u_t009_025/c3_r1_rbl
+ u_t009_025/r0_w0_wl u_t009_025/r0_w1_wl u_t009_025/r0_r0_rwl u_t009_025/r0_r1_rwl
+ u_t009_025/r1_w0_wl u_t009_025/r1_w1_wl u_t009_025/r1_r0_rwl u_t009_025/r1_r1_rwl
+ u_t009_025/r2_w0_wl u_t009_025/r2_w1_wl u_t009_025/r2_r0_rwl u_t009_025/r2_r1_rwl
+ u_t009_025/r3_w0_wl u_t009_025/r3_w1_wl u_t009_025/r3_r0_rwl u_t009_025/r3_r1_rwl
+ VSS u_t009_031/VSS VSUBS detronyx_12t_2w2r_rc4_4x4_routed_5layer_direct
Xu_t009_014 u_t009_014/c0_w0_bl u_t009_014/c0_w0_br u_t009_014/c0_w1_bl u_t009_014/c0_w1_br
+ u_t009_014/c0_r0_rbl u_t009_014/c0_r1_rbl u_t009_014/c1_w0_bl u_t009_014/c1_w0_br
+ u_t009_014/c1_w1_bl u_t009_014/c1_w1_br u_t009_014/c1_r0_rbl u_t009_014/c1_r1_rbl
+ u_t009_014/c2_w0_bl u_t009_014/c2_w0_br u_t009_014/c2_w1_bl u_t009_014/c2_w1_br
+ u_t009_014/c2_r0_rbl u_t009_014/c2_r1_rbl u_t009_014/c3_w0_bl u_t009_014/c3_w0_br
+ u_t009_014/c3_w1_bl u_t009_014/c3_w1_br u_t009_014/c3_r0_rbl u_t009_014/c3_r1_rbl
+ u_t009_014/r0_w0_wl u_t009_014/r0_w1_wl u_t009_014/r0_r0_rwl u_t009_014/r0_r1_rwl
+ u_t009_014/r1_w0_wl u_t009_014/r1_w1_wl u_t009_014/r1_r0_rwl u_t009_014/r1_r1_rwl
+ u_t009_014/r2_w0_wl u_t009_014/r2_w1_wl u_t009_014/r2_r0_rwl u_t009_014/r2_r1_rwl
+ u_t009_014/r3_w0_wl u_t009_014/r3_w1_wl u_t009_014/r3_r0_rwl u_t009_014/r3_r1_rwl
+ u_t009_014/VDD u_t009_031/VSS VSUBS detronyx_12t_2w2r_rc4_4x4_routed_5layer_direct
Xu_t009_003 u_t009_003/c0_w0_bl u_t009_003/c0_w0_br u_t009_003/c0_w1_bl u_t009_003/c0_w1_br
+ u_t009_003/c0_r0_rbl u_t009_003/c0_r1_rbl u_t009_003/c1_w0_bl u_t009_003/c1_w0_br
+ u_t009_003/c1_w1_bl u_t009_003/c1_w1_br u_t009_003/c1_r0_rbl u_t009_003/c1_r1_rbl
+ u_t009_003/c2_w0_bl u_t009_003/c2_w0_br u_t009_003/c2_w1_bl u_t009_003/c2_w1_br
+ u_t009_003/c2_r0_rbl u_t009_003/c2_r1_rbl u_t009_003/c3_w0_bl u_t009_003/c3_w0_br
+ u_t009_003/c3_w1_bl u_t009_003/c3_w1_br u_t009_003/c3_r0_rbl u_t009_003/c3_r1_rbl
+ u_t009_003/r0_w0_wl u_t009_003/r0_w1_wl u_t009_003/r0_r0_rwl u_t009_003/r0_r1_rwl
+ u_t009_003/r1_w0_wl u_t009_003/r1_w1_wl u_t009_003/r1_r0_rwl u_t009_003/r1_r1_rwl
+ u_t009_003/r2_w0_wl u_t009_003/r2_w1_wl u_t009_003/r2_r0_rwl u_t009_003/r2_r1_rwl
+ u_t009_003/r3_w0_wl u_t009_003/r3_w1_wl u_t009_003/r3_r0_rwl u_t009_003/r3_r1_rwl
+ u_t009_003/VDD u_t009_031/VSS VSUBS detronyx_12t_2w2r_rc4_4x4_routed_5layer_direct
Xgf180mcu_as_sc_mcu7t3v3__nand3_2_29 gf180mcu_as_sc_mcu7t3v3__nor2_2_8/VDD gf180mcu_as_sc_mcu7t3v3__nor2_2_8/VSS
+ VSS VSS VSS VSS gf180mcu_as_sc_mcu7t3v3__nor2_2_8/VNW VSUBS gf180mcu_as_sc_mcu7t3v3__nand3_2
Xgf180mcu_as_sc_mcu7t3v3__nand3_2_18 gf180mcu_as_sc_mcu7t3v3__nor2_2_5/VDD gf180mcu_as_sc_mcu7t3v3__nor2_2_5/VSS
+ VSS VSS VSS VSS gf180mcu_as_sc_mcu7t3v3__nor2_2_5/VNW VSUBS gf180mcu_as_sc_mcu7t3v3__nand3_2
Xu_t024_028 u_t024_028/c0_w0_bl u_t024_028/c0_w0_br u_t024_028/c0_w1_bl u_t024_028/c0_w1_br
+ u_t024_028/c0_r0_rbl u_t024_028/c0_r1_rbl u_t024_028/c1_w0_bl u_t024_028/c1_w0_br
+ u_t024_028/c1_w1_bl u_t024_028/c1_w1_br u_t024_028/c1_r0_rbl u_t024_028/c1_r1_rbl
+ u_t024_028/c2_w0_bl u_t024_028/c2_w0_br u_t024_028/c2_w1_bl u_t024_028/c2_w1_br
+ u_t024_028/c2_r0_rbl u_t024_028/c2_r1_rbl u_t024_028/c3_w0_bl u_t024_028/c3_w0_br
+ u_t024_028/c3_w1_bl u_t024_028/c3_w1_br u_t024_028/c3_r0_rbl u_t024_028/c3_r1_rbl
+ u_t024_028/r0_w0_wl u_t024_028/r0_w1_wl u_t024_028/r0_r0_rwl u_t024_028/r0_r1_rwl
+ u_t024_028/r1_w0_wl u_t024_028/r1_w1_wl u_t024_028/r1_r0_rwl u_t024_028/r1_r1_rwl
+ u_t024_028/r2_w0_wl u_t024_028/r2_w1_wl u_t024_028/r2_r0_rwl u_t024_028/r2_r1_rwl
+ u_t024_028/r3_w0_wl u_t024_028/r3_w1_wl u_t024_028/r3_r0_rwl u_t024_028/r3_r1_rwl
+ u_t025_028/VDD u_t024_028/VSS VSUBS detronyx_12t_2w2r_rc4_4x4_routed_5layer_direct
Xu_t024_017 u_t024_017/c0_w0_bl u_t024_017/c0_w0_br u_t024_017/c0_w1_bl u_t024_017/c0_w1_br
+ u_t024_017/c0_r0_rbl u_t024_017/c0_r1_rbl u_t024_017/c1_w0_bl u_t024_017/c1_w0_br
+ u_t024_017/c1_w1_bl u_t024_017/c1_w1_br u_t024_017/c1_r0_rbl u_t024_017/c1_r1_rbl
+ u_t024_017/c2_w0_bl u_t024_017/c2_w0_br u_t024_017/c2_w1_bl u_t024_017/c2_w1_br
+ u_t024_017/c2_r0_rbl u_t024_017/c2_r1_rbl u_t024_017/c3_w0_bl u_t024_017/c3_w0_br
+ u_t024_017/c3_w1_bl u_t024_017/c3_w1_br u_t024_017/c3_r0_rbl u_t024_017/c3_r1_rbl
+ u_t024_017/r0_w0_wl u_t024_017/r0_w1_wl u_t024_017/r0_r0_rwl u_t024_017/r0_r1_rwl
+ u_t024_017/r1_w0_wl u_t024_017/r1_w1_wl u_t024_017/r1_r0_rwl u_t024_017/r1_r1_rwl
+ u_t024_017/r2_w0_wl u_t024_017/r2_w1_wl u_t024_017/r2_r0_rwl u_t024_017/r2_r1_rwl
+ u_t024_017/r3_w0_wl u_t024_017/r3_w1_wl u_t024_017/r3_r0_rwl u_t024_017/r3_r1_rwl
+ VSS u_t024_017/VSS VSUBS detronyx_12t_2w2r_rc4_4x4_routed_5layer_direct
Xu_t024_006 u_t024_006/c0_w0_bl u_t024_006/c0_w0_br u_t024_006/c0_w1_bl u_t024_006/c0_w1_br
+ u_t024_006/c0_r0_rbl u_t024_006/c0_r1_rbl u_t024_006/c1_w0_bl u_t024_006/c1_w0_br
+ u_t024_006/c1_w1_bl u_t024_006/c1_w1_br u_t024_006/c1_r0_rbl u_t024_006/c1_r1_rbl
+ u_t024_006/c2_w0_bl u_t024_006/c2_w0_br u_t024_006/c2_w1_bl u_t024_006/c2_w1_br
+ u_t024_006/c2_r0_rbl u_t024_006/c2_r1_rbl u_t024_006/c3_w0_bl u_t024_006/c3_w0_br
+ u_t024_006/c3_w1_bl u_t024_006/c3_w1_br u_t024_006/c3_r0_rbl u_t024_006/c3_r1_rbl
+ u_t024_006/r0_w0_wl u_t024_006/r0_w1_wl u_t024_006/r0_r0_rwl u_t024_006/r0_r1_rwl
+ u_t024_006/r1_w0_wl u_t024_006/r1_w1_wl u_t024_006/r1_r0_rwl u_t024_006/r1_r1_rwl
+ u_t024_006/r2_w0_wl u_t024_006/r2_w1_wl u_t024_006/r2_r0_rwl u_t024_006/r2_r1_rwl
+ u_t024_006/r3_w0_wl u_t024_006/r3_w1_wl u_t024_006/r3_r0_rwl u_t024_006/r3_r1_rwl
+ u_t025_006/VDD u_t024_009/VSS VSUBS detronyx_12t_2w2r_rc4_4x4_routed_5layer_direct
Xgf180mcu_as_sc_mcu7t3v3__inv_2_150 VSS gf180mcu_as_sc_mcu7t3v3__inv_2_99/VDD gf180mcu_as_sc_mcu7t3v3__inv_2_150/Y
+ VSS gf180mcu_as_sc_mcu7t3v3__inv_2_150/VNW VSUBS gf180mcu_as_sc_mcu7t3v3__inv_2
Xgf180mcu_as_sc_mcu7t3v3__inv_2_183 gf180mcu_as_sc_mcu7t3v3__inv_2_184/VDD gf180mcu_as_sc_mcu7t3v3__inv_2_200/VDD
+ gf180mcu_as_sc_mcu7t3v3__inv_2_183/Y VSS gf180mcu_as_sc_mcu7t3v3__inv_2_184/VNW
+ VSUBS gf180mcu_as_sc_mcu7t3v3__inv_2
Xgf180mcu_as_sc_mcu7t3v3__inv_2_172 VSS gf180mcu_as_sc_mcu7t3v3__inv_2_177/VDD gf180mcu_as_sc_mcu7t3v3__inv_2_172/Y
+ VSS gf180mcu_as_sc_mcu7t3v3__inv_2_173/VNW VSUBS gf180mcu_as_sc_mcu7t3v3__inv_2
Xgf180mcu_as_sc_mcu7t3v3__inv_2_161 gf180mcu_as_sc_mcu7t3v3__inv_2_196/VSS gf180mcu_as_sc_mcu7t3v3__inv_2_165/VDD
+ gf180mcu_as_sc_mcu7t3v3__inv_2_161/Y VSS gf180mcu_as_sc_mcu7t3v3__inv_2_161/VNW
+ VSUBS gf180mcu_as_sc_mcu7t3v3__inv_2
Xgf180mcu_as_sc_mcu7t3v3__inv_2_194 VSS gf180mcu_as_sc_mcu7t3v3__inv_2_196/VSS VSS
+ VSS gf180mcu_as_sc_mcu7t3v3__inv_2_196/VNW VSUBS gf180mcu_as_sc_mcu7t3v3__inv_2
Xgf180mcu_as_sc_mcu7t3v3__inv_2_1649 gf180mcu_as_sc_mcu7t3v3__inv_2_1669/VDD VSS gf180mcu_as_sc_mcu7t3v3__inv_2_1675/Y
+ gf180mcu_as_sc_mcu7t3v3__inv_2_1675/Y gf180mcu_as_sc_mcu7t3v3__inv_2_1669/VNW VSUBS
+ gf180mcu_as_sc_mcu7t3v3__inv_2
Xgf180mcu_as_sc_mcu7t3v3__inv_2_1627 VSS gf180mcu_as_sc_mcu7t3v3__inv_2_1671/VDD VSS
+ gf180mcu_as_sc_mcu7t3v3__inv_2_1675/Y gf180mcu_as_sc_mcu7t3v3__inv_2_1670/VNW VSUBS
+ gf180mcu_as_sc_mcu7t3v3__inv_2
Xgf180mcu_as_sc_mcu7t3v3__inv_2_1638 VSS VSS VSS gf180mcu_as_sc_mcu7t3v3__inv_2_1682/Y
+ gf180mcu_as_sc_mcu7t3v3__inv_2_1679/VNW VSUBS gf180mcu_as_sc_mcu7t3v3__inv_2
Xgf180mcu_as_sc_mcu7t3v3__inv_2_1605 gf180mcu_as_sc_mcu7t3v3__inv_2_1682/VSS gf180mcu_as_sc_mcu7t3v3__inv_2_1665/VDD
+ gf180mcu_as_sc_mcu7t3v3__inv_2_1605/Y gf180mcu_as_sc_mcu7t3v3__inv_2_1682/Y gf180mcu_as_sc_mcu7t3v3__inv_2_1664/VNW
+ VSUBS gf180mcu_as_sc_mcu7t3v3__inv_2
Xgf180mcu_as_sc_mcu7t3v3__inv_2_1616 VSS gf180mcu_as_sc_mcu7t3v3__inv_2_1663/VDD VSS
+ gf180mcu_as_sc_mcu7t3v3__inv_2_1685/Y gf180mcu_as_sc_mcu7t3v3__inv_2_1662/VNW VSUBS
+ gf180mcu_as_sc_mcu7t3v3__inv_2
Xu_t015_028 u_t015_028/c0_w0_bl u_t015_028/c0_w0_br u_t015_028/c0_w1_bl u_t015_028/c0_w1_br
+ u_t015_028/c0_r0_rbl u_t015_028/c0_r1_rbl u_t015_028/c1_w0_bl u_t015_028/c1_w0_br
+ u_t015_028/c1_w1_bl u_t015_028/c1_w1_br u_t015_028/c1_r0_rbl u_t015_028/c1_r1_rbl
+ u_t015_028/c2_w0_bl u_t015_028/c2_w0_br u_t015_028/c2_w1_bl u_t015_028/c2_w1_br
+ u_t015_028/c2_r0_rbl u_t015_028/c2_r1_rbl u_t015_028/c3_w0_bl u_t015_028/c3_w0_br
+ u_t015_028/c3_w1_bl u_t015_028/c3_w1_br u_t015_028/c3_r0_rbl u_t015_028/c3_r1_rbl
+ u_t015_028/r0_w0_wl u_t015_028/r0_w1_wl u_t015_028/r0_r0_rwl u_t015_028/r0_r1_rwl
+ u_t015_028/r1_w0_wl u_t015_028/r1_w1_wl u_t015_028/r1_r0_rwl u_t015_028/r1_r1_rwl
+ u_t015_028/r2_w0_wl u_t015_028/r2_w1_wl u_t015_028/r2_r0_rwl u_t015_028/r2_r1_rwl
+ u_t015_028/r3_w0_wl u_t015_028/r3_w1_wl u_t015_028/r3_r0_rwl u_t015_028/r3_r1_rwl
+ u_t015_028/VDD u_t015_028/VSS VSUBS detronyx_12t_2w2r_rc4_4x4_routed_5layer_direct
Xu_t015_017 u_t015_017/c0_w0_bl u_t015_017/c0_w0_br u_t015_017/c0_w1_bl u_t015_017/c0_w1_br
+ u_t015_017/c0_r0_rbl u_t015_017/c0_r1_rbl u_t015_017/c1_w0_bl u_t015_017/c1_w0_br
+ u_t015_017/c1_w1_bl u_t015_017/c1_w1_br u_t015_017/c1_r0_rbl u_t015_017/c1_r1_rbl
+ u_t015_017/c2_w0_bl u_t015_017/c2_w0_br u_t015_017/c2_w1_bl u_t015_017/c2_w1_br
+ u_t015_017/c2_r0_rbl u_t015_017/c2_r1_rbl u_t015_017/c3_w0_bl u_t015_017/c3_w0_br
+ u_t015_017/c3_w1_bl u_t015_017/c3_w1_br u_t015_017/c3_r0_rbl u_t015_017/c3_r1_rbl
+ u_t015_017/r0_w0_wl u_t015_017/r0_w1_wl u_t015_017/r0_r0_rwl u_t015_017/r0_r1_rwl
+ u_t015_017/r1_w0_wl u_t015_017/r1_w1_wl u_t015_017/r1_r0_rwl u_t015_017/r1_r1_rwl
+ u_t015_017/r2_w0_wl u_t015_017/r2_w1_wl u_t015_017/r2_r0_rwl u_t015_017/r2_r1_rwl
+ u_t015_017/r3_w0_wl u_t015_017/r3_w1_wl u_t015_017/r3_r0_rwl u_t015_017/r3_r1_rwl
+ VSS u_t015_017/VSS VSUBS detronyx_12t_2w2r_rc4_4x4_routed_5layer_direct
Xu_t015_006 u_t015_006/c0_w0_bl u_t015_006/c0_w0_br u_t015_006/c0_w1_bl u_t015_006/c0_w1_br
+ u_t015_006/c0_r0_rbl u_t015_006/c0_r1_rbl u_t015_006/c1_w0_bl u_t015_006/c1_w0_br
+ u_t015_006/c1_w1_bl u_t015_006/c1_w1_br u_t015_006/c1_r0_rbl u_t015_006/c1_r1_rbl
+ u_t015_006/c2_w0_bl u_t015_006/c2_w0_br u_t015_006/c2_w1_bl u_t015_006/c2_w1_br
+ u_t015_006/c2_r0_rbl u_t015_006/c2_r1_rbl u_t015_006/c3_w0_bl u_t015_006/c3_w0_br
+ u_t015_006/c3_w1_bl u_t015_006/c3_w1_br u_t015_006/c3_r0_rbl u_t015_006/c3_r1_rbl
+ u_t015_006/r0_w0_wl u_t015_006/r0_w1_wl u_t015_006/r0_r0_rwl u_t015_006/r0_r1_rwl
+ u_t015_006/r1_w0_wl u_t015_006/r1_w1_wl u_t015_006/r1_r0_rwl u_t015_006/r1_r1_rwl
+ u_t015_006/r2_w0_wl u_t015_006/r2_w1_wl u_t015_006/r2_r0_rwl u_t015_006/r2_r1_rwl
+ u_t015_006/r3_w0_wl u_t015_006/r3_w1_wl u_t015_006/r3_r0_rwl u_t015_006/r3_r1_rwl
+ u_t015_006/VDD u_t015_009/VSS VSUBS detronyx_12t_2w2r_rc4_4x4_routed_5layer_direct
Xu_t030_009 u_t030_009/c0_w0_bl u_t030_009/c0_w0_br u_t030_009/c0_w1_bl u_t030_009/c0_w1_br
+ u_t030_009/c0_r0_rbl u_t030_009/c0_r1_rbl u_t030_009/c1_w0_bl u_t030_009/c1_w0_br
+ u_t030_009/c1_w1_bl u_t030_009/c1_w1_br u_t030_009/c1_r0_rbl u_t030_009/c1_r1_rbl
+ u_t030_009/c2_w0_bl u_t030_009/c2_w0_br u_t030_009/c2_w1_bl u_t030_009/c2_w1_br
+ u_t030_009/c2_r0_rbl u_t030_009/c2_r1_rbl u_t030_009/c3_w0_bl u_t030_009/c3_w0_br
+ u_t030_009/c3_w1_bl u_t030_009/c3_w1_br u_t030_009/c3_r0_rbl u_t030_009/c3_r1_rbl
+ u_t030_009/r0_w0_wl u_t030_009/r0_w1_wl u_t030_009/r0_r0_rwl u_t030_009/r0_r1_rwl
+ u_t030_009/r1_w0_wl u_t030_009/r1_w1_wl u_t030_009/r1_r0_rwl u_t030_009/r1_r1_rwl
+ u_t030_009/r2_w0_wl u_t030_009/r2_w1_wl u_t030_009/r2_r0_rwl u_t030_009/r2_r1_rwl
+ u_t030_009/r3_w0_wl u_t030_009/r3_w1_wl u_t030_009/r3_r0_rwl u_t030_009/r3_r1_rwl
+ VSS u_t030_031/VSS VSUBS detronyx_12t_2w2r_rc4_4x4_routed_5layer_direct
Xu_t006_028 u_t006_028/c0_w0_bl u_t006_028/c0_w0_br u_t006_028/c0_w1_bl u_t006_028/c0_w1_br
+ u_t006_028/c0_r0_rbl u_t006_028/c0_r1_rbl u_t006_028/c1_w0_bl u_t006_028/c1_w0_br
+ u_t006_028/c1_w1_bl u_t006_028/c1_w1_br u_t006_028/c1_r0_rbl u_t006_028/c1_r1_rbl
+ u_t006_028/c2_w0_bl u_t006_028/c2_w0_br u_t006_028/c2_w1_bl u_t006_028/c2_w1_br
+ u_t006_028/c2_r0_rbl u_t006_028/c2_r1_rbl u_t006_028/c3_w0_bl u_t006_028/c3_w0_br
+ u_t006_028/c3_w1_bl u_t006_028/c3_w1_br u_t006_028/c3_r0_rbl u_t006_028/c3_r1_rbl
+ u_t006_028/r0_w0_wl u_t006_028/r0_w1_wl u_t006_028/r0_r0_rwl u_t006_028/r0_r1_rwl
+ u_t006_028/r1_w0_wl u_t006_028/r1_w1_wl u_t006_028/r1_r0_rwl u_t006_028/r1_r1_rwl
+ u_t006_028/r2_w0_wl u_t006_028/r2_w1_wl u_t006_028/r2_r0_rwl u_t006_028/r2_r1_rwl
+ u_t006_028/r3_w0_wl u_t006_028/r3_w1_wl u_t006_028/r3_r0_rwl u_t006_028/r3_r1_rwl
+ u_t006_028/VDD u_t006_028/VSS VSUBS detronyx_12t_2w2r_rc4_4x4_routed_5layer_direct
Xu_t006_017 u_t006_017/c0_w0_bl u_t006_017/c0_w0_br u_t006_017/c0_w1_bl u_t006_017/c0_w1_br
+ u_t006_017/c0_r0_rbl u_t006_017/c0_r1_rbl u_t006_017/c1_w0_bl u_t006_017/c1_w0_br
+ u_t006_017/c1_w1_bl u_t006_017/c1_w1_br u_t006_017/c1_r0_rbl u_t006_017/c1_r1_rbl
+ u_t006_017/c2_w0_bl u_t006_017/c2_w0_br u_t006_017/c2_w1_bl u_t006_017/c2_w1_br
+ u_t006_017/c2_r0_rbl u_t006_017/c2_r1_rbl u_t006_017/c3_w0_bl u_t006_017/c3_w0_br
+ u_t006_017/c3_w1_bl u_t006_017/c3_w1_br u_t006_017/c3_r0_rbl u_t006_017/c3_r1_rbl
+ u_t006_017/r0_w0_wl u_t006_017/r0_w1_wl u_t006_017/r0_r0_rwl u_t006_017/r0_r1_rwl
+ u_t006_017/r1_w0_wl u_t006_017/r1_w1_wl u_t006_017/r1_r0_rwl u_t006_017/r1_r1_rwl
+ u_t006_017/r2_w0_wl u_t006_017/r2_w1_wl u_t006_017/r2_r0_rwl u_t006_017/r2_r1_rwl
+ u_t006_017/r3_w0_wl u_t006_017/r3_w1_wl u_t006_017/r3_r0_rwl u_t006_017/r3_r1_rwl
+ VSS u_t006_017/VSS VSUBS detronyx_12t_2w2r_rc4_4x4_routed_5layer_direct
Xu_t021_009 u_t021_009/c0_w0_bl u_t021_009/c0_w0_br u_t021_009/c0_w1_bl u_t021_009/c0_w1_br
+ u_t021_009/c0_r0_rbl u_t021_009/c0_r1_rbl u_t021_009/c1_w0_bl u_t021_009/c1_w0_br
+ u_t021_009/c1_w1_bl u_t021_009/c1_w1_br u_t021_009/c1_r0_rbl u_t021_009/c1_r1_rbl
+ u_t021_009/c2_w0_bl u_t021_009/c2_w0_br u_t021_009/c2_w1_bl u_t021_009/c2_w1_br
+ u_t021_009/c2_r0_rbl u_t021_009/c2_r1_rbl u_t021_009/c3_w0_bl u_t021_009/c3_w0_br
+ u_t021_009/c3_w1_bl u_t021_009/c3_w1_br u_t021_009/c3_r0_rbl u_t021_009/c3_r1_rbl
+ u_t021_009/r0_w0_wl u_t021_009/r0_w1_wl u_t021_009/r0_r0_rwl u_t021_009/r0_r1_rwl
+ u_t021_009/r1_w0_wl u_t021_009/r1_w1_wl u_t021_009/r1_r0_rwl u_t021_009/r1_r1_rwl
+ u_t021_009/r2_w0_wl u_t021_009/r2_w1_wl u_t021_009/r2_r0_rwl u_t021_009/r2_r1_rwl
+ u_t021_009/r3_w0_wl u_t021_009/r3_w1_wl u_t021_009/r3_r0_rwl u_t021_009/r3_r1_rwl
+ VSS u_t021_031/VSS VSUBS detronyx_12t_2w2r_rc4_4x4_routed_5layer_direct
Xu_t006_006 u_t006_006/c0_w0_bl u_t006_006/c0_w0_br u_t006_006/c0_w1_bl u_t006_006/c0_w1_br
+ u_t006_006/c0_r0_rbl u_t006_006/c0_r1_rbl u_t006_006/c1_w0_bl u_t006_006/c1_w0_br
+ u_t006_006/c1_w1_bl u_t006_006/c1_w1_br u_t006_006/c1_r0_rbl u_t006_006/c1_r1_rbl
+ u_t006_006/c2_w0_bl u_t006_006/c2_w0_br u_t006_006/c2_w1_bl u_t006_006/c2_w1_br
+ u_t006_006/c2_r0_rbl u_t006_006/c2_r1_rbl u_t006_006/c3_w0_bl u_t006_006/c3_w0_br
+ u_t006_006/c3_w1_bl u_t006_006/c3_w1_br u_t006_006/c3_r0_rbl u_t006_006/c3_r1_rbl
+ u_t006_006/r0_w0_wl u_t006_006/r0_w1_wl u_t006_006/r0_r0_rwl u_t006_006/r0_r1_rwl
+ u_t006_006/r1_w0_wl u_t006_006/r1_w1_wl u_t006_006/r1_r0_rwl u_t006_006/r1_r1_rwl
+ u_t006_006/r2_w0_wl u_t006_006/r2_w1_wl u_t006_006/r2_r0_rwl u_t006_006/r2_r1_rwl
+ u_t006_006/r3_w0_wl u_t006_006/r3_w1_wl u_t006_006/r3_r0_rwl u_t006_006/r3_r1_rwl
+ u_t006_006/VDD u_t006_009/VSS VSUBS detronyx_12t_2w2r_rc4_4x4_routed_5layer_direct
Xgf180mcu_as_sc_mcu7t3v3__nand2_2_51 gf180mcu_as_sc_mcu7t3v3__nand3_2_31/VDD gf180mcu_as_sc_mcu7t3v3__nor2_2_8/VSS
+ VSS VSS VSS gf180mcu_as_sc_mcu7t3v3__nand3_2_31/VNW VSUBS gf180mcu_as_sc_mcu7t3v3__nand2_2
Xgf180mcu_as_sc_mcu7t3v3__nand2_2_62 gf180mcu_as_sc_mcu7t3v3__nand3_2_31/VDD gf180mcu_as_sc_mcu7t3v3__nand3_2_31/VSS
+ VSS VSS VSS gf180mcu_as_sc_mcu7t3v3__nand3_2_31/VNW VSUBS gf180mcu_as_sc_mcu7t3v3__nand2_2
Xgf180mcu_as_sc_mcu7t3v3__nand2_2_40 gf180mcu_as_sc_mcu7t3v3__nand3_2_5/VDD gf180mcu_as_sc_mcu7t3v3__nor2_2_6/VSS
+ VSS VSS VSS gf180mcu_as_sc_mcu7t3v3__nand3_2_5/VNW VSUBS gf180mcu_as_sc_mcu7t3v3__nand2_2
Xu_t020_031 u_t020_031/c0_w0_bl u_t020_031/c0_w0_br u_t020_031/c0_w1_bl u_t020_031/c0_w1_br
+ u_t020_031/c0_r0_rbl u_t020_031/c0_r1_rbl u_t020_031/c1_w0_bl u_t020_031/c1_w0_br
+ u_t020_031/c1_w1_bl u_t020_031/c1_w1_br u_t020_031/c1_r0_rbl u_t020_031/c1_r1_rbl
+ u_t020_031/c2_w0_bl u_t020_031/c2_w0_br u_t020_031/c2_w1_bl u_t020_031/c2_w1_br
+ u_t020_031/c2_r0_rbl u_t020_031/c2_r1_rbl u_t020_031/c3_w0_bl u_t020_031/c3_w0_br
+ u_t020_031/c3_w1_bl u_t020_031/c3_w1_br u_t020_031/c3_r0_rbl u_t020_031/c3_r1_rbl
+ u_t020_031/r0_w0_wl u_t020_031/r0_w1_wl u_t020_031/r0_r0_rwl u_t020_031/r0_r1_rwl
+ u_t020_031/r1_w0_wl u_t020_031/r1_w1_wl u_t020_031/r1_r0_rwl u_t020_031/r1_r1_rwl
+ u_t020_031/r2_w0_wl u_t020_031/r2_w1_wl u_t020_031/r2_r0_rwl u_t020_031/r2_r1_rwl
+ u_t020_031/r3_w0_wl u_t020_031/r3_w1_wl u_t020_031/r3_r0_rwl u_t020_031/r3_r1_rwl
+ VSS u_t020_031/VSS VSUBS detronyx_12t_2w2r_rc4_4x4_routed_5layer_direct
Xu_t020_020 u_t020_020/c0_w0_bl u_t020_020/c0_w0_br u_t020_020/c0_w1_bl u_t020_020/c0_w1_br
+ u_t020_020/c0_r0_rbl u_t020_020/c0_r1_rbl u_t020_020/c1_w0_bl u_t020_020/c1_w0_br
+ u_t020_020/c1_w1_bl u_t020_020/c1_w1_br u_t020_020/c1_r0_rbl u_t020_020/c1_r1_rbl
+ u_t020_020/c2_w0_bl u_t020_020/c2_w0_br u_t020_020/c2_w1_bl u_t020_020/c2_w1_br
+ u_t020_020/c2_r0_rbl u_t020_020/c2_r1_rbl u_t020_020/c3_w0_bl u_t020_020/c3_w0_br
+ u_t020_020/c3_w1_bl u_t020_020/c3_w1_br u_t020_020/c3_r0_rbl u_t020_020/c3_r1_rbl
+ u_t020_020/r0_w0_wl u_t020_020/r0_w1_wl u_t020_020/r0_r0_rwl u_t020_020/r0_r1_rwl
+ u_t020_020/r1_w0_wl u_t020_020/r1_w1_wl u_t020_020/r1_r0_rwl u_t020_020/r1_r1_rwl
+ u_t020_020/r2_w0_wl u_t020_020/r2_w1_wl u_t020_020/r2_r0_rwl u_t020_020/r2_r1_rwl
+ u_t020_020/r3_w0_wl u_t020_020/r3_w1_wl u_t020_020/r3_r0_rwl u_t020_020/r3_r1_rwl
+ u_t020_020/VDD u_t020_020/VSS VSUBS detronyx_12t_2w2r_rc4_4x4_routed_5layer_direct
Xu_t012_009 u_t012_009/c0_w0_bl u_t012_009/c0_w0_br u_t012_009/c0_w1_bl u_t012_009/c0_w1_br
+ u_t012_009/c0_r0_rbl u_t012_009/c0_r1_rbl u_t012_009/c1_w0_bl u_t012_009/c1_w0_br
+ u_t012_009/c1_w1_bl u_t012_009/c1_w1_br u_t012_009/c1_r0_rbl u_t012_009/c1_r1_rbl
+ u_t012_009/c2_w0_bl u_t012_009/c2_w0_br u_t012_009/c2_w1_bl u_t012_009/c2_w1_br
+ u_t012_009/c2_r0_rbl u_t012_009/c2_r1_rbl u_t012_009/c3_w0_bl u_t012_009/c3_w0_br
+ u_t012_009/c3_w1_bl u_t012_009/c3_w1_br u_t012_009/c3_r0_rbl u_t012_009/c3_r1_rbl
+ u_t012_009/r0_w0_wl u_t012_009/r0_w1_wl u_t012_009/r0_r0_rwl u_t012_009/r0_r1_rwl
+ u_t012_009/r1_w0_wl u_t012_009/r1_w1_wl u_t012_009/r1_r0_rwl u_t012_009/r1_r1_rwl
+ u_t012_009/r2_w0_wl u_t012_009/r2_w1_wl u_t012_009/r2_r0_rwl u_t012_009/r2_r1_rwl
+ u_t012_009/r3_w0_wl u_t012_009/r3_w1_wl u_t012_009/r3_r0_rwl u_t012_009/r3_r1_rwl
+ VSS u_t012_031/VSS VSUBS detronyx_12t_2w2r_rc4_4x4_routed_5layer_direct
Xgf180mcu_as_sc_mcu7t3v3__inv_2_1413 VSS gf180mcu_as_sc_mcu7t3v3__inv_2_1694/VDD gf180mcu_as_sc_mcu7t3v3__inv_2_1413/Y
+ VSS gf180mcu_as_sc_mcu7t3v3__inv_2_1413/VNW VSUBS gf180mcu_as_sc_mcu7t3v3__inv_2
Xgf180mcu_as_sc_mcu7t3v3__inv_2_1435 VSS gf180mcu_as_sc_mcu7t3v3__inv_2_1440/VDD VSS
+ VSS gf180mcu_as_sc_mcu7t3v3__inv_2_1436/VNW VSUBS gf180mcu_as_sc_mcu7t3v3__inv_2
Xgf180mcu_as_sc_mcu7t3v3__inv_2_1424 VSS gf180mcu_as_sc_mcu7t3v3__inv_2_1428/VDD VSS
+ VSS gf180mcu_as_sc_mcu7t3v3__inv_2_1424/VNW VSUBS gf180mcu_as_sc_mcu7t3v3__inv_2
Xgf180mcu_as_sc_mcu7t3v3__inv_2_1402 gf180mcu_as_sc_mcu7t3v3__inv_2_1433/VSS VSS VSS
+ VSS gf180mcu_as_sc_mcu7t3v3__inv_2_1404/VNW VSUBS gf180mcu_as_sc_mcu7t3v3__inv_2
Xgf180mcu_as_sc_mcu7t3v3__inv_2_1468 gf180mcu_as_sc_mcu7t3v3__inv_2_1468/VDD VSS gf180mcu_as_sc_mcu7t3v3__inv_2_1468/Y
+ VSS gf180mcu_as_sc_mcu7t3v3__inv_2_1468/VNW VSUBS gf180mcu_as_sc_mcu7t3v3__inv_2
Xgf180mcu_as_sc_mcu7t3v3__inv_2_1479 gf180mcu_as_sc_mcu7t3v3__inv_2_1480/VDD VSS gf180mcu_as_sc_mcu7t3v3__inv_2_1479/Y
+ VSS gf180mcu_as_sc_mcu7t3v3__inv_2_1480/VNW VSUBS gf180mcu_as_sc_mcu7t3v3__inv_2
Xgf180mcu_as_sc_mcu7t3v3__inv_2_1446 VSS VSS VSS VSS gf180mcu_as_sc_mcu7t3v3__inv_2_1448/VNW
+ VSUBS gf180mcu_as_sc_mcu7t3v3__inv_2
Xgf180mcu_as_sc_mcu7t3v3__inv_2_1457 gf180mcu_as_sc_mcu7t3v3__inv_2_1457/VDD VSS VSS
+ VSS gf180mcu_as_sc_mcu7t3v3__inv_2_1457/VNW VSUBS gf180mcu_as_sc_mcu7t3v3__inv_2
Xu_t003_009 u_t003_009/c0_w0_bl u_t003_009/c0_w0_br u_t003_009/c0_w1_bl u_t003_009/c0_w1_br
+ u_t003_009/c0_r0_rbl u_t003_009/c0_r1_rbl u_t003_009/c1_w0_bl u_t003_009/c1_w0_br
+ u_t003_009/c1_w1_bl u_t003_009/c1_w1_br u_t003_009/c1_r0_rbl u_t003_009/c1_r1_rbl
+ u_t003_009/c2_w0_bl u_t003_009/c2_w0_br u_t003_009/c2_w1_bl u_t003_009/c2_w1_br
+ u_t003_009/c2_r0_rbl u_t003_009/c2_r1_rbl u_t003_009/c3_w0_bl u_t003_009/c3_w0_br
+ u_t003_009/c3_w1_bl u_t003_009/c3_w1_br u_t003_009/c3_r0_rbl u_t003_009/c3_r1_rbl
+ u_t003_009/r0_w0_wl u_t003_009/r0_w1_wl u_t003_009/r0_r0_rwl u_t003_009/r0_r1_rwl
+ u_t003_009/r1_w0_wl u_t003_009/r1_w1_wl u_t003_009/r1_r0_rwl u_t003_009/r1_r1_rwl
+ u_t003_009/r2_w0_wl u_t003_009/r2_w1_wl u_t003_009/r2_r0_rwl u_t003_009/r2_r1_rwl
+ u_t003_009/r3_w0_wl u_t003_009/r3_w1_wl u_t003_009/r3_r0_rwl u_t003_009/r3_r1_rwl
+ VSS u_t003_009/VSS VSUBS detronyx_12t_2w2r_rc4_4x4_routed_5layer_direct
Xgf180mcu_as_sc_mcu7t3v3__inv_2_919 VSS VSS VSS VSS gf180mcu_as_sc_mcu7t3v3__inv_2_920/VNW
+ VSUBS gf180mcu_as_sc_mcu7t3v3__inv_2
Xgf180mcu_as_sc_mcu7t3v3__inv_2_908 VSS VSS VSS VSS gf180mcu_as_sc_mcu7t3v3__inv_2_909/VNW
+ VSUBS gf180mcu_as_sc_mcu7t3v3__inv_2
Xu_t011_031 u_t011_031/c0_w0_bl u_t011_031/c0_w0_br u_t011_031/c0_w1_bl u_t011_031/c0_w1_br
+ u_t011_031/c0_r0_rbl u_t011_031/c0_r1_rbl u_t011_031/c1_w0_bl u_t011_031/c1_w0_br
+ u_t011_031/c1_w1_bl u_t011_031/c1_w1_br u_t011_031/c1_r0_rbl u_t011_031/c1_r1_rbl
+ u_t011_031/c2_w0_bl u_t011_031/c2_w0_br u_t011_031/c2_w1_bl u_t011_031/c2_w1_br
+ u_t011_031/c2_r0_rbl u_t011_031/c2_r1_rbl u_t011_031/c3_w0_bl u_t011_031/c3_w0_br
+ u_t011_031/c3_w1_bl u_t011_031/c3_w1_br u_t011_031/c3_r0_rbl u_t011_031/c3_r1_rbl
+ u_t011_031/r0_w0_wl u_t011_031/r0_w1_wl u_t011_031/r0_r0_rwl u_t011_031/r0_r1_rwl
+ u_t011_031/r1_w0_wl u_t011_031/r1_w1_wl u_t011_031/r1_r0_rwl u_t011_031/r1_r1_rwl
+ u_t011_031/r2_w0_wl u_t011_031/r2_w1_wl u_t011_031/r2_r0_rwl u_t011_031/r2_r1_rwl
+ u_t011_031/r3_w0_wl u_t011_031/r3_w1_wl u_t011_031/r3_r0_rwl u_t011_031/r3_r1_rwl
+ VSS u_t011_031/VSS VSUBS detronyx_12t_2w2r_rc4_4x4_routed_5layer_direct
Xu_t011_020 u_t011_020/c0_w0_bl u_t011_020/c0_w0_br u_t011_020/c0_w1_bl u_t011_020/c0_w1_br
+ u_t011_020/c0_r0_rbl u_t011_020/c0_r1_rbl u_t011_020/c1_w0_bl u_t011_020/c1_w0_br
+ u_t011_020/c1_w1_bl u_t011_020/c1_w1_br u_t011_020/c1_r0_rbl u_t011_020/c1_r1_rbl
+ u_t011_020/c2_w0_bl u_t011_020/c2_w0_br u_t011_020/c2_w1_bl u_t011_020/c2_w1_br
+ u_t011_020/c2_r0_rbl u_t011_020/c2_r1_rbl u_t011_020/c3_w0_bl u_t011_020/c3_w0_br
+ u_t011_020/c3_w1_bl u_t011_020/c3_w1_br u_t011_020/c3_r0_rbl u_t011_020/c3_r1_rbl
+ u_t011_020/r0_w0_wl u_t011_020/r0_w1_wl u_t011_020/r0_r0_rwl u_t011_020/r0_r1_rwl
+ u_t011_020/r1_w0_wl u_t011_020/r1_w1_wl u_t011_020/r1_r0_rwl u_t011_020/r1_r1_rwl
+ u_t011_020/r2_w0_wl u_t011_020/r2_w1_wl u_t011_020/r2_r0_rwl u_t011_020/r2_r1_rwl
+ u_t011_020/r3_w0_wl u_t011_020/r3_w1_wl u_t011_020/r3_r0_rwl u_t011_020/r3_r1_rwl
+ u_t011_020/VDD u_t011_020/VSS VSUBS detronyx_12t_2w2r_rc4_4x4_routed_5layer_direct
Xgf180mcu_as_sc_mcu7t3v3__nand4_2_218 VSS VSS VSS VSS VSS VSS VSS gf180mcu_as_sc_mcu7t3v3__inv_2_764/VNW
+ VSUBS gf180mcu_as_sc_mcu7t3v3__nand4_2
Xgf180mcu_as_sc_mcu7t3v3__nand4_2_229 VSS VSS VSS VSS VSS VSS VSS gf180mcu_as_sc_mcu7t3v3__inv_2_781/VNW
+ VSUBS gf180mcu_as_sc_mcu7t3v3__nand4_2
Xgf180mcu_as_sc_mcu7t3v3__nand4_2_207 gf180mcu_as_sc_mcu7t3v3__inv_2_659/VDD gf180mcu_as_sc_mcu7t3v3__inv_2_663/VDD
+ VSS VSS VSS VSS VSS gf180mcu_as_sc_mcu7t3v3__inv_2_659/VNW VSUBS gf180mcu_as_sc_mcu7t3v3__nand4_2
Xu_t002_031 u_t002_031/c0_w0_bl u_t002_031/c0_w0_br u_t002_031/c0_w1_bl u_t002_031/c0_w1_br
+ u_t002_031/c0_r0_rbl u_t002_031/c0_r1_rbl u_t002_031/c1_w0_bl u_t002_031/c1_w0_br
+ u_t002_031/c1_w1_bl u_t002_031/c1_w1_br u_t002_031/c1_r0_rbl u_t002_031/c1_r1_rbl
+ u_t002_031/c2_w0_bl u_t002_031/c2_w0_br u_t002_031/c2_w1_bl u_t002_031/c2_w1_br
+ u_t002_031/c2_r0_rbl u_t002_031/c2_r1_rbl u_t002_031/c3_w0_bl u_t002_031/c3_w0_br
+ u_t002_031/c3_w1_bl u_t002_031/c3_w1_br u_t002_031/c3_r0_rbl u_t002_031/c3_r1_rbl
+ u_t002_031/r0_w0_wl u_t002_031/r0_w1_wl u_t002_031/r0_r0_rwl u_t002_031/r0_r1_rwl
+ u_t002_031/r1_w0_wl u_t002_031/r1_w1_wl u_t002_031/r1_r0_rwl u_t002_031/r1_r1_rwl
+ u_t002_031/r2_w0_wl u_t002_031/r2_w1_wl u_t002_031/r2_r0_rwl u_t002_031/r2_r1_rwl
+ u_t002_031/r3_w0_wl u_t002_031/r3_w1_wl u_t002_031/r3_r0_rwl u_t002_031/r3_r1_rwl
+ VSS u_t002_031/VSS VSUBS detronyx_12t_2w2r_rc4_4x4_routed_5layer_direct
Xu_t002_020 u_t002_020/c0_w0_bl u_t002_020/c0_w0_br u_t002_020/c0_w1_bl u_t002_020/c0_w1_br
+ u_t002_020/c0_r0_rbl u_t002_020/c0_r1_rbl u_t002_020/c1_w0_bl u_t002_020/c1_w0_br
+ u_t002_020/c1_w1_bl u_t002_020/c1_w1_br u_t002_020/c1_r0_rbl u_t002_020/c1_r1_rbl
+ u_t002_020/c2_w0_bl u_t002_020/c2_w0_br u_t002_020/c2_w1_bl u_t002_020/c2_w1_br
+ u_t002_020/c2_r0_rbl u_t002_020/c2_r1_rbl u_t002_020/c3_w0_bl u_t002_020/c3_w0_br
+ u_t002_020/c3_w1_bl u_t002_020/c3_w1_br u_t002_020/c3_r0_rbl u_t002_020/c3_r1_rbl
+ u_t002_020/r0_w0_wl u_t002_020/r0_w1_wl u_t002_020/r0_r0_rwl u_t002_020/r0_r1_rwl
+ u_t002_020/r1_w0_wl u_t002_020/r1_w1_wl u_t002_020/r1_r0_rwl u_t002_020/r1_r1_rwl
+ u_t002_020/r2_w0_wl u_t002_020/r2_w1_wl u_t002_020/r2_r0_rwl u_t002_020/r2_r1_rwl
+ u_t002_020/r3_w0_wl u_t002_020/r3_w1_wl u_t002_020/r3_r0_rwl u_t002_020/r3_r1_rwl
+ u_t002_020/VDD u_t002_020/VSS VSUBS detronyx_12t_2w2r_rc4_4x4_routed_5layer_direct
Xgf180mcu_as_sc_mcu7t3v3__inv_2_1254 gf180mcu_as_sc_mcu7t3v3__nor2_2_8/VDD gf180mcu_as_sc_mcu7t3v3__nand3_2_32/VSS
+ VSS VSS gf180mcu_as_sc_mcu7t3v3__nor2_2_8/VNW VSUBS gf180mcu_as_sc_mcu7t3v3__inv_2
Xgf180mcu_as_sc_mcu7t3v3__inv_2_1210 gf180mcu_as_sc_mcu7t3v3__nor2_2_8/VDD gf180mcu_as_sc_mcu7t3v3__nand3_2_32/VSS
+ VSS VSS gf180mcu_as_sc_mcu7t3v3__nor2_2_8/VNW VSUBS gf180mcu_as_sc_mcu7t3v3__inv_2
Xgf180mcu_as_sc_mcu7t3v3__inv_2_1221 gf180mcu_as_sc_mcu7t3v3__nor2_2_8/VDD gf180mcu_as_sc_mcu7t3v3__nand3_2_32/VSS
+ VSS VSS gf180mcu_as_sc_mcu7t3v3__nor2_2_8/VNW VSUBS gf180mcu_as_sc_mcu7t3v3__inv_2
Xgf180mcu_as_sc_mcu7t3v3__inv_2_1287 gf180mcu_as_sc_mcu7t3v3__nor2_2_8/VDD gf180mcu_as_sc_mcu7t3v3__nor2_2_8/VSS
+ VSS VSS gf180mcu_as_sc_mcu7t3v3__nor2_2_8/VNW VSUBS gf180mcu_as_sc_mcu7t3v3__inv_2
Xgf180mcu_as_sc_mcu7t3v3__inv_2_1265 gf180mcu_as_sc_mcu7t3v3__nand3_2_31/VDD gf180mcu_as_sc_mcu7t3v3__nand3_2_31/VSS
+ VSS VSS gf180mcu_as_sc_mcu7t3v3__nand3_2_31/VNW VSUBS gf180mcu_as_sc_mcu7t3v3__inv_2
Xgf180mcu_as_sc_mcu7t3v3__inv_2_1276 VSS VSS VSS VSS gf180mcu_as_sc_mcu7t3v3__inv_2_1277/VNW
+ VSUBS gf180mcu_as_sc_mcu7t3v3__inv_2
Xgf180mcu_as_sc_mcu7t3v3__inv_2_1243 VSS VSS VSS VSS gf180mcu_as_sc_mcu7t3v3__inv_2_1244/VNW
+ VSUBS gf180mcu_as_sc_mcu7t3v3__inv_2
Xgf180mcu_as_sc_mcu7t3v3__inv_2_1232 VSS VSS VSS VSS gf180mcu_as_sc_mcu7t3v3__inv_2_1237/VNW
+ VSUBS gf180mcu_as_sc_mcu7t3v3__inv_2
Xgf180mcu_as_sc_mcu7t3v3__inv_2_1298 VSS VSS VSS VSS gf180mcu_as_sc_mcu7t3v3__inv_2_1298/VNW
+ VSUBS gf180mcu_as_sc_mcu7t3v3__inv_2
Xgf180mcu_as_sc_mcu7t3v3__inv_2_716 VSS VSS gf180mcu_as_sc_mcu7t3v3__inv_2_716/Y gf180mcu_as_sc_mcu7t3v3__inv_2_720/Y
+ gf180mcu_as_sc_mcu7t3v3__inv_2_720/VNW VSUBS gf180mcu_as_sc_mcu7t3v3__inv_2
Xgf180mcu_as_sc_mcu7t3v3__inv_2_705 gf180mcu_as_sc_mcu7t3v3__inv_2_727/VSS gf180mcu_as_sc_mcu7t3v3__inv_2_731/VDD
+ gf180mcu_as_sc_mcu7t3v3__inv_2_705/Y gf180mcu_as_sc_mcu7t3v3__inv_2_732/Y gf180mcu_as_sc_mcu7t3v3__inv_2_707/VNW
+ VSUBS gf180mcu_as_sc_mcu7t3v3__inv_2
Xgf180mcu_as_sc_mcu7t3v3__inv_2_727 VSS gf180mcu_as_sc_mcu7t3v3__inv_2_727/VSS gf180mcu_as_sc_mcu7t3v3__inv_2_727/Y
+ VSS gf180mcu_as_sc_mcu7t3v3__inv_2_727/VNW VSUBS gf180mcu_as_sc_mcu7t3v3__inv_2
Xgf180mcu_as_sc_mcu7t3v3__inv_2_749 VSS VSS gf180mcu_as_sc_mcu7t3v3__inv_2_749/Y VSS
+ gf180mcu_as_sc_mcu7t3v3__inv_2_749/VNW VSUBS gf180mcu_as_sc_mcu7t3v3__inv_2
Xgf180mcu_as_sc_mcu7t3v3__inv_2_738 VSS gf180mcu_as_sc_mcu7t3v3__inv_2_738/VSS gf180mcu_as_sc_mcu7t3v3__inv_2_738/Y
+ gf180mcu_as_sc_mcu7t3v3__inv_2_738/A gf180mcu_as_sc_mcu7t3v3__inv_2_738/VNW VSUBS
+ gf180mcu_as_sc_mcu7t3v3__inv_2
Xgf180mcu_as_sc_mcu7t3v3__inv_2_70 gf180mcu_as_sc_mcu7t3v3__inv_2_70/VDD gf180mcu_as_sc_mcu7t3v3__inv_2_71/VDD
+ gf180mcu_as_sc_mcu7t3v3__inv_2_71/Y VSS gf180mcu_as_sc_mcu7t3v3__inv_2_70/VNW VSUBS
+ gf180mcu_as_sc_mcu7t3v3__inv_2
Xgf180mcu_as_sc_mcu7t3v3__inv_2_1062 gf180mcu_as_sc_mcu7t3v3__inv_2_1064/VDD gf180mcu_as_sc_mcu7t3v3__inv_2_1072/VDD
+ VSS gf180mcu_as_sc_mcu7t3v3__inv_2_1144/A gf180mcu_as_sc_mcu7t3v3__inv_2_1064/VNW
+ VSUBS gf180mcu_as_sc_mcu7t3v3__inv_2
Xgf180mcu_as_sc_mcu7t3v3__inv_2_1084 gf180mcu_as_sc_mcu7t3v3__inv_2_1084/VDD VSS gf180mcu_as_sc_mcu7t3v3__inv_2_1084/Y
+ VSS gf180mcu_as_sc_mcu7t3v3__inv_2_1084/VNW VSUBS gf180mcu_as_sc_mcu7t3v3__inv_2
Xgf180mcu_as_sc_mcu7t3v3__inv_2_1095 gf180mcu_as_sc_mcu7t3v3__inv_2_1096/VDD VSS gf180mcu_as_sc_mcu7t3v3__inv_2_1095/Y
+ gf180mcu_as_sc_mcu7t3v3__inv_2_1096/Y gf180mcu_as_sc_mcu7t3v3__inv_2_1096/VNW VSUBS
+ gf180mcu_as_sc_mcu7t3v3__inv_2
Xgf180mcu_as_sc_mcu7t3v3__inv_2_1073 VSS VSS gf180mcu_as_sc_mcu7t3v3__inv_2_1073/Y
+ VSS gf180mcu_as_sc_mcu7t3v3__inv_2_1073/VNW VSUBS gf180mcu_as_sc_mcu7t3v3__inv_2
Xgf180mcu_as_sc_mcu7t3v3__inv_2_1051 VSS VSS gf180mcu_as_sc_mcu7t3v3__inv_2_1051/Y
+ VSS gf180mcu_as_sc_mcu7t3v3__inv_2_1051/VNW VSUBS gf180mcu_as_sc_mcu7t3v3__inv_2
Xgf180mcu_as_sc_mcu7t3v3__inv_2_92 gf180mcu_as_sc_mcu7t3v3__inv_2_96/VDD gf180mcu_as_sc_mcu7t3v3__inv_2_96/VSS
+ VSS VSS gf180mcu_as_sc_mcu7t3v3__inv_2_96/VNW VSUBS gf180mcu_as_sc_mcu7t3v3__inv_2
Xgf180mcu_as_sc_mcu7t3v3__inv_2_81 gf180mcu_as_sc_mcu7t3v3__inv_2_88/VSS gf180mcu_as_sc_mcu7t3v3__inv_2_88/VSS
+ VSS VSS gf180mcu_as_sc_mcu7t3v3__inv_2_83/VNW VSUBS gf180mcu_as_sc_mcu7t3v3__inv_2
Xgf180mcu_as_sc_mcu7t3v3__inv_2_1040 gf180mcu_as_sc_mcu7t3v3__inv_2_1042/VDD gf180mcu_as_sc_mcu7t3v3__inv_2_1046/VDD
+ VSS gf180mcu_as_sc_mcu7t3v3__inv_2_992/A gf180mcu_as_sc_mcu7t3v3__inv_2_1042/VNW
+ VSUBS gf180mcu_as_sc_mcu7t3v3__inv_2
Xgf180mcu_as_sc_mcu7t3v3__nand4_2_7 gf180mcu_as_sc_mcu7t3v3__inv_2_9/VSS gf180mcu_as_sc_mcu7t3v3__inv_2_0/VSS
+ VSS VSS VSS VSS VSS gf180mcu_as_sc_mcu7t3v3__inv_2_0/VNW VSUBS gf180mcu_as_sc_mcu7t3v3__nand4_2
Xgf180mcu_as_sc_mcu7t3v3__inv_2_557 VSS VSS VSS VSS gf180mcu_as_sc_mcu7t3v3__inv_2_558/VNW
+ VSUBS gf180mcu_as_sc_mcu7t3v3__inv_2
Xgf180mcu_as_sc_mcu7t3v3__inv_2_568 gf180mcu_as_sc_mcu7t3v3__inv_2_572/VDD gf180mcu_as_sc_mcu7t3v3__inv_2_572/VDD
+ gf180mcu_as_sc_mcu7t3v3__inv_2_574/A gf180mcu_as_sc_mcu7t3v3__inv_2_569/Y gf180mcu_as_sc_mcu7t3v3__inv_2_569/VNW
+ VSUBS gf180mcu_as_sc_mcu7t3v3__inv_2
Xgf180mcu_as_sc_mcu7t3v3__inv_2_579 gf180mcu_as_sc_mcu7t3v3__inv_2_584/VDD gf180mcu_as_sc_mcu7t3v3__inv_2_584/VDD
+ VSS gf180mcu_as_sc_mcu7t3v3__inv_2_580/Y gf180mcu_as_sc_mcu7t3v3__inv_2_580/VNW
+ VSUBS gf180mcu_as_sc_mcu7t3v3__inv_2
Xgf180mcu_as_sc_mcu7t3v3__inv_2_513 VSS VSS VSS VSS gf180mcu_as_sc_mcu7t3v3__inv_2_514/VNW
+ VSUBS gf180mcu_as_sc_mcu7t3v3__inv_2
Xgf180mcu_as_sc_mcu7t3v3__inv_2_502 VSS VSS VSS VSS gf180mcu_as_sc_mcu7t3v3__inv_2_502/VNW
+ VSUBS gf180mcu_as_sc_mcu7t3v3__inv_2
Xgf180mcu_as_sc_mcu7t3v3__inv_2_546 VSS VSS gf180mcu_as_sc_mcu7t3v3__inv_2_546/Y VSS
+ gf180mcu_as_sc_mcu7t3v3__inv_2_546/VNW VSUBS gf180mcu_as_sc_mcu7t3v3__inv_2
Xgf180mcu_as_sc_mcu7t3v3__inv_2_524 VSS VSS gf180mcu_as_sc_mcu7t3v3__inv_2_524/Y VSS
+ gf180mcu_as_sc_mcu7t3v3__inv_2_526/VNW VSUBS gf180mcu_as_sc_mcu7t3v3__inv_2
Xgf180mcu_as_sc_mcu7t3v3__inv_2_535 VSS VSS VSS VSS gf180mcu_as_sc_mcu7t3v3__inv_2_535/VNW
+ VSUBS gf180mcu_as_sc_mcu7t3v3__inv_2
Xgf180mcu_as_sc_mcu7t3v3__nand4_2_390 gf180mcu_as_sc_mcu7t3v3__inv_2_1369/VDD VSS
+ VSS VSS VSS VSS VSS gf180mcu_as_sc_mcu7t3v3__inv_2_1369/VNW VSUBS gf180mcu_as_sc_mcu7t3v3__nand4_2
Xgf180mcu_as_sc_mcu7t3v3__inv_2_398 VSS VSS gf180mcu_as_sc_mcu7t3v3__inv_2_398/Y VSS
+ gf180mcu_as_sc_mcu7t3v3__inv_2_398/VNW VSUBS gf180mcu_as_sc_mcu7t3v3__inv_2
Xgf180mcu_as_sc_mcu7t3v3__inv_2_376 gf180mcu_as_sc_mcu7t3v3__nor2_2_6/VDD gf180mcu_as_sc_mcu7t3v3__nor2_2_6/VSS
+ VSS VSS gf180mcu_as_sc_mcu7t3v3__nor2_2_6/VNW VSUBS gf180mcu_as_sc_mcu7t3v3__inv_2
Xgf180mcu_as_sc_mcu7t3v3__inv_2_387 gf180mcu_as_sc_mcu7t3v3__nand3_2_5/VDD gf180mcu_as_sc_mcu7t3v3__nor2_2_4/VSS
+ VSS VSS gf180mcu_as_sc_mcu7t3v3__nand3_2_5/VNW VSUBS gf180mcu_as_sc_mcu7t3v3__inv_2
Xgf180mcu_as_sc_mcu7t3v3__inv_2_365 VSS VSS gf180mcu_as_sc_mcu7t3v3__inv_2_66/Y VSS
+ gf180mcu_as_sc_mcu7t3v3__inv_2_365/VNW VSUBS gf180mcu_as_sc_mcu7t3v3__inv_2
Xgf180mcu_as_sc_mcu7t3v3__inv_2_354 gf180mcu_as_sc_mcu7t3v3__inv_2_354/VDD gf180mcu_as_sc_mcu7t3v3__inv_2_355/VDD
+ gf180mcu_as_sc_mcu7t3v3__inv_2_358/Y VSS gf180mcu_as_sc_mcu7t3v3__inv_2_354/VNW
+ VSUBS gf180mcu_as_sc_mcu7t3v3__inv_2
Xgf180mcu_as_sc_mcu7t3v3__inv_2_343 VSS gf180mcu_as_sc_mcu7t3v3__inv_2_344/VDD gf180mcu_as_sc_mcu7t3v3__inv_2_344/Y
+ VSS gf180mcu_as_sc_mcu7t3v3__inv_2_343/VNW VSUBS gf180mcu_as_sc_mcu7t3v3__inv_2
Xgf180mcu_as_sc_mcu7t3v3__inv_2_321 VSS gf180mcu_as_sc_mcu7t3v3__inv_2_344/VDD VSS
+ gf180mcu_as_sc_mcu7t3v3__inv_2_344/Y gf180mcu_as_sc_mcu7t3v3__inv_2_343/VNW VSUBS
+ gf180mcu_as_sc_mcu7t3v3__inv_2
Xgf180mcu_as_sc_mcu7t3v3__inv_2_310 gf180mcu_as_sc_mcu7t3v3__inv_2_334/VDD gf180mcu_as_sc_mcu7t3v3__inv_2_335/VDD
+ VSS gf180mcu_as_sc_mcu7t3v3__inv_2_338/Y gf180mcu_as_sc_mcu7t3v3__inv_2_334/VNW
+ VSUBS gf180mcu_as_sc_mcu7t3v3__inv_2
Xgf180mcu_as_sc_mcu7t3v3__inv_2_332 gf180mcu_as_sc_mcu7t3v3__inv_2_332/VDD VSS gf180mcu_as_sc_mcu7t3v3__inv_2_338/Y
+ VSS gf180mcu_as_sc_mcu7t3v3__inv_2_332/VNW VSUBS gf180mcu_as_sc_mcu7t3v3__inv_2
Xu_t027_026 u_t027_026/c0_w0_bl u_t027_026/c0_w0_br u_t027_026/c0_w1_bl u_t027_026/c0_w1_br
+ u_t027_026/c0_r0_rbl u_t027_026/c0_r1_rbl u_t027_026/c1_w0_bl u_t027_026/c1_w0_br
+ u_t027_026/c1_w1_bl u_t027_026/c1_w1_br u_t027_026/c1_r0_rbl u_t027_026/c1_r1_rbl
+ u_t027_026/c2_w0_bl u_t027_026/c2_w0_br u_t027_026/c2_w1_bl u_t027_026/c2_w1_br
+ u_t027_026/c2_r0_rbl u_t027_026/c2_r1_rbl u_t027_026/c3_w0_bl u_t027_026/c3_w0_br
+ u_t027_026/c3_w1_bl u_t027_026/c3_w1_br u_t027_026/c3_r0_rbl u_t027_026/c3_r1_rbl
+ u_t027_026/r0_w0_wl u_t027_026/r0_w1_wl u_t027_026/r0_r0_rwl u_t027_026/r0_r1_rwl
+ u_t027_026/r1_w0_wl u_t027_026/r1_w1_wl u_t027_026/r1_r0_rwl u_t027_026/r1_r1_rwl
+ u_t027_026/r2_w0_wl u_t027_026/r2_w1_wl u_t027_026/r2_r0_rwl u_t027_026/r2_r1_rwl
+ u_t027_026/r3_w0_wl u_t027_026/r3_w1_wl u_t027_026/r3_r0_rwl u_t027_026/r3_r1_rwl
+ u_t027_026/VDD u_t027_026/VSS VSUBS detronyx_12t_2w2r_rc4_4x4_routed_5layer_direct
Xu_t027_015 u_t027_015/c0_w0_bl u_t027_015/c0_w0_br u_t027_015/c0_w1_bl u_t027_015/c0_w1_br
+ u_t027_015/c0_r0_rbl u_t027_015/c0_r1_rbl u_t027_015/c1_w0_bl u_t027_015/c1_w0_br
+ u_t027_015/c1_w1_bl u_t027_015/c1_w1_br u_t027_015/c1_r0_rbl u_t027_015/c1_r1_rbl
+ u_t027_015/c2_w0_bl u_t027_015/c2_w0_br u_t027_015/c2_w1_bl u_t027_015/c2_w1_br
+ u_t027_015/c2_r0_rbl u_t027_015/c2_r1_rbl u_t027_015/c3_w0_bl u_t027_015/c3_w0_br
+ u_t027_015/c3_w1_bl u_t027_015/c3_w1_br u_t027_015/c3_r0_rbl u_t027_015/c3_r1_rbl
+ u_t027_015/r0_w0_wl u_t027_015/r0_w1_wl u_t027_015/r0_r0_rwl u_t027_015/r0_r1_rwl
+ u_t027_015/r1_w0_wl u_t027_015/r1_w1_wl u_t027_015/r1_r0_rwl u_t027_015/r1_r1_rwl
+ u_t027_015/r2_w0_wl u_t027_015/r2_w1_wl u_t027_015/r2_r0_rwl u_t027_015/r2_r1_rwl
+ u_t027_015/r3_w0_wl u_t027_015/r3_w1_wl u_t027_015/r3_r0_rwl u_t027_015/r3_r1_rwl
+ VSS u_t027_017/VSS VSUBS detronyx_12t_2w2r_rc4_4x4_routed_5layer_direct
Xu_t027_004 u_t027_004/c0_w0_bl u_t027_004/c0_w0_br u_t027_004/c0_w1_bl u_t027_004/c0_w1_br
+ u_t027_004/c0_r0_rbl u_t027_004/c0_r1_rbl u_t027_004/c1_w0_bl u_t027_004/c1_w0_br
+ u_t027_004/c1_w1_bl u_t027_004/c1_w1_br u_t027_004/c1_r0_rbl u_t027_004/c1_r1_rbl
+ u_t027_004/c2_w0_bl u_t027_004/c2_w0_br u_t027_004/c2_w1_bl u_t027_004/c2_w1_br
+ u_t027_004/c2_r0_rbl u_t027_004/c2_r1_rbl u_t027_004/c3_w0_bl u_t027_004/c3_w0_br
+ u_t027_004/c3_w1_bl u_t027_004/c3_w1_br u_t027_004/c3_r0_rbl u_t027_004/c3_r1_rbl
+ u_t027_004/r0_w0_wl u_t027_004/r0_w1_wl u_t027_004/r0_r0_rwl u_t027_004/r0_r1_rwl
+ u_t027_004/r1_w0_wl u_t027_004/r1_w1_wl u_t027_004/r1_r0_rwl u_t027_004/r1_r1_rwl
+ u_t027_004/r2_w0_wl u_t027_004/r2_w1_wl u_t027_004/r2_r0_rwl u_t027_004/r2_r1_rwl
+ u_t027_004/r3_w0_wl u_t027_004/r3_w1_wl u_t027_004/r3_r0_rwl u_t027_004/r3_r1_rwl
+ u_t027_004/VDD u_t027_004/VSS VSUBS detronyx_12t_2w2r_rc4_4x4_routed_5layer_direct
Xu_t018_026 u_t018_026/c0_w0_bl u_t018_026/c0_w0_br u_t018_026/c0_w1_bl u_t018_026/c0_w1_br
+ u_t018_026/c0_r0_rbl u_t018_026/c0_r1_rbl u_t018_026/c1_w0_bl u_t018_026/c1_w0_br
+ u_t018_026/c1_w1_bl u_t018_026/c1_w1_br u_t018_026/c1_r0_rbl u_t018_026/c1_r1_rbl
+ u_t018_026/c2_w0_bl u_t018_026/c2_w0_br u_t018_026/c2_w1_bl u_t018_026/c2_w1_br
+ u_t018_026/c2_r0_rbl u_t018_026/c2_r1_rbl u_t018_026/c3_w0_bl u_t018_026/c3_w0_br
+ u_t018_026/c3_w1_bl u_t018_026/c3_w1_br u_t018_026/c3_r0_rbl u_t018_026/c3_r1_rbl
+ u_t018_026/r0_w0_wl u_t018_026/r0_w1_wl u_t018_026/r0_r0_rwl u_t018_026/r0_r1_rwl
+ u_t018_026/r1_w0_wl u_t018_026/r1_w1_wl u_t018_026/r1_r0_rwl u_t018_026/r1_r1_rwl
+ u_t018_026/r2_w0_wl u_t018_026/r2_w1_wl u_t018_026/r2_r0_rwl u_t018_026/r2_r1_rwl
+ u_t018_026/r3_w0_wl u_t018_026/r3_w1_wl u_t018_026/r3_r0_rwl u_t018_026/r3_r1_rwl
+ u_t018_026/VDD u_t018_026/VSS VSUBS detronyx_12t_2w2r_rc4_4x4_routed_5layer_direct
Xu_t018_015 u_t018_015/c0_w0_bl u_t018_015/c0_w0_br u_t018_015/c0_w1_bl u_t018_015/c0_w1_br
+ u_t018_015/c0_r0_rbl u_t018_015/c0_r1_rbl u_t018_015/c1_w0_bl u_t018_015/c1_w0_br
+ u_t018_015/c1_w1_bl u_t018_015/c1_w1_br u_t018_015/c1_r0_rbl u_t018_015/c1_r1_rbl
+ u_t018_015/c2_w0_bl u_t018_015/c2_w0_br u_t018_015/c2_w1_bl u_t018_015/c2_w1_br
+ u_t018_015/c2_r0_rbl u_t018_015/c2_r1_rbl u_t018_015/c3_w0_bl u_t018_015/c3_w0_br
+ u_t018_015/c3_w1_bl u_t018_015/c3_w1_br u_t018_015/c3_r0_rbl u_t018_015/c3_r1_rbl
+ u_t018_015/r0_w0_wl u_t018_015/r0_w1_wl u_t018_015/r0_r0_rwl u_t018_015/r0_r1_rwl
+ u_t018_015/r1_w0_wl u_t018_015/r1_w1_wl u_t018_015/r1_r0_rwl u_t018_015/r1_r1_rwl
+ u_t018_015/r2_w0_wl u_t018_015/r2_w1_wl u_t018_015/r2_r0_rwl u_t018_015/r2_r1_rwl
+ u_t018_015/r3_w0_wl u_t018_015/r3_w1_wl u_t018_015/r3_r0_rwl u_t018_015/r3_r1_rwl
+ VSS u_t018_017/VSS VSUBS detronyx_12t_2w2r_rc4_4x4_routed_5layer_direct
Xu_t018_004 u_t018_004/c0_w0_bl u_t018_004/c0_w0_br u_t018_004/c0_w1_bl u_t018_004/c0_w1_br
+ u_t018_004/c0_r0_rbl u_t018_004/c0_r1_rbl u_t018_004/c1_w0_bl u_t018_004/c1_w0_br
+ u_t018_004/c1_w1_bl u_t018_004/c1_w1_br u_t018_004/c1_r0_rbl u_t018_004/c1_r1_rbl
+ u_t018_004/c2_w0_bl u_t018_004/c2_w0_br u_t018_004/c2_w1_bl u_t018_004/c2_w1_br
+ u_t018_004/c2_r0_rbl u_t018_004/c2_r1_rbl u_t018_004/c3_w0_bl u_t018_004/c3_w0_br
+ u_t018_004/c3_w1_bl u_t018_004/c3_w1_br u_t018_004/c3_r0_rbl u_t018_004/c3_r1_rbl
+ u_t018_004/r0_w0_wl u_t018_004/r0_w1_wl u_t018_004/r0_r0_rwl u_t018_004/r0_r1_rwl
+ u_t018_004/r1_w0_wl u_t018_004/r1_w1_wl u_t018_004/r1_r0_rwl u_t018_004/r1_r1_rwl
+ u_t018_004/r2_w0_wl u_t018_004/r2_w1_wl u_t018_004/r2_r0_rwl u_t018_004/r2_r1_rwl
+ u_t018_004/r3_w0_wl u_t018_004/r3_w1_wl u_t018_004/r3_r0_rwl u_t018_004/r3_r1_rwl
+ u_t018_004/VDD u_t018_004/VSS VSUBS detronyx_12t_2w2r_rc4_4x4_routed_5layer_direct
Xu_t009_026 u_t009_026/c0_w0_bl u_t009_026/c0_w0_br u_t009_026/c0_w1_bl u_t009_026/c0_w1_br
+ u_t009_026/c0_r0_rbl u_t009_026/c0_r1_rbl u_t009_026/c1_w0_bl u_t009_026/c1_w0_br
+ u_t009_026/c1_w1_bl u_t009_026/c1_w1_br u_t009_026/c1_r0_rbl u_t009_026/c1_r1_rbl
+ u_t009_026/c2_w0_bl u_t009_026/c2_w0_br u_t009_026/c2_w1_bl u_t009_026/c2_w1_br
+ u_t009_026/c2_r0_rbl u_t009_026/c2_r1_rbl u_t009_026/c3_w0_bl u_t009_026/c3_w0_br
+ u_t009_026/c3_w1_bl u_t009_026/c3_w1_br u_t009_026/c3_r0_rbl u_t009_026/c3_r1_rbl
+ u_t009_026/r0_w0_wl u_t009_026/r0_w1_wl u_t009_026/r0_r0_rwl u_t009_026/r0_r1_rwl
+ u_t009_026/r1_w0_wl u_t009_026/r1_w1_wl u_t009_026/r1_r0_rwl u_t009_026/r1_r1_rwl
+ u_t009_026/r2_w0_wl u_t009_026/r2_w1_wl u_t009_026/r2_r0_rwl u_t009_026/r2_r1_rwl
+ u_t009_026/r3_w0_wl u_t009_026/r3_w1_wl u_t009_026/r3_r0_rwl u_t009_026/r3_r1_rwl
+ u_t009_026/VDD u_t009_031/VSS VSUBS detronyx_12t_2w2r_rc4_4x4_routed_5layer_direct
Xu_t024_018 u_t024_018/c0_w0_bl u_t024_018/c0_w0_br u_t024_018/c0_w1_bl u_t024_018/c0_w1_br
+ u_t024_018/c0_r0_rbl u_t024_018/c0_r1_rbl u_t024_018/c1_w0_bl u_t024_018/c1_w0_br
+ u_t024_018/c1_w1_bl u_t024_018/c1_w1_br u_t024_018/c1_r0_rbl u_t024_018/c1_r1_rbl
+ u_t024_018/c2_w0_bl u_t024_018/c2_w0_br u_t024_018/c2_w1_bl u_t024_018/c2_w1_br
+ u_t024_018/c2_r0_rbl u_t024_018/c2_r1_rbl u_t024_018/c3_w0_bl u_t024_018/c3_w0_br
+ u_t024_018/c3_w1_bl u_t024_018/c3_w1_br u_t024_018/c3_r0_rbl u_t024_018/c3_r1_rbl
+ u_t024_018/r0_w0_wl u_t024_018/r0_w1_wl u_t024_018/r0_r0_rwl u_t024_018/r0_r1_rwl
+ u_t024_018/r1_w0_wl u_t024_018/r1_w1_wl u_t024_018/r1_r0_rwl u_t024_018/r1_r1_rwl
+ u_t024_018/r2_w0_wl u_t024_018/r2_w1_wl u_t024_018/r2_r0_rwl u_t024_018/r2_r1_rwl
+ u_t024_018/r3_w0_wl u_t024_018/r3_w1_wl u_t024_018/r3_r0_rwl u_t024_018/r3_r1_rwl
+ u_t025_018/VDD u_t024_018/VSS VSUBS detronyx_12t_2w2r_rc4_4x4_routed_5layer_direct
Xu_t009_015 u_t009_015/c0_w0_bl u_t009_015/c0_w0_br u_t009_015/c0_w1_bl u_t009_015/c0_w1_br
+ u_t009_015/c0_r0_rbl u_t009_015/c0_r1_rbl u_t009_015/c1_w0_bl u_t009_015/c1_w0_br
+ u_t009_015/c1_w1_bl u_t009_015/c1_w1_br u_t009_015/c1_r0_rbl u_t009_015/c1_r1_rbl
+ u_t009_015/c2_w0_bl u_t009_015/c2_w0_br u_t009_015/c2_w1_bl u_t009_015/c2_w1_br
+ u_t009_015/c2_r0_rbl u_t009_015/c2_r1_rbl u_t009_015/c3_w0_bl u_t009_015/c3_w0_br
+ u_t009_015/c3_w1_bl u_t009_015/c3_w1_br u_t009_015/c3_r0_rbl u_t009_015/c3_r1_rbl
+ u_t009_015/r0_w0_wl u_t009_015/r0_w1_wl u_t009_015/r0_r0_rwl u_t009_015/r0_r1_rwl
+ u_t009_015/r1_w0_wl u_t009_015/r1_w1_wl u_t009_015/r1_r0_rwl u_t009_015/r1_r1_rwl
+ u_t009_015/r2_w0_wl u_t009_015/r2_w1_wl u_t009_015/r2_r0_rwl u_t009_015/r2_r1_rwl
+ u_t009_015/r3_w0_wl u_t009_015/r3_w1_wl u_t009_015/r3_r0_rwl u_t009_015/r3_r1_rwl
+ VSS u_t009_031/VSS VSUBS detronyx_12t_2w2r_rc4_4x4_routed_5layer_direct
Xu_t024_007 u_t024_007/c0_w0_bl u_t024_007/c0_w0_br u_t024_007/c0_w1_bl u_t024_007/c0_w1_br
+ u_t024_007/c0_r0_rbl u_t024_007/c0_r1_rbl u_t024_007/c1_w0_bl u_t024_007/c1_w0_br
+ u_t024_007/c1_w1_bl u_t024_007/c1_w1_br u_t024_007/c1_r0_rbl u_t024_007/c1_r1_rbl
+ u_t024_007/c2_w0_bl u_t024_007/c2_w0_br u_t024_007/c2_w1_bl u_t024_007/c2_w1_br
+ u_t024_007/c2_r0_rbl u_t024_007/c2_r1_rbl u_t024_007/c3_w0_bl u_t024_007/c3_w0_br
+ u_t024_007/c3_w1_bl u_t024_007/c3_w1_br u_t024_007/c3_r0_rbl u_t024_007/c3_r1_rbl
+ u_t024_007/r0_w0_wl u_t024_007/r0_w1_wl u_t024_007/r0_r0_rwl u_t024_007/r0_r1_rwl
+ u_t024_007/r1_w0_wl u_t024_007/r1_w1_wl u_t024_007/r1_r0_rwl u_t024_007/r1_r1_rwl
+ u_t024_007/r2_w0_wl u_t024_007/r2_w1_wl u_t024_007/r2_r0_rwl u_t024_007/r2_r1_rwl
+ u_t024_007/r3_w0_wl u_t024_007/r3_w1_wl u_t024_007/r3_r0_rwl u_t024_007/r3_r1_rwl
+ VSS u_t024_009/VSS VSUBS detronyx_12t_2w2r_rc4_4x4_routed_5layer_direct
Xu_t009_004 u_t009_004/c0_w0_bl u_t009_004/c0_w0_br u_t009_004/c0_w1_bl u_t009_004/c0_w1_br
+ u_t009_004/c0_r0_rbl u_t009_004/c0_r1_rbl u_t009_004/c1_w0_bl u_t009_004/c1_w0_br
+ u_t009_004/c1_w1_bl u_t009_004/c1_w1_br u_t009_004/c1_r0_rbl u_t009_004/c1_r1_rbl
+ u_t009_004/c2_w0_bl u_t009_004/c2_w0_br u_t009_004/c2_w1_bl u_t009_004/c2_w1_br
+ u_t009_004/c2_r0_rbl u_t009_004/c2_r1_rbl u_t009_004/c3_w0_bl u_t009_004/c3_w0_br
+ u_t009_004/c3_w1_bl u_t009_004/c3_w1_br u_t009_004/c3_r0_rbl u_t009_004/c3_r1_rbl
+ u_t009_004/r0_w0_wl u_t009_004/r0_w1_wl u_t009_004/r0_r0_rwl u_t009_004/r0_r1_rwl
+ u_t009_004/r1_w0_wl u_t009_004/r1_w1_wl u_t009_004/r1_r0_rwl u_t009_004/r1_r1_rwl
+ u_t009_004/r2_w0_wl u_t009_004/r2_w1_wl u_t009_004/r2_r0_rwl u_t009_004/r2_r1_rwl
+ u_t009_004/r3_w0_wl u_t009_004/r3_w1_wl u_t009_004/r3_r0_rwl u_t009_004/r3_r1_rwl
+ u_t009_004/VDD u_t009_031/VSS VSUBS detronyx_12t_2w2r_rc4_4x4_routed_5layer_direct
Xgf180mcu_as_sc_mcu7t3v3__nand3_2_19 gf180mcu_as_sc_mcu7t3v3__nor2_2_5/VDD gf180mcu_as_sc_mcu7t3v3__nand3_2_8/VSS
+ VSS VSS VSS VSS gf180mcu_as_sc_mcu7t3v3__nor2_2_5/VNW VSUBS gf180mcu_as_sc_mcu7t3v3__nand3_2
Xu_t024_029 u_t024_029/c0_w0_bl u_t024_029/c0_w0_br u_t024_029/c0_w1_bl u_t024_029/c0_w1_br
+ u_t024_029/c0_r0_rbl u_t024_029/c0_r1_rbl u_t024_029/c1_w0_bl u_t024_029/c1_w0_br
+ u_t024_029/c1_w1_bl u_t024_029/c1_w1_br u_t024_029/c1_r0_rbl u_t024_029/c1_r1_rbl
+ u_t024_029/c2_w0_bl u_t024_029/c2_w0_br u_t024_029/c2_w1_bl u_t024_029/c2_w1_br
+ u_t024_029/c2_r0_rbl u_t024_029/c2_r1_rbl u_t024_029/c3_w0_bl u_t024_029/c3_w0_br
+ u_t024_029/c3_w1_bl u_t024_029/c3_w1_br u_t024_029/c3_r0_rbl u_t024_029/c3_r1_rbl
+ u_t024_029/r0_w0_wl u_t024_029/r0_w1_wl u_t024_029/r0_r0_rwl u_t024_029/r0_r1_rwl
+ u_t024_029/r1_w0_wl u_t024_029/r1_w1_wl u_t024_029/r1_r0_rwl u_t024_029/r1_r1_rwl
+ u_t024_029/r2_w0_wl u_t024_029/r2_w1_wl u_t024_029/r2_r0_rwl u_t024_029/r2_r1_rwl
+ u_t024_029/r3_w0_wl u_t024_029/r3_w1_wl u_t024_029/r3_r0_rwl u_t024_029/r3_r1_rwl
+ u_t025_029/VDD u_t024_031/VSS VSUBS detronyx_12t_2w2r_rc4_4x4_routed_5layer_direct
Xgf180mcu_as_sc_mcu7t3v3__inv_2_1606 gf180mcu_as_sc_mcu7t3v3__inv_2_1654/VDD VSS VSS
+ gf180mcu_as_sc_mcu7t3v3__inv_2_1682/Y gf180mcu_as_sc_mcu7t3v3__inv_2_1654/VNW VSUBS
+ gf180mcu_as_sc_mcu7t3v3__inv_2
Xgf180mcu_as_sc_mcu7t3v3__inv_2_1617 VSS gf180mcu_as_sc_mcu7t3v3__inv_2_1663/VDD gf180mcu_as_sc_mcu7t3v3__inv_2_1617/Y
+ gf180mcu_as_sc_mcu7t3v3__inv_2_1685/Y gf180mcu_as_sc_mcu7t3v3__inv_2_1662/VNW VSUBS
+ gf180mcu_as_sc_mcu7t3v3__inv_2
Xgf180mcu_as_sc_mcu7t3v3__inv_2_140 VSS gf180mcu_as_sc_mcu7t3v3__inv_2_146/VDD VSS
+ VSS gf180mcu_as_sc_mcu7t3v3__inv_2_142/VNW VSUBS gf180mcu_as_sc_mcu7t3v3__inv_2
Xgf180mcu_as_sc_mcu7t3v3__inv_2_151 gf180mcu_as_sc_mcu7t3v3__inv_2_151/VDD gf180mcu_as_sc_mcu7t3v3__inv_2_151/VSS
+ gf180mcu_as_sc_mcu7t3v3__inv_2_151/Y VSS gf180mcu_as_sc_mcu7t3v3__inv_2_151/VNW
+ VSUBS gf180mcu_as_sc_mcu7t3v3__inv_2
Xgf180mcu_as_sc_mcu7t3v3__inv_2_184 gf180mcu_as_sc_mcu7t3v3__inv_2_184/VDD gf180mcu_as_sc_mcu7t3v3__inv_2_200/VDD
+ gf180mcu_as_sc_mcu7t3v3__inv_2_184/Y VSS gf180mcu_as_sc_mcu7t3v3__inv_2_184/VNW
+ VSUBS gf180mcu_as_sc_mcu7t3v3__inv_2
Xgf180mcu_as_sc_mcu7t3v3__inv_2_173 VSS gf180mcu_as_sc_mcu7t3v3__inv_2_177/VDD gf180mcu_as_sc_mcu7t3v3__inv_2_173/Y
+ VSS gf180mcu_as_sc_mcu7t3v3__inv_2_173/VNW VSUBS gf180mcu_as_sc_mcu7t3v3__inv_2
Xgf180mcu_as_sc_mcu7t3v3__inv_2_195 VSS gf180mcu_as_sc_mcu7t3v3__inv_2_196/VSS VSS
+ VSS gf180mcu_as_sc_mcu7t3v3__inv_2_196/VNW VSUBS gf180mcu_as_sc_mcu7t3v3__inv_2
Xgf180mcu_as_sc_mcu7t3v3__inv_2_162 VSS gf180mcu_as_sc_mcu7t3v3__inv_2_188/VDD VSS
+ VSS gf180mcu_as_sc_mcu7t3v3__inv_2_181/VNW VSUBS gf180mcu_as_sc_mcu7t3v3__inv_2
Xgf180mcu_as_sc_mcu7t3v3__inv_2_1628 VSS gf180mcu_as_sc_mcu7t3v3__inv_2_1671/VDD gf180mcu_as_sc_mcu7t3v3__inv_2_1675/Y
+ gf180mcu_as_sc_mcu7t3v3__inv_2_1675/Y gf180mcu_as_sc_mcu7t3v3__inv_2_1670/VNW VSUBS
+ gf180mcu_as_sc_mcu7t3v3__inv_2
Xgf180mcu_as_sc_mcu7t3v3__inv_2_1639 gf180mcu_as_sc_mcu7t3v3__inv_2_1674/VDD gf180mcu_as_sc_mcu7t3v3__inv_2_1675/VDD
+ VSS gf180mcu_as_sc_mcu7t3v3__inv_2_1675/Y gf180mcu_as_sc_mcu7t3v3__inv_2_1674/VNW
+ VSUBS gf180mcu_as_sc_mcu7t3v3__inv_2
Xu_t015_029 u_t015_029/c0_w0_bl u_t015_029/c0_w0_br u_t015_029/c0_w1_bl u_t015_029/c0_w1_br
+ u_t015_029/c0_r0_rbl u_t015_029/c0_r1_rbl u_t015_029/c1_w0_bl u_t015_029/c1_w0_br
+ u_t015_029/c1_w1_bl u_t015_029/c1_w1_br u_t015_029/c1_r0_rbl u_t015_029/c1_r1_rbl
+ u_t015_029/c2_w0_bl u_t015_029/c2_w0_br u_t015_029/c2_w1_bl u_t015_029/c2_w1_br
+ u_t015_029/c2_r0_rbl u_t015_029/c2_r1_rbl u_t015_029/c3_w0_bl u_t015_029/c3_w0_br
+ u_t015_029/c3_w1_bl u_t015_029/c3_w1_br u_t015_029/c3_r0_rbl u_t015_029/c3_r1_rbl
+ u_t015_029/r0_w0_wl u_t015_029/r0_w1_wl u_t015_029/r0_r0_rwl u_t015_029/r0_r1_rwl
+ u_t015_029/r1_w0_wl u_t015_029/r1_w1_wl u_t015_029/r1_r0_rwl u_t015_029/r1_r1_rwl
+ u_t015_029/r2_w0_wl u_t015_029/r2_w1_wl u_t015_029/r2_r0_rwl u_t015_029/r2_r1_rwl
+ u_t015_029/r3_w0_wl u_t015_029/r3_w1_wl u_t015_029/r3_r0_rwl u_t015_029/r3_r1_rwl
+ u_t015_029/VDD u_t015_031/VSS VSUBS detronyx_12t_2w2r_rc4_4x4_routed_5layer_direct
Xu_t015_018 u_t015_018/c0_w0_bl u_t015_018/c0_w0_br u_t015_018/c0_w1_bl u_t015_018/c0_w1_br
+ u_t015_018/c0_r0_rbl u_t015_018/c0_r1_rbl u_t015_018/c1_w0_bl u_t015_018/c1_w0_br
+ u_t015_018/c1_w1_bl u_t015_018/c1_w1_br u_t015_018/c1_r0_rbl u_t015_018/c1_r1_rbl
+ u_t015_018/c2_w0_bl u_t015_018/c2_w0_br u_t015_018/c2_w1_bl u_t015_018/c2_w1_br
+ u_t015_018/c2_r0_rbl u_t015_018/c2_r1_rbl u_t015_018/c3_w0_bl u_t015_018/c3_w0_br
+ u_t015_018/c3_w1_bl u_t015_018/c3_w1_br u_t015_018/c3_r0_rbl u_t015_018/c3_r1_rbl
+ u_t015_018/r0_w0_wl u_t015_018/r0_w1_wl u_t015_018/r0_r0_rwl u_t015_018/r0_r1_rwl
+ u_t015_018/r1_w0_wl u_t015_018/r1_w1_wl u_t015_018/r1_r0_rwl u_t015_018/r1_r1_rwl
+ u_t015_018/r2_w0_wl u_t015_018/r2_w1_wl u_t015_018/r2_r0_rwl u_t015_018/r2_r1_rwl
+ u_t015_018/r3_w0_wl u_t015_018/r3_w1_wl u_t015_018/r3_r0_rwl u_t015_018/r3_r1_rwl
+ u_t015_018/VDD u_t015_018/VSS VSUBS detronyx_12t_2w2r_rc4_4x4_routed_5layer_direct
Xu_t015_007 u_t015_007/c0_w0_bl u_t015_007/c0_w0_br u_t015_007/c0_w1_bl u_t015_007/c0_w1_br
+ u_t015_007/c0_r0_rbl u_t015_007/c0_r1_rbl u_t015_007/c1_w0_bl u_t015_007/c1_w0_br
+ u_t015_007/c1_w1_bl u_t015_007/c1_w1_br u_t015_007/c1_r0_rbl u_t015_007/c1_r1_rbl
+ u_t015_007/c2_w0_bl u_t015_007/c2_w0_br u_t015_007/c2_w1_bl u_t015_007/c2_w1_br
+ u_t015_007/c2_r0_rbl u_t015_007/c2_r1_rbl u_t015_007/c3_w0_bl u_t015_007/c3_w0_br
+ u_t015_007/c3_w1_bl u_t015_007/c3_w1_br u_t015_007/c3_r0_rbl u_t015_007/c3_r1_rbl
+ u_t015_007/r0_w0_wl u_t015_007/r0_w1_wl u_t015_007/r0_r0_rwl u_t015_007/r0_r1_rwl
+ u_t015_007/r1_w0_wl u_t015_007/r1_w1_wl u_t015_007/r1_r0_rwl u_t015_007/r1_r1_rwl
+ u_t015_007/r2_w0_wl u_t015_007/r2_w1_wl u_t015_007/r2_r0_rwl u_t015_007/r2_r1_rwl
+ u_t015_007/r3_w0_wl u_t015_007/r3_w1_wl u_t015_007/r3_r0_rwl u_t015_007/r3_r1_rwl
+ VSS u_t015_009/VSS VSUBS detronyx_12t_2w2r_rc4_4x4_routed_5layer_direct
Xu_t006_018 u_t006_018/c0_w0_bl u_t006_018/c0_w0_br u_t006_018/c0_w1_bl u_t006_018/c0_w1_br
+ u_t006_018/c0_r0_rbl u_t006_018/c0_r1_rbl u_t006_018/c1_w0_bl u_t006_018/c1_w0_br
+ u_t006_018/c1_w1_bl u_t006_018/c1_w1_br u_t006_018/c1_r0_rbl u_t006_018/c1_r1_rbl
+ u_t006_018/c2_w0_bl u_t006_018/c2_w0_br u_t006_018/c2_w1_bl u_t006_018/c2_w1_br
+ u_t006_018/c2_r0_rbl u_t006_018/c2_r1_rbl u_t006_018/c3_w0_bl u_t006_018/c3_w0_br
+ u_t006_018/c3_w1_bl u_t006_018/c3_w1_br u_t006_018/c3_r0_rbl u_t006_018/c3_r1_rbl
+ u_t006_018/r0_w0_wl u_t006_018/r0_w1_wl u_t006_018/r0_r0_rwl u_t006_018/r0_r1_rwl
+ u_t006_018/r1_w0_wl u_t006_018/r1_w1_wl u_t006_018/r1_r0_rwl u_t006_018/r1_r1_rwl
+ u_t006_018/r2_w0_wl u_t006_018/r2_w1_wl u_t006_018/r2_r0_rwl u_t006_018/r2_r1_rwl
+ u_t006_018/r3_w0_wl u_t006_018/r3_w1_wl u_t006_018/r3_r0_rwl u_t006_018/r3_r1_rwl
+ u_t006_018/VDD u_t006_018/VSS VSUBS detronyx_12t_2w2r_rc4_4x4_routed_5layer_direct
Xu_t006_007 u_t006_007/c0_w0_bl u_t006_007/c0_w0_br u_t006_007/c0_w1_bl u_t006_007/c0_w1_br
+ u_t006_007/c0_r0_rbl u_t006_007/c0_r1_rbl u_t006_007/c1_w0_bl u_t006_007/c1_w0_br
+ u_t006_007/c1_w1_bl u_t006_007/c1_w1_br u_t006_007/c1_r0_rbl u_t006_007/c1_r1_rbl
+ u_t006_007/c2_w0_bl u_t006_007/c2_w0_br u_t006_007/c2_w1_bl u_t006_007/c2_w1_br
+ u_t006_007/c2_r0_rbl u_t006_007/c2_r1_rbl u_t006_007/c3_w0_bl u_t006_007/c3_w0_br
+ u_t006_007/c3_w1_bl u_t006_007/c3_w1_br u_t006_007/c3_r0_rbl u_t006_007/c3_r1_rbl
+ u_t006_007/r0_w0_wl u_t006_007/r0_w1_wl u_t006_007/r0_r0_rwl u_t006_007/r0_r1_rwl
+ u_t006_007/r1_w0_wl u_t006_007/r1_w1_wl u_t006_007/r1_r0_rwl u_t006_007/r1_r1_rwl
+ u_t006_007/r2_w0_wl u_t006_007/r2_w1_wl u_t006_007/r2_r0_rwl u_t006_007/r2_r1_rwl
+ u_t006_007/r3_w0_wl u_t006_007/r3_w1_wl u_t006_007/r3_r0_rwl u_t006_007/r3_r1_rwl
+ VSS u_t006_009/VSS VSUBS detronyx_12t_2w2r_rc4_4x4_routed_5layer_direct
Xgf180mcu_as_sc_mcu7t3v3__nand2_2_41 gf180mcu_as_sc_mcu7t3v3__nor2_2_4/VDD gf180mcu_as_sc_mcu7t3v3__nand3_2_8/VSS
+ VSS VSS VSS gf180mcu_as_sc_mcu7t3v3__nor2_2_4/VNW VSUBS gf180mcu_as_sc_mcu7t3v3__nand2_2
Xgf180mcu_as_sc_mcu7t3v3__nand2_2_30 gf180mcu_as_sc_mcu7t3v3__nand3_2_5/VDD gf180mcu_as_sc_mcu7t3v3__nor2_2_4/VSS
+ VSS VSS VSS gf180mcu_as_sc_mcu7t3v3__nand3_2_5/VNW VSUBS gf180mcu_as_sc_mcu7t3v3__nand2_2
Xu_t006_029 u_t006_029/c0_w0_bl u_t006_029/c0_w0_br u_t006_029/c0_w1_bl u_t006_029/c0_w1_br
+ u_t006_029/c0_r0_rbl u_t006_029/c0_r1_rbl u_t006_029/c1_w0_bl u_t006_029/c1_w0_br
+ u_t006_029/c1_w1_bl u_t006_029/c1_w1_br u_t006_029/c1_r0_rbl u_t006_029/c1_r1_rbl
+ u_t006_029/c2_w0_bl u_t006_029/c2_w0_br u_t006_029/c2_w1_bl u_t006_029/c2_w1_br
+ u_t006_029/c2_r0_rbl u_t006_029/c2_r1_rbl u_t006_029/c3_w0_bl u_t006_029/c3_w0_br
+ u_t006_029/c3_w1_bl u_t006_029/c3_w1_br u_t006_029/c3_r0_rbl u_t006_029/c3_r1_rbl
+ u_t006_029/r0_w0_wl u_t006_029/r0_w1_wl u_t006_029/r0_r0_rwl u_t006_029/r0_r1_rwl
+ u_t006_029/r1_w0_wl u_t006_029/r1_w1_wl u_t006_029/r1_r0_rwl u_t006_029/r1_r1_rwl
+ u_t006_029/r2_w0_wl u_t006_029/r2_w1_wl u_t006_029/r2_r0_rwl u_t006_029/r2_r1_rwl
+ u_t006_029/r3_w0_wl u_t006_029/r3_w1_wl u_t006_029/r3_r0_rwl u_t006_029/r3_r1_rwl
+ u_t006_029/VDD u_t006_031/VSS VSUBS detronyx_12t_2w2r_rc4_4x4_routed_5layer_direct
Xgf180mcu_as_sc_mcu7t3v3__nand2_2_63 gf180mcu_as_sc_mcu7t3v3__nor2_2_8/VDD gf180mcu_as_sc_mcu7t3v3__nand3_2_32/VSS
+ VSS VSS VSS gf180mcu_as_sc_mcu7t3v3__nor2_2_8/VNW VSUBS gf180mcu_as_sc_mcu7t3v3__nand2_2
Xgf180mcu_as_sc_mcu7t3v3__nand2_2_52 gf180mcu_as_sc_mcu7t3v3__nand3_2_31/VDD gf180mcu_as_sc_mcu7t3v3__nand3_2_31/VSS
+ VSS VSS VSS gf180mcu_as_sc_mcu7t3v3__nand3_2_31/VNW VSUBS gf180mcu_as_sc_mcu7t3v3__nand2_2
Xu_t020_021 u_t020_021/c0_w0_bl u_t020_021/c0_w0_br u_t020_021/c0_w1_bl u_t020_021/c0_w1_br
+ u_t020_021/c0_r0_rbl u_t020_021/c0_r1_rbl u_t020_021/c1_w0_bl u_t020_021/c1_w0_br
+ u_t020_021/c1_w1_bl u_t020_021/c1_w1_br u_t020_021/c1_r0_rbl u_t020_021/c1_r1_rbl
+ u_t020_021/c2_w0_bl u_t020_021/c2_w0_br u_t020_021/c2_w1_bl u_t020_021/c2_w1_br
+ u_t020_021/c2_r0_rbl u_t020_021/c2_r1_rbl u_t020_021/c3_w0_bl u_t020_021/c3_w0_br
+ u_t020_021/c3_w1_bl u_t020_021/c3_w1_br u_t020_021/c3_r0_rbl u_t020_021/c3_r1_rbl
+ u_t020_021/r0_w0_wl u_t020_021/r0_w1_wl u_t020_021/r0_r0_rwl u_t020_021/r0_r1_rwl
+ u_t020_021/r1_w0_wl u_t020_021/r1_w1_wl u_t020_021/r1_r0_rwl u_t020_021/r1_r1_rwl
+ u_t020_021/r2_w0_wl u_t020_021/r2_w1_wl u_t020_021/r2_r0_rwl u_t020_021/r2_r1_rwl
+ u_t020_021/r3_w0_wl u_t020_021/r3_w1_wl u_t020_021/r3_r0_rwl u_t020_021/r3_r1_rwl
+ u_t020_021/VDD u_t020_024/VSS VSUBS detronyx_12t_2w2r_rc4_4x4_routed_5layer_direct
Xu_t020_010 u_t020_010/c0_w0_bl u_t020_010/c0_w0_br u_t020_010/c0_w1_bl u_t020_010/c0_w1_br
+ u_t020_010/c0_r0_rbl u_t020_010/c0_r1_rbl u_t020_010/c1_w0_bl u_t020_010/c1_w0_br
+ u_t020_010/c1_w1_bl u_t020_010/c1_w1_br u_t020_010/c1_r0_rbl u_t020_010/c1_r1_rbl
+ u_t020_010/c2_w0_bl u_t020_010/c2_w0_br u_t020_010/c2_w1_bl u_t020_010/c2_w1_br
+ u_t020_010/c2_r0_rbl u_t020_010/c2_r1_rbl u_t020_010/c3_w0_bl u_t020_010/c3_w0_br
+ u_t020_010/c3_w1_bl u_t020_010/c3_w1_br u_t020_010/c3_r0_rbl u_t020_010/c3_r1_rbl
+ u_t020_010/r0_w0_wl u_t020_010/r0_w1_wl u_t020_010/r0_r0_rwl u_t020_010/r0_r1_rwl
+ u_t020_010/r1_w0_wl u_t020_010/r1_w1_wl u_t020_010/r1_r0_rwl u_t020_010/r1_r1_rwl
+ u_t020_010/r2_w0_wl u_t020_010/r2_w1_wl u_t020_010/r2_r0_rwl u_t020_010/r2_r1_rwl
+ u_t020_010/r3_w0_wl u_t020_010/r3_w1_wl u_t020_010/r3_r0_rwl u_t020_010/r3_r1_rwl
+ VSS u_t020_010/VSS VSUBS detronyx_12t_2w2r_rc4_4x4_routed_5layer_direct
Xgf180mcu_as_sc_mcu7t3v3__inv_2_1458 gf180mcu_as_sc_mcu7t3v3__inv_2_1497/VSS VSS VSS
+ VSS gf180mcu_as_sc_mcu7t3v3__inv_2_1462/VNW VSUBS gf180mcu_as_sc_mcu7t3v3__inv_2
Xgf180mcu_as_sc_mcu7t3v3__inv_2_1469 VSS gf180mcu_as_sc_mcu7t3v3__inv_2_1485/VSS VSS
+ VSS gf180mcu_as_sc_mcu7t3v3__inv_2_1485/VNW VSUBS gf180mcu_as_sc_mcu7t3v3__inv_2
Xgf180mcu_as_sc_mcu7t3v3__inv_2_1447 VSS VSS VSS VSS gf180mcu_as_sc_mcu7t3v3__inv_2_1448/VNW
+ VSUBS gf180mcu_as_sc_mcu7t3v3__inv_2
Xgf180mcu_as_sc_mcu7t3v3__inv_2_1436 VSS gf180mcu_as_sc_mcu7t3v3__inv_2_1440/VDD VSS
+ VSS gf180mcu_as_sc_mcu7t3v3__inv_2_1436/VNW VSUBS gf180mcu_as_sc_mcu7t3v3__inv_2
Xgf180mcu_as_sc_mcu7t3v3__inv_2_1414 gf180mcu_as_sc_mcu7t3v3__inv_2_1416/VDD gf180mcu_as_sc_mcu7t3v3__inv_2_1420/VDD
+ VSS VSS gf180mcu_as_sc_mcu7t3v3__inv_2_1416/VNW VSUBS gf180mcu_as_sc_mcu7t3v3__inv_2
Xgf180mcu_as_sc_mcu7t3v3__inv_2_1403 gf180mcu_as_sc_mcu7t3v3__inv_2_1433/VSS VSS gf180mcu_as_sc_mcu7t3v3__inv_2_1403/Y
+ VSS gf180mcu_as_sc_mcu7t3v3__inv_2_1404/VNW VSUBS gf180mcu_as_sc_mcu7t3v3__inv_2
Xgf180mcu_as_sc_mcu7t3v3__inv_2_1425 gf180mcu_as_sc_mcu7t3v3__inv_2_1502/VSS VSS gf180mcu_as_sc_mcu7t3v3__inv_2_1425/Y
+ VSS gf180mcu_as_sc_mcu7t3v3__inv_2_1429/VNW VSUBS gf180mcu_as_sc_mcu7t3v3__inv_2
Xgf180mcu_as_sc_mcu7t3v3__inv_2_909 VSS VSS VSS VSS gf180mcu_as_sc_mcu7t3v3__inv_2_909/VNW
+ VSUBS gf180mcu_as_sc_mcu7t3v3__inv_2
Xu_t011_021 u_t011_021/c0_w0_bl u_t011_021/c0_w0_br u_t011_021/c0_w1_bl u_t011_021/c0_w1_br
+ u_t011_021/c0_r0_rbl u_t011_021/c0_r1_rbl u_t011_021/c1_w0_bl u_t011_021/c1_w0_br
+ u_t011_021/c1_w1_bl u_t011_021/c1_w1_br u_t011_021/c1_r0_rbl u_t011_021/c1_r1_rbl
+ u_t011_021/c2_w0_bl u_t011_021/c2_w0_br u_t011_021/c2_w1_bl u_t011_021/c2_w1_br
+ u_t011_021/c2_r0_rbl u_t011_021/c2_r1_rbl u_t011_021/c3_w0_bl u_t011_021/c3_w0_br
+ u_t011_021/c3_w1_bl u_t011_021/c3_w1_br u_t011_021/c3_r0_rbl u_t011_021/c3_r1_rbl
+ u_t011_021/r0_w0_wl u_t011_021/r0_w1_wl u_t011_021/r0_r0_rwl u_t011_021/r0_r1_rwl
+ u_t011_021/r1_w0_wl u_t011_021/r1_w1_wl u_t011_021/r1_r0_rwl u_t011_021/r1_r1_rwl
+ u_t011_021/r2_w0_wl u_t011_021/r2_w1_wl u_t011_021/r2_r0_rwl u_t011_021/r2_r1_rwl
+ u_t011_021/r3_w0_wl u_t011_021/r3_w1_wl u_t011_021/r3_r0_rwl u_t011_021/r3_r1_rwl
+ u_t011_021/VDD u_t011_024/VSS VSUBS detronyx_12t_2w2r_rc4_4x4_routed_5layer_direct
Xu_t011_010 u_t011_010/c0_w0_bl u_t011_010/c0_w0_br u_t011_010/c0_w1_bl u_t011_010/c0_w1_br
+ u_t011_010/c0_r0_rbl u_t011_010/c0_r1_rbl u_t011_010/c1_w0_bl u_t011_010/c1_w0_br
+ u_t011_010/c1_w1_bl u_t011_010/c1_w1_br u_t011_010/c1_r0_rbl u_t011_010/c1_r1_rbl
+ u_t011_010/c2_w0_bl u_t011_010/c2_w0_br u_t011_010/c2_w1_bl u_t011_010/c2_w1_br
+ u_t011_010/c2_r0_rbl u_t011_010/c2_r1_rbl u_t011_010/c3_w0_bl u_t011_010/c3_w0_br
+ u_t011_010/c3_w1_bl u_t011_010/c3_w1_br u_t011_010/c3_r0_rbl u_t011_010/c3_r1_rbl
+ u_t011_010/r0_w0_wl u_t011_010/r0_w1_wl u_t011_010/r0_r0_rwl u_t011_010/r0_r1_rwl
+ u_t011_010/r1_w0_wl u_t011_010/r1_w1_wl u_t011_010/r1_r0_rwl u_t011_010/r1_r1_rwl
+ u_t011_010/r2_w0_wl u_t011_010/r2_w1_wl u_t011_010/r2_r0_rwl u_t011_010/r2_r1_rwl
+ u_t011_010/r3_w0_wl u_t011_010/r3_w1_wl u_t011_010/r3_r0_rwl u_t011_010/r3_r1_rwl
+ VSS u_t011_010/VSS VSUBS detronyx_12t_2w2r_rc4_4x4_routed_5layer_direct
Xgf180mcu_as_sc_mcu7t3v3__nand4_2_219 VSS VSS VSS VSS VSS VSS VSS gf180mcu_as_sc_mcu7t3v3__inv_2_768/VNW
+ VSUBS gf180mcu_as_sc_mcu7t3v3__nand4_2
Xgf180mcu_as_sc_mcu7t3v3__nand4_2_208 gf180mcu_as_sc_mcu7t3v3__inv_2_663/VDD VSS VSS
+ VSS VSS VSS VSS gf180mcu_as_sc_mcu7t3v3__inv_2_663/VNW VSUBS gf180mcu_as_sc_mcu7t3v3__nand4_2
Xu_t002_021 u_t002_021/c0_w0_bl u_t002_021/c0_w0_br u_t002_021/c0_w1_bl u_t002_021/c0_w1_br
+ u_t002_021/c0_r0_rbl u_t002_021/c0_r1_rbl u_t002_021/c1_w0_bl u_t002_021/c1_w0_br
+ u_t002_021/c1_w1_bl u_t002_021/c1_w1_br u_t002_021/c1_r0_rbl u_t002_021/c1_r1_rbl
+ u_t002_021/c2_w0_bl u_t002_021/c2_w0_br u_t002_021/c2_w1_bl u_t002_021/c2_w1_br
+ u_t002_021/c2_r0_rbl u_t002_021/c2_r1_rbl u_t002_021/c3_w0_bl u_t002_021/c3_w0_br
+ u_t002_021/c3_w1_bl u_t002_021/c3_w1_br u_t002_021/c3_r0_rbl u_t002_021/c3_r1_rbl
+ u_t002_021/r0_w0_wl u_t002_021/r0_w1_wl u_t002_021/r0_r0_rwl u_t002_021/r0_r1_rwl
+ u_t002_021/r1_w0_wl u_t002_021/r1_w1_wl u_t002_021/r1_r0_rwl u_t002_021/r1_r1_rwl
+ u_t002_021/r2_w0_wl u_t002_021/r2_w1_wl u_t002_021/r2_r0_rwl u_t002_021/r2_r1_rwl
+ u_t002_021/r3_w0_wl u_t002_021/r3_w1_wl u_t002_021/r3_r0_rwl u_t002_021/r3_r1_rwl
+ u_t002_021/VDD u_t002_024/VSS VSUBS detronyx_12t_2w2r_rc4_4x4_routed_5layer_direct
Xu_t002_010 u_t002_010/c0_w0_bl u_t002_010/c0_w0_br u_t002_010/c0_w1_bl u_t002_010/c0_w1_br
+ u_t002_010/c0_r0_rbl u_t002_010/c0_r1_rbl u_t002_010/c1_w0_bl u_t002_010/c1_w0_br
+ u_t002_010/c1_w1_bl u_t002_010/c1_w1_br u_t002_010/c1_r0_rbl u_t002_010/c1_r1_rbl
+ u_t002_010/c2_w0_bl u_t002_010/c2_w0_br u_t002_010/c2_w1_bl u_t002_010/c2_w1_br
+ u_t002_010/c2_r0_rbl u_t002_010/c2_r1_rbl u_t002_010/c3_w0_bl u_t002_010/c3_w0_br
+ u_t002_010/c3_w1_bl u_t002_010/c3_w1_br u_t002_010/c3_r0_rbl u_t002_010/c3_r1_rbl
+ u_t002_010/r0_w0_wl u_t002_010/r0_w1_wl u_t002_010/r0_r0_rwl u_t002_010/r0_r1_rwl
+ u_t002_010/r1_w0_wl u_t002_010/r1_w1_wl u_t002_010/r1_r0_rwl u_t002_010/r1_r1_rwl
+ u_t002_010/r2_w0_wl u_t002_010/r2_w1_wl u_t002_010/r2_r0_rwl u_t002_010/r2_r1_rwl
+ u_t002_010/r3_w0_wl u_t002_010/r3_w1_wl u_t002_010/r3_r0_rwl u_t002_010/r3_r1_rwl
+ VSS u_t002_010/VSS VSUBS detronyx_12t_2w2r_rc4_4x4_routed_5layer_direct
Xgf180mcu_as_sc_mcu7t3v3__inv_2_1266 gf180mcu_as_sc_mcu7t3v3__nor2_2_8/VDD gf180mcu_as_sc_mcu7t3v3__nand3_2_32/VSS
+ gf180mcu_as_sc_mcu7t3v3__inv_2_1266/Y VSS gf180mcu_as_sc_mcu7t3v3__nor2_2_8/VNW
+ VSUBS gf180mcu_as_sc_mcu7t3v3__inv_2
Xgf180mcu_as_sc_mcu7t3v3__inv_2_1255 gf180mcu_as_sc_mcu7t3v3__nor2_2_8/VDD gf180mcu_as_sc_mcu7t3v3__nor2_2_8/VSS
+ VSS VSS gf180mcu_as_sc_mcu7t3v3__nor2_2_8/VNW VSUBS gf180mcu_as_sc_mcu7t3v3__inv_2
Xgf180mcu_as_sc_mcu7t3v3__inv_2_1211 gf180mcu_as_sc_mcu7t3v3__nor2_2_8/VDD gf180mcu_as_sc_mcu7t3v3__nor2_2_8/VSS
+ VSS VSS gf180mcu_as_sc_mcu7t3v3__nor2_2_8/VNW VSUBS gf180mcu_as_sc_mcu7t3v3__inv_2
Xgf180mcu_as_sc_mcu7t3v3__inv_2_1222 gf180mcu_as_sc_mcu7t3v3__nor2_2_8/VDD gf180mcu_as_sc_mcu7t3v3__nor2_2_8/VSS
+ VSS VSS gf180mcu_as_sc_mcu7t3v3__nor2_2_8/VNW VSUBS gf180mcu_as_sc_mcu7t3v3__inv_2
Xgf180mcu_as_sc_mcu7t3v3__inv_2_1288 gf180mcu_as_sc_mcu7t3v3__nand3_2_31/VDD gf180mcu_as_sc_mcu7t3v3__nor2_2_8/VSS
+ VSS VSS gf180mcu_as_sc_mcu7t3v3__nand3_2_31/VNW VSUBS gf180mcu_as_sc_mcu7t3v3__inv_2
Xgf180mcu_as_sc_mcu7t3v3__inv_2_1200 gf180mcu_as_sc_mcu7t3v3__nand3_2_31/VDD gf180mcu_as_sc_mcu7t3v3__nor2_2_8/VSS
+ VSS VSS gf180mcu_as_sc_mcu7t3v3__nand3_2_31/VNW VSUBS gf180mcu_as_sc_mcu7t3v3__inv_2
Xgf180mcu_as_sc_mcu7t3v3__inv_2_1277 VSS VSS VSS VSS gf180mcu_as_sc_mcu7t3v3__inv_2_1277/VNW
+ VSUBS gf180mcu_as_sc_mcu7t3v3__inv_2
Xgf180mcu_as_sc_mcu7t3v3__inv_2_1244 VSS VSS VSS VSS gf180mcu_as_sc_mcu7t3v3__inv_2_1244/VNW
+ VSUBS gf180mcu_as_sc_mcu7t3v3__inv_2
Xgf180mcu_as_sc_mcu7t3v3__inv_2_1233 VSS VSS VSS VSS gf180mcu_as_sc_mcu7t3v3__inv_2_1235/VNW
+ VSUBS gf180mcu_as_sc_mcu7t3v3__inv_2
Xgf180mcu_as_sc_mcu7t3v3__inv_2_1299 VSS VSS gf180mcu_as_sc_mcu7t3v3__inv_2_1691/Y
+ gf180mcu_as_sc_mcu7t3v3__inv_2_1691/Y gf180mcu_as_sc_mcu7t3v3__inv_2_1380/VNW VSUBS
+ gf180mcu_as_sc_mcu7t3v3__inv_2
Xgf180mcu_as_sc_mcu7t3v3__inv_2_739 VSS gf180mcu_as_sc_mcu7t3v3__inv_2_741/VSS gf180mcu_as_sc_mcu7t3v3__inv_2_739/Y
+ gf180mcu_as_sc_mcu7t3v3__inv_2_739/A gf180mcu_as_sc_mcu7t3v3__inv_2_741/VNW VSUBS
+ gf180mcu_as_sc_mcu7t3v3__inv_2
Xgf180mcu_as_sc_mcu7t3v3__inv_2_706 gf180mcu_as_sc_mcu7t3v3__inv_2_727/VSS gf180mcu_as_sc_mcu7t3v3__inv_2_731/VDD
+ gf180mcu_as_sc_mcu7t3v3__inv_2_706/Y gf180mcu_as_sc_mcu7t3v3__inv_2_707/Y gf180mcu_as_sc_mcu7t3v3__inv_2_707/VNW
+ VSUBS gf180mcu_as_sc_mcu7t3v3__inv_2
Xgf180mcu_as_sc_mcu7t3v3__inv_2_717 gf180mcu_as_sc_mcu7t3v3__inv_2_719/VDD gf180mcu_as_sc_mcu7t3v3__inv_2_723/VDD
+ gf180mcu_as_sc_mcu7t3v3__inv_2_717/Y gf180mcu_as_sc_mcu7t3v3__inv_2_732/Y gf180mcu_as_sc_mcu7t3v3__inv_2_719/VNW
+ VSUBS gf180mcu_as_sc_mcu7t3v3__inv_2
Xgf180mcu_as_sc_mcu7t3v3__inv_2_728 VSS VSS gf180mcu_as_sc_mcu7t3v3__inv_2_728/Y gf180mcu_as_sc_mcu7t3v3__inv_2_732/Y
+ gf180mcu_as_sc_mcu7t3v3__inv_2_736/VNW VSUBS gf180mcu_as_sc_mcu7t3v3__inv_2
Xgf180mcu_as_sc_mcu7t3v3__inv_2_82 gf180mcu_as_sc_mcu7t3v3__inv_2_88/VSS gf180mcu_as_sc_mcu7t3v3__inv_2_88/VSS
+ VSS VSS gf180mcu_as_sc_mcu7t3v3__inv_2_83/VNW VSUBS gf180mcu_as_sc_mcu7t3v3__inv_2
Xgf180mcu_as_sc_mcu7t3v3__inv_2_93 gf180mcu_as_sc_mcu7t3v3__inv_2_95/VDD VSS VSS VSS
+ gf180mcu_as_sc_mcu7t3v3__inv_2_95/VNW VSUBS gf180mcu_as_sc_mcu7t3v3__inv_2
Xgf180mcu_as_sc_mcu7t3v3__inv_2_60 VSS gf180mcu_as_sc_mcu7t3v3__inv_2_61/VDD gf180mcu_as_sc_mcu7t3v3__inv_2_77/Y
+ VSS gf180mcu_as_sc_mcu7t3v3__inv_2_60/VNW VSUBS gf180mcu_as_sc_mcu7t3v3__inv_2
Xgf180mcu_as_sc_mcu7t3v3__inv_2_71 gf180mcu_as_sc_mcu7t3v3__inv_2_71/VDD gf180mcu_as_sc_mcu7t3v3__inv_2_73/VDD
+ gf180mcu_as_sc_mcu7t3v3__inv_2_71/Y VSS gf180mcu_as_sc_mcu7t3v3__inv_2_71/VNW VSUBS
+ gf180mcu_as_sc_mcu7t3v3__inv_2
Xgf180mcu_as_sc_mcu7t3v3__inv_2_1063 gf180mcu_as_sc_mcu7t3v3__inv_2_1064/VDD gf180mcu_as_sc_mcu7t3v3__inv_2_1072/VDD
+ gf180mcu_as_sc_mcu7t3v3__inv_2_1063/Y gf180mcu_as_sc_mcu7t3v3__inv_2_1064/Y gf180mcu_as_sc_mcu7t3v3__inv_2_1064/VNW
+ VSUBS gf180mcu_as_sc_mcu7t3v3__inv_2
Xgf180mcu_as_sc_mcu7t3v3__inv_2_1074 VSS gf180mcu_as_sc_mcu7t3v3__inv_2_1080/VDD VSS
+ gf180mcu_as_sc_mcu7t3v3__inv_2_1144/A gf180mcu_as_sc_mcu7t3v3__inv_2_1076/VNW VSUBS
+ gf180mcu_as_sc_mcu7t3v3__inv_2
Xgf180mcu_as_sc_mcu7t3v3__inv_2_1096 gf180mcu_as_sc_mcu7t3v3__inv_2_1096/VDD VSS gf180mcu_as_sc_mcu7t3v3__inv_2_1096/Y
+ VSS gf180mcu_as_sc_mcu7t3v3__inv_2_1096/VNW VSUBS gf180mcu_as_sc_mcu7t3v3__inv_2
Xgf180mcu_as_sc_mcu7t3v3__inv_2_1085 VSS gf180mcu_as_sc_mcu7t3v3__inv_2_1089/VSS gf180mcu_as_sc_mcu7t3v3__inv_2_1085/Y
+ gf180mcu_as_sc_mcu7t3v3__inv_2_1089/Y gf180mcu_as_sc_mcu7t3v3__inv_2_1089/VNW VSUBS
+ gf180mcu_as_sc_mcu7t3v3__inv_2
Xgf180mcu_as_sc_mcu7t3v3__inv_2_1052 gf180mcu_as_sc_mcu7t3v3__inv_2_1053/VDD VSS VSS
+ gf180mcu_as_sc_mcu7t3v3__inv_2_1052/A gf180mcu_as_sc_mcu7t3v3__inv_2_1053/VNW VSUBS
+ gf180mcu_as_sc_mcu7t3v3__inv_2
Xgf180mcu_as_sc_mcu7t3v3__inv_2_1030 gf180mcu_as_sc_mcu7t3v3__inv_2_1030/VDD gf180mcu_as_sc_mcu7t3v3__inv_2_1034/VDD
+ gf180mcu_as_sc_mcu7t3v3__inv_2_1030/Y VSS gf180mcu_as_sc_mcu7t3v3__inv_2_1030/VNW
+ VSUBS gf180mcu_as_sc_mcu7t3v3__inv_2
Xgf180mcu_as_sc_mcu7t3v3__inv_2_1041 gf180mcu_as_sc_mcu7t3v3__inv_2_1042/VDD gf180mcu_as_sc_mcu7t3v3__inv_2_1046/VDD
+ gf180mcu_as_sc_mcu7t3v3__inv_2_1041/Y gf180mcu_as_sc_mcu7t3v3__inv_2_1042/Y gf180mcu_as_sc_mcu7t3v3__inv_2_1042/VNW
+ VSUBS gf180mcu_as_sc_mcu7t3v3__inv_2
Xgf180mcu_as_sc_mcu7t3v3__nand4_2_8 gf180mcu_as_sc_mcu7t3v3__inv_2_8/VSS VSS VSS VSS
+ VSS VSS VSS gf180mcu_as_sc_mcu7t3v3__inv_2_53/VNW VSUBS gf180mcu_as_sc_mcu7t3v3__nand4_2
Xgf180mcu_as_sc_mcu7t3v3__inv_2_547 VSS VSS gf180mcu_as_sc_mcu7t3v3__inv_2_547/Y VSS
+ gf180mcu_as_sc_mcu7t3v3__inv_2_547/VNW VSUBS gf180mcu_as_sc_mcu7t3v3__inv_2
Xgf180mcu_as_sc_mcu7t3v3__inv_2_558 VSS VSS gf180mcu_as_sc_mcu7t3v3__inv_2_558/Y VSS
+ gf180mcu_as_sc_mcu7t3v3__inv_2_558/VNW VSUBS gf180mcu_as_sc_mcu7t3v3__inv_2
Xgf180mcu_as_sc_mcu7t3v3__inv_2_569 gf180mcu_as_sc_mcu7t3v3__inv_2_572/VDD gf180mcu_as_sc_mcu7t3v3__inv_2_572/VDD
+ gf180mcu_as_sc_mcu7t3v3__inv_2_569/Y VSS gf180mcu_as_sc_mcu7t3v3__inv_2_569/VNW
+ VSUBS gf180mcu_as_sc_mcu7t3v3__inv_2
Xgf180mcu_as_sc_mcu7t3v3__inv_2_514 VSS VSS VSS VSS gf180mcu_as_sc_mcu7t3v3__inv_2_514/VNW
+ VSUBS gf180mcu_as_sc_mcu7t3v3__inv_2
Xgf180mcu_as_sc_mcu7t3v3__inv_2_536 VSS VSS gf180mcu_as_sc_mcu7t3v3__inv_2_536/Y VSS
+ gf180mcu_as_sc_mcu7t3v3__inv_2_538/VNW VSUBS gf180mcu_as_sc_mcu7t3v3__inv_2
Xgf180mcu_as_sc_mcu7t3v3__inv_2_525 VSS VSS VSS VSS gf180mcu_as_sc_mcu7t3v3__inv_2_526/VNW
+ VSUBS gf180mcu_as_sc_mcu7t3v3__inv_2
Xgf180mcu_as_sc_mcu7t3v3__inv_2_503 VSS VSS VSS VSS gf180mcu_as_sc_mcu7t3v3__inv_2_511/VNW
+ VSUBS gf180mcu_as_sc_mcu7t3v3__inv_2
Xgf180mcu_as_sc_mcu7t3v3__nand4_2_380 gf180mcu_as_sc_mcu7t3v3__inv_2_1372/VDD gf180mcu_as_sc_mcu7t3v3__inv_2_1373/VDD
+ VSS VSS VSS VSS VSS gf180mcu_as_sc_mcu7t3v3__inv_2_1372/VNW VSUBS gf180mcu_as_sc_mcu7t3v3__nand4_2
Xgf180mcu_as_sc_mcu7t3v3__nand4_2_391 gf180mcu_as_sc_mcu7t3v3__inv_2_1375/VDD gf180mcu_as_sc_mcu7t3v3__inv_2_1376/VDD
+ VSS VSS VSS VSS VSS gf180mcu_as_sc_mcu7t3v3__inv_2_1375/VNW VSUBS gf180mcu_as_sc_mcu7t3v3__nand4_2
Xgf180mcu_as_sc_mcu7t3v3__inv_2_300 gf180mcu_as_sc_mcu7t3v3__inv_2_344/VDD VSS VSS
+ gf180mcu_as_sc_mcu7t3v3__inv_2_344/Y gf180mcu_as_sc_mcu7t3v3__inv_2_344/VNW VSUBS
+ gf180mcu_as_sc_mcu7t3v3__inv_2
Xgf180mcu_as_sc_mcu7t3v3__inv_2_311 gf180mcu_as_sc_mcu7t3v3__inv_2_334/VDD gf180mcu_as_sc_mcu7t3v3__inv_2_335/VDD
+ gf180mcu_as_sc_mcu7t3v3__inv_2_311/Y gf180mcu_as_sc_mcu7t3v3__inv_2_338/Y gf180mcu_as_sc_mcu7t3v3__inv_2_334/VNW
+ VSUBS gf180mcu_as_sc_mcu7t3v3__inv_2
Xgf180mcu_as_sc_mcu7t3v3__inv_2_399 gf180mcu_as_sc_mcu7t3v3__nor2_2_5/VDD gf180mcu_as_sc_mcu7t3v3__nor2_2_5/VSS
+ VSS VSS gf180mcu_as_sc_mcu7t3v3__nor2_2_5/VNW VSUBS gf180mcu_as_sc_mcu7t3v3__inv_2
Xgf180mcu_as_sc_mcu7t3v3__inv_2_377 gf180mcu_as_sc_mcu7t3v3__nor2_2_6/VDD gf180mcu_as_sc_mcu7t3v3__nand3_2_3/VSS
+ VSS VSS gf180mcu_as_sc_mcu7t3v3__nor2_2_6/VNW VSUBS gf180mcu_as_sc_mcu7t3v3__inv_2
Xgf180mcu_as_sc_mcu7t3v3__inv_2_388 gf180mcu_as_sc_mcu7t3v3__nand3_2_5/VDD gf180mcu_as_sc_mcu7t3v3__nor2_2_6/VSS
+ VSS VSS gf180mcu_as_sc_mcu7t3v3__nand3_2_5/VNW VSUBS gf180mcu_as_sc_mcu7t3v3__inv_2
Xgf180mcu_as_sc_mcu7t3v3__inv_2_366 gf180mcu_as_sc_mcu7t3v3__inv_2_368/VDD gf180mcu_as_sc_mcu7t3v3__inv_2_65/VDD
+ VSS gf180mcu_as_sc_mcu7t3v3__inv_2_66/Y gf180mcu_as_sc_mcu7t3v3__inv_2_368/VNW VSUBS
+ gf180mcu_as_sc_mcu7t3v3__inv_2
Xgf180mcu_as_sc_mcu7t3v3__inv_2_355 gf180mcu_as_sc_mcu7t3v3__inv_2_355/VDD gf180mcu_as_sc_mcu7t3v3__inv_2_356/VDD
+ gf180mcu_as_sc_mcu7t3v3__inv_2_358/Y VSS gf180mcu_as_sc_mcu7t3v3__inv_2_355/VNW
+ VSUBS gf180mcu_as_sc_mcu7t3v3__inv_2
Xgf180mcu_as_sc_mcu7t3v3__inv_2_344 gf180mcu_as_sc_mcu7t3v3__inv_2_344/VDD VSS gf180mcu_as_sc_mcu7t3v3__inv_2_344/Y
+ VSS gf180mcu_as_sc_mcu7t3v3__inv_2_344/VNW VSUBS gf180mcu_as_sc_mcu7t3v3__inv_2
Xgf180mcu_as_sc_mcu7t3v3__inv_2_322 gf180mcu_as_sc_mcu7t3v3__inv_2_338/VDD VSS VSS
+ gf180mcu_as_sc_mcu7t3v3__inv_2_338/Y gf180mcu_as_sc_mcu7t3v3__inv_2_338/VNW VSUBS
+ gf180mcu_as_sc_mcu7t3v3__inv_2
Xgf180mcu_as_sc_mcu7t3v3__inv_2_333 VSS gf180mcu_as_sc_mcu7t3v3__inv_2_334/VDD gf180mcu_as_sc_mcu7t3v3__inv_2_338/Y
+ VSS gf180mcu_as_sc_mcu7t3v3__inv_2_333/VNW VSUBS gf180mcu_as_sc_mcu7t3v3__inv_2
Xu_t027_027 u_t027_027/c0_w0_bl u_t027_027/c0_w0_br u_t027_027/c0_w1_bl u_t027_027/c0_w1_br
+ u_t027_027/c0_r0_rbl u_t027_027/c0_r1_rbl u_t027_027/c1_w0_bl u_t027_027/c1_w0_br
+ u_t027_027/c1_w1_bl u_t027_027/c1_w1_br u_t027_027/c1_r0_rbl u_t027_027/c1_r1_rbl
+ u_t027_027/c2_w0_bl u_t027_027/c2_w0_br u_t027_027/c2_w1_bl u_t027_027/c2_w1_br
+ u_t027_027/c2_r0_rbl u_t027_027/c2_r1_rbl u_t027_027/c3_w0_bl u_t027_027/c3_w0_br
+ u_t027_027/c3_w1_bl u_t027_027/c3_w1_br u_t027_027/c3_r0_rbl u_t027_027/c3_r1_rbl
+ u_t027_027/r0_w0_wl u_t027_027/r0_w1_wl u_t027_027/r0_r0_rwl u_t027_027/r0_r1_rwl
+ u_t027_027/r1_w0_wl u_t027_027/r1_w1_wl u_t027_027/r1_r0_rwl u_t027_027/r1_r1_rwl
+ u_t027_027/r2_w0_wl u_t027_027/r2_w1_wl u_t027_027/r2_r0_rwl u_t027_027/r2_r1_rwl
+ u_t027_027/r3_w0_wl u_t027_027/r3_w1_wl u_t027_027/r3_r0_rwl u_t027_027/r3_r1_rwl
+ u_t027_027/VDD u_t027_027/VSS VSUBS detronyx_12t_2w2r_rc4_4x4_routed_5layer_direct
Xu_t027_016 u_t027_016/c0_w0_bl u_t027_016/c0_w0_br u_t027_016/c0_w1_bl u_t027_016/c0_w1_br
+ u_t027_016/c0_r0_rbl u_t027_016/c0_r1_rbl u_t027_016/c1_w0_bl u_t027_016/c1_w0_br
+ u_t027_016/c1_w1_bl u_t027_016/c1_w1_br u_t027_016/c1_r0_rbl u_t027_016/c1_r1_rbl
+ u_t027_016/c2_w0_bl u_t027_016/c2_w0_br u_t027_016/c2_w1_bl u_t027_016/c2_w1_br
+ u_t027_016/c2_r0_rbl u_t027_016/c2_r1_rbl u_t027_016/c3_w0_bl u_t027_016/c3_w0_br
+ u_t027_016/c3_w1_bl u_t027_016/c3_w1_br u_t027_016/c3_r0_rbl u_t027_016/c3_r1_rbl
+ u_t027_016/r0_w0_wl u_t027_016/r0_w1_wl u_t027_016/r0_r0_rwl u_t027_016/r0_r1_rwl
+ u_t027_016/r1_w0_wl u_t027_016/r1_w1_wl u_t027_016/r1_r0_rwl u_t027_016/r1_r1_rwl
+ u_t027_016/r2_w0_wl u_t027_016/r2_w1_wl u_t027_016/r2_r0_rwl u_t027_016/r2_r1_rwl
+ u_t027_016/r3_w0_wl u_t027_016/r3_w1_wl u_t027_016/r3_r0_rwl u_t027_016/r3_r1_rwl
+ VSS u_t027_017/VSS VSUBS detronyx_12t_2w2r_rc4_4x4_routed_5layer_direct
Xu_t027_005 u_t027_005/c0_w0_bl u_t027_005/c0_w0_br u_t027_005/c0_w1_bl u_t027_005/c0_w1_br
+ u_t027_005/c0_r0_rbl u_t027_005/c0_r1_rbl u_t027_005/c1_w0_bl u_t027_005/c1_w0_br
+ u_t027_005/c1_w1_bl u_t027_005/c1_w1_br u_t027_005/c1_r0_rbl u_t027_005/c1_r1_rbl
+ u_t027_005/c2_w0_bl u_t027_005/c2_w0_br u_t027_005/c2_w1_bl u_t027_005/c2_w1_br
+ u_t027_005/c2_r0_rbl u_t027_005/c2_r1_rbl u_t027_005/c3_w0_bl u_t027_005/c3_w0_br
+ u_t027_005/c3_w1_bl u_t027_005/c3_w1_br u_t027_005/c3_r0_rbl u_t027_005/c3_r1_rbl
+ u_t027_005/r0_w0_wl u_t027_005/r0_w1_wl u_t027_005/r0_r0_rwl u_t027_005/r0_r1_rwl
+ u_t027_005/r1_w0_wl u_t027_005/r1_w1_wl u_t027_005/r1_r0_rwl u_t027_005/r1_r1_rwl
+ u_t027_005/r2_w0_wl u_t027_005/r2_w1_wl u_t027_005/r2_r0_rwl u_t027_005/r2_r1_rwl
+ u_t027_005/r3_w0_wl u_t027_005/r3_w1_wl u_t027_005/r3_r0_rwl u_t027_005/r3_r1_rwl
+ u_t027_005/VDD u_t027_005/VSS VSUBS detronyx_12t_2w2r_rc4_4x4_routed_5layer_direct
Xu_t018_027 u_t018_027/c0_w0_bl u_t018_027/c0_w0_br u_t018_027/c0_w1_bl u_t018_027/c0_w1_br
+ u_t018_027/c0_r0_rbl u_t018_027/c0_r1_rbl u_t018_027/c1_w0_bl u_t018_027/c1_w0_br
+ u_t018_027/c1_w1_bl u_t018_027/c1_w1_br u_t018_027/c1_r0_rbl u_t018_027/c1_r1_rbl
+ u_t018_027/c2_w0_bl u_t018_027/c2_w0_br u_t018_027/c2_w1_bl u_t018_027/c2_w1_br
+ u_t018_027/c2_r0_rbl u_t018_027/c2_r1_rbl u_t018_027/c3_w0_bl u_t018_027/c3_w0_br
+ u_t018_027/c3_w1_bl u_t018_027/c3_w1_br u_t018_027/c3_r0_rbl u_t018_027/c3_r1_rbl
+ u_t018_027/r0_w0_wl u_t018_027/r0_w1_wl u_t018_027/r0_r0_rwl u_t018_027/r0_r1_rwl
+ u_t018_027/r1_w0_wl u_t018_027/r1_w1_wl u_t018_027/r1_r0_rwl u_t018_027/r1_r1_rwl
+ u_t018_027/r2_w0_wl u_t018_027/r2_w1_wl u_t018_027/r2_r0_rwl u_t018_027/r2_r1_rwl
+ u_t018_027/r3_w0_wl u_t018_027/r3_w1_wl u_t018_027/r3_r0_rwl u_t018_027/r3_r1_rwl
+ u_t018_027/VDD u_t018_027/VSS VSUBS detronyx_12t_2w2r_rc4_4x4_routed_5layer_direct
Xu_t018_016 u_t018_016/c0_w0_bl u_t018_016/c0_w0_br u_t018_016/c0_w1_bl u_t018_016/c0_w1_br
+ u_t018_016/c0_r0_rbl u_t018_016/c0_r1_rbl u_t018_016/c1_w0_bl u_t018_016/c1_w0_br
+ u_t018_016/c1_w1_bl u_t018_016/c1_w1_br u_t018_016/c1_r0_rbl u_t018_016/c1_r1_rbl
+ u_t018_016/c2_w0_bl u_t018_016/c2_w0_br u_t018_016/c2_w1_bl u_t018_016/c2_w1_br
+ u_t018_016/c2_r0_rbl u_t018_016/c2_r1_rbl u_t018_016/c3_w0_bl u_t018_016/c3_w0_br
+ u_t018_016/c3_w1_bl u_t018_016/c3_w1_br u_t018_016/c3_r0_rbl u_t018_016/c3_r1_rbl
+ u_t018_016/r0_w0_wl u_t018_016/r0_w1_wl u_t018_016/r0_r0_rwl u_t018_016/r0_r1_rwl
+ u_t018_016/r1_w0_wl u_t018_016/r1_w1_wl u_t018_016/r1_r0_rwl u_t018_016/r1_r1_rwl
+ u_t018_016/r2_w0_wl u_t018_016/r2_w1_wl u_t018_016/r2_r0_rwl u_t018_016/r2_r1_rwl
+ u_t018_016/r3_w0_wl u_t018_016/r3_w1_wl u_t018_016/r3_r0_rwl u_t018_016/r3_r1_rwl
+ VSS u_t018_017/VSS VSUBS detronyx_12t_2w2r_rc4_4x4_routed_5layer_direct
Xu_t018_005 u_t018_005/c0_w0_bl u_t018_005/c0_w0_br u_t018_005/c0_w1_bl u_t018_005/c0_w1_br
+ u_t018_005/c0_r0_rbl u_t018_005/c0_r1_rbl u_t018_005/c1_w0_bl u_t018_005/c1_w0_br
+ u_t018_005/c1_w1_bl u_t018_005/c1_w1_br u_t018_005/c1_r0_rbl u_t018_005/c1_r1_rbl
+ u_t018_005/c2_w0_bl u_t018_005/c2_w0_br u_t018_005/c2_w1_bl u_t018_005/c2_w1_br
+ u_t018_005/c2_r0_rbl u_t018_005/c2_r1_rbl u_t018_005/c3_w0_bl u_t018_005/c3_w0_br
+ u_t018_005/c3_w1_bl u_t018_005/c3_w1_br u_t018_005/c3_r0_rbl u_t018_005/c3_r1_rbl
+ u_t018_005/r0_w0_wl u_t018_005/r0_w1_wl u_t018_005/r0_r0_rwl u_t018_005/r0_r1_rwl
+ u_t018_005/r1_w0_wl u_t018_005/r1_w1_wl u_t018_005/r1_r0_rwl u_t018_005/r1_r1_rwl
+ u_t018_005/r2_w0_wl u_t018_005/r2_w1_wl u_t018_005/r2_r0_rwl u_t018_005/r2_r1_rwl
+ u_t018_005/r3_w0_wl u_t018_005/r3_w1_wl u_t018_005/r3_r0_rwl u_t018_005/r3_r1_rwl
+ u_t018_005/VDD u_t018_005/VSS VSUBS detronyx_12t_2w2r_rc4_4x4_routed_5layer_direct
Xu_t009_027 u_t009_027/c0_w0_bl u_t009_027/c0_w0_br u_t009_027/c0_w1_bl u_t009_027/c0_w1_br
+ u_t009_027/c0_r0_rbl u_t009_027/c0_r1_rbl u_t009_027/c1_w0_bl u_t009_027/c1_w0_br
+ u_t009_027/c1_w1_bl u_t009_027/c1_w1_br u_t009_027/c1_r0_rbl u_t009_027/c1_r1_rbl
+ u_t009_027/c2_w0_bl u_t009_027/c2_w0_br u_t009_027/c2_w1_bl u_t009_027/c2_w1_br
+ u_t009_027/c2_r0_rbl u_t009_027/c2_r1_rbl u_t009_027/c3_w0_bl u_t009_027/c3_w0_br
+ u_t009_027/c3_w1_bl u_t009_027/c3_w1_br u_t009_027/c3_r0_rbl u_t009_027/c3_r1_rbl
+ u_t009_027/r0_w0_wl u_t009_027/r0_w1_wl u_t009_027/r0_r0_rwl u_t009_027/r0_r1_rwl
+ u_t009_027/r1_w0_wl u_t009_027/r1_w1_wl u_t009_027/r1_r0_rwl u_t009_027/r1_r1_rwl
+ u_t009_027/r2_w0_wl u_t009_027/r2_w1_wl u_t009_027/r2_r0_rwl u_t009_027/r2_r1_rwl
+ u_t009_027/r3_w0_wl u_t009_027/r3_w1_wl u_t009_027/r3_r0_rwl u_t009_027/r3_r1_rwl
+ u_t009_027/VDD u_t009_031/VSS VSUBS detronyx_12t_2w2r_rc4_4x4_routed_5layer_direct
Xu_t024_019 u_t024_019/c0_w0_bl u_t024_019/c0_w0_br u_t024_019/c0_w1_bl u_t024_019/c0_w1_br
+ u_t024_019/c0_r0_rbl u_t024_019/c0_r1_rbl u_t024_019/c1_w0_bl u_t024_019/c1_w0_br
+ u_t024_019/c1_w1_bl u_t024_019/c1_w1_br u_t024_019/c1_r0_rbl u_t024_019/c1_r1_rbl
+ u_t024_019/c2_w0_bl u_t024_019/c2_w0_br u_t024_019/c2_w1_bl u_t024_019/c2_w1_br
+ u_t024_019/c2_r0_rbl u_t024_019/c2_r1_rbl u_t024_019/c3_w0_bl u_t024_019/c3_w0_br
+ u_t024_019/c3_w1_bl u_t024_019/c3_w1_br u_t024_019/c3_r0_rbl u_t024_019/c3_r1_rbl
+ u_t024_019/r0_w0_wl u_t024_019/r0_w1_wl u_t024_019/r0_r0_rwl u_t024_019/r0_r1_rwl
+ u_t024_019/r1_w0_wl u_t024_019/r1_w1_wl u_t024_019/r1_r0_rwl u_t024_019/r1_r1_rwl
+ u_t024_019/r2_w0_wl u_t024_019/r2_w1_wl u_t024_019/r2_r0_rwl u_t024_019/r2_r1_rwl
+ u_t024_019/r3_w0_wl u_t024_019/r3_w1_wl u_t024_019/r3_r0_rwl u_t024_019/r3_r1_rwl
+ u_t025_019/VDD u_t024_019/VSS VSUBS detronyx_12t_2w2r_rc4_4x4_routed_5layer_direct
Xu_t009_016 u_t009_016/c0_w0_bl u_t009_016/c0_w0_br u_t009_016/c0_w1_bl u_t009_016/c0_w1_br
+ u_t009_016/c0_r0_rbl u_t009_016/c0_r1_rbl u_t009_016/c1_w0_bl u_t009_016/c1_w0_br
+ u_t009_016/c1_w1_bl u_t009_016/c1_w1_br u_t009_016/c1_r0_rbl u_t009_016/c1_r1_rbl
+ u_t009_016/c2_w0_bl u_t009_016/c2_w0_br u_t009_016/c2_w1_bl u_t009_016/c2_w1_br
+ u_t009_016/c2_r0_rbl u_t009_016/c2_r1_rbl u_t009_016/c3_w0_bl u_t009_016/c3_w0_br
+ u_t009_016/c3_w1_bl u_t009_016/c3_w1_br u_t009_016/c3_r0_rbl u_t009_016/c3_r1_rbl
+ u_t009_016/r0_w0_wl u_t009_016/r0_w1_wl u_t009_016/r0_r0_rwl u_t009_016/r0_r1_rwl
+ u_t009_016/r1_w0_wl u_t009_016/r1_w1_wl u_t009_016/r1_r0_rwl u_t009_016/r1_r1_rwl
+ u_t009_016/r2_w0_wl u_t009_016/r2_w1_wl u_t009_016/r2_r0_rwl u_t009_016/r2_r1_rwl
+ u_t009_016/r3_w0_wl u_t009_016/r3_w1_wl u_t009_016/r3_r0_rwl u_t009_016/r3_r1_rwl
+ VSS u_t009_031/VSS VSUBS detronyx_12t_2w2r_rc4_4x4_routed_5layer_direct
Xu_t024_008 u_t024_008/c0_w0_bl u_t024_008/c0_w0_br u_t024_008/c0_w1_bl u_t024_008/c0_w1_br
+ u_t024_008/c0_r0_rbl u_t024_008/c0_r1_rbl u_t024_008/c1_w0_bl u_t024_008/c1_w0_br
+ u_t024_008/c1_w1_bl u_t024_008/c1_w1_br u_t024_008/c1_r0_rbl u_t024_008/c1_r1_rbl
+ u_t024_008/c2_w0_bl u_t024_008/c2_w0_br u_t024_008/c2_w1_bl u_t024_008/c2_w1_br
+ u_t024_008/c2_r0_rbl u_t024_008/c2_r1_rbl u_t024_008/c3_w0_bl u_t024_008/c3_w0_br
+ u_t024_008/c3_w1_bl u_t024_008/c3_w1_br u_t024_008/c3_r0_rbl u_t024_008/c3_r1_rbl
+ u_t024_008/r0_w0_wl u_t024_008/r0_w1_wl u_t024_008/r0_r0_rwl u_t024_008/r0_r1_rwl
+ u_t024_008/r1_w0_wl u_t024_008/r1_w1_wl u_t024_008/r1_r0_rwl u_t024_008/r1_r1_rwl
+ u_t024_008/r2_w0_wl u_t024_008/r2_w1_wl u_t024_008/r2_r0_rwl u_t024_008/r2_r1_rwl
+ u_t024_008/r3_w0_wl u_t024_008/r3_w1_wl u_t024_008/r3_r0_rwl u_t024_008/r3_r1_rwl
+ VSS u_t024_009/VSS VSUBS detronyx_12t_2w2r_rc4_4x4_routed_5layer_direct
Xu_t009_005 u_t009_005/c0_w0_bl u_t009_005/c0_w0_br u_t009_005/c0_w1_bl u_t009_005/c0_w1_br
+ u_t009_005/c0_r0_rbl u_t009_005/c0_r1_rbl u_t009_005/c1_w0_bl u_t009_005/c1_w0_br
+ u_t009_005/c1_w1_bl u_t009_005/c1_w1_br u_t009_005/c1_r0_rbl u_t009_005/c1_r1_rbl
+ u_t009_005/c2_w0_bl u_t009_005/c2_w0_br u_t009_005/c2_w1_bl u_t009_005/c2_w1_br
+ u_t009_005/c2_r0_rbl u_t009_005/c2_r1_rbl u_t009_005/c3_w0_bl u_t009_005/c3_w0_br
+ u_t009_005/c3_w1_bl u_t009_005/c3_w1_br u_t009_005/c3_r0_rbl u_t009_005/c3_r1_rbl
+ u_t009_005/r0_w0_wl u_t009_005/r0_w1_wl u_t009_005/r0_r0_rwl u_t009_005/r0_r1_rwl
+ u_t009_005/r1_w0_wl u_t009_005/r1_w1_wl u_t009_005/r1_r0_rwl u_t009_005/r1_r1_rwl
+ u_t009_005/r2_w0_wl u_t009_005/r2_w1_wl u_t009_005/r2_r0_rwl u_t009_005/r2_r1_rwl
+ u_t009_005/r3_w0_wl u_t009_005/r3_w1_wl u_t009_005/r3_r0_rwl u_t009_005/r3_r1_rwl
+ u_t009_005/VDD u_t009_031/VSS VSUBS detronyx_12t_2w2r_rc4_4x4_routed_5layer_direct
Xgf180mcu_as_sc_mcu7t3v3__inv_2_141 VSS gf180mcu_as_sc_mcu7t3v3__inv_2_146/VDD VSS
+ VSS gf180mcu_as_sc_mcu7t3v3__inv_2_142/VNW VSUBS gf180mcu_as_sc_mcu7t3v3__inv_2
Xgf180mcu_as_sc_mcu7t3v3__inv_2_130 VSS gf180mcu_as_sc_mcu7t3v3__inv_2_134/VDD VSS
+ VSS gf180mcu_as_sc_mcu7t3v3__inv_2_130/VNW VSUBS gf180mcu_as_sc_mcu7t3v3__inv_2
Xgf180mcu_as_sc_mcu7t3v3__inv_2_152 gf180mcu_as_sc_mcu7t3v3__inv_2_152/VSS gf180mcu_as_sc_mcu7t3v3__inv_2_152/VSS
+ VSS VSS gf180mcu_as_sc_mcu7t3v3__inv_2_152/VNW VSUBS gf180mcu_as_sc_mcu7t3v3__inv_2
Xgf180mcu_as_sc_mcu7t3v3__inv_2_1629 VSS VSS gf180mcu_as_sc_mcu7t3v3__inv_2_1682/Y
+ gf180mcu_as_sc_mcu7t3v3__inv_2_1682/Y gf180mcu_as_sc_mcu7t3v3__inv_2_1679/VNW VSUBS
+ gf180mcu_as_sc_mcu7t3v3__inv_2
Xgf180mcu_as_sc_mcu7t3v3__inv_2_1607 gf180mcu_as_sc_mcu7t3v3__inv_2_1654/VDD VSS gf180mcu_as_sc_mcu7t3v3__inv_2_1607/Y
+ gf180mcu_as_sc_mcu7t3v3__inv_2_1682/Y gf180mcu_as_sc_mcu7t3v3__inv_2_1654/VNW VSUBS
+ gf180mcu_as_sc_mcu7t3v3__inv_2
Xgf180mcu_as_sc_mcu7t3v3__inv_2_1618 gf180mcu_as_sc_mcu7t3v3__inv_2_1657/VDD VSS VSS
+ gf180mcu_as_sc_mcu7t3v3__inv_2_1657/Y gf180mcu_as_sc_mcu7t3v3__inv_2_1657/VNW VSUBS
+ gf180mcu_as_sc_mcu7t3v3__inv_2
Xgf180mcu_as_sc_mcu7t3v3__inv_2_185 VSS VSS VSS VSS gf180mcu_as_sc_mcu7t3v3__inv_2_193/VNW
+ VSUBS gf180mcu_as_sc_mcu7t3v3__inv_2
Xgf180mcu_as_sc_mcu7t3v3__inv_2_163 gf180mcu_as_sc_mcu7t3v3__inv_2_165/VDD VSS VSS
+ VSS gf180mcu_as_sc_mcu7t3v3__inv_2_165/VNW VSUBS gf180mcu_as_sc_mcu7t3v3__inv_2
Xgf180mcu_as_sc_mcu7t3v3__inv_2_196 VSS gf180mcu_as_sc_mcu7t3v3__inv_2_196/VSS VSS
+ VSS gf180mcu_as_sc_mcu7t3v3__inv_2_196/VNW VSUBS gf180mcu_as_sc_mcu7t3v3__inv_2
Xgf180mcu_as_sc_mcu7t3v3__inv_2_174 gf180mcu_as_sc_mcu7t3v3__inv_2_260/VSS gf180mcu_as_sc_mcu7t3v3__inv_2_205/VDD
+ gf180mcu_as_sc_mcu7t3v3__inv_2_174/Y VSS gf180mcu_as_sc_mcu7t3v3__inv_2_174/VNW
+ VSUBS gf180mcu_as_sc_mcu7t3v3__inv_2
Xu_t023_030 u_t023_030/c0_w0_bl u_t023_030/c0_w0_br u_t023_030/c0_w1_bl u_t023_030/c0_w1_br
+ u_t023_030/c0_r0_rbl u_t023_030/c0_r1_rbl u_t023_030/c1_w0_bl u_t023_030/c1_w0_br
+ u_t023_030/c1_w1_bl u_t023_030/c1_w1_br u_t023_030/c1_r0_rbl u_t023_030/c1_r1_rbl
+ u_t023_030/c2_w0_bl u_t023_030/c2_w0_br u_t023_030/c2_w1_bl u_t023_030/c2_w1_br
+ u_t023_030/c2_r0_rbl u_t023_030/c2_r1_rbl u_t023_030/c3_w0_bl u_t023_030/c3_w0_br
+ u_t023_030/c3_w1_bl u_t023_030/c3_w1_br u_t023_030/c3_r0_rbl u_t023_030/c3_r1_rbl
+ u_t023_030/r0_w0_wl u_t023_030/r0_w1_wl u_t023_030/r0_r0_rwl u_t023_030/r0_r1_rwl
+ u_t023_030/r1_w0_wl u_t023_030/r1_w1_wl u_t023_030/r1_r0_rwl u_t023_030/r1_r1_rwl
+ u_t023_030/r2_w0_wl u_t023_030/r2_w1_wl u_t023_030/r2_r0_rwl u_t023_030/r2_r1_rwl
+ u_t023_030/r3_w0_wl u_t023_030/r3_w1_wl u_t023_030/r3_r0_rwl u_t023_030/r3_r1_rwl
+ VSS u_t023_031/VSS VSUBS detronyx_12t_2w2r_rc4_4x4_routed_5layer_direct
Xu_t015_019 u_t015_019/c0_w0_bl u_t015_019/c0_w0_br u_t015_019/c0_w1_bl u_t015_019/c0_w1_br
+ u_t015_019/c0_r0_rbl u_t015_019/c0_r1_rbl u_t015_019/c1_w0_bl u_t015_019/c1_w0_br
+ u_t015_019/c1_w1_bl u_t015_019/c1_w1_br u_t015_019/c1_r0_rbl u_t015_019/c1_r1_rbl
+ u_t015_019/c2_w0_bl u_t015_019/c2_w0_br u_t015_019/c2_w1_bl u_t015_019/c2_w1_br
+ u_t015_019/c2_r0_rbl u_t015_019/c2_r1_rbl u_t015_019/c3_w0_bl u_t015_019/c3_w0_br
+ u_t015_019/c3_w1_bl u_t015_019/c3_w1_br u_t015_019/c3_r0_rbl u_t015_019/c3_r1_rbl
+ u_t015_019/r0_w0_wl u_t015_019/r0_w1_wl u_t015_019/r0_r0_rwl u_t015_019/r0_r1_rwl
+ u_t015_019/r1_w0_wl u_t015_019/r1_w1_wl u_t015_019/r1_r0_rwl u_t015_019/r1_r1_rwl
+ u_t015_019/r2_w0_wl u_t015_019/r2_w1_wl u_t015_019/r2_r0_rwl u_t015_019/r2_r1_rwl
+ u_t015_019/r3_w0_wl u_t015_019/r3_w1_wl u_t015_019/r3_r0_rwl u_t015_019/r3_r1_rwl
+ u_t015_019/VDD u_t015_019/VSS VSUBS detronyx_12t_2w2r_rc4_4x4_routed_5layer_direct
Xu_t015_008 u_t015_008/c0_w0_bl u_t015_008/c0_w0_br u_t015_008/c0_w1_bl u_t015_008/c0_w1_br
+ u_t015_008/c0_r0_rbl u_t015_008/c0_r1_rbl u_t015_008/c1_w0_bl u_t015_008/c1_w0_br
+ u_t015_008/c1_w1_bl u_t015_008/c1_w1_br u_t015_008/c1_r0_rbl u_t015_008/c1_r1_rbl
+ u_t015_008/c2_w0_bl u_t015_008/c2_w0_br u_t015_008/c2_w1_bl u_t015_008/c2_w1_br
+ u_t015_008/c2_r0_rbl u_t015_008/c2_r1_rbl u_t015_008/c3_w0_bl u_t015_008/c3_w0_br
+ u_t015_008/c3_w1_bl u_t015_008/c3_w1_br u_t015_008/c3_r0_rbl u_t015_008/c3_r1_rbl
+ u_t015_008/r0_w0_wl u_t015_008/r0_w1_wl u_t015_008/r0_r0_rwl u_t015_008/r0_r1_rwl
+ u_t015_008/r1_w0_wl u_t015_008/r1_w1_wl u_t015_008/r1_r0_rwl u_t015_008/r1_r1_rwl
+ u_t015_008/r2_w0_wl u_t015_008/r2_w1_wl u_t015_008/r2_r0_rwl u_t015_008/r2_r1_rwl
+ u_t015_008/r3_w0_wl u_t015_008/r3_w1_wl u_t015_008/r3_r0_rwl u_t015_008/r3_r1_rwl
+ VSS u_t015_009/VSS VSUBS detronyx_12t_2w2r_rc4_4x4_routed_5layer_direct
Xu_t006_019 u_t006_019/c0_w0_bl u_t006_019/c0_w0_br u_t006_019/c0_w1_bl u_t006_019/c0_w1_br
+ u_t006_019/c0_r0_rbl u_t006_019/c0_r1_rbl u_t006_019/c1_w0_bl u_t006_019/c1_w0_br
+ u_t006_019/c1_w1_bl u_t006_019/c1_w1_br u_t006_019/c1_r0_rbl u_t006_019/c1_r1_rbl
+ u_t006_019/c2_w0_bl u_t006_019/c2_w0_br u_t006_019/c2_w1_bl u_t006_019/c2_w1_br
+ u_t006_019/c2_r0_rbl u_t006_019/c2_r1_rbl u_t006_019/c3_w0_bl u_t006_019/c3_w0_br
+ u_t006_019/c3_w1_bl u_t006_019/c3_w1_br u_t006_019/c3_r0_rbl u_t006_019/c3_r1_rbl
+ u_t006_019/r0_w0_wl u_t006_019/r0_w1_wl u_t006_019/r0_r0_rwl u_t006_019/r0_r1_rwl
+ u_t006_019/r1_w0_wl u_t006_019/r1_w1_wl u_t006_019/r1_r0_rwl u_t006_019/r1_r1_rwl
+ u_t006_019/r2_w0_wl u_t006_019/r2_w1_wl u_t006_019/r2_r0_rwl u_t006_019/r2_r1_rwl
+ u_t006_019/r3_w0_wl u_t006_019/r3_w1_wl u_t006_019/r3_r0_rwl u_t006_019/r3_r1_rwl
+ u_t006_019/VDD u_t006_019/VSS VSUBS detronyx_12t_2w2r_rc4_4x4_routed_5layer_direct
Xu_t006_008 u_t006_008/c0_w0_bl u_t006_008/c0_w0_br u_t006_008/c0_w1_bl u_t006_008/c0_w1_br
+ u_t006_008/c0_r0_rbl u_t006_008/c0_r1_rbl u_t006_008/c1_w0_bl u_t006_008/c1_w0_br
+ u_t006_008/c1_w1_bl u_t006_008/c1_w1_br u_t006_008/c1_r0_rbl u_t006_008/c1_r1_rbl
+ u_t006_008/c2_w0_bl u_t006_008/c2_w0_br u_t006_008/c2_w1_bl u_t006_008/c2_w1_br
+ u_t006_008/c2_r0_rbl u_t006_008/c2_r1_rbl u_t006_008/c3_w0_bl u_t006_008/c3_w0_br
+ u_t006_008/c3_w1_bl u_t006_008/c3_w1_br u_t006_008/c3_r0_rbl u_t006_008/c3_r1_rbl
+ u_t006_008/r0_w0_wl u_t006_008/r0_w1_wl u_t006_008/r0_r0_rwl u_t006_008/r0_r1_rwl
+ u_t006_008/r1_w0_wl u_t006_008/r1_w1_wl u_t006_008/r1_r0_rwl u_t006_008/r1_r1_rwl
+ u_t006_008/r2_w0_wl u_t006_008/r2_w1_wl u_t006_008/r2_r0_rwl u_t006_008/r2_r1_rwl
+ u_t006_008/r3_w0_wl u_t006_008/r3_w1_wl u_t006_008/r3_r0_rwl u_t006_008/r3_r1_rwl
+ VSS u_t006_009/VSS VSUBS detronyx_12t_2w2r_rc4_4x4_routed_5layer_direct
Xgf180mcu_as_sc_mcu7t3v3__nand2_2_64 gf180mcu_as_sc_mcu7t3v3__nand3_2_31/VDD gf180mcu_as_sc_mcu7t3v3__nor2_2_8/VSS
+ VSS VSS VSS gf180mcu_as_sc_mcu7t3v3__nand3_2_31/VNW VSUBS gf180mcu_as_sc_mcu7t3v3__nand2_2
Xgf180mcu_as_sc_mcu7t3v3__nand2_2_53 gf180mcu_as_sc_mcu7t3v3__nand3_2_31/VDD gf180mcu_as_sc_mcu7t3v3__nor2_2_8/VSS
+ VSS VSS VSS gf180mcu_as_sc_mcu7t3v3__nand3_2_31/VNW VSUBS gf180mcu_as_sc_mcu7t3v3__nand2_2
Xgf180mcu_as_sc_mcu7t3v3__nand2_2_42 gf180mcu_as_sc_mcu7t3v3__nor2_2_5/VDD gf180mcu_as_sc_mcu7t3v3__nand3_2_8/VSS
+ VSS VSS VSS gf180mcu_as_sc_mcu7t3v3__nor2_2_5/VNW VSUBS gf180mcu_as_sc_mcu7t3v3__nand2_2
Xgf180mcu_as_sc_mcu7t3v3__nand2_2_20 gf180mcu_as_sc_mcu7t3v3__nor2_2_4/VDD gf180mcu_as_sc_mcu7t3v3__nor2_2_4/VSS
+ VSS VSS VSS gf180mcu_as_sc_mcu7t3v3__nor2_2_4/VNW VSUBS gf180mcu_as_sc_mcu7t3v3__nand2_2
Xgf180mcu_as_sc_mcu7t3v3__nand2_2_31 gf180mcu_as_sc_mcu7t3v3__nand3_2_5/VDD gf180mcu_as_sc_mcu7t3v3__nor2_2_6/VSS
+ VSS VSS VSS gf180mcu_as_sc_mcu7t3v3__nand3_2_5/VNW VSUBS gf180mcu_as_sc_mcu7t3v3__nand2_2
Xu_t014_030 u_t014_030/c0_w0_bl u_t014_030/c0_w0_br u_t014_030/c0_w1_bl u_t014_030/c0_w1_br
+ u_t014_030/c0_r0_rbl u_t014_030/c0_r1_rbl u_t014_030/c1_w0_bl u_t014_030/c1_w0_br
+ u_t014_030/c1_w1_bl u_t014_030/c1_w1_br u_t014_030/c1_r0_rbl u_t014_030/c1_r1_rbl
+ u_t014_030/c2_w0_bl u_t014_030/c2_w0_br u_t014_030/c2_w1_bl u_t014_030/c2_w1_br
+ u_t014_030/c2_r0_rbl u_t014_030/c2_r1_rbl u_t014_030/c3_w0_bl u_t014_030/c3_w0_br
+ u_t014_030/c3_w1_bl u_t014_030/c3_w1_br u_t014_030/c3_r0_rbl u_t014_030/c3_r1_rbl
+ u_t014_030/r0_w0_wl u_t014_030/r0_w1_wl u_t014_030/r0_r0_rwl u_t014_030/r0_r1_rwl
+ u_t014_030/r1_w0_wl u_t014_030/r1_w1_wl u_t014_030/r1_r0_rwl u_t014_030/r1_r1_rwl
+ u_t014_030/r2_w0_wl u_t014_030/r2_w1_wl u_t014_030/r2_r0_rwl u_t014_030/r2_r1_rwl
+ u_t014_030/r3_w0_wl u_t014_030/r3_w1_wl u_t014_030/r3_r0_rwl u_t014_030/r3_r1_rwl
+ VSS u_t014_031/VSS VSUBS detronyx_12t_2w2r_rc4_4x4_routed_5layer_direct
Xu_t005_030 u_t005_030/c0_w0_bl u_t005_030/c0_w0_br u_t005_030/c0_w1_bl u_t005_030/c0_w1_br
+ u_t005_030/c0_r0_rbl u_t005_030/c0_r1_rbl u_t005_030/c1_w0_bl u_t005_030/c1_w0_br
+ u_t005_030/c1_w1_bl u_t005_030/c1_w1_br u_t005_030/c1_r0_rbl u_t005_030/c1_r1_rbl
+ u_t005_030/c2_w0_bl u_t005_030/c2_w0_br u_t005_030/c2_w1_bl u_t005_030/c2_w1_br
+ u_t005_030/c2_r0_rbl u_t005_030/c2_r1_rbl u_t005_030/c3_w0_bl u_t005_030/c3_w0_br
+ u_t005_030/c3_w1_bl u_t005_030/c3_w1_br u_t005_030/c3_r0_rbl u_t005_030/c3_r1_rbl
+ u_t005_030/r0_w0_wl u_t005_030/r0_w1_wl u_t005_030/r0_r0_rwl u_t005_030/r0_r1_rwl
+ u_t005_030/r1_w0_wl u_t005_030/r1_w1_wl u_t005_030/r1_r0_rwl u_t005_030/r1_r1_rwl
+ u_t005_030/r2_w0_wl u_t005_030/r2_w1_wl u_t005_030/r2_r0_rwl u_t005_030/r2_r1_rwl
+ u_t005_030/r3_w0_wl u_t005_030/r3_w1_wl u_t005_030/r3_r0_rwl u_t005_030/r3_r1_rwl
+ VSS u_t005_031/VSS VSUBS detronyx_12t_2w2r_rc4_4x4_routed_5layer_direct
Xu_t020_000 u_t020_000/c0_w0_bl u_t020_000/c0_w0_br u_t020_000/c0_w1_bl u_t020_000/c0_w1_br
+ u_t020_000/c0_r0_rbl u_t020_000/c0_r1_rbl u_t020_000/c1_w0_bl u_t020_000/c1_w0_br
+ u_t020_000/c1_w1_bl u_t020_000/c1_w1_br u_t020_000/c1_r0_rbl u_t020_000/c1_r1_rbl
+ u_t020_000/c2_w0_bl u_t020_000/c2_w0_br u_t020_000/c2_w1_bl u_t020_000/c2_w1_br
+ u_t020_000/c2_r0_rbl u_t020_000/c2_r1_rbl u_t020_000/c3_w0_bl u_t020_000/c3_w0_br
+ u_t020_000/c3_w1_bl u_t020_000/c3_w1_br u_t020_000/c3_r0_rbl u_t020_000/c3_r1_rbl
+ u_t020_000/r0_w0_wl u_t020_000/r0_w1_wl u_t020_000/r0_r0_rwl u_t020_000/r0_r1_rwl
+ u_t020_000/r1_w0_wl u_t020_000/r1_w1_wl u_t020_000/r1_r0_rwl u_t020_000/r1_r1_rwl
+ u_t020_000/r2_w0_wl u_t020_000/r2_w1_wl u_t020_000/r2_r0_rwl u_t020_000/r2_r1_rwl
+ u_t020_000/r3_w0_wl u_t020_000/r3_w1_wl u_t020_000/r3_r0_rwl u_t020_000/r3_r1_rwl
+ VSS u_t020_002/VSS VSUBS detronyx_12t_2w2r_rc4_4x4_routed_5layer_direct
Xu_t020_022 u_t020_022/c0_w0_bl u_t020_022/c0_w0_br u_t020_022/c0_w1_bl u_t020_022/c0_w1_br
+ u_t020_022/c0_r0_rbl u_t020_022/c0_r1_rbl u_t020_022/c1_w0_bl u_t020_022/c1_w0_br
+ u_t020_022/c1_w1_bl u_t020_022/c1_w1_br u_t020_022/c1_r0_rbl u_t020_022/c1_r1_rbl
+ u_t020_022/c2_w0_bl u_t020_022/c2_w0_br u_t020_022/c2_w1_bl u_t020_022/c2_w1_br
+ u_t020_022/c2_r0_rbl u_t020_022/c2_r1_rbl u_t020_022/c3_w0_bl u_t020_022/c3_w0_br
+ u_t020_022/c3_w1_bl u_t020_022/c3_w1_br u_t020_022/c3_r0_rbl u_t020_022/c3_r1_rbl
+ u_t020_022/r0_w0_wl u_t020_022/r0_w1_wl u_t020_022/r0_r0_rwl u_t020_022/r0_r1_rwl
+ u_t020_022/r1_w0_wl u_t020_022/r1_w1_wl u_t020_022/r1_r0_rwl u_t020_022/r1_r1_rwl
+ u_t020_022/r2_w0_wl u_t020_022/r2_w1_wl u_t020_022/r2_r0_rwl u_t020_022/r2_r1_rwl
+ u_t020_022/r3_w0_wl u_t020_022/r3_w1_wl u_t020_022/r3_r0_rwl u_t020_022/r3_r1_rwl
+ VSS u_t020_024/VSS VSUBS detronyx_12t_2w2r_rc4_4x4_routed_5layer_direct
Xu_t020_011 u_t020_011/c0_w0_bl u_t020_011/c0_w0_br u_t020_011/c0_w1_bl u_t020_011/c0_w1_br
+ u_t020_011/c0_r0_rbl u_t020_011/c0_r1_rbl u_t020_011/c1_w0_bl u_t020_011/c1_w0_br
+ u_t020_011/c1_w1_bl u_t020_011/c1_w1_br u_t020_011/c1_r0_rbl u_t020_011/c1_r1_rbl
+ u_t020_011/c2_w0_bl u_t020_011/c2_w0_br u_t020_011/c2_w1_bl u_t020_011/c2_w1_br
+ u_t020_011/c2_r0_rbl u_t020_011/c2_r1_rbl u_t020_011/c3_w0_bl u_t020_011/c3_w0_br
+ u_t020_011/c3_w1_bl u_t020_011/c3_w1_br u_t020_011/c3_r0_rbl u_t020_011/c3_r1_rbl
+ u_t020_011/r0_w0_wl u_t020_011/r0_w1_wl u_t020_011/r0_r0_rwl u_t020_011/r0_r1_rwl
+ u_t020_011/r1_w0_wl u_t020_011/r1_w1_wl u_t020_011/r1_r0_rwl u_t020_011/r1_r1_rwl
+ u_t020_011/r2_w0_wl u_t020_011/r2_w1_wl u_t020_011/r2_r0_rwl u_t020_011/r2_r1_rwl
+ u_t020_011/r3_w0_wl u_t020_011/r3_w1_wl u_t020_011/r3_r0_rwl u_t020_011/r3_r1_rwl
+ u_t020_011/VDD u_t020_011/VSS VSUBS detronyx_12t_2w2r_rc4_4x4_routed_5layer_direct
Xgf180mcu_as_sc_mcu7t3v3__inv_2_1448 VSS VSS VSS VSS gf180mcu_as_sc_mcu7t3v3__inv_2_1448/VNW
+ VSUBS gf180mcu_as_sc_mcu7t3v3__inv_2
Xgf180mcu_as_sc_mcu7t3v3__inv_2_1426 gf180mcu_as_sc_mcu7t3v3__inv_2_1428/VDD gf180mcu_as_sc_mcu7t3v3__inv_2_1432/VDD
+ VSS VSS gf180mcu_as_sc_mcu7t3v3__inv_2_1428/VNW VSUBS gf180mcu_as_sc_mcu7t3v3__inv_2
Xgf180mcu_as_sc_mcu7t3v3__inv_2_1415 gf180mcu_as_sc_mcu7t3v3__inv_2_1416/VDD gf180mcu_as_sc_mcu7t3v3__inv_2_1420/VDD
+ gf180mcu_as_sc_mcu7t3v3__inv_2_1415/Y VSS gf180mcu_as_sc_mcu7t3v3__inv_2_1416/VNW
+ VSUBS gf180mcu_as_sc_mcu7t3v3__inv_2
Xgf180mcu_as_sc_mcu7t3v3__inv_2_1404 gf180mcu_as_sc_mcu7t3v3__inv_2_1433/VSS VSS gf180mcu_as_sc_mcu7t3v3__inv_2_1404/Y
+ VSS gf180mcu_as_sc_mcu7t3v3__inv_2_1404/VNW VSUBS gf180mcu_as_sc_mcu7t3v3__inv_2
Xgf180mcu_as_sc_mcu7t3v3__inv_2_1437 VSS VSS VSS VSS gf180mcu_as_sc_mcu7t3v3__inv_2_1445/VNW
+ VSUBS gf180mcu_as_sc_mcu7t3v3__inv_2
Xgf180mcu_as_sc_mcu7t3v3__inv_2_1459 VSS gf180mcu_as_sc_mcu7t3v3__inv_2_1502/VDD VSS
+ VSS gf180mcu_as_sc_mcu7t3v3__inv_2_1461/VNW VSUBS gf180mcu_as_sc_mcu7t3v3__inv_2
Xu_t011_022 u_t011_022/c0_w0_bl u_t011_022/c0_w0_br u_t011_022/c0_w1_bl u_t011_022/c0_w1_br
+ u_t011_022/c0_r0_rbl u_t011_022/c0_r1_rbl u_t011_022/c1_w0_bl u_t011_022/c1_w0_br
+ u_t011_022/c1_w1_bl u_t011_022/c1_w1_br u_t011_022/c1_r0_rbl u_t011_022/c1_r1_rbl
+ u_t011_022/c2_w0_bl u_t011_022/c2_w0_br u_t011_022/c2_w1_bl u_t011_022/c2_w1_br
+ u_t011_022/c2_r0_rbl u_t011_022/c2_r1_rbl u_t011_022/c3_w0_bl u_t011_022/c3_w0_br
+ u_t011_022/c3_w1_bl u_t011_022/c3_w1_br u_t011_022/c3_r0_rbl u_t011_022/c3_r1_rbl
+ u_t011_022/r0_w0_wl u_t011_022/r0_w1_wl u_t011_022/r0_r0_rwl u_t011_022/r0_r1_rwl
+ u_t011_022/r1_w0_wl u_t011_022/r1_w1_wl u_t011_022/r1_r0_rwl u_t011_022/r1_r1_rwl
+ u_t011_022/r2_w0_wl u_t011_022/r2_w1_wl u_t011_022/r2_r0_rwl u_t011_022/r2_r1_rwl
+ u_t011_022/r3_w0_wl u_t011_022/r3_w1_wl u_t011_022/r3_r0_rwl u_t011_022/r3_r1_rwl
+ VSS u_t011_024/VSS VSUBS detronyx_12t_2w2r_rc4_4x4_routed_5layer_direct
Xu_t011_011 u_t011_011/c0_w0_bl u_t011_011/c0_w0_br u_t011_011/c0_w1_bl u_t011_011/c0_w1_br
+ u_t011_011/c0_r0_rbl u_t011_011/c0_r1_rbl u_t011_011/c1_w0_bl u_t011_011/c1_w0_br
+ u_t011_011/c1_w1_bl u_t011_011/c1_w1_br u_t011_011/c1_r0_rbl u_t011_011/c1_r1_rbl
+ u_t011_011/c2_w0_bl u_t011_011/c2_w0_br u_t011_011/c2_w1_bl u_t011_011/c2_w1_br
+ u_t011_011/c2_r0_rbl u_t011_011/c2_r1_rbl u_t011_011/c3_w0_bl u_t011_011/c3_w0_br
+ u_t011_011/c3_w1_bl u_t011_011/c3_w1_br u_t011_011/c3_r0_rbl u_t011_011/c3_r1_rbl
+ u_t011_011/r0_w0_wl u_t011_011/r0_w1_wl u_t011_011/r0_r0_rwl u_t011_011/r0_r1_rwl
+ u_t011_011/r1_w0_wl u_t011_011/r1_w1_wl u_t011_011/r1_r0_rwl u_t011_011/r1_r1_rwl
+ u_t011_011/r2_w0_wl u_t011_011/r2_w1_wl u_t011_011/r2_r0_rwl u_t011_011/r2_r1_rwl
+ u_t011_011/r3_w0_wl u_t011_011/r3_w1_wl u_t011_011/r3_r0_rwl u_t011_011/r3_r1_rwl
+ u_t011_011/VDD u_t011_011/VSS VSUBS detronyx_12t_2w2r_rc4_4x4_routed_5layer_direct
Xu_t011_000 u_t011_000/c0_w0_bl u_t011_000/c0_w0_br u_t011_000/c0_w1_bl u_t011_000/c0_w1_br
+ u_t011_000/c0_r0_rbl u_t011_000/c0_r1_rbl u_t011_000/c1_w0_bl u_t011_000/c1_w0_br
+ u_t011_000/c1_w1_bl u_t011_000/c1_w1_br u_t011_000/c1_r0_rbl u_t011_000/c1_r1_rbl
+ u_t011_000/c2_w0_bl u_t011_000/c2_w0_br u_t011_000/c2_w1_bl u_t011_000/c2_w1_br
+ u_t011_000/c2_r0_rbl u_t011_000/c2_r1_rbl u_t011_000/c3_w0_bl u_t011_000/c3_w0_br
+ u_t011_000/c3_w1_bl u_t011_000/c3_w1_br u_t011_000/c3_r0_rbl u_t011_000/c3_r1_rbl
+ u_t011_000/r0_w0_wl u_t011_000/r0_w1_wl u_t011_000/r0_r0_rwl u_t011_000/r0_r1_rwl
+ u_t011_000/r1_w0_wl u_t011_000/r1_w1_wl u_t011_000/r1_r0_rwl u_t011_000/r1_r1_rwl
+ u_t011_000/r2_w0_wl u_t011_000/r2_w1_wl u_t011_000/r2_r0_rwl u_t011_000/r2_r1_rwl
+ u_t011_000/r3_w0_wl u_t011_000/r3_w1_wl u_t011_000/r3_r0_rwl u_t011_000/r3_r1_rwl
+ VSS u_t011_002/VSS VSUBS detronyx_12t_2w2r_rc4_4x4_routed_5layer_direct
Xgf180mcu_as_sc_mcu7t3v3__nand4_2_209 VSS VSS VSS VSS VSS VSS VSS gf180mcu_as_sc_mcu7t3v3__inv_2_676/VNW
+ VSUBS gf180mcu_as_sc_mcu7t3v3__nand4_2
Xu_t002_022 u_t002_022/c0_w0_bl u_t002_022/c0_w0_br u_t002_022/c0_w1_bl u_t002_022/c0_w1_br
+ u_t002_022/c0_r0_rbl u_t002_022/c0_r1_rbl u_t002_022/c1_w0_bl u_t002_022/c1_w0_br
+ u_t002_022/c1_w1_bl u_t002_022/c1_w1_br u_t002_022/c1_r0_rbl u_t002_022/c1_r1_rbl
+ u_t002_022/c2_w0_bl u_t002_022/c2_w0_br u_t002_022/c2_w1_bl u_t002_022/c2_w1_br
+ u_t002_022/c2_r0_rbl u_t002_022/c2_r1_rbl u_t002_022/c3_w0_bl u_t002_022/c3_w0_br
+ u_t002_022/c3_w1_bl u_t002_022/c3_w1_br u_t002_022/c3_r0_rbl u_t002_022/c3_r1_rbl
+ u_t002_022/r0_w0_wl u_t002_022/r0_w1_wl u_t002_022/r0_r0_rwl u_t002_022/r0_r1_rwl
+ u_t002_022/r1_w0_wl u_t002_022/r1_w1_wl u_t002_022/r1_r0_rwl u_t002_022/r1_r1_rwl
+ u_t002_022/r2_w0_wl u_t002_022/r2_w1_wl u_t002_022/r2_r0_rwl u_t002_022/r2_r1_rwl
+ u_t002_022/r3_w0_wl u_t002_022/r3_w1_wl u_t002_022/r3_r0_rwl u_t002_022/r3_r1_rwl
+ VSS u_t002_024/VSS VSUBS detronyx_12t_2w2r_rc4_4x4_routed_5layer_direct
Xu_t002_011 u_t002_011/c0_w0_bl u_t002_011/c0_w0_br u_t002_011/c0_w1_bl u_t002_011/c0_w1_br
+ u_t002_011/c0_r0_rbl u_t002_011/c0_r1_rbl u_t002_011/c1_w0_bl u_t002_011/c1_w0_br
+ u_t002_011/c1_w1_bl u_t002_011/c1_w1_br u_t002_011/c1_r0_rbl u_t002_011/c1_r1_rbl
+ u_t002_011/c2_w0_bl u_t002_011/c2_w0_br u_t002_011/c2_w1_bl u_t002_011/c2_w1_br
+ u_t002_011/c2_r0_rbl u_t002_011/c2_r1_rbl u_t002_011/c3_w0_bl u_t002_011/c3_w0_br
+ u_t002_011/c3_w1_bl u_t002_011/c3_w1_br u_t002_011/c3_r0_rbl u_t002_011/c3_r1_rbl
+ u_t002_011/r0_w0_wl u_t002_011/r0_w1_wl u_t002_011/r0_r0_rwl u_t002_011/r0_r1_rwl
+ u_t002_011/r1_w0_wl u_t002_011/r1_w1_wl u_t002_011/r1_r0_rwl u_t002_011/r1_r1_rwl
+ u_t002_011/r2_w0_wl u_t002_011/r2_w1_wl u_t002_011/r2_r0_rwl u_t002_011/r2_r1_rwl
+ u_t002_011/r3_w0_wl u_t002_011/r3_w1_wl u_t002_011/r3_r0_rwl u_t002_011/r3_r1_rwl
+ u_t002_011/VDD u_t002_011/VSS VSUBS detronyx_12t_2w2r_rc4_4x4_routed_5layer_direct
Xu_t002_000 u_t002_000/c0_w0_bl u_t002_000/c0_w0_br u_t002_000/c0_w1_bl u_t002_000/c0_w1_br
+ u_t002_000/c0_r0_rbl u_t002_000/c0_r1_rbl u_t002_000/c1_w0_bl u_t002_000/c1_w0_br
+ u_t002_000/c1_w1_bl u_t002_000/c1_w1_br u_t002_000/c1_r0_rbl u_t002_000/c1_r1_rbl
+ u_t002_000/c2_w0_bl u_t002_000/c2_w0_br u_t002_000/c2_w1_bl u_t002_000/c2_w1_br
+ u_t002_000/c2_r0_rbl u_t002_000/c2_r1_rbl u_t002_000/c3_w0_bl u_t002_000/c3_w0_br
+ u_t002_000/c3_w1_bl u_t002_000/c3_w1_br u_t002_000/c3_r0_rbl u_t002_000/c3_r1_rbl
+ u_t002_000/r0_w0_wl u_t002_000/r0_w1_wl u_t002_000/r0_r0_rwl u_t002_000/r0_r1_rwl
+ u_t002_000/r1_w0_wl u_t002_000/r1_w1_wl u_t002_000/r1_r0_rwl u_t002_000/r1_r1_rwl
+ u_t002_000/r2_w0_wl u_t002_000/r2_w1_wl u_t002_000/r2_r0_rwl u_t002_000/r2_r1_rwl
+ u_t002_000/r3_w0_wl u_t002_000/r3_w1_wl u_t002_000/r3_r0_rwl u_t002_000/r3_r1_rwl
+ VSS u_t002_002/VSS VSUBS detronyx_12t_2w2r_rc4_4x4_routed_5layer_direct
Xgf180mcu_as_sc_mcu7t3v3__inv_2_1201 gf180mcu_as_sc_mcu7t3v3__nand3_2_31/VDD gf180mcu_as_sc_mcu7t3v3__nand3_2_31/VSS
+ VSS VSS gf180mcu_as_sc_mcu7t3v3__nand3_2_31/VNW VSUBS gf180mcu_as_sc_mcu7t3v3__inv_2
Xgf180mcu_as_sc_mcu7t3v3__inv_2_1267 gf180mcu_as_sc_mcu7t3v3__nor2_2_8/VDD gf180mcu_as_sc_mcu7t3v3__nor2_2_8/VSS
+ gf180mcu_as_sc_mcu7t3v3__inv_2_1267/Y VSS gf180mcu_as_sc_mcu7t3v3__nor2_2_8/VNW
+ VSUBS gf180mcu_as_sc_mcu7t3v3__inv_2
Xgf180mcu_as_sc_mcu7t3v3__inv_2_1256 gf180mcu_as_sc_mcu7t3v3__nand3_2_31/VDD gf180mcu_as_sc_mcu7t3v3__nor2_2_8/VSS
+ VSS VSS gf180mcu_as_sc_mcu7t3v3__nand3_2_31/VNW VSUBS gf180mcu_as_sc_mcu7t3v3__inv_2
Xgf180mcu_as_sc_mcu7t3v3__inv_2_1212 gf180mcu_as_sc_mcu7t3v3__nand3_2_31/VDD gf180mcu_as_sc_mcu7t3v3__nor2_2_8/VSS
+ VSS VSS gf180mcu_as_sc_mcu7t3v3__nand3_2_31/VNW VSUBS gf180mcu_as_sc_mcu7t3v3__inv_2
Xgf180mcu_as_sc_mcu7t3v3__inv_2_1223 gf180mcu_as_sc_mcu7t3v3__nand3_2_31/VDD gf180mcu_as_sc_mcu7t3v3__nor2_2_8/VSS
+ VSS VSS gf180mcu_as_sc_mcu7t3v3__nand3_2_31/VNW VSUBS gf180mcu_as_sc_mcu7t3v3__inv_2
Xgf180mcu_as_sc_mcu7t3v3__inv_2_1289 gf180mcu_as_sc_mcu7t3v3__nand3_2_31/VDD gf180mcu_as_sc_mcu7t3v3__nand3_2_31/VSS
+ VSS VSS gf180mcu_as_sc_mcu7t3v3__nand3_2_31/VNW VSUBS gf180mcu_as_sc_mcu7t3v3__inv_2
Xgf180mcu_as_sc_mcu7t3v3__inv_2_1278 VSS VSS gf180mcu_as_sc_mcu7t3v3__inv_2_1278/Y
+ VSS gf180mcu_as_sc_mcu7t3v3__inv_2_1282/VNW VSUBS gf180mcu_as_sc_mcu7t3v3__inv_2
Xgf180mcu_as_sc_mcu7t3v3__inv_2_1245 VSS VSS gf180mcu_as_sc_mcu7t3v3__inv_2_1245/Y
+ VSS gf180mcu_as_sc_mcu7t3v3__inv_2_1245/VNW VSUBS gf180mcu_as_sc_mcu7t3v3__inv_2
Xgf180mcu_as_sc_mcu7t3v3__inv_2_1234 VSS VSS VSS VSS gf180mcu_as_sc_mcu7t3v3__inv_2_1235/VNW
+ VSUBS gf180mcu_as_sc_mcu7t3v3__inv_2
Xgf180mcu_as_sc_mcu7t3v3__inv_2_707 gf180mcu_as_sc_mcu7t3v3__inv_2_727/VSS gf180mcu_as_sc_mcu7t3v3__inv_2_731/VDD
+ gf180mcu_as_sc_mcu7t3v3__inv_2_707/Y VSS gf180mcu_as_sc_mcu7t3v3__inv_2_707/VNW
+ VSUBS gf180mcu_as_sc_mcu7t3v3__inv_2
Xgf180mcu_as_sc_mcu7t3v3__inv_2_729 gf180mcu_as_sc_mcu7t3v3__inv_2_731/VDD VSS gf180mcu_as_sc_mcu7t3v3__inv_2_729/Y
+ gf180mcu_as_sc_mcu7t3v3__inv_2_732/Y gf180mcu_as_sc_mcu7t3v3__inv_2_731/VNW VSUBS
+ gf180mcu_as_sc_mcu7t3v3__inv_2
Xgf180mcu_as_sc_mcu7t3v3__inv_2_718 gf180mcu_as_sc_mcu7t3v3__inv_2_719/VDD gf180mcu_as_sc_mcu7t3v3__inv_2_723/VDD
+ gf180mcu_as_sc_mcu7t3v3__inv_2_718/Y gf180mcu_as_sc_mcu7t3v3__inv_2_719/Y gf180mcu_as_sc_mcu7t3v3__inv_2_719/VNW
+ VSUBS gf180mcu_as_sc_mcu7t3v3__inv_2
Xgf180mcu_as_sc_mcu7t3v3__inv_2_1053 gf180mcu_as_sc_mcu7t3v3__inv_2_1053/VDD VSS gf180mcu_as_sc_mcu7t3v3__inv_2_1053/Y
+ gf180mcu_as_sc_mcu7t3v3__inv_2_1053/A gf180mcu_as_sc_mcu7t3v3__inv_2_1053/VNW VSUBS
+ gf180mcu_as_sc_mcu7t3v3__inv_2
Xgf180mcu_as_sc_mcu7t3v3__inv_2_1031 VSS VSS gf180mcu_as_sc_mcu7t3v3__inv_2_1031/Y
+ gf180mcu_as_sc_mcu7t3v3__inv_2_1035/Y gf180mcu_as_sc_mcu7t3v3__inv_2_1035/VNW VSUBS
+ gf180mcu_as_sc_mcu7t3v3__inv_2
Xgf180mcu_as_sc_mcu7t3v3__inv_2_1020 VSS VSS VSS gf180mcu_as_sc_mcu7t3v3__inv_2_992/A
+ gf180mcu_as_sc_mcu7t3v3__inv_2_1022/VNW VSUBS gf180mcu_as_sc_mcu7t3v3__inv_2
Xgf180mcu_as_sc_mcu7t3v3__inv_2_50 gf180mcu_as_sc_mcu7t3v3__inv_2_6/VSS gf180mcu_as_sc_mcu7t3v3__inv_2_6/VSS
+ gf180mcu_as_sc_mcu7t3v3__inv_2_8/A VSS gf180mcu_as_sc_mcu7t3v3__inv_2_6/VNW VSUBS
+ gf180mcu_as_sc_mcu7t3v3__inv_2
Xgf180mcu_as_sc_mcu7t3v3__inv_2_83 gf180mcu_as_sc_mcu7t3v3__inv_2_88/VSS gf180mcu_as_sc_mcu7t3v3__inv_2_88/VSS
+ VSS VSS gf180mcu_as_sc_mcu7t3v3__inv_2_83/VNW VSUBS gf180mcu_as_sc_mcu7t3v3__inv_2
Xgf180mcu_as_sc_mcu7t3v3__inv_2_94 gf180mcu_as_sc_mcu7t3v3__inv_2_95/VDD VSS VSS VSS
+ gf180mcu_as_sc_mcu7t3v3__inv_2_95/VNW VSUBS gf180mcu_as_sc_mcu7t3v3__inv_2
Xgf180mcu_as_sc_mcu7t3v3__inv_2_61 gf180mcu_as_sc_mcu7t3v3__inv_2_61/VDD gf180mcu_as_sc_mcu7t3v3__inv_2_62/VDD
+ gf180mcu_as_sc_mcu7t3v3__inv_2_77/Y VSS gf180mcu_as_sc_mcu7t3v3__inv_2_61/VNW VSUBS
+ gf180mcu_as_sc_mcu7t3v3__inv_2
Xgf180mcu_as_sc_mcu7t3v3__inv_2_72 gf180mcu_as_sc_mcu7t3v3__inv_2_73/VDD gf180mcu_as_sc_mcu7t3v3__inv_2_73/VDD
+ gf180mcu_as_sc_mcu7t3v3__inv_2_77/Y VSS gf180mcu_as_sc_mcu7t3v3__inv_2_72/VNW VSUBS
+ gf180mcu_as_sc_mcu7t3v3__inv_2
Xgf180mcu_as_sc_mcu7t3v3__inv_2_1042 gf180mcu_as_sc_mcu7t3v3__inv_2_1042/VDD gf180mcu_as_sc_mcu7t3v3__inv_2_1046/VDD
+ gf180mcu_as_sc_mcu7t3v3__inv_2_1042/Y VSS gf180mcu_as_sc_mcu7t3v3__inv_2_1042/VNW
+ VSUBS gf180mcu_as_sc_mcu7t3v3__inv_2
Xgf180mcu_as_sc_mcu7t3v3__inv_2_1097 gf180mcu_as_sc_mcu7t3v3__inv_2_1146/VSS gf180mcu_as_sc_mcu7t3v3__inv_2_1105/VSS
+ VSS gf180mcu_as_sc_mcu7t3v3__inv_2_1144/A gf180mcu_as_sc_mcu7t3v3__inv_2_1105/VNW
+ VSUBS gf180mcu_as_sc_mcu7t3v3__inv_2
Xgf180mcu_as_sc_mcu7t3v3__inv_2_1064 gf180mcu_as_sc_mcu7t3v3__inv_2_1064/VDD gf180mcu_as_sc_mcu7t3v3__inv_2_1072/VDD
+ gf180mcu_as_sc_mcu7t3v3__inv_2_1064/Y VSS gf180mcu_as_sc_mcu7t3v3__inv_2_1064/VNW
+ VSUBS gf180mcu_as_sc_mcu7t3v3__inv_2
Xgf180mcu_as_sc_mcu7t3v3__inv_2_1075 VSS gf180mcu_as_sc_mcu7t3v3__inv_2_1080/VDD gf180mcu_as_sc_mcu7t3v3__inv_2_1144/A
+ gf180mcu_as_sc_mcu7t3v3__inv_2_1076/Y gf180mcu_as_sc_mcu7t3v3__inv_2_1076/VNW VSUBS
+ gf180mcu_as_sc_mcu7t3v3__inv_2
Xgf180mcu_as_sc_mcu7t3v3__inv_2_1086 VSS VSS VSS gf180mcu_as_sc_mcu7t3v3__inv_2_1094/A
+ gf180mcu_as_sc_mcu7t3v3__inv_2_1088/VNW VSUBS gf180mcu_as_sc_mcu7t3v3__inv_2
Xgf180mcu_as_sc_mcu7t3v3__nand4_2_9 VSS gf180mcu_as_sc_mcu7t3v3__inv_2_61/VDD VSS
+ VSS VSS VSS VSS gf180mcu_as_sc_mcu7t3v3__inv_2_60/VNW VSUBS gf180mcu_as_sc_mcu7t3v3__nand4_2
Xgf180mcu_as_sc_mcu7t3v3__inv_2_559 gf180mcu_as_sc_mcu7t3v3__inv_2_636/VSS VSS gf180mcu_as_sc_mcu7t3v3__inv_2_559/Y
+ gf180mcu_as_sc_mcu7t3v3__inv_2_635/Y gf180mcu_as_sc_mcu7t3v3__inv_2_561/VNW VSUBS
+ gf180mcu_as_sc_mcu7t3v3__inv_2
Xgf180mcu_as_sc_mcu7t3v3__inv_2_548 gf180mcu_as_sc_mcu7t3v3__nand3_2_5/VDD gf180mcu_as_sc_mcu7t3v3__nor2_2_4/VSS
+ VSS VSS gf180mcu_as_sc_mcu7t3v3__nand3_2_5/VNW VSUBS gf180mcu_as_sc_mcu7t3v3__inv_2
Xgf180mcu_as_sc_mcu7t3v3__inv_2_504 VSS VSS gf180mcu_as_sc_mcu7t3v3__inv_2_504/Y VSS
+ gf180mcu_as_sc_mcu7t3v3__inv_2_506/VNW VSUBS gf180mcu_as_sc_mcu7t3v3__inv_2
Xgf180mcu_as_sc_mcu7t3v3__inv_2_537 VSS VSS VSS VSS gf180mcu_as_sc_mcu7t3v3__inv_2_538/VNW
+ VSUBS gf180mcu_as_sc_mcu7t3v3__inv_2
Xgf180mcu_as_sc_mcu7t3v3__inv_2_526 VSS VSS VSS VSS gf180mcu_as_sc_mcu7t3v3__inv_2_526/VNW
+ VSUBS gf180mcu_as_sc_mcu7t3v3__inv_2
Xgf180mcu_as_sc_mcu7t3v3__inv_2_515 VSS VSS gf180mcu_as_sc_mcu7t3v3__inv_2_515/Y VSS
+ gf180mcu_as_sc_mcu7t3v3__inv_2_535/VNW VSUBS gf180mcu_as_sc_mcu7t3v3__inv_2
Xgf180mcu_as_sc_mcu7t3v3__nand4_2_370 VSS VSS VSS VSS VSS VSS gf180mcu_as_sc_mcu7t3v3__nand4_2_370/Y
+ gf180mcu_as_sc_mcu7t3v3__inv_2_1194/VNW VSUBS gf180mcu_as_sc_mcu7t3v3__nand4_2
Xgf180mcu_as_sc_mcu7t3v3__nand4_2_381 VSS VSS VSS VSS VSS VSS VSS gf180mcu_as_sc_mcu7t3v3__inv_2_1380/VNW
+ VSUBS gf180mcu_as_sc_mcu7t3v3__nand4_2
Xgf180mcu_as_sc_mcu7t3v3__nand4_2_392 VSS VSS VSS VSS VSS VSS VSS gf180mcu_as_sc_mcu7t3v3__inv_2_1370/VNW
+ VSUBS gf180mcu_as_sc_mcu7t3v3__nand4_2
Xgf180mcu_as_sc_mcu7t3v3__inv_2_312 VSS VSS VSS gf180mcu_as_sc_mcu7t3v3__inv_2_344/Y
+ gf180mcu_as_sc_mcu7t3v3__inv_2_342/VNW VSUBS gf180mcu_as_sc_mcu7t3v3__inv_2
Xgf180mcu_as_sc_mcu7t3v3__inv_2_323 gf180mcu_as_sc_mcu7t3v3__inv_2_338/VDD VSS gf180mcu_as_sc_mcu7t3v3__inv_2_323/Y
+ gf180mcu_as_sc_mcu7t3v3__inv_2_338/Y gf180mcu_as_sc_mcu7t3v3__inv_2_338/VNW VSUBS
+ gf180mcu_as_sc_mcu7t3v3__inv_2
Xgf180mcu_as_sc_mcu7t3v3__inv_2_334 gf180mcu_as_sc_mcu7t3v3__inv_2_334/VDD gf180mcu_as_sc_mcu7t3v3__inv_2_335/VDD
+ gf180mcu_as_sc_mcu7t3v3__inv_2_338/Y VSS gf180mcu_as_sc_mcu7t3v3__inv_2_334/VNW
+ VSUBS gf180mcu_as_sc_mcu7t3v3__inv_2
Xgf180mcu_as_sc_mcu7t3v3__inv_2_301 gf180mcu_as_sc_mcu7t3v3__inv_2_331/VDD gf180mcu_as_sc_mcu7t3v3__inv_2_332/VDD
+ VSS gf180mcu_as_sc_mcu7t3v3__inv_2_338/Y gf180mcu_as_sc_mcu7t3v3__inv_2_331/VNW
+ VSUBS gf180mcu_as_sc_mcu7t3v3__inv_2
Xgf180mcu_as_sc_mcu7t3v3__inv_2_378 gf180mcu_as_sc_mcu7t3v3__nor2_2_4/VDD gf180mcu_as_sc_mcu7t3v3__nor2_2_4/VSS
+ VSS VSS gf180mcu_as_sc_mcu7t3v3__nor2_2_4/VNW VSUBS gf180mcu_as_sc_mcu7t3v3__inv_2
Xgf180mcu_as_sc_mcu7t3v3__inv_2_389 gf180mcu_as_sc_mcu7t3v3__nor2_2_6/VDD gf180mcu_as_sc_mcu7t3v3__nor2_2_6/VSS
+ VSS VSS gf180mcu_as_sc_mcu7t3v3__nor2_2_6/VNW VSUBS gf180mcu_as_sc_mcu7t3v3__inv_2
Xgf180mcu_as_sc_mcu7t3v3__inv_2_367 gf180mcu_as_sc_mcu7t3v3__inv_2_368/VDD gf180mcu_as_sc_mcu7t3v3__inv_2_65/VDD
+ gf180mcu_as_sc_mcu7t3v3__inv_2_66/Y gf180mcu_as_sc_mcu7t3v3__inv_2_66/Y gf180mcu_as_sc_mcu7t3v3__inv_2_368/VNW
+ VSUBS gf180mcu_as_sc_mcu7t3v3__inv_2
Xgf180mcu_as_sc_mcu7t3v3__inv_2_356 gf180mcu_as_sc_mcu7t3v3__inv_2_356/VDD gf180mcu_as_sc_mcu7t3v3__inv_2_357/VDD
+ gf180mcu_as_sc_mcu7t3v3__inv_2_358/Y VSS gf180mcu_as_sc_mcu7t3v3__inv_2_356/VNW
+ VSUBS gf180mcu_as_sc_mcu7t3v3__inv_2
Xgf180mcu_as_sc_mcu7t3v3__inv_2_345 VSS VSS gf180mcu_as_sc_mcu7t3v3__inv_2_358/Y VSS
+ gf180mcu_as_sc_mcu7t3v3__inv_2_345/VNW VSUBS gf180mcu_as_sc_mcu7t3v3__inv_2
Xu_t027_017 u_t027_017/c0_w0_bl u_t027_017/c0_w0_br u_t027_017/c0_w1_bl u_t027_017/c0_w1_br
+ u_t027_017/c0_r0_rbl u_t027_017/c0_r1_rbl u_t027_017/c1_w0_bl u_t027_017/c1_w0_br
+ u_t027_017/c1_w1_bl u_t027_017/c1_w1_br u_t027_017/c1_r0_rbl u_t027_017/c1_r1_rbl
+ u_t027_017/c2_w0_bl u_t027_017/c2_w0_br u_t027_017/c2_w1_bl u_t027_017/c2_w1_br
+ u_t027_017/c2_r0_rbl u_t027_017/c2_r1_rbl u_t027_017/c3_w0_bl u_t027_017/c3_w0_br
+ u_t027_017/c3_w1_bl u_t027_017/c3_w1_br u_t027_017/c3_r0_rbl u_t027_017/c3_r1_rbl
+ u_t027_017/r0_w0_wl u_t027_017/r0_w1_wl u_t027_017/r0_r0_rwl u_t027_017/r0_r1_rwl
+ u_t027_017/r1_w0_wl u_t027_017/r1_w1_wl u_t027_017/r1_r0_rwl u_t027_017/r1_r1_rwl
+ u_t027_017/r2_w0_wl u_t027_017/r2_w1_wl u_t027_017/r2_r0_rwl u_t027_017/r2_r1_rwl
+ u_t027_017/r3_w0_wl u_t027_017/r3_w1_wl u_t027_017/r3_r0_rwl u_t027_017/r3_r1_rwl
+ VSS u_t027_017/VSS VSUBS detronyx_12t_2w2r_rc4_4x4_routed_5layer_direct
Xu_t027_006 u_t027_006/c0_w0_bl u_t027_006/c0_w0_br u_t027_006/c0_w1_bl u_t027_006/c0_w1_br
+ u_t027_006/c0_r0_rbl u_t027_006/c0_r1_rbl u_t027_006/c1_w0_bl u_t027_006/c1_w0_br
+ u_t027_006/c1_w1_bl u_t027_006/c1_w1_br u_t027_006/c1_r0_rbl u_t027_006/c1_r1_rbl
+ u_t027_006/c2_w0_bl u_t027_006/c2_w0_br u_t027_006/c2_w1_bl u_t027_006/c2_w1_br
+ u_t027_006/c2_r0_rbl u_t027_006/c2_r1_rbl u_t027_006/c3_w0_bl u_t027_006/c3_w0_br
+ u_t027_006/c3_w1_bl u_t027_006/c3_w1_br u_t027_006/c3_r0_rbl u_t027_006/c3_r1_rbl
+ u_t027_006/r0_w0_wl u_t027_006/r0_w1_wl u_t027_006/r0_r0_rwl u_t027_006/r0_r1_rwl
+ u_t027_006/r1_w0_wl u_t027_006/r1_w1_wl u_t027_006/r1_r0_rwl u_t027_006/r1_r1_rwl
+ u_t027_006/r2_w0_wl u_t027_006/r2_w1_wl u_t027_006/r2_r0_rwl u_t027_006/r2_r1_rwl
+ u_t027_006/r3_w0_wl u_t027_006/r3_w1_wl u_t027_006/r3_r0_rwl u_t027_006/r3_r1_rwl
+ u_t027_006/VDD u_t027_009/VSS VSUBS detronyx_12t_2w2r_rc4_4x4_routed_5layer_direct
Xu_t027_028 u_t027_028/c0_w0_bl u_t027_028/c0_w0_br u_t027_028/c0_w1_bl u_t027_028/c0_w1_br
+ u_t027_028/c0_r0_rbl u_t027_028/c0_r1_rbl u_t027_028/c1_w0_bl u_t027_028/c1_w0_br
+ u_t027_028/c1_w1_bl u_t027_028/c1_w1_br u_t027_028/c1_r0_rbl u_t027_028/c1_r1_rbl
+ u_t027_028/c2_w0_bl u_t027_028/c2_w0_br u_t027_028/c2_w1_bl u_t027_028/c2_w1_br
+ u_t027_028/c2_r0_rbl u_t027_028/c2_r1_rbl u_t027_028/c3_w0_bl u_t027_028/c3_w0_br
+ u_t027_028/c3_w1_bl u_t027_028/c3_w1_br u_t027_028/c3_r0_rbl u_t027_028/c3_r1_rbl
+ u_t027_028/r0_w0_wl u_t027_028/r0_w1_wl u_t027_028/r0_r0_rwl u_t027_028/r0_r1_rwl
+ u_t027_028/r1_w0_wl u_t027_028/r1_w1_wl u_t027_028/r1_r0_rwl u_t027_028/r1_r1_rwl
+ u_t027_028/r2_w0_wl u_t027_028/r2_w1_wl u_t027_028/r2_r0_rwl u_t027_028/r2_r1_rwl
+ u_t027_028/r3_w0_wl u_t027_028/r3_w1_wl u_t027_028/r3_r0_rwl u_t027_028/r3_r1_rwl
+ u_t027_028/VDD u_t027_028/VSS VSUBS detronyx_12t_2w2r_rc4_4x4_routed_5layer_direct
Xgf180mcu_as_sc_mcu7t3v3__inv_2_890 VSS VSS VSS VSS gf180mcu_as_sc_mcu7t3v3__inv_2_892/VNW
+ VSUBS gf180mcu_as_sc_mcu7t3v3__inv_2
Xu_t018_028 u_t018_028/c0_w0_bl u_t018_028/c0_w0_br u_t018_028/c0_w1_bl u_t018_028/c0_w1_br
+ u_t018_028/c0_r0_rbl u_t018_028/c0_r1_rbl u_t018_028/c1_w0_bl u_t018_028/c1_w0_br
+ u_t018_028/c1_w1_bl u_t018_028/c1_w1_br u_t018_028/c1_r0_rbl u_t018_028/c1_r1_rbl
+ u_t018_028/c2_w0_bl u_t018_028/c2_w0_br u_t018_028/c2_w1_bl u_t018_028/c2_w1_br
+ u_t018_028/c2_r0_rbl u_t018_028/c2_r1_rbl u_t018_028/c3_w0_bl u_t018_028/c3_w0_br
+ u_t018_028/c3_w1_bl u_t018_028/c3_w1_br u_t018_028/c3_r0_rbl u_t018_028/c3_r1_rbl
+ u_t018_028/r0_w0_wl u_t018_028/r0_w1_wl u_t018_028/r0_r0_rwl u_t018_028/r0_r1_rwl
+ u_t018_028/r1_w0_wl u_t018_028/r1_w1_wl u_t018_028/r1_r0_rwl u_t018_028/r1_r1_rwl
+ u_t018_028/r2_w0_wl u_t018_028/r2_w1_wl u_t018_028/r2_r0_rwl u_t018_028/r2_r1_rwl
+ u_t018_028/r3_w0_wl u_t018_028/r3_w1_wl u_t018_028/r3_r0_rwl u_t018_028/r3_r1_rwl
+ u_t018_028/VDD u_t018_028/VSS VSUBS detronyx_12t_2w2r_rc4_4x4_routed_5layer_direct
Xu_t018_017 u_t018_017/c0_w0_bl u_t018_017/c0_w0_br u_t018_017/c0_w1_bl u_t018_017/c0_w1_br
+ u_t018_017/c0_r0_rbl u_t018_017/c0_r1_rbl u_t018_017/c1_w0_bl u_t018_017/c1_w0_br
+ u_t018_017/c1_w1_bl u_t018_017/c1_w1_br u_t018_017/c1_r0_rbl u_t018_017/c1_r1_rbl
+ u_t018_017/c2_w0_bl u_t018_017/c2_w0_br u_t018_017/c2_w1_bl u_t018_017/c2_w1_br
+ u_t018_017/c2_r0_rbl u_t018_017/c2_r1_rbl u_t018_017/c3_w0_bl u_t018_017/c3_w0_br
+ u_t018_017/c3_w1_bl u_t018_017/c3_w1_br u_t018_017/c3_r0_rbl u_t018_017/c3_r1_rbl
+ u_t018_017/r0_w0_wl u_t018_017/r0_w1_wl u_t018_017/r0_r0_rwl u_t018_017/r0_r1_rwl
+ u_t018_017/r1_w0_wl u_t018_017/r1_w1_wl u_t018_017/r1_r0_rwl u_t018_017/r1_r1_rwl
+ u_t018_017/r2_w0_wl u_t018_017/r2_w1_wl u_t018_017/r2_r0_rwl u_t018_017/r2_r1_rwl
+ u_t018_017/r3_w0_wl u_t018_017/r3_w1_wl u_t018_017/r3_r0_rwl u_t018_017/r3_r1_rwl
+ VSS u_t018_017/VSS VSUBS detronyx_12t_2w2r_rc4_4x4_routed_5layer_direct
Xu_t018_006 u_t018_006/c0_w0_bl u_t018_006/c0_w0_br u_t018_006/c0_w1_bl u_t018_006/c0_w1_br
+ u_t018_006/c0_r0_rbl u_t018_006/c0_r1_rbl u_t018_006/c1_w0_bl u_t018_006/c1_w0_br
+ u_t018_006/c1_w1_bl u_t018_006/c1_w1_br u_t018_006/c1_r0_rbl u_t018_006/c1_r1_rbl
+ u_t018_006/c2_w0_bl u_t018_006/c2_w0_br u_t018_006/c2_w1_bl u_t018_006/c2_w1_br
+ u_t018_006/c2_r0_rbl u_t018_006/c2_r1_rbl u_t018_006/c3_w0_bl u_t018_006/c3_w0_br
+ u_t018_006/c3_w1_bl u_t018_006/c3_w1_br u_t018_006/c3_r0_rbl u_t018_006/c3_r1_rbl
+ u_t018_006/r0_w0_wl u_t018_006/r0_w1_wl u_t018_006/r0_r0_rwl u_t018_006/r0_r1_rwl
+ u_t018_006/r1_w0_wl u_t018_006/r1_w1_wl u_t018_006/r1_r0_rwl u_t018_006/r1_r1_rwl
+ u_t018_006/r2_w0_wl u_t018_006/r2_w1_wl u_t018_006/r2_r0_rwl u_t018_006/r2_r1_rwl
+ u_t018_006/r3_w0_wl u_t018_006/r3_w1_wl u_t018_006/r3_r0_rwl u_t018_006/r3_r1_rwl
+ u_t018_006/VDD u_t018_009/VSS VSUBS detronyx_12t_2w2r_rc4_4x4_routed_5layer_direct
Xu_t009_017 u_t009_017/c0_w0_bl u_t009_017/c0_w0_br u_t009_017/c0_w1_bl u_t009_017/c0_w1_br
+ u_t009_017/c0_r0_rbl u_t009_017/c0_r1_rbl u_t009_017/c1_w0_bl u_t009_017/c1_w0_br
+ u_t009_017/c1_w1_bl u_t009_017/c1_w1_br u_t009_017/c1_r0_rbl u_t009_017/c1_r1_rbl
+ u_t009_017/c2_w0_bl u_t009_017/c2_w0_br u_t009_017/c2_w1_bl u_t009_017/c2_w1_br
+ u_t009_017/c2_r0_rbl u_t009_017/c2_r1_rbl u_t009_017/c3_w0_bl u_t009_017/c3_w0_br
+ u_t009_017/c3_w1_bl u_t009_017/c3_w1_br u_t009_017/c3_r0_rbl u_t009_017/c3_r1_rbl
+ u_t009_017/r0_w0_wl u_t009_017/r0_w1_wl u_t009_017/r0_r0_rwl u_t009_017/r0_r1_rwl
+ u_t009_017/r1_w0_wl u_t009_017/r1_w1_wl u_t009_017/r1_r0_rwl u_t009_017/r1_r1_rwl
+ u_t009_017/r2_w0_wl u_t009_017/r2_w1_wl u_t009_017/r2_r0_rwl u_t009_017/r2_r1_rwl
+ u_t009_017/r3_w0_wl u_t009_017/r3_w1_wl u_t009_017/r3_r0_rwl u_t009_017/r3_r1_rwl
+ VSS u_t009_031/VSS VSUBS detronyx_12t_2w2r_rc4_4x4_routed_5layer_direct
Xu_t009_006 u_t009_006/c0_w0_bl u_t009_006/c0_w0_br u_t009_006/c0_w1_bl u_t009_006/c0_w1_br
+ u_t009_006/c0_r0_rbl u_t009_006/c0_r1_rbl u_t009_006/c1_w0_bl u_t009_006/c1_w0_br
+ u_t009_006/c1_w1_bl u_t009_006/c1_w1_br u_t009_006/c1_r0_rbl u_t009_006/c1_r1_rbl
+ u_t009_006/c2_w0_bl u_t009_006/c2_w0_br u_t009_006/c2_w1_bl u_t009_006/c2_w1_br
+ u_t009_006/c2_r0_rbl u_t009_006/c2_r1_rbl u_t009_006/c3_w0_bl u_t009_006/c3_w0_br
+ u_t009_006/c3_w1_bl u_t009_006/c3_w1_br u_t009_006/c3_r0_rbl u_t009_006/c3_r1_rbl
+ u_t009_006/r0_w0_wl u_t009_006/r0_w1_wl u_t009_006/r0_r0_rwl u_t009_006/r0_r1_rwl
+ u_t009_006/r1_w0_wl u_t009_006/r1_w1_wl u_t009_006/r1_r0_rwl u_t009_006/r1_r1_rwl
+ u_t009_006/r2_w0_wl u_t009_006/r2_w1_wl u_t009_006/r2_r0_rwl u_t009_006/r2_r1_rwl
+ u_t009_006/r3_w0_wl u_t009_006/r3_w1_wl u_t009_006/r3_r0_rwl u_t009_006/r3_r1_rwl
+ u_t009_006/VDD u_t009_031/VSS VSUBS detronyx_12t_2w2r_rc4_4x4_routed_5layer_direct
Xu_t009_028 u_t009_028/c0_w0_bl u_t009_028/c0_w0_br u_t009_028/c0_w1_bl u_t009_028/c0_w1_br
+ u_t009_028/c0_r0_rbl u_t009_028/c0_r1_rbl u_t009_028/c1_w0_bl u_t009_028/c1_w0_br
+ u_t009_028/c1_w1_bl u_t009_028/c1_w1_br u_t009_028/c1_r0_rbl u_t009_028/c1_r1_rbl
+ u_t009_028/c2_w0_bl u_t009_028/c2_w0_br u_t009_028/c2_w1_bl u_t009_028/c2_w1_br
+ u_t009_028/c2_r0_rbl u_t009_028/c2_r1_rbl u_t009_028/c3_w0_bl u_t009_028/c3_w0_br
+ u_t009_028/c3_w1_bl u_t009_028/c3_w1_br u_t009_028/c3_r0_rbl u_t009_028/c3_r1_rbl
+ u_t009_028/r0_w0_wl u_t009_028/r0_w1_wl u_t009_028/r0_r0_rwl u_t009_028/r0_r1_rwl
+ u_t009_028/r1_w0_wl u_t009_028/r1_w1_wl u_t009_028/r1_r0_rwl u_t009_028/r1_r1_rwl
+ u_t009_028/r2_w0_wl u_t009_028/r2_w1_wl u_t009_028/r2_r0_rwl u_t009_028/r2_r1_rwl
+ u_t009_028/r3_w0_wl u_t009_028/r3_w1_wl u_t009_028/r3_r0_rwl u_t009_028/r3_r1_rwl
+ u_t009_028/VDD u_t009_031/VSS VSUBS detronyx_12t_2w2r_rc4_4x4_routed_5layer_direct
Xu_t024_009 u_t024_009/c0_w0_bl u_t024_009/c0_w0_br u_t024_009/c0_w1_bl u_t024_009/c0_w1_br
+ u_t024_009/c0_r0_rbl u_t024_009/c0_r1_rbl u_t024_009/c1_w0_bl u_t024_009/c1_w0_br
+ u_t024_009/c1_w1_bl u_t024_009/c1_w1_br u_t024_009/c1_r0_rbl u_t024_009/c1_r1_rbl
+ u_t024_009/c2_w0_bl u_t024_009/c2_w0_br u_t024_009/c2_w1_bl u_t024_009/c2_w1_br
+ u_t024_009/c2_r0_rbl u_t024_009/c2_r1_rbl u_t024_009/c3_w0_bl u_t024_009/c3_w0_br
+ u_t024_009/c3_w1_bl u_t024_009/c3_w1_br u_t024_009/c3_r0_rbl u_t024_009/c3_r1_rbl
+ u_t024_009/r0_w0_wl u_t024_009/r0_w1_wl u_t024_009/r0_r0_rwl u_t024_009/r0_r1_rwl
+ u_t024_009/r1_w0_wl u_t024_009/r1_w1_wl u_t024_009/r1_r0_rwl u_t024_009/r1_r1_rwl
+ u_t024_009/r2_w0_wl u_t024_009/r2_w1_wl u_t024_009/r2_r0_rwl u_t024_009/r2_r1_rwl
+ u_t024_009/r3_w0_wl u_t024_009/r3_w1_wl u_t024_009/r3_r0_rwl u_t024_009/r3_r1_rwl
+ VSS u_t024_009/VSS VSUBS detronyx_12t_2w2r_rc4_4x4_routed_5layer_direct
Xgf180mcu_as_sc_mcu7t3v3__inv_2_142 VSS gf180mcu_as_sc_mcu7t3v3__inv_2_146/VDD VSS
+ VSS gf180mcu_as_sc_mcu7t3v3__inv_2_142/VNW VSUBS gf180mcu_as_sc_mcu7t3v3__inv_2
Xgf180mcu_as_sc_mcu7t3v3__inv_2_153 gf180mcu_as_sc_mcu7t3v3__inv_2_99/VDD gf180mcu_as_sc_mcu7t3v3__inv_2_99/VDD
+ VSS VSS gf180mcu_as_sc_mcu7t3v3__inv_2_155/VNW VSUBS gf180mcu_as_sc_mcu7t3v3__inv_2
Xgf180mcu_as_sc_mcu7t3v3__inv_2_120 gf180mcu_as_sc_mcu7t3v3__inv_2_139/VSS gf180mcu_as_sc_mcu7t3v3__inv_2_126/VDD
+ VSS VSS gf180mcu_as_sc_mcu7t3v3__inv_2_122/VNW VSUBS gf180mcu_as_sc_mcu7t3v3__inv_2
Xgf180mcu_as_sc_mcu7t3v3__inv_2_131 gf180mcu_as_sc_mcu7t3v3__inv_2_152/VSS gf180mcu_as_sc_mcu7t3v3__inv_2_152/VSS
+ VSS VSS gf180mcu_as_sc_mcu7t3v3__inv_2_152/VNW VSUBS gf180mcu_as_sc_mcu7t3v3__inv_2
Xgf180mcu_as_sc_mcu7t3v3__inv_2_175 gf180mcu_as_sc_mcu7t3v3__inv_2_177/VDD VSS VSS
+ VSS gf180mcu_as_sc_mcu7t3v3__inv_2_177/VNW VSUBS gf180mcu_as_sc_mcu7t3v3__inv_2
Xgf180mcu_as_sc_mcu7t3v3__inv_2_164 gf180mcu_as_sc_mcu7t3v3__inv_2_165/VDD VSS gf180mcu_as_sc_mcu7t3v3__inv_2_164/Y
+ VSS gf180mcu_as_sc_mcu7t3v3__inv_2_165/VNW VSUBS gf180mcu_as_sc_mcu7t3v3__inv_2
Xgf180mcu_as_sc_mcu7t3v3__inv_2_186 gf180mcu_as_sc_mcu7t3v3__inv_2_188/VDD gf180mcu_as_sc_mcu7t3v3__inv_2_192/VDD
+ VSS VSS gf180mcu_as_sc_mcu7t3v3__inv_2_188/VNW VSUBS gf180mcu_as_sc_mcu7t3v3__inv_2
Xgf180mcu_as_sc_mcu7t3v3__inv_2_1619 gf180mcu_as_sc_mcu7t3v3__inv_2_1657/VDD VSS gf180mcu_as_sc_mcu7t3v3__inv_2_1619/Y
+ gf180mcu_as_sc_mcu7t3v3__inv_2_1657/Y gf180mcu_as_sc_mcu7t3v3__inv_2_1657/VNW VSUBS
+ gf180mcu_as_sc_mcu7t3v3__inv_2
Xgf180mcu_as_sc_mcu7t3v3__inv_2_1608 VSS VSS VSS gf180mcu_as_sc_mcu7t3v3__inv_2_1685/Y
+ gf180mcu_as_sc_mcu7t3v3__inv_2_1661/VNW VSUBS gf180mcu_as_sc_mcu7t3v3__inv_2
Xgf180mcu_as_sc_mcu7t3v3__inv_2_197 gf180mcu_as_sc_mcu7t3v3__inv_2_205/VDD VSS VSS
+ VSS gf180mcu_as_sc_mcu7t3v3__inv_2_205/VNW VSUBS gf180mcu_as_sc_mcu7t3v3__inv_2
Xu_t015_009 u_t015_009/c0_w0_bl u_t015_009/c0_w0_br u_t015_009/c0_w1_bl u_t015_009/c0_w1_br
+ u_t015_009/c0_r0_rbl u_t015_009/c0_r1_rbl u_t015_009/c1_w0_bl u_t015_009/c1_w0_br
+ u_t015_009/c1_w1_bl u_t015_009/c1_w1_br u_t015_009/c1_r0_rbl u_t015_009/c1_r1_rbl
+ u_t015_009/c2_w0_bl u_t015_009/c2_w0_br u_t015_009/c2_w1_bl u_t015_009/c2_w1_br
+ u_t015_009/c2_r0_rbl u_t015_009/c2_r1_rbl u_t015_009/c3_w0_bl u_t015_009/c3_w0_br
+ u_t015_009/c3_w1_bl u_t015_009/c3_w1_br u_t015_009/c3_r0_rbl u_t015_009/c3_r1_rbl
+ u_t015_009/r0_w0_wl u_t015_009/r0_w1_wl u_t015_009/r0_r0_rwl u_t015_009/r0_r1_rwl
+ u_t015_009/r1_w0_wl u_t015_009/r1_w1_wl u_t015_009/r1_r0_rwl u_t015_009/r1_r1_rwl
+ u_t015_009/r2_w0_wl u_t015_009/r2_w1_wl u_t015_009/r2_r0_rwl u_t015_009/r2_r1_rwl
+ u_t015_009/r3_w0_wl u_t015_009/r3_w1_wl u_t015_009/r3_r0_rwl u_t015_009/r3_r1_rwl
+ VSS u_t015_009/VSS VSUBS detronyx_12t_2w2r_rc4_4x4_routed_5layer_direct
Xu_t023_031 u_t023_031/c0_w0_bl u_t023_031/c0_w0_br u_t023_031/c0_w1_bl u_t023_031/c0_w1_br
+ u_t023_031/c0_r0_rbl u_t023_031/c0_r1_rbl u_t023_031/c1_w0_bl u_t023_031/c1_w0_br
+ u_t023_031/c1_w1_bl u_t023_031/c1_w1_br u_t023_031/c1_r0_rbl u_t023_031/c1_r1_rbl
+ u_t023_031/c2_w0_bl u_t023_031/c2_w0_br u_t023_031/c2_w1_bl u_t023_031/c2_w1_br
+ u_t023_031/c2_r0_rbl u_t023_031/c2_r1_rbl u_t023_031/c3_w0_bl u_t023_031/c3_w0_br
+ u_t023_031/c3_w1_bl u_t023_031/c3_w1_br u_t023_031/c3_r0_rbl u_t023_031/c3_r1_rbl
+ u_t023_031/r0_w0_wl u_t023_031/r0_w1_wl u_t023_031/r0_r0_rwl u_t023_031/r0_r1_rwl
+ u_t023_031/r1_w0_wl u_t023_031/r1_w1_wl u_t023_031/r1_r0_rwl u_t023_031/r1_r1_rwl
+ u_t023_031/r2_w0_wl u_t023_031/r2_w1_wl u_t023_031/r2_r0_rwl u_t023_031/r2_r1_rwl
+ u_t023_031/r3_w0_wl u_t023_031/r3_w1_wl u_t023_031/r3_r0_rwl u_t023_031/r3_r1_rwl
+ VSS u_t023_031/VSS VSUBS detronyx_12t_2w2r_rc4_4x4_routed_5layer_direct
Xu_t023_020 u_t023_020/c0_w0_bl u_t023_020/c0_w0_br u_t023_020/c0_w1_bl u_t023_020/c0_w1_br
+ u_t023_020/c0_r0_rbl u_t023_020/c0_r1_rbl u_t023_020/c1_w0_bl u_t023_020/c1_w0_br
+ u_t023_020/c1_w1_bl u_t023_020/c1_w1_br u_t023_020/c1_r0_rbl u_t023_020/c1_r1_rbl
+ u_t023_020/c2_w0_bl u_t023_020/c2_w0_br u_t023_020/c2_w1_bl u_t023_020/c2_w1_br
+ u_t023_020/c2_r0_rbl u_t023_020/c2_r1_rbl u_t023_020/c3_w0_bl u_t023_020/c3_w0_br
+ u_t023_020/c3_w1_bl u_t023_020/c3_w1_br u_t023_020/c3_r0_rbl u_t023_020/c3_r1_rbl
+ u_t023_020/r0_w0_wl u_t023_020/r0_w1_wl u_t023_020/r0_r0_rwl u_t023_020/r0_r1_rwl
+ u_t023_020/r1_w0_wl u_t023_020/r1_w1_wl u_t023_020/r1_r0_rwl u_t023_020/r1_r1_rwl
+ u_t023_020/r2_w0_wl u_t023_020/r2_w1_wl u_t023_020/r2_r0_rwl u_t023_020/r2_r1_rwl
+ u_t023_020/r3_w0_wl u_t023_020/r3_w1_wl u_t023_020/r3_r0_rwl u_t023_020/r3_r1_rwl
+ u_t023_020/VDD u_t023_020/VSS VSUBS detronyx_12t_2w2r_rc4_4x4_routed_5layer_direct
Xu_t014_031 u_t014_031/c0_w0_bl u_t014_031/c0_w0_br u_t014_031/c0_w1_bl u_t014_031/c0_w1_br
+ u_t014_031/c0_r0_rbl u_t014_031/c0_r1_rbl u_t014_031/c1_w0_bl u_t014_031/c1_w0_br
+ u_t014_031/c1_w1_bl u_t014_031/c1_w1_br u_t014_031/c1_r0_rbl u_t014_031/c1_r1_rbl
+ u_t014_031/c2_w0_bl u_t014_031/c2_w0_br u_t014_031/c2_w1_bl u_t014_031/c2_w1_br
+ u_t014_031/c2_r0_rbl u_t014_031/c2_r1_rbl u_t014_031/c3_w0_bl u_t014_031/c3_w0_br
+ u_t014_031/c3_w1_bl u_t014_031/c3_w1_br u_t014_031/c3_r0_rbl u_t014_031/c3_r1_rbl
+ u_t014_031/r0_w0_wl u_t014_031/r0_w1_wl u_t014_031/r0_r0_rwl u_t014_031/r0_r1_rwl
+ u_t014_031/r1_w0_wl u_t014_031/r1_w1_wl u_t014_031/r1_r0_rwl u_t014_031/r1_r1_rwl
+ u_t014_031/r2_w0_wl u_t014_031/r2_w1_wl u_t014_031/r2_r0_rwl u_t014_031/r2_r1_rwl
+ u_t014_031/r3_w0_wl u_t014_031/r3_w1_wl u_t014_031/r3_r0_rwl u_t014_031/r3_r1_rwl
+ VSS u_t014_031/VSS VSUBS detronyx_12t_2w2r_rc4_4x4_routed_5layer_direct
Xu_t014_020 u_t014_020/c0_w0_bl u_t014_020/c0_w0_br u_t014_020/c0_w1_bl u_t014_020/c0_w1_br
+ u_t014_020/c0_r0_rbl u_t014_020/c0_r1_rbl u_t014_020/c1_w0_bl u_t014_020/c1_w0_br
+ u_t014_020/c1_w1_bl u_t014_020/c1_w1_br u_t014_020/c1_r0_rbl u_t014_020/c1_r1_rbl
+ u_t014_020/c2_w0_bl u_t014_020/c2_w0_br u_t014_020/c2_w1_bl u_t014_020/c2_w1_br
+ u_t014_020/c2_r0_rbl u_t014_020/c2_r1_rbl u_t014_020/c3_w0_bl u_t014_020/c3_w0_br
+ u_t014_020/c3_w1_bl u_t014_020/c3_w1_br u_t014_020/c3_r0_rbl u_t014_020/c3_r1_rbl
+ u_t014_020/r0_w0_wl u_t014_020/r0_w1_wl u_t014_020/r0_r0_rwl u_t014_020/r0_r1_rwl
+ u_t014_020/r1_w0_wl u_t014_020/r1_w1_wl u_t014_020/r1_r0_rwl u_t014_020/r1_r1_rwl
+ u_t014_020/r2_w0_wl u_t014_020/r2_w1_wl u_t014_020/r2_r0_rwl u_t014_020/r2_r1_rwl
+ u_t014_020/r3_w0_wl u_t014_020/r3_w1_wl u_t014_020/r3_r0_rwl u_t014_020/r3_r1_rwl
+ u_t014_020/VDD u_t014_020/VSS VSUBS detronyx_12t_2w2r_rc4_4x4_routed_5layer_direct
Xu_t006_009 u_t006_009/c0_w0_bl u_t006_009/c0_w0_br u_t006_009/c0_w1_bl u_t006_009/c0_w1_br
+ u_t006_009/c0_r0_rbl u_t006_009/c0_r1_rbl u_t006_009/c1_w0_bl u_t006_009/c1_w0_br
+ u_t006_009/c1_w1_bl u_t006_009/c1_w1_br u_t006_009/c1_r0_rbl u_t006_009/c1_r1_rbl
+ u_t006_009/c2_w0_bl u_t006_009/c2_w0_br u_t006_009/c2_w1_bl u_t006_009/c2_w1_br
+ u_t006_009/c2_r0_rbl u_t006_009/c2_r1_rbl u_t006_009/c3_w0_bl u_t006_009/c3_w0_br
+ u_t006_009/c3_w1_bl u_t006_009/c3_w1_br u_t006_009/c3_r0_rbl u_t006_009/c3_r1_rbl
+ u_t006_009/r0_w0_wl u_t006_009/r0_w1_wl u_t006_009/r0_r0_rwl u_t006_009/r0_r1_rwl
+ u_t006_009/r1_w0_wl u_t006_009/r1_w1_wl u_t006_009/r1_r0_rwl u_t006_009/r1_r1_rwl
+ u_t006_009/r2_w0_wl u_t006_009/r2_w1_wl u_t006_009/r2_r0_rwl u_t006_009/r2_r1_rwl
+ u_t006_009/r3_w0_wl u_t006_009/r3_w1_wl u_t006_009/r3_r0_rwl u_t006_009/r3_r1_rwl
+ VSS u_t006_009/VSS VSUBS detronyx_12t_2w2r_rc4_4x4_routed_5layer_direct
Xgf180mcu_as_sc_mcu7t3v3__nand2_2_65 gf180mcu_as_sc_mcu7t3v3__nand3_2_31/VDD gf180mcu_as_sc_mcu7t3v3__nand3_2_31/VSS
+ VSS VSS VSS gf180mcu_as_sc_mcu7t3v3__nand3_2_31/VNW VSUBS gf180mcu_as_sc_mcu7t3v3__nand2_2
Xgf180mcu_as_sc_mcu7t3v3__nand2_2_54 gf180mcu_as_sc_mcu7t3v3__nand3_2_31/VDD gf180mcu_as_sc_mcu7t3v3__nand3_2_31/VSS
+ VSS VSS VSS gf180mcu_as_sc_mcu7t3v3__nand3_2_31/VNW VSUBS gf180mcu_as_sc_mcu7t3v3__nand2_2
Xgf180mcu_as_sc_mcu7t3v3__nand2_2_10 gf180mcu_as_sc_mcu7t3v3__nor2_2_5/VDD gf180mcu_as_sc_mcu7t3v3__nand3_2_8/VSS
+ VSS VSS VSS gf180mcu_as_sc_mcu7t3v3__nor2_2_5/VNW VSUBS gf180mcu_as_sc_mcu7t3v3__nand2_2
Xgf180mcu_as_sc_mcu7t3v3__nand2_2_32 gf180mcu_as_sc_mcu7t3v3__nor2_2_6/VDD gf180mcu_as_sc_mcu7t3v3__nor2_2_6/VSS
+ VSS VSS VSS gf180mcu_as_sc_mcu7t3v3__nor2_2_6/VNW VSUBS gf180mcu_as_sc_mcu7t3v3__nand2_2
Xgf180mcu_as_sc_mcu7t3v3__nand2_2_43 gf180mcu_as_sc_mcu7t3v3__nor2_2_6/VDD gf180mcu_as_sc_mcu7t3v3__nand3_2_3/VSS
+ VSS VSS VSS gf180mcu_as_sc_mcu7t3v3__nor2_2_6/VNW VSUBS gf180mcu_as_sc_mcu7t3v3__nand2_2
Xgf180mcu_as_sc_mcu7t3v3__nand2_2_21 gf180mcu_as_sc_mcu7t3v3__nand3_2_5/VDD gf180mcu_as_sc_mcu7t3v3__nor2_2_4/VSS
+ VSS VSS VSS gf180mcu_as_sc_mcu7t3v3__nand3_2_5/VNW VSUBS gf180mcu_as_sc_mcu7t3v3__nand2_2
Xu_t005_031 u_t005_031/c0_w0_bl u_t005_031/c0_w0_br u_t005_031/c0_w1_bl u_t005_031/c0_w1_br
+ u_t005_031/c0_r0_rbl u_t005_031/c0_r1_rbl u_t005_031/c1_w0_bl u_t005_031/c1_w0_br
+ u_t005_031/c1_w1_bl u_t005_031/c1_w1_br u_t005_031/c1_r0_rbl u_t005_031/c1_r1_rbl
+ u_t005_031/c2_w0_bl u_t005_031/c2_w0_br u_t005_031/c2_w1_bl u_t005_031/c2_w1_br
+ u_t005_031/c2_r0_rbl u_t005_031/c2_r1_rbl u_t005_031/c3_w0_bl u_t005_031/c3_w0_br
+ u_t005_031/c3_w1_bl u_t005_031/c3_w1_br u_t005_031/c3_r0_rbl u_t005_031/c3_r1_rbl
+ u_t005_031/r0_w0_wl u_t005_031/r0_w1_wl u_t005_031/r0_r0_rwl u_t005_031/r0_r1_rwl
+ u_t005_031/r1_w0_wl u_t005_031/r1_w1_wl u_t005_031/r1_r0_rwl u_t005_031/r1_r1_rwl
+ u_t005_031/r2_w0_wl u_t005_031/r2_w1_wl u_t005_031/r2_r0_rwl u_t005_031/r2_r1_rwl
+ u_t005_031/r3_w0_wl u_t005_031/r3_w1_wl u_t005_031/r3_r0_rwl u_t005_031/r3_r1_rwl
+ VSS u_t005_031/VSS VSUBS detronyx_12t_2w2r_rc4_4x4_routed_5layer_direct
Xu_t020_023 u_t020_023/c0_w0_bl u_t020_023/c0_w0_br u_t020_023/c0_w1_bl u_t020_023/c0_w1_br
+ u_t020_023/c0_r0_rbl u_t020_023/c0_r1_rbl u_t020_023/c1_w0_bl u_t020_023/c1_w0_br
+ u_t020_023/c1_w1_bl u_t020_023/c1_w1_br u_t020_023/c1_r0_rbl u_t020_023/c1_r1_rbl
+ u_t020_023/c2_w0_bl u_t020_023/c2_w0_br u_t020_023/c2_w1_bl u_t020_023/c2_w1_br
+ u_t020_023/c2_r0_rbl u_t020_023/c2_r1_rbl u_t020_023/c3_w0_bl u_t020_023/c3_w0_br
+ u_t020_023/c3_w1_bl u_t020_023/c3_w1_br u_t020_023/c3_r0_rbl u_t020_023/c3_r1_rbl
+ u_t020_023/r0_w0_wl u_t020_023/r0_w1_wl u_t020_023/r0_r0_rwl u_t020_023/r0_r1_rwl
+ u_t020_023/r1_w0_wl u_t020_023/r1_w1_wl u_t020_023/r1_r0_rwl u_t020_023/r1_r1_rwl
+ u_t020_023/r2_w0_wl u_t020_023/r2_w1_wl u_t020_023/r2_r0_rwl u_t020_023/r2_r1_rwl
+ u_t020_023/r3_w0_wl u_t020_023/r3_w1_wl u_t020_023/r3_r0_rwl u_t020_023/r3_r1_rwl
+ VSS u_t020_024/VSS VSUBS detronyx_12t_2w2r_rc4_4x4_routed_5layer_direct
Xu_t005_020 u_t005_020/c0_w0_bl u_t005_020/c0_w0_br u_t005_020/c0_w1_bl u_t005_020/c0_w1_br
+ u_t005_020/c0_r0_rbl u_t005_020/c0_r1_rbl u_t005_020/c1_w0_bl u_t005_020/c1_w0_br
+ u_t005_020/c1_w1_bl u_t005_020/c1_w1_br u_t005_020/c1_r0_rbl u_t005_020/c1_r1_rbl
+ u_t005_020/c2_w0_bl u_t005_020/c2_w0_br u_t005_020/c2_w1_bl u_t005_020/c2_w1_br
+ u_t005_020/c2_r0_rbl u_t005_020/c2_r1_rbl u_t005_020/c3_w0_bl u_t005_020/c3_w0_br
+ u_t005_020/c3_w1_bl u_t005_020/c3_w1_br u_t005_020/c3_r0_rbl u_t005_020/c3_r1_rbl
+ u_t005_020/r0_w0_wl u_t005_020/r0_w1_wl u_t005_020/r0_r0_rwl u_t005_020/r0_r1_rwl
+ u_t005_020/r1_w0_wl u_t005_020/r1_w1_wl u_t005_020/r1_r0_rwl u_t005_020/r1_r1_rwl
+ u_t005_020/r2_w0_wl u_t005_020/r2_w1_wl u_t005_020/r2_r0_rwl u_t005_020/r2_r1_rwl
+ u_t005_020/r3_w0_wl u_t005_020/r3_w1_wl u_t005_020/r3_r0_rwl u_t005_020/r3_r1_rwl
+ u_t005_020/VDD u_t005_031/VSS VSUBS detronyx_12t_2w2r_rc4_4x4_routed_5layer_direct
Xu_t020_012 u_t020_012/c0_w0_bl u_t020_012/c0_w0_br u_t020_012/c0_w1_bl u_t020_012/c0_w1_br
+ u_t020_012/c0_r0_rbl u_t020_012/c0_r1_rbl u_t020_012/c1_w0_bl u_t020_012/c1_w0_br
+ u_t020_012/c1_w1_bl u_t020_012/c1_w1_br u_t020_012/c1_r0_rbl u_t020_012/c1_r1_rbl
+ u_t020_012/c2_w0_bl u_t020_012/c2_w0_br u_t020_012/c2_w1_bl u_t020_012/c2_w1_br
+ u_t020_012/c2_r0_rbl u_t020_012/c2_r1_rbl u_t020_012/c3_w0_bl u_t020_012/c3_w0_br
+ u_t020_012/c3_w1_bl u_t020_012/c3_w1_br u_t020_012/c3_r0_rbl u_t020_012/c3_r1_rbl
+ u_t020_012/r0_w0_wl u_t020_012/r0_w1_wl u_t020_012/r0_r0_rwl u_t020_012/r0_r1_rwl
+ u_t020_012/r1_w0_wl u_t020_012/r1_w1_wl u_t020_012/r1_r0_rwl u_t020_012/r1_r1_rwl
+ u_t020_012/r2_w0_wl u_t020_012/r2_w1_wl u_t020_012/r2_r0_rwl u_t020_012/r2_r1_rwl
+ u_t020_012/r3_w0_wl u_t020_012/r3_w1_wl u_t020_012/r3_r0_rwl u_t020_012/r3_r1_rwl
+ u_t020_012/VDD u_t020_012/VSS VSUBS detronyx_12t_2w2r_rc4_4x4_routed_5layer_direct
Xu_t020_001 u_t020_001/c0_w0_bl u_t020_001/c0_w0_br u_t020_001/c0_w1_bl u_t020_001/c0_w1_br
+ u_t020_001/c0_r0_rbl u_t020_001/c0_r1_rbl u_t020_001/c1_w0_bl u_t020_001/c1_w0_br
+ u_t020_001/c1_w1_bl u_t020_001/c1_w1_br u_t020_001/c1_r0_rbl u_t020_001/c1_r1_rbl
+ u_t020_001/c2_w0_bl u_t020_001/c2_w0_br u_t020_001/c2_w1_bl u_t020_001/c2_w1_br
+ u_t020_001/c2_r0_rbl u_t020_001/c2_r1_rbl u_t020_001/c3_w0_bl u_t020_001/c3_w0_br
+ u_t020_001/c3_w1_bl u_t020_001/c3_w1_br u_t020_001/c3_r0_rbl u_t020_001/c3_r1_rbl
+ u_t020_001/r0_w0_wl u_t020_001/r0_w1_wl u_t020_001/r0_r0_rwl u_t020_001/r0_r1_rwl
+ u_t020_001/r1_w0_wl u_t020_001/r1_w1_wl u_t020_001/r1_r0_rwl u_t020_001/r1_r1_rwl
+ u_t020_001/r2_w0_wl u_t020_001/r2_w1_wl u_t020_001/r2_r0_rwl u_t020_001/r2_r1_rwl
+ u_t020_001/r3_w0_wl u_t020_001/r3_w1_wl u_t020_001/r3_r0_rwl u_t020_001/r3_r1_rwl
+ VSS u_t020_002/VSS VSUBS detronyx_12t_2w2r_rc4_4x4_routed_5layer_direct
Xgf180mcu_as_sc_mcu7t3v3__inv_2_1405 VSS gf180mcu_as_sc_mcu7t3v3__inv_2_1694/VDD VSS
+ VSS gf180mcu_as_sc_mcu7t3v3__inv_2_1413/VNW VSUBS gf180mcu_as_sc_mcu7t3v3__inv_2
Xgf180mcu_as_sc_mcu7t3v3__inv_2_1438 gf180mcu_as_sc_mcu7t3v3__inv_2_1440/VDD gf180mcu_as_sc_mcu7t3v3__inv_2_1444/VDD
+ VSS VSS gf180mcu_as_sc_mcu7t3v3__inv_2_1440/VNW VSUBS gf180mcu_as_sc_mcu7t3v3__inv_2
Xgf180mcu_as_sc_mcu7t3v3__inv_2_1427 gf180mcu_as_sc_mcu7t3v3__inv_2_1428/VDD gf180mcu_as_sc_mcu7t3v3__inv_2_1432/VDD
+ gf180mcu_as_sc_mcu7t3v3__inv_2_1427/Y VSS gf180mcu_as_sc_mcu7t3v3__inv_2_1428/VNW
+ VSUBS gf180mcu_as_sc_mcu7t3v3__inv_2
Xgf180mcu_as_sc_mcu7t3v3__inv_2_1416 gf180mcu_as_sc_mcu7t3v3__inv_2_1416/VDD gf180mcu_as_sc_mcu7t3v3__inv_2_1420/VDD
+ gf180mcu_as_sc_mcu7t3v3__inv_2_1416/Y VSS gf180mcu_as_sc_mcu7t3v3__inv_2_1416/VNW
+ VSUBS gf180mcu_as_sc_mcu7t3v3__inv_2
Xgf180mcu_as_sc_mcu7t3v3__inv_2_1449 VSS gf180mcu_as_sc_mcu7t3v3__inv_2_1499/VSS VSS
+ VSS gf180mcu_as_sc_mcu7t3v3__inv_2_1499/VNW VSUBS gf180mcu_as_sc_mcu7t3v3__inv_2
Xu_t011_023 u_t011_023/c0_w0_bl u_t011_023/c0_w0_br u_t011_023/c0_w1_bl u_t011_023/c0_w1_br
+ u_t011_023/c0_r0_rbl u_t011_023/c0_r1_rbl u_t011_023/c1_w0_bl u_t011_023/c1_w0_br
+ u_t011_023/c1_w1_bl u_t011_023/c1_w1_br u_t011_023/c1_r0_rbl u_t011_023/c1_r1_rbl
+ u_t011_023/c2_w0_bl u_t011_023/c2_w0_br u_t011_023/c2_w1_bl u_t011_023/c2_w1_br
+ u_t011_023/c2_r0_rbl u_t011_023/c2_r1_rbl u_t011_023/c3_w0_bl u_t011_023/c3_w0_br
+ u_t011_023/c3_w1_bl u_t011_023/c3_w1_br u_t011_023/c3_r0_rbl u_t011_023/c3_r1_rbl
+ u_t011_023/r0_w0_wl u_t011_023/r0_w1_wl u_t011_023/r0_r0_rwl u_t011_023/r0_r1_rwl
+ u_t011_023/r1_w0_wl u_t011_023/r1_w1_wl u_t011_023/r1_r0_rwl u_t011_023/r1_r1_rwl
+ u_t011_023/r2_w0_wl u_t011_023/r2_w1_wl u_t011_023/r2_r0_rwl u_t011_023/r2_r1_rwl
+ u_t011_023/r3_w0_wl u_t011_023/r3_w1_wl u_t011_023/r3_r0_rwl u_t011_023/r3_r1_rwl
+ VSS u_t011_024/VSS VSUBS detronyx_12t_2w2r_rc4_4x4_routed_5layer_direct
Xu_t011_012 u_t011_012/c0_w0_bl u_t011_012/c0_w0_br u_t011_012/c0_w1_bl u_t011_012/c0_w1_br
+ u_t011_012/c0_r0_rbl u_t011_012/c0_r1_rbl u_t011_012/c1_w0_bl u_t011_012/c1_w0_br
+ u_t011_012/c1_w1_bl u_t011_012/c1_w1_br u_t011_012/c1_r0_rbl u_t011_012/c1_r1_rbl
+ u_t011_012/c2_w0_bl u_t011_012/c2_w0_br u_t011_012/c2_w1_bl u_t011_012/c2_w1_br
+ u_t011_012/c2_r0_rbl u_t011_012/c2_r1_rbl u_t011_012/c3_w0_bl u_t011_012/c3_w0_br
+ u_t011_012/c3_w1_bl u_t011_012/c3_w1_br u_t011_012/c3_r0_rbl u_t011_012/c3_r1_rbl
+ u_t011_012/r0_w0_wl u_t011_012/r0_w1_wl u_t011_012/r0_r0_rwl u_t011_012/r0_r1_rwl
+ u_t011_012/r1_w0_wl u_t011_012/r1_w1_wl u_t011_012/r1_r0_rwl u_t011_012/r1_r1_rwl
+ u_t011_012/r2_w0_wl u_t011_012/r2_w1_wl u_t011_012/r2_r0_rwl u_t011_012/r2_r1_rwl
+ u_t011_012/r3_w0_wl u_t011_012/r3_w1_wl u_t011_012/r3_r0_rwl u_t011_012/r3_r1_rwl
+ u_t011_012/VDD u_t011_012/VSS VSUBS detronyx_12t_2w2r_rc4_4x4_routed_5layer_direct
Xu_t011_001 u_t011_001/c0_w0_bl u_t011_001/c0_w0_br u_t011_001/c0_w1_bl u_t011_001/c0_w1_br
+ u_t011_001/c0_r0_rbl u_t011_001/c0_r1_rbl u_t011_001/c1_w0_bl u_t011_001/c1_w0_br
+ u_t011_001/c1_w1_bl u_t011_001/c1_w1_br u_t011_001/c1_r0_rbl u_t011_001/c1_r1_rbl
+ u_t011_001/c2_w0_bl u_t011_001/c2_w0_br u_t011_001/c2_w1_bl u_t011_001/c2_w1_br
+ u_t011_001/c2_r0_rbl u_t011_001/c2_r1_rbl u_t011_001/c3_w0_bl u_t011_001/c3_w0_br
+ u_t011_001/c3_w1_bl u_t011_001/c3_w1_br u_t011_001/c3_r0_rbl u_t011_001/c3_r1_rbl
+ u_t011_001/r0_w0_wl u_t011_001/r0_w1_wl u_t011_001/r0_r0_rwl u_t011_001/r0_r1_rwl
+ u_t011_001/r1_w0_wl u_t011_001/r1_w1_wl u_t011_001/r1_r0_rwl u_t011_001/r1_r1_rwl
+ u_t011_001/r2_w0_wl u_t011_001/r2_w1_wl u_t011_001/r2_r0_rwl u_t011_001/r2_r1_rwl
+ u_t011_001/r3_w0_wl u_t011_001/r3_w1_wl u_t011_001/r3_r0_rwl u_t011_001/r3_r1_rwl
+ VSS u_t011_002/VSS VSUBS detronyx_12t_2w2r_rc4_4x4_routed_5layer_direct
Xu_t002_023 u_t002_023/c0_w0_bl u_t002_023/c0_w0_br u_t002_023/c0_w1_bl u_t002_023/c0_w1_br
+ u_t002_023/c0_r0_rbl u_t002_023/c0_r1_rbl u_t002_023/c1_w0_bl u_t002_023/c1_w0_br
+ u_t002_023/c1_w1_bl u_t002_023/c1_w1_br u_t002_023/c1_r0_rbl u_t002_023/c1_r1_rbl
+ u_t002_023/c2_w0_bl u_t002_023/c2_w0_br u_t002_023/c2_w1_bl u_t002_023/c2_w1_br
+ u_t002_023/c2_r0_rbl u_t002_023/c2_r1_rbl u_t002_023/c3_w0_bl u_t002_023/c3_w0_br
+ u_t002_023/c3_w1_bl u_t002_023/c3_w1_br u_t002_023/c3_r0_rbl u_t002_023/c3_r1_rbl
+ u_t002_023/r0_w0_wl u_t002_023/r0_w1_wl u_t002_023/r0_r0_rwl u_t002_023/r0_r1_rwl
+ u_t002_023/r1_w0_wl u_t002_023/r1_w1_wl u_t002_023/r1_r0_rwl u_t002_023/r1_r1_rwl
+ u_t002_023/r2_w0_wl u_t002_023/r2_w1_wl u_t002_023/r2_r0_rwl u_t002_023/r2_r1_rwl
+ u_t002_023/r3_w0_wl u_t002_023/r3_w1_wl u_t002_023/r3_r0_rwl u_t002_023/r3_r1_rwl
+ VSS u_t002_024/VSS VSUBS detronyx_12t_2w2r_rc4_4x4_routed_5layer_direct
Xu_t002_012 u_t002_012/c0_w0_bl u_t002_012/c0_w0_br u_t002_012/c0_w1_bl u_t002_012/c0_w1_br
+ u_t002_012/c0_r0_rbl u_t002_012/c0_r1_rbl u_t002_012/c1_w0_bl u_t002_012/c1_w0_br
+ u_t002_012/c1_w1_bl u_t002_012/c1_w1_br u_t002_012/c1_r0_rbl u_t002_012/c1_r1_rbl
+ u_t002_012/c2_w0_bl u_t002_012/c2_w0_br u_t002_012/c2_w1_bl u_t002_012/c2_w1_br
+ u_t002_012/c2_r0_rbl u_t002_012/c2_r1_rbl u_t002_012/c3_w0_bl u_t002_012/c3_w0_br
+ u_t002_012/c3_w1_bl u_t002_012/c3_w1_br u_t002_012/c3_r0_rbl u_t002_012/c3_r1_rbl
+ u_t002_012/r0_w0_wl u_t002_012/r0_w1_wl u_t002_012/r0_r0_rwl u_t002_012/r0_r1_rwl
+ u_t002_012/r1_w0_wl u_t002_012/r1_w1_wl u_t002_012/r1_r0_rwl u_t002_012/r1_r1_rwl
+ u_t002_012/r2_w0_wl u_t002_012/r2_w1_wl u_t002_012/r2_r0_rwl u_t002_012/r2_r1_rwl
+ u_t002_012/r3_w0_wl u_t002_012/r3_w1_wl u_t002_012/r3_r0_rwl u_t002_012/r3_r1_rwl
+ u_t002_012/VDD u_t002_012/VSS VSUBS detronyx_12t_2w2r_rc4_4x4_routed_5layer_direct
Xu_t002_001 u_t002_001/c0_w0_bl u_t002_001/c0_w0_br u_t002_001/c0_w1_bl u_t002_001/c0_w1_br
+ u_t002_001/c0_r0_rbl u_t002_001/c0_r1_rbl u_t002_001/c1_w0_bl u_t002_001/c1_w0_br
+ u_t002_001/c1_w1_bl u_t002_001/c1_w1_br u_t002_001/c1_r0_rbl u_t002_001/c1_r1_rbl
+ u_t002_001/c2_w0_bl u_t002_001/c2_w0_br u_t002_001/c2_w1_bl u_t002_001/c2_w1_br
+ u_t002_001/c2_r0_rbl u_t002_001/c2_r1_rbl u_t002_001/c3_w0_bl u_t002_001/c3_w0_br
+ u_t002_001/c3_w1_bl u_t002_001/c3_w1_br u_t002_001/c3_r0_rbl u_t002_001/c3_r1_rbl
+ u_t002_001/r0_w0_wl u_t002_001/r0_w1_wl u_t002_001/r0_r0_rwl u_t002_001/r0_r1_rwl
+ u_t002_001/r1_w0_wl u_t002_001/r1_w1_wl u_t002_001/r1_r0_rwl u_t002_001/r1_r1_rwl
+ u_t002_001/r2_w0_wl u_t002_001/r2_w1_wl u_t002_001/r2_r0_rwl u_t002_001/r2_r1_rwl
+ u_t002_001/r3_w0_wl u_t002_001/r3_w1_wl u_t002_001/r3_r0_rwl u_t002_001/r3_r1_rwl
+ VSS u_t002_002/VSS VSUBS detronyx_12t_2w2r_rc4_4x4_routed_5layer_direct
Xgf180mcu_as_sc_mcu7t3v3__inv_2_1202 gf180mcu_as_sc_mcu7t3v3__nor2_2_8/VDD gf180mcu_as_sc_mcu7t3v3__nand3_2_32/VSS
+ gf180mcu_as_sc_mcu7t3v3__inv_2_1202/Y VSS gf180mcu_as_sc_mcu7t3v3__nor2_2_8/VNW
+ VSUBS gf180mcu_as_sc_mcu7t3v3__inv_2
Xgf180mcu_as_sc_mcu7t3v3__inv_2_1213 gf180mcu_as_sc_mcu7t3v3__nand3_2_31/VDD gf180mcu_as_sc_mcu7t3v3__nand3_2_31/VSS
+ VSS VSS gf180mcu_as_sc_mcu7t3v3__nand3_2_31/VNW VSUBS gf180mcu_as_sc_mcu7t3v3__inv_2
Xgf180mcu_as_sc_mcu7t3v3__inv_2_1224 gf180mcu_as_sc_mcu7t3v3__nand3_2_31/VDD gf180mcu_as_sc_mcu7t3v3__nand3_2_31/VSS
+ VSS VSS gf180mcu_as_sc_mcu7t3v3__nand3_2_31/VNW VSUBS gf180mcu_as_sc_mcu7t3v3__inv_2
Xgf180mcu_as_sc_mcu7t3v3__inv_2_1235 VSS VSS VSS VSS gf180mcu_as_sc_mcu7t3v3__inv_2_1235/VNW
+ VSUBS gf180mcu_as_sc_mcu7t3v3__inv_2
Xgf180mcu_as_sc_mcu7t3v3__inv_2_1268 gf180mcu_as_sc_mcu7t3v3__nand3_2_31/VDD gf180mcu_as_sc_mcu7t3v3__nor2_2_8/VSS
+ gf180mcu_as_sc_mcu7t3v3__inv_2_1268/Y VSS gf180mcu_as_sc_mcu7t3v3__nand3_2_31/VNW
+ VSUBS gf180mcu_as_sc_mcu7t3v3__inv_2
Xgf180mcu_as_sc_mcu7t3v3__inv_2_1257 gf180mcu_as_sc_mcu7t3v3__nand3_2_31/VDD gf180mcu_as_sc_mcu7t3v3__nand3_2_31/VSS
+ VSS VSS gf180mcu_as_sc_mcu7t3v3__nand3_2_31/VNW VSUBS gf180mcu_as_sc_mcu7t3v3__inv_2
Xgf180mcu_as_sc_mcu7t3v3__inv_2_1279 VSS VSS VSS VSS gf180mcu_as_sc_mcu7t3v3__inv_2_1281/VNW
+ VSUBS gf180mcu_as_sc_mcu7t3v3__inv_2
Xgf180mcu_as_sc_mcu7t3v3__inv_2_1246 VSS VSS VSS VSS gf180mcu_as_sc_mcu7t3v3__inv_2_1247/VNW
+ VSUBS gf180mcu_as_sc_mcu7t3v3__inv_2
Xgf180mcu_as_sc_mcu7t3v3__inv_2_719 gf180mcu_as_sc_mcu7t3v3__inv_2_719/VDD gf180mcu_as_sc_mcu7t3v3__inv_2_723/VDD
+ gf180mcu_as_sc_mcu7t3v3__inv_2_719/Y VSS gf180mcu_as_sc_mcu7t3v3__inv_2_719/VNW
+ VSUBS gf180mcu_as_sc_mcu7t3v3__inv_2
Xgf180mcu_as_sc_mcu7t3v3__inv_2_708 VSS gf180mcu_as_sc_mcu7t3v3__inv_2_724/VSS gf180mcu_as_sc_mcu7t3v3__inv_2_708/Y
+ gf180mcu_as_sc_mcu7t3v3__inv_2_732/Y gf180mcu_as_sc_mcu7t3v3__inv_2_724/VNW VSUBS
+ gf180mcu_as_sc_mcu7t3v3__inv_2
Xgf180mcu_as_sc_mcu7t3v3__inv_2_1076 VSS gf180mcu_as_sc_mcu7t3v3__inv_2_1080/VDD gf180mcu_as_sc_mcu7t3v3__inv_2_1076/Y
+ VSS gf180mcu_as_sc_mcu7t3v3__inv_2_1076/VNW VSUBS gf180mcu_as_sc_mcu7t3v3__inv_2
Xgf180mcu_as_sc_mcu7t3v3__inv_2_1065 VSS VSS VSS gf180mcu_as_sc_mcu7t3v3__inv_2_1294/Y
+ gf180mcu_as_sc_mcu7t3v3__inv_2_1073/VNW VSUBS gf180mcu_as_sc_mcu7t3v3__inv_2
Xgf180mcu_as_sc_mcu7t3v3__inv_2_1010 gf180mcu_as_sc_mcu7t3v3__inv_2_1011/VDD gf180mcu_as_sc_mcu7t3v3__inv_2_1016/VDD
+ gf180mcu_as_sc_mcu7t3v3__inv_2_1010/Y gf180mcu_as_sc_mcu7t3v3__inv_2_1011/Y gf180mcu_as_sc_mcu7t3v3__inv_2_1011/VNW
+ VSUBS gf180mcu_as_sc_mcu7t3v3__inv_2
Xgf180mcu_as_sc_mcu7t3v3__inv_2_1043 VSS VSS VSS gf180mcu_as_sc_mcu7t3v3__inv_2_1043/A
+ gf180mcu_as_sc_mcu7t3v3__inv_2_1051/VNW VSUBS gf180mcu_as_sc_mcu7t3v3__inv_2
Xgf180mcu_as_sc_mcu7t3v3__inv_2_1021 VSS VSS gf180mcu_as_sc_mcu7t3v3__inv_2_992/A
+ gf180mcu_as_sc_mcu7t3v3__inv_2_1022/Y gf180mcu_as_sc_mcu7t3v3__inv_2_1022/VNW VSUBS
+ gf180mcu_as_sc_mcu7t3v3__inv_2
Xgf180mcu_as_sc_mcu7t3v3__inv_2_62 gf180mcu_as_sc_mcu7t3v3__inv_2_62/VDD gf180mcu_as_sc_mcu7t3v3__inv_2_69/VSS
+ gf180mcu_as_sc_mcu7t3v3__inv_2_77/Y VSS gf180mcu_as_sc_mcu7t3v3__inv_2_62/VNW VSUBS
+ gf180mcu_as_sc_mcu7t3v3__inv_2
Xgf180mcu_as_sc_mcu7t3v3__inv_2_84 gf180mcu_as_sc_mcu7t3v3__inv_2_96/VDD gf180mcu_as_sc_mcu7t3v3__inv_2_96/VDD
+ VSS VSS gf180mcu_as_sc_mcu7t3v3__inv_2_84/VNW VSUBS gf180mcu_as_sc_mcu7t3v3__inv_2
Xgf180mcu_as_sc_mcu7t3v3__inv_2_51 gf180mcu_as_sc_mcu7t3v3__inv_2_6/VSS gf180mcu_as_sc_mcu7t3v3__inv_2_8/VDD
+ gf180mcu_as_sc_mcu7t3v3__inv_2_8/A VSS gf180mcu_as_sc_mcu7t3v3__inv_2_4/VNW VSUBS
+ gf180mcu_as_sc_mcu7t3v3__inv_2
Xgf180mcu_as_sc_mcu7t3v3__inv_2_95 gf180mcu_as_sc_mcu7t3v3__inv_2_95/VDD VSS VSS VSS
+ gf180mcu_as_sc_mcu7t3v3__inv_2_95/VNW VSUBS gf180mcu_as_sc_mcu7t3v3__inv_2
Xgf180mcu_as_sc_mcu7t3v3__inv_2_73 gf180mcu_as_sc_mcu7t3v3__inv_2_73/VDD gf180mcu_as_sc_mcu7t3v3__inv_2_74/VDD
+ gf180mcu_as_sc_mcu7t3v3__inv_2_77/Y VSS gf180mcu_as_sc_mcu7t3v3__inv_2_73/VNW VSUBS
+ gf180mcu_as_sc_mcu7t3v3__inv_2
Xgf180mcu_as_sc_mcu7t3v3__inv_2_40 gf180mcu_as_sc_mcu7t3v3__inv_2_70/VDD gf180mcu_as_sc_mcu7t3v3__inv_2_70/VDD
+ VSS gf180mcu_as_sc_mcu7t3v3__inv_2_71/Y gf180mcu_as_sc_mcu7t3v3__inv_2_64/VNW VSUBS
+ gf180mcu_as_sc_mcu7t3v3__inv_2
Xgf180mcu_as_sc_mcu7t3v3__inv_2_1054 gf180mcu_as_sc_mcu7t3v3__inv_2_1056/VDD gf180mcu_as_sc_mcu7t3v3__inv_2_994/VDD
+ VSS gf180mcu_as_sc_mcu7t3v3__inv_2_992/A gf180mcu_as_sc_mcu7t3v3__inv_2_1056/VNW
+ VSUBS gf180mcu_as_sc_mcu7t3v3__inv_2
Xgf180mcu_as_sc_mcu7t3v3__inv_2_1032 gf180mcu_as_sc_mcu7t3v3__inv_2_1034/VDD VSS VSS
+ gf180mcu_as_sc_mcu7t3v3__inv_2_992/A gf180mcu_as_sc_mcu7t3v3__inv_2_1034/VNW VSUBS
+ gf180mcu_as_sc_mcu7t3v3__inv_2
Xgf180mcu_as_sc_mcu7t3v3__inv_2_1087 VSS VSS gf180mcu_as_sc_mcu7t3v3__inv_2_1094/A
+ gf180mcu_as_sc_mcu7t3v3__inv_2_1088/Y gf180mcu_as_sc_mcu7t3v3__inv_2_1088/VNW VSUBS
+ gf180mcu_as_sc_mcu7t3v3__inv_2
Xgf180mcu_as_sc_mcu7t3v3__inv_2_1098 VSS VSS VSS gf180mcu_as_sc_mcu7t3v3__inv_2_1106/A
+ gf180mcu_as_sc_mcu7t3v3__inv_2_1100/VNW VSUBS gf180mcu_as_sc_mcu7t3v3__inv_2
Xgf180mcu_as_sc_mcu7t3v3__inv_2_516 VSS VSS gf180mcu_as_sc_mcu7t3v3__inv_2_516/Y VSS
+ gf180mcu_as_sc_mcu7t3v3__inv_2_518/VNW VSUBS gf180mcu_as_sc_mcu7t3v3__inv_2
Xgf180mcu_as_sc_mcu7t3v3__inv_2_527 VSS VSS VSS VSS gf180mcu_as_sc_mcu7t3v3__inv_2_531/VNW
+ VSUBS gf180mcu_as_sc_mcu7t3v3__inv_2
Xgf180mcu_as_sc_mcu7t3v3__inv_2_505 VSS VSS VSS VSS gf180mcu_as_sc_mcu7t3v3__inv_2_506/VNW
+ VSUBS gf180mcu_as_sc_mcu7t3v3__inv_2
Xgf180mcu_as_sc_mcu7t3v3__inv_2_549 gf180mcu_as_sc_mcu7t3v3__nand3_2_5/VDD gf180mcu_as_sc_mcu7t3v3__nor2_2_6/VSS
+ VSS VSS gf180mcu_as_sc_mcu7t3v3__nand3_2_5/VNW VSUBS gf180mcu_as_sc_mcu7t3v3__inv_2
Xgf180mcu_as_sc_mcu7t3v3__inv_2_538 VSS VSS VSS VSS gf180mcu_as_sc_mcu7t3v3__inv_2_538/VNW
+ VSUBS gf180mcu_as_sc_mcu7t3v3__inv_2
Xgf180mcu_as_sc_mcu7t3v3__nand4_2_360 VSS VSS VSS VSS VSS VSS VSS gf180mcu_as_sc_mcu7t3v3__inv_2_1241/VNW
+ VSUBS gf180mcu_as_sc_mcu7t3v3__nand4_2
Xgf180mcu_as_sc_mcu7t3v3__nand4_2_371 VSS VSS VSS VSS VSS VSS VSS gf180mcu_as_sc_mcu7t3v3__inv_2_1197/VNW
+ VSUBS gf180mcu_as_sc_mcu7t3v3__nand4_2
Xgf180mcu_as_sc_mcu7t3v3__nand4_2_382 VSS gf180mcu_as_sc_mcu7t3v3__inv_2_1691/VDD
+ VSS VSS VSS VSS VSS gf180mcu_as_sc_mcu7t3v3__inv_2_1365/VNW VSUBS gf180mcu_as_sc_mcu7t3v3__nand4_2
Xgf180mcu_as_sc_mcu7t3v3__nand4_2_393 gf180mcu_as_sc_mcu7t3v3__inv_2_1378/VDD gf180mcu_as_sc_mcu7t3v3__inv_2_1379/VDD
+ VSS VSS VSS VSS VSS gf180mcu_as_sc_mcu7t3v3__inv_2_1378/VNW VSUBS gf180mcu_as_sc_mcu7t3v3__nand4_2
Xgf180mcu_as_sc_mcu7t3v3__inv_2_368 gf180mcu_as_sc_mcu7t3v3__inv_2_368/VDD gf180mcu_as_sc_mcu7t3v3__inv_2_65/VDD
+ gf180mcu_as_sc_mcu7t3v3__inv_2_66/Y VSS gf180mcu_as_sc_mcu7t3v3__inv_2_368/VNW VSUBS
+ gf180mcu_as_sc_mcu7t3v3__inv_2
Xgf180mcu_as_sc_mcu7t3v3__inv_2_357 gf180mcu_as_sc_mcu7t3v3__inv_2_357/VDD gf180mcu_as_sc_mcu7t3v3__inv_2_358/VDD
+ gf180mcu_as_sc_mcu7t3v3__inv_2_358/Y VSS gf180mcu_as_sc_mcu7t3v3__inv_2_357/VNW
+ VSUBS gf180mcu_as_sc_mcu7t3v3__inv_2
Xgf180mcu_as_sc_mcu7t3v3__inv_2_346 VSS gf180mcu_as_sc_mcu7t3v3__inv_2_354/VDD VSS
+ gf180mcu_as_sc_mcu7t3v3__inv_2_358/Y gf180mcu_as_sc_mcu7t3v3__inv_2_348/VNW VSUBS
+ gf180mcu_as_sc_mcu7t3v3__inv_2
Xgf180mcu_as_sc_mcu7t3v3__inv_2_324 VSS gf180mcu_as_sc_mcu7t3v3__inv_2_344/VDD gf180mcu_as_sc_mcu7t3v3__inv_2_324/Y
+ gf180mcu_as_sc_mcu7t3v3__inv_2_344/Y gf180mcu_as_sc_mcu7t3v3__inv_2_343/VNW VSUBS
+ gf180mcu_as_sc_mcu7t3v3__inv_2
Xgf180mcu_as_sc_mcu7t3v3__inv_2_335 gf180mcu_as_sc_mcu7t3v3__inv_2_335/VDD VSS gf180mcu_as_sc_mcu7t3v3__inv_2_338/Y
+ VSS gf180mcu_as_sc_mcu7t3v3__inv_2_335/VNW VSUBS gf180mcu_as_sc_mcu7t3v3__inv_2
Xgf180mcu_as_sc_mcu7t3v3__inv_2_313 gf180mcu_as_sc_mcu7t3v3__inv_2_335/VDD VSS VSS
+ gf180mcu_as_sc_mcu7t3v3__inv_2_338/Y gf180mcu_as_sc_mcu7t3v3__inv_2_335/VNW VSUBS
+ gf180mcu_as_sc_mcu7t3v3__inv_2
Xgf180mcu_as_sc_mcu7t3v3__inv_2_302 gf180mcu_as_sc_mcu7t3v3__inv_2_331/VDD gf180mcu_as_sc_mcu7t3v3__inv_2_332/VDD
+ gf180mcu_as_sc_mcu7t3v3__inv_2_302/Y gf180mcu_as_sc_mcu7t3v3__inv_2_338/Y gf180mcu_as_sc_mcu7t3v3__inv_2_331/VNW
+ VSUBS gf180mcu_as_sc_mcu7t3v3__inv_2
Xgf180mcu_as_sc_mcu7t3v3__inv_2_379 gf180mcu_as_sc_mcu7t3v3__nor2_2_5/VDD gf180mcu_as_sc_mcu7t3v3__nor2_2_5/VSS
+ VSS VSS gf180mcu_as_sc_mcu7t3v3__nor2_2_5/VNW VSUBS gf180mcu_as_sc_mcu7t3v3__inv_2
Xu_t027_029 u_t027_029/c0_w0_bl u_t027_029/c0_w0_br u_t027_029/c0_w1_bl u_t027_029/c0_w1_br
+ u_t027_029/c0_r0_rbl u_t027_029/c0_r1_rbl u_t027_029/c1_w0_bl u_t027_029/c1_w0_br
+ u_t027_029/c1_w1_bl u_t027_029/c1_w1_br u_t027_029/c1_r0_rbl u_t027_029/c1_r1_rbl
+ u_t027_029/c2_w0_bl u_t027_029/c2_w0_br u_t027_029/c2_w1_bl u_t027_029/c2_w1_br
+ u_t027_029/c2_r0_rbl u_t027_029/c2_r1_rbl u_t027_029/c3_w0_bl u_t027_029/c3_w0_br
+ u_t027_029/c3_w1_bl u_t027_029/c3_w1_br u_t027_029/c3_r0_rbl u_t027_029/c3_r1_rbl
+ u_t027_029/r0_w0_wl u_t027_029/r0_w1_wl u_t027_029/r0_r0_rwl u_t027_029/r0_r1_rwl
+ u_t027_029/r1_w0_wl u_t027_029/r1_w1_wl u_t027_029/r1_r0_rwl u_t027_029/r1_r1_rwl
+ u_t027_029/r2_w0_wl u_t027_029/r2_w1_wl u_t027_029/r2_r0_rwl u_t027_029/r2_r1_rwl
+ u_t027_029/r3_w0_wl u_t027_029/r3_w1_wl u_t027_029/r3_r0_rwl u_t027_029/r3_r1_rwl
+ u_t027_029/VDD u_t027_031/VSS VSUBS detronyx_12t_2w2r_rc4_4x4_routed_5layer_direct
Xu_t027_018 u_t027_018/c0_w0_bl u_t027_018/c0_w0_br u_t027_018/c0_w1_bl u_t027_018/c0_w1_br
+ u_t027_018/c0_r0_rbl u_t027_018/c0_r1_rbl u_t027_018/c1_w0_bl u_t027_018/c1_w0_br
+ u_t027_018/c1_w1_bl u_t027_018/c1_w1_br u_t027_018/c1_r0_rbl u_t027_018/c1_r1_rbl
+ u_t027_018/c2_w0_bl u_t027_018/c2_w0_br u_t027_018/c2_w1_bl u_t027_018/c2_w1_br
+ u_t027_018/c2_r0_rbl u_t027_018/c2_r1_rbl u_t027_018/c3_w0_bl u_t027_018/c3_w0_br
+ u_t027_018/c3_w1_bl u_t027_018/c3_w1_br u_t027_018/c3_r0_rbl u_t027_018/c3_r1_rbl
+ u_t027_018/r0_w0_wl u_t027_018/r0_w1_wl u_t027_018/r0_r0_rwl u_t027_018/r0_r1_rwl
+ u_t027_018/r1_w0_wl u_t027_018/r1_w1_wl u_t027_018/r1_r0_rwl u_t027_018/r1_r1_rwl
+ u_t027_018/r2_w0_wl u_t027_018/r2_w1_wl u_t027_018/r2_r0_rwl u_t027_018/r2_r1_rwl
+ u_t027_018/r3_w0_wl u_t027_018/r3_w1_wl u_t027_018/r3_r0_rwl u_t027_018/r3_r1_rwl
+ u_t027_018/VDD u_t027_018/VSS VSUBS detronyx_12t_2w2r_rc4_4x4_routed_5layer_direct
Xu_t027_007 u_t027_007/c0_w0_bl u_t027_007/c0_w0_br u_t027_007/c0_w1_bl u_t027_007/c0_w1_br
+ u_t027_007/c0_r0_rbl u_t027_007/c0_r1_rbl u_t027_007/c1_w0_bl u_t027_007/c1_w0_br
+ u_t027_007/c1_w1_bl u_t027_007/c1_w1_br u_t027_007/c1_r0_rbl u_t027_007/c1_r1_rbl
+ u_t027_007/c2_w0_bl u_t027_007/c2_w0_br u_t027_007/c2_w1_bl u_t027_007/c2_w1_br
+ u_t027_007/c2_r0_rbl u_t027_007/c2_r1_rbl u_t027_007/c3_w0_bl u_t027_007/c3_w0_br
+ u_t027_007/c3_w1_bl u_t027_007/c3_w1_br u_t027_007/c3_r0_rbl u_t027_007/c3_r1_rbl
+ u_t027_007/r0_w0_wl u_t027_007/r0_w1_wl u_t027_007/r0_r0_rwl u_t027_007/r0_r1_rwl
+ u_t027_007/r1_w0_wl u_t027_007/r1_w1_wl u_t027_007/r1_r0_rwl u_t027_007/r1_r1_rwl
+ u_t027_007/r2_w0_wl u_t027_007/r2_w1_wl u_t027_007/r2_r0_rwl u_t027_007/r2_r1_rwl
+ u_t027_007/r3_w0_wl u_t027_007/r3_w1_wl u_t027_007/r3_r0_rwl u_t027_007/r3_r1_rwl
+ VSS u_t027_009/VSS VSUBS detronyx_12t_2w2r_rc4_4x4_routed_5layer_direct
Xgf180mcu_as_sc_mcu7t3v3__inv_2_891 VSS VSS VSS VSS gf180mcu_as_sc_mcu7t3v3__inv_2_892/VNW
+ VSUBS gf180mcu_as_sc_mcu7t3v3__inv_2
Xgf180mcu_as_sc_mcu7t3v3__inv_2_880 VSS VSS gf180mcu_as_sc_mcu7t3v3__inv_2_880/Y VSS
+ gf180mcu_as_sc_mcu7t3v3__inv_2_880/VNW VSUBS gf180mcu_as_sc_mcu7t3v3__inv_2
Xu_t018_029 u_t018_029/c0_w0_bl u_t018_029/c0_w0_br u_t018_029/c0_w1_bl u_t018_029/c0_w1_br
+ u_t018_029/c0_r0_rbl u_t018_029/c0_r1_rbl u_t018_029/c1_w0_bl u_t018_029/c1_w0_br
+ u_t018_029/c1_w1_bl u_t018_029/c1_w1_br u_t018_029/c1_r0_rbl u_t018_029/c1_r1_rbl
+ u_t018_029/c2_w0_bl u_t018_029/c2_w0_br u_t018_029/c2_w1_bl u_t018_029/c2_w1_br
+ u_t018_029/c2_r0_rbl u_t018_029/c2_r1_rbl u_t018_029/c3_w0_bl u_t018_029/c3_w0_br
+ u_t018_029/c3_w1_bl u_t018_029/c3_w1_br u_t018_029/c3_r0_rbl u_t018_029/c3_r1_rbl
+ u_t018_029/r0_w0_wl u_t018_029/r0_w1_wl u_t018_029/r0_r0_rwl u_t018_029/r0_r1_rwl
+ u_t018_029/r1_w0_wl u_t018_029/r1_w1_wl u_t018_029/r1_r0_rwl u_t018_029/r1_r1_rwl
+ u_t018_029/r2_w0_wl u_t018_029/r2_w1_wl u_t018_029/r2_r0_rwl u_t018_029/r2_r1_rwl
+ u_t018_029/r3_w0_wl u_t018_029/r3_w1_wl u_t018_029/r3_r0_rwl u_t018_029/r3_r1_rwl
+ u_t018_029/VDD u_t018_031/VSS VSUBS detronyx_12t_2w2r_rc4_4x4_routed_5layer_direct
Xu_t018_018 u_t018_018/c0_w0_bl u_t018_018/c0_w0_br u_t018_018/c0_w1_bl u_t018_018/c0_w1_br
+ u_t018_018/c0_r0_rbl u_t018_018/c0_r1_rbl u_t018_018/c1_w0_bl u_t018_018/c1_w0_br
+ u_t018_018/c1_w1_bl u_t018_018/c1_w1_br u_t018_018/c1_r0_rbl u_t018_018/c1_r1_rbl
+ u_t018_018/c2_w0_bl u_t018_018/c2_w0_br u_t018_018/c2_w1_bl u_t018_018/c2_w1_br
+ u_t018_018/c2_r0_rbl u_t018_018/c2_r1_rbl u_t018_018/c3_w0_bl u_t018_018/c3_w0_br
+ u_t018_018/c3_w1_bl u_t018_018/c3_w1_br u_t018_018/c3_r0_rbl u_t018_018/c3_r1_rbl
+ u_t018_018/r0_w0_wl u_t018_018/r0_w1_wl u_t018_018/r0_r0_rwl u_t018_018/r0_r1_rwl
+ u_t018_018/r1_w0_wl u_t018_018/r1_w1_wl u_t018_018/r1_r0_rwl u_t018_018/r1_r1_rwl
+ u_t018_018/r2_w0_wl u_t018_018/r2_w1_wl u_t018_018/r2_r0_rwl u_t018_018/r2_r1_rwl
+ u_t018_018/r3_w0_wl u_t018_018/r3_w1_wl u_t018_018/r3_r0_rwl u_t018_018/r3_r1_rwl
+ u_t018_018/VDD u_t018_018/VSS VSUBS detronyx_12t_2w2r_rc4_4x4_routed_5layer_direct
Xu_t018_007 u_t018_007/c0_w0_bl u_t018_007/c0_w0_br u_t018_007/c0_w1_bl u_t018_007/c0_w1_br
+ u_t018_007/c0_r0_rbl u_t018_007/c0_r1_rbl u_t018_007/c1_w0_bl u_t018_007/c1_w0_br
+ u_t018_007/c1_w1_bl u_t018_007/c1_w1_br u_t018_007/c1_r0_rbl u_t018_007/c1_r1_rbl
+ u_t018_007/c2_w0_bl u_t018_007/c2_w0_br u_t018_007/c2_w1_bl u_t018_007/c2_w1_br
+ u_t018_007/c2_r0_rbl u_t018_007/c2_r1_rbl u_t018_007/c3_w0_bl u_t018_007/c3_w0_br
+ u_t018_007/c3_w1_bl u_t018_007/c3_w1_br u_t018_007/c3_r0_rbl u_t018_007/c3_r1_rbl
+ u_t018_007/r0_w0_wl u_t018_007/r0_w1_wl u_t018_007/r0_r0_rwl u_t018_007/r0_r1_rwl
+ u_t018_007/r1_w0_wl u_t018_007/r1_w1_wl u_t018_007/r1_r0_rwl u_t018_007/r1_r1_rwl
+ u_t018_007/r2_w0_wl u_t018_007/r2_w1_wl u_t018_007/r2_r0_rwl u_t018_007/r2_r1_rwl
+ u_t018_007/r3_w0_wl u_t018_007/r3_w1_wl u_t018_007/r3_r0_rwl u_t018_007/r3_r1_rwl
+ VSS u_t018_009/VSS VSUBS detronyx_12t_2w2r_rc4_4x4_routed_5layer_direct
Xgf180mcu_as_sc_mcu7t3v3__nand4_2_190 VSS VSS VSS VSS VSS VSS VSS gf180mcu_as_sc_mcu7t3v3__inv_2_735/VNW
+ VSUBS gf180mcu_as_sc_mcu7t3v3__nand4_2
Xu_t009_029 u_t009_029/c0_w0_bl u_t009_029/c0_w0_br u_t009_029/c0_w1_bl u_t009_029/c0_w1_br
+ u_t009_029/c0_r0_rbl u_t009_029/c0_r1_rbl u_t009_029/c1_w0_bl u_t009_029/c1_w0_br
+ u_t009_029/c1_w1_bl u_t009_029/c1_w1_br u_t009_029/c1_r0_rbl u_t009_029/c1_r1_rbl
+ u_t009_029/c2_w0_bl u_t009_029/c2_w0_br u_t009_029/c2_w1_bl u_t009_029/c2_w1_br
+ u_t009_029/c2_r0_rbl u_t009_029/c2_r1_rbl u_t009_029/c3_w0_bl u_t009_029/c3_w0_br
+ u_t009_029/c3_w1_bl u_t009_029/c3_w1_br u_t009_029/c3_r0_rbl u_t009_029/c3_r1_rbl
+ u_t009_029/r0_w0_wl u_t009_029/r0_w1_wl u_t009_029/r0_r0_rwl u_t009_029/r0_r1_rwl
+ u_t009_029/r1_w0_wl u_t009_029/r1_w1_wl u_t009_029/r1_r0_rwl u_t009_029/r1_r1_rwl
+ u_t009_029/r2_w0_wl u_t009_029/r2_w1_wl u_t009_029/r2_r0_rwl u_t009_029/r2_r1_rwl
+ u_t009_029/r3_w0_wl u_t009_029/r3_w1_wl u_t009_029/r3_r0_rwl u_t009_029/r3_r1_rwl
+ u_t009_029/VDD u_t009_031/VSS VSUBS detronyx_12t_2w2r_rc4_4x4_routed_5layer_direct
Xu_t009_018 u_t009_018/c0_w0_bl u_t009_018/c0_w0_br u_t009_018/c0_w1_bl u_t009_018/c0_w1_br
+ u_t009_018/c0_r0_rbl u_t009_018/c0_r1_rbl u_t009_018/c1_w0_bl u_t009_018/c1_w0_br
+ u_t009_018/c1_w1_bl u_t009_018/c1_w1_br u_t009_018/c1_r0_rbl u_t009_018/c1_r1_rbl
+ u_t009_018/c2_w0_bl u_t009_018/c2_w0_br u_t009_018/c2_w1_bl u_t009_018/c2_w1_br
+ u_t009_018/c2_r0_rbl u_t009_018/c2_r1_rbl u_t009_018/c3_w0_bl u_t009_018/c3_w0_br
+ u_t009_018/c3_w1_bl u_t009_018/c3_w1_br u_t009_018/c3_r0_rbl u_t009_018/c3_r1_rbl
+ u_t009_018/r0_w0_wl u_t009_018/r0_w1_wl u_t009_018/r0_r0_rwl u_t009_018/r0_r1_rwl
+ u_t009_018/r1_w0_wl u_t009_018/r1_w1_wl u_t009_018/r1_r0_rwl u_t009_018/r1_r1_rwl
+ u_t009_018/r2_w0_wl u_t009_018/r2_w1_wl u_t009_018/r2_r0_rwl u_t009_018/r2_r1_rwl
+ u_t009_018/r3_w0_wl u_t009_018/r3_w1_wl u_t009_018/r3_r0_rwl u_t009_018/r3_r1_rwl
+ u_t009_018/VDD u_t009_031/VSS VSUBS detronyx_12t_2w2r_rc4_4x4_routed_5layer_direct
Xu_t009_007 u_t009_007/c0_w0_bl u_t009_007/c0_w0_br u_t009_007/c0_w1_bl u_t009_007/c0_w1_br
+ u_t009_007/c0_r0_rbl u_t009_007/c0_r1_rbl u_t009_007/c1_w0_bl u_t009_007/c1_w0_br
+ u_t009_007/c1_w1_bl u_t009_007/c1_w1_br u_t009_007/c1_r0_rbl u_t009_007/c1_r1_rbl
+ u_t009_007/c2_w0_bl u_t009_007/c2_w0_br u_t009_007/c2_w1_bl u_t009_007/c2_w1_br
+ u_t009_007/c2_r0_rbl u_t009_007/c2_r1_rbl u_t009_007/c3_w0_bl u_t009_007/c3_w0_br
+ u_t009_007/c3_w1_bl u_t009_007/c3_w1_br u_t009_007/c3_r0_rbl u_t009_007/c3_r1_rbl
+ u_t009_007/r0_w0_wl u_t009_007/r0_w1_wl u_t009_007/r0_r0_rwl u_t009_007/r0_r1_rwl
+ u_t009_007/r1_w0_wl u_t009_007/r1_w1_wl u_t009_007/r1_r0_rwl u_t009_007/r1_r1_rwl
+ u_t009_007/r2_w0_wl u_t009_007/r2_w1_wl u_t009_007/r2_r0_rwl u_t009_007/r2_r1_rwl
+ u_t009_007/r3_w0_wl u_t009_007/r3_w1_wl u_t009_007/r3_r0_rwl u_t009_007/r3_r1_rwl
+ VSS u_t009_031/VSS VSUBS detronyx_12t_2w2r_rc4_4x4_routed_5layer_direct
Xgf180mcu_as_sc_mcu7t3v3__inv_2_154 gf180mcu_as_sc_mcu7t3v3__inv_2_99/VDD gf180mcu_as_sc_mcu7t3v3__inv_2_99/VDD
+ VSS VSS gf180mcu_as_sc_mcu7t3v3__inv_2_155/VNW VSUBS gf180mcu_as_sc_mcu7t3v3__inv_2
Xgf180mcu_as_sc_mcu7t3v3__inv_2_132 gf180mcu_as_sc_mcu7t3v3__inv_2_134/VDD gf180mcu_as_sc_mcu7t3v3__inv_2_138/VDD
+ VSS VSS gf180mcu_as_sc_mcu7t3v3__inv_2_134/VNW VSUBS gf180mcu_as_sc_mcu7t3v3__inv_2
Xgf180mcu_as_sc_mcu7t3v3__inv_2_121 gf180mcu_as_sc_mcu7t3v3__inv_2_139/VSS gf180mcu_as_sc_mcu7t3v3__inv_2_126/VDD
+ gf180mcu_as_sc_mcu7t3v3__inv_2_121/Y VSS gf180mcu_as_sc_mcu7t3v3__inv_2_122/VNW
+ VSUBS gf180mcu_as_sc_mcu7t3v3__inv_2
Xgf180mcu_as_sc_mcu7t3v3__inv_2_143 gf180mcu_as_sc_mcu7t3v3__inv_2_151/VDD gf180mcu_as_sc_mcu7t3v3__inv_2_151/VSS
+ VSS VSS gf180mcu_as_sc_mcu7t3v3__inv_2_151/VNW VSUBS gf180mcu_as_sc_mcu7t3v3__inv_2
Xgf180mcu_as_sc_mcu7t3v3__inv_2_110 gf180mcu_as_sc_mcu7t3v3__inv_2_371/VSS gf180mcu_as_sc_mcu7t3v3__inv_2_115/VDD
+ VSS VSS gf180mcu_as_sc_mcu7t3v3__inv_2_111/VNW VSUBS gf180mcu_as_sc_mcu7t3v3__inv_2
Xgf180mcu_as_sc_mcu7t3v3__inv_2_198 gf180mcu_as_sc_mcu7t3v3__inv_2_200/VDD VSS VSS
+ VSS gf180mcu_as_sc_mcu7t3v3__inv_2_200/VNW VSUBS gf180mcu_as_sc_mcu7t3v3__inv_2
Xgf180mcu_as_sc_mcu7t3v3__inv_2_176 gf180mcu_as_sc_mcu7t3v3__inv_2_177/VDD VSS gf180mcu_as_sc_mcu7t3v3__inv_2_176/Y
+ VSS gf180mcu_as_sc_mcu7t3v3__inv_2_177/VNW VSUBS gf180mcu_as_sc_mcu7t3v3__inv_2
Xgf180mcu_as_sc_mcu7t3v3__inv_2_165 gf180mcu_as_sc_mcu7t3v3__inv_2_165/VDD VSS gf180mcu_as_sc_mcu7t3v3__inv_2_165/Y
+ VSS gf180mcu_as_sc_mcu7t3v3__inv_2_165/VNW VSUBS gf180mcu_as_sc_mcu7t3v3__inv_2
Xgf180mcu_as_sc_mcu7t3v3__inv_2_187 gf180mcu_as_sc_mcu7t3v3__inv_2_188/VDD gf180mcu_as_sc_mcu7t3v3__inv_2_192/VDD
+ gf180mcu_as_sc_mcu7t3v3__inv_2_187/Y VSS gf180mcu_as_sc_mcu7t3v3__inv_2_188/VNW
+ VSUBS gf180mcu_as_sc_mcu7t3v3__inv_2
Xgf180mcu_as_sc_mcu7t3v3__inv_2_1609 VSS VSS gf180mcu_as_sc_mcu7t3v3__inv_2_1685/Y
+ gf180mcu_as_sc_mcu7t3v3__inv_2_1685/Y gf180mcu_as_sc_mcu7t3v3__inv_2_1661/VNW VSUBS
+ gf180mcu_as_sc_mcu7t3v3__inv_2
Xu_t023_021 u_t023_021/c0_w0_bl u_t023_021/c0_w0_br u_t023_021/c0_w1_bl u_t023_021/c0_w1_br
+ u_t023_021/c0_r0_rbl u_t023_021/c0_r1_rbl u_t023_021/c1_w0_bl u_t023_021/c1_w0_br
+ u_t023_021/c1_w1_bl u_t023_021/c1_w1_br u_t023_021/c1_r0_rbl u_t023_021/c1_r1_rbl
+ u_t023_021/c2_w0_bl u_t023_021/c2_w0_br u_t023_021/c2_w1_bl u_t023_021/c2_w1_br
+ u_t023_021/c2_r0_rbl u_t023_021/c2_r1_rbl u_t023_021/c3_w0_bl u_t023_021/c3_w0_br
+ u_t023_021/c3_w1_bl u_t023_021/c3_w1_br u_t023_021/c3_r0_rbl u_t023_021/c3_r1_rbl
+ u_t023_021/r0_w0_wl u_t023_021/r0_w1_wl u_t023_021/r0_r0_rwl u_t023_021/r0_r1_rwl
+ u_t023_021/r1_w0_wl u_t023_021/r1_w1_wl u_t023_021/r1_r0_rwl u_t023_021/r1_r1_rwl
+ u_t023_021/r2_w0_wl u_t023_021/r2_w1_wl u_t023_021/r2_r0_rwl u_t023_021/r2_r1_rwl
+ u_t023_021/r3_w0_wl u_t023_021/r3_w1_wl u_t023_021/r3_r0_rwl u_t023_021/r3_r1_rwl
+ u_t023_021/VDD u_t023_024/VSS VSUBS detronyx_12t_2w2r_rc4_4x4_routed_5layer_direct
Xu_t023_010 u_t023_010/c0_w0_bl u_t023_010/c0_w0_br u_t023_010/c0_w1_bl u_t023_010/c0_w1_br
+ u_t023_010/c0_r0_rbl u_t023_010/c0_r1_rbl u_t023_010/c1_w0_bl u_t023_010/c1_w0_br
+ u_t023_010/c1_w1_bl u_t023_010/c1_w1_br u_t023_010/c1_r0_rbl u_t023_010/c1_r1_rbl
+ u_t023_010/c2_w0_bl u_t023_010/c2_w0_br u_t023_010/c2_w1_bl u_t023_010/c2_w1_br
+ u_t023_010/c2_r0_rbl u_t023_010/c2_r1_rbl u_t023_010/c3_w0_bl u_t023_010/c3_w0_br
+ u_t023_010/c3_w1_bl u_t023_010/c3_w1_br u_t023_010/c3_r0_rbl u_t023_010/c3_r1_rbl
+ u_t023_010/r0_w0_wl u_t023_010/r0_w1_wl u_t023_010/r0_r0_rwl u_t023_010/r0_r1_rwl
+ u_t023_010/r1_w0_wl u_t023_010/r1_w1_wl u_t023_010/r1_r0_rwl u_t023_010/r1_r1_rwl
+ u_t023_010/r2_w0_wl u_t023_010/r2_w1_wl u_t023_010/r2_r0_rwl u_t023_010/r2_r1_rwl
+ u_t023_010/r3_w0_wl u_t023_010/r3_w1_wl u_t023_010/r3_r0_rwl u_t023_010/r3_r1_rwl
+ VSS u_t023_010/VSS VSUBS detronyx_12t_2w2r_rc4_4x4_routed_5layer_direct
Xu_t014_021 u_t014_021/c0_w0_bl u_t014_021/c0_w0_br u_t014_021/c0_w1_bl u_t014_021/c0_w1_br
+ u_t014_021/c0_r0_rbl u_t014_021/c0_r1_rbl u_t014_021/c1_w0_bl u_t014_021/c1_w0_br
+ u_t014_021/c1_w1_bl u_t014_021/c1_w1_br u_t014_021/c1_r0_rbl u_t014_021/c1_r1_rbl
+ u_t014_021/c2_w0_bl u_t014_021/c2_w0_br u_t014_021/c2_w1_bl u_t014_021/c2_w1_br
+ u_t014_021/c2_r0_rbl u_t014_021/c2_r1_rbl u_t014_021/c3_w0_bl u_t014_021/c3_w0_br
+ u_t014_021/c3_w1_bl u_t014_021/c3_w1_br u_t014_021/c3_r0_rbl u_t014_021/c3_r1_rbl
+ u_t014_021/r0_w0_wl u_t014_021/r0_w1_wl u_t014_021/r0_r0_rwl u_t014_021/r0_r1_rwl
+ u_t014_021/r1_w0_wl u_t014_021/r1_w1_wl u_t014_021/r1_r0_rwl u_t014_021/r1_r1_rwl
+ u_t014_021/r2_w0_wl u_t014_021/r2_w1_wl u_t014_021/r2_r0_rwl u_t014_021/r2_r1_rwl
+ u_t014_021/r3_w0_wl u_t014_021/r3_w1_wl u_t014_021/r3_r0_rwl u_t014_021/r3_r1_rwl
+ u_t014_021/VDD u_t014_024/VSS VSUBS detronyx_12t_2w2r_rc4_4x4_routed_5layer_direct
Xu_t014_010 u_t014_010/c0_w0_bl u_t014_010/c0_w0_br u_t014_010/c0_w1_bl u_t014_010/c0_w1_br
+ u_t014_010/c0_r0_rbl u_t014_010/c0_r1_rbl u_t014_010/c1_w0_bl u_t014_010/c1_w0_br
+ u_t014_010/c1_w1_bl u_t014_010/c1_w1_br u_t014_010/c1_r0_rbl u_t014_010/c1_r1_rbl
+ u_t014_010/c2_w0_bl u_t014_010/c2_w0_br u_t014_010/c2_w1_bl u_t014_010/c2_w1_br
+ u_t014_010/c2_r0_rbl u_t014_010/c2_r1_rbl u_t014_010/c3_w0_bl u_t014_010/c3_w0_br
+ u_t014_010/c3_w1_bl u_t014_010/c3_w1_br u_t014_010/c3_r0_rbl u_t014_010/c3_r1_rbl
+ u_t014_010/r0_w0_wl u_t014_010/r0_w1_wl u_t014_010/r0_r0_rwl u_t014_010/r0_r1_rwl
+ u_t014_010/r1_w0_wl u_t014_010/r1_w1_wl u_t014_010/r1_r0_rwl u_t014_010/r1_r1_rwl
+ u_t014_010/r2_w0_wl u_t014_010/r2_w1_wl u_t014_010/r2_r0_rwl u_t014_010/r2_r1_rwl
+ u_t014_010/r3_w0_wl u_t014_010/r3_w1_wl u_t014_010/r3_r0_rwl u_t014_010/r3_r1_rwl
+ VSS u_t014_010/VSS VSUBS detronyx_12t_2w2r_rc4_4x4_routed_5layer_direct
Xgf180mcu_as_sc_mcu7t3v3__nand2_2_55 gf180mcu_as_sc_mcu7t3v3__nand3_2_31/VDD gf180mcu_as_sc_mcu7t3v3__nor2_2_8/VSS
+ VSS VSS VSS gf180mcu_as_sc_mcu7t3v3__nand3_2_31/VNW VSUBS gf180mcu_as_sc_mcu7t3v3__nand2_2
Xgf180mcu_as_sc_mcu7t3v3__nand2_2_44 gf180mcu_as_sc_mcu7t3v3__nand3_2_31/VDD gf180mcu_as_sc_mcu7t3v3__nand3_2_31/VSS
+ VSS VSS VSS gf180mcu_as_sc_mcu7t3v3__nand3_2_31/VNW VSUBS gf180mcu_as_sc_mcu7t3v3__nand2_2
Xgf180mcu_as_sc_mcu7t3v3__nand2_2_33 gf180mcu_as_sc_mcu7t3v3__nor2_2_5/VDD gf180mcu_as_sc_mcu7t3v3__nor2_2_5/VSS
+ VSS VSS VSS gf180mcu_as_sc_mcu7t3v3__nor2_2_5/VNW VSUBS gf180mcu_as_sc_mcu7t3v3__nand2_2
Xgf180mcu_as_sc_mcu7t3v3__nand2_2_11 gf180mcu_as_sc_mcu7t3v3__nor2_2_4/VDD gf180mcu_as_sc_mcu7t3v3__nand3_2_8/VSS
+ VSS VSS VSS gf180mcu_as_sc_mcu7t3v3__nor2_2_4/VNW VSUBS gf180mcu_as_sc_mcu7t3v3__nand2_2
Xgf180mcu_as_sc_mcu7t3v3__nand2_2_22 gf180mcu_as_sc_mcu7t3v3__nand3_2_5/VDD gf180mcu_as_sc_mcu7t3v3__nor2_2_6/VSS
+ VSS VSS VSS gf180mcu_as_sc_mcu7t3v3__nand3_2_5/VNW VSUBS gf180mcu_as_sc_mcu7t3v3__nand2_2
Xu_t020_024 u_t020_024/c0_w0_bl u_t020_024/c0_w0_br u_t020_024/c0_w1_bl u_t020_024/c0_w1_br
+ u_t020_024/c0_r0_rbl u_t020_024/c0_r1_rbl u_t020_024/c1_w0_bl u_t020_024/c1_w0_br
+ u_t020_024/c1_w1_bl u_t020_024/c1_w1_br u_t020_024/c1_r0_rbl u_t020_024/c1_r1_rbl
+ u_t020_024/c2_w0_bl u_t020_024/c2_w0_br u_t020_024/c2_w1_bl u_t020_024/c2_w1_br
+ u_t020_024/c2_r0_rbl u_t020_024/c2_r1_rbl u_t020_024/c3_w0_bl u_t020_024/c3_w0_br
+ u_t020_024/c3_w1_bl u_t020_024/c3_w1_br u_t020_024/c3_r0_rbl u_t020_024/c3_r1_rbl
+ u_t020_024/r0_w0_wl u_t020_024/r0_w1_wl u_t020_024/r0_r0_rwl u_t020_024/r0_r1_rwl
+ u_t020_024/r1_w0_wl u_t020_024/r1_w1_wl u_t020_024/r1_r0_rwl u_t020_024/r1_r1_rwl
+ u_t020_024/r2_w0_wl u_t020_024/r2_w1_wl u_t020_024/r2_r0_rwl u_t020_024/r2_r1_rwl
+ u_t020_024/r3_w0_wl u_t020_024/r3_w1_wl u_t020_024/r3_r0_rwl u_t020_024/r3_r1_rwl
+ VSS u_t020_024/VSS VSUBS detronyx_12t_2w2r_rc4_4x4_routed_5layer_direct
Xu_t005_021 u_t005_021/c0_w0_bl u_t005_021/c0_w0_br u_t005_021/c0_w1_bl u_t005_021/c0_w1_br
+ u_t005_021/c0_r0_rbl u_t005_021/c0_r1_rbl u_t005_021/c1_w0_bl u_t005_021/c1_w0_br
+ u_t005_021/c1_w1_bl u_t005_021/c1_w1_br u_t005_021/c1_r0_rbl u_t005_021/c1_r1_rbl
+ u_t005_021/c2_w0_bl u_t005_021/c2_w0_br u_t005_021/c2_w1_bl u_t005_021/c2_w1_br
+ u_t005_021/c2_r0_rbl u_t005_021/c2_r1_rbl u_t005_021/c3_w0_bl u_t005_021/c3_w0_br
+ u_t005_021/c3_w1_bl u_t005_021/c3_w1_br u_t005_021/c3_r0_rbl u_t005_021/c3_r1_rbl
+ u_t005_021/r0_w0_wl u_t005_021/r0_w1_wl u_t005_021/r0_r0_rwl u_t005_021/r0_r1_rwl
+ u_t005_021/r1_w0_wl u_t005_021/r1_w1_wl u_t005_021/r1_r0_rwl u_t005_021/r1_r1_rwl
+ u_t005_021/r2_w0_wl u_t005_021/r2_w1_wl u_t005_021/r2_r0_rwl u_t005_021/r2_r1_rwl
+ u_t005_021/r3_w0_wl u_t005_021/r3_w1_wl u_t005_021/r3_r0_rwl u_t005_021/r3_r1_rwl
+ u_t005_021/VDD u_t005_031/VSS VSUBS detronyx_12t_2w2r_rc4_4x4_routed_5layer_direct
Xu_t020_013 u_t020_013/c0_w0_bl u_t020_013/c0_w0_br u_t020_013/c0_w1_bl u_t020_013/c0_w1_br
+ u_t020_013/c0_r0_rbl u_t020_013/c0_r1_rbl u_t020_013/c1_w0_bl u_t020_013/c1_w0_br
+ u_t020_013/c1_w1_bl u_t020_013/c1_w1_br u_t020_013/c1_r0_rbl u_t020_013/c1_r1_rbl
+ u_t020_013/c2_w0_bl u_t020_013/c2_w0_br u_t020_013/c2_w1_bl u_t020_013/c2_w1_br
+ u_t020_013/c2_r0_rbl u_t020_013/c2_r1_rbl u_t020_013/c3_w0_bl u_t020_013/c3_w0_br
+ u_t020_013/c3_w1_bl u_t020_013/c3_w1_br u_t020_013/c3_r0_rbl u_t020_013/c3_r1_rbl
+ u_t020_013/r0_w0_wl u_t020_013/r0_w1_wl u_t020_013/r0_r0_rwl u_t020_013/r0_r1_rwl
+ u_t020_013/r1_w0_wl u_t020_013/r1_w1_wl u_t020_013/r1_r0_rwl u_t020_013/r1_r1_rwl
+ u_t020_013/r2_w0_wl u_t020_013/r2_w1_wl u_t020_013/r2_r0_rwl u_t020_013/r2_r1_rwl
+ u_t020_013/r3_w0_wl u_t020_013/r3_w1_wl u_t020_013/r3_r0_rwl u_t020_013/r3_r1_rwl
+ u_t020_013/VDD u_t020_013/VSS VSUBS detronyx_12t_2w2r_rc4_4x4_routed_5layer_direct
Xu_t005_010 u_t005_010/c0_w0_bl u_t005_010/c0_w0_br u_t005_010/c0_w1_bl u_t005_010/c0_w1_br
+ u_t005_010/c0_r0_rbl u_t005_010/c0_r1_rbl u_t005_010/c1_w0_bl u_t005_010/c1_w0_br
+ u_t005_010/c1_w1_bl u_t005_010/c1_w1_br u_t005_010/c1_r0_rbl u_t005_010/c1_r1_rbl
+ u_t005_010/c2_w0_bl u_t005_010/c2_w0_br u_t005_010/c2_w1_bl u_t005_010/c2_w1_br
+ u_t005_010/c2_r0_rbl u_t005_010/c2_r1_rbl u_t005_010/c3_w0_bl u_t005_010/c3_w0_br
+ u_t005_010/c3_w1_bl u_t005_010/c3_w1_br u_t005_010/c3_r0_rbl u_t005_010/c3_r1_rbl
+ u_t005_010/r0_w0_wl u_t005_010/r0_w1_wl u_t005_010/r0_r0_rwl u_t005_010/r0_r1_rwl
+ u_t005_010/r1_w0_wl u_t005_010/r1_w1_wl u_t005_010/r1_r0_rwl u_t005_010/r1_r1_rwl
+ u_t005_010/r2_w0_wl u_t005_010/r2_w1_wl u_t005_010/r2_r0_rwl u_t005_010/r2_r1_rwl
+ u_t005_010/r3_w0_wl u_t005_010/r3_w1_wl u_t005_010/r3_r0_rwl u_t005_010/r3_r1_rwl
+ VSS u_t005_031/VSS VSUBS detronyx_12t_2w2r_rc4_4x4_routed_5layer_direct
Xu_t020_002 u_t020_002/c0_w0_bl u_t020_002/c0_w0_br u_t020_002/c0_w1_bl u_t020_002/c0_w1_br
+ u_t020_002/c0_r0_rbl u_t020_002/c0_r1_rbl u_t020_002/c1_w0_bl u_t020_002/c1_w0_br
+ u_t020_002/c1_w1_bl u_t020_002/c1_w1_br u_t020_002/c1_r0_rbl u_t020_002/c1_r1_rbl
+ u_t020_002/c2_w0_bl u_t020_002/c2_w0_br u_t020_002/c2_w1_bl u_t020_002/c2_w1_br
+ u_t020_002/c2_r0_rbl u_t020_002/c2_r1_rbl u_t020_002/c3_w0_bl u_t020_002/c3_w0_br
+ u_t020_002/c3_w1_bl u_t020_002/c3_w1_br u_t020_002/c3_r0_rbl u_t020_002/c3_r1_rbl
+ u_t020_002/r0_w0_wl u_t020_002/r0_w1_wl u_t020_002/r0_r0_rwl u_t020_002/r0_r1_rwl
+ u_t020_002/r1_w0_wl u_t020_002/r1_w1_wl u_t020_002/r1_r0_rwl u_t020_002/r1_r1_rwl
+ u_t020_002/r2_w0_wl u_t020_002/r2_w1_wl u_t020_002/r2_r0_rwl u_t020_002/r2_r1_rwl
+ u_t020_002/r3_w0_wl u_t020_002/r3_w1_wl u_t020_002/r3_r0_rwl u_t020_002/r3_r1_rwl
+ VSS u_t020_002/VSS VSUBS detronyx_12t_2w2r_rc4_4x4_routed_5layer_direct
Xgf180mcu_as_sc_mcu7t3v3__inv_2_1406 VSS VSS VSS VSS gf180mcu_as_sc_mcu7t3v3__inv_2_1408/VNW
+ VSUBS gf180mcu_as_sc_mcu7t3v3__inv_2
Xgf180mcu_as_sc_mcu7t3v3__inv_2_1417 VSS gf180mcu_as_sc_mcu7t3v3__inv_2_1433/VSS VSS
+ VSS gf180mcu_as_sc_mcu7t3v3__inv_2_1433/VNW VSUBS gf180mcu_as_sc_mcu7t3v3__inv_2
Xgf180mcu_as_sc_mcu7t3v3__inv_2_1439 gf180mcu_as_sc_mcu7t3v3__inv_2_1440/VDD gf180mcu_as_sc_mcu7t3v3__inv_2_1444/VDD
+ gf180mcu_as_sc_mcu7t3v3__inv_2_1439/Y VSS gf180mcu_as_sc_mcu7t3v3__inv_2_1440/VNW
+ VSUBS gf180mcu_as_sc_mcu7t3v3__inv_2
Xgf180mcu_as_sc_mcu7t3v3__inv_2_1428 gf180mcu_as_sc_mcu7t3v3__inv_2_1428/VDD gf180mcu_as_sc_mcu7t3v3__inv_2_1432/VDD
+ gf180mcu_as_sc_mcu7t3v3__inv_2_1428/Y VSS gf180mcu_as_sc_mcu7t3v3__inv_2_1428/VNW
+ VSUBS gf180mcu_as_sc_mcu7t3v3__inv_2
Xu_t011_024 u_t011_024/c0_w0_bl u_t011_024/c0_w0_br u_t011_024/c0_w1_bl u_t011_024/c0_w1_br
+ u_t011_024/c0_r0_rbl u_t011_024/c0_r1_rbl u_t011_024/c1_w0_bl u_t011_024/c1_w0_br
+ u_t011_024/c1_w1_bl u_t011_024/c1_w1_br u_t011_024/c1_r0_rbl u_t011_024/c1_r1_rbl
+ u_t011_024/c2_w0_bl u_t011_024/c2_w0_br u_t011_024/c2_w1_bl u_t011_024/c2_w1_br
+ u_t011_024/c2_r0_rbl u_t011_024/c2_r1_rbl u_t011_024/c3_w0_bl u_t011_024/c3_w0_br
+ u_t011_024/c3_w1_bl u_t011_024/c3_w1_br u_t011_024/c3_r0_rbl u_t011_024/c3_r1_rbl
+ u_t011_024/r0_w0_wl u_t011_024/r0_w1_wl u_t011_024/r0_r0_rwl u_t011_024/r0_r1_rwl
+ u_t011_024/r1_w0_wl u_t011_024/r1_w1_wl u_t011_024/r1_r0_rwl u_t011_024/r1_r1_rwl
+ u_t011_024/r2_w0_wl u_t011_024/r2_w1_wl u_t011_024/r2_r0_rwl u_t011_024/r2_r1_rwl
+ u_t011_024/r3_w0_wl u_t011_024/r3_w1_wl u_t011_024/r3_r0_rwl u_t011_024/r3_r1_rwl
+ VSS u_t011_024/VSS VSUBS detronyx_12t_2w2r_rc4_4x4_routed_5layer_direct
Xu_t011_013 u_t011_013/c0_w0_bl u_t011_013/c0_w0_br u_t011_013/c0_w1_bl u_t011_013/c0_w1_br
+ u_t011_013/c0_r0_rbl u_t011_013/c0_r1_rbl u_t011_013/c1_w0_bl u_t011_013/c1_w0_br
+ u_t011_013/c1_w1_bl u_t011_013/c1_w1_br u_t011_013/c1_r0_rbl u_t011_013/c1_r1_rbl
+ u_t011_013/c2_w0_bl u_t011_013/c2_w0_br u_t011_013/c2_w1_bl u_t011_013/c2_w1_br
+ u_t011_013/c2_r0_rbl u_t011_013/c2_r1_rbl u_t011_013/c3_w0_bl u_t011_013/c3_w0_br
+ u_t011_013/c3_w1_bl u_t011_013/c3_w1_br u_t011_013/c3_r0_rbl u_t011_013/c3_r1_rbl
+ u_t011_013/r0_w0_wl u_t011_013/r0_w1_wl u_t011_013/r0_r0_rwl u_t011_013/r0_r1_rwl
+ u_t011_013/r1_w0_wl u_t011_013/r1_w1_wl u_t011_013/r1_r0_rwl u_t011_013/r1_r1_rwl
+ u_t011_013/r2_w0_wl u_t011_013/r2_w1_wl u_t011_013/r2_r0_rwl u_t011_013/r2_r1_rwl
+ u_t011_013/r3_w0_wl u_t011_013/r3_w1_wl u_t011_013/r3_r0_rwl u_t011_013/r3_r1_rwl
+ u_t011_013/VDD u_t011_013/VSS VSUBS detronyx_12t_2w2r_rc4_4x4_routed_5layer_direct
Xu_t011_002 u_t011_002/c0_w0_bl u_t011_002/c0_w0_br u_t011_002/c0_w1_bl u_t011_002/c0_w1_br
+ u_t011_002/c0_r0_rbl u_t011_002/c0_r1_rbl u_t011_002/c1_w0_bl u_t011_002/c1_w0_br
+ u_t011_002/c1_w1_bl u_t011_002/c1_w1_br u_t011_002/c1_r0_rbl u_t011_002/c1_r1_rbl
+ u_t011_002/c2_w0_bl u_t011_002/c2_w0_br u_t011_002/c2_w1_bl u_t011_002/c2_w1_br
+ u_t011_002/c2_r0_rbl u_t011_002/c2_r1_rbl u_t011_002/c3_w0_bl u_t011_002/c3_w0_br
+ u_t011_002/c3_w1_bl u_t011_002/c3_w1_br u_t011_002/c3_r0_rbl u_t011_002/c3_r1_rbl
+ u_t011_002/r0_w0_wl u_t011_002/r0_w1_wl u_t011_002/r0_r0_rwl u_t011_002/r0_r1_rwl
+ u_t011_002/r1_w0_wl u_t011_002/r1_w1_wl u_t011_002/r1_r0_rwl u_t011_002/r1_r1_rwl
+ u_t011_002/r2_w0_wl u_t011_002/r2_w1_wl u_t011_002/r2_r0_rwl u_t011_002/r2_r1_rwl
+ u_t011_002/r3_w0_wl u_t011_002/r3_w1_wl u_t011_002/r3_r0_rwl u_t011_002/r3_r1_rwl
+ VSS u_t011_002/VSS VSUBS detronyx_12t_2w2r_rc4_4x4_routed_5layer_direct
Xu_t002_024 u_t002_024/c0_w0_bl u_t002_024/c0_w0_br u_t002_024/c0_w1_bl u_t002_024/c0_w1_br
+ u_t002_024/c0_r0_rbl u_t002_024/c0_r1_rbl u_t002_024/c1_w0_bl u_t002_024/c1_w0_br
+ u_t002_024/c1_w1_bl u_t002_024/c1_w1_br u_t002_024/c1_r0_rbl u_t002_024/c1_r1_rbl
+ u_t002_024/c2_w0_bl u_t002_024/c2_w0_br u_t002_024/c2_w1_bl u_t002_024/c2_w1_br
+ u_t002_024/c2_r0_rbl u_t002_024/c2_r1_rbl u_t002_024/c3_w0_bl u_t002_024/c3_w0_br
+ u_t002_024/c3_w1_bl u_t002_024/c3_w1_br u_t002_024/c3_r0_rbl u_t002_024/c3_r1_rbl
+ u_t002_024/r0_w0_wl u_t002_024/r0_w1_wl u_t002_024/r0_r0_rwl u_t002_024/r0_r1_rwl
+ u_t002_024/r1_w0_wl u_t002_024/r1_w1_wl u_t002_024/r1_r0_rwl u_t002_024/r1_r1_rwl
+ u_t002_024/r2_w0_wl u_t002_024/r2_w1_wl u_t002_024/r2_r0_rwl u_t002_024/r2_r1_rwl
+ u_t002_024/r3_w0_wl u_t002_024/r3_w1_wl u_t002_024/r3_r0_rwl u_t002_024/r3_r1_rwl
+ VSS u_t002_024/VSS VSUBS detronyx_12t_2w2r_rc4_4x4_routed_5layer_direct
Xu_t002_013 u_t002_013/c0_w0_bl u_t002_013/c0_w0_br u_t002_013/c0_w1_bl u_t002_013/c0_w1_br
+ u_t002_013/c0_r0_rbl u_t002_013/c0_r1_rbl u_t002_013/c1_w0_bl u_t002_013/c1_w0_br
+ u_t002_013/c1_w1_bl u_t002_013/c1_w1_br u_t002_013/c1_r0_rbl u_t002_013/c1_r1_rbl
+ u_t002_013/c2_w0_bl u_t002_013/c2_w0_br u_t002_013/c2_w1_bl u_t002_013/c2_w1_br
+ u_t002_013/c2_r0_rbl u_t002_013/c2_r1_rbl u_t002_013/c3_w0_bl u_t002_013/c3_w0_br
+ u_t002_013/c3_w1_bl u_t002_013/c3_w1_br u_t002_013/c3_r0_rbl u_t002_013/c3_r1_rbl
+ u_t002_013/r0_w0_wl u_t002_013/r0_w1_wl u_t002_013/r0_r0_rwl u_t002_013/r0_r1_rwl
+ u_t002_013/r1_w0_wl u_t002_013/r1_w1_wl u_t002_013/r1_r0_rwl u_t002_013/r1_r1_rwl
+ u_t002_013/r2_w0_wl u_t002_013/r2_w1_wl u_t002_013/r2_r0_rwl u_t002_013/r2_r1_rwl
+ u_t002_013/r3_w0_wl u_t002_013/r3_w1_wl u_t002_013/r3_r0_rwl u_t002_013/r3_r1_rwl
+ u_t002_013/VDD u_t002_013/VSS VSUBS detronyx_12t_2w2r_rc4_4x4_routed_5layer_direct
Xu_t002_002 u_t002_002/c0_w0_bl u_t002_002/c0_w0_br u_t002_002/c0_w1_bl u_t002_002/c0_w1_br
+ u_t002_002/c0_r0_rbl u_t002_002/c0_r1_rbl u_t002_002/c1_w0_bl u_t002_002/c1_w0_br
+ u_t002_002/c1_w1_bl u_t002_002/c1_w1_br u_t002_002/c1_r0_rbl u_t002_002/c1_r1_rbl
+ u_t002_002/c2_w0_bl u_t002_002/c2_w0_br u_t002_002/c2_w1_bl u_t002_002/c2_w1_br
+ u_t002_002/c2_r0_rbl u_t002_002/c2_r1_rbl u_t002_002/c3_w0_bl u_t002_002/c3_w0_br
+ u_t002_002/c3_w1_bl u_t002_002/c3_w1_br u_t002_002/c3_r0_rbl u_t002_002/c3_r1_rbl
+ u_t002_002/r0_w0_wl u_t002_002/r0_w1_wl u_t002_002/r0_r0_rwl u_t002_002/r0_r1_rwl
+ u_t002_002/r1_w0_wl u_t002_002/r1_w1_wl u_t002_002/r1_r0_rwl u_t002_002/r1_r1_rwl
+ u_t002_002/r2_w0_wl u_t002_002/r2_w1_wl u_t002_002/r2_r0_rwl u_t002_002/r2_r1_rwl
+ u_t002_002/r3_w0_wl u_t002_002/r3_w1_wl u_t002_002/r3_r0_rwl u_t002_002/r3_r1_rwl
+ VSS u_t002_002/VSS VSUBS detronyx_12t_2w2r_rc4_4x4_routed_5layer_direct
Xgf180mcu_as_sc_mcu7t3v3__inv_2_1258 gf180mcu_as_sc_mcu7t3v3__nor2_2_8/VDD gf180mcu_as_sc_mcu7t3v3__nand3_2_32/VSS
+ VSS VSS gf180mcu_as_sc_mcu7t3v3__nor2_2_8/VNW VSUBS gf180mcu_as_sc_mcu7t3v3__inv_2
Xgf180mcu_as_sc_mcu7t3v3__inv_2_1214 gf180mcu_as_sc_mcu7t3v3__nor2_2_8/VDD gf180mcu_as_sc_mcu7t3v3__nand3_2_32/VSS
+ VSS VSS gf180mcu_as_sc_mcu7t3v3__nor2_2_8/VNW VSUBS gf180mcu_as_sc_mcu7t3v3__inv_2
Xgf180mcu_as_sc_mcu7t3v3__inv_2_1203 gf180mcu_as_sc_mcu7t3v3__nor2_2_8/VDD gf180mcu_as_sc_mcu7t3v3__nor2_2_8/VSS
+ gf180mcu_as_sc_mcu7t3v3__inv_2_1203/Y VSS gf180mcu_as_sc_mcu7t3v3__nor2_2_8/VNW
+ VSUBS gf180mcu_as_sc_mcu7t3v3__inv_2
Xgf180mcu_as_sc_mcu7t3v3__inv_2_1225 gf180mcu_as_sc_mcu7t3v3__nand3_2_31/VDD gf180mcu_as_sc_mcu7t3v3__nor2_2_8/VSS
+ VSS VSS gf180mcu_as_sc_mcu7t3v3__nand3_2_31/VNW VSUBS gf180mcu_as_sc_mcu7t3v3__inv_2
Xgf180mcu_as_sc_mcu7t3v3__inv_2_1269 gf180mcu_as_sc_mcu7t3v3__nand3_2_31/VDD gf180mcu_as_sc_mcu7t3v3__nand3_2_31/VSS
+ gf180mcu_as_sc_mcu7t3v3__inv_2_1269/Y VSS gf180mcu_as_sc_mcu7t3v3__nand3_2_31/VNW
+ VSUBS gf180mcu_as_sc_mcu7t3v3__inv_2
Xgf180mcu_as_sc_mcu7t3v3__inv_2_1247 VSS VSS VSS VSS gf180mcu_as_sc_mcu7t3v3__inv_2_1247/VNW
+ VSUBS gf180mcu_as_sc_mcu7t3v3__inv_2
Xgf180mcu_as_sc_mcu7t3v3__inv_2_1236 VSS VSS VSS VSS gf180mcu_as_sc_mcu7t3v3__inv_2_1237/VNW
+ VSUBS gf180mcu_as_sc_mcu7t3v3__inv_2
Xgf180mcu_as_sc_mcu7t3v3__inv_2_709 gf180mcu_as_sc_mcu7t3v3__inv_2_711/VDD VSS gf180mcu_as_sc_mcu7t3v3__inv_2_709/Y
+ gf180mcu_as_sc_mcu7t3v3__inv_2_732/Y gf180mcu_as_sc_mcu7t3v3__inv_2_711/VNW VSUBS
+ gf180mcu_as_sc_mcu7t3v3__inv_2
Xgf180mcu_as_sc_mcu7t3v3__inv_2_52 gf180mcu_as_sc_mcu7t3v3__inv_2_8/VDD gf180mcu_as_sc_mcu7t3v3__inv_2_8/VSS
+ gf180mcu_as_sc_mcu7t3v3__inv_2_8/A VSS gf180mcu_as_sc_mcu7t3v3__inv_2_8/VNW VSUBS
+ gf180mcu_as_sc_mcu7t3v3__inv_2
Xgf180mcu_as_sc_mcu7t3v3__inv_2_30 VSS gf180mcu_as_sc_mcu7t3v3__inv_2_61/VDD VSS gf180mcu_as_sc_mcu7t3v3__inv_2_77/Y
+ gf180mcu_as_sc_mcu7t3v3__inv_2_60/VNW VSUBS gf180mcu_as_sc_mcu7t3v3__inv_2
Xgf180mcu_as_sc_mcu7t3v3__inv_2_41 gf180mcu_as_sc_mcu7t3v3__inv_2_70/VDD gf180mcu_as_sc_mcu7t3v3__inv_2_70/VDD
+ gf180mcu_as_sc_mcu7t3v3__inv_2_71/Y gf180mcu_as_sc_mcu7t3v3__inv_2_71/Y gf180mcu_as_sc_mcu7t3v3__inv_2_64/VNW
+ VSUBS gf180mcu_as_sc_mcu7t3v3__inv_2
Xgf180mcu_as_sc_mcu7t3v3__inv_2_1077 gf180mcu_as_sc_mcu7t3v3__inv_2_1105/VSS VSS VSS
+ gf180mcu_as_sc_mcu7t3v3__inv_2_1144/A gf180mcu_as_sc_mcu7t3v3__inv_2_1093/VNW VSUBS
+ gf180mcu_as_sc_mcu7t3v3__inv_2
Xgf180mcu_as_sc_mcu7t3v3__inv_2_1088 VSS VSS gf180mcu_as_sc_mcu7t3v3__inv_2_1088/Y
+ VSS gf180mcu_as_sc_mcu7t3v3__inv_2_1088/VNW VSUBS gf180mcu_as_sc_mcu7t3v3__inv_2
Xgf180mcu_as_sc_mcu7t3v3__inv_2_1099 VSS VSS gf180mcu_as_sc_mcu7t3v3__inv_2_1106/A
+ gf180mcu_as_sc_mcu7t3v3__inv_2_1100/Y gf180mcu_as_sc_mcu7t3v3__inv_2_1100/VNW VSUBS
+ gf180mcu_as_sc_mcu7t3v3__inv_2
Xgf180mcu_as_sc_mcu7t3v3__inv_2_1066 gf180mcu_as_sc_mcu7t3v3__inv_2_1089/VSS gf180mcu_as_sc_mcu7t3v3__inv_2_1295/VDD
+ VSS gf180mcu_as_sc_mcu7t3v3__inv_2_1294/Y gf180mcu_as_sc_mcu7t3v3__inv_2_1068/VNW
+ VSUBS gf180mcu_as_sc_mcu7t3v3__inv_2
Xgf180mcu_as_sc_mcu7t3v3__inv_2_1011 gf180mcu_as_sc_mcu7t3v3__inv_2_1011/VDD gf180mcu_as_sc_mcu7t3v3__inv_2_1016/VDD
+ gf180mcu_as_sc_mcu7t3v3__inv_2_1011/Y VSS gf180mcu_as_sc_mcu7t3v3__inv_2_1011/VNW
+ VSUBS gf180mcu_as_sc_mcu7t3v3__inv_2
Xgf180mcu_as_sc_mcu7t3v3__inv_2_1022 VSS VSS gf180mcu_as_sc_mcu7t3v3__inv_2_1022/Y
+ VSS gf180mcu_as_sc_mcu7t3v3__inv_2_1022/VNW VSUBS gf180mcu_as_sc_mcu7t3v3__inv_2
Xgf180mcu_as_sc_mcu7t3v3__inv_2_96 gf180mcu_as_sc_mcu7t3v3__inv_2_96/VDD gf180mcu_as_sc_mcu7t3v3__inv_2_96/VSS
+ gf180mcu_as_sc_mcu7t3v3__inv_2_96/Y VSS gf180mcu_as_sc_mcu7t3v3__inv_2_96/VNW VSUBS
+ gf180mcu_as_sc_mcu7t3v3__inv_2
Xgf180mcu_as_sc_mcu7t3v3__inv_2_85 gf180mcu_as_sc_mcu7t3v3__inv_2_88/VSS gf180mcu_as_sc_mcu7t3v3__inv_2_91/VDD
+ VSS VSS gf180mcu_as_sc_mcu7t3v3__inv_2_87/VNW VSUBS gf180mcu_as_sc_mcu7t3v3__inv_2
Xgf180mcu_as_sc_mcu7t3v3__inv_2_74 gf180mcu_as_sc_mcu7t3v3__inv_2_74/VDD gf180mcu_as_sc_mcu7t3v3__inv_2_75/VDD
+ gf180mcu_as_sc_mcu7t3v3__inv_2_77/Y VSS gf180mcu_as_sc_mcu7t3v3__inv_2_74/VNW VSUBS
+ gf180mcu_as_sc_mcu7t3v3__inv_2
Xgf180mcu_as_sc_mcu7t3v3__inv_2_63 gf180mcu_as_sc_mcu7t3v3__inv_2_66/VSS gf180mcu_as_sc_mcu7t3v3__inv_2_70/VDD
+ gf180mcu_as_sc_mcu7t3v3__inv_2_66/Y VSS gf180mcu_as_sc_mcu7t3v3__inv_2_63/VNW VSUBS
+ gf180mcu_as_sc_mcu7t3v3__inv_2
Xgf180mcu_as_sc_mcu7t3v3__inv_2_1000 VSS gf180mcu_as_sc_mcu7t3v3__inv_2_967/VDD VSS
+ gf180mcu_as_sc_mcu7t3v3__inv_2_997/Y gf180mcu_as_sc_mcu7t3v3__inv_2_1002/VNW VSUBS
+ gf180mcu_as_sc_mcu7t3v3__inv_2
Xgf180mcu_as_sc_mcu7t3v3__inv_2_1055 gf180mcu_as_sc_mcu7t3v3__inv_2_1056/VDD gf180mcu_as_sc_mcu7t3v3__inv_2_994/VDD
+ gf180mcu_as_sc_mcu7t3v3__inv_2_1055/Y gf180mcu_as_sc_mcu7t3v3__inv_2_1056/Y gf180mcu_as_sc_mcu7t3v3__inv_2_1056/VNW
+ VSUBS gf180mcu_as_sc_mcu7t3v3__inv_2
Xgf180mcu_as_sc_mcu7t3v3__inv_2_1044 gf180mcu_as_sc_mcu7t3v3__inv_2_1046/VDD VSS VSS
+ gf180mcu_as_sc_mcu7t3v3__inv_2_992/A gf180mcu_as_sc_mcu7t3v3__inv_2_1046/VNW VSUBS
+ gf180mcu_as_sc_mcu7t3v3__inv_2
Xgf180mcu_as_sc_mcu7t3v3__inv_2_1033 gf180mcu_as_sc_mcu7t3v3__inv_2_1034/VDD VSS gf180mcu_as_sc_mcu7t3v3__inv_2_992/A
+ gf180mcu_as_sc_mcu7t3v3__inv_2_1034/Y gf180mcu_as_sc_mcu7t3v3__inv_2_1034/VNW VSUBS
+ gf180mcu_as_sc_mcu7t3v3__inv_2
Xgf180mcu_as_sc_mcu7t3v3__inv_2_517 VSS VSS VSS VSS gf180mcu_as_sc_mcu7t3v3__inv_2_518/VNW
+ VSUBS gf180mcu_as_sc_mcu7t3v3__inv_2
Xgf180mcu_as_sc_mcu7t3v3__inv_2_539 VSS VSS gf180mcu_as_sc_mcu7t3v3__inv_2_539/Y VSS
+ gf180mcu_as_sc_mcu7t3v3__inv_2_547/VNW VSUBS gf180mcu_as_sc_mcu7t3v3__inv_2
Xgf180mcu_as_sc_mcu7t3v3__inv_2_506 VSS VSS VSS VSS gf180mcu_as_sc_mcu7t3v3__inv_2_506/VNW
+ VSUBS gf180mcu_as_sc_mcu7t3v3__inv_2
Xgf180mcu_as_sc_mcu7t3v3__inv_2_528 VSS VSS gf180mcu_as_sc_mcu7t3v3__inv_2_528/Y VSS
+ gf180mcu_as_sc_mcu7t3v3__inv_2_530/VNW VSUBS gf180mcu_as_sc_mcu7t3v3__inv_2
Xgf180mcu_as_sc_mcu7t3v3__nand3_2_0 gf180mcu_as_sc_mcu7t3v3__nor2_2_5/VDD gf180mcu_as_sc_mcu7t3v3__nor2_2_5/VSS
+ VSS VSS VSS VSS gf180mcu_as_sc_mcu7t3v3__nor2_2_5/VNW VSUBS gf180mcu_as_sc_mcu7t3v3__nand3_2
Xgf180mcu_as_sc_mcu7t3v3__nand4_2_361 VSS VSS VSS VSS VSS VSS gf180mcu_as_sc_mcu7t3v3__nand4_2_361/Y
+ gf180mcu_as_sc_mcu7t3v3__inv_2_1245/VNW VSUBS gf180mcu_as_sc_mcu7t3v3__nand4_2
Xgf180mcu_as_sc_mcu7t3v3__nand4_2_350 VSS VSS VSS VSS VSS VSS gf180mcu_as_sc_mcu7t3v3__nand4_2_350/Y
+ gf180mcu_as_sc_mcu7t3v3__inv_2_1229/VNW VSUBS gf180mcu_as_sc_mcu7t3v3__nand4_2
Xgf180mcu_as_sc_mcu7t3v3__nand4_2_372 VSS VSS VSS VSS VSS VSS gf180mcu_as_sc_mcu7t3v3__nand4_2_372/Y
+ gf180mcu_as_sc_mcu7t3v3__inv_2_1151/VNW VSUBS gf180mcu_as_sc_mcu7t3v3__nand4_2
Xgf180mcu_as_sc_mcu7t3v3__nand4_2_383 gf180mcu_as_sc_mcu7t3v3__inv_2_1373/VDD VSS
+ VSS VSS VSS VSS VSS gf180mcu_as_sc_mcu7t3v3__inv_2_1373/VNW VSUBS gf180mcu_as_sc_mcu7t3v3__nand4_2
Xgf180mcu_as_sc_mcu7t3v3__nand4_2_394 VSS gf180mcu_as_sc_mcu7t3v3__inv_2_1372/VDD
+ VSS VSS VSS VSS VSS gf180mcu_as_sc_mcu7t3v3__inv_2_1371/VNW VSUBS gf180mcu_as_sc_mcu7t3v3__nand4_2
Xgf180mcu_as_sc_mcu7t3v3__inv_2_369 gf180mcu_as_sc_mcu7t3v3__inv_2_371/VDD gf180mcu_as_sc_mcu7t3v3__inv_2_371/VSS
+ VSS VSS gf180mcu_as_sc_mcu7t3v3__inv_2_371/VNW VSUBS gf180mcu_as_sc_mcu7t3v3__inv_2
Xgf180mcu_as_sc_mcu7t3v3__inv_2_358 gf180mcu_as_sc_mcu7t3v3__inv_2_358/VDD gf180mcu_as_sc_mcu7t3v3__inv_2_359/VDD
+ gf180mcu_as_sc_mcu7t3v3__inv_2_358/Y VSS gf180mcu_as_sc_mcu7t3v3__inv_2_358/VNW
+ VSUBS gf180mcu_as_sc_mcu7t3v3__inv_2
Xgf180mcu_as_sc_mcu7t3v3__inv_2_347 VSS gf180mcu_as_sc_mcu7t3v3__inv_2_354/VDD gf180mcu_as_sc_mcu7t3v3__inv_2_347/Y
+ gf180mcu_as_sc_mcu7t3v3__inv_2_358/Y gf180mcu_as_sc_mcu7t3v3__inv_2_348/VNW VSUBS
+ gf180mcu_as_sc_mcu7t3v3__inv_2
Xgf180mcu_as_sc_mcu7t3v3__inv_2_303 gf180mcu_as_sc_mcu7t3v3__inv_2_341/VDD VSS VSS
+ gf180mcu_as_sc_mcu7t3v3__inv_2_341/Y gf180mcu_as_sc_mcu7t3v3__inv_2_341/VNW VSUBS
+ gf180mcu_as_sc_mcu7t3v3__inv_2
Xgf180mcu_as_sc_mcu7t3v3__inv_2_325 VSS VSS VSS gf180mcu_as_sc_mcu7t3v3__inv_2_341/Y
+ gf180mcu_as_sc_mcu7t3v3__inv_2_339/VNW VSUBS gf180mcu_as_sc_mcu7t3v3__inv_2
Xgf180mcu_as_sc_mcu7t3v3__inv_2_336 VSS gf180mcu_as_sc_mcu7t3v3__inv_2_337/VDD gf180mcu_as_sc_mcu7t3v3__inv_2_338/Y
+ VSS gf180mcu_as_sc_mcu7t3v3__inv_2_336/VNW VSUBS gf180mcu_as_sc_mcu7t3v3__inv_2
Xgf180mcu_as_sc_mcu7t3v3__inv_2_314 gf180mcu_as_sc_mcu7t3v3__inv_2_335/VDD VSS gf180mcu_as_sc_mcu7t3v3__inv_2_338/Y
+ gf180mcu_as_sc_mcu7t3v3__inv_2_338/Y gf180mcu_as_sc_mcu7t3v3__inv_2_335/VNW VSUBS
+ gf180mcu_as_sc_mcu7t3v3__inv_2
Xu_t027_019 u_t027_019/c0_w0_bl u_t027_019/c0_w0_br u_t027_019/c0_w1_bl u_t027_019/c0_w1_br
+ u_t027_019/c0_r0_rbl u_t027_019/c0_r1_rbl u_t027_019/c1_w0_bl u_t027_019/c1_w0_br
+ u_t027_019/c1_w1_bl u_t027_019/c1_w1_br u_t027_019/c1_r0_rbl u_t027_019/c1_r1_rbl
+ u_t027_019/c2_w0_bl u_t027_019/c2_w0_br u_t027_019/c2_w1_bl u_t027_019/c2_w1_br
+ u_t027_019/c2_r0_rbl u_t027_019/c2_r1_rbl u_t027_019/c3_w0_bl u_t027_019/c3_w0_br
+ u_t027_019/c3_w1_bl u_t027_019/c3_w1_br u_t027_019/c3_r0_rbl u_t027_019/c3_r1_rbl
+ u_t027_019/r0_w0_wl u_t027_019/r0_w1_wl u_t027_019/r0_r0_rwl u_t027_019/r0_r1_rwl
+ u_t027_019/r1_w0_wl u_t027_019/r1_w1_wl u_t027_019/r1_r0_rwl u_t027_019/r1_r1_rwl
+ u_t027_019/r2_w0_wl u_t027_019/r2_w1_wl u_t027_019/r2_r0_rwl u_t027_019/r2_r1_rwl
+ u_t027_019/r3_w0_wl u_t027_019/r3_w1_wl u_t027_019/r3_r0_rwl u_t027_019/r3_r1_rwl
+ u_t027_019/VDD u_t027_019/VSS VSUBS detronyx_12t_2w2r_rc4_4x4_routed_5layer_direct
Xu_t027_008 u_t027_008/c0_w0_bl u_t027_008/c0_w0_br u_t027_008/c0_w1_bl u_t027_008/c0_w1_br
+ u_t027_008/c0_r0_rbl u_t027_008/c0_r1_rbl u_t027_008/c1_w0_bl u_t027_008/c1_w0_br
+ u_t027_008/c1_w1_bl u_t027_008/c1_w1_br u_t027_008/c1_r0_rbl u_t027_008/c1_r1_rbl
+ u_t027_008/c2_w0_bl u_t027_008/c2_w0_br u_t027_008/c2_w1_bl u_t027_008/c2_w1_br
+ u_t027_008/c2_r0_rbl u_t027_008/c2_r1_rbl u_t027_008/c3_w0_bl u_t027_008/c3_w0_br
+ u_t027_008/c3_w1_bl u_t027_008/c3_w1_br u_t027_008/c3_r0_rbl u_t027_008/c3_r1_rbl
+ u_t027_008/r0_w0_wl u_t027_008/r0_w1_wl u_t027_008/r0_r0_rwl u_t027_008/r0_r1_rwl
+ u_t027_008/r1_w0_wl u_t027_008/r1_w1_wl u_t027_008/r1_r0_rwl u_t027_008/r1_r1_rwl
+ u_t027_008/r2_w0_wl u_t027_008/r2_w1_wl u_t027_008/r2_r0_rwl u_t027_008/r2_r1_rwl
+ u_t027_008/r3_w0_wl u_t027_008/r3_w1_wl u_t027_008/r3_r0_rwl u_t027_008/r3_r1_rwl
+ VSS u_t027_009/VSS VSUBS detronyx_12t_2w2r_rc4_4x4_routed_5layer_direct
Xgf180mcu_as_sc_mcu7t3v3__inv_2_892 VSS VSS gf180mcu_as_sc_mcu7t3v3__inv_2_892/Y VSS
+ gf180mcu_as_sc_mcu7t3v3__inv_2_892/VNW VSUBS gf180mcu_as_sc_mcu7t3v3__inv_2
Xgf180mcu_as_sc_mcu7t3v3__inv_2_870 VSS VSS VSS VSS gf180mcu_as_sc_mcu7t3v3__inv_2_872/VNW
+ VSUBS gf180mcu_as_sc_mcu7t3v3__inv_2
Xgf180mcu_as_sc_mcu7t3v3__inv_2_881 VSS VSS gf180mcu_as_sc_mcu7t3v3__inv_2_881/Y VSS
+ gf180mcu_as_sc_mcu7t3v3__inv_2_881/VNW VSUBS gf180mcu_as_sc_mcu7t3v3__inv_2
Xu_t018_008 u_t018_008/c0_w0_bl u_t018_008/c0_w0_br u_t018_008/c0_w1_bl u_t018_008/c0_w1_br
+ u_t018_008/c0_r0_rbl u_t018_008/c0_r1_rbl u_t018_008/c1_w0_bl u_t018_008/c1_w0_br
+ u_t018_008/c1_w1_bl u_t018_008/c1_w1_br u_t018_008/c1_r0_rbl u_t018_008/c1_r1_rbl
+ u_t018_008/c2_w0_bl u_t018_008/c2_w0_br u_t018_008/c2_w1_bl u_t018_008/c2_w1_br
+ u_t018_008/c2_r0_rbl u_t018_008/c2_r1_rbl u_t018_008/c3_w0_bl u_t018_008/c3_w0_br
+ u_t018_008/c3_w1_bl u_t018_008/c3_w1_br u_t018_008/c3_r0_rbl u_t018_008/c3_r1_rbl
+ u_t018_008/r0_w0_wl u_t018_008/r0_w1_wl u_t018_008/r0_r0_rwl u_t018_008/r0_r1_rwl
+ u_t018_008/r1_w0_wl u_t018_008/r1_w1_wl u_t018_008/r1_r0_rwl u_t018_008/r1_r1_rwl
+ u_t018_008/r2_w0_wl u_t018_008/r2_w1_wl u_t018_008/r2_r0_rwl u_t018_008/r2_r1_rwl
+ u_t018_008/r3_w0_wl u_t018_008/r3_w1_wl u_t018_008/r3_r0_rwl u_t018_008/r3_r1_rwl
+ VSS u_t018_009/VSS VSUBS detronyx_12t_2w2r_rc4_4x4_routed_5layer_direct
Xgf180mcu_as_sc_mcu7t3v3__nand4_2_180 gf180mcu_as_sc_mcu7t3v3__inv_2_695/VDD VSS VSS
+ VSS VSS VSS VSS gf180mcu_as_sc_mcu7t3v3__inv_2_695/VNW VSUBS gf180mcu_as_sc_mcu7t3v3__nand4_2
Xu_t026_030 u_t026_030/c0_w0_bl u_t026_030/c0_w0_br u_t026_030/c0_w1_bl u_t026_030/c0_w1_br
+ u_t026_030/c0_r0_rbl u_t026_030/c0_r1_rbl u_t026_030/c1_w0_bl u_t026_030/c1_w0_br
+ u_t026_030/c1_w1_bl u_t026_030/c1_w1_br u_t026_030/c1_r0_rbl u_t026_030/c1_r1_rbl
+ u_t026_030/c2_w0_bl u_t026_030/c2_w0_br u_t026_030/c2_w1_bl u_t026_030/c2_w1_br
+ u_t026_030/c2_r0_rbl u_t026_030/c2_r1_rbl u_t026_030/c3_w0_bl u_t026_030/c3_w0_br
+ u_t026_030/c3_w1_bl u_t026_030/c3_w1_br u_t026_030/c3_r0_rbl u_t026_030/c3_r1_rbl
+ u_t026_030/r0_w0_wl u_t026_030/r0_w1_wl u_t026_030/r0_r0_rwl u_t026_030/r0_r1_rwl
+ u_t026_030/r1_w0_wl u_t026_030/r1_w1_wl u_t026_030/r1_r0_rwl u_t026_030/r1_r1_rwl
+ u_t026_030/r2_w0_wl u_t026_030/r2_w1_wl u_t026_030/r2_r0_rwl u_t026_030/r2_r1_rwl
+ u_t026_030/r3_w0_wl u_t026_030/r3_w1_wl u_t026_030/r3_r0_rwl u_t026_030/r3_r1_rwl
+ VSS u_t026_031/VSS VSUBS detronyx_12t_2w2r_rc4_4x4_routed_5layer_direct
Xu_t018_019 u_t018_019/c0_w0_bl u_t018_019/c0_w0_br u_t018_019/c0_w1_bl u_t018_019/c0_w1_br
+ u_t018_019/c0_r0_rbl u_t018_019/c0_r1_rbl u_t018_019/c1_w0_bl u_t018_019/c1_w0_br
+ u_t018_019/c1_w1_bl u_t018_019/c1_w1_br u_t018_019/c1_r0_rbl u_t018_019/c1_r1_rbl
+ u_t018_019/c2_w0_bl u_t018_019/c2_w0_br u_t018_019/c2_w1_bl u_t018_019/c2_w1_br
+ u_t018_019/c2_r0_rbl u_t018_019/c2_r1_rbl u_t018_019/c3_w0_bl u_t018_019/c3_w0_br
+ u_t018_019/c3_w1_bl u_t018_019/c3_w1_br u_t018_019/c3_r0_rbl u_t018_019/c3_r1_rbl
+ u_t018_019/r0_w0_wl u_t018_019/r0_w1_wl u_t018_019/r0_r0_rwl u_t018_019/r0_r1_rwl
+ u_t018_019/r1_w0_wl u_t018_019/r1_w1_wl u_t018_019/r1_r0_rwl u_t018_019/r1_r1_rwl
+ u_t018_019/r2_w0_wl u_t018_019/r2_w1_wl u_t018_019/r2_r0_rwl u_t018_019/r2_r1_rwl
+ u_t018_019/r3_w0_wl u_t018_019/r3_w1_wl u_t018_019/r3_r0_rwl u_t018_019/r3_r1_rwl
+ u_t018_019/VDD u_t018_019/VSS VSUBS detronyx_12t_2w2r_rc4_4x4_routed_5layer_direct
Xgf180mcu_as_sc_mcu7t3v3__nand4_2_191 VSS gf180mcu_as_sc_mcu7t3v3__inv_2_738/VSS VSS
+ VSS VSS VSS VSS gf180mcu_as_sc_mcu7t3v3__inv_2_738/VNW VSUBS gf180mcu_as_sc_mcu7t3v3__nand4_2
Xu_t017_030 u_t017_030/c0_w0_bl u_t017_030/c0_w0_br u_t017_030/c0_w1_bl u_t017_030/c0_w1_br
+ u_t017_030/c0_r0_rbl u_t017_030/c0_r1_rbl u_t017_030/c1_w0_bl u_t017_030/c1_w0_br
+ u_t017_030/c1_w1_bl u_t017_030/c1_w1_br u_t017_030/c1_r0_rbl u_t017_030/c1_r1_rbl
+ u_t017_030/c2_w0_bl u_t017_030/c2_w0_br u_t017_030/c2_w1_bl u_t017_030/c2_w1_br
+ u_t017_030/c2_r0_rbl u_t017_030/c2_r1_rbl u_t017_030/c3_w0_bl u_t017_030/c3_w0_br
+ u_t017_030/c3_w1_bl u_t017_030/c3_w1_br u_t017_030/c3_r0_rbl u_t017_030/c3_r1_rbl
+ u_t017_030/r0_w0_wl u_t017_030/r0_w1_wl u_t017_030/r0_r0_rwl u_t017_030/r0_r1_rwl
+ u_t017_030/r1_w0_wl u_t017_030/r1_w1_wl u_t017_030/r1_r0_rwl u_t017_030/r1_r1_rwl
+ u_t017_030/r2_w0_wl u_t017_030/r2_w1_wl u_t017_030/r2_r0_rwl u_t017_030/r2_r1_rwl
+ u_t017_030/r3_w0_wl u_t017_030/r3_w1_wl u_t017_030/r3_r0_rwl u_t017_030/r3_r1_rwl
+ VSS u_t017_031/VSS VSUBS detronyx_12t_2w2r_rc4_4x4_routed_5layer_direct
Xu_t009_019 u_t009_019/c0_w0_bl u_t009_019/c0_w0_br u_t009_019/c0_w1_bl u_t009_019/c0_w1_br
+ u_t009_019/c0_r0_rbl u_t009_019/c0_r1_rbl u_t009_019/c1_w0_bl u_t009_019/c1_w0_br
+ u_t009_019/c1_w1_bl u_t009_019/c1_w1_br u_t009_019/c1_r0_rbl u_t009_019/c1_r1_rbl
+ u_t009_019/c2_w0_bl u_t009_019/c2_w0_br u_t009_019/c2_w1_bl u_t009_019/c2_w1_br
+ u_t009_019/c2_r0_rbl u_t009_019/c2_r1_rbl u_t009_019/c3_w0_bl u_t009_019/c3_w0_br
+ u_t009_019/c3_w1_bl u_t009_019/c3_w1_br u_t009_019/c3_r0_rbl u_t009_019/c3_r1_rbl
+ u_t009_019/r0_w0_wl u_t009_019/r0_w1_wl u_t009_019/r0_r0_rwl u_t009_019/r0_r1_rwl
+ u_t009_019/r1_w0_wl u_t009_019/r1_w1_wl u_t009_019/r1_r0_rwl u_t009_019/r1_r1_rwl
+ u_t009_019/r2_w0_wl u_t009_019/r2_w1_wl u_t009_019/r2_r0_rwl u_t009_019/r2_r1_rwl
+ u_t009_019/r3_w0_wl u_t009_019/r3_w1_wl u_t009_019/r3_r0_rwl u_t009_019/r3_r1_rwl
+ u_t009_019/VDD u_t009_031/VSS VSUBS detronyx_12t_2w2r_rc4_4x4_routed_5layer_direct
Xu_t009_008 u_t009_008/c0_w0_bl u_t009_008/c0_w0_br u_t009_008/c0_w1_bl u_t009_008/c0_w1_br
+ u_t009_008/c0_r0_rbl u_t009_008/c0_r1_rbl u_t009_008/c1_w0_bl u_t009_008/c1_w0_br
+ u_t009_008/c1_w1_bl u_t009_008/c1_w1_br u_t009_008/c1_r0_rbl u_t009_008/c1_r1_rbl
+ u_t009_008/c2_w0_bl u_t009_008/c2_w0_br u_t009_008/c2_w1_bl u_t009_008/c2_w1_br
+ u_t009_008/c2_r0_rbl u_t009_008/c2_r1_rbl u_t009_008/c3_w0_bl u_t009_008/c3_w0_br
+ u_t009_008/c3_w1_bl u_t009_008/c3_w1_br u_t009_008/c3_r0_rbl u_t009_008/c3_r1_rbl
+ u_t009_008/r0_w0_wl u_t009_008/r0_w1_wl u_t009_008/r0_r0_rwl u_t009_008/r0_r1_rwl
+ u_t009_008/r1_w0_wl u_t009_008/r1_w1_wl u_t009_008/r1_r0_rwl u_t009_008/r1_r1_rwl
+ u_t009_008/r2_w0_wl u_t009_008/r2_w1_wl u_t009_008/r2_r0_rwl u_t009_008/r2_r1_rwl
+ u_t009_008/r3_w0_wl u_t009_008/r3_w1_wl u_t009_008/r3_r0_rwl u_t009_008/r3_r1_rwl
+ VSS u_t009_031/VSS VSUBS detronyx_12t_2w2r_rc4_4x4_routed_5layer_direct
Xgf180mcu_as_sc_mcu7t3v3__inv_2_100 gf180mcu_as_sc_mcu7t3v3__inv_2_96/VDD gf180mcu_as_sc_mcu7t3v3__inv_2_96/VSS
+ gf180mcu_as_sc_mcu7t3v3__inv_2_100/Y VSS gf180mcu_as_sc_mcu7t3v3__inv_2_96/VNW VSUBS
+ gf180mcu_as_sc_mcu7t3v3__inv_2
Xgf180mcu_as_sc_mcu7t3v3__inv_2_144 gf180mcu_as_sc_mcu7t3v3__inv_2_146/VDD VSS VSS
+ VSS gf180mcu_as_sc_mcu7t3v3__inv_2_146/VNW VSUBS gf180mcu_as_sc_mcu7t3v3__inv_2
Xgf180mcu_as_sc_mcu7t3v3__inv_2_155 gf180mcu_as_sc_mcu7t3v3__inv_2_99/VDD gf180mcu_as_sc_mcu7t3v3__inv_2_99/VDD
+ VSS VSS gf180mcu_as_sc_mcu7t3v3__inv_2_155/VNW VSUBS gf180mcu_as_sc_mcu7t3v3__inv_2
Xgf180mcu_as_sc_mcu7t3v3__inv_2_133 gf180mcu_as_sc_mcu7t3v3__inv_2_134/VDD gf180mcu_as_sc_mcu7t3v3__inv_2_138/VDD
+ gf180mcu_as_sc_mcu7t3v3__inv_2_133/Y VSS gf180mcu_as_sc_mcu7t3v3__inv_2_134/VNW
+ VSUBS gf180mcu_as_sc_mcu7t3v3__inv_2
Xgf180mcu_as_sc_mcu7t3v3__inv_2_122 gf180mcu_as_sc_mcu7t3v3__inv_2_139/VSS gf180mcu_as_sc_mcu7t3v3__inv_2_126/VDD
+ gf180mcu_as_sc_mcu7t3v3__inv_2_122/Y VSS gf180mcu_as_sc_mcu7t3v3__inv_2_122/VNW
+ VSUBS gf180mcu_as_sc_mcu7t3v3__inv_2
Xgf180mcu_as_sc_mcu7t3v3__inv_2_111 gf180mcu_as_sc_mcu7t3v3__inv_2_371/VSS gf180mcu_as_sc_mcu7t3v3__inv_2_115/VDD
+ VSS VSS gf180mcu_as_sc_mcu7t3v3__inv_2_111/VNW VSUBS gf180mcu_as_sc_mcu7t3v3__inv_2
Xgf180mcu_as_sc_mcu7t3v3__inv_2_199 gf180mcu_as_sc_mcu7t3v3__inv_2_200/VDD VSS VSS
+ VSS gf180mcu_as_sc_mcu7t3v3__inv_2_200/VNW VSUBS gf180mcu_as_sc_mcu7t3v3__inv_2
Xgf180mcu_as_sc_mcu7t3v3__inv_2_177 gf180mcu_as_sc_mcu7t3v3__inv_2_177/VDD VSS gf180mcu_as_sc_mcu7t3v3__inv_2_177/Y
+ VSS gf180mcu_as_sc_mcu7t3v3__inv_2_177/VNW VSUBS gf180mcu_as_sc_mcu7t3v3__inv_2
Xgf180mcu_as_sc_mcu7t3v3__inv_2_188 gf180mcu_as_sc_mcu7t3v3__inv_2_188/VDD gf180mcu_as_sc_mcu7t3v3__inv_2_192/VDD
+ gf180mcu_as_sc_mcu7t3v3__inv_2_188/Y VSS gf180mcu_as_sc_mcu7t3v3__inv_2_188/VNW
+ VSUBS gf180mcu_as_sc_mcu7t3v3__inv_2
Xgf180mcu_as_sc_mcu7t3v3__inv_2_166 gf180mcu_as_sc_mcu7t3v3__inv_2_260/VSS gf180mcu_as_sc_mcu7t3v3__inv_2_205/VDD
+ VSS VSS gf180mcu_as_sc_mcu7t3v3__inv_2_174/VNW VSUBS gf180mcu_as_sc_mcu7t3v3__inv_2
Xu_t008_030 u_t008_030/c0_w0_bl u_t008_030/c0_w0_br u_t008_030/c0_w1_bl u_t008_030/c0_w1_br
+ u_t008_030/c0_r0_rbl u_t008_030/c0_r1_rbl u_t008_030/c1_w0_bl u_t008_030/c1_w0_br
+ u_t008_030/c1_w1_bl u_t008_030/c1_w1_br u_t008_030/c1_r0_rbl u_t008_030/c1_r1_rbl
+ u_t008_030/c2_w0_bl u_t008_030/c2_w0_br u_t008_030/c2_w1_bl u_t008_030/c2_w1_br
+ u_t008_030/c2_r0_rbl u_t008_030/c2_r1_rbl u_t008_030/c3_w0_bl u_t008_030/c3_w0_br
+ u_t008_030/c3_w1_bl u_t008_030/c3_w1_br u_t008_030/c3_r0_rbl u_t008_030/c3_r1_rbl
+ u_t008_030/r0_w0_wl u_t008_030/r0_w1_wl u_t008_030/r0_r0_rwl u_t008_030/r0_r1_rwl
+ u_t008_030/r1_w0_wl u_t008_030/r1_w1_wl u_t008_030/r1_r0_rwl u_t008_030/r1_r1_rwl
+ u_t008_030/r2_w0_wl u_t008_030/r2_w1_wl u_t008_030/r2_r0_rwl u_t008_030/r2_r1_rwl
+ u_t008_030/r3_w0_wl u_t008_030/r3_w1_wl u_t008_030/r3_r0_rwl u_t008_030/r3_r1_rwl
+ VSS u_t008_031/VSS VSUBS detronyx_12t_2w2r_rc4_4x4_routed_5layer_direct
Xu_t023_022 u_t023_022/c0_w0_bl u_t023_022/c0_w0_br u_t023_022/c0_w1_bl u_t023_022/c0_w1_br
+ u_t023_022/c0_r0_rbl u_t023_022/c0_r1_rbl u_t023_022/c1_w0_bl u_t023_022/c1_w0_br
+ u_t023_022/c1_w1_bl u_t023_022/c1_w1_br u_t023_022/c1_r0_rbl u_t023_022/c1_r1_rbl
+ u_t023_022/c2_w0_bl u_t023_022/c2_w0_br u_t023_022/c2_w1_bl u_t023_022/c2_w1_br
+ u_t023_022/c2_r0_rbl u_t023_022/c2_r1_rbl u_t023_022/c3_w0_bl u_t023_022/c3_w0_br
+ u_t023_022/c3_w1_bl u_t023_022/c3_w1_br u_t023_022/c3_r0_rbl u_t023_022/c3_r1_rbl
+ u_t023_022/r0_w0_wl u_t023_022/r0_w1_wl u_t023_022/r0_r0_rwl u_t023_022/r0_r1_rwl
+ u_t023_022/r1_w0_wl u_t023_022/r1_w1_wl u_t023_022/r1_r0_rwl u_t023_022/r1_r1_rwl
+ u_t023_022/r2_w0_wl u_t023_022/r2_w1_wl u_t023_022/r2_r0_rwl u_t023_022/r2_r1_rwl
+ u_t023_022/r3_w0_wl u_t023_022/r3_w1_wl u_t023_022/r3_r0_rwl u_t023_022/r3_r1_rwl
+ VSS u_t023_024/VSS VSUBS detronyx_12t_2w2r_rc4_4x4_routed_5layer_direct
Xu_t023_011 u_t023_011/c0_w0_bl u_t023_011/c0_w0_br u_t023_011/c0_w1_bl u_t023_011/c0_w1_br
+ u_t023_011/c0_r0_rbl u_t023_011/c0_r1_rbl u_t023_011/c1_w0_bl u_t023_011/c1_w0_br
+ u_t023_011/c1_w1_bl u_t023_011/c1_w1_br u_t023_011/c1_r0_rbl u_t023_011/c1_r1_rbl
+ u_t023_011/c2_w0_bl u_t023_011/c2_w0_br u_t023_011/c2_w1_bl u_t023_011/c2_w1_br
+ u_t023_011/c2_r0_rbl u_t023_011/c2_r1_rbl u_t023_011/c3_w0_bl u_t023_011/c3_w0_br
+ u_t023_011/c3_w1_bl u_t023_011/c3_w1_br u_t023_011/c3_r0_rbl u_t023_011/c3_r1_rbl
+ u_t023_011/r0_w0_wl u_t023_011/r0_w1_wl u_t023_011/r0_r0_rwl u_t023_011/r0_r1_rwl
+ u_t023_011/r1_w0_wl u_t023_011/r1_w1_wl u_t023_011/r1_r0_rwl u_t023_011/r1_r1_rwl
+ u_t023_011/r2_w0_wl u_t023_011/r2_w1_wl u_t023_011/r2_r0_rwl u_t023_011/r2_r1_rwl
+ u_t023_011/r3_w0_wl u_t023_011/r3_w1_wl u_t023_011/r3_r0_rwl u_t023_011/r3_r1_rwl
+ u_t023_011/VDD u_t023_011/VSS VSUBS detronyx_12t_2w2r_rc4_4x4_routed_5layer_direct
Xu_t023_000 u_t023_000/c0_w0_bl u_t023_000/c0_w0_br u_t023_000/c0_w1_bl u_t023_000/c0_w1_br
+ u_t023_000/c0_r0_rbl u_t023_000/c0_r1_rbl u_t023_000/c1_w0_bl u_t023_000/c1_w0_br
+ u_t023_000/c1_w1_bl u_t023_000/c1_w1_br u_t023_000/c1_r0_rbl u_t023_000/c1_r1_rbl
+ u_t023_000/c2_w0_bl u_t023_000/c2_w0_br u_t023_000/c2_w1_bl u_t023_000/c2_w1_br
+ u_t023_000/c2_r0_rbl u_t023_000/c2_r1_rbl u_t023_000/c3_w0_bl u_t023_000/c3_w0_br
+ u_t023_000/c3_w1_bl u_t023_000/c3_w1_br u_t023_000/c3_r0_rbl u_t023_000/c3_r1_rbl
+ u_t023_000/r0_w0_wl u_t023_000/r0_w1_wl u_t023_000/r0_r0_rwl u_t023_000/r0_r1_rwl
+ u_t023_000/r1_w0_wl u_t023_000/r1_w1_wl u_t023_000/r1_r0_rwl u_t023_000/r1_r1_rwl
+ u_t023_000/r2_w0_wl u_t023_000/r2_w1_wl u_t023_000/r2_r0_rwl u_t023_000/r2_r1_rwl
+ u_t023_000/r3_w0_wl u_t023_000/r3_w1_wl u_t023_000/r3_r0_rwl u_t023_000/r3_r1_rwl
+ VSS u_t023_002/VSS VSUBS detronyx_12t_2w2r_rc4_4x4_routed_5layer_direct
Xgf180mcu_as_sc_mcu7t3v3__nand2_2_12 gf180mcu_as_sc_mcu7t3v3__nor2_2_4/VDD gf180mcu_as_sc_mcu7t3v3__nor2_2_4/VSS
+ VSS VSS VSS gf180mcu_as_sc_mcu7t3v3__nor2_2_4/VNW VSUBS gf180mcu_as_sc_mcu7t3v3__nand2_2
Xgf180mcu_as_sc_mcu7t3v3__nand2_2_23 gf180mcu_as_sc_mcu7t3v3__nor2_2_6/VDD gf180mcu_as_sc_mcu7t3v3__nor2_2_6/VSS
+ VSS VSS VSS gf180mcu_as_sc_mcu7t3v3__nor2_2_6/VNW VSUBS gf180mcu_as_sc_mcu7t3v3__nand2_2
Xu_t014_022 u_t014_022/c0_w0_bl u_t014_022/c0_w0_br u_t014_022/c0_w1_bl u_t014_022/c0_w1_br
+ u_t014_022/c0_r0_rbl u_t014_022/c0_r1_rbl u_t014_022/c1_w0_bl u_t014_022/c1_w0_br
+ u_t014_022/c1_w1_bl u_t014_022/c1_w1_br u_t014_022/c1_r0_rbl u_t014_022/c1_r1_rbl
+ u_t014_022/c2_w0_bl u_t014_022/c2_w0_br u_t014_022/c2_w1_bl u_t014_022/c2_w1_br
+ u_t014_022/c2_r0_rbl u_t014_022/c2_r1_rbl u_t014_022/c3_w0_bl u_t014_022/c3_w0_br
+ u_t014_022/c3_w1_bl u_t014_022/c3_w1_br u_t014_022/c3_r0_rbl u_t014_022/c3_r1_rbl
+ u_t014_022/r0_w0_wl u_t014_022/r0_w1_wl u_t014_022/r0_r0_rwl u_t014_022/r0_r1_rwl
+ u_t014_022/r1_w0_wl u_t014_022/r1_w1_wl u_t014_022/r1_r0_rwl u_t014_022/r1_r1_rwl
+ u_t014_022/r2_w0_wl u_t014_022/r2_w1_wl u_t014_022/r2_r0_rwl u_t014_022/r2_r1_rwl
+ u_t014_022/r3_w0_wl u_t014_022/r3_w1_wl u_t014_022/r3_r0_rwl u_t014_022/r3_r1_rwl
+ VSS u_t014_024/VSS VSUBS detronyx_12t_2w2r_rc4_4x4_routed_5layer_direct
Xu_t014_011 u_t014_011/c0_w0_bl u_t014_011/c0_w0_br u_t014_011/c0_w1_bl u_t014_011/c0_w1_br
+ u_t014_011/c0_r0_rbl u_t014_011/c0_r1_rbl u_t014_011/c1_w0_bl u_t014_011/c1_w0_br
+ u_t014_011/c1_w1_bl u_t014_011/c1_w1_br u_t014_011/c1_r0_rbl u_t014_011/c1_r1_rbl
+ u_t014_011/c2_w0_bl u_t014_011/c2_w0_br u_t014_011/c2_w1_bl u_t014_011/c2_w1_br
+ u_t014_011/c2_r0_rbl u_t014_011/c2_r1_rbl u_t014_011/c3_w0_bl u_t014_011/c3_w0_br
+ u_t014_011/c3_w1_bl u_t014_011/c3_w1_br u_t014_011/c3_r0_rbl u_t014_011/c3_r1_rbl
+ u_t014_011/r0_w0_wl u_t014_011/r0_w1_wl u_t014_011/r0_r0_rwl u_t014_011/r0_r1_rwl
+ u_t014_011/r1_w0_wl u_t014_011/r1_w1_wl u_t014_011/r1_r0_rwl u_t014_011/r1_r1_rwl
+ u_t014_011/r2_w0_wl u_t014_011/r2_w1_wl u_t014_011/r2_r0_rwl u_t014_011/r2_r1_rwl
+ u_t014_011/r3_w0_wl u_t014_011/r3_w1_wl u_t014_011/r3_r0_rwl u_t014_011/r3_r1_rwl
+ u_t014_011/VDD u_t014_011/VSS VSUBS detronyx_12t_2w2r_rc4_4x4_routed_5layer_direct
Xu_t014_000 u_t014_000/c0_w0_bl u_t014_000/c0_w0_br u_t014_000/c0_w1_bl u_t014_000/c0_w1_br
+ u_t014_000/c0_r0_rbl u_t014_000/c0_r1_rbl u_t014_000/c1_w0_bl u_t014_000/c1_w0_br
+ u_t014_000/c1_w1_bl u_t014_000/c1_w1_br u_t014_000/c1_r0_rbl u_t014_000/c1_r1_rbl
+ u_t014_000/c2_w0_bl u_t014_000/c2_w0_br u_t014_000/c2_w1_bl u_t014_000/c2_w1_br
+ u_t014_000/c2_r0_rbl u_t014_000/c2_r1_rbl u_t014_000/c3_w0_bl u_t014_000/c3_w0_br
+ u_t014_000/c3_w1_bl u_t014_000/c3_w1_br u_t014_000/c3_r0_rbl u_t014_000/c3_r1_rbl
+ u_t014_000/r0_w0_wl u_t014_000/r0_w1_wl u_t014_000/r0_r0_rwl u_t014_000/r0_r1_rwl
+ u_t014_000/r1_w0_wl u_t014_000/r1_w1_wl u_t014_000/r1_r0_rwl u_t014_000/r1_r1_rwl
+ u_t014_000/r2_w0_wl u_t014_000/r2_w1_wl u_t014_000/r2_r0_rwl u_t014_000/r2_r1_rwl
+ u_t014_000/r3_w0_wl u_t014_000/r3_w1_wl u_t014_000/r3_r0_rwl u_t014_000/r3_r1_rwl
+ VSS u_t014_002/VSS VSUBS detronyx_12t_2w2r_rc4_4x4_routed_5layer_direct
Xgf180mcu_as_sc_mcu7t3v3__nand2_2_56 gf180mcu_as_sc_mcu7t3v3__nor2_2_8/VDD gf180mcu_as_sc_mcu7t3v3__nand3_2_32/VSS
+ VSS VSS VSS gf180mcu_as_sc_mcu7t3v3__nor2_2_8/VNW VSUBS gf180mcu_as_sc_mcu7t3v3__nand2_2
Xgf180mcu_as_sc_mcu7t3v3__nand2_2_45 gf180mcu_as_sc_mcu7t3v3__nand3_2_31/VDD gf180mcu_as_sc_mcu7t3v3__nor2_2_8/VSS
+ VSS VSS VSS gf180mcu_as_sc_mcu7t3v3__nand3_2_31/VNW VSUBS gf180mcu_as_sc_mcu7t3v3__nand2_2
Xgf180mcu_as_sc_mcu7t3v3__nand2_2_34 gf180mcu_as_sc_mcu7t3v3__nor2_2_5/VDD gf180mcu_as_sc_mcu7t3v3__nand3_2_8/VSS
+ VSS VSS VSS gf180mcu_as_sc_mcu7t3v3__nor2_2_5/VNW VSUBS gf180mcu_as_sc_mcu7t3v3__nand2_2
Xu_t005_022 u_t005_022/c0_w0_bl u_t005_022/c0_w0_br u_t005_022/c0_w1_bl u_t005_022/c0_w1_br
+ u_t005_022/c0_r0_rbl u_t005_022/c0_r1_rbl u_t005_022/c1_w0_bl u_t005_022/c1_w0_br
+ u_t005_022/c1_w1_bl u_t005_022/c1_w1_br u_t005_022/c1_r0_rbl u_t005_022/c1_r1_rbl
+ u_t005_022/c2_w0_bl u_t005_022/c2_w0_br u_t005_022/c2_w1_bl u_t005_022/c2_w1_br
+ u_t005_022/c2_r0_rbl u_t005_022/c2_r1_rbl u_t005_022/c3_w0_bl u_t005_022/c3_w0_br
+ u_t005_022/c3_w1_bl u_t005_022/c3_w1_br u_t005_022/c3_r0_rbl u_t005_022/c3_r1_rbl
+ u_t005_022/r0_w0_wl u_t005_022/r0_w1_wl u_t005_022/r0_r0_rwl u_t005_022/r0_r1_rwl
+ u_t005_022/r1_w0_wl u_t005_022/r1_w1_wl u_t005_022/r1_r0_rwl u_t005_022/r1_r1_rwl
+ u_t005_022/r2_w0_wl u_t005_022/r2_w1_wl u_t005_022/r2_r0_rwl u_t005_022/r2_r1_rwl
+ u_t005_022/r3_w0_wl u_t005_022/r3_w1_wl u_t005_022/r3_r0_rwl u_t005_022/r3_r1_rwl
+ VSS u_t005_031/VSS VSUBS detronyx_12t_2w2r_rc4_4x4_routed_5layer_direct
Xu_t005_011 u_t005_011/c0_w0_bl u_t005_011/c0_w0_br u_t005_011/c0_w1_bl u_t005_011/c0_w1_br
+ u_t005_011/c0_r0_rbl u_t005_011/c0_r1_rbl u_t005_011/c1_w0_bl u_t005_011/c1_w0_br
+ u_t005_011/c1_w1_bl u_t005_011/c1_w1_br u_t005_011/c1_r0_rbl u_t005_011/c1_r1_rbl
+ u_t005_011/c2_w0_bl u_t005_011/c2_w0_br u_t005_011/c2_w1_bl u_t005_011/c2_w1_br
+ u_t005_011/c2_r0_rbl u_t005_011/c2_r1_rbl u_t005_011/c3_w0_bl u_t005_011/c3_w0_br
+ u_t005_011/c3_w1_bl u_t005_011/c3_w1_br u_t005_011/c3_r0_rbl u_t005_011/c3_r1_rbl
+ u_t005_011/r0_w0_wl u_t005_011/r0_w1_wl u_t005_011/r0_r0_rwl u_t005_011/r0_r1_rwl
+ u_t005_011/r1_w0_wl u_t005_011/r1_w1_wl u_t005_011/r1_r0_rwl u_t005_011/r1_r1_rwl
+ u_t005_011/r2_w0_wl u_t005_011/r2_w1_wl u_t005_011/r2_r0_rwl u_t005_011/r2_r1_rwl
+ u_t005_011/r3_w0_wl u_t005_011/r3_w1_wl u_t005_011/r3_r0_rwl u_t005_011/r3_r1_rwl
+ u_t005_011/VDD u_t005_031/VSS VSUBS detronyx_12t_2w2r_rc4_4x4_routed_5layer_direct
Xu_t005_000 u_t005_000/c0_w0_bl u_t005_000/c0_w0_br u_t005_000/c0_w1_bl u_t005_000/c0_w1_br
+ u_t005_000/c0_r0_rbl u_t005_000/c0_r1_rbl u_t005_000/c1_w0_bl u_t005_000/c1_w0_br
+ u_t005_000/c1_w1_bl u_t005_000/c1_w1_br u_t005_000/c1_r0_rbl u_t005_000/c1_r1_rbl
+ u_t005_000/c2_w0_bl u_t005_000/c2_w0_br u_t005_000/c2_w1_bl u_t005_000/c2_w1_br
+ u_t005_000/c2_r0_rbl u_t005_000/c2_r1_rbl u_t005_000/c3_w0_bl u_t005_000/c3_w0_br
+ u_t005_000/c3_w1_bl u_t005_000/c3_w1_br u_t005_000/c3_r0_rbl u_t005_000/c3_r1_rbl
+ u_t005_000/r0_w0_wl u_t005_000/r0_w1_wl u_t005_000/r0_r0_rwl u_t005_000/r0_r1_rwl
+ u_t005_000/r1_w0_wl u_t005_000/r1_w1_wl u_t005_000/r1_r0_rwl u_t005_000/r1_r1_rwl
+ u_t005_000/r2_w0_wl u_t005_000/r2_w1_wl u_t005_000/r2_r0_rwl u_t005_000/r2_r1_rwl
+ u_t005_000/r3_w0_wl u_t005_000/r3_w1_wl u_t005_000/r3_r0_rwl u_t005_000/r3_r1_rwl
+ VSS u_t005_031/VSS VSUBS detronyx_12t_2w2r_rc4_4x4_routed_5layer_direct
Xu_t020_025 u_t020_025/c0_w0_bl u_t020_025/c0_w0_br u_t020_025/c0_w1_bl u_t020_025/c0_w1_br
+ u_t020_025/c0_r0_rbl u_t020_025/c0_r1_rbl u_t020_025/c1_w0_bl u_t020_025/c1_w0_br
+ u_t020_025/c1_w1_bl u_t020_025/c1_w1_br u_t020_025/c1_r0_rbl u_t020_025/c1_r1_rbl
+ u_t020_025/c2_w0_bl u_t020_025/c2_w0_br u_t020_025/c2_w1_bl u_t020_025/c2_w1_br
+ u_t020_025/c2_r0_rbl u_t020_025/c2_r1_rbl u_t020_025/c3_w0_bl u_t020_025/c3_w0_br
+ u_t020_025/c3_w1_bl u_t020_025/c3_w1_br u_t020_025/c3_r0_rbl u_t020_025/c3_r1_rbl
+ u_t020_025/r0_w0_wl u_t020_025/r0_w1_wl u_t020_025/r0_r0_rwl u_t020_025/r0_r1_rwl
+ u_t020_025/r1_w0_wl u_t020_025/r1_w1_wl u_t020_025/r1_r0_rwl u_t020_025/r1_r1_rwl
+ u_t020_025/r2_w0_wl u_t020_025/r2_w1_wl u_t020_025/r2_r0_rwl u_t020_025/r2_r1_rwl
+ u_t020_025/r3_w0_wl u_t020_025/r3_w1_wl u_t020_025/r3_r0_rwl u_t020_025/r3_r1_rwl
+ VSS u_t020_025/VSS VSUBS detronyx_12t_2w2r_rc4_4x4_routed_5layer_direct
Xu_t020_014 u_t020_014/c0_w0_bl u_t020_014/c0_w0_br u_t020_014/c0_w1_bl u_t020_014/c0_w1_br
+ u_t020_014/c0_r0_rbl u_t020_014/c0_r1_rbl u_t020_014/c1_w0_bl u_t020_014/c1_w0_br
+ u_t020_014/c1_w1_bl u_t020_014/c1_w1_br u_t020_014/c1_r0_rbl u_t020_014/c1_r1_rbl
+ u_t020_014/c2_w0_bl u_t020_014/c2_w0_br u_t020_014/c2_w1_bl u_t020_014/c2_w1_br
+ u_t020_014/c2_r0_rbl u_t020_014/c2_r1_rbl u_t020_014/c3_w0_bl u_t020_014/c3_w0_br
+ u_t020_014/c3_w1_bl u_t020_014/c3_w1_br u_t020_014/c3_r0_rbl u_t020_014/c3_r1_rbl
+ u_t020_014/r0_w0_wl u_t020_014/r0_w1_wl u_t020_014/r0_r0_rwl u_t020_014/r0_r1_rwl
+ u_t020_014/r1_w0_wl u_t020_014/r1_w1_wl u_t020_014/r1_r0_rwl u_t020_014/r1_r1_rwl
+ u_t020_014/r2_w0_wl u_t020_014/r2_w1_wl u_t020_014/r2_r0_rwl u_t020_014/r2_r1_rwl
+ u_t020_014/r3_w0_wl u_t020_014/r3_w1_wl u_t020_014/r3_r0_rwl u_t020_014/r3_r1_rwl
+ u_t020_014/VDD u_t020_017/VSS VSUBS detronyx_12t_2w2r_rc4_4x4_routed_5layer_direct
Xu_t020_003 u_t020_003/c0_w0_bl u_t020_003/c0_w0_br u_t020_003/c0_w1_bl u_t020_003/c0_w1_br
+ u_t020_003/c0_r0_rbl u_t020_003/c0_r1_rbl u_t020_003/c1_w0_bl u_t020_003/c1_w0_br
+ u_t020_003/c1_w1_bl u_t020_003/c1_w1_br u_t020_003/c1_r0_rbl u_t020_003/c1_r1_rbl
+ u_t020_003/c2_w0_bl u_t020_003/c2_w0_br u_t020_003/c2_w1_bl u_t020_003/c2_w1_br
+ u_t020_003/c2_r0_rbl u_t020_003/c2_r1_rbl u_t020_003/c3_w0_bl u_t020_003/c3_w0_br
+ u_t020_003/c3_w1_bl u_t020_003/c3_w1_br u_t020_003/c3_r0_rbl u_t020_003/c3_r1_rbl
+ u_t020_003/r0_w0_wl u_t020_003/r0_w1_wl u_t020_003/r0_r0_rwl u_t020_003/r0_r1_rwl
+ u_t020_003/r1_w0_wl u_t020_003/r1_w1_wl u_t020_003/r1_r0_rwl u_t020_003/r1_r1_rwl
+ u_t020_003/r2_w0_wl u_t020_003/r2_w1_wl u_t020_003/r2_r0_rwl u_t020_003/r2_r1_rwl
+ u_t020_003/r3_w0_wl u_t020_003/r3_w1_wl u_t020_003/r3_r0_rwl u_t020_003/r3_r1_rwl
+ u_t020_003/VDD u_t020_003/VSS VSUBS detronyx_12t_2w2r_rc4_4x4_routed_5layer_direct
Xgf180mcu_as_sc_mcu7t3v3__inv_2_1418 gf180mcu_as_sc_mcu7t3v3__inv_2_1420/VDD VSS VSS
+ VSS gf180mcu_as_sc_mcu7t3v3__inv_2_1420/VNW VSUBS gf180mcu_as_sc_mcu7t3v3__inv_2
Xgf180mcu_as_sc_mcu7t3v3__inv_2_1407 VSS VSS VSS VSS gf180mcu_as_sc_mcu7t3v3__inv_2_1408/VNW
+ VSUBS gf180mcu_as_sc_mcu7t3v3__inv_2
Xgf180mcu_as_sc_mcu7t3v3__inv_2_1429 gf180mcu_as_sc_mcu7t3v3__inv_2_1502/VSS VSS gf180mcu_as_sc_mcu7t3v3__inv_2_1429/Y
+ VSS gf180mcu_as_sc_mcu7t3v3__inv_2_1429/VNW VSUBS gf180mcu_as_sc_mcu7t3v3__inv_2
Xu_t011_014 u_t011_014/c0_w0_bl u_t011_014/c0_w0_br u_t011_014/c0_w1_bl u_t011_014/c0_w1_br
+ u_t011_014/c0_r0_rbl u_t011_014/c0_r1_rbl u_t011_014/c1_w0_bl u_t011_014/c1_w0_br
+ u_t011_014/c1_w1_bl u_t011_014/c1_w1_br u_t011_014/c1_r0_rbl u_t011_014/c1_r1_rbl
+ u_t011_014/c2_w0_bl u_t011_014/c2_w0_br u_t011_014/c2_w1_bl u_t011_014/c2_w1_br
+ u_t011_014/c2_r0_rbl u_t011_014/c2_r1_rbl u_t011_014/c3_w0_bl u_t011_014/c3_w0_br
+ u_t011_014/c3_w1_bl u_t011_014/c3_w1_br u_t011_014/c3_r0_rbl u_t011_014/c3_r1_rbl
+ u_t011_014/r0_w0_wl u_t011_014/r0_w1_wl u_t011_014/r0_r0_rwl u_t011_014/r0_r1_rwl
+ u_t011_014/r1_w0_wl u_t011_014/r1_w1_wl u_t011_014/r1_r0_rwl u_t011_014/r1_r1_rwl
+ u_t011_014/r2_w0_wl u_t011_014/r2_w1_wl u_t011_014/r2_r0_rwl u_t011_014/r2_r1_rwl
+ u_t011_014/r3_w0_wl u_t011_014/r3_w1_wl u_t011_014/r3_r0_rwl u_t011_014/r3_r1_rwl
+ u_t011_014/VDD u_t011_017/VSS VSUBS detronyx_12t_2w2r_rc4_4x4_routed_5layer_direct
Xu_t011_003 u_t011_003/c0_w0_bl u_t011_003/c0_w0_br u_t011_003/c0_w1_bl u_t011_003/c0_w1_br
+ u_t011_003/c0_r0_rbl u_t011_003/c0_r1_rbl u_t011_003/c1_w0_bl u_t011_003/c1_w0_br
+ u_t011_003/c1_w1_bl u_t011_003/c1_w1_br u_t011_003/c1_r0_rbl u_t011_003/c1_r1_rbl
+ u_t011_003/c2_w0_bl u_t011_003/c2_w0_br u_t011_003/c2_w1_bl u_t011_003/c2_w1_br
+ u_t011_003/c2_r0_rbl u_t011_003/c2_r1_rbl u_t011_003/c3_w0_bl u_t011_003/c3_w0_br
+ u_t011_003/c3_w1_bl u_t011_003/c3_w1_br u_t011_003/c3_r0_rbl u_t011_003/c3_r1_rbl
+ u_t011_003/r0_w0_wl u_t011_003/r0_w1_wl u_t011_003/r0_r0_rwl u_t011_003/r0_r1_rwl
+ u_t011_003/r1_w0_wl u_t011_003/r1_w1_wl u_t011_003/r1_r0_rwl u_t011_003/r1_r1_rwl
+ u_t011_003/r2_w0_wl u_t011_003/r2_w1_wl u_t011_003/r2_r0_rwl u_t011_003/r2_r1_rwl
+ u_t011_003/r3_w0_wl u_t011_003/r3_w1_wl u_t011_003/r3_r0_rwl u_t011_003/r3_r1_rwl
+ u_t011_003/VDD u_t011_003/VSS VSUBS detronyx_12t_2w2r_rc4_4x4_routed_5layer_direct
Xu_t011_025 u_t011_025/c0_w0_bl u_t011_025/c0_w0_br u_t011_025/c0_w1_bl u_t011_025/c0_w1_br
+ u_t011_025/c0_r0_rbl u_t011_025/c0_r1_rbl u_t011_025/c1_w0_bl u_t011_025/c1_w0_br
+ u_t011_025/c1_w1_bl u_t011_025/c1_w1_br u_t011_025/c1_r0_rbl u_t011_025/c1_r1_rbl
+ u_t011_025/c2_w0_bl u_t011_025/c2_w0_br u_t011_025/c2_w1_bl u_t011_025/c2_w1_br
+ u_t011_025/c2_r0_rbl u_t011_025/c2_r1_rbl u_t011_025/c3_w0_bl u_t011_025/c3_w0_br
+ u_t011_025/c3_w1_bl u_t011_025/c3_w1_br u_t011_025/c3_r0_rbl u_t011_025/c3_r1_rbl
+ u_t011_025/r0_w0_wl u_t011_025/r0_w1_wl u_t011_025/r0_r0_rwl u_t011_025/r0_r1_rwl
+ u_t011_025/r1_w0_wl u_t011_025/r1_w1_wl u_t011_025/r1_r0_rwl u_t011_025/r1_r1_rwl
+ u_t011_025/r2_w0_wl u_t011_025/r2_w1_wl u_t011_025/r2_r0_rwl u_t011_025/r2_r1_rwl
+ u_t011_025/r3_w0_wl u_t011_025/r3_w1_wl u_t011_025/r3_r0_rwl u_t011_025/r3_r1_rwl
+ VSS u_t011_025/VSS VSUBS detronyx_12t_2w2r_rc4_4x4_routed_5layer_direct
Xu_t002_025 u_t002_025/c0_w0_bl u_t002_025/c0_w0_br u_t002_025/c0_w1_bl u_t002_025/c0_w1_br
+ u_t002_025/c0_r0_rbl u_t002_025/c0_r1_rbl u_t002_025/c1_w0_bl u_t002_025/c1_w0_br
+ u_t002_025/c1_w1_bl u_t002_025/c1_w1_br u_t002_025/c1_r0_rbl u_t002_025/c1_r1_rbl
+ u_t002_025/c2_w0_bl u_t002_025/c2_w0_br u_t002_025/c2_w1_bl u_t002_025/c2_w1_br
+ u_t002_025/c2_r0_rbl u_t002_025/c2_r1_rbl u_t002_025/c3_w0_bl u_t002_025/c3_w0_br
+ u_t002_025/c3_w1_bl u_t002_025/c3_w1_br u_t002_025/c3_r0_rbl u_t002_025/c3_r1_rbl
+ u_t002_025/r0_w0_wl u_t002_025/r0_w1_wl u_t002_025/r0_r0_rwl u_t002_025/r0_r1_rwl
+ u_t002_025/r1_w0_wl u_t002_025/r1_w1_wl u_t002_025/r1_r0_rwl u_t002_025/r1_r1_rwl
+ u_t002_025/r2_w0_wl u_t002_025/r2_w1_wl u_t002_025/r2_r0_rwl u_t002_025/r2_r1_rwl
+ u_t002_025/r3_w0_wl u_t002_025/r3_w1_wl u_t002_025/r3_r0_rwl u_t002_025/r3_r1_rwl
+ VSS u_t002_025/VSS VSUBS detronyx_12t_2w2r_rc4_4x4_routed_5layer_direct
Xu_t002_014 u_t002_014/c0_w0_bl u_t002_014/c0_w0_br u_t002_014/c0_w1_bl u_t002_014/c0_w1_br
+ u_t002_014/c0_r0_rbl u_t002_014/c0_r1_rbl u_t002_014/c1_w0_bl u_t002_014/c1_w0_br
+ u_t002_014/c1_w1_bl u_t002_014/c1_w1_br u_t002_014/c1_r0_rbl u_t002_014/c1_r1_rbl
+ u_t002_014/c2_w0_bl u_t002_014/c2_w0_br u_t002_014/c2_w1_bl u_t002_014/c2_w1_br
+ u_t002_014/c2_r0_rbl u_t002_014/c2_r1_rbl u_t002_014/c3_w0_bl u_t002_014/c3_w0_br
+ u_t002_014/c3_w1_bl u_t002_014/c3_w1_br u_t002_014/c3_r0_rbl u_t002_014/c3_r1_rbl
+ u_t002_014/r0_w0_wl u_t002_014/r0_w1_wl u_t002_014/r0_r0_rwl u_t002_014/r0_r1_rwl
+ u_t002_014/r1_w0_wl u_t002_014/r1_w1_wl u_t002_014/r1_r0_rwl u_t002_014/r1_r1_rwl
+ u_t002_014/r2_w0_wl u_t002_014/r2_w1_wl u_t002_014/r2_r0_rwl u_t002_014/r2_r1_rwl
+ u_t002_014/r3_w0_wl u_t002_014/r3_w1_wl u_t002_014/r3_r0_rwl u_t002_014/r3_r1_rwl
+ u_t002_014/VDD u_t002_017/VSS VSUBS detronyx_12t_2w2r_rc4_4x4_routed_5layer_direct
Xu_t002_003 u_t002_003/c0_w0_bl u_t002_003/c0_w0_br u_t002_003/c0_w1_bl u_t002_003/c0_w1_br
+ u_t002_003/c0_r0_rbl u_t002_003/c0_r1_rbl u_t002_003/c1_w0_bl u_t002_003/c1_w0_br
+ u_t002_003/c1_w1_bl u_t002_003/c1_w1_br u_t002_003/c1_r0_rbl u_t002_003/c1_r1_rbl
+ u_t002_003/c2_w0_bl u_t002_003/c2_w0_br u_t002_003/c2_w1_bl u_t002_003/c2_w1_br
+ u_t002_003/c2_r0_rbl u_t002_003/c2_r1_rbl u_t002_003/c3_w0_bl u_t002_003/c3_w0_br
+ u_t002_003/c3_w1_bl u_t002_003/c3_w1_br u_t002_003/c3_r0_rbl u_t002_003/c3_r1_rbl
+ u_t002_003/r0_w0_wl u_t002_003/r0_w1_wl u_t002_003/r0_r0_rwl u_t002_003/r0_r1_rwl
+ u_t002_003/r1_w0_wl u_t002_003/r1_w1_wl u_t002_003/r1_r0_rwl u_t002_003/r1_r1_rwl
+ u_t002_003/r2_w0_wl u_t002_003/r2_w1_wl u_t002_003/r2_r0_rwl u_t002_003/r2_r1_rwl
+ u_t002_003/r3_w0_wl u_t002_003/r3_w1_wl u_t002_003/r3_r0_rwl u_t002_003/r3_r1_rwl
+ u_t002_003/VDD u_t002_003/VSS VSUBS detronyx_12t_2w2r_rc4_4x4_routed_5layer_direct
Xgf180mcu_as_sc_mcu7t3v3__inv_2_1248 gf180mcu_as_sc_mcu7t3v3__nor2_2_8/VDD gf180mcu_as_sc_mcu7t3v3__nor2_2_8/VSS
+ VSS VSS gf180mcu_as_sc_mcu7t3v3__nor2_2_8/VNW VSUBS gf180mcu_as_sc_mcu7t3v3__inv_2
Xgf180mcu_as_sc_mcu7t3v3__inv_2_1259 gf180mcu_as_sc_mcu7t3v3__nor2_2_8/VDD gf180mcu_as_sc_mcu7t3v3__nor2_2_8/VSS
+ VSS VSS gf180mcu_as_sc_mcu7t3v3__nor2_2_8/VNW VSUBS gf180mcu_as_sc_mcu7t3v3__inv_2
Xgf180mcu_as_sc_mcu7t3v3__inv_2_1215 gf180mcu_as_sc_mcu7t3v3__nor2_2_8/VDD gf180mcu_as_sc_mcu7t3v3__nor2_2_8/VSS
+ VSS VSS gf180mcu_as_sc_mcu7t3v3__nor2_2_8/VNW VSUBS gf180mcu_as_sc_mcu7t3v3__inv_2
Xgf180mcu_as_sc_mcu7t3v3__inv_2_1204 gf180mcu_as_sc_mcu7t3v3__nand3_2_31/VDD gf180mcu_as_sc_mcu7t3v3__nor2_2_8/VSS
+ VSS VSS gf180mcu_as_sc_mcu7t3v3__nand3_2_31/VNW VSUBS gf180mcu_as_sc_mcu7t3v3__inv_2
Xgf180mcu_as_sc_mcu7t3v3__inv_2_1226 VSS VSS VSS VSS gf180mcu_as_sc_mcu7t3v3__inv_2_1285/VNW
+ VSUBS gf180mcu_as_sc_mcu7t3v3__inv_2
Xgf180mcu_as_sc_mcu7t3v3__inv_2_1237 VSS VSS gf180mcu_as_sc_mcu7t3v3__inv_2_1237/Y
+ VSS gf180mcu_as_sc_mcu7t3v3__inv_2_1237/VNW VSUBS gf180mcu_as_sc_mcu7t3v3__inv_2
Xgf180mcu_as_sc_mcu7t3v3__nand4_2_510 gf180mcu_as_sc_mcu7t3v3__inv_2_1691/VDD VSS
+ VSS VSS VSS VSS VSS gf180mcu_as_sc_mcu7t3v3__inv_2_1691/VNW VSUBS gf180mcu_as_sc_mcu7t3v3__nand4_2
Xgf180mcu_as_sc_mcu7t3v3__inv_2_86 gf180mcu_as_sc_mcu7t3v3__inv_2_88/VSS gf180mcu_as_sc_mcu7t3v3__inv_2_91/VDD
+ gf180mcu_as_sc_mcu7t3v3__inv_2_86/Y VSS gf180mcu_as_sc_mcu7t3v3__inv_2_87/VNW VSUBS
+ gf180mcu_as_sc_mcu7t3v3__inv_2
Xgf180mcu_as_sc_mcu7t3v3__inv_2_53 gf180mcu_as_sc_mcu7t3v3__inv_2_8/VSS VSS gf180mcu_as_sc_mcu7t3v3__inv_2_8/A
+ VSS gf180mcu_as_sc_mcu7t3v3__inv_2_53/VNW VSUBS gf180mcu_as_sc_mcu7t3v3__inv_2
Xgf180mcu_as_sc_mcu7t3v3__inv_2_31 VSS gf180mcu_as_sc_mcu7t3v3__inv_2_61/VDD gf180mcu_as_sc_mcu7t3v3__inv_2_77/Y
+ gf180mcu_as_sc_mcu7t3v3__inv_2_77/Y gf180mcu_as_sc_mcu7t3v3__inv_2_60/VNW VSUBS
+ gf180mcu_as_sc_mcu7t3v3__inv_2
Xgf180mcu_as_sc_mcu7t3v3__inv_2_75 gf180mcu_as_sc_mcu7t3v3__inv_2_75/VDD VSS gf180mcu_as_sc_mcu7t3v3__inv_2_77/Y
+ VSS gf180mcu_as_sc_mcu7t3v3__inv_2_75/VNW VSUBS gf180mcu_as_sc_mcu7t3v3__inv_2
Xgf180mcu_as_sc_mcu7t3v3__inv_2_42 gf180mcu_as_sc_mcu7t3v3__inv_2_73/VDD gf180mcu_as_sc_mcu7t3v3__inv_2_74/VDD
+ VSS gf180mcu_as_sc_mcu7t3v3__inv_2_77/Y gf180mcu_as_sc_mcu7t3v3__inv_2_73/VNW VSUBS
+ gf180mcu_as_sc_mcu7t3v3__inv_2
Xgf180mcu_as_sc_mcu7t3v3__inv_2_64 gf180mcu_as_sc_mcu7t3v3__inv_2_70/VDD gf180mcu_as_sc_mcu7t3v3__inv_2_70/VDD
+ gf180mcu_as_sc_mcu7t3v3__inv_2_71/Y VSS gf180mcu_as_sc_mcu7t3v3__inv_2_64/VNW VSUBS
+ gf180mcu_as_sc_mcu7t3v3__inv_2
Xgf180mcu_as_sc_mcu7t3v3__inv_2_20 gf180mcu_as_sc_mcu7t3v3__inv_2_66/VSS gf180mcu_as_sc_mcu7t3v3__inv_2_70/VDD
+ VSS gf180mcu_as_sc_mcu7t3v3__inv_2_66/Y gf180mcu_as_sc_mcu7t3v3__inv_2_63/VNW VSUBS
+ gf180mcu_as_sc_mcu7t3v3__inv_2
Xgf180mcu_as_sc_mcu7t3v3__inv_2_1001 VSS gf180mcu_as_sc_mcu7t3v3__inv_2_967/VDD gf180mcu_as_sc_mcu7t3v3__inv_2_1001/Y
+ gf180mcu_as_sc_mcu7t3v3__inv_2_1002/Y gf180mcu_as_sc_mcu7t3v3__inv_2_1002/VNW VSUBS
+ gf180mcu_as_sc_mcu7t3v3__inv_2
Xgf180mcu_as_sc_mcu7t3v3__inv_2_1078 gf180mcu_as_sc_mcu7t3v3__inv_2_1080/VDD gf180mcu_as_sc_mcu7t3v3__inv_2_1084/VDD
+ VSS gf180mcu_as_sc_mcu7t3v3__inv_2_1144/A gf180mcu_as_sc_mcu7t3v3__inv_2_1080/VNW
+ VSUBS gf180mcu_as_sc_mcu7t3v3__inv_2
Xgf180mcu_as_sc_mcu7t3v3__inv_2_1089 VSS gf180mcu_as_sc_mcu7t3v3__inv_2_1089/VSS gf180mcu_as_sc_mcu7t3v3__inv_2_1089/Y
+ VSS gf180mcu_as_sc_mcu7t3v3__inv_2_1089/VNW VSUBS gf180mcu_as_sc_mcu7t3v3__inv_2
Xgf180mcu_as_sc_mcu7t3v3__inv_2_1067 gf180mcu_as_sc_mcu7t3v3__inv_2_1089/VSS gf180mcu_as_sc_mcu7t3v3__inv_2_1295/VDD
+ gf180mcu_as_sc_mcu7t3v3__inv_2_1067/Y gf180mcu_as_sc_mcu7t3v3__inv_2_1068/Y gf180mcu_as_sc_mcu7t3v3__inv_2_1068/VNW
+ VSUBS gf180mcu_as_sc_mcu7t3v3__inv_2
Xgf180mcu_as_sc_mcu7t3v3__inv_2_1012 gf180mcu_as_sc_mcu7t3v3__inv_2_1016/VDD VSS gf180mcu_as_sc_mcu7t3v3__inv_2_1294/Y
+ gf180mcu_as_sc_mcu7t3v3__inv_2_1016/Y gf180mcu_as_sc_mcu7t3v3__inv_2_1016/VNW VSUBS
+ gf180mcu_as_sc_mcu7t3v3__inv_2
Xgf180mcu_as_sc_mcu7t3v3__inv_2_1023 VSS gf180mcu_as_sc_mcu7t3v3__inv_2_1053/VDD gf180mcu_as_sc_mcu7t3v3__inv_2_1023/Y
+ VSS gf180mcu_as_sc_mcu7t3v3__inv_2_1039/VNW VSUBS gf180mcu_as_sc_mcu7t3v3__inv_2
Xgf180mcu_as_sc_mcu7t3v3__inv_2_97 gf180mcu_as_sc_mcu7t3v3__inv_2_99/VDD gf180mcu_as_sc_mcu7t3v3__inv_2_99/VSS
+ VSS VSS gf180mcu_as_sc_mcu7t3v3__inv_2_99/VNW VSUBS gf180mcu_as_sc_mcu7t3v3__inv_2
Xgf180mcu_as_sc_mcu7t3v3__inv_2_1056 gf180mcu_as_sc_mcu7t3v3__inv_2_1056/VDD gf180mcu_as_sc_mcu7t3v3__inv_2_994/VDD
+ gf180mcu_as_sc_mcu7t3v3__inv_2_1056/Y VSS gf180mcu_as_sc_mcu7t3v3__inv_2_1056/VNW
+ VSUBS gf180mcu_as_sc_mcu7t3v3__inv_2
Xgf180mcu_as_sc_mcu7t3v3__inv_2_1045 gf180mcu_as_sc_mcu7t3v3__inv_2_1046/VDD VSS gf180mcu_as_sc_mcu7t3v3__inv_2_992/A
+ gf180mcu_as_sc_mcu7t3v3__inv_2_1046/Y gf180mcu_as_sc_mcu7t3v3__inv_2_1046/VNW VSUBS
+ gf180mcu_as_sc_mcu7t3v3__inv_2
Xgf180mcu_as_sc_mcu7t3v3__inv_2_1034 gf180mcu_as_sc_mcu7t3v3__inv_2_1034/VDD VSS gf180mcu_as_sc_mcu7t3v3__inv_2_1034/Y
+ VSS gf180mcu_as_sc_mcu7t3v3__inv_2_1034/VNW VSUBS gf180mcu_as_sc_mcu7t3v3__inv_2
Xgf180mcu_as_sc_mcu7t3v3__inv_2_518 VSS VSS VSS VSS gf180mcu_as_sc_mcu7t3v3__inv_2_518/VNW
+ VSUBS gf180mcu_as_sc_mcu7t3v3__inv_2
Xgf180mcu_as_sc_mcu7t3v3__inv_2_529 VSS VSS VSS VSS gf180mcu_as_sc_mcu7t3v3__inv_2_530/VNW
+ VSUBS gf180mcu_as_sc_mcu7t3v3__inv_2
Xgf180mcu_as_sc_mcu7t3v3__inv_2_507 VSS VSS gf180mcu_as_sc_mcu7t3v3__inv_2_507/Y VSS
+ gf180mcu_as_sc_mcu7t3v3__inv_2_511/VNW VSUBS gf180mcu_as_sc_mcu7t3v3__inv_2
Xgf180mcu_as_sc_mcu7t3v3__inv_2_1590 VSS gf180mcu_as_sc_mcu7t3v3__inv_2_1592/VSS VSS
+ VSS gf180mcu_as_sc_mcu7t3v3__inv_2_1592/VNW VSUBS gf180mcu_as_sc_mcu7t3v3__inv_2
Xgf180mcu_as_sc_mcu7t3v3__nand3_2_1 gf180mcu_as_sc_mcu7t3v3__nor2_2_5/VDD gf180mcu_as_sc_mcu7t3v3__nand3_2_8/VSS
+ VSS VSS VSS VSS gf180mcu_as_sc_mcu7t3v3__nor2_2_5/VNW VSUBS gf180mcu_as_sc_mcu7t3v3__nand3_2
Xgf180mcu_as_sc_mcu7t3v3__nand4_2_340 VSS gf180mcu_as_sc_mcu7t3v3__inv_2_1141/VDD
+ VSS VSS VSS VSS VSS gf180mcu_as_sc_mcu7t3v3__inv_2_1138/VNW VSUBS gf180mcu_as_sc_mcu7t3v3__nand4_2
Xgf180mcu_as_sc_mcu7t3v3__nand4_2_351 VSS VSS VSS VSS VSS VSS VSS gf180mcu_as_sc_mcu7t3v3__inv_2_1235/VNW
+ VSUBS gf180mcu_as_sc_mcu7t3v3__nand4_2
Xgf180mcu_as_sc_mcu7t3v3__nand4_2_362 VSS VSS VSS VSS VSS VSS gf180mcu_as_sc_mcu7t3v3__nand4_2_362/Y
+ gf180mcu_as_sc_mcu7t3v3__inv_2_1292/VNW VSUBS gf180mcu_as_sc_mcu7t3v3__nand4_2
Xgf180mcu_as_sc_mcu7t3v3__nand4_2_373 VSS VSS VSS VSS VSS VSS gf180mcu_as_sc_mcu7t3v3__nand4_2_373/Y
+ gf180mcu_as_sc_mcu7t3v3__inv_2_1155/VNW VSUBS gf180mcu_as_sc_mcu7t3v3__nand4_2
Xgf180mcu_as_sc_mcu7t3v3__nand4_2_395 gf180mcu_as_sc_mcu7t3v3__inv_2_1376/VDD VSS
+ VSS VSS VSS VSS VSS gf180mcu_as_sc_mcu7t3v3__inv_2_1376/VNW VSUBS gf180mcu_as_sc_mcu7t3v3__nand4_2
Xgf180mcu_as_sc_mcu7t3v3__nand4_2_384 gf180mcu_as_sc_mcu7t3v3__inv_2_1397/VSS VSS
+ VSS VSS VSS VSS VSS gf180mcu_as_sc_mcu7t3v3__inv_2_1366/VNW VSUBS gf180mcu_as_sc_mcu7t3v3__nand4_2
Xgf180mcu_as_sc_mcu7t3v3__inv_2_359 gf180mcu_as_sc_mcu7t3v3__inv_2_359/VDD gf180mcu_as_sc_mcu7t3v3__inv_2_360/VDD
+ gf180mcu_as_sc_mcu7t3v3__inv_2_361/Y VSS gf180mcu_as_sc_mcu7t3v3__inv_2_359/VNW
+ VSUBS gf180mcu_as_sc_mcu7t3v3__inv_2
Xgf180mcu_as_sc_mcu7t3v3__inv_2_348 VSS gf180mcu_as_sc_mcu7t3v3__inv_2_354/VDD gf180mcu_as_sc_mcu7t3v3__inv_2_358/Y
+ VSS gf180mcu_as_sc_mcu7t3v3__inv_2_348/VNW VSUBS gf180mcu_as_sc_mcu7t3v3__inv_2
Xgf180mcu_as_sc_mcu7t3v3__inv_2_315 VSS VSS gf180mcu_as_sc_mcu7t3v3__inv_2_344/Y gf180mcu_as_sc_mcu7t3v3__inv_2_344/Y
+ gf180mcu_as_sc_mcu7t3v3__inv_2_342/VNW VSUBS gf180mcu_as_sc_mcu7t3v3__inv_2
Xgf180mcu_as_sc_mcu7t3v3__inv_2_326 VSS VSS gf180mcu_as_sc_mcu7t3v3__inv_2_341/Y gf180mcu_as_sc_mcu7t3v3__inv_2_341/Y
+ gf180mcu_as_sc_mcu7t3v3__inv_2_339/VNW VSUBS gf180mcu_as_sc_mcu7t3v3__inv_2
Xgf180mcu_as_sc_mcu7t3v3__inv_2_337 gf180mcu_as_sc_mcu7t3v3__inv_2_337/VDD gf180mcu_as_sc_mcu7t3v3__inv_2_338/VDD
+ gf180mcu_as_sc_mcu7t3v3__inv_2_338/Y VSS gf180mcu_as_sc_mcu7t3v3__inv_2_337/VNW
+ VSUBS gf180mcu_as_sc_mcu7t3v3__inv_2
Xgf180mcu_as_sc_mcu7t3v3__inv_2_304 gf180mcu_as_sc_mcu7t3v3__inv_2_332/VDD VSS VSS
+ gf180mcu_as_sc_mcu7t3v3__inv_2_338/Y gf180mcu_as_sc_mcu7t3v3__inv_2_332/VNW VSUBS
+ gf180mcu_as_sc_mcu7t3v3__inv_2
Xu_t027_009 u_t027_009/c0_w0_bl u_t027_009/c0_w0_br u_t027_009/c0_w1_bl u_t027_009/c0_w1_br
+ u_t027_009/c0_r0_rbl u_t027_009/c0_r1_rbl u_t027_009/c1_w0_bl u_t027_009/c1_w0_br
+ u_t027_009/c1_w1_bl u_t027_009/c1_w1_br u_t027_009/c1_r0_rbl u_t027_009/c1_r1_rbl
+ u_t027_009/c2_w0_bl u_t027_009/c2_w0_br u_t027_009/c2_w1_bl u_t027_009/c2_w1_br
+ u_t027_009/c2_r0_rbl u_t027_009/c2_r1_rbl u_t027_009/c3_w0_bl u_t027_009/c3_w0_br
+ u_t027_009/c3_w1_bl u_t027_009/c3_w1_br u_t027_009/c3_r0_rbl u_t027_009/c3_r1_rbl
+ u_t027_009/r0_w0_wl u_t027_009/r0_w1_wl u_t027_009/r0_r0_rwl u_t027_009/r0_r1_rwl
+ u_t027_009/r1_w0_wl u_t027_009/r1_w1_wl u_t027_009/r1_r0_rwl u_t027_009/r1_r1_rwl
+ u_t027_009/r2_w0_wl u_t027_009/r2_w1_wl u_t027_009/r2_r0_rwl u_t027_009/r2_r1_rwl
+ u_t027_009/r3_w0_wl u_t027_009/r3_w1_wl u_t027_009/r3_r0_rwl u_t027_009/r3_r1_rwl
+ VSS u_t027_009/VSS VSUBS detronyx_12t_2w2r_rc4_4x4_routed_5layer_direct
Xgf180mcu_as_sc_mcu7t3v3__inv_2_882 VSS VSS VSS VSS gf180mcu_as_sc_mcu7t3v3__inv_2_884/VNW
+ VSUBS gf180mcu_as_sc_mcu7t3v3__inv_2
Xgf180mcu_as_sc_mcu7t3v3__inv_2_871 VSS VSS VSS VSS gf180mcu_as_sc_mcu7t3v3__inv_2_872/VNW
+ VSUBS gf180mcu_as_sc_mcu7t3v3__inv_2
Xgf180mcu_as_sc_mcu7t3v3__inv_2_860 VSS VSS VSS VSS gf180mcu_as_sc_mcu7t3v3__inv_2_860/VNW
+ VSUBS gf180mcu_as_sc_mcu7t3v3__inv_2
Xgf180mcu_as_sc_mcu7t3v3__inv_2_893 VSS VSS VSS VSS gf180mcu_as_sc_mcu7t3v3__inv_2_897/VNW
+ VSUBS gf180mcu_as_sc_mcu7t3v3__inv_2
Xu_t018_009 u_t018_009/c0_w0_bl u_t018_009/c0_w0_br u_t018_009/c0_w1_bl u_t018_009/c0_w1_br
+ u_t018_009/c0_r0_rbl u_t018_009/c0_r1_rbl u_t018_009/c1_w0_bl u_t018_009/c1_w0_br
+ u_t018_009/c1_w1_bl u_t018_009/c1_w1_br u_t018_009/c1_r0_rbl u_t018_009/c1_r1_rbl
+ u_t018_009/c2_w0_bl u_t018_009/c2_w0_br u_t018_009/c2_w1_bl u_t018_009/c2_w1_br
+ u_t018_009/c2_r0_rbl u_t018_009/c2_r1_rbl u_t018_009/c3_w0_bl u_t018_009/c3_w0_br
+ u_t018_009/c3_w1_bl u_t018_009/c3_w1_br u_t018_009/c3_r0_rbl u_t018_009/c3_r1_rbl
+ u_t018_009/r0_w0_wl u_t018_009/r0_w1_wl u_t018_009/r0_r0_rwl u_t018_009/r0_r1_rwl
+ u_t018_009/r1_w0_wl u_t018_009/r1_w1_wl u_t018_009/r1_r0_rwl u_t018_009/r1_r1_rwl
+ u_t018_009/r2_w0_wl u_t018_009/r2_w1_wl u_t018_009/r2_r0_rwl u_t018_009/r2_r1_rwl
+ u_t018_009/r3_w0_wl u_t018_009/r3_w1_wl u_t018_009/r3_r0_rwl u_t018_009/r3_r1_rwl
+ VSS u_t018_009/VSS VSUBS detronyx_12t_2w2r_rc4_4x4_routed_5layer_direct
Xgf180mcu_as_sc_mcu7t3v3__nand4_2_170 gf180mcu_as_sc_mcu7t3v3__inv_2_633/VSS VSS VSS
+ VSS VSS VSS VSS gf180mcu_as_sc_mcu7t3v3__inv_2_589/VNW VSUBS gf180mcu_as_sc_mcu7t3v3__nand4_2
Xgf180mcu_as_sc_mcu7t3v3__nand4_2_181 VSS VSS VSS VSS VSS VSS VSS gf180mcu_as_sc_mcu7t3v3__inv_2_699/VNW
+ VSUBS gf180mcu_as_sc_mcu7t3v3__nand4_2
Xgf180mcu_as_sc_mcu7t3v3__nand4_2_192 gf180mcu_as_sc_mcu7t3v3__inv_2_738/VSS VSS VSS
+ VSS VSS VSS VSS gf180mcu_as_sc_mcu7t3v3__inv_2_704/VNW VSUBS gf180mcu_as_sc_mcu7t3v3__nand4_2
Xu_t026_031 u_t026_031/c0_w0_bl u_t026_031/c0_w0_br u_t026_031/c0_w1_bl u_t026_031/c0_w1_br
+ u_t026_031/c0_r0_rbl u_t026_031/c0_r1_rbl u_t026_031/c1_w0_bl u_t026_031/c1_w0_br
+ u_t026_031/c1_w1_bl u_t026_031/c1_w1_br u_t026_031/c1_r0_rbl u_t026_031/c1_r1_rbl
+ u_t026_031/c2_w0_bl u_t026_031/c2_w0_br u_t026_031/c2_w1_bl u_t026_031/c2_w1_br
+ u_t026_031/c2_r0_rbl u_t026_031/c2_r1_rbl u_t026_031/c3_w0_bl u_t026_031/c3_w0_br
+ u_t026_031/c3_w1_bl u_t026_031/c3_w1_br u_t026_031/c3_r0_rbl u_t026_031/c3_r1_rbl
+ u_t026_031/r0_w0_wl u_t026_031/r0_w1_wl u_t026_031/r0_r0_rwl u_t026_031/r0_r1_rwl
+ u_t026_031/r1_w0_wl u_t026_031/r1_w1_wl u_t026_031/r1_r0_rwl u_t026_031/r1_r1_rwl
+ u_t026_031/r2_w0_wl u_t026_031/r2_w1_wl u_t026_031/r2_r0_rwl u_t026_031/r2_r1_rwl
+ u_t026_031/r3_w0_wl u_t026_031/r3_w1_wl u_t026_031/r3_r0_rwl u_t026_031/r3_r1_rwl
+ VSS u_t026_031/VSS VSUBS detronyx_12t_2w2r_rc4_4x4_routed_5layer_direct
Xu_t026_020 u_t026_020/c0_w0_bl u_t026_020/c0_w0_br u_t026_020/c0_w1_bl u_t026_020/c0_w1_br
+ u_t026_020/c0_r0_rbl u_t026_020/c0_r1_rbl u_t026_020/c1_w0_bl u_t026_020/c1_w0_br
+ u_t026_020/c1_w1_bl u_t026_020/c1_w1_br u_t026_020/c1_r0_rbl u_t026_020/c1_r1_rbl
+ u_t026_020/c2_w0_bl u_t026_020/c2_w0_br u_t026_020/c2_w1_bl u_t026_020/c2_w1_br
+ u_t026_020/c2_r0_rbl u_t026_020/c2_r1_rbl u_t026_020/c3_w0_bl u_t026_020/c3_w0_br
+ u_t026_020/c3_w1_bl u_t026_020/c3_w1_br u_t026_020/c3_r0_rbl u_t026_020/c3_r1_rbl
+ u_t026_020/r0_w0_wl u_t026_020/r0_w1_wl u_t026_020/r0_r0_rwl u_t026_020/r0_r1_rwl
+ u_t026_020/r1_w0_wl u_t026_020/r1_w1_wl u_t026_020/r1_r0_rwl u_t026_020/r1_r1_rwl
+ u_t026_020/r2_w0_wl u_t026_020/r2_w1_wl u_t026_020/r2_r0_rwl u_t026_020/r2_r1_rwl
+ u_t026_020/r3_w0_wl u_t026_020/r3_w1_wl u_t026_020/r3_r0_rwl u_t026_020/r3_r1_rwl
+ u_t026_020/VDD u_t026_031/VSS VSUBS detronyx_12t_2w2r_rc4_4x4_routed_5layer_direct
Xu_t017_031 u_t017_031/c0_w0_bl u_t017_031/c0_w0_br u_t017_031/c0_w1_bl u_t017_031/c0_w1_br
+ u_t017_031/c0_r0_rbl u_t017_031/c0_r1_rbl u_t017_031/c1_w0_bl u_t017_031/c1_w0_br
+ u_t017_031/c1_w1_bl u_t017_031/c1_w1_br u_t017_031/c1_r0_rbl u_t017_031/c1_r1_rbl
+ u_t017_031/c2_w0_bl u_t017_031/c2_w0_br u_t017_031/c2_w1_bl u_t017_031/c2_w1_br
+ u_t017_031/c2_r0_rbl u_t017_031/c2_r1_rbl u_t017_031/c3_w0_bl u_t017_031/c3_w0_br
+ u_t017_031/c3_w1_bl u_t017_031/c3_w1_br u_t017_031/c3_r0_rbl u_t017_031/c3_r1_rbl
+ u_t017_031/r0_w0_wl u_t017_031/r0_w1_wl u_t017_031/r0_r0_rwl u_t017_031/r0_r1_rwl
+ u_t017_031/r1_w0_wl u_t017_031/r1_w1_wl u_t017_031/r1_r0_rwl u_t017_031/r1_r1_rwl
+ u_t017_031/r2_w0_wl u_t017_031/r2_w1_wl u_t017_031/r2_r0_rwl u_t017_031/r2_r1_rwl
+ u_t017_031/r3_w0_wl u_t017_031/r3_w1_wl u_t017_031/r3_r0_rwl u_t017_031/r3_r1_rwl
+ VSS u_t017_031/VSS VSUBS detronyx_12t_2w2r_rc4_4x4_routed_5layer_direct
Xu_t017_020 u_t017_020/c0_w0_bl u_t017_020/c0_w0_br u_t017_020/c0_w1_bl u_t017_020/c0_w1_br
+ u_t017_020/c0_r0_rbl u_t017_020/c0_r1_rbl u_t017_020/c1_w0_bl u_t017_020/c1_w0_br
+ u_t017_020/c1_w1_bl u_t017_020/c1_w1_br u_t017_020/c1_r0_rbl u_t017_020/c1_r1_rbl
+ u_t017_020/c2_w0_bl u_t017_020/c2_w0_br u_t017_020/c2_w1_bl u_t017_020/c2_w1_br
+ u_t017_020/c2_r0_rbl u_t017_020/c2_r1_rbl u_t017_020/c3_w0_bl u_t017_020/c3_w0_br
+ u_t017_020/c3_w1_bl u_t017_020/c3_w1_br u_t017_020/c3_r0_rbl u_t017_020/c3_r1_rbl
+ u_t017_020/r0_w0_wl u_t017_020/r0_w1_wl u_t017_020/r0_r0_rwl u_t017_020/r0_r1_rwl
+ u_t017_020/r1_w0_wl u_t017_020/r1_w1_wl u_t017_020/r1_r0_rwl u_t017_020/r1_r1_rwl
+ u_t017_020/r2_w0_wl u_t017_020/r2_w1_wl u_t017_020/r2_r0_rwl u_t017_020/r2_r1_rwl
+ u_t017_020/r3_w0_wl u_t017_020/r3_w1_wl u_t017_020/r3_r0_rwl u_t017_020/r3_r1_rwl
+ u_t017_020/VDD u_t017_031/VSS VSUBS detronyx_12t_2w2r_rc4_4x4_routed_5layer_direct
Xu_t009_009 u_t009_009/c0_w0_bl u_t009_009/c0_w0_br u_t009_009/c0_w1_bl u_t009_009/c0_w1_br
+ u_t009_009/c0_r0_rbl u_t009_009/c0_r1_rbl u_t009_009/c1_w0_bl u_t009_009/c1_w0_br
+ u_t009_009/c1_w1_bl u_t009_009/c1_w1_br u_t009_009/c1_r0_rbl u_t009_009/c1_r1_rbl
+ u_t009_009/c2_w0_bl u_t009_009/c2_w0_br u_t009_009/c2_w1_bl u_t009_009/c2_w1_br
+ u_t009_009/c2_r0_rbl u_t009_009/c2_r1_rbl u_t009_009/c3_w0_bl u_t009_009/c3_w0_br
+ u_t009_009/c3_w1_bl u_t009_009/c3_w1_br u_t009_009/c3_r0_rbl u_t009_009/c3_r1_rbl
+ u_t009_009/r0_w0_wl u_t009_009/r0_w1_wl u_t009_009/r0_r0_rwl u_t009_009/r0_r1_rwl
+ u_t009_009/r1_w0_wl u_t009_009/r1_w1_wl u_t009_009/r1_r0_rwl u_t009_009/r1_r1_rwl
+ u_t009_009/r2_w0_wl u_t009_009/r2_w1_wl u_t009_009/r2_r0_rwl u_t009_009/r2_r1_rwl
+ u_t009_009/r3_w0_wl u_t009_009/r3_w1_wl u_t009_009/r3_r0_rwl u_t009_009/r3_r1_rwl
+ VSS u_t009_031/VSS VSUBS detronyx_12t_2w2r_rc4_4x4_routed_5layer_direct
Xgf180mcu_as_sc_mcu7t3v3__inv_2_101 gf180mcu_as_sc_mcu7t3v3__inv_2_99/VSS gf180mcu_as_sc_mcu7t3v3__inv_2_96/VDD
+ VSS VSS gf180mcu_as_sc_mcu7t3v3__inv_2_103/VNW VSUBS gf180mcu_as_sc_mcu7t3v3__inv_2
Xgf180mcu_as_sc_mcu7t3v3__inv_2_134 gf180mcu_as_sc_mcu7t3v3__inv_2_134/VDD gf180mcu_as_sc_mcu7t3v3__inv_2_138/VDD
+ gf180mcu_as_sc_mcu7t3v3__inv_2_134/Y VSS gf180mcu_as_sc_mcu7t3v3__inv_2_134/VNW
+ VSUBS gf180mcu_as_sc_mcu7t3v3__inv_2
Xgf180mcu_as_sc_mcu7t3v3__inv_2_123 gf180mcu_as_sc_mcu7t3v3__inv_2_151/VSS gf180mcu_as_sc_mcu7t3v3__inv_2_151/VSS
+ VSS VSS gf180mcu_as_sc_mcu7t3v3__inv_2_123/VNW VSUBS gf180mcu_as_sc_mcu7t3v3__inv_2
Xgf180mcu_as_sc_mcu7t3v3__inv_2_112 gf180mcu_as_sc_mcu7t3v3__inv_2_151/VSS gf180mcu_as_sc_mcu7t3v3__inv_2_151/VSS
+ VSS VSS gf180mcu_as_sc_mcu7t3v3__inv_2_123/VNW VSUBS gf180mcu_as_sc_mcu7t3v3__inv_2
Xgf180mcu_as_sc_mcu7t3v3__inv_2_145 gf180mcu_as_sc_mcu7t3v3__inv_2_146/VDD VSS gf180mcu_as_sc_mcu7t3v3__inv_2_145/Y
+ VSS gf180mcu_as_sc_mcu7t3v3__inv_2_146/VNW VSUBS gf180mcu_as_sc_mcu7t3v3__inv_2
Xgf180mcu_as_sc_mcu7t3v3__inv_2_156 gf180mcu_as_sc_mcu7t3v3__inv_2_206/VDD gf180mcu_as_sc_mcu7t3v3__inv_2_371/VDD
+ gf180mcu_as_sc_mcu7t3v3__inv_2_156/Y VSS gf180mcu_as_sc_mcu7t3v3__inv_2_206/VNW
+ VSUBS gf180mcu_as_sc_mcu7t3v3__inv_2
Xgf180mcu_as_sc_mcu7t3v3__inv_2_178 VSS gf180mcu_as_sc_mcu7t3v3__inv_2_184/VDD VSS
+ VSS gf180mcu_as_sc_mcu7t3v3__inv_2_180/VNW VSUBS gf180mcu_as_sc_mcu7t3v3__inv_2
Xgf180mcu_as_sc_mcu7t3v3__inv_2_189 VSS VSS VSS VSS gf180mcu_as_sc_mcu7t3v3__inv_2_193/VNW
+ VSUBS gf180mcu_as_sc_mcu7t3v3__inv_2
Xgf180mcu_as_sc_mcu7t3v3__inv_2_167 VSS VSS VSS VSS gf180mcu_as_sc_mcu7t3v3__inv_2_169/VNW
+ VSUBS gf180mcu_as_sc_mcu7t3v3__inv_2
Xu_t008_031 u_t008_031/c0_w0_bl u_t008_031/c0_w0_br u_t008_031/c0_w1_bl u_t008_031/c0_w1_br
+ u_t008_031/c0_r0_rbl u_t008_031/c0_r1_rbl u_t008_031/c1_w0_bl u_t008_031/c1_w0_br
+ u_t008_031/c1_w1_bl u_t008_031/c1_w1_br u_t008_031/c1_r0_rbl u_t008_031/c1_r1_rbl
+ u_t008_031/c2_w0_bl u_t008_031/c2_w0_br u_t008_031/c2_w1_bl u_t008_031/c2_w1_br
+ u_t008_031/c2_r0_rbl u_t008_031/c2_r1_rbl u_t008_031/c3_w0_bl u_t008_031/c3_w0_br
+ u_t008_031/c3_w1_bl u_t008_031/c3_w1_br u_t008_031/c3_r0_rbl u_t008_031/c3_r1_rbl
+ u_t008_031/r0_w0_wl u_t008_031/r0_w1_wl u_t008_031/r0_r0_rwl u_t008_031/r0_r1_rwl
+ u_t008_031/r1_w0_wl u_t008_031/r1_w1_wl u_t008_031/r1_r0_rwl u_t008_031/r1_r1_rwl
+ u_t008_031/r2_w0_wl u_t008_031/r2_w1_wl u_t008_031/r2_r0_rwl u_t008_031/r2_r1_rwl
+ u_t008_031/r3_w0_wl u_t008_031/r3_w1_wl u_t008_031/r3_r0_rwl u_t008_031/r3_r1_rwl
+ VSS u_t008_031/VSS VSUBS detronyx_12t_2w2r_rc4_4x4_routed_5layer_direct
Xu_t023_023 u_t023_023/c0_w0_bl u_t023_023/c0_w0_br u_t023_023/c0_w1_bl u_t023_023/c0_w1_br
+ u_t023_023/c0_r0_rbl u_t023_023/c0_r1_rbl u_t023_023/c1_w0_bl u_t023_023/c1_w0_br
+ u_t023_023/c1_w1_bl u_t023_023/c1_w1_br u_t023_023/c1_r0_rbl u_t023_023/c1_r1_rbl
+ u_t023_023/c2_w0_bl u_t023_023/c2_w0_br u_t023_023/c2_w1_bl u_t023_023/c2_w1_br
+ u_t023_023/c2_r0_rbl u_t023_023/c2_r1_rbl u_t023_023/c3_w0_bl u_t023_023/c3_w0_br
+ u_t023_023/c3_w1_bl u_t023_023/c3_w1_br u_t023_023/c3_r0_rbl u_t023_023/c3_r1_rbl
+ u_t023_023/r0_w0_wl u_t023_023/r0_w1_wl u_t023_023/r0_r0_rwl u_t023_023/r0_r1_rwl
+ u_t023_023/r1_w0_wl u_t023_023/r1_w1_wl u_t023_023/r1_r0_rwl u_t023_023/r1_r1_rwl
+ u_t023_023/r2_w0_wl u_t023_023/r2_w1_wl u_t023_023/r2_r0_rwl u_t023_023/r2_r1_rwl
+ u_t023_023/r3_w0_wl u_t023_023/r3_w1_wl u_t023_023/r3_r0_rwl u_t023_023/r3_r1_rwl
+ VSS u_t023_024/VSS VSUBS detronyx_12t_2w2r_rc4_4x4_routed_5layer_direct
Xu_t008_020 u_t008_020/c0_w0_bl u_t008_020/c0_w0_br u_t008_020/c0_w1_bl u_t008_020/c0_w1_br
+ u_t008_020/c0_r0_rbl u_t008_020/c0_r1_rbl u_t008_020/c1_w0_bl u_t008_020/c1_w0_br
+ u_t008_020/c1_w1_bl u_t008_020/c1_w1_br u_t008_020/c1_r0_rbl u_t008_020/c1_r1_rbl
+ u_t008_020/c2_w0_bl u_t008_020/c2_w0_br u_t008_020/c2_w1_bl u_t008_020/c2_w1_br
+ u_t008_020/c2_r0_rbl u_t008_020/c2_r1_rbl u_t008_020/c3_w0_bl u_t008_020/c3_w0_br
+ u_t008_020/c3_w1_bl u_t008_020/c3_w1_br u_t008_020/c3_r0_rbl u_t008_020/c3_r1_rbl
+ u_t008_020/r0_w0_wl u_t008_020/r0_w1_wl u_t008_020/r0_r0_rwl u_t008_020/r0_r1_rwl
+ u_t008_020/r1_w0_wl u_t008_020/r1_w1_wl u_t008_020/r1_r0_rwl u_t008_020/r1_r1_rwl
+ u_t008_020/r2_w0_wl u_t008_020/r2_w1_wl u_t008_020/r2_r0_rwl u_t008_020/r2_r1_rwl
+ u_t008_020/r3_w0_wl u_t008_020/r3_w1_wl u_t008_020/r3_r0_rwl u_t008_020/r3_r1_rwl
+ u_t008_020/VDD u_t008_031/VSS VSUBS detronyx_12t_2w2r_rc4_4x4_routed_5layer_direct
Xu_t023_012 u_t023_012/c0_w0_bl u_t023_012/c0_w0_br u_t023_012/c0_w1_bl u_t023_012/c0_w1_br
+ u_t023_012/c0_r0_rbl u_t023_012/c0_r1_rbl u_t023_012/c1_w0_bl u_t023_012/c1_w0_br
+ u_t023_012/c1_w1_bl u_t023_012/c1_w1_br u_t023_012/c1_r0_rbl u_t023_012/c1_r1_rbl
+ u_t023_012/c2_w0_bl u_t023_012/c2_w0_br u_t023_012/c2_w1_bl u_t023_012/c2_w1_br
+ u_t023_012/c2_r0_rbl u_t023_012/c2_r1_rbl u_t023_012/c3_w0_bl u_t023_012/c3_w0_br
+ u_t023_012/c3_w1_bl u_t023_012/c3_w1_br u_t023_012/c3_r0_rbl u_t023_012/c3_r1_rbl
+ u_t023_012/r0_w0_wl u_t023_012/r0_w1_wl u_t023_012/r0_r0_rwl u_t023_012/r0_r1_rwl
+ u_t023_012/r1_w0_wl u_t023_012/r1_w1_wl u_t023_012/r1_r0_rwl u_t023_012/r1_r1_rwl
+ u_t023_012/r2_w0_wl u_t023_012/r2_w1_wl u_t023_012/r2_r0_rwl u_t023_012/r2_r1_rwl
+ u_t023_012/r3_w0_wl u_t023_012/r3_w1_wl u_t023_012/r3_r0_rwl u_t023_012/r3_r1_rwl
+ u_t023_012/VDD u_t023_012/VSS VSUBS detronyx_12t_2w2r_rc4_4x4_routed_5layer_direct
Xu_t023_001 u_t023_001/c0_w0_bl u_t023_001/c0_w0_br u_t023_001/c0_w1_bl u_t023_001/c0_w1_br
+ u_t023_001/c0_r0_rbl u_t023_001/c0_r1_rbl u_t023_001/c1_w0_bl u_t023_001/c1_w0_br
+ u_t023_001/c1_w1_bl u_t023_001/c1_w1_br u_t023_001/c1_r0_rbl u_t023_001/c1_r1_rbl
+ u_t023_001/c2_w0_bl u_t023_001/c2_w0_br u_t023_001/c2_w1_bl u_t023_001/c2_w1_br
+ u_t023_001/c2_r0_rbl u_t023_001/c2_r1_rbl u_t023_001/c3_w0_bl u_t023_001/c3_w0_br
+ u_t023_001/c3_w1_bl u_t023_001/c3_w1_br u_t023_001/c3_r0_rbl u_t023_001/c3_r1_rbl
+ u_t023_001/r0_w0_wl u_t023_001/r0_w1_wl u_t023_001/r0_r0_rwl u_t023_001/r0_r1_rwl
+ u_t023_001/r1_w0_wl u_t023_001/r1_w1_wl u_t023_001/r1_r0_rwl u_t023_001/r1_r1_rwl
+ u_t023_001/r2_w0_wl u_t023_001/r2_w1_wl u_t023_001/r2_r0_rwl u_t023_001/r2_r1_rwl
+ u_t023_001/r3_w0_wl u_t023_001/r3_w1_wl u_t023_001/r3_r0_rwl u_t023_001/r3_r1_rwl
+ VSS u_t023_002/VSS VSUBS detronyx_12t_2w2r_rc4_4x4_routed_5layer_direct
Xgf180mcu_as_sc_mcu7t3v3__inv_2_690 VSS gf180mcu_as_sc_mcu7t3v3__inv_2_695/VDD gf180mcu_as_sc_mcu7t3v3__inv_2_690/Y
+ gf180mcu_as_sc_mcu7t3v3__inv_2_691/Y gf180mcu_as_sc_mcu7t3v3__inv_2_691/VNW VSUBS
+ gf180mcu_as_sc_mcu7t3v3__inv_2
Xgf180mcu_as_sc_mcu7t3v3__nand2_2_57 gf180mcu_as_sc_mcu7t3v3__nor2_2_8/VDD gf180mcu_as_sc_mcu7t3v3__nand3_2_32/VSS
+ VSS VSS VSS gf180mcu_as_sc_mcu7t3v3__nor2_2_8/VNW VSUBS gf180mcu_as_sc_mcu7t3v3__nand2_2
Xgf180mcu_as_sc_mcu7t3v3__nand2_2_46 gf180mcu_as_sc_mcu7t3v3__nand3_2_31/VDD gf180mcu_as_sc_mcu7t3v3__nand3_2_31/VSS
+ VSS VSS VSS gf180mcu_as_sc_mcu7t3v3__nand3_2_31/VNW VSUBS gf180mcu_as_sc_mcu7t3v3__nand2_2
Xgf180mcu_as_sc_mcu7t3v3__nand2_2_35 gf180mcu_as_sc_mcu7t3v3__nor2_2_4/VDD gf180mcu_as_sc_mcu7t3v3__nand3_2_8/VSS
+ VSS VSS VSS gf180mcu_as_sc_mcu7t3v3__nor2_2_4/VNW VSUBS gf180mcu_as_sc_mcu7t3v3__nand2_2
Xgf180mcu_as_sc_mcu7t3v3__nand2_2_24 gf180mcu_as_sc_mcu7t3v3__nor2_2_6/VDD gf180mcu_as_sc_mcu7t3v3__nand3_2_3/VSS
+ VSS VSS VSS gf180mcu_as_sc_mcu7t3v3__nor2_2_6/VNW VSUBS gf180mcu_as_sc_mcu7t3v3__nand2_2
Xgf180mcu_as_sc_mcu7t3v3__nand2_2_13 gf180mcu_as_sc_mcu7t3v3__nand3_2_5/VDD gf180mcu_as_sc_mcu7t3v3__nor2_2_4/VSS
+ VSS VSS VSS gf180mcu_as_sc_mcu7t3v3__nand3_2_5/VNW VSUBS gf180mcu_as_sc_mcu7t3v3__nand2_2
Xu_t014_023 u_t014_023/c0_w0_bl u_t014_023/c0_w0_br u_t014_023/c0_w1_bl u_t014_023/c0_w1_br
+ u_t014_023/c0_r0_rbl u_t014_023/c0_r1_rbl u_t014_023/c1_w0_bl u_t014_023/c1_w0_br
+ u_t014_023/c1_w1_bl u_t014_023/c1_w1_br u_t014_023/c1_r0_rbl u_t014_023/c1_r1_rbl
+ u_t014_023/c2_w0_bl u_t014_023/c2_w0_br u_t014_023/c2_w1_bl u_t014_023/c2_w1_br
+ u_t014_023/c2_r0_rbl u_t014_023/c2_r1_rbl u_t014_023/c3_w0_bl u_t014_023/c3_w0_br
+ u_t014_023/c3_w1_bl u_t014_023/c3_w1_br u_t014_023/c3_r0_rbl u_t014_023/c3_r1_rbl
+ u_t014_023/r0_w0_wl u_t014_023/r0_w1_wl u_t014_023/r0_r0_rwl u_t014_023/r0_r1_rwl
+ u_t014_023/r1_w0_wl u_t014_023/r1_w1_wl u_t014_023/r1_r0_rwl u_t014_023/r1_r1_rwl
+ u_t014_023/r2_w0_wl u_t014_023/r2_w1_wl u_t014_023/r2_r0_rwl u_t014_023/r2_r1_rwl
+ u_t014_023/r3_w0_wl u_t014_023/r3_w1_wl u_t014_023/r3_r0_rwl u_t014_023/r3_r1_rwl
+ VSS u_t014_024/VSS VSUBS detronyx_12t_2w2r_rc4_4x4_routed_5layer_direct
Xu_t014_012 u_t014_012/c0_w0_bl u_t014_012/c0_w0_br u_t014_012/c0_w1_bl u_t014_012/c0_w1_br
+ u_t014_012/c0_r0_rbl u_t014_012/c0_r1_rbl u_t014_012/c1_w0_bl u_t014_012/c1_w0_br
+ u_t014_012/c1_w1_bl u_t014_012/c1_w1_br u_t014_012/c1_r0_rbl u_t014_012/c1_r1_rbl
+ u_t014_012/c2_w0_bl u_t014_012/c2_w0_br u_t014_012/c2_w1_bl u_t014_012/c2_w1_br
+ u_t014_012/c2_r0_rbl u_t014_012/c2_r1_rbl u_t014_012/c3_w0_bl u_t014_012/c3_w0_br
+ u_t014_012/c3_w1_bl u_t014_012/c3_w1_br u_t014_012/c3_r0_rbl u_t014_012/c3_r1_rbl
+ u_t014_012/r0_w0_wl u_t014_012/r0_w1_wl u_t014_012/r0_r0_rwl u_t014_012/r0_r1_rwl
+ u_t014_012/r1_w0_wl u_t014_012/r1_w1_wl u_t014_012/r1_r0_rwl u_t014_012/r1_r1_rwl
+ u_t014_012/r2_w0_wl u_t014_012/r2_w1_wl u_t014_012/r2_r0_rwl u_t014_012/r2_r1_rwl
+ u_t014_012/r3_w0_wl u_t014_012/r3_w1_wl u_t014_012/r3_r0_rwl u_t014_012/r3_r1_rwl
+ u_t014_012/VDD u_t014_012/VSS VSUBS detronyx_12t_2w2r_rc4_4x4_routed_5layer_direct
Xu_t014_001 u_t014_001/c0_w0_bl u_t014_001/c0_w0_br u_t014_001/c0_w1_bl u_t014_001/c0_w1_br
+ u_t014_001/c0_r0_rbl u_t014_001/c0_r1_rbl u_t014_001/c1_w0_bl u_t014_001/c1_w0_br
+ u_t014_001/c1_w1_bl u_t014_001/c1_w1_br u_t014_001/c1_r0_rbl u_t014_001/c1_r1_rbl
+ u_t014_001/c2_w0_bl u_t014_001/c2_w0_br u_t014_001/c2_w1_bl u_t014_001/c2_w1_br
+ u_t014_001/c2_r0_rbl u_t014_001/c2_r1_rbl u_t014_001/c3_w0_bl u_t014_001/c3_w0_br
+ u_t014_001/c3_w1_bl u_t014_001/c3_w1_br u_t014_001/c3_r0_rbl u_t014_001/c3_r1_rbl
+ u_t014_001/r0_w0_wl u_t014_001/r0_w1_wl u_t014_001/r0_r0_rwl u_t014_001/r0_r1_rwl
+ u_t014_001/r1_w0_wl u_t014_001/r1_w1_wl u_t014_001/r1_r0_rwl u_t014_001/r1_r1_rwl
+ u_t014_001/r2_w0_wl u_t014_001/r2_w1_wl u_t014_001/r2_r0_rwl u_t014_001/r2_r1_rwl
+ u_t014_001/r3_w0_wl u_t014_001/r3_w1_wl u_t014_001/r3_r0_rwl u_t014_001/r3_r1_rwl
+ VSS u_t014_002/VSS VSUBS detronyx_12t_2w2r_rc4_4x4_routed_5layer_direct
Xu_t005_023 u_t005_023/c0_w0_bl u_t005_023/c0_w0_br u_t005_023/c0_w1_bl u_t005_023/c0_w1_br
+ u_t005_023/c0_r0_rbl u_t005_023/c0_r1_rbl u_t005_023/c1_w0_bl u_t005_023/c1_w0_br
+ u_t005_023/c1_w1_bl u_t005_023/c1_w1_br u_t005_023/c1_r0_rbl u_t005_023/c1_r1_rbl
+ u_t005_023/c2_w0_bl u_t005_023/c2_w0_br u_t005_023/c2_w1_bl u_t005_023/c2_w1_br
+ u_t005_023/c2_r0_rbl u_t005_023/c2_r1_rbl u_t005_023/c3_w0_bl u_t005_023/c3_w0_br
+ u_t005_023/c3_w1_bl u_t005_023/c3_w1_br u_t005_023/c3_r0_rbl u_t005_023/c3_r1_rbl
+ u_t005_023/r0_w0_wl u_t005_023/r0_w1_wl u_t005_023/r0_r0_rwl u_t005_023/r0_r1_rwl
+ u_t005_023/r1_w0_wl u_t005_023/r1_w1_wl u_t005_023/r1_r0_rwl u_t005_023/r1_r1_rwl
+ u_t005_023/r2_w0_wl u_t005_023/r2_w1_wl u_t005_023/r2_r0_rwl u_t005_023/r2_r1_rwl
+ u_t005_023/r3_w0_wl u_t005_023/r3_w1_wl u_t005_023/r3_r0_rwl u_t005_023/r3_r1_rwl
+ VSS u_t005_031/VSS VSUBS detronyx_12t_2w2r_rc4_4x4_routed_5layer_direct
Xu_t005_012 u_t005_012/c0_w0_bl u_t005_012/c0_w0_br u_t005_012/c0_w1_bl u_t005_012/c0_w1_br
+ u_t005_012/c0_r0_rbl u_t005_012/c0_r1_rbl u_t005_012/c1_w0_bl u_t005_012/c1_w0_br
+ u_t005_012/c1_w1_bl u_t005_012/c1_w1_br u_t005_012/c1_r0_rbl u_t005_012/c1_r1_rbl
+ u_t005_012/c2_w0_bl u_t005_012/c2_w0_br u_t005_012/c2_w1_bl u_t005_012/c2_w1_br
+ u_t005_012/c2_r0_rbl u_t005_012/c2_r1_rbl u_t005_012/c3_w0_bl u_t005_012/c3_w0_br
+ u_t005_012/c3_w1_bl u_t005_012/c3_w1_br u_t005_012/c3_r0_rbl u_t005_012/c3_r1_rbl
+ u_t005_012/r0_w0_wl u_t005_012/r0_w1_wl u_t005_012/r0_r0_rwl u_t005_012/r0_r1_rwl
+ u_t005_012/r1_w0_wl u_t005_012/r1_w1_wl u_t005_012/r1_r0_rwl u_t005_012/r1_r1_rwl
+ u_t005_012/r2_w0_wl u_t005_012/r2_w1_wl u_t005_012/r2_r0_rwl u_t005_012/r2_r1_rwl
+ u_t005_012/r3_w0_wl u_t005_012/r3_w1_wl u_t005_012/r3_r0_rwl u_t005_012/r3_r1_rwl
+ u_t005_012/VDD u_t005_031/VSS VSUBS detronyx_12t_2w2r_rc4_4x4_routed_5layer_direct
Xu_t005_001 u_t005_001/c0_w0_bl u_t005_001/c0_w0_br u_t005_001/c0_w1_bl u_t005_001/c0_w1_br
+ u_t005_001/c0_r0_rbl u_t005_001/c0_r1_rbl u_t005_001/c1_w0_bl u_t005_001/c1_w0_br
+ u_t005_001/c1_w1_bl u_t005_001/c1_w1_br u_t005_001/c1_r0_rbl u_t005_001/c1_r1_rbl
+ u_t005_001/c2_w0_bl u_t005_001/c2_w0_br u_t005_001/c2_w1_bl u_t005_001/c2_w1_br
+ u_t005_001/c2_r0_rbl u_t005_001/c2_r1_rbl u_t005_001/c3_w0_bl u_t005_001/c3_w0_br
+ u_t005_001/c3_w1_bl u_t005_001/c3_w1_br u_t005_001/c3_r0_rbl u_t005_001/c3_r1_rbl
+ u_t005_001/r0_w0_wl u_t005_001/r0_w1_wl u_t005_001/r0_r0_rwl u_t005_001/r0_r1_rwl
+ u_t005_001/r1_w0_wl u_t005_001/r1_w1_wl u_t005_001/r1_r0_rwl u_t005_001/r1_r1_rwl
+ u_t005_001/r2_w0_wl u_t005_001/r2_w1_wl u_t005_001/r2_r0_rwl u_t005_001/r2_r1_rwl
+ u_t005_001/r3_w0_wl u_t005_001/r3_w1_wl u_t005_001/r3_r0_rwl u_t005_001/r3_r1_rwl
+ VSS u_t005_031/VSS VSUBS detronyx_12t_2w2r_rc4_4x4_routed_5layer_direct
Xu_t020_026 u_t020_026/c0_w0_bl u_t020_026/c0_w0_br u_t020_026/c0_w1_bl u_t020_026/c0_w1_br
+ u_t020_026/c0_r0_rbl u_t020_026/c0_r1_rbl u_t020_026/c1_w0_bl u_t020_026/c1_w0_br
+ u_t020_026/c1_w1_bl u_t020_026/c1_w1_br u_t020_026/c1_r0_rbl u_t020_026/c1_r1_rbl
+ u_t020_026/c2_w0_bl u_t020_026/c2_w0_br u_t020_026/c2_w1_bl u_t020_026/c2_w1_br
+ u_t020_026/c2_r0_rbl u_t020_026/c2_r1_rbl u_t020_026/c3_w0_bl u_t020_026/c3_w0_br
+ u_t020_026/c3_w1_bl u_t020_026/c3_w1_br u_t020_026/c3_r0_rbl u_t020_026/c3_r1_rbl
+ u_t020_026/r0_w0_wl u_t020_026/r0_w1_wl u_t020_026/r0_r0_rwl u_t020_026/r0_r1_rwl
+ u_t020_026/r1_w0_wl u_t020_026/r1_w1_wl u_t020_026/r1_r0_rwl u_t020_026/r1_r1_rwl
+ u_t020_026/r2_w0_wl u_t020_026/r2_w1_wl u_t020_026/r2_r0_rwl u_t020_026/r2_r1_rwl
+ u_t020_026/r3_w0_wl u_t020_026/r3_w1_wl u_t020_026/r3_r0_rwl u_t020_026/r3_r1_rwl
+ u_t020_026/VDD u_t020_026/VSS VSUBS detronyx_12t_2w2r_rc4_4x4_routed_5layer_direct
Xu_t020_015 u_t020_015/c0_w0_bl u_t020_015/c0_w0_br u_t020_015/c0_w1_bl u_t020_015/c0_w1_br
+ u_t020_015/c0_r0_rbl u_t020_015/c0_r1_rbl u_t020_015/c1_w0_bl u_t020_015/c1_w0_br
+ u_t020_015/c1_w1_bl u_t020_015/c1_w1_br u_t020_015/c1_r0_rbl u_t020_015/c1_r1_rbl
+ u_t020_015/c2_w0_bl u_t020_015/c2_w0_br u_t020_015/c2_w1_bl u_t020_015/c2_w1_br
+ u_t020_015/c2_r0_rbl u_t020_015/c2_r1_rbl u_t020_015/c3_w0_bl u_t020_015/c3_w0_br
+ u_t020_015/c3_w1_bl u_t020_015/c3_w1_br u_t020_015/c3_r0_rbl u_t020_015/c3_r1_rbl
+ u_t020_015/r0_w0_wl u_t020_015/r0_w1_wl u_t020_015/r0_r0_rwl u_t020_015/r0_r1_rwl
+ u_t020_015/r1_w0_wl u_t020_015/r1_w1_wl u_t020_015/r1_r0_rwl u_t020_015/r1_r1_rwl
+ u_t020_015/r2_w0_wl u_t020_015/r2_w1_wl u_t020_015/r2_r0_rwl u_t020_015/r2_r1_rwl
+ u_t020_015/r3_w0_wl u_t020_015/r3_w1_wl u_t020_015/r3_r0_rwl u_t020_015/r3_r1_rwl
+ VSS u_t020_017/VSS VSUBS detronyx_12t_2w2r_rc4_4x4_routed_5layer_direct
Xu_t020_004 u_t020_004/c0_w0_bl u_t020_004/c0_w0_br u_t020_004/c0_w1_bl u_t020_004/c0_w1_br
+ u_t020_004/c0_r0_rbl u_t020_004/c0_r1_rbl u_t020_004/c1_w0_bl u_t020_004/c1_w0_br
+ u_t020_004/c1_w1_bl u_t020_004/c1_w1_br u_t020_004/c1_r0_rbl u_t020_004/c1_r1_rbl
+ u_t020_004/c2_w0_bl u_t020_004/c2_w0_br u_t020_004/c2_w1_bl u_t020_004/c2_w1_br
+ u_t020_004/c2_r0_rbl u_t020_004/c2_r1_rbl u_t020_004/c3_w0_bl u_t020_004/c3_w0_br
+ u_t020_004/c3_w1_bl u_t020_004/c3_w1_br u_t020_004/c3_r0_rbl u_t020_004/c3_r1_rbl
+ u_t020_004/r0_w0_wl u_t020_004/r0_w1_wl u_t020_004/r0_r0_rwl u_t020_004/r0_r1_rwl
+ u_t020_004/r1_w0_wl u_t020_004/r1_w1_wl u_t020_004/r1_r0_rwl u_t020_004/r1_r1_rwl
+ u_t020_004/r2_w0_wl u_t020_004/r2_w1_wl u_t020_004/r2_r0_rwl u_t020_004/r2_r1_rwl
+ u_t020_004/r3_w0_wl u_t020_004/r3_w1_wl u_t020_004/r3_r0_rwl u_t020_004/r3_r1_rwl
+ u_t020_004/VDD u_t020_004/VSS VSUBS detronyx_12t_2w2r_rc4_4x4_routed_5layer_direct
Xgf180mcu_as_sc_mcu7t3v3__inv_2_1419 gf180mcu_as_sc_mcu7t3v3__inv_2_1420/VDD VSS VSS
+ VSS gf180mcu_as_sc_mcu7t3v3__inv_2_1420/VNW VSUBS gf180mcu_as_sc_mcu7t3v3__inv_2
Xgf180mcu_as_sc_mcu7t3v3__inv_2_1408 VSS VSS VSS VSS gf180mcu_as_sc_mcu7t3v3__inv_2_1408/VNW
+ VSUBS gf180mcu_as_sc_mcu7t3v3__inv_2
Xu_t011_026 u_t011_026/c0_w0_bl u_t011_026/c0_w0_br u_t011_026/c0_w1_bl u_t011_026/c0_w1_br
+ u_t011_026/c0_r0_rbl u_t011_026/c0_r1_rbl u_t011_026/c1_w0_bl u_t011_026/c1_w0_br
+ u_t011_026/c1_w1_bl u_t011_026/c1_w1_br u_t011_026/c1_r0_rbl u_t011_026/c1_r1_rbl
+ u_t011_026/c2_w0_bl u_t011_026/c2_w0_br u_t011_026/c2_w1_bl u_t011_026/c2_w1_br
+ u_t011_026/c2_r0_rbl u_t011_026/c2_r1_rbl u_t011_026/c3_w0_bl u_t011_026/c3_w0_br
+ u_t011_026/c3_w1_bl u_t011_026/c3_w1_br u_t011_026/c3_r0_rbl u_t011_026/c3_r1_rbl
+ u_t011_026/r0_w0_wl u_t011_026/r0_w1_wl u_t011_026/r0_r0_rwl u_t011_026/r0_r1_rwl
+ u_t011_026/r1_w0_wl u_t011_026/r1_w1_wl u_t011_026/r1_r0_rwl u_t011_026/r1_r1_rwl
+ u_t011_026/r2_w0_wl u_t011_026/r2_w1_wl u_t011_026/r2_r0_rwl u_t011_026/r2_r1_rwl
+ u_t011_026/r3_w0_wl u_t011_026/r3_w1_wl u_t011_026/r3_r0_rwl u_t011_026/r3_r1_rwl
+ u_t011_026/VDD u_t011_026/VSS VSUBS detronyx_12t_2w2r_rc4_4x4_routed_5layer_direct
Xu_t011_015 u_t011_015/c0_w0_bl u_t011_015/c0_w0_br u_t011_015/c0_w1_bl u_t011_015/c0_w1_br
+ u_t011_015/c0_r0_rbl u_t011_015/c0_r1_rbl u_t011_015/c1_w0_bl u_t011_015/c1_w0_br
+ u_t011_015/c1_w1_bl u_t011_015/c1_w1_br u_t011_015/c1_r0_rbl u_t011_015/c1_r1_rbl
+ u_t011_015/c2_w0_bl u_t011_015/c2_w0_br u_t011_015/c2_w1_bl u_t011_015/c2_w1_br
+ u_t011_015/c2_r0_rbl u_t011_015/c2_r1_rbl u_t011_015/c3_w0_bl u_t011_015/c3_w0_br
+ u_t011_015/c3_w1_bl u_t011_015/c3_w1_br u_t011_015/c3_r0_rbl u_t011_015/c3_r1_rbl
+ u_t011_015/r0_w0_wl u_t011_015/r0_w1_wl u_t011_015/r0_r0_rwl u_t011_015/r0_r1_rwl
+ u_t011_015/r1_w0_wl u_t011_015/r1_w1_wl u_t011_015/r1_r0_rwl u_t011_015/r1_r1_rwl
+ u_t011_015/r2_w0_wl u_t011_015/r2_w1_wl u_t011_015/r2_r0_rwl u_t011_015/r2_r1_rwl
+ u_t011_015/r3_w0_wl u_t011_015/r3_w1_wl u_t011_015/r3_r0_rwl u_t011_015/r3_r1_rwl
+ VSS u_t011_017/VSS VSUBS detronyx_12t_2w2r_rc4_4x4_routed_5layer_direct
Xu_t011_004 u_t011_004/c0_w0_bl u_t011_004/c0_w0_br u_t011_004/c0_w1_bl u_t011_004/c0_w1_br
+ u_t011_004/c0_r0_rbl u_t011_004/c0_r1_rbl u_t011_004/c1_w0_bl u_t011_004/c1_w0_br
+ u_t011_004/c1_w1_bl u_t011_004/c1_w1_br u_t011_004/c1_r0_rbl u_t011_004/c1_r1_rbl
+ u_t011_004/c2_w0_bl u_t011_004/c2_w0_br u_t011_004/c2_w1_bl u_t011_004/c2_w1_br
+ u_t011_004/c2_r0_rbl u_t011_004/c2_r1_rbl u_t011_004/c3_w0_bl u_t011_004/c3_w0_br
+ u_t011_004/c3_w1_bl u_t011_004/c3_w1_br u_t011_004/c3_r0_rbl u_t011_004/c3_r1_rbl
+ u_t011_004/r0_w0_wl u_t011_004/r0_w1_wl u_t011_004/r0_r0_rwl u_t011_004/r0_r1_rwl
+ u_t011_004/r1_w0_wl u_t011_004/r1_w1_wl u_t011_004/r1_r0_rwl u_t011_004/r1_r1_rwl
+ u_t011_004/r2_w0_wl u_t011_004/r2_w1_wl u_t011_004/r2_r0_rwl u_t011_004/r2_r1_rwl
+ u_t011_004/r3_w0_wl u_t011_004/r3_w1_wl u_t011_004/r3_r0_rwl u_t011_004/r3_r1_rwl
+ u_t011_004/VDD u_t011_004/VSS VSUBS detronyx_12t_2w2r_rc4_4x4_routed_5layer_direct
Xu_t002_026 u_t002_026/c0_w0_bl u_t002_026/c0_w0_br u_t002_026/c0_w1_bl u_t002_026/c0_w1_br
+ u_t002_026/c0_r0_rbl u_t002_026/c0_r1_rbl u_t002_026/c1_w0_bl u_t002_026/c1_w0_br
+ u_t002_026/c1_w1_bl u_t002_026/c1_w1_br u_t002_026/c1_r0_rbl u_t002_026/c1_r1_rbl
+ u_t002_026/c2_w0_bl u_t002_026/c2_w0_br u_t002_026/c2_w1_bl u_t002_026/c2_w1_br
+ u_t002_026/c2_r0_rbl u_t002_026/c2_r1_rbl u_t002_026/c3_w0_bl u_t002_026/c3_w0_br
+ u_t002_026/c3_w1_bl u_t002_026/c3_w1_br u_t002_026/c3_r0_rbl u_t002_026/c3_r1_rbl
+ u_t002_026/r0_w0_wl u_t002_026/r0_w1_wl u_t002_026/r0_r0_rwl u_t002_026/r0_r1_rwl
+ u_t002_026/r1_w0_wl u_t002_026/r1_w1_wl u_t002_026/r1_r0_rwl u_t002_026/r1_r1_rwl
+ u_t002_026/r2_w0_wl u_t002_026/r2_w1_wl u_t002_026/r2_r0_rwl u_t002_026/r2_r1_rwl
+ u_t002_026/r3_w0_wl u_t002_026/r3_w1_wl u_t002_026/r3_r0_rwl u_t002_026/r3_r1_rwl
+ u_t002_026/VDD u_t002_026/VSS VSUBS detronyx_12t_2w2r_rc4_4x4_routed_5layer_direct
Xu_t002_015 u_t002_015/c0_w0_bl u_t002_015/c0_w0_br u_t002_015/c0_w1_bl u_t002_015/c0_w1_br
+ u_t002_015/c0_r0_rbl u_t002_015/c0_r1_rbl u_t002_015/c1_w0_bl u_t002_015/c1_w0_br
+ u_t002_015/c1_w1_bl u_t002_015/c1_w1_br u_t002_015/c1_r0_rbl u_t002_015/c1_r1_rbl
+ u_t002_015/c2_w0_bl u_t002_015/c2_w0_br u_t002_015/c2_w1_bl u_t002_015/c2_w1_br
+ u_t002_015/c2_r0_rbl u_t002_015/c2_r1_rbl u_t002_015/c3_w0_bl u_t002_015/c3_w0_br
+ u_t002_015/c3_w1_bl u_t002_015/c3_w1_br u_t002_015/c3_r0_rbl u_t002_015/c3_r1_rbl
+ u_t002_015/r0_w0_wl u_t002_015/r0_w1_wl u_t002_015/r0_r0_rwl u_t002_015/r0_r1_rwl
+ u_t002_015/r1_w0_wl u_t002_015/r1_w1_wl u_t002_015/r1_r0_rwl u_t002_015/r1_r1_rwl
+ u_t002_015/r2_w0_wl u_t002_015/r2_w1_wl u_t002_015/r2_r0_rwl u_t002_015/r2_r1_rwl
+ u_t002_015/r3_w0_wl u_t002_015/r3_w1_wl u_t002_015/r3_r0_rwl u_t002_015/r3_r1_rwl
+ VSS u_t002_017/VSS VSUBS detronyx_12t_2w2r_rc4_4x4_routed_5layer_direct
Xu_t002_004 u_t002_004/c0_w0_bl u_t002_004/c0_w0_br u_t002_004/c0_w1_bl u_t002_004/c0_w1_br
+ u_t002_004/c0_r0_rbl u_t002_004/c0_r1_rbl u_t002_004/c1_w0_bl u_t002_004/c1_w0_br
+ u_t002_004/c1_w1_bl u_t002_004/c1_w1_br u_t002_004/c1_r0_rbl u_t002_004/c1_r1_rbl
+ u_t002_004/c2_w0_bl u_t002_004/c2_w0_br u_t002_004/c2_w1_bl u_t002_004/c2_w1_br
+ u_t002_004/c2_r0_rbl u_t002_004/c2_r1_rbl u_t002_004/c3_w0_bl u_t002_004/c3_w0_br
+ u_t002_004/c3_w1_bl u_t002_004/c3_w1_br u_t002_004/c3_r0_rbl u_t002_004/c3_r1_rbl
+ u_t002_004/r0_w0_wl u_t002_004/r0_w1_wl u_t002_004/r0_r0_rwl u_t002_004/r0_r1_rwl
+ u_t002_004/r1_w0_wl u_t002_004/r1_w1_wl u_t002_004/r1_r0_rwl u_t002_004/r1_r1_rwl
+ u_t002_004/r2_w0_wl u_t002_004/r2_w1_wl u_t002_004/r2_r0_rwl u_t002_004/r2_r1_rwl
+ u_t002_004/r3_w0_wl u_t002_004/r3_w1_wl u_t002_004/r3_r0_rwl u_t002_004/r3_r1_rwl
+ u_t002_004/VDD u_t002_004/VSS VSUBS detronyx_12t_2w2r_rc4_4x4_routed_5layer_direct
Xgf180mcu_as_sc_mcu7t3v3__inv_2_1216 gf180mcu_as_sc_mcu7t3v3__nand3_2_31/VDD gf180mcu_as_sc_mcu7t3v3__nor2_2_8/VSS
+ VSS VSS gf180mcu_as_sc_mcu7t3v3__nand3_2_31/VNW VSUBS gf180mcu_as_sc_mcu7t3v3__inv_2
Xgf180mcu_as_sc_mcu7t3v3__inv_2_1205 gf180mcu_as_sc_mcu7t3v3__nand3_2_31/VDD gf180mcu_as_sc_mcu7t3v3__nand3_2_31/VSS
+ VSS VSS gf180mcu_as_sc_mcu7t3v3__nand3_2_31/VNW VSUBS gf180mcu_as_sc_mcu7t3v3__inv_2
Xgf180mcu_as_sc_mcu7t3v3__inv_2_1249 VSS VSS VSS VSS gf180mcu_as_sc_mcu7t3v3__inv_2_1284/VNW
+ VSUBS gf180mcu_as_sc_mcu7t3v3__inv_2
Xgf180mcu_as_sc_mcu7t3v3__inv_2_1238 VSS VSS VSS VSS gf180mcu_as_sc_mcu7t3v3__inv_2_1245/VNW
+ VSUBS gf180mcu_as_sc_mcu7t3v3__inv_2
Xgf180mcu_as_sc_mcu7t3v3__inv_2_1227 VSS VSS VSS VSS gf180mcu_as_sc_mcu7t3v3__inv_2_1229/VNW
+ VSUBS gf180mcu_as_sc_mcu7t3v3__inv_2
Xgf180mcu_as_sc_mcu7t3v3__nand4_2_500 VSS gf180mcu_as_sc_mcu7t3v3__inv_2_1671/VDD
+ VSS VSS VSS VSS VSS gf180mcu_as_sc_mcu7t3v3__inv_2_1670/VNW VSUBS gf180mcu_as_sc_mcu7t3v3__nand4_2
Xgf180mcu_as_sc_mcu7t3v3__nand4_2_511 gf180mcu_as_sc_mcu7t3v3__inv_2_1694/VDD VSS
+ VSS VSS VSS VSS gf180mcu_as_sc_mcu7t3v3__nand4_2_511/Y gf180mcu_as_sc_mcu7t3v3__inv_2_1694/VNW
+ VSUBS gf180mcu_as_sc_mcu7t3v3__nand4_2
Xgf180mcu_as_sc_mcu7t3v3__inv_2_1013 VSS VSS VSS gf180mcu_as_sc_mcu7t3v3__inv_2_1052/A
+ gf180mcu_as_sc_mcu7t3v3__inv_2_1015/VNW VSUBS gf180mcu_as_sc_mcu7t3v3__inv_2
Xgf180mcu_as_sc_mcu7t3v3__inv_2_1024 VSS gf180mcu_as_sc_mcu7t3v3__inv_2_1030/VDD VSS
+ gf180mcu_as_sc_mcu7t3v3__inv_2_992/A gf180mcu_as_sc_mcu7t3v3__inv_2_1026/VNW VSUBS
+ gf180mcu_as_sc_mcu7t3v3__inv_2
Xgf180mcu_as_sc_mcu7t3v3__inv_2_54 gf180mcu_as_sc_mcu7t3v3__inv_2_69/VSS gf180mcu_as_sc_mcu7t3v3__inv_2_2/VDD
+ gf180mcu_as_sc_mcu7t3v3__inv_2_2/A VSS gf180mcu_as_sc_mcu7t3v3__inv_2_54/VNW VSUBS
+ gf180mcu_as_sc_mcu7t3v3__inv_2
Xgf180mcu_as_sc_mcu7t3v3__inv_2_98 gf180mcu_as_sc_mcu7t3v3__inv_2_99/VDD gf180mcu_as_sc_mcu7t3v3__inv_2_99/VSS
+ gf180mcu_as_sc_mcu7t3v3__inv_2_98/Y VSS gf180mcu_as_sc_mcu7t3v3__inv_2_99/VNW VSUBS
+ gf180mcu_as_sc_mcu7t3v3__inv_2
Xgf180mcu_as_sc_mcu7t3v3__inv_2_10 gf180mcu_as_sc_mcu7t3v3__inv_2_9/VSS gf180mcu_as_sc_mcu7t3v3__inv_2_9/VSS
+ gf180mcu_as_sc_mcu7t3v3__inv_2_9/A gf180mcu_as_sc_mcu7t3v3__inv_2_9/A gf180mcu_as_sc_mcu7t3v3__inv_2_9/VNW
+ VSUBS gf180mcu_as_sc_mcu7t3v3__inv_2
Xgf180mcu_as_sc_mcu7t3v3__inv_2_87 gf180mcu_as_sc_mcu7t3v3__inv_2_88/VSS gf180mcu_as_sc_mcu7t3v3__inv_2_91/VDD
+ gf180mcu_as_sc_mcu7t3v3__inv_2_87/Y VSS gf180mcu_as_sc_mcu7t3v3__inv_2_87/VNW VSUBS
+ gf180mcu_as_sc_mcu7t3v3__inv_2
Xgf180mcu_as_sc_mcu7t3v3__inv_2_32 gf180mcu_as_sc_mcu7t3v3__inv_2_77/VDD gf180mcu_as_sc_mcu7t3v3__inv_2_77/VSS
+ VSS gf180mcu_as_sc_mcu7t3v3__inv_2_77/Y gf180mcu_as_sc_mcu7t3v3__inv_2_77/VNW VSUBS
+ gf180mcu_as_sc_mcu7t3v3__inv_2
Xgf180mcu_as_sc_mcu7t3v3__inv_2_76 VSS gf180mcu_as_sc_mcu7t3v3__inv_2_77/VDD gf180mcu_as_sc_mcu7t3v3__inv_2_77/Y
+ VSS gf180mcu_as_sc_mcu7t3v3__inv_2_76/VNW VSUBS gf180mcu_as_sc_mcu7t3v3__inv_2
Xgf180mcu_as_sc_mcu7t3v3__inv_2_43 gf180mcu_as_sc_mcu7t3v3__inv_2_70/VDD gf180mcu_as_sc_mcu7t3v3__inv_2_71/VDD
+ VSS gf180mcu_as_sc_mcu7t3v3__inv_2_71/Y gf180mcu_as_sc_mcu7t3v3__inv_2_70/VNW VSUBS
+ gf180mcu_as_sc_mcu7t3v3__inv_2
Xgf180mcu_as_sc_mcu7t3v3__inv_2_21 gf180mcu_as_sc_mcu7t3v3__inv_2_66/VSS gf180mcu_as_sc_mcu7t3v3__inv_2_70/VDD
+ gf180mcu_as_sc_mcu7t3v3__inv_2_21/Y gf180mcu_as_sc_mcu7t3v3__inv_2_66/Y gf180mcu_as_sc_mcu7t3v3__inv_2_63/VNW
+ VSUBS gf180mcu_as_sc_mcu7t3v3__inv_2
Xgf180mcu_as_sc_mcu7t3v3__inv_2_65 gf180mcu_as_sc_mcu7t3v3__inv_2_65/VDD gf180mcu_as_sc_mcu7t3v3__inv_2_66/VDD
+ gf180mcu_as_sc_mcu7t3v3__inv_2_66/Y VSS gf180mcu_as_sc_mcu7t3v3__inv_2_65/VNW VSUBS
+ gf180mcu_as_sc_mcu7t3v3__inv_2
Xgf180mcu_as_sc_mcu7t3v3__inv_2_1002 VSS gf180mcu_as_sc_mcu7t3v3__inv_2_967/VDD gf180mcu_as_sc_mcu7t3v3__inv_2_1002/Y
+ VSS gf180mcu_as_sc_mcu7t3v3__inv_2_1002/VNW VSUBS gf180mcu_as_sc_mcu7t3v3__inv_2
Xgf180mcu_as_sc_mcu7t3v3__inv_2_1079 gf180mcu_as_sc_mcu7t3v3__inv_2_1080/VDD gf180mcu_as_sc_mcu7t3v3__inv_2_1084/VDD
+ gf180mcu_as_sc_mcu7t3v3__inv_2_1079/Y gf180mcu_as_sc_mcu7t3v3__inv_2_1080/Y gf180mcu_as_sc_mcu7t3v3__inv_2_1080/VNW
+ VSUBS gf180mcu_as_sc_mcu7t3v3__inv_2
Xgf180mcu_as_sc_mcu7t3v3__inv_2_1057 gf180mcu_as_sc_mcu7t3v3__inv_2_1107/VDD VSS gf180mcu_as_sc_mcu7t3v3__inv_2_1107/A
+ VSS gf180mcu_as_sc_mcu7t3v3__inv_2_1107/VNW VSUBS gf180mcu_as_sc_mcu7t3v3__inv_2
Xgf180mcu_as_sc_mcu7t3v3__inv_2_1068 gf180mcu_as_sc_mcu7t3v3__inv_2_1089/VSS gf180mcu_as_sc_mcu7t3v3__inv_2_1295/VDD
+ gf180mcu_as_sc_mcu7t3v3__inv_2_1068/Y VSS gf180mcu_as_sc_mcu7t3v3__inv_2_1068/VNW
+ VSUBS gf180mcu_as_sc_mcu7t3v3__inv_2
Xgf180mcu_as_sc_mcu7t3v3__inv_2_1035 VSS VSS gf180mcu_as_sc_mcu7t3v3__inv_2_1035/Y
+ VSS gf180mcu_as_sc_mcu7t3v3__inv_2_1035/VNW VSUBS gf180mcu_as_sc_mcu7t3v3__inv_2
Xgf180mcu_as_sc_mcu7t3v3__inv_2_1046 gf180mcu_as_sc_mcu7t3v3__inv_2_1046/VDD VSS gf180mcu_as_sc_mcu7t3v3__inv_2_1046/Y
+ VSS gf180mcu_as_sc_mcu7t3v3__inv_2_1046/VNW VSUBS gf180mcu_as_sc_mcu7t3v3__inv_2
Xgf180mcu_as_sc_mcu7t3v3__inv_2_508 VSS VSS gf180mcu_as_sc_mcu7t3v3__inv_2_508/Y VSS
+ gf180mcu_as_sc_mcu7t3v3__inv_2_510/VNW VSUBS gf180mcu_as_sc_mcu7t3v3__inv_2
Xgf180mcu_as_sc_mcu7t3v3__inv_2_519 VSS VSS VSS VSS gf180mcu_as_sc_mcu7t3v3__inv_2_535/VNW
+ VSUBS gf180mcu_as_sc_mcu7t3v3__inv_2
Xgf180mcu_as_sc_mcu7t3v3__inv_2_1580 gf180mcu_as_sc_mcu7t3v3__inv_2_1581/VDD VSS VSS
+ VSS gf180mcu_as_sc_mcu7t3v3__inv_2_1581/VNW VSUBS gf180mcu_as_sc_mcu7t3v3__inv_2
Xgf180mcu_as_sc_mcu7t3v3__inv_2_1591 VSS gf180mcu_as_sc_mcu7t3v3__inv_2_1592/VSS gf180mcu_as_sc_mcu7t3v3__inv_2_1591/Y
+ VSS gf180mcu_as_sc_mcu7t3v3__inv_2_1592/VNW VSUBS gf180mcu_as_sc_mcu7t3v3__inv_2
Xgf180mcu_as_sc_mcu7t3v3__nand3_2_2 gf180mcu_as_sc_mcu7t3v3__nor2_2_6/VDD gf180mcu_as_sc_mcu7t3v3__nor2_2_6/VSS
+ VSS VSS VSS VSS gf180mcu_as_sc_mcu7t3v3__nor2_2_6/VNW VSUBS gf180mcu_as_sc_mcu7t3v3__nand3_2
Xgf180mcu_as_sc_mcu7t3v3__nand4_2_352 VSS VSS VSS VSS VSS VSS gf180mcu_as_sc_mcu7t3v3__nand4_2_352/Y
+ gf180mcu_as_sc_mcu7t3v3__inv_2_1281/VNW VSUBS gf180mcu_as_sc_mcu7t3v3__nand4_2
Xgf180mcu_as_sc_mcu7t3v3__nand4_2_341 gf180mcu_as_sc_mcu7t3v3__inv_2_1141/VDD gf180mcu_as_sc_mcu7t3v3__inv_2_1143/VDD
+ VSS VSS VSS VSS VSS gf180mcu_as_sc_mcu7t3v3__inv_2_1141/VNW VSUBS gf180mcu_as_sc_mcu7t3v3__nand4_2
Xgf180mcu_as_sc_mcu7t3v3__nand4_2_363 VSS VSS VSS VSS VSS VSS gf180mcu_as_sc_mcu7t3v3__nand4_2_363/Y
+ gf180mcu_as_sc_mcu7t3v3__inv_2_1177/VNW VSUBS gf180mcu_as_sc_mcu7t3v3__nand4_2
Xgf180mcu_as_sc_mcu7t3v3__nand4_2_330 gf180mcu_as_sc_mcu7t3v3__inv_2_1107/VDD VSS
+ VSS VSS VSS VSS VSS gf180mcu_as_sc_mcu7t3v3__inv_2_1107/VNW VSUBS gf180mcu_as_sc_mcu7t3v3__nand4_2
Xgf180mcu_as_sc_mcu7t3v3__nand4_2_374 VSS VSS VSS VSS VSS VSS VSS gf180mcu_as_sc_mcu7t3v3__inv_2_1162/VNW
+ VSUBS gf180mcu_as_sc_mcu7t3v3__nand4_2
Xgf180mcu_as_sc_mcu7t3v3__nand4_2_396 gf180mcu_as_sc_mcu7t3v3__inv_2_1400/VDD gf180mcu_as_sc_mcu7t3v3__inv_2_1400/VSS
+ VSS VSS VSS VSS VSS gf180mcu_as_sc_mcu7t3v3__inv_2_1400/VNW VSUBS gf180mcu_as_sc_mcu7t3v3__nand4_2
Xgf180mcu_as_sc_mcu7t3v3__nand4_2_385 VSS gf180mcu_as_sc_mcu7t3v3__inv_2_1378/VDD
+ VSS VSS VSS VSS VSS gf180mcu_as_sc_mcu7t3v3__inv_2_1377/VNW VSUBS gf180mcu_as_sc_mcu7t3v3__nand4_2
Xgf180mcu_as_sc_mcu7t3v3__inv_2_316 VSS gf180mcu_as_sc_mcu7t3v3__inv_2_337/VDD VSS
+ gf180mcu_as_sc_mcu7t3v3__inv_2_338/Y gf180mcu_as_sc_mcu7t3v3__inv_2_336/VNW VSUBS
+ gf180mcu_as_sc_mcu7t3v3__inv_2
Xgf180mcu_as_sc_mcu7t3v3__inv_2_305 gf180mcu_as_sc_mcu7t3v3__inv_2_332/VDD VSS gf180mcu_as_sc_mcu7t3v3__inv_2_338/Y
+ gf180mcu_as_sc_mcu7t3v3__inv_2_338/Y gf180mcu_as_sc_mcu7t3v3__inv_2_332/VNW VSUBS
+ gf180mcu_as_sc_mcu7t3v3__inv_2
Xgf180mcu_as_sc_mcu7t3v3__inv_2_349 VSS gf180mcu_as_sc_mcu7t3v3__inv_2_350/VDD gf180mcu_as_sc_mcu7t3v3__inv_2_66/Y
+ VSS gf180mcu_as_sc_mcu7t3v3__inv_2_349/VNW VSUBS gf180mcu_as_sc_mcu7t3v3__inv_2
Xgf180mcu_as_sc_mcu7t3v3__inv_2_327 VSS VSS VSS gf180mcu_as_sc_mcu7t3v3__inv_2_358/Y
+ gf180mcu_as_sc_mcu7t3v3__inv_2_345/VNW VSUBS gf180mcu_as_sc_mcu7t3v3__inv_2
Xgf180mcu_as_sc_mcu7t3v3__inv_2_338 gf180mcu_as_sc_mcu7t3v3__inv_2_338/VDD VSS gf180mcu_as_sc_mcu7t3v3__inv_2_338/Y
+ VSS gf180mcu_as_sc_mcu7t3v3__inv_2_338/VNW VSUBS gf180mcu_as_sc_mcu7t3v3__inv_2
Xgf180mcu_as_sc_mcu7t3v3__inv_2_850 VSS VSS gf180mcu_as_sc_mcu7t3v3__inv_2_850/Y VSS
+ gf180mcu_as_sc_mcu7t3v3__inv_2_852/VNW VSUBS gf180mcu_as_sc_mcu7t3v3__inv_2
Xgf180mcu_as_sc_mcu7t3v3__inv_2_861 VSS VSS VSS VSS gf180mcu_as_sc_mcu7t3v3__inv_2_865/VNW
+ VSUBS gf180mcu_as_sc_mcu7t3v3__inv_2
Xgf180mcu_as_sc_mcu7t3v3__inv_2_872 VSS VSS VSS VSS gf180mcu_as_sc_mcu7t3v3__inv_2_872/VNW
+ VSUBS gf180mcu_as_sc_mcu7t3v3__inv_2
Xgf180mcu_as_sc_mcu7t3v3__inv_2_894 VSS VSS VSS VSS gf180mcu_as_sc_mcu7t3v3__inv_2_896/VNW
+ VSUBS gf180mcu_as_sc_mcu7t3v3__inv_2
Xgf180mcu_as_sc_mcu7t3v3__inv_2_883 VSS VSS VSS VSS gf180mcu_as_sc_mcu7t3v3__inv_2_884/VNW
+ VSUBS gf180mcu_as_sc_mcu7t3v3__inv_2
Xu_t026_021 u_t026_021/c0_w0_bl u_t026_021/c0_w0_br u_t026_021/c0_w1_bl u_t026_021/c0_w1_br
+ u_t026_021/c0_r0_rbl u_t026_021/c0_r1_rbl u_t026_021/c1_w0_bl u_t026_021/c1_w0_br
+ u_t026_021/c1_w1_bl u_t026_021/c1_w1_br u_t026_021/c1_r0_rbl u_t026_021/c1_r1_rbl
+ u_t026_021/c2_w0_bl u_t026_021/c2_w0_br u_t026_021/c2_w1_bl u_t026_021/c2_w1_br
+ u_t026_021/c2_r0_rbl u_t026_021/c2_r1_rbl u_t026_021/c3_w0_bl u_t026_021/c3_w0_br
+ u_t026_021/c3_w1_bl u_t026_021/c3_w1_br u_t026_021/c3_r0_rbl u_t026_021/c3_r1_rbl
+ u_t026_021/r0_w0_wl u_t026_021/r0_w1_wl u_t026_021/r0_r0_rwl u_t026_021/r0_r1_rwl
+ u_t026_021/r1_w0_wl u_t026_021/r1_w1_wl u_t026_021/r1_r0_rwl u_t026_021/r1_r1_rwl
+ u_t026_021/r2_w0_wl u_t026_021/r2_w1_wl u_t026_021/r2_r0_rwl u_t026_021/r2_r1_rwl
+ u_t026_021/r3_w0_wl u_t026_021/r3_w1_wl u_t026_021/r3_r0_rwl u_t026_021/r3_r1_rwl
+ u_t026_021/VDD u_t026_031/VSS VSUBS detronyx_12t_2w2r_rc4_4x4_routed_5layer_direct
Xu_t026_010 u_t026_010/c0_w0_bl u_t026_010/c0_w0_br u_t026_010/c0_w1_bl u_t026_010/c0_w1_br
+ u_t026_010/c0_r0_rbl u_t026_010/c0_r1_rbl u_t026_010/c1_w0_bl u_t026_010/c1_w0_br
+ u_t026_010/c1_w1_bl u_t026_010/c1_w1_br u_t026_010/c1_r0_rbl u_t026_010/c1_r1_rbl
+ u_t026_010/c2_w0_bl u_t026_010/c2_w0_br u_t026_010/c2_w1_bl u_t026_010/c2_w1_br
+ u_t026_010/c2_r0_rbl u_t026_010/c2_r1_rbl u_t026_010/c3_w0_bl u_t026_010/c3_w0_br
+ u_t026_010/c3_w1_bl u_t026_010/c3_w1_br u_t026_010/c3_r0_rbl u_t026_010/c3_r1_rbl
+ u_t026_010/r0_w0_wl u_t026_010/r0_w1_wl u_t026_010/r0_r0_rwl u_t026_010/r0_r1_rwl
+ u_t026_010/r1_w0_wl u_t026_010/r1_w1_wl u_t026_010/r1_r0_rwl u_t026_010/r1_r1_rwl
+ u_t026_010/r2_w0_wl u_t026_010/r2_w1_wl u_t026_010/r2_r0_rwl u_t026_010/r2_r1_rwl
+ u_t026_010/r3_w0_wl u_t026_010/r3_w1_wl u_t026_010/r3_r0_rwl u_t026_010/r3_r1_rwl
+ VSS u_t026_031/VSS VSUBS detronyx_12t_2w2r_rc4_4x4_routed_5layer_direct
Xgf180mcu_as_sc_mcu7t3v3__nand4_2_160 gf180mcu_as_sc_mcu7t3v3__inv_2_585/VSS VSS VSS
+ VSS VSS VSS VSS gf180mcu_as_sc_mcu7t3v3__inv_2_581/VNW VSUBS gf180mcu_as_sc_mcu7t3v3__nand4_2
Xgf180mcu_as_sc_mcu7t3v3__nand4_2_171 VSS gf180mcu_as_sc_mcu7t3v3__inv_2_597/VDD VSS
+ VSS VSS VSS VSS gf180mcu_as_sc_mcu7t3v3__inv_2_593/VNW VSUBS gf180mcu_as_sc_mcu7t3v3__nand4_2
Xgf180mcu_as_sc_mcu7t3v3__nand4_2_193 VSS VSS VSS VSS VSS VSS VSS gf180mcu_as_sc_mcu7t3v3__inv_2_720/VNW
+ VSUBS gf180mcu_as_sc_mcu7t3v3__nand4_2
Xgf180mcu_as_sc_mcu7t3v3__nand4_2_182 gf180mcu_as_sc_mcu7t3v3__inv_2_724/VSS gf180mcu_as_sc_mcu7t3v3__inv_2_711/VDD
+ VSS VSS VSS VSS VSS gf180mcu_as_sc_mcu7t3v3__inv_2_703/VNW VSUBS gf180mcu_as_sc_mcu7t3v3__nand4_2
Xu_t017_021 u_t017_021/c0_w0_bl u_t017_021/c0_w0_br u_t017_021/c0_w1_bl u_t017_021/c0_w1_br
+ u_t017_021/c0_r0_rbl u_t017_021/c0_r1_rbl u_t017_021/c1_w0_bl u_t017_021/c1_w0_br
+ u_t017_021/c1_w1_bl u_t017_021/c1_w1_br u_t017_021/c1_r0_rbl u_t017_021/c1_r1_rbl
+ u_t017_021/c2_w0_bl u_t017_021/c2_w0_br u_t017_021/c2_w1_bl u_t017_021/c2_w1_br
+ u_t017_021/c2_r0_rbl u_t017_021/c2_r1_rbl u_t017_021/c3_w0_bl u_t017_021/c3_w0_br
+ u_t017_021/c3_w1_bl u_t017_021/c3_w1_br u_t017_021/c3_r0_rbl u_t017_021/c3_r1_rbl
+ u_t017_021/r0_w0_wl u_t017_021/r0_w1_wl u_t017_021/r0_r0_rwl u_t017_021/r0_r1_rwl
+ u_t017_021/r1_w0_wl u_t017_021/r1_w1_wl u_t017_021/r1_r0_rwl u_t017_021/r1_r1_rwl
+ u_t017_021/r2_w0_wl u_t017_021/r2_w1_wl u_t017_021/r2_r0_rwl u_t017_021/r2_r1_rwl
+ u_t017_021/r3_w0_wl u_t017_021/r3_w1_wl u_t017_021/r3_r0_rwl u_t017_021/r3_r1_rwl
+ u_t017_021/VDD u_t017_031/VSS VSUBS detronyx_12t_2w2r_rc4_4x4_routed_5layer_direct
Xu_t017_010 u_t017_010/c0_w0_bl u_t017_010/c0_w0_br u_t017_010/c0_w1_bl u_t017_010/c0_w1_br
+ u_t017_010/c0_r0_rbl u_t017_010/c0_r1_rbl u_t017_010/c1_w0_bl u_t017_010/c1_w0_br
+ u_t017_010/c1_w1_bl u_t017_010/c1_w1_br u_t017_010/c1_r0_rbl u_t017_010/c1_r1_rbl
+ u_t017_010/c2_w0_bl u_t017_010/c2_w0_br u_t017_010/c2_w1_bl u_t017_010/c2_w1_br
+ u_t017_010/c2_r0_rbl u_t017_010/c2_r1_rbl u_t017_010/c3_w0_bl u_t017_010/c3_w0_br
+ u_t017_010/c3_w1_bl u_t017_010/c3_w1_br u_t017_010/c3_r0_rbl u_t017_010/c3_r1_rbl
+ u_t017_010/r0_w0_wl u_t017_010/r0_w1_wl u_t017_010/r0_r0_rwl u_t017_010/r0_r1_rwl
+ u_t017_010/r1_w0_wl u_t017_010/r1_w1_wl u_t017_010/r1_r0_rwl u_t017_010/r1_r1_rwl
+ u_t017_010/r2_w0_wl u_t017_010/r2_w1_wl u_t017_010/r2_r0_rwl u_t017_010/r2_r1_rwl
+ u_t017_010/r3_w0_wl u_t017_010/r3_w1_wl u_t017_010/r3_r0_rwl u_t017_010/r3_r1_rwl
+ VSS u_t017_031/VSS VSUBS detronyx_12t_2w2r_rc4_4x4_routed_5layer_direct
Xgf180mcu_as_sc_mcu7t3v3__inv_2_146 gf180mcu_as_sc_mcu7t3v3__inv_2_146/VDD VSS gf180mcu_as_sc_mcu7t3v3__inv_2_146/Y
+ VSS gf180mcu_as_sc_mcu7t3v3__inv_2_146/VNW VSUBS gf180mcu_as_sc_mcu7t3v3__inv_2
Xgf180mcu_as_sc_mcu7t3v3__inv_2_102 gf180mcu_as_sc_mcu7t3v3__inv_2_99/VSS gf180mcu_as_sc_mcu7t3v3__inv_2_96/VDD
+ gf180mcu_as_sc_mcu7t3v3__inv_2_102/Y VSS gf180mcu_as_sc_mcu7t3v3__inv_2_103/VNW
+ VSUBS gf180mcu_as_sc_mcu7t3v3__inv_2
Xgf180mcu_as_sc_mcu7t3v3__inv_2_124 gf180mcu_as_sc_mcu7t3v3__inv_2_126/VDD VSS VSS
+ VSS gf180mcu_as_sc_mcu7t3v3__inv_2_126/VNW VSUBS gf180mcu_as_sc_mcu7t3v3__inv_2
Xgf180mcu_as_sc_mcu7t3v3__inv_2_135 gf180mcu_as_sc_mcu7t3v3__inv_2_152/VSS gf180mcu_as_sc_mcu7t3v3__inv_2_151/VDD
+ gf180mcu_as_sc_mcu7t3v3__inv_2_135/Y VSS gf180mcu_as_sc_mcu7t3v3__inv_2_135/VNW
+ VSUBS gf180mcu_as_sc_mcu7t3v3__inv_2
Xgf180mcu_as_sc_mcu7t3v3__inv_2_113 gf180mcu_as_sc_mcu7t3v3__inv_2_115/VDD gf180mcu_as_sc_mcu7t3v3__inv_2_119/VDD
+ VSS VSS gf180mcu_as_sc_mcu7t3v3__inv_2_115/VNW VSUBS gf180mcu_as_sc_mcu7t3v3__inv_2
Xgf180mcu_as_sc_mcu7t3v3__inv_2_157 gf180mcu_as_sc_mcu7t3v3__inv_2_206/VDD gf180mcu_as_sc_mcu7t3v3__inv_2_371/VDD
+ gf180mcu_as_sc_mcu7t3v3__inv_2_157/Y VSS gf180mcu_as_sc_mcu7t3v3__inv_2_206/VNW
+ VSUBS gf180mcu_as_sc_mcu7t3v3__inv_2
Xgf180mcu_as_sc_mcu7t3v3__inv_2_168 VSS VSS VSS VSS gf180mcu_as_sc_mcu7t3v3__inv_2_169/VNW
+ VSUBS gf180mcu_as_sc_mcu7t3v3__inv_2
Xgf180mcu_as_sc_mcu7t3v3__inv_2_179 VSS gf180mcu_as_sc_mcu7t3v3__inv_2_184/VDD gf180mcu_as_sc_mcu7t3v3__inv_2_179/Y
+ VSS gf180mcu_as_sc_mcu7t3v3__inv_2_180/VNW VSUBS gf180mcu_as_sc_mcu7t3v3__inv_2
Xu_t008_021 u_t008_021/c0_w0_bl u_t008_021/c0_w0_br u_t008_021/c0_w1_bl u_t008_021/c0_w1_br
+ u_t008_021/c0_r0_rbl u_t008_021/c0_r1_rbl u_t008_021/c1_w0_bl u_t008_021/c1_w0_br
+ u_t008_021/c1_w1_bl u_t008_021/c1_w1_br u_t008_021/c1_r0_rbl u_t008_021/c1_r1_rbl
+ u_t008_021/c2_w0_bl u_t008_021/c2_w0_br u_t008_021/c2_w1_bl u_t008_021/c2_w1_br
+ u_t008_021/c2_r0_rbl u_t008_021/c2_r1_rbl u_t008_021/c3_w0_bl u_t008_021/c3_w0_br
+ u_t008_021/c3_w1_bl u_t008_021/c3_w1_br u_t008_021/c3_r0_rbl u_t008_021/c3_r1_rbl
+ u_t008_021/r0_w0_wl u_t008_021/r0_w1_wl u_t008_021/r0_r0_rwl u_t008_021/r0_r1_rwl
+ u_t008_021/r1_w0_wl u_t008_021/r1_w1_wl u_t008_021/r1_r0_rwl u_t008_021/r1_r1_rwl
+ u_t008_021/r2_w0_wl u_t008_021/r2_w1_wl u_t008_021/r2_r0_rwl u_t008_021/r2_r1_rwl
+ u_t008_021/r3_w0_wl u_t008_021/r3_w1_wl u_t008_021/r3_r0_rwl u_t008_021/r3_r1_rwl
+ u_t008_021/VDD u_t008_031/VSS VSUBS detronyx_12t_2w2r_rc4_4x4_routed_5layer_direct
Xu_t008_010 u_t008_010/c0_w0_bl u_t008_010/c0_w0_br u_t008_010/c0_w1_bl u_t008_010/c0_w1_br
+ u_t008_010/c0_r0_rbl u_t008_010/c0_r1_rbl u_t008_010/c1_w0_bl u_t008_010/c1_w0_br
+ u_t008_010/c1_w1_bl u_t008_010/c1_w1_br u_t008_010/c1_r0_rbl u_t008_010/c1_r1_rbl
+ u_t008_010/c2_w0_bl u_t008_010/c2_w0_br u_t008_010/c2_w1_bl u_t008_010/c2_w1_br
+ u_t008_010/c2_r0_rbl u_t008_010/c2_r1_rbl u_t008_010/c3_w0_bl u_t008_010/c3_w0_br
+ u_t008_010/c3_w1_bl u_t008_010/c3_w1_br u_t008_010/c3_r0_rbl u_t008_010/c3_r1_rbl
+ u_t008_010/r0_w0_wl u_t008_010/r0_w1_wl u_t008_010/r0_r0_rwl u_t008_010/r0_r1_rwl
+ u_t008_010/r1_w0_wl u_t008_010/r1_w1_wl u_t008_010/r1_r0_rwl u_t008_010/r1_r1_rwl
+ u_t008_010/r2_w0_wl u_t008_010/r2_w1_wl u_t008_010/r2_r0_rwl u_t008_010/r2_r1_rwl
+ u_t008_010/r3_w0_wl u_t008_010/r3_w1_wl u_t008_010/r3_r0_rwl u_t008_010/r3_r1_rwl
+ VSS u_t008_031/VSS VSUBS detronyx_12t_2w2r_rc4_4x4_routed_5layer_direct
Xu_t023_024 u_t023_024/c0_w0_bl u_t023_024/c0_w0_br u_t023_024/c0_w1_bl u_t023_024/c0_w1_br
+ u_t023_024/c0_r0_rbl u_t023_024/c0_r1_rbl u_t023_024/c1_w0_bl u_t023_024/c1_w0_br
+ u_t023_024/c1_w1_bl u_t023_024/c1_w1_br u_t023_024/c1_r0_rbl u_t023_024/c1_r1_rbl
+ u_t023_024/c2_w0_bl u_t023_024/c2_w0_br u_t023_024/c2_w1_bl u_t023_024/c2_w1_br
+ u_t023_024/c2_r0_rbl u_t023_024/c2_r1_rbl u_t023_024/c3_w0_bl u_t023_024/c3_w0_br
+ u_t023_024/c3_w1_bl u_t023_024/c3_w1_br u_t023_024/c3_r0_rbl u_t023_024/c3_r1_rbl
+ u_t023_024/r0_w0_wl u_t023_024/r0_w1_wl u_t023_024/r0_r0_rwl u_t023_024/r0_r1_rwl
+ u_t023_024/r1_w0_wl u_t023_024/r1_w1_wl u_t023_024/r1_r0_rwl u_t023_024/r1_r1_rwl
+ u_t023_024/r2_w0_wl u_t023_024/r2_w1_wl u_t023_024/r2_r0_rwl u_t023_024/r2_r1_rwl
+ u_t023_024/r3_w0_wl u_t023_024/r3_w1_wl u_t023_024/r3_r0_rwl u_t023_024/r3_r1_rwl
+ VSS u_t023_024/VSS VSUBS detronyx_12t_2w2r_rc4_4x4_routed_5layer_direct
Xu_t023_013 u_t023_013/c0_w0_bl u_t023_013/c0_w0_br u_t023_013/c0_w1_bl u_t023_013/c0_w1_br
+ u_t023_013/c0_r0_rbl u_t023_013/c0_r1_rbl u_t023_013/c1_w0_bl u_t023_013/c1_w0_br
+ u_t023_013/c1_w1_bl u_t023_013/c1_w1_br u_t023_013/c1_r0_rbl u_t023_013/c1_r1_rbl
+ u_t023_013/c2_w0_bl u_t023_013/c2_w0_br u_t023_013/c2_w1_bl u_t023_013/c2_w1_br
+ u_t023_013/c2_r0_rbl u_t023_013/c2_r1_rbl u_t023_013/c3_w0_bl u_t023_013/c3_w0_br
+ u_t023_013/c3_w1_bl u_t023_013/c3_w1_br u_t023_013/c3_r0_rbl u_t023_013/c3_r1_rbl
+ u_t023_013/r0_w0_wl u_t023_013/r0_w1_wl u_t023_013/r0_r0_rwl u_t023_013/r0_r1_rwl
+ u_t023_013/r1_w0_wl u_t023_013/r1_w1_wl u_t023_013/r1_r0_rwl u_t023_013/r1_r1_rwl
+ u_t023_013/r2_w0_wl u_t023_013/r2_w1_wl u_t023_013/r2_r0_rwl u_t023_013/r2_r1_rwl
+ u_t023_013/r3_w0_wl u_t023_013/r3_w1_wl u_t023_013/r3_r0_rwl u_t023_013/r3_r1_rwl
+ u_t023_013/VDD u_t023_013/VSS VSUBS detronyx_12t_2w2r_rc4_4x4_routed_5layer_direct
Xu_t023_002 u_t023_002/c0_w0_bl u_t023_002/c0_w0_br u_t023_002/c0_w1_bl u_t023_002/c0_w1_br
+ u_t023_002/c0_r0_rbl u_t023_002/c0_r1_rbl u_t023_002/c1_w0_bl u_t023_002/c1_w0_br
+ u_t023_002/c1_w1_bl u_t023_002/c1_w1_br u_t023_002/c1_r0_rbl u_t023_002/c1_r1_rbl
+ u_t023_002/c2_w0_bl u_t023_002/c2_w0_br u_t023_002/c2_w1_bl u_t023_002/c2_w1_br
+ u_t023_002/c2_r0_rbl u_t023_002/c2_r1_rbl u_t023_002/c3_w0_bl u_t023_002/c3_w0_br
+ u_t023_002/c3_w1_bl u_t023_002/c3_w1_br u_t023_002/c3_r0_rbl u_t023_002/c3_r1_rbl
+ u_t023_002/r0_w0_wl u_t023_002/r0_w1_wl u_t023_002/r0_r0_rwl u_t023_002/r0_r1_rwl
+ u_t023_002/r1_w0_wl u_t023_002/r1_w1_wl u_t023_002/r1_r0_rwl u_t023_002/r1_r1_rwl
+ u_t023_002/r2_w0_wl u_t023_002/r2_w1_wl u_t023_002/r2_r0_rwl u_t023_002/r2_r1_rwl
+ u_t023_002/r3_w0_wl u_t023_002/r3_w1_wl u_t023_002/r3_r0_rwl u_t023_002/r3_r1_rwl
+ VSS u_t023_002/VSS VSUBS detronyx_12t_2w2r_rc4_4x4_routed_5layer_direct
Xgf180mcu_as_sc_mcu7t3v3__inv_2_680 VSS VSS gf180mcu_as_sc_mcu7t3v3__inv_2_680/Y gf180mcu_as_sc_mcu7t3v3__inv_2_848/Y
+ gf180mcu_as_sc_mcu7t3v3__inv_2_680/VNW VSUBS gf180mcu_as_sc_mcu7t3v3__inv_2
Xgf180mcu_as_sc_mcu7t3v3__inv_2_691 VSS gf180mcu_as_sc_mcu7t3v3__inv_2_695/VDD gf180mcu_as_sc_mcu7t3v3__inv_2_691/Y
+ VSS gf180mcu_as_sc_mcu7t3v3__inv_2_691/VNW VSUBS gf180mcu_as_sc_mcu7t3v3__inv_2
Xu_t014_013 u_t014_013/c0_w0_bl u_t014_013/c0_w0_br u_t014_013/c0_w1_bl u_t014_013/c0_w1_br
+ u_t014_013/c0_r0_rbl u_t014_013/c0_r1_rbl u_t014_013/c1_w0_bl u_t014_013/c1_w0_br
+ u_t014_013/c1_w1_bl u_t014_013/c1_w1_br u_t014_013/c1_r0_rbl u_t014_013/c1_r1_rbl
+ u_t014_013/c2_w0_bl u_t014_013/c2_w0_br u_t014_013/c2_w1_bl u_t014_013/c2_w1_br
+ u_t014_013/c2_r0_rbl u_t014_013/c2_r1_rbl u_t014_013/c3_w0_bl u_t014_013/c3_w0_br
+ u_t014_013/c3_w1_bl u_t014_013/c3_w1_br u_t014_013/c3_r0_rbl u_t014_013/c3_r1_rbl
+ u_t014_013/r0_w0_wl u_t014_013/r0_w1_wl u_t014_013/r0_r0_rwl u_t014_013/r0_r1_rwl
+ u_t014_013/r1_w0_wl u_t014_013/r1_w1_wl u_t014_013/r1_r0_rwl u_t014_013/r1_r1_rwl
+ u_t014_013/r2_w0_wl u_t014_013/r2_w1_wl u_t014_013/r2_r0_rwl u_t014_013/r2_r1_rwl
+ u_t014_013/r3_w0_wl u_t014_013/r3_w1_wl u_t014_013/r3_r0_rwl u_t014_013/r3_r1_rwl
+ u_t014_013/VDD u_t014_013/VSS VSUBS detronyx_12t_2w2r_rc4_4x4_routed_5layer_direct
Xu_t014_002 u_t014_002/c0_w0_bl u_t014_002/c0_w0_br u_t014_002/c0_w1_bl u_t014_002/c0_w1_br
+ u_t014_002/c0_r0_rbl u_t014_002/c0_r1_rbl u_t014_002/c1_w0_bl u_t014_002/c1_w0_br
+ u_t014_002/c1_w1_bl u_t014_002/c1_w1_br u_t014_002/c1_r0_rbl u_t014_002/c1_r1_rbl
+ u_t014_002/c2_w0_bl u_t014_002/c2_w0_br u_t014_002/c2_w1_bl u_t014_002/c2_w1_br
+ u_t014_002/c2_r0_rbl u_t014_002/c2_r1_rbl u_t014_002/c3_w0_bl u_t014_002/c3_w0_br
+ u_t014_002/c3_w1_bl u_t014_002/c3_w1_br u_t014_002/c3_r0_rbl u_t014_002/c3_r1_rbl
+ u_t014_002/r0_w0_wl u_t014_002/r0_w1_wl u_t014_002/r0_r0_rwl u_t014_002/r0_r1_rwl
+ u_t014_002/r1_w0_wl u_t014_002/r1_w1_wl u_t014_002/r1_r0_rwl u_t014_002/r1_r1_rwl
+ u_t014_002/r2_w0_wl u_t014_002/r2_w1_wl u_t014_002/r2_r0_rwl u_t014_002/r2_r1_rwl
+ u_t014_002/r3_w0_wl u_t014_002/r3_w1_wl u_t014_002/r3_r0_rwl u_t014_002/r3_r1_rwl
+ VSS u_t014_002/VSS VSUBS detronyx_12t_2w2r_rc4_4x4_routed_5layer_direct
Xgf180mcu_as_sc_mcu7t3v3__nand2_2_47 gf180mcu_as_sc_mcu7t3v3__nor2_2_8/VDD gf180mcu_as_sc_mcu7t3v3__nand3_2_32/VSS
+ VSS VSS VSS gf180mcu_as_sc_mcu7t3v3__nor2_2_8/VNW VSUBS gf180mcu_as_sc_mcu7t3v3__nand2_2
Xgf180mcu_as_sc_mcu7t3v3__nand2_2_58 gf180mcu_as_sc_mcu7t3v3__nor2_2_8/VDD gf180mcu_as_sc_mcu7t3v3__nor2_2_8/VSS
+ VSS VSS VSS gf180mcu_as_sc_mcu7t3v3__nor2_2_8/VNW VSUBS gf180mcu_as_sc_mcu7t3v3__nand2_2
Xgf180mcu_as_sc_mcu7t3v3__nand2_2_36 gf180mcu_as_sc_mcu7t3v3__nor2_2_4/VDD gf180mcu_as_sc_mcu7t3v3__nor2_2_4/VSS
+ VSS VSS VSS gf180mcu_as_sc_mcu7t3v3__nor2_2_4/VNW VSUBS gf180mcu_as_sc_mcu7t3v3__nand2_2
Xgf180mcu_as_sc_mcu7t3v3__nand2_2_25 gf180mcu_as_sc_mcu7t3v3__nor2_2_6/VDD gf180mcu_as_sc_mcu7t3v3__nand3_2_3/VSS
+ VSS VSS VSS gf180mcu_as_sc_mcu7t3v3__nor2_2_6/VNW VSUBS gf180mcu_as_sc_mcu7t3v3__nand2_2
Xgf180mcu_as_sc_mcu7t3v3__nand2_2_14 gf180mcu_as_sc_mcu7t3v3__nand3_2_5/VDD gf180mcu_as_sc_mcu7t3v3__nor2_2_6/VSS
+ VSS VSS VSS gf180mcu_as_sc_mcu7t3v3__nand3_2_5/VNW VSUBS gf180mcu_as_sc_mcu7t3v3__nand2_2
Xu_t014_024 u_t014_024/c0_w0_bl u_t014_024/c0_w0_br u_t014_024/c0_w1_bl u_t014_024/c0_w1_br
+ u_t014_024/c0_r0_rbl u_t014_024/c0_r1_rbl u_t014_024/c1_w0_bl u_t014_024/c1_w0_br
+ u_t014_024/c1_w1_bl u_t014_024/c1_w1_br u_t014_024/c1_r0_rbl u_t014_024/c1_r1_rbl
+ u_t014_024/c2_w0_bl u_t014_024/c2_w0_br u_t014_024/c2_w1_bl u_t014_024/c2_w1_br
+ u_t014_024/c2_r0_rbl u_t014_024/c2_r1_rbl u_t014_024/c3_w0_bl u_t014_024/c3_w0_br
+ u_t014_024/c3_w1_bl u_t014_024/c3_w1_br u_t014_024/c3_r0_rbl u_t014_024/c3_r1_rbl
+ u_t014_024/r0_w0_wl u_t014_024/r0_w1_wl u_t014_024/r0_r0_rwl u_t014_024/r0_r1_rwl
+ u_t014_024/r1_w0_wl u_t014_024/r1_w1_wl u_t014_024/r1_r0_rwl u_t014_024/r1_r1_rwl
+ u_t014_024/r2_w0_wl u_t014_024/r2_w1_wl u_t014_024/r2_r0_rwl u_t014_024/r2_r1_rwl
+ u_t014_024/r3_w0_wl u_t014_024/r3_w1_wl u_t014_024/r3_r0_rwl u_t014_024/r3_r1_rwl
+ VSS u_t014_024/VSS VSUBS detronyx_12t_2w2r_rc4_4x4_routed_5layer_direct
Xu_t005_024 u_t005_024/c0_w0_bl u_t005_024/c0_w0_br u_t005_024/c0_w1_bl u_t005_024/c0_w1_br
+ u_t005_024/c0_r0_rbl u_t005_024/c0_r1_rbl u_t005_024/c1_w0_bl u_t005_024/c1_w0_br
+ u_t005_024/c1_w1_bl u_t005_024/c1_w1_br u_t005_024/c1_r0_rbl u_t005_024/c1_r1_rbl
+ u_t005_024/c2_w0_bl u_t005_024/c2_w0_br u_t005_024/c2_w1_bl u_t005_024/c2_w1_br
+ u_t005_024/c2_r0_rbl u_t005_024/c2_r1_rbl u_t005_024/c3_w0_bl u_t005_024/c3_w0_br
+ u_t005_024/c3_w1_bl u_t005_024/c3_w1_br u_t005_024/c3_r0_rbl u_t005_024/c3_r1_rbl
+ u_t005_024/r0_w0_wl u_t005_024/r0_w1_wl u_t005_024/r0_r0_rwl u_t005_024/r0_r1_rwl
+ u_t005_024/r1_w0_wl u_t005_024/r1_w1_wl u_t005_024/r1_r0_rwl u_t005_024/r1_r1_rwl
+ u_t005_024/r2_w0_wl u_t005_024/r2_w1_wl u_t005_024/r2_r0_rwl u_t005_024/r2_r1_rwl
+ u_t005_024/r3_w0_wl u_t005_024/r3_w1_wl u_t005_024/r3_r0_rwl u_t005_024/r3_r1_rwl
+ VSS u_t005_031/VSS VSUBS detronyx_12t_2w2r_rc4_4x4_routed_5layer_direct
Xu_t005_013 u_t005_013/c0_w0_bl u_t005_013/c0_w0_br u_t005_013/c0_w1_bl u_t005_013/c0_w1_br
+ u_t005_013/c0_r0_rbl u_t005_013/c0_r1_rbl u_t005_013/c1_w0_bl u_t005_013/c1_w0_br
+ u_t005_013/c1_w1_bl u_t005_013/c1_w1_br u_t005_013/c1_r0_rbl u_t005_013/c1_r1_rbl
+ u_t005_013/c2_w0_bl u_t005_013/c2_w0_br u_t005_013/c2_w1_bl u_t005_013/c2_w1_br
+ u_t005_013/c2_r0_rbl u_t005_013/c2_r1_rbl u_t005_013/c3_w0_bl u_t005_013/c3_w0_br
+ u_t005_013/c3_w1_bl u_t005_013/c3_w1_br u_t005_013/c3_r0_rbl u_t005_013/c3_r1_rbl
+ u_t005_013/r0_w0_wl u_t005_013/r0_w1_wl u_t005_013/r0_r0_rwl u_t005_013/r0_r1_rwl
+ u_t005_013/r1_w0_wl u_t005_013/r1_w1_wl u_t005_013/r1_r0_rwl u_t005_013/r1_r1_rwl
+ u_t005_013/r2_w0_wl u_t005_013/r2_w1_wl u_t005_013/r2_r0_rwl u_t005_013/r2_r1_rwl
+ u_t005_013/r3_w0_wl u_t005_013/r3_w1_wl u_t005_013/r3_r0_rwl u_t005_013/r3_r1_rwl
+ u_t005_013/VDD u_t005_031/VSS VSUBS detronyx_12t_2w2r_rc4_4x4_routed_5layer_direct
Xu_t020_005 u_t020_005/c0_w0_bl u_t020_005/c0_w0_br u_t020_005/c0_w1_bl u_t020_005/c0_w1_br
+ u_t020_005/c0_r0_rbl u_t020_005/c0_r1_rbl u_t020_005/c1_w0_bl u_t020_005/c1_w0_br
+ u_t020_005/c1_w1_bl u_t020_005/c1_w1_br u_t020_005/c1_r0_rbl u_t020_005/c1_r1_rbl
+ u_t020_005/c2_w0_bl u_t020_005/c2_w0_br u_t020_005/c2_w1_bl u_t020_005/c2_w1_br
+ u_t020_005/c2_r0_rbl u_t020_005/c2_r1_rbl u_t020_005/c3_w0_bl u_t020_005/c3_w0_br
+ u_t020_005/c3_w1_bl u_t020_005/c3_w1_br u_t020_005/c3_r0_rbl u_t020_005/c3_r1_rbl
+ u_t020_005/r0_w0_wl u_t020_005/r0_w1_wl u_t020_005/r0_r0_rwl u_t020_005/r0_r1_rwl
+ u_t020_005/r1_w0_wl u_t020_005/r1_w1_wl u_t020_005/r1_r0_rwl u_t020_005/r1_r1_rwl
+ u_t020_005/r2_w0_wl u_t020_005/r2_w1_wl u_t020_005/r2_r0_rwl u_t020_005/r2_r1_rwl
+ u_t020_005/r3_w0_wl u_t020_005/r3_w1_wl u_t020_005/r3_r0_rwl u_t020_005/r3_r1_rwl
+ u_t020_005/VDD u_t020_005/VSS VSUBS detronyx_12t_2w2r_rc4_4x4_routed_5layer_direct
Xu_t005_002 u_t005_002/c0_w0_bl u_t005_002/c0_w0_br u_t005_002/c0_w1_bl u_t005_002/c0_w1_br
+ u_t005_002/c0_r0_rbl u_t005_002/c0_r1_rbl u_t005_002/c1_w0_bl u_t005_002/c1_w0_br
+ u_t005_002/c1_w1_bl u_t005_002/c1_w1_br u_t005_002/c1_r0_rbl u_t005_002/c1_r1_rbl
+ u_t005_002/c2_w0_bl u_t005_002/c2_w0_br u_t005_002/c2_w1_bl u_t005_002/c2_w1_br
+ u_t005_002/c2_r0_rbl u_t005_002/c2_r1_rbl u_t005_002/c3_w0_bl u_t005_002/c3_w0_br
+ u_t005_002/c3_w1_bl u_t005_002/c3_w1_br u_t005_002/c3_r0_rbl u_t005_002/c3_r1_rbl
+ u_t005_002/r0_w0_wl u_t005_002/r0_w1_wl u_t005_002/r0_r0_rwl u_t005_002/r0_r1_rwl
+ u_t005_002/r1_w0_wl u_t005_002/r1_w1_wl u_t005_002/r1_r0_rwl u_t005_002/r1_r1_rwl
+ u_t005_002/r2_w0_wl u_t005_002/r2_w1_wl u_t005_002/r2_r0_rwl u_t005_002/r2_r1_rwl
+ u_t005_002/r3_w0_wl u_t005_002/r3_w1_wl u_t005_002/r3_r0_rwl u_t005_002/r3_r1_rwl
+ VSS u_t005_031/VSS VSUBS detronyx_12t_2w2r_rc4_4x4_routed_5layer_direct
Xu_t020_027 u_t020_027/c0_w0_bl u_t020_027/c0_w0_br u_t020_027/c0_w1_bl u_t020_027/c0_w1_br
+ u_t020_027/c0_r0_rbl u_t020_027/c0_r1_rbl u_t020_027/c1_w0_bl u_t020_027/c1_w0_br
+ u_t020_027/c1_w1_bl u_t020_027/c1_w1_br u_t020_027/c1_r0_rbl u_t020_027/c1_r1_rbl
+ u_t020_027/c2_w0_bl u_t020_027/c2_w0_br u_t020_027/c2_w1_bl u_t020_027/c2_w1_br
+ u_t020_027/c2_r0_rbl u_t020_027/c2_r1_rbl u_t020_027/c3_w0_bl u_t020_027/c3_w0_br
+ u_t020_027/c3_w1_bl u_t020_027/c3_w1_br u_t020_027/c3_r0_rbl u_t020_027/c3_r1_rbl
+ u_t020_027/r0_w0_wl u_t020_027/r0_w1_wl u_t020_027/r0_r0_rwl u_t020_027/r0_r1_rwl
+ u_t020_027/r1_w0_wl u_t020_027/r1_w1_wl u_t020_027/r1_r0_rwl u_t020_027/r1_r1_rwl
+ u_t020_027/r2_w0_wl u_t020_027/r2_w1_wl u_t020_027/r2_r0_rwl u_t020_027/r2_r1_rwl
+ u_t020_027/r3_w0_wl u_t020_027/r3_w1_wl u_t020_027/r3_r0_rwl u_t020_027/r3_r1_rwl
+ u_t020_027/VDD u_t020_027/VSS VSUBS detronyx_12t_2w2r_rc4_4x4_routed_5layer_direct
Xu_t020_016 u_t020_016/c0_w0_bl u_t020_016/c0_w0_br u_t020_016/c0_w1_bl u_t020_016/c0_w1_br
+ u_t020_016/c0_r0_rbl u_t020_016/c0_r1_rbl u_t020_016/c1_w0_bl u_t020_016/c1_w0_br
+ u_t020_016/c1_w1_bl u_t020_016/c1_w1_br u_t020_016/c1_r0_rbl u_t020_016/c1_r1_rbl
+ u_t020_016/c2_w0_bl u_t020_016/c2_w0_br u_t020_016/c2_w1_bl u_t020_016/c2_w1_br
+ u_t020_016/c2_r0_rbl u_t020_016/c2_r1_rbl u_t020_016/c3_w0_bl u_t020_016/c3_w0_br
+ u_t020_016/c3_w1_bl u_t020_016/c3_w1_br u_t020_016/c3_r0_rbl u_t020_016/c3_r1_rbl
+ u_t020_016/r0_w0_wl u_t020_016/r0_w1_wl u_t020_016/r0_r0_rwl u_t020_016/r0_r1_rwl
+ u_t020_016/r1_w0_wl u_t020_016/r1_w1_wl u_t020_016/r1_r0_rwl u_t020_016/r1_r1_rwl
+ u_t020_016/r2_w0_wl u_t020_016/r2_w1_wl u_t020_016/r2_r0_rwl u_t020_016/r2_r1_rwl
+ u_t020_016/r3_w0_wl u_t020_016/r3_w1_wl u_t020_016/r3_r0_rwl u_t020_016/r3_r1_rwl
+ VSS u_t020_017/VSS VSUBS detronyx_12t_2w2r_rc4_4x4_routed_5layer_direct
Xgf180mcu_as_sc_mcu7t3v3__inv_2_1409 VSS gf180mcu_as_sc_mcu7t3v3__inv_2_1694/VDD gf180mcu_as_sc_mcu7t3v3__inv_2_1409/Y
+ VSS gf180mcu_as_sc_mcu7t3v3__inv_2_1413/VNW VSUBS gf180mcu_as_sc_mcu7t3v3__inv_2
Xu_t011_027 u_t011_027/c0_w0_bl u_t011_027/c0_w0_br u_t011_027/c0_w1_bl u_t011_027/c0_w1_br
+ u_t011_027/c0_r0_rbl u_t011_027/c0_r1_rbl u_t011_027/c1_w0_bl u_t011_027/c1_w0_br
+ u_t011_027/c1_w1_bl u_t011_027/c1_w1_br u_t011_027/c1_r0_rbl u_t011_027/c1_r1_rbl
+ u_t011_027/c2_w0_bl u_t011_027/c2_w0_br u_t011_027/c2_w1_bl u_t011_027/c2_w1_br
+ u_t011_027/c2_r0_rbl u_t011_027/c2_r1_rbl u_t011_027/c3_w0_bl u_t011_027/c3_w0_br
+ u_t011_027/c3_w1_bl u_t011_027/c3_w1_br u_t011_027/c3_r0_rbl u_t011_027/c3_r1_rbl
+ u_t011_027/r0_w0_wl u_t011_027/r0_w1_wl u_t011_027/r0_r0_rwl u_t011_027/r0_r1_rwl
+ u_t011_027/r1_w0_wl u_t011_027/r1_w1_wl u_t011_027/r1_r0_rwl u_t011_027/r1_r1_rwl
+ u_t011_027/r2_w0_wl u_t011_027/r2_w1_wl u_t011_027/r2_r0_rwl u_t011_027/r2_r1_rwl
+ u_t011_027/r3_w0_wl u_t011_027/r3_w1_wl u_t011_027/r3_r0_rwl u_t011_027/r3_r1_rwl
+ u_t011_027/VDD u_t011_027/VSS VSUBS detronyx_12t_2w2r_rc4_4x4_routed_5layer_direct
Xu_t011_016 u_t011_016/c0_w0_bl u_t011_016/c0_w0_br u_t011_016/c0_w1_bl u_t011_016/c0_w1_br
+ u_t011_016/c0_r0_rbl u_t011_016/c0_r1_rbl u_t011_016/c1_w0_bl u_t011_016/c1_w0_br
+ u_t011_016/c1_w1_bl u_t011_016/c1_w1_br u_t011_016/c1_r0_rbl u_t011_016/c1_r1_rbl
+ u_t011_016/c2_w0_bl u_t011_016/c2_w0_br u_t011_016/c2_w1_bl u_t011_016/c2_w1_br
+ u_t011_016/c2_r0_rbl u_t011_016/c2_r1_rbl u_t011_016/c3_w0_bl u_t011_016/c3_w0_br
+ u_t011_016/c3_w1_bl u_t011_016/c3_w1_br u_t011_016/c3_r0_rbl u_t011_016/c3_r1_rbl
+ u_t011_016/r0_w0_wl u_t011_016/r0_w1_wl u_t011_016/r0_r0_rwl u_t011_016/r0_r1_rwl
+ u_t011_016/r1_w0_wl u_t011_016/r1_w1_wl u_t011_016/r1_r0_rwl u_t011_016/r1_r1_rwl
+ u_t011_016/r2_w0_wl u_t011_016/r2_w1_wl u_t011_016/r2_r0_rwl u_t011_016/r2_r1_rwl
+ u_t011_016/r3_w0_wl u_t011_016/r3_w1_wl u_t011_016/r3_r0_rwl u_t011_016/r3_r1_rwl
+ VSS u_t011_017/VSS VSUBS detronyx_12t_2w2r_rc4_4x4_routed_5layer_direct
Xu_t011_005 u_t011_005/c0_w0_bl u_t011_005/c0_w0_br u_t011_005/c0_w1_bl u_t011_005/c0_w1_br
+ u_t011_005/c0_r0_rbl u_t011_005/c0_r1_rbl u_t011_005/c1_w0_bl u_t011_005/c1_w0_br
+ u_t011_005/c1_w1_bl u_t011_005/c1_w1_br u_t011_005/c1_r0_rbl u_t011_005/c1_r1_rbl
+ u_t011_005/c2_w0_bl u_t011_005/c2_w0_br u_t011_005/c2_w1_bl u_t011_005/c2_w1_br
+ u_t011_005/c2_r0_rbl u_t011_005/c2_r1_rbl u_t011_005/c3_w0_bl u_t011_005/c3_w0_br
+ u_t011_005/c3_w1_bl u_t011_005/c3_w1_br u_t011_005/c3_r0_rbl u_t011_005/c3_r1_rbl
+ u_t011_005/r0_w0_wl u_t011_005/r0_w1_wl u_t011_005/r0_r0_rwl u_t011_005/r0_r1_rwl
+ u_t011_005/r1_w0_wl u_t011_005/r1_w1_wl u_t011_005/r1_r0_rwl u_t011_005/r1_r1_rwl
+ u_t011_005/r2_w0_wl u_t011_005/r2_w1_wl u_t011_005/r2_r0_rwl u_t011_005/r2_r1_rwl
+ u_t011_005/r3_w0_wl u_t011_005/r3_w1_wl u_t011_005/r3_r0_rwl u_t011_005/r3_r1_rwl
+ u_t011_005/VDD u_t011_005/VSS VSUBS detronyx_12t_2w2r_rc4_4x4_routed_5layer_direct
Xu_t002_005 u_t002_005/c0_w0_bl u_t002_005/c0_w0_br u_t002_005/c0_w1_bl u_t002_005/c0_w1_br
+ u_t002_005/c0_r0_rbl u_t002_005/c0_r1_rbl u_t002_005/c1_w0_bl u_t002_005/c1_w0_br
+ u_t002_005/c1_w1_bl u_t002_005/c1_w1_br u_t002_005/c1_r0_rbl u_t002_005/c1_r1_rbl
+ u_t002_005/c2_w0_bl u_t002_005/c2_w0_br u_t002_005/c2_w1_bl u_t002_005/c2_w1_br
+ u_t002_005/c2_r0_rbl u_t002_005/c2_r1_rbl u_t002_005/c3_w0_bl u_t002_005/c3_w0_br
+ u_t002_005/c3_w1_bl u_t002_005/c3_w1_br u_t002_005/c3_r0_rbl u_t002_005/c3_r1_rbl
+ u_t002_005/r0_w0_wl u_t002_005/r0_w1_wl u_t002_005/r0_r0_rwl u_t002_005/r0_r1_rwl
+ u_t002_005/r1_w0_wl u_t002_005/r1_w1_wl u_t002_005/r1_r0_rwl u_t002_005/r1_r1_rwl
+ u_t002_005/r2_w0_wl u_t002_005/r2_w1_wl u_t002_005/r2_r0_rwl u_t002_005/r2_r1_rwl
+ u_t002_005/r3_w0_wl u_t002_005/r3_w1_wl u_t002_005/r3_r0_rwl u_t002_005/r3_r1_rwl
+ u_t002_005/VDD u_t002_005/VSS VSUBS detronyx_12t_2w2r_rc4_4x4_routed_5layer_direct
Xu_t002_027 u_t002_027/c0_w0_bl u_t002_027/c0_w0_br u_t002_027/c0_w1_bl u_t002_027/c0_w1_br
+ u_t002_027/c0_r0_rbl u_t002_027/c0_r1_rbl u_t002_027/c1_w0_bl u_t002_027/c1_w0_br
+ u_t002_027/c1_w1_bl u_t002_027/c1_w1_br u_t002_027/c1_r0_rbl u_t002_027/c1_r1_rbl
+ u_t002_027/c2_w0_bl u_t002_027/c2_w0_br u_t002_027/c2_w1_bl u_t002_027/c2_w1_br
+ u_t002_027/c2_r0_rbl u_t002_027/c2_r1_rbl u_t002_027/c3_w0_bl u_t002_027/c3_w0_br
+ u_t002_027/c3_w1_bl u_t002_027/c3_w1_br u_t002_027/c3_r0_rbl u_t002_027/c3_r1_rbl
+ u_t002_027/r0_w0_wl u_t002_027/r0_w1_wl u_t002_027/r0_r0_rwl u_t002_027/r0_r1_rwl
+ u_t002_027/r1_w0_wl u_t002_027/r1_w1_wl u_t002_027/r1_r0_rwl u_t002_027/r1_r1_rwl
+ u_t002_027/r2_w0_wl u_t002_027/r2_w1_wl u_t002_027/r2_r0_rwl u_t002_027/r2_r1_rwl
+ u_t002_027/r3_w0_wl u_t002_027/r3_w1_wl u_t002_027/r3_r0_rwl u_t002_027/r3_r1_rwl
+ u_t002_027/VDD u_t002_027/VSS VSUBS detronyx_12t_2w2r_rc4_4x4_routed_5layer_direct
Xu_t002_016 u_t002_016/c0_w0_bl u_t002_016/c0_w0_br u_t002_016/c0_w1_bl u_t002_016/c0_w1_br
+ u_t002_016/c0_r0_rbl u_t002_016/c0_r1_rbl u_t002_016/c1_w0_bl u_t002_016/c1_w0_br
+ u_t002_016/c1_w1_bl u_t002_016/c1_w1_br u_t002_016/c1_r0_rbl u_t002_016/c1_r1_rbl
+ u_t002_016/c2_w0_bl u_t002_016/c2_w0_br u_t002_016/c2_w1_bl u_t002_016/c2_w1_br
+ u_t002_016/c2_r0_rbl u_t002_016/c2_r1_rbl u_t002_016/c3_w0_bl u_t002_016/c3_w0_br
+ u_t002_016/c3_w1_bl u_t002_016/c3_w1_br u_t002_016/c3_r0_rbl u_t002_016/c3_r1_rbl
+ u_t002_016/r0_w0_wl u_t002_016/r0_w1_wl u_t002_016/r0_r0_rwl u_t002_016/r0_r1_rwl
+ u_t002_016/r1_w0_wl u_t002_016/r1_w1_wl u_t002_016/r1_r0_rwl u_t002_016/r1_r1_rwl
+ u_t002_016/r2_w0_wl u_t002_016/r2_w1_wl u_t002_016/r2_r0_rwl u_t002_016/r2_r1_rwl
+ u_t002_016/r3_w0_wl u_t002_016/r3_w1_wl u_t002_016/r3_r0_rwl u_t002_016/r3_r1_rwl
+ VSS u_t002_017/VSS VSUBS detronyx_12t_2w2r_rc4_4x4_routed_5layer_direct
Xgf180mcu_as_sc_mcu7t3v3__inv_2_1206 gf180mcu_as_sc_mcu7t3v3__nor2_2_8/VDD gf180mcu_as_sc_mcu7t3v3__nand3_2_32/VSS
+ VSS VSS gf180mcu_as_sc_mcu7t3v3__nor2_2_8/VNW VSUBS gf180mcu_as_sc_mcu7t3v3__inv_2
Xgf180mcu_as_sc_mcu7t3v3__inv_2_1217 gf180mcu_as_sc_mcu7t3v3__nand3_2_31/VDD gf180mcu_as_sc_mcu7t3v3__nand3_2_31/VSS
+ VSS VSS gf180mcu_as_sc_mcu7t3v3__nand3_2_31/VNW VSUBS gf180mcu_as_sc_mcu7t3v3__inv_2
Xgf180mcu_as_sc_mcu7t3v3__inv_2_1239 VSS VSS VSS VSS gf180mcu_as_sc_mcu7t3v3__inv_2_1241/VNW
+ VSUBS gf180mcu_as_sc_mcu7t3v3__inv_2
Xgf180mcu_as_sc_mcu7t3v3__inv_2_1228 VSS VSS VSS VSS gf180mcu_as_sc_mcu7t3v3__inv_2_1229/VNW
+ VSUBS gf180mcu_as_sc_mcu7t3v3__inv_2
Xgf180mcu_as_sc_mcu7t3v3__nand4_2_501 VSS VSS VSS VSS VSS VSS VSS gf180mcu_as_sc_mcu7t3v3__inv_2_1679/VNW
+ VSUBS gf180mcu_as_sc_mcu7t3v3__nand4_2
Xgf180mcu_as_sc_mcu7t3v3__nand4_2_512 VSS VSS VSS VSS VSS VSS gf180mcu_as_sc_mcu7t3v3__nand4_2_512/Y
+ gf180mcu_as_sc_mcu7t3v3__inv_2_1697/VNW VSUBS gf180mcu_as_sc_mcu7t3v3__nand4_2
Xgf180mcu_as_sc_mcu7t3v3__inv_2_1058 VSS gf180mcu_as_sc_mcu7t3v3__inv_2_1064/VDD VSS
+ gf180mcu_as_sc_mcu7t3v3__inv_2_1144/A gf180mcu_as_sc_mcu7t3v3__inv_2_1060/VNW VSUBS
+ gf180mcu_as_sc_mcu7t3v3__inv_2
Xgf180mcu_as_sc_mcu7t3v3__inv_2_1003 gf180mcu_as_sc_mcu7t3v3__inv_2_1053/VDD VSS gf180mcu_as_sc_mcu7t3v3__inv_2_1053/A
+ VSS gf180mcu_as_sc_mcu7t3v3__inv_2_1053/VNW VSUBS gf180mcu_as_sc_mcu7t3v3__inv_2
Xgf180mcu_as_sc_mcu7t3v3__inv_2_1014 VSS VSS gf180mcu_as_sc_mcu7t3v3__inv_2_1014/Y
+ gf180mcu_as_sc_mcu7t3v3__inv_2_1015/Y gf180mcu_as_sc_mcu7t3v3__inv_2_1015/VNW VSUBS
+ gf180mcu_as_sc_mcu7t3v3__inv_2
Xgf180mcu_as_sc_mcu7t3v3__inv_2_1047 VSS VSS gf180mcu_as_sc_mcu7t3v3__inv_2_1047/Y
+ gf180mcu_as_sc_mcu7t3v3__inv_2_1051/Y gf180mcu_as_sc_mcu7t3v3__inv_2_1051/VNW VSUBS
+ gf180mcu_as_sc_mcu7t3v3__inv_2
Xgf180mcu_as_sc_mcu7t3v3__inv_2_1025 VSS gf180mcu_as_sc_mcu7t3v3__inv_2_1030/VDD gf180mcu_as_sc_mcu7t3v3__inv_2_1025/Y
+ gf180mcu_as_sc_mcu7t3v3__inv_2_1026/Y gf180mcu_as_sc_mcu7t3v3__inv_2_1026/VNW VSUBS
+ gf180mcu_as_sc_mcu7t3v3__inv_2
Xgf180mcu_as_sc_mcu7t3v3__inv_2_99 gf180mcu_as_sc_mcu7t3v3__inv_2_99/VDD gf180mcu_as_sc_mcu7t3v3__inv_2_99/VSS
+ gf180mcu_as_sc_mcu7t3v3__inv_2_99/Y VSS gf180mcu_as_sc_mcu7t3v3__inv_2_99/VNW VSUBS
+ gf180mcu_as_sc_mcu7t3v3__inv_2
Xgf180mcu_as_sc_mcu7t3v3__inv_2_55 gf180mcu_as_sc_mcu7t3v3__inv_2_2/VDD gf180mcu_as_sc_mcu7t3v3__inv_2_9/VSS
+ gf180mcu_as_sc_mcu7t3v3__inv_2_2/A VSS gf180mcu_as_sc_mcu7t3v3__inv_2_2/VNW VSUBS
+ gf180mcu_as_sc_mcu7t3v3__inv_2
Xgf180mcu_as_sc_mcu7t3v3__inv_2_88 gf180mcu_as_sc_mcu7t3v3__inv_2_96/VSS gf180mcu_as_sc_mcu7t3v3__inv_2_88/VSS
+ VSS VSS gf180mcu_as_sc_mcu7t3v3__inv_2_88/VNW VSUBS gf180mcu_as_sc_mcu7t3v3__inv_2
Xgf180mcu_as_sc_mcu7t3v3__inv_2_11 gf180mcu_as_sc_mcu7t3v3__inv_2_8/VSS VSS VSS gf180mcu_as_sc_mcu7t3v3__inv_2_8/A
+ gf180mcu_as_sc_mcu7t3v3__inv_2_53/VNW VSUBS gf180mcu_as_sc_mcu7t3v3__inv_2
Xgf180mcu_as_sc_mcu7t3v3__inv_2_33 gf180mcu_as_sc_mcu7t3v3__inv_2_61/VDD gf180mcu_as_sc_mcu7t3v3__inv_2_62/VDD
+ VSS gf180mcu_as_sc_mcu7t3v3__inv_2_77/Y gf180mcu_as_sc_mcu7t3v3__inv_2_61/VNW VSUBS
+ gf180mcu_as_sc_mcu7t3v3__inv_2
Xgf180mcu_as_sc_mcu7t3v3__inv_2_77 gf180mcu_as_sc_mcu7t3v3__inv_2_77/VDD gf180mcu_as_sc_mcu7t3v3__inv_2_77/VSS
+ gf180mcu_as_sc_mcu7t3v3__inv_2_77/Y VSS gf180mcu_as_sc_mcu7t3v3__inv_2_77/VNW VSUBS
+ gf180mcu_as_sc_mcu7t3v3__inv_2
Xgf180mcu_as_sc_mcu7t3v3__inv_2_22 gf180mcu_as_sc_mcu7t3v3__inv_2_74/VDD gf180mcu_as_sc_mcu7t3v3__inv_2_75/VDD
+ VSS gf180mcu_as_sc_mcu7t3v3__inv_2_77/Y gf180mcu_as_sc_mcu7t3v3__inv_2_74/VNW VSUBS
+ gf180mcu_as_sc_mcu7t3v3__inv_2
Xgf180mcu_as_sc_mcu7t3v3__inv_2_44 gf180mcu_as_sc_mcu7t3v3__inv_2_70/VDD gf180mcu_as_sc_mcu7t3v3__inv_2_71/VDD
+ gf180mcu_as_sc_mcu7t3v3__inv_2_44/Y gf180mcu_as_sc_mcu7t3v3__inv_2_71/Y gf180mcu_as_sc_mcu7t3v3__inv_2_70/VNW
+ VSUBS gf180mcu_as_sc_mcu7t3v3__inv_2
Xgf180mcu_as_sc_mcu7t3v3__inv_2_66 gf180mcu_as_sc_mcu7t3v3__inv_2_66/VDD gf180mcu_as_sc_mcu7t3v3__inv_2_66/VSS
+ gf180mcu_as_sc_mcu7t3v3__inv_2_66/Y VSS gf180mcu_as_sc_mcu7t3v3__inv_2_66/VNW VSUBS
+ gf180mcu_as_sc_mcu7t3v3__inv_2
Xgf180mcu_as_sc_mcu7t3v3__inv_2_1036 VSS gf180mcu_as_sc_mcu7t3v3__inv_2_1042/VDD VSS
+ gf180mcu_as_sc_mcu7t3v3__inv_2_992/A gf180mcu_as_sc_mcu7t3v3__inv_2_1038/VNW VSUBS
+ gf180mcu_as_sc_mcu7t3v3__inv_2
Xgf180mcu_as_sc_mcu7t3v3__inv_2_1069 VSS VSS gf180mcu_as_sc_mcu7t3v3__inv_2_1294/Y
+ gf180mcu_as_sc_mcu7t3v3__inv_2_1073/Y gf180mcu_as_sc_mcu7t3v3__inv_2_1073/VNW VSUBS
+ gf180mcu_as_sc_mcu7t3v3__inv_2
Xgf180mcu_as_sc_mcu7t3v3__inv_2_509 VSS VSS VSS VSS gf180mcu_as_sc_mcu7t3v3__inv_2_510/VNW
+ VSUBS gf180mcu_as_sc_mcu7t3v3__inv_2
Xgf180mcu_as_sc_mcu7t3v3__inv_2_1581 gf180mcu_as_sc_mcu7t3v3__inv_2_1581/VDD VSS VSS
+ VSS gf180mcu_as_sc_mcu7t3v3__inv_2_1581/VNW VSUBS gf180mcu_as_sc_mcu7t3v3__inv_2
Xgf180mcu_as_sc_mcu7t3v3__inv_2_1570 VSS VSS VSS VSS gf180mcu_as_sc_mcu7t3v3__inv_2_1570/VNW
+ VSUBS gf180mcu_as_sc_mcu7t3v3__inv_2
Xgf180mcu_as_sc_mcu7t3v3__inv_2_1592 VSS gf180mcu_as_sc_mcu7t3v3__inv_2_1592/VSS gf180mcu_as_sc_mcu7t3v3__inv_2_1592/Y
+ VSS gf180mcu_as_sc_mcu7t3v3__inv_2_1592/VNW VSUBS gf180mcu_as_sc_mcu7t3v3__inv_2
Xgf180mcu_as_sc_mcu7t3v3__nand3_2_3 gf180mcu_as_sc_mcu7t3v3__nor2_2_6/VDD gf180mcu_as_sc_mcu7t3v3__nand3_2_3/VSS
+ VSS VSS VSS VSS gf180mcu_as_sc_mcu7t3v3__nor2_2_6/VNW VSUBS gf180mcu_as_sc_mcu7t3v3__nand3_2
Xgf180mcu_as_sc_mcu7t3v3__nand4_2_353 VSS VSS VSS VSS VSS VSS VSS gf180mcu_as_sc_mcu7t3v3__inv_2_1284/VNW
+ VSUBS gf180mcu_as_sc_mcu7t3v3__nand4_2
Xgf180mcu_as_sc_mcu7t3v3__nand4_2_342 gf180mcu_as_sc_mcu7t3v3__inv_2_1143/VDD VSS
+ VSS VSS VSS VSS VSS gf180mcu_as_sc_mcu7t3v3__inv_2_1143/VNW VSUBS gf180mcu_as_sc_mcu7t3v3__nand4_2
Xgf180mcu_as_sc_mcu7t3v3__nand4_2_364 VSS VSS VSS VSS VSS VSS gf180mcu_as_sc_mcu7t3v3__nand4_2_364/Y
+ gf180mcu_as_sc_mcu7t3v3__inv_2_1160/VNW VSUBS gf180mcu_as_sc_mcu7t3v3__nand4_2
Xgf180mcu_as_sc_mcu7t3v3__nand4_2_331 VSS VSS VSS VSS VSS VSS VSS gf180mcu_as_sc_mcu7t3v3__inv_2_1073/VNW
+ VSUBS gf180mcu_as_sc_mcu7t3v3__nand4_2
Xgf180mcu_as_sc_mcu7t3v3__nand4_2_375 VSS VSS VSS VSS VSS VSS gf180mcu_as_sc_mcu7t3v3__nand4_2_375/Y
+ gf180mcu_as_sc_mcu7t3v3__inv_2_1172/VNW VSUBS gf180mcu_as_sc_mcu7t3v3__nand4_2
Xgf180mcu_as_sc_mcu7t3v3__nand4_2_320 gf180mcu_as_sc_mcu7t3v3__inv_2_1089/VSS gf180mcu_as_sc_mcu7t3v3__inv_2_1295/VDD
+ VSS VSS VSS VSS VSS gf180mcu_as_sc_mcu7t3v3__inv_2_1068/VNW VSUBS gf180mcu_as_sc_mcu7t3v3__nand4_2
Xgf180mcu_as_sc_mcu7t3v3__nand4_2_397 VSS gf180mcu_as_sc_mcu7t3v3__inv_2_1400/VDD
+ VSS VSS VSS VSS VSS gf180mcu_as_sc_mcu7t3v3__inv_2_1399/VNW VSUBS gf180mcu_as_sc_mcu7t3v3__nand4_2
Xgf180mcu_as_sc_mcu7t3v3__nand4_2_386 VSS VSS VSS VSS VSS VSS VSS gf180mcu_as_sc_mcu7t3v3__inv_2_1367/VNW
+ VSUBS gf180mcu_as_sc_mcu7t3v3__nand4_2
Xu_t029_030 u_t029_030/c0_w0_bl u_t029_030/c0_w0_br u_t029_030/c0_w1_bl u_t029_030/c0_w1_br
+ u_t029_030/c0_r0_rbl u_t029_030/c0_r1_rbl u_t029_030/c1_w0_bl u_t029_030/c1_w0_br
+ u_t029_030/c1_w1_bl u_t029_030/c1_w1_br u_t029_030/c1_r0_rbl u_t029_030/c1_r1_rbl
+ u_t029_030/c2_w0_bl u_t029_030/c2_w0_br u_t029_030/c2_w1_bl u_t029_030/c2_w1_br
+ u_t029_030/c2_r0_rbl u_t029_030/c2_r1_rbl u_t029_030/c3_w0_bl u_t029_030/c3_w0_br
+ u_t029_030/c3_w1_bl u_t029_030/c3_w1_br u_t029_030/c3_r0_rbl u_t029_030/c3_r1_rbl
+ u_t029_030/r0_w0_wl u_t029_030/r0_w1_wl u_t029_030/r0_r0_rwl u_t029_030/r0_r1_rwl
+ u_t029_030/r1_w0_wl u_t029_030/r1_w1_wl u_t029_030/r1_r0_rwl u_t029_030/r1_r1_rwl
+ u_t029_030/r2_w0_wl u_t029_030/r2_w1_wl u_t029_030/r2_r0_rwl u_t029_030/r2_r1_rwl
+ u_t029_030/r3_w0_wl u_t029_030/r3_w1_wl u_t029_030/r3_r0_rwl u_t029_030/r3_r1_rwl
+ VSS u_t029_031/VSS VSUBS detronyx_12t_2w2r_rc4_4x4_routed_5layer_direct
Xgf180mcu_as_sc_mcu7t3v3__inv_2_306 gf180mcu_as_sc_mcu7t3v3__inv_2_341/VDD VSS gf180mcu_as_sc_mcu7t3v3__inv_2_306/Y
+ gf180mcu_as_sc_mcu7t3v3__inv_2_341/Y gf180mcu_as_sc_mcu7t3v3__inv_2_341/VNW VSUBS
+ gf180mcu_as_sc_mcu7t3v3__inv_2
Xgf180mcu_as_sc_mcu7t3v3__inv_2_328 VSS gf180mcu_as_sc_mcu7t3v3__inv_2_341/VDD VSS
+ gf180mcu_as_sc_mcu7t3v3__inv_2_341/Y gf180mcu_as_sc_mcu7t3v3__inv_2_340/VNW VSUBS
+ gf180mcu_as_sc_mcu7t3v3__inv_2
Xgf180mcu_as_sc_mcu7t3v3__inv_2_339 VSS VSS gf180mcu_as_sc_mcu7t3v3__inv_2_341/Y VSS
+ gf180mcu_as_sc_mcu7t3v3__inv_2_339/VNW VSUBS gf180mcu_as_sc_mcu7t3v3__inv_2
Xgf180mcu_as_sc_mcu7t3v3__inv_2_317 VSS gf180mcu_as_sc_mcu7t3v3__inv_2_337/VDD gf180mcu_as_sc_mcu7t3v3__inv_2_338/Y
+ gf180mcu_as_sc_mcu7t3v3__inv_2_338/Y gf180mcu_as_sc_mcu7t3v3__inv_2_336/VNW VSUBS
+ gf180mcu_as_sc_mcu7t3v3__inv_2
Xgf180mcu_as_sc_mcu7t3v3__inv_2_851 VSS VSS VSS VSS gf180mcu_as_sc_mcu7t3v3__inv_2_852/VNW
+ VSUBS gf180mcu_as_sc_mcu7t3v3__inv_2
Xgf180mcu_as_sc_mcu7t3v3__inv_2_840 VSS VSS gf180mcu_as_sc_mcu7t3v3__inv_2_840/Y VSS
+ gf180mcu_as_sc_mcu7t3v3__inv_2_840/VNW VSUBS gf180mcu_as_sc_mcu7t3v3__inv_2
Xgf180mcu_as_sc_mcu7t3v3__inv_2_895 VSS VSS VSS VSS gf180mcu_as_sc_mcu7t3v3__inv_2_896/VNW
+ VSUBS gf180mcu_as_sc_mcu7t3v3__inv_2
Xgf180mcu_as_sc_mcu7t3v3__inv_2_884 VSS VSS VSS VSS gf180mcu_as_sc_mcu7t3v3__inv_2_884/VNW
+ VSUBS gf180mcu_as_sc_mcu7t3v3__inv_2
Xgf180mcu_as_sc_mcu7t3v3__inv_2_862 VSS VSS VSS VSS gf180mcu_as_sc_mcu7t3v3__inv_2_864/VNW
+ VSUBS gf180mcu_as_sc_mcu7t3v3__inv_2
Xgf180mcu_as_sc_mcu7t3v3__inv_2_873 VSS VSS VSS VSS gf180mcu_as_sc_mcu7t3v3__inv_2_881/VNW
+ VSUBS gf180mcu_as_sc_mcu7t3v3__inv_2
Xu_t026_022 u_t026_022/c0_w0_bl u_t026_022/c0_w0_br u_t026_022/c0_w1_bl u_t026_022/c0_w1_br
+ u_t026_022/c0_r0_rbl u_t026_022/c0_r1_rbl u_t026_022/c1_w0_bl u_t026_022/c1_w0_br
+ u_t026_022/c1_w1_bl u_t026_022/c1_w1_br u_t026_022/c1_r0_rbl u_t026_022/c1_r1_rbl
+ u_t026_022/c2_w0_bl u_t026_022/c2_w0_br u_t026_022/c2_w1_bl u_t026_022/c2_w1_br
+ u_t026_022/c2_r0_rbl u_t026_022/c2_r1_rbl u_t026_022/c3_w0_bl u_t026_022/c3_w0_br
+ u_t026_022/c3_w1_bl u_t026_022/c3_w1_br u_t026_022/c3_r0_rbl u_t026_022/c3_r1_rbl
+ u_t026_022/r0_w0_wl u_t026_022/r0_w1_wl u_t026_022/r0_r0_rwl u_t026_022/r0_r1_rwl
+ u_t026_022/r1_w0_wl u_t026_022/r1_w1_wl u_t026_022/r1_r0_rwl u_t026_022/r1_r1_rwl
+ u_t026_022/r2_w0_wl u_t026_022/r2_w1_wl u_t026_022/r2_r0_rwl u_t026_022/r2_r1_rwl
+ u_t026_022/r3_w0_wl u_t026_022/r3_w1_wl u_t026_022/r3_r0_rwl u_t026_022/r3_r1_rwl
+ VSS u_t026_031/VSS VSUBS detronyx_12t_2w2r_rc4_4x4_routed_5layer_direct
Xu_t026_011 u_t026_011/c0_w0_bl u_t026_011/c0_w0_br u_t026_011/c0_w1_bl u_t026_011/c0_w1_br
+ u_t026_011/c0_r0_rbl u_t026_011/c0_r1_rbl u_t026_011/c1_w0_bl u_t026_011/c1_w0_br
+ u_t026_011/c1_w1_bl u_t026_011/c1_w1_br u_t026_011/c1_r0_rbl u_t026_011/c1_r1_rbl
+ u_t026_011/c2_w0_bl u_t026_011/c2_w0_br u_t026_011/c2_w1_bl u_t026_011/c2_w1_br
+ u_t026_011/c2_r0_rbl u_t026_011/c2_r1_rbl u_t026_011/c3_w0_bl u_t026_011/c3_w0_br
+ u_t026_011/c3_w1_bl u_t026_011/c3_w1_br u_t026_011/c3_r0_rbl u_t026_011/c3_r1_rbl
+ u_t026_011/r0_w0_wl u_t026_011/r0_w1_wl u_t026_011/r0_r0_rwl u_t026_011/r0_r1_rwl
+ u_t026_011/r1_w0_wl u_t026_011/r1_w1_wl u_t026_011/r1_r0_rwl u_t026_011/r1_r1_rwl
+ u_t026_011/r2_w0_wl u_t026_011/r2_w1_wl u_t026_011/r2_r0_rwl u_t026_011/r2_r1_rwl
+ u_t026_011/r3_w0_wl u_t026_011/r3_w1_wl u_t026_011/r3_r0_rwl u_t026_011/r3_r1_rwl
+ u_t026_011/VDD u_t026_031/VSS VSUBS detronyx_12t_2w2r_rc4_4x4_routed_5layer_direct
Xu_t026_000 u_t026_000/c0_w0_bl u_t026_000/c0_w0_br u_t026_000/c0_w1_bl u_t026_000/c0_w1_br
+ u_t026_000/c0_r0_rbl u_t026_000/c0_r1_rbl u_t026_000/c1_w0_bl u_t026_000/c1_w0_br
+ u_t026_000/c1_w1_bl u_t026_000/c1_w1_br u_t026_000/c1_r0_rbl u_t026_000/c1_r1_rbl
+ u_t026_000/c2_w0_bl u_t026_000/c2_w0_br u_t026_000/c2_w1_bl u_t026_000/c2_w1_br
+ u_t026_000/c2_r0_rbl u_t026_000/c2_r1_rbl u_t026_000/c3_w0_bl u_t026_000/c3_w0_br
+ u_t026_000/c3_w1_bl u_t026_000/c3_w1_br u_t026_000/c3_r0_rbl u_t026_000/c3_r1_rbl
+ u_t026_000/r0_w0_wl u_t026_000/r0_w1_wl u_t026_000/r0_r0_rwl u_t026_000/r0_r1_rwl
+ u_t026_000/r1_w0_wl u_t026_000/r1_w1_wl u_t026_000/r1_r0_rwl u_t026_000/r1_r1_rwl
+ u_t026_000/r2_w0_wl u_t026_000/r2_w1_wl u_t026_000/r2_r0_rwl u_t026_000/r2_r1_rwl
+ u_t026_000/r3_w0_wl u_t026_000/r3_w1_wl u_t026_000/r3_r0_rwl u_t026_000/r3_r1_rwl
+ VSS u_t026_031/VSS VSUBS detronyx_12t_2w2r_rc4_4x4_routed_5layer_direct
Xgf180mcu_as_sc_mcu7t3v3__nand4_2_150 gf180mcu_as_sc_mcu7t3v3__nor2_2_6/VDD gf180mcu_as_sc_mcu7t3v3__nor2_2_6/VSS
+ VSS VSS VSS VSS VSS gf180mcu_as_sc_mcu7t3v3__nor2_2_6/VNW VSUBS gf180mcu_as_sc_mcu7t3v3__nand4_2
Xgf180mcu_as_sc_mcu7t3v3__nand4_2_172 gf180mcu_as_sc_mcu7t3v3__inv_2_597/VDD gf180mcu_as_sc_mcu7t3v3__inv_2_601/VDD
+ VSS VSS VSS VSS VSS gf180mcu_as_sc_mcu7t3v3__inv_2_597/VNW VSUBS gf180mcu_as_sc_mcu7t3v3__nand4_2
Xgf180mcu_as_sc_mcu7t3v3__nand4_2_161 gf180mcu_as_sc_mcu7t3v3__inv_2_630/VDD gf180mcu_as_sc_mcu7t3v3__inv_2_630/VSS
+ VSS VSS VSS VSS VSS gf180mcu_as_sc_mcu7t3v3__inv_2_630/VNW VSUBS gf180mcu_as_sc_mcu7t3v3__nand4_2
Xgf180mcu_as_sc_mcu7t3v3__nand4_2_183 gf180mcu_as_sc_mcu7t3v3__inv_2_727/VSS gf180mcu_as_sc_mcu7t3v3__inv_2_731/VDD
+ VSS VSS VSS VSS VSS gf180mcu_as_sc_mcu7t3v3__inv_2_707/VNW VSUBS gf180mcu_as_sc_mcu7t3v3__nand4_2
Xgf180mcu_as_sc_mcu7t3v3__nand4_2_194 VSS VSS VSS VSS VSS VSS VSS gf180mcu_as_sc_mcu7t3v3__inv_2_736/VNW
+ VSUBS gf180mcu_as_sc_mcu7t3v3__nand4_2
Xu_t017_022 u_t017_022/c0_w0_bl u_t017_022/c0_w0_br u_t017_022/c0_w1_bl u_t017_022/c0_w1_br
+ u_t017_022/c0_r0_rbl u_t017_022/c0_r1_rbl u_t017_022/c1_w0_bl u_t017_022/c1_w0_br
+ u_t017_022/c1_w1_bl u_t017_022/c1_w1_br u_t017_022/c1_r0_rbl u_t017_022/c1_r1_rbl
+ u_t017_022/c2_w0_bl u_t017_022/c2_w0_br u_t017_022/c2_w1_bl u_t017_022/c2_w1_br
+ u_t017_022/c2_r0_rbl u_t017_022/c2_r1_rbl u_t017_022/c3_w0_bl u_t017_022/c3_w0_br
+ u_t017_022/c3_w1_bl u_t017_022/c3_w1_br u_t017_022/c3_r0_rbl u_t017_022/c3_r1_rbl
+ u_t017_022/r0_w0_wl u_t017_022/r0_w1_wl u_t017_022/r0_r0_rwl u_t017_022/r0_r1_rwl
+ u_t017_022/r1_w0_wl u_t017_022/r1_w1_wl u_t017_022/r1_r0_rwl u_t017_022/r1_r1_rwl
+ u_t017_022/r2_w0_wl u_t017_022/r2_w1_wl u_t017_022/r2_r0_rwl u_t017_022/r2_r1_rwl
+ u_t017_022/r3_w0_wl u_t017_022/r3_w1_wl u_t017_022/r3_r0_rwl u_t017_022/r3_r1_rwl
+ VSS u_t017_031/VSS VSUBS detronyx_12t_2w2r_rc4_4x4_routed_5layer_direct
Xu_t017_011 u_t017_011/c0_w0_bl u_t017_011/c0_w0_br u_t017_011/c0_w1_bl u_t017_011/c0_w1_br
+ u_t017_011/c0_r0_rbl u_t017_011/c0_r1_rbl u_t017_011/c1_w0_bl u_t017_011/c1_w0_br
+ u_t017_011/c1_w1_bl u_t017_011/c1_w1_br u_t017_011/c1_r0_rbl u_t017_011/c1_r1_rbl
+ u_t017_011/c2_w0_bl u_t017_011/c2_w0_br u_t017_011/c2_w1_bl u_t017_011/c2_w1_br
+ u_t017_011/c2_r0_rbl u_t017_011/c2_r1_rbl u_t017_011/c3_w0_bl u_t017_011/c3_w0_br
+ u_t017_011/c3_w1_bl u_t017_011/c3_w1_br u_t017_011/c3_r0_rbl u_t017_011/c3_r1_rbl
+ u_t017_011/r0_w0_wl u_t017_011/r0_w1_wl u_t017_011/r0_r0_rwl u_t017_011/r0_r1_rwl
+ u_t017_011/r1_w0_wl u_t017_011/r1_w1_wl u_t017_011/r1_r0_rwl u_t017_011/r1_r1_rwl
+ u_t017_011/r2_w0_wl u_t017_011/r2_w1_wl u_t017_011/r2_r0_rwl u_t017_011/r2_r1_rwl
+ u_t017_011/r3_w0_wl u_t017_011/r3_w1_wl u_t017_011/r3_r0_rwl u_t017_011/r3_r1_rwl
+ u_t017_011/VDD u_t017_031/VSS VSUBS detronyx_12t_2w2r_rc4_4x4_routed_5layer_direct
Xu_t017_000 u_t017_000/c0_w0_bl u_t017_000/c0_w0_br u_t017_000/c0_w1_bl u_t017_000/c0_w1_br
+ u_t017_000/c0_r0_rbl u_t017_000/c0_r1_rbl u_t017_000/c1_w0_bl u_t017_000/c1_w0_br
+ u_t017_000/c1_w1_bl u_t017_000/c1_w1_br u_t017_000/c1_r0_rbl u_t017_000/c1_r1_rbl
+ u_t017_000/c2_w0_bl u_t017_000/c2_w0_br u_t017_000/c2_w1_bl u_t017_000/c2_w1_br
+ u_t017_000/c2_r0_rbl u_t017_000/c2_r1_rbl u_t017_000/c3_w0_bl u_t017_000/c3_w0_br
+ u_t017_000/c3_w1_bl u_t017_000/c3_w1_br u_t017_000/c3_r0_rbl u_t017_000/c3_r1_rbl
+ u_t017_000/r0_w0_wl u_t017_000/r0_w1_wl u_t017_000/r0_r0_rwl u_t017_000/r0_r1_rwl
+ u_t017_000/r1_w0_wl u_t017_000/r1_w1_wl u_t017_000/r1_r0_rwl u_t017_000/r1_r1_rwl
+ u_t017_000/r2_w0_wl u_t017_000/r2_w1_wl u_t017_000/r2_r0_rwl u_t017_000/r2_r1_rwl
+ u_t017_000/r3_w0_wl u_t017_000/r3_w1_wl u_t017_000/r3_r0_rwl u_t017_000/r3_r1_rwl
+ VSS u_t017_031/VSS VSUBS detronyx_12t_2w2r_rc4_4x4_routed_5layer_direct
Xgf180mcu_as_sc_mcu7t3v3__inv_2_103 gf180mcu_as_sc_mcu7t3v3__inv_2_99/VSS gf180mcu_as_sc_mcu7t3v3__inv_2_96/VDD
+ gf180mcu_as_sc_mcu7t3v3__inv_2_103/Y VSS gf180mcu_as_sc_mcu7t3v3__inv_2_103/VNW
+ VSUBS gf180mcu_as_sc_mcu7t3v3__inv_2
Xgf180mcu_as_sc_mcu7t3v3__inv_2_136 gf180mcu_as_sc_mcu7t3v3__inv_2_138/VDD VSS VSS
+ VSS gf180mcu_as_sc_mcu7t3v3__inv_2_138/VNW VSUBS gf180mcu_as_sc_mcu7t3v3__inv_2
Xgf180mcu_as_sc_mcu7t3v3__inv_2_125 gf180mcu_as_sc_mcu7t3v3__inv_2_126/VDD VSS VSS
+ VSS gf180mcu_as_sc_mcu7t3v3__inv_2_126/VNW VSUBS gf180mcu_as_sc_mcu7t3v3__inv_2
Xgf180mcu_as_sc_mcu7t3v3__inv_2_147 gf180mcu_as_sc_mcu7t3v3__inv_2_151/VDD gf180mcu_as_sc_mcu7t3v3__inv_2_151/VSS
+ gf180mcu_as_sc_mcu7t3v3__inv_2_147/Y VSS gf180mcu_as_sc_mcu7t3v3__inv_2_151/VNW
+ VSUBS gf180mcu_as_sc_mcu7t3v3__inv_2
Xgf180mcu_as_sc_mcu7t3v3__inv_2_114 gf180mcu_as_sc_mcu7t3v3__inv_2_115/VDD gf180mcu_as_sc_mcu7t3v3__inv_2_119/VDD
+ gf180mcu_as_sc_mcu7t3v3__inv_2_114/Y VSS gf180mcu_as_sc_mcu7t3v3__inv_2_115/VNW
+ VSUBS gf180mcu_as_sc_mcu7t3v3__inv_2
Xgf180mcu_as_sc_mcu7t3v3__inv_2_169 VSS VSS VSS VSS gf180mcu_as_sc_mcu7t3v3__inv_2_169/VNW
+ VSUBS gf180mcu_as_sc_mcu7t3v3__inv_2
Xgf180mcu_as_sc_mcu7t3v3__inv_2_158 VSS gf180mcu_as_sc_mcu7t3v3__inv_2_188/VDD VSS
+ VSS gf180mcu_as_sc_mcu7t3v3__inv_2_181/VNW VSUBS gf180mcu_as_sc_mcu7t3v3__inv_2
Xu_t008_022 u_t008_022/c0_w0_bl u_t008_022/c0_w0_br u_t008_022/c0_w1_bl u_t008_022/c0_w1_br
+ u_t008_022/c0_r0_rbl u_t008_022/c0_r1_rbl u_t008_022/c1_w0_bl u_t008_022/c1_w0_br
+ u_t008_022/c1_w1_bl u_t008_022/c1_w1_br u_t008_022/c1_r0_rbl u_t008_022/c1_r1_rbl
+ u_t008_022/c2_w0_bl u_t008_022/c2_w0_br u_t008_022/c2_w1_bl u_t008_022/c2_w1_br
+ u_t008_022/c2_r0_rbl u_t008_022/c2_r1_rbl u_t008_022/c3_w0_bl u_t008_022/c3_w0_br
+ u_t008_022/c3_w1_bl u_t008_022/c3_w1_br u_t008_022/c3_r0_rbl u_t008_022/c3_r1_rbl
+ u_t008_022/r0_w0_wl u_t008_022/r0_w1_wl u_t008_022/r0_r0_rwl u_t008_022/r0_r1_rwl
+ u_t008_022/r1_w0_wl u_t008_022/r1_w1_wl u_t008_022/r1_r0_rwl u_t008_022/r1_r1_rwl
+ u_t008_022/r2_w0_wl u_t008_022/r2_w1_wl u_t008_022/r2_r0_rwl u_t008_022/r2_r1_rwl
+ u_t008_022/r3_w0_wl u_t008_022/r3_w1_wl u_t008_022/r3_r0_rwl u_t008_022/r3_r1_rwl
+ VSS u_t008_031/VSS VSUBS detronyx_12t_2w2r_rc4_4x4_routed_5layer_direct
Xu_t008_011 u_t008_011/c0_w0_bl u_t008_011/c0_w0_br u_t008_011/c0_w1_bl u_t008_011/c0_w1_br
+ u_t008_011/c0_r0_rbl u_t008_011/c0_r1_rbl u_t008_011/c1_w0_bl u_t008_011/c1_w0_br
+ u_t008_011/c1_w1_bl u_t008_011/c1_w1_br u_t008_011/c1_r0_rbl u_t008_011/c1_r1_rbl
+ u_t008_011/c2_w0_bl u_t008_011/c2_w0_br u_t008_011/c2_w1_bl u_t008_011/c2_w1_br
+ u_t008_011/c2_r0_rbl u_t008_011/c2_r1_rbl u_t008_011/c3_w0_bl u_t008_011/c3_w0_br
+ u_t008_011/c3_w1_bl u_t008_011/c3_w1_br u_t008_011/c3_r0_rbl u_t008_011/c3_r1_rbl
+ u_t008_011/r0_w0_wl u_t008_011/r0_w1_wl u_t008_011/r0_r0_rwl u_t008_011/r0_r1_rwl
+ u_t008_011/r1_w0_wl u_t008_011/r1_w1_wl u_t008_011/r1_r0_rwl u_t008_011/r1_r1_rwl
+ u_t008_011/r2_w0_wl u_t008_011/r2_w1_wl u_t008_011/r2_r0_rwl u_t008_011/r2_r1_rwl
+ u_t008_011/r3_w0_wl u_t008_011/r3_w1_wl u_t008_011/r3_r0_rwl u_t008_011/r3_r1_rwl
+ u_t008_011/VDD u_t008_031/VSS VSUBS detronyx_12t_2w2r_rc4_4x4_routed_5layer_direct
Xu_t008_000 u_t008_000/c0_w0_bl u_t008_000/c0_w0_br u_t008_000/c0_w1_bl u_t008_000/c0_w1_br
+ u_t008_000/c0_r0_rbl u_t008_000/c0_r1_rbl u_t008_000/c1_w0_bl u_t008_000/c1_w0_br
+ u_t008_000/c1_w1_bl u_t008_000/c1_w1_br u_t008_000/c1_r0_rbl u_t008_000/c1_r1_rbl
+ u_t008_000/c2_w0_bl u_t008_000/c2_w0_br u_t008_000/c2_w1_bl u_t008_000/c2_w1_br
+ u_t008_000/c2_r0_rbl u_t008_000/c2_r1_rbl u_t008_000/c3_w0_bl u_t008_000/c3_w0_br
+ u_t008_000/c3_w1_bl u_t008_000/c3_w1_br u_t008_000/c3_r0_rbl u_t008_000/c3_r1_rbl
+ u_t008_000/r0_w0_wl u_t008_000/r0_w1_wl u_t008_000/r0_r0_rwl u_t008_000/r0_r1_rwl
+ u_t008_000/r1_w0_wl u_t008_000/r1_w1_wl u_t008_000/r1_r0_rwl u_t008_000/r1_r1_rwl
+ u_t008_000/r2_w0_wl u_t008_000/r2_w1_wl u_t008_000/r2_r0_rwl u_t008_000/r2_r1_rwl
+ u_t008_000/r3_w0_wl u_t008_000/r3_w1_wl u_t008_000/r3_r0_rwl u_t008_000/r3_r1_rwl
+ VSS u_t008_031/VSS VSUBS detronyx_12t_2w2r_rc4_4x4_routed_5layer_direct
Xu_t023_025 u_t023_025/c0_w0_bl u_t023_025/c0_w0_br u_t023_025/c0_w1_bl u_t023_025/c0_w1_br
+ u_t023_025/c0_r0_rbl u_t023_025/c0_r1_rbl u_t023_025/c1_w0_bl u_t023_025/c1_w0_br
+ u_t023_025/c1_w1_bl u_t023_025/c1_w1_br u_t023_025/c1_r0_rbl u_t023_025/c1_r1_rbl
+ u_t023_025/c2_w0_bl u_t023_025/c2_w0_br u_t023_025/c2_w1_bl u_t023_025/c2_w1_br
+ u_t023_025/c2_r0_rbl u_t023_025/c2_r1_rbl u_t023_025/c3_w0_bl u_t023_025/c3_w0_br
+ u_t023_025/c3_w1_bl u_t023_025/c3_w1_br u_t023_025/c3_r0_rbl u_t023_025/c3_r1_rbl
+ u_t023_025/r0_w0_wl u_t023_025/r0_w1_wl u_t023_025/r0_r0_rwl u_t023_025/r0_r1_rwl
+ u_t023_025/r1_w0_wl u_t023_025/r1_w1_wl u_t023_025/r1_r0_rwl u_t023_025/r1_r1_rwl
+ u_t023_025/r2_w0_wl u_t023_025/r2_w1_wl u_t023_025/r2_r0_rwl u_t023_025/r2_r1_rwl
+ u_t023_025/r3_w0_wl u_t023_025/r3_w1_wl u_t023_025/r3_r0_rwl u_t023_025/r3_r1_rwl
+ VSS u_t023_025/VSS VSUBS detronyx_12t_2w2r_rc4_4x4_routed_5layer_direct
Xu_t023_014 u_t023_014/c0_w0_bl u_t023_014/c0_w0_br u_t023_014/c0_w1_bl u_t023_014/c0_w1_br
+ u_t023_014/c0_r0_rbl u_t023_014/c0_r1_rbl u_t023_014/c1_w0_bl u_t023_014/c1_w0_br
+ u_t023_014/c1_w1_bl u_t023_014/c1_w1_br u_t023_014/c1_r0_rbl u_t023_014/c1_r1_rbl
+ u_t023_014/c2_w0_bl u_t023_014/c2_w0_br u_t023_014/c2_w1_bl u_t023_014/c2_w1_br
+ u_t023_014/c2_r0_rbl u_t023_014/c2_r1_rbl u_t023_014/c3_w0_bl u_t023_014/c3_w0_br
+ u_t023_014/c3_w1_bl u_t023_014/c3_w1_br u_t023_014/c3_r0_rbl u_t023_014/c3_r1_rbl
+ u_t023_014/r0_w0_wl u_t023_014/r0_w1_wl u_t023_014/r0_r0_rwl u_t023_014/r0_r1_rwl
+ u_t023_014/r1_w0_wl u_t023_014/r1_w1_wl u_t023_014/r1_r0_rwl u_t023_014/r1_r1_rwl
+ u_t023_014/r2_w0_wl u_t023_014/r2_w1_wl u_t023_014/r2_r0_rwl u_t023_014/r2_r1_rwl
+ u_t023_014/r3_w0_wl u_t023_014/r3_w1_wl u_t023_014/r3_r0_rwl u_t023_014/r3_r1_rwl
+ u_t023_014/VDD u_t023_017/VSS VSUBS detronyx_12t_2w2r_rc4_4x4_routed_5layer_direct
Xu_t023_003 u_t023_003/c0_w0_bl u_t023_003/c0_w0_br u_t023_003/c0_w1_bl u_t023_003/c0_w1_br
+ u_t023_003/c0_r0_rbl u_t023_003/c0_r1_rbl u_t023_003/c1_w0_bl u_t023_003/c1_w0_br
+ u_t023_003/c1_w1_bl u_t023_003/c1_w1_br u_t023_003/c1_r0_rbl u_t023_003/c1_r1_rbl
+ u_t023_003/c2_w0_bl u_t023_003/c2_w0_br u_t023_003/c2_w1_bl u_t023_003/c2_w1_br
+ u_t023_003/c2_r0_rbl u_t023_003/c2_r1_rbl u_t023_003/c3_w0_bl u_t023_003/c3_w0_br
+ u_t023_003/c3_w1_bl u_t023_003/c3_w1_br u_t023_003/c3_r0_rbl u_t023_003/c3_r1_rbl
+ u_t023_003/r0_w0_wl u_t023_003/r0_w1_wl u_t023_003/r0_r0_rwl u_t023_003/r0_r1_rwl
+ u_t023_003/r1_w0_wl u_t023_003/r1_w1_wl u_t023_003/r1_r0_rwl u_t023_003/r1_r1_rwl
+ u_t023_003/r2_w0_wl u_t023_003/r2_w1_wl u_t023_003/r2_r0_rwl u_t023_003/r2_r1_rwl
+ u_t023_003/r3_w0_wl u_t023_003/r3_w1_wl u_t023_003/r3_r0_rwl u_t023_003/r3_r1_rwl
+ u_t023_003/VDD u_t023_003/VSS VSUBS detronyx_12t_2w2r_rc4_4x4_routed_5layer_direct
Xgf180mcu_as_sc_mcu7t3v3__inv_2_670 gf180mcu_as_sc_mcu7t3v3__inv_2_671/VDD VSS gf180mcu_as_sc_mcu7t3v3__inv_2_848/Y
+ gf180mcu_as_sc_mcu7t3v3__inv_2_671/Y gf180mcu_as_sc_mcu7t3v3__inv_2_671/VNW VSUBS
+ gf180mcu_as_sc_mcu7t3v3__inv_2
Xgf180mcu_as_sc_mcu7t3v3__inv_2_681 gf180mcu_as_sc_mcu7t3v3__inv_2_741/VSS gf180mcu_as_sc_mcu7t3v3__inv_2_687/VDD
+ gf180mcu_as_sc_mcu7t3v3__inv_2_681/Y gf180mcu_as_sc_mcu7t3v3__inv_2_739/A gf180mcu_as_sc_mcu7t3v3__inv_2_683/VNW
+ VSUBS gf180mcu_as_sc_mcu7t3v3__inv_2
Xgf180mcu_as_sc_mcu7t3v3__inv_2_692 VSS gf180mcu_as_sc_mcu7t3v3__inv_2_724/VSS gf180mcu_as_sc_mcu7t3v3__inv_2_724/A
+ VSS gf180mcu_as_sc_mcu7t3v3__inv_2_724/VNW VSUBS gf180mcu_as_sc_mcu7t3v3__inv_2
Xu_t014_025 u_t014_025/c0_w0_bl u_t014_025/c0_w0_br u_t014_025/c0_w1_bl u_t014_025/c0_w1_br
+ u_t014_025/c0_r0_rbl u_t014_025/c0_r1_rbl u_t014_025/c1_w0_bl u_t014_025/c1_w0_br
+ u_t014_025/c1_w1_bl u_t014_025/c1_w1_br u_t014_025/c1_r0_rbl u_t014_025/c1_r1_rbl
+ u_t014_025/c2_w0_bl u_t014_025/c2_w0_br u_t014_025/c2_w1_bl u_t014_025/c2_w1_br
+ u_t014_025/c2_r0_rbl u_t014_025/c2_r1_rbl u_t014_025/c3_w0_bl u_t014_025/c3_w0_br
+ u_t014_025/c3_w1_bl u_t014_025/c3_w1_br u_t014_025/c3_r0_rbl u_t014_025/c3_r1_rbl
+ u_t014_025/r0_w0_wl u_t014_025/r0_w1_wl u_t014_025/r0_r0_rwl u_t014_025/r0_r1_rwl
+ u_t014_025/r1_w0_wl u_t014_025/r1_w1_wl u_t014_025/r1_r0_rwl u_t014_025/r1_r1_rwl
+ u_t014_025/r2_w0_wl u_t014_025/r2_w1_wl u_t014_025/r2_r0_rwl u_t014_025/r2_r1_rwl
+ u_t014_025/r3_w0_wl u_t014_025/r3_w1_wl u_t014_025/r3_r0_rwl u_t014_025/r3_r1_rwl
+ VSS u_t014_025/VSS VSUBS detronyx_12t_2w2r_rc4_4x4_routed_5layer_direct
Xu_t014_014 u_t014_014/c0_w0_bl u_t014_014/c0_w0_br u_t014_014/c0_w1_bl u_t014_014/c0_w1_br
+ u_t014_014/c0_r0_rbl u_t014_014/c0_r1_rbl u_t014_014/c1_w0_bl u_t014_014/c1_w0_br
+ u_t014_014/c1_w1_bl u_t014_014/c1_w1_br u_t014_014/c1_r0_rbl u_t014_014/c1_r1_rbl
+ u_t014_014/c2_w0_bl u_t014_014/c2_w0_br u_t014_014/c2_w1_bl u_t014_014/c2_w1_br
+ u_t014_014/c2_r0_rbl u_t014_014/c2_r1_rbl u_t014_014/c3_w0_bl u_t014_014/c3_w0_br
+ u_t014_014/c3_w1_bl u_t014_014/c3_w1_br u_t014_014/c3_r0_rbl u_t014_014/c3_r1_rbl
+ u_t014_014/r0_w0_wl u_t014_014/r0_w1_wl u_t014_014/r0_r0_rwl u_t014_014/r0_r1_rwl
+ u_t014_014/r1_w0_wl u_t014_014/r1_w1_wl u_t014_014/r1_r0_rwl u_t014_014/r1_r1_rwl
+ u_t014_014/r2_w0_wl u_t014_014/r2_w1_wl u_t014_014/r2_r0_rwl u_t014_014/r2_r1_rwl
+ u_t014_014/r3_w0_wl u_t014_014/r3_w1_wl u_t014_014/r3_r0_rwl u_t014_014/r3_r1_rwl
+ u_t014_014/VDD u_t014_017/VSS VSUBS detronyx_12t_2w2r_rc4_4x4_routed_5layer_direct
Xu_t014_003 u_t014_003/c0_w0_bl u_t014_003/c0_w0_br u_t014_003/c0_w1_bl u_t014_003/c0_w1_br
+ u_t014_003/c0_r0_rbl u_t014_003/c0_r1_rbl u_t014_003/c1_w0_bl u_t014_003/c1_w0_br
+ u_t014_003/c1_w1_bl u_t014_003/c1_w1_br u_t014_003/c1_r0_rbl u_t014_003/c1_r1_rbl
+ u_t014_003/c2_w0_bl u_t014_003/c2_w0_br u_t014_003/c2_w1_bl u_t014_003/c2_w1_br
+ u_t014_003/c2_r0_rbl u_t014_003/c2_r1_rbl u_t014_003/c3_w0_bl u_t014_003/c3_w0_br
+ u_t014_003/c3_w1_bl u_t014_003/c3_w1_br u_t014_003/c3_r0_rbl u_t014_003/c3_r1_rbl
+ u_t014_003/r0_w0_wl u_t014_003/r0_w1_wl u_t014_003/r0_r0_rwl u_t014_003/r0_r1_rwl
+ u_t014_003/r1_w0_wl u_t014_003/r1_w1_wl u_t014_003/r1_r0_rwl u_t014_003/r1_r1_rwl
+ u_t014_003/r2_w0_wl u_t014_003/r2_w1_wl u_t014_003/r2_r0_rwl u_t014_003/r2_r1_rwl
+ u_t014_003/r3_w0_wl u_t014_003/r3_w1_wl u_t014_003/r3_r0_rwl u_t014_003/r3_r1_rwl
+ u_t014_003/VDD u_t014_003/VSS VSUBS detronyx_12t_2w2r_rc4_4x4_routed_5layer_direct
Xgf180mcu_as_sc_mcu7t3v3__nand2_2_59 gf180mcu_as_sc_mcu7t3v3__nor2_2_8/VDD gf180mcu_as_sc_mcu7t3v3__nand3_2_32/VSS
+ VSS VSS VSS gf180mcu_as_sc_mcu7t3v3__nor2_2_8/VNW VSUBS gf180mcu_as_sc_mcu7t3v3__nand2_2
Xgf180mcu_as_sc_mcu7t3v3__nand2_2_48 gf180mcu_as_sc_mcu7t3v3__nor2_2_8/VDD gf180mcu_as_sc_mcu7t3v3__nor2_2_8/VSS
+ VSS VSS VSS gf180mcu_as_sc_mcu7t3v3__nor2_2_8/VNW VSUBS gf180mcu_as_sc_mcu7t3v3__nand2_2
Xgf180mcu_as_sc_mcu7t3v3__nand2_2_26 gf180mcu_as_sc_mcu7t3v3__nor2_2_5/VDD gf180mcu_as_sc_mcu7t3v3__nor2_2_5/VSS
+ VSS VSS VSS gf180mcu_as_sc_mcu7t3v3__nor2_2_5/VNW VSUBS gf180mcu_as_sc_mcu7t3v3__nand2_2
Xgf180mcu_as_sc_mcu7t3v3__nand2_2_15 gf180mcu_as_sc_mcu7t3v3__nor2_2_6/VDD gf180mcu_as_sc_mcu7t3v3__nor2_2_6/VSS
+ VSS VSS VSS gf180mcu_as_sc_mcu7t3v3__nor2_2_6/VNW VSUBS gf180mcu_as_sc_mcu7t3v3__nand2_2
Xgf180mcu_as_sc_mcu7t3v3__nand2_2_37 gf180mcu_as_sc_mcu7t3v3__nand3_2_5/VDD gf180mcu_as_sc_mcu7t3v3__nor2_2_4/VSS
+ VSS VSS VSS gf180mcu_as_sc_mcu7t3v3__nand3_2_5/VNW VSUBS gf180mcu_as_sc_mcu7t3v3__nand2_2
Xu_t020_028 u_t020_028/c0_w0_bl u_t020_028/c0_w0_br u_t020_028/c0_w1_bl u_t020_028/c0_w1_br
+ u_t020_028/c0_r0_rbl u_t020_028/c0_r1_rbl u_t020_028/c1_w0_bl u_t020_028/c1_w0_br
+ u_t020_028/c1_w1_bl u_t020_028/c1_w1_br u_t020_028/c1_r0_rbl u_t020_028/c1_r1_rbl
+ u_t020_028/c2_w0_bl u_t020_028/c2_w0_br u_t020_028/c2_w1_bl u_t020_028/c2_w1_br
+ u_t020_028/c2_r0_rbl u_t020_028/c2_r1_rbl u_t020_028/c3_w0_bl u_t020_028/c3_w0_br
+ u_t020_028/c3_w1_bl u_t020_028/c3_w1_br u_t020_028/c3_r0_rbl u_t020_028/c3_r1_rbl
+ u_t020_028/r0_w0_wl u_t020_028/r0_w1_wl u_t020_028/r0_r0_rwl u_t020_028/r0_r1_rwl
+ u_t020_028/r1_w0_wl u_t020_028/r1_w1_wl u_t020_028/r1_r0_rwl u_t020_028/r1_r1_rwl
+ u_t020_028/r2_w0_wl u_t020_028/r2_w1_wl u_t020_028/r2_r0_rwl u_t020_028/r2_r1_rwl
+ u_t020_028/r3_w0_wl u_t020_028/r3_w1_wl u_t020_028/r3_r0_rwl u_t020_028/r3_r1_rwl
+ u_t020_028/VDD u_t020_028/VSS VSUBS detronyx_12t_2w2r_rc4_4x4_routed_5layer_direct
Xu_t005_025 u_t005_025/c0_w0_bl u_t005_025/c0_w0_br u_t005_025/c0_w1_bl u_t005_025/c0_w1_br
+ u_t005_025/c0_r0_rbl u_t005_025/c0_r1_rbl u_t005_025/c1_w0_bl u_t005_025/c1_w0_br
+ u_t005_025/c1_w1_bl u_t005_025/c1_w1_br u_t005_025/c1_r0_rbl u_t005_025/c1_r1_rbl
+ u_t005_025/c2_w0_bl u_t005_025/c2_w0_br u_t005_025/c2_w1_bl u_t005_025/c2_w1_br
+ u_t005_025/c2_r0_rbl u_t005_025/c2_r1_rbl u_t005_025/c3_w0_bl u_t005_025/c3_w0_br
+ u_t005_025/c3_w1_bl u_t005_025/c3_w1_br u_t005_025/c3_r0_rbl u_t005_025/c3_r1_rbl
+ u_t005_025/r0_w0_wl u_t005_025/r0_w1_wl u_t005_025/r0_r0_rwl u_t005_025/r0_r1_rwl
+ u_t005_025/r1_w0_wl u_t005_025/r1_w1_wl u_t005_025/r1_r0_rwl u_t005_025/r1_r1_rwl
+ u_t005_025/r2_w0_wl u_t005_025/r2_w1_wl u_t005_025/r2_r0_rwl u_t005_025/r2_r1_rwl
+ u_t005_025/r3_w0_wl u_t005_025/r3_w1_wl u_t005_025/r3_r0_rwl u_t005_025/r3_r1_rwl
+ VSS u_t005_031/VSS VSUBS detronyx_12t_2w2r_rc4_4x4_routed_5layer_direct
Xu_t020_017 u_t020_017/c0_w0_bl u_t020_017/c0_w0_br u_t020_017/c0_w1_bl u_t020_017/c0_w1_br
+ u_t020_017/c0_r0_rbl u_t020_017/c0_r1_rbl u_t020_017/c1_w0_bl u_t020_017/c1_w0_br
+ u_t020_017/c1_w1_bl u_t020_017/c1_w1_br u_t020_017/c1_r0_rbl u_t020_017/c1_r1_rbl
+ u_t020_017/c2_w0_bl u_t020_017/c2_w0_br u_t020_017/c2_w1_bl u_t020_017/c2_w1_br
+ u_t020_017/c2_r0_rbl u_t020_017/c2_r1_rbl u_t020_017/c3_w0_bl u_t020_017/c3_w0_br
+ u_t020_017/c3_w1_bl u_t020_017/c3_w1_br u_t020_017/c3_r0_rbl u_t020_017/c3_r1_rbl
+ u_t020_017/r0_w0_wl u_t020_017/r0_w1_wl u_t020_017/r0_r0_rwl u_t020_017/r0_r1_rwl
+ u_t020_017/r1_w0_wl u_t020_017/r1_w1_wl u_t020_017/r1_r0_rwl u_t020_017/r1_r1_rwl
+ u_t020_017/r2_w0_wl u_t020_017/r2_w1_wl u_t020_017/r2_r0_rwl u_t020_017/r2_r1_rwl
+ u_t020_017/r3_w0_wl u_t020_017/r3_w1_wl u_t020_017/r3_r0_rwl u_t020_017/r3_r1_rwl
+ VSS u_t020_017/VSS VSUBS detronyx_12t_2w2r_rc4_4x4_routed_5layer_direct
Xu_t005_014 u_t005_014/c0_w0_bl u_t005_014/c0_w0_br u_t005_014/c0_w1_bl u_t005_014/c0_w1_br
+ u_t005_014/c0_r0_rbl u_t005_014/c0_r1_rbl u_t005_014/c1_w0_bl u_t005_014/c1_w0_br
+ u_t005_014/c1_w1_bl u_t005_014/c1_w1_br u_t005_014/c1_r0_rbl u_t005_014/c1_r1_rbl
+ u_t005_014/c2_w0_bl u_t005_014/c2_w0_br u_t005_014/c2_w1_bl u_t005_014/c2_w1_br
+ u_t005_014/c2_r0_rbl u_t005_014/c2_r1_rbl u_t005_014/c3_w0_bl u_t005_014/c3_w0_br
+ u_t005_014/c3_w1_bl u_t005_014/c3_w1_br u_t005_014/c3_r0_rbl u_t005_014/c3_r1_rbl
+ u_t005_014/r0_w0_wl u_t005_014/r0_w1_wl u_t005_014/r0_r0_rwl u_t005_014/r0_r1_rwl
+ u_t005_014/r1_w0_wl u_t005_014/r1_w1_wl u_t005_014/r1_r0_rwl u_t005_014/r1_r1_rwl
+ u_t005_014/r2_w0_wl u_t005_014/r2_w1_wl u_t005_014/r2_r0_rwl u_t005_014/r2_r1_rwl
+ u_t005_014/r3_w0_wl u_t005_014/r3_w1_wl u_t005_014/r3_r0_rwl u_t005_014/r3_r1_rwl
+ u_t005_014/VDD u_t005_031/VSS VSUBS detronyx_12t_2w2r_rc4_4x4_routed_5layer_direct
Xu_t020_006 u_t020_006/c0_w0_bl u_t020_006/c0_w0_br u_t020_006/c0_w1_bl u_t020_006/c0_w1_br
+ u_t020_006/c0_r0_rbl u_t020_006/c0_r1_rbl u_t020_006/c1_w0_bl u_t020_006/c1_w0_br
+ u_t020_006/c1_w1_bl u_t020_006/c1_w1_br u_t020_006/c1_r0_rbl u_t020_006/c1_r1_rbl
+ u_t020_006/c2_w0_bl u_t020_006/c2_w0_br u_t020_006/c2_w1_bl u_t020_006/c2_w1_br
+ u_t020_006/c2_r0_rbl u_t020_006/c2_r1_rbl u_t020_006/c3_w0_bl u_t020_006/c3_w0_br
+ u_t020_006/c3_w1_bl u_t020_006/c3_w1_br u_t020_006/c3_r0_rbl u_t020_006/c3_r1_rbl
+ u_t020_006/r0_w0_wl u_t020_006/r0_w1_wl u_t020_006/r0_r0_rwl u_t020_006/r0_r1_rwl
+ u_t020_006/r1_w0_wl u_t020_006/r1_w1_wl u_t020_006/r1_r0_rwl u_t020_006/r1_r1_rwl
+ u_t020_006/r2_w0_wl u_t020_006/r2_w1_wl u_t020_006/r2_r0_rwl u_t020_006/r2_r1_rwl
+ u_t020_006/r3_w0_wl u_t020_006/r3_w1_wl u_t020_006/r3_r0_rwl u_t020_006/r3_r1_rwl
+ u_t020_006/VDD u_t020_009/VSS VSUBS detronyx_12t_2w2r_rc4_4x4_routed_5layer_direct
Xu_t005_003 u_t005_003/c0_w0_bl u_t005_003/c0_w0_br u_t005_003/c0_w1_bl u_t005_003/c0_w1_br
+ u_t005_003/c0_r0_rbl u_t005_003/c0_r1_rbl u_t005_003/c1_w0_bl u_t005_003/c1_w0_br
+ u_t005_003/c1_w1_bl u_t005_003/c1_w1_br u_t005_003/c1_r0_rbl u_t005_003/c1_r1_rbl
+ u_t005_003/c2_w0_bl u_t005_003/c2_w0_br u_t005_003/c2_w1_bl u_t005_003/c2_w1_br
+ u_t005_003/c2_r0_rbl u_t005_003/c2_r1_rbl u_t005_003/c3_w0_bl u_t005_003/c3_w0_br
+ u_t005_003/c3_w1_bl u_t005_003/c3_w1_br u_t005_003/c3_r0_rbl u_t005_003/c3_r1_rbl
+ u_t005_003/r0_w0_wl u_t005_003/r0_w1_wl u_t005_003/r0_r0_rwl u_t005_003/r0_r1_rwl
+ u_t005_003/r1_w0_wl u_t005_003/r1_w1_wl u_t005_003/r1_r0_rwl u_t005_003/r1_r1_rwl
+ u_t005_003/r2_w0_wl u_t005_003/r2_w1_wl u_t005_003/r2_r0_rwl u_t005_003/r2_r1_rwl
+ u_t005_003/r3_w0_wl u_t005_003/r3_w1_wl u_t005_003/r3_r0_rwl u_t005_003/r3_r1_rwl
+ u_t005_003/VDD u_t005_031/VSS VSUBS detronyx_12t_2w2r_rc4_4x4_routed_5layer_direct
Xu_t011_028 u_t011_028/c0_w0_bl u_t011_028/c0_w0_br u_t011_028/c0_w1_bl u_t011_028/c0_w1_br
+ u_t011_028/c0_r0_rbl u_t011_028/c0_r1_rbl u_t011_028/c1_w0_bl u_t011_028/c1_w0_br
+ u_t011_028/c1_w1_bl u_t011_028/c1_w1_br u_t011_028/c1_r0_rbl u_t011_028/c1_r1_rbl
+ u_t011_028/c2_w0_bl u_t011_028/c2_w0_br u_t011_028/c2_w1_bl u_t011_028/c2_w1_br
+ u_t011_028/c2_r0_rbl u_t011_028/c2_r1_rbl u_t011_028/c3_w0_bl u_t011_028/c3_w0_br
+ u_t011_028/c3_w1_bl u_t011_028/c3_w1_br u_t011_028/c3_r0_rbl u_t011_028/c3_r1_rbl
+ u_t011_028/r0_w0_wl u_t011_028/r0_w1_wl u_t011_028/r0_r0_rwl u_t011_028/r0_r1_rwl
+ u_t011_028/r1_w0_wl u_t011_028/r1_w1_wl u_t011_028/r1_r0_rwl u_t011_028/r1_r1_rwl
+ u_t011_028/r2_w0_wl u_t011_028/r2_w1_wl u_t011_028/r2_r0_rwl u_t011_028/r2_r1_rwl
+ u_t011_028/r3_w0_wl u_t011_028/r3_w1_wl u_t011_028/r3_r0_rwl u_t011_028/r3_r1_rwl
+ u_t011_028/VDD u_t011_028/VSS VSUBS detronyx_12t_2w2r_rc4_4x4_routed_5layer_direct
Xu_t011_017 u_t011_017/c0_w0_bl u_t011_017/c0_w0_br u_t011_017/c0_w1_bl u_t011_017/c0_w1_br
+ u_t011_017/c0_r0_rbl u_t011_017/c0_r1_rbl u_t011_017/c1_w0_bl u_t011_017/c1_w0_br
+ u_t011_017/c1_w1_bl u_t011_017/c1_w1_br u_t011_017/c1_r0_rbl u_t011_017/c1_r1_rbl
+ u_t011_017/c2_w0_bl u_t011_017/c2_w0_br u_t011_017/c2_w1_bl u_t011_017/c2_w1_br
+ u_t011_017/c2_r0_rbl u_t011_017/c2_r1_rbl u_t011_017/c3_w0_bl u_t011_017/c3_w0_br
+ u_t011_017/c3_w1_bl u_t011_017/c3_w1_br u_t011_017/c3_r0_rbl u_t011_017/c3_r1_rbl
+ u_t011_017/r0_w0_wl u_t011_017/r0_w1_wl u_t011_017/r0_r0_rwl u_t011_017/r0_r1_rwl
+ u_t011_017/r1_w0_wl u_t011_017/r1_w1_wl u_t011_017/r1_r0_rwl u_t011_017/r1_r1_rwl
+ u_t011_017/r2_w0_wl u_t011_017/r2_w1_wl u_t011_017/r2_r0_rwl u_t011_017/r2_r1_rwl
+ u_t011_017/r3_w0_wl u_t011_017/r3_w1_wl u_t011_017/r3_r0_rwl u_t011_017/r3_r1_rwl
+ VSS u_t011_017/VSS VSUBS detronyx_12t_2w2r_rc4_4x4_routed_5layer_direct
Xu_t011_006 u_t011_006/c0_w0_bl u_t011_006/c0_w0_br u_t011_006/c0_w1_bl u_t011_006/c0_w1_br
+ u_t011_006/c0_r0_rbl u_t011_006/c0_r1_rbl u_t011_006/c1_w0_bl u_t011_006/c1_w0_br
+ u_t011_006/c1_w1_bl u_t011_006/c1_w1_br u_t011_006/c1_r0_rbl u_t011_006/c1_r1_rbl
+ u_t011_006/c2_w0_bl u_t011_006/c2_w0_br u_t011_006/c2_w1_bl u_t011_006/c2_w1_br
+ u_t011_006/c2_r0_rbl u_t011_006/c2_r1_rbl u_t011_006/c3_w0_bl u_t011_006/c3_w0_br
+ u_t011_006/c3_w1_bl u_t011_006/c3_w1_br u_t011_006/c3_r0_rbl u_t011_006/c3_r1_rbl
+ u_t011_006/r0_w0_wl u_t011_006/r0_w1_wl u_t011_006/r0_r0_rwl u_t011_006/r0_r1_rwl
+ u_t011_006/r1_w0_wl u_t011_006/r1_w1_wl u_t011_006/r1_r0_rwl u_t011_006/r1_r1_rwl
+ u_t011_006/r2_w0_wl u_t011_006/r2_w1_wl u_t011_006/r2_r0_rwl u_t011_006/r2_r1_rwl
+ u_t011_006/r3_w0_wl u_t011_006/r3_w1_wl u_t011_006/r3_r0_rwl u_t011_006/r3_r1_rwl
+ u_t011_006/VDD u_t011_009/VSS VSUBS detronyx_12t_2w2r_rc4_4x4_routed_5layer_direct
Xu_t002_028 u_t002_028/c0_w0_bl u_t002_028/c0_w0_br u_t002_028/c0_w1_bl u_t002_028/c0_w1_br
+ u_t002_028/c0_r0_rbl u_t002_028/c0_r1_rbl u_t002_028/c1_w0_bl u_t002_028/c1_w0_br
+ u_t002_028/c1_w1_bl u_t002_028/c1_w1_br u_t002_028/c1_r0_rbl u_t002_028/c1_r1_rbl
+ u_t002_028/c2_w0_bl u_t002_028/c2_w0_br u_t002_028/c2_w1_bl u_t002_028/c2_w1_br
+ u_t002_028/c2_r0_rbl u_t002_028/c2_r1_rbl u_t002_028/c3_w0_bl u_t002_028/c3_w0_br
+ u_t002_028/c3_w1_bl u_t002_028/c3_w1_br u_t002_028/c3_r0_rbl u_t002_028/c3_r1_rbl
+ u_t002_028/r0_w0_wl u_t002_028/r0_w1_wl u_t002_028/r0_r0_rwl u_t002_028/r0_r1_rwl
+ u_t002_028/r1_w0_wl u_t002_028/r1_w1_wl u_t002_028/r1_r0_rwl u_t002_028/r1_r1_rwl
+ u_t002_028/r2_w0_wl u_t002_028/r2_w1_wl u_t002_028/r2_r0_rwl u_t002_028/r2_r1_rwl
+ u_t002_028/r3_w0_wl u_t002_028/r3_w1_wl u_t002_028/r3_r0_rwl u_t002_028/r3_r1_rwl
+ u_t002_028/VDD u_t002_028/VSS VSUBS detronyx_12t_2w2r_rc4_4x4_routed_5layer_direct
Xu_t002_017 u_t002_017/c0_w0_bl u_t002_017/c0_w0_br u_t002_017/c0_w1_bl u_t002_017/c0_w1_br
+ u_t002_017/c0_r0_rbl u_t002_017/c0_r1_rbl u_t002_017/c1_w0_bl u_t002_017/c1_w0_br
+ u_t002_017/c1_w1_bl u_t002_017/c1_w1_br u_t002_017/c1_r0_rbl u_t002_017/c1_r1_rbl
+ u_t002_017/c2_w0_bl u_t002_017/c2_w0_br u_t002_017/c2_w1_bl u_t002_017/c2_w1_br
+ u_t002_017/c2_r0_rbl u_t002_017/c2_r1_rbl u_t002_017/c3_w0_bl u_t002_017/c3_w0_br
+ u_t002_017/c3_w1_bl u_t002_017/c3_w1_br u_t002_017/c3_r0_rbl u_t002_017/c3_r1_rbl
+ u_t002_017/r0_w0_wl u_t002_017/r0_w1_wl u_t002_017/r0_r0_rwl u_t002_017/r0_r1_rwl
+ u_t002_017/r1_w0_wl u_t002_017/r1_w1_wl u_t002_017/r1_r0_rwl u_t002_017/r1_r1_rwl
+ u_t002_017/r2_w0_wl u_t002_017/r2_w1_wl u_t002_017/r2_r0_rwl u_t002_017/r2_r1_rwl
+ u_t002_017/r3_w0_wl u_t002_017/r3_w1_wl u_t002_017/r3_r0_rwl u_t002_017/r3_r1_rwl
+ VSS u_t002_017/VSS VSUBS detronyx_12t_2w2r_rc4_4x4_routed_5layer_direct
Xu_t002_006 u_t002_006/c0_w0_bl u_t002_006/c0_w0_br u_t002_006/c0_w1_bl u_t002_006/c0_w1_br
+ u_t002_006/c0_r0_rbl u_t002_006/c0_r1_rbl u_t002_006/c1_w0_bl u_t002_006/c1_w0_br
+ u_t002_006/c1_w1_bl u_t002_006/c1_w1_br u_t002_006/c1_r0_rbl u_t002_006/c1_r1_rbl
+ u_t002_006/c2_w0_bl u_t002_006/c2_w0_br u_t002_006/c2_w1_bl u_t002_006/c2_w1_br
+ u_t002_006/c2_r0_rbl u_t002_006/c2_r1_rbl u_t002_006/c3_w0_bl u_t002_006/c3_w0_br
+ u_t002_006/c3_w1_bl u_t002_006/c3_w1_br u_t002_006/c3_r0_rbl u_t002_006/c3_r1_rbl
+ u_t002_006/r0_w0_wl u_t002_006/r0_w1_wl u_t002_006/r0_r0_rwl u_t002_006/r0_r1_rwl
+ u_t002_006/r1_w0_wl u_t002_006/r1_w1_wl u_t002_006/r1_r0_rwl u_t002_006/r1_r1_rwl
+ u_t002_006/r2_w0_wl u_t002_006/r2_w1_wl u_t002_006/r2_r0_rwl u_t002_006/r2_r1_rwl
+ u_t002_006/r3_w0_wl u_t002_006/r3_w1_wl u_t002_006/r3_r0_rwl u_t002_006/r3_r1_rwl
+ u_t002_006/VDD u_t002_009/VSS VSUBS detronyx_12t_2w2r_rc4_4x4_routed_5layer_direct
Xgf180mcu_as_sc_mcu7t3v3__inv_2_1218 gf180mcu_as_sc_mcu7t3v3__nor2_2_8/VDD gf180mcu_as_sc_mcu7t3v3__nand3_2_32/VSS
+ VSS VSS gf180mcu_as_sc_mcu7t3v3__nor2_2_8/VNW VSUBS gf180mcu_as_sc_mcu7t3v3__inv_2
Xgf180mcu_as_sc_mcu7t3v3__inv_2_1207 gf180mcu_as_sc_mcu7t3v3__nor2_2_8/VDD gf180mcu_as_sc_mcu7t3v3__nor2_2_8/VSS
+ VSS VSS gf180mcu_as_sc_mcu7t3v3__nor2_2_8/VNW VSUBS gf180mcu_as_sc_mcu7t3v3__inv_2
Xgf180mcu_as_sc_mcu7t3v3__inv_2_1229 VSS VSS gf180mcu_as_sc_mcu7t3v3__inv_2_1229/Y
+ VSS gf180mcu_as_sc_mcu7t3v3__inv_2_1229/VNW VSUBS gf180mcu_as_sc_mcu7t3v3__inv_2
Xgf180mcu_as_sc_mcu7t3v3__nand4_2_502 gf180mcu_as_sc_mcu7t3v3__inv_2_1678/VDD VSS
+ VSS VSS VSS VSS VSS gf180mcu_as_sc_mcu7t3v3__inv_2_1678/VNW VSUBS gf180mcu_as_sc_mcu7t3v3__nand4_2
Xgf180mcu_as_sc_mcu7t3v3__nand4_2_513 gf180mcu_as_sc_mcu7t3v3__inv_2_990/VSS VSS VSS
+ VSS VSS VSS VSS gf180mcu_as_sc_mcu7t3v3__inv_2_1700/VNW VSUBS gf180mcu_as_sc_mcu7t3v3__nand4_2
Xgf180mcu_as_sc_mcu7t3v3__inv_2_12 gf180mcu_as_sc_mcu7t3v3__inv_2_8/VSS VSS gf180mcu_as_sc_mcu7t3v3__inv_2_8/A
+ gf180mcu_as_sc_mcu7t3v3__inv_2_8/A gf180mcu_as_sc_mcu7t3v3__inv_2_53/VNW VSUBS gf180mcu_as_sc_mcu7t3v3__inv_2
Xgf180mcu_as_sc_mcu7t3v3__inv_2_34 gf180mcu_as_sc_mcu7t3v3__inv_2_61/VDD gf180mcu_as_sc_mcu7t3v3__inv_2_62/VDD
+ gf180mcu_as_sc_mcu7t3v3__inv_2_34/Y gf180mcu_as_sc_mcu7t3v3__inv_2_77/Y gf180mcu_as_sc_mcu7t3v3__inv_2_61/VNW
+ VSUBS gf180mcu_as_sc_mcu7t3v3__inv_2
Xgf180mcu_as_sc_mcu7t3v3__inv_2_23 gf180mcu_as_sc_mcu7t3v3__inv_2_74/VDD gf180mcu_as_sc_mcu7t3v3__inv_2_75/VDD
+ gf180mcu_as_sc_mcu7t3v3__inv_2_23/Y gf180mcu_as_sc_mcu7t3v3__inv_2_77/Y gf180mcu_as_sc_mcu7t3v3__inv_2_74/VNW
+ VSUBS gf180mcu_as_sc_mcu7t3v3__inv_2
Xgf180mcu_as_sc_mcu7t3v3__inv_2_1059 VSS gf180mcu_as_sc_mcu7t3v3__inv_2_1064/VDD gf180mcu_as_sc_mcu7t3v3__inv_2_1059/Y
+ gf180mcu_as_sc_mcu7t3v3__inv_2_1060/Y gf180mcu_as_sc_mcu7t3v3__inv_2_1060/VNW VSUBS
+ gf180mcu_as_sc_mcu7t3v3__inv_2
Xgf180mcu_as_sc_mcu7t3v3__inv_2_1004 VSS gf180mcu_as_sc_mcu7t3v3__inv_2_1053/VDD gf180mcu_as_sc_mcu7t3v3__inv_2_1052/A
+ gf180mcu_as_sc_mcu7t3v3__inv_2_1023/Y gf180mcu_as_sc_mcu7t3v3__inv_2_1039/VNW VSUBS
+ gf180mcu_as_sc_mcu7t3v3__inv_2
Xgf180mcu_as_sc_mcu7t3v3__inv_2_1015 VSS VSS gf180mcu_as_sc_mcu7t3v3__inv_2_1015/Y
+ VSS gf180mcu_as_sc_mcu7t3v3__inv_2_1015/VNW VSUBS gf180mcu_as_sc_mcu7t3v3__inv_2
Xgf180mcu_as_sc_mcu7t3v3__inv_2_1026 VSS gf180mcu_as_sc_mcu7t3v3__inv_2_1030/VDD gf180mcu_as_sc_mcu7t3v3__inv_2_1026/Y
+ VSS gf180mcu_as_sc_mcu7t3v3__inv_2_1026/VNW VSUBS gf180mcu_as_sc_mcu7t3v3__inv_2
Xgf180mcu_as_sc_mcu7t3v3__inv_2_67 gf180mcu_as_sc_mcu7t3v3__inv_2_69/VSS gf180mcu_as_sc_mcu7t3v3__inv_2_69/VSS
+ VSS gf180mcu_as_sc_mcu7t3v3__inv_2_2/A gf180mcu_as_sc_mcu7t3v3__inv_2_69/VNW VSUBS
+ gf180mcu_as_sc_mcu7t3v3__inv_2
Xgf180mcu_as_sc_mcu7t3v3__inv_2_56 gf180mcu_as_sc_mcu7t3v3__inv_2_9/VSS gf180mcu_as_sc_mcu7t3v3__inv_2_9/VSS
+ gf180mcu_as_sc_mcu7t3v3__inv_2_9/A VSS gf180mcu_as_sc_mcu7t3v3__inv_2_9/VNW VSUBS
+ gf180mcu_as_sc_mcu7t3v3__inv_2
Xgf180mcu_as_sc_mcu7t3v3__inv_2_78 gf180mcu_as_sc_mcu7t3v3__inv_2_96/VDD gf180mcu_as_sc_mcu7t3v3__inv_2_96/VDD
+ VSS VSS gf180mcu_as_sc_mcu7t3v3__inv_2_84/VNW VSUBS gf180mcu_as_sc_mcu7t3v3__inv_2
Xgf180mcu_as_sc_mcu7t3v3__inv_2_89 gf180mcu_as_sc_mcu7t3v3__inv_2_91/VDD gf180mcu_as_sc_mcu7t3v3__inv_2_95/VDD
+ VSS VSS gf180mcu_as_sc_mcu7t3v3__inv_2_91/VNW VSUBS gf180mcu_as_sc_mcu7t3v3__inv_2
Xgf180mcu_as_sc_mcu7t3v3__inv_2_45 gf180mcu_as_sc_mcu7t3v3__inv_2_65/VDD gf180mcu_as_sc_mcu7t3v3__inv_2_66/VDD
+ VSS gf180mcu_as_sc_mcu7t3v3__inv_2_66/Y gf180mcu_as_sc_mcu7t3v3__inv_2_65/VNW VSUBS
+ gf180mcu_as_sc_mcu7t3v3__inv_2
Xgf180mcu_as_sc_mcu7t3v3__inv_2_1048 VSS gf180mcu_as_sc_mcu7t3v3__inv_2_1056/VDD VSS
+ gf180mcu_as_sc_mcu7t3v3__inv_2_992/A gf180mcu_as_sc_mcu7t3v3__inv_2_1050/VNW VSUBS
+ gf180mcu_as_sc_mcu7t3v3__inv_2
Xgf180mcu_as_sc_mcu7t3v3__inv_2_1037 VSS gf180mcu_as_sc_mcu7t3v3__inv_2_1042/VDD gf180mcu_as_sc_mcu7t3v3__inv_2_992/A
+ gf180mcu_as_sc_mcu7t3v3__inv_2_1038/Y gf180mcu_as_sc_mcu7t3v3__inv_2_1038/VNW VSUBS
+ gf180mcu_as_sc_mcu7t3v3__inv_2
Xgf180mcu_as_sc_mcu7t3v3__inv_2_1571 VSS gf180mcu_as_sc_mcu7t3v3__inv_2_1577/VDD VSS
+ VSS gf180mcu_as_sc_mcu7t3v3__inv_2_1573/VNW VSUBS gf180mcu_as_sc_mcu7t3v3__inv_2
Xgf180mcu_as_sc_mcu7t3v3__inv_2_1582 VSS gf180mcu_as_sc_mcu7t3v3__inv_2_1586/VSS gf180mcu_as_sc_mcu7t3v3__inv_2_1582/Y
+ VSS gf180mcu_as_sc_mcu7t3v3__inv_2_1586/VNW VSUBS gf180mcu_as_sc_mcu7t3v3__inv_2
Xgf180mcu_as_sc_mcu7t3v3__inv_2_1560 VSS VSS VSS VSS gf180mcu_as_sc_mcu7t3v3__inv_2_1561/VNW
+ VSUBS gf180mcu_as_sc_mcu7t3v3__inv_2
Xgf180mcu_as_sc_mcu7t3v3__inv_2_1593 VSS gf180mcu_as_sc_mcu7t3v3__inv_2_1660/VDD gf180mcu_as_sc_mcu7t3v3__inv_2_1593/Y
+ gf180mcu_as_sc_mcu7t3v3__inv_2_1660/Y gf180mcu_as_sc_mcu7t3v3__inv_2_1659/VNW VSUBS
+ gf180mcu_as_sc_mcu7t3v3__inv_2
Xgf180mcu_as_sc_mcu7t3v3__nand3_2_4 gf180mcu_as_sc_mcu7t3v3__nand3_2_5/VDD gf180mcu_as_sc_mcu7t3v3__nor2_2_4/VSS
+ VSS VSS VSS VSS gf180mcu_as_sc_mcu7t3v3__nand3_2_5/VNW VSUBS gf180mcu_as_sc_mcu7t3v3__nand3_2
Xgf180mcu_as_sc_mcu7t3v3__nand4_2_310 VSS gf180mcu_as_sc_mcu7t3v3__inv_2_1011/VDD
+ VSS VSS VSS VSS VSS gf180mcu_as_sc_mcu7t3v3__inv_2_1007/VNW VSUBS gf180mcu_as_sc_mcu7t3v3__nand4_2
Xgf180mcu_as_sc_mcu7t3v3__nand4_2_354 VSS VSS VSS VSS VSS VSS VSS gf180mcu_as_sc_mcu7t3v3__inv_2_1277/VNW
+ VSUBS gf180mcu_as_sc_mcu7t3v3__nand4_2
Xgf180mcu_as_sc_mcu7t3v3__nand4_2_343 VSS VSS VSS VSS VSS VSS VSS gf180mcu_as_sc_mcu7t3v3__inv_2_1111/VNW
+ VSUBS gf180mcu_as_sc_mcu7t3v3__nand4_2
Xgf180mcu_as_sc_mcu7t3v3__nand4_2_365 VSS VSS VSS VSS VSS VSS VSS gf180mcu_as_sc_mcu7t3v3__inv_2_1171/VNW
+ VSUBS gf180mcu_as_sc_mcu7t3v3__nand4_2
Xgf180mcu_as_sc_mcu7t3v3__nand4_2_321 gf180mcu_as_sc_mcu7t3v3__inv_2_1072/VDD VSS
+ VSS VSS VSS VSS VSS gf180mcu_as_sc_mcu7t3v3__inv_2_1072/VNW VSUBS gf180mcu_as_sc_mcu7t3v3__nand4_2
Xgf180mcu_as_sc_mcu7t3v3__nand4_2_332 VSS gf180mcu_as_sc_mcu7t3v3__inv_2_1089/VSS
+ VSS VSS VSS VSS VSS gf180mcu_as_sc_mcu7t3v3__inv_2_1089/VNW VSUBS gf180mcu_as_sc_mcu7t3v3__nand4_2
Xgf180mcu_as_sc_mcu7t3v3__nand4_2_376 VSS VSS VSS VSS VSS VSS gf180mcu_as_sc_mcu7t3v3__nand4_2_376/Y
+ gf180mcu_as_sc_mcu7t3v3__inv_2_1191/VNW VSUBS gf180mcu_as_sc_mcu7t3v3__nand4_2
Xgf180mcu_as_sc_mcu7t3v3__nand4_2_387 VSS gf180mcu_as_sc_mcu7t3v3__inv_2_1375/VDD
+ VSS VSS VSS VSS VSS gf180mcu_as_sc_mcu7t3v3__inv_2_1374/VNW VSUBS gf180mcu_as_sc_mcu7t3v3__nand4_2
Xgf180mcu_as_sc_mcu7t3v3__nand4_2_398 VSS gf180mcu_as_sc_mcu7t3v3__inv_2_1398/VSS
+ VSS VSS VSS VSS VSS gf180mcu_as_sc_mcu7t3v3__inv_2_1398/VNW VSUBS gf180mcu_as_sc_mcu7t3v3__nand4_2
Xu_t029_031 u_t029_031/c0_w0_bl u_t029_031/c0_w0_br u_t029_031/c0_w1_bl u_t029_031/c0_w1_br
+ u_t029_031/c0_r0_rbl u_t029_031/c0_r1_rbl u_t029_031/c1_w0_bl u_t029_031/c1_w0_br
+ u_t029_031/c1_w1_bl u_t029_031/c1_w1_br u_t029_031/c1_r0_rbl u_t029_031/c1_r1_rbl
+ u_t029_031/c2_w0_bl u_t029_031/c2_w0_br u_t029_031/c2_w1_bl u_t029_031/c2_w1_br
+ u_t029_031/c2_r0_rbl u_t029_031/c2_r1_rbl u_t029_031/c3_w0_bl u_t029_031/c3_w0_br
+ u_t029_031/c3_w1_bl u_t029_031/c3_w1_br u_t029_031/c3_r0_rbl u_t029_031/c3_r1_rbl
+ u_t029_031/r0_w0_wl u_t029_031/r0_w1_wl u_t029_031/r0_r0_rwl u_t029_031/r0_r1_rwl
+ u_t029_031/r1_w0_wl u_t029_031/r1_w1_wl u_t029_031/r1_r0_rwl u_t029_031/r1_r1_rwl
+ u_t029_031/r2_w0_wl u_t029_031/r2_w1_wl u_t029_031/r2_r0_rwl u_t029_031/r2_r1_rwl
+ u_t029_031/r3_w0_wl u_t029_031/r3_w1_wl u_t029_031/r3_r0_rwl u_t029_031/r3_r1_rwl
+ VSS u_t029_031/VSS VSUBS detronyx_12t_2w2r_rc4_4x4_routed_5layer_direct
Xu_t029_020 u_t029_020/c0_w0_bl u_t029_020/c0_w0_br u_t029_020/c0_w1_bl u_t029_020/c0_w1_br
+ u_t029_020/c0_r0_rbl u_t029_020/c0_r1_rbl u_t029_020/c1_w0_bl u_t029_020/c1_w0_br
+ u_t029_020/c1_w1_bl u_t029_020/c1_w1_br u_t029_020/c1_r0_rbl u_t029_020/c1_r1_rbl
+ u_t029_020/c2_w0_bl u_t029_020/c2_w0_br u_t029_020/c2_w1_bl u_t029_020/c2_w1_br
+ u_t029_020/c2_r0_rbl u_t029_020/c2_r1_rbl u_t029_020/c3_w0_bl u_t029_020/c3_w0_br
+ u_t029_020/c3_w1_bl u_t029_020/c3_w1_br u_t029_020/c3_r0_rbl u_t029_020/c3_r1_rbl
+ u_t029_020/r0_w0_wl u_t029_020/r0_w1_wl u_t029_020/r0_r0_rwl u_t029_020/r0_r1_rwl
+ u_t029_020/r1_w0_wl u_t029_020/r1_w1_wl u_t029_020/r1_r0_rwl u_t029_020/r1_r1_rwl
+ u_t029_020/r2_w0_wl u_t029_020/r2_w1_wl u_t029_020/r2_r0_rwl u_t029_020/r2_r1_rwl
+ u_t029_020/r3_w0_wl u_t029_020/r3_w1_wl u_t029_020/r3_r0_rwl u_t029_020/r3_r1_rwl
+ u_t029_020/VDD u_t029_031/VSS VSUBS detronyx_12t_2w2r_rc4_4x4_routed_5layer_direct
Xgf180mcu_as_sc_mcu7t3v3__inv_2_318 VSS VSS gf180mcu_as_sc_mcu7t3v3__inv_2_358/Y gf180mcu_as_sc_mcu7t3v3__inv_2_358/Y
+ gf180mcu_as_sc_mcu7t3v3__inv_2_345/VNW VSUBS gf180mcu_as_sc_mcu7t3v3__inv_2
Xgf180mcu_as_sc_mcu7t3v3__inv_2_307 VSS gf180mcu_as_sc_mcu7t3v3__inv_2_334/VDD VSS
+ gf180mcu_as_sc_mcu7t3v3__inv_2_338/Y gf180mcu_as_sc_mcu7t3v3__inv_2_333/VNW VSUBS
+ gf180mcu_as_sc_mcu7t3v3__inv_2
Xgf180mcu_as_sc_mcu7t3v3__inv_2_329 VSS VSS gf180mcu_as_sc_mcu7t3v3__inv_2_338/Y VSS
+ gf180mcu_as_sc_mcu7t3v3__inv_2_329/VNW VSUBS gf180mcu_as_sc_mcu7t3v3__inv_2
Xgf180mcu_as_sc_mcu7t3v3__inv_2_1390 gf180mcu_as_sc_mcu7t3v3__inv_2_1390/VDD gf180mcu_as_sc_mcu7t3v3__inv_2_1391/VDD
+ gf180mcu_as_sc_mcu7t3v3__inv_2_1398/Y VSS gf180mcu_as_sc_mcu7t3v3__inv_2_1390/VNW
+ VSUBS gf180mcu_as_sc_mcu7t3v3__inv_2
Xgf180mcu_as_sc_mcu7t3v3__inv_2_852 VSS VSS VSS VSS gf180mcu_as_sc_mcu7t3v3__inv_2_852/VNW
+ VSUBS gf180mcu_as_sc_mcu7t3v3__inv_2
Xgf180mcu_as_sc_mcu7t3v3__inv_2_841 VSS VSS VSS VSS gf180mcu_as_sc_mcu7t3v3__inv_2_841/VNW
+ VSUBS gf180mcu_as_sc_mcu7t3v3__inv_2
Xgf180mcu_as_sc_mcu7t3v3__inv_2_830 VSS VSS gf180mcu_as_sc_mcu7t3v3__inv_2_830/Y VSS
+ gf180mcu_as_sc_mcu7t3v3__inv_2_832/VNW VSUBS gf180mcu_as_sc_mcu7t3v3__inv_2
Xgf180mcu_as_sc_mcu7t3v3__inv_2_896 VSS VSS gf180mcu_as_sc_mcu7t3v3__inv_2_896/Y VSS
+ gf180mcu_as_sc_mcu7t3v3__inv_2_896/VNW VSUBS gf180mcu_as_sc_mcu7t3v3__inv_2
Xgf180mcu_as_sc_mcu7t3v3__inv_2_874 VSS VSS VSS VSS gf180mcu_as_sc_mcu7t3v3__inv_2_876/VNW
+ VSUBS gf180mcu_as_sc_mcu7t3v3__inv_2
Xgf180mcu_as_sc_mcu7t3v3__inv_2_863 VSS VSS VSS VSS gf180mcu_as_sc_mcu7t3v3__inv_2_864/VNW
+ VSUBS gf180mcu_as_sc_mcu7t3v3__inv_2
Xgf180mcu_as_sc_mcu7t3v3__inv_2_885 VSS VSS VSS VSS gf180mcu_as_sc_mcu7t3v3__inv_2_885/VNW
+ VSUBS gf180mcu_as_sc_mcu7t3v3__inv_2
Xgf180mcu_as_sc_mcu7t3v3__nand4_2_151 gf180mcu_as_sc_mcu7t3v3__nor2_2_6/VDD gf180mcu_as_sc_mcu7t3v3__nand3_2_3/VSS
+ VSS VSS VSS VSS VSS gf180mcu_as_sc_mcu7t3v3__nor2_2_6/VNW VSUBS gf180mcu_as_sc_mcu7t3v3__nand4_2
Xgf180mcu_as_sc_mcu7t3v3__nand4_2_140 VSS VSS VSS VSS VSS VSS gf180mcu_as_sc_mcu7t3v3__nand4_2_140/Y
+ gf180mcu_as_sc_mcu7t3v3__inv_2_546/VNW VSUBS gf180mcu_as_sc_mcu7t3v3__nand4_2
Xgf180mcu_as_sc_mcu7t3v3__nand4_2_162 gf180mcu_as_sc_mcu7t3v3__inv_2_630/VSS gf180mcu_as_sc_mcu7t3v3__inv_2_616/VDD
+ VSS VSS VSS VSS VSS gf180mcu_as_sc_mcu7t3v3__inv_2_608/VNW VSUBS gf180mcu_as_sc_mcu7t3v3__nand4_2
Xu_t026_023 u_t026_023/c0_w0_bl u_t026_023/c0_w0_br u_t026_023/c0_w1_bl u_t026_023/c0_w1_br
+ u_t026_023/c0_r0_rbl u_t026_023/c0_r1_rbl u_t026_023/c1_w0_bl u_t026_023/c1_w0_br
+ u_t026_023/c1_w1_bl u_t026_023/c1_w1_br u_t026_023/c1_r0_rbl u_t026_023/c1_r1_rbl
+ u_t026_023/c2_w0_bl u_t026_023/c2_w0_br u_t026_023/c2_w1_bl u_t026_023/c2_w1_br
+ u_t026_023/c2_r0_rbl u_t026_023/c2_r1_rbl u_t026_023/c3_w0_bl u_t026_023/c3_w0_br
+ u_t026_023/c3_w1_bl u_t026_023/c3_w1_br u_t026_023/c3_r0_rbl u_t026_023/c3_r1_rbl
+ u_t026_023/r0_w0_wl u_t026_023/r0_w1_wl u_t026_023/r0_r0_rwl u_t026_023/r0_r1_rwl
+ u_t026_023/r1_w0_wl u_t026_023/r1_w1_wl u_t026_023/r1_r0_rwl u_t026_023/r1_r1_rwl
+ u_t026_023/r2_w0_wl u_t026_023/r2_w1_wl u_t026_023/r2_r0_rwl u_t026_023/r2_r1_rwl
+ u_t026_023/r3_w0_wl u_t026_023/r3_w1_wl u_t026_023/r3_r0_rwl u_t026_023/r3_r1_rwl
+ VSS u_t026_031/VSS VSUBS detronyx_12t_2w2r_rc4_4x4_routed_5layer_direct
Xu_t026_012 u_t026_012/c0_w0_bl u_t026_012/c0_w0_br u_t026_012/c0_w1_bl u_t026_012/c0_w1_br
+ u_t026_012/c0_r0_rbl u_t026_012/c0_r1_rbl u_t026_012/c1_w0_bl u_t026_012/c1_w0_br
+ u_t026_012/c1_w1_bl u_t026_012/c1_w1_br u_t026_012/c1_r0_rbl u_t026_012/c1_r1_rbl
+ u_t026_012/c2_w0_bl u_t026_012/c2_w0_br u_t026_012/c2_w1_bl u_t026_012/c2_w1_br
+ u_t026_012/c2_r0_rbl u_t026_012/c2_r1_rbl u_t026_012/c3_w0_bl u_t026_012/c3_w0_br
+ u_t026_012/c3_w1_bl u_t026_012/c3_w1_br u_t026_012/c3_r0_rbl u_t026_012/c3_r1_rbl
+ u_t026_012/r0_w0_wl u_t026_012/r0_w1_wl u_t026_012/r0_r0_rwl u_t026_012/r0_r1_rwl
+ u_t026_012/r1_w0_wl u_t026_012/r1_w1_wl u_t026_012/r1_r0_rwl u_t026_012/r1_r1_rwl
+ u_t026_012/r2_w0_wl u_t026_012/r2_w1_wl u_t026_012/r2_r0_rwl u_t026_012/r2_r1_rwl
+ u_t026_012/r3_w0_wl u_t026_012/r3_w1_wl u_t026_012/r3_r0_rwl u_t026_012/r3_r1_rwl
+ u_t026_012/VDD u_t026_031/VSS VSUBS detronyx_12t_2w2r_rc4_4x4_routed_5layer_direct
Xu_t026_001 u_t026_001/c0_w0_bl u_t026_001/c0_w0_br u_t026_001/c0_w1_bl u_t026_001/c0_w1_br
+ u_t026_001/c0_r0_rbl u_t026_001/c0_r1_rbl u_t026_001/c1_w0_bl u_t026_001/c1_w0_br
+ u_t026_001/c1_w1_bl u_t026_001/c1_w1_br u_t026_001/c1_r0_rbl u_t026_001/c1_r1_rbl
+ u_t026_001/c2_w0_bl u_t026_001/c2_w0_br u_t026_001/c2_w1_bl u_t026_001/c2_w1_br
+ u_t026_001/c2_r0_rbl u_t026_001/c2_r1_rbl u_t026_001/c3_w0_bl u_t026_001/c3_w0_br
+ u_t026_001/c3_w1_bl u_t026_001/c3_w1_br u_t026_001/c3_r0_rbl u_t026_001/c3_r1_rbl
+ u_t026_001/r0_w0_wl u_t026_001/r0_w1_wl u_t026_001/r0_r0_rwl u_t026_001/r0_r1_rwl
+ u_t026_001/r1_w0_wl u_t026_001/r1_w1_wl u_t026_001/r1_r0_rwl u_t026_001/r1_r1_rwl
+ u_t026_001/r2_w0_wl u_t026_001/r2_w1_wl u_t026_001/r2_r0_rwl u_t026_001/r2_r1_rwl
+ u_t026_001/r3_w0_wl u_t026_001/r3_w1_wl u_t026_001/r3_r0_rwl u_t026_001/r3_r1_rwl
+ VSS u_t026_031/VSS VSUBS detronyx_12t_2w2r_rc4_4x4_routed_5layer_direct
Xgf180mcu_as_sc_mcu7t3v3__nand4_2_173 gf180mcu_as_sc_mcu7t3v3__inv_2_601/VDD VSS VSS
+ VSS VSS VSS VSS gf180mcu_as_sc_mcu7t3v3__inv_2_601/VNW VSUBS gf180mcu_as_sc_mcu7t3v3__nand4_2
Xgf180mcu_as_sc_mcu7t3v3__nand4_2_90 gf180mcu_as_sc_mcu7t3v3__inv_2_361/VDD gf180mcu_as_sc_mcu7t3v3__inv_2_363/VDD
+ VSS VSS VSS VSS VSS gf180mcu_as_sc_mcu7t3v3__inv_2_361/VNW VSUBS gf180mcu_as_sc_mcu7t3v3__nand4_2
Xgf180mcu_as_sc_mcu7t3v3__nand4_2_184 gf180mcu_as_sc_mcu7t3v3__inv_2_711/VDD VSS VSS
+ VSS VSS VSS VSS gf180mcu_as_sc_mcu7t3v3__inv_2_711/VNW VSUBS gf180mcu_as_sc_mcu7t3v3__nand4_2
Xgf180mcu_as_sc_mcu7t3v3__nand4_2_195 VSS gf180mcu_as_sc_mcu7t3v3__inv_2_724/VSS VSS
+ VSS VSS VSS VSS gf180mcu_as_sc_mcu7t3v3__inv_2_724/VNW VSUBS gf180mcu_as_sc_mcu7t3v3__nand4_2
Xu_t017_012 u_t017_012/c0_w0_bl u_t017_012/c0_w0_br u_t017_012/c0_w1_bl u_t017_012/c0_w1_br
+ u_t017_012/c0_r0_rbl u_t017_012/c0_r1_rbl u_t017_012/c1_w0_bl u_t017_012/c1_w0_br
+ u_t017_012/c1_w1_bl u_t017_012/c1_w1_br u_t017_012/c1_r0_rbl u_t017_012/c1_r1_rbl
+ u_t017_012/c2_w0_bl u_t017_012/c2_w0_br u_t017_012/c2_w1_bl u_t017_012/c2_w1_br
+ u_t017_012/c2_r0_rbl u_t017_012/c2_r1_rbl u_t017_012/c3_w0_bl u_t017_012/c3_w0_br
+ u_t017_012/c3_w1_bl u_t017_012/c3_w1_br u_t017_012/c3_r0_rbl u_t017_012/c3_r1_rbl
+ u_t017_012/r0_w0_wl u_t017_012/r0_w1_wl u_t017_012/r0_r0_rwl u_t017_012/r0_r1_rwl
+ u_t017_012/r1_w0_wl u_t017_012/r1_w1_wl u_t017_012/r1_r0_rwl u_t017_012/r1_r1_rwl
+ u_t017_012/r2_w0_wl u_t017_012/r2_w1_wl u_t017_012/r2_r0_rwl u_t017_012/r2_r1_rwl
+ u_t017_012/r3_w0_wl u_t017_012/r3_w1_wl u_t017_012/r3_r0_rwl u_t017_012/r3_r1_rwl
+ u_t017_012/VDD u_t017_031/VSS VSUBS detronyx_12t_2w2r_rc4_4x4_routed_5layer_direct
Xu_t017_001 u_t017_001/c0_w0_bl u_t017_001/c0_w0_br u_t017_001/c0_w1_bl u_t017_001/c0_w1_br
+ u_t017_001/c0_r0_rbl u_t017_001/c0_r1_rbl u_t017_001/c1_w0_bl u_t017_001/c1_w0_br
+ u_t017_001/c1_w1_bl u_t017_001/c1_w1_br u_t017_001/c1_r0_rbl u_t017_001/c1_r1_rbl
+ u_t017_001/c2_w0_bl u_t017_001/c2_w0_br u_t017_001/c2_w1_bl u_t017_001/c2_w1_br
+ u_t017_001/c2_r0_rbl u_t017_001/c2_r1_rbl u_t017_001/c3_w0_bl u_t017_001/c3_w0_br
+ u_t017_001/c3_w1_bl u_t017_001/c3_w1_br u_t017_001/c3_r0_rbl u_t017_001/c3_r1_rbl
+ u_t017_001/r0_w0_wl u_t017_001/r0_w1_wl u_t017_001/r0_r0_rwl u_t017_001/r0_r1_rwl
+ u_t017_001/r1_w0_wl u_t017_001/r1_w1_wl u_t017_001/r1_r0_rwl u_t017_001/r1_r1_rwl
+ u_t017_001/r2_w0_wl u_t017_001/r2_w1_wl u_t017_001/r2_r0_rwl u_t017_001/r2_r1_rwl
+ u_t017_001/r3_w0_wl u_t017_001/r3_w1_wl u_t017_001/r3_r0_rwl u_t017_001/r3_r1_rwl
+ VSS u_t017_031/VSS VSUBS detronyx_12t_2w2r_rc4_4x4_routed_5layer_direct
Xu_t017_023 u_t017_023/c0_w0_bl u_t017_023/c0_w0_br u_t017_023/c0_w1_bl u_t017_023/c0_w1_br
+ u_t017_023/c0_r0_rbl u_t017_023/c0_r1_rbl u_t017_023/c1_w0_bl u_t017_023/c1_w0_br
+ u_t017_023/c1_w1_bl u_t017_023/c1_w1_br u_t017_023/c1_r0_rbl u_t017_023/c1_r1_rbl
+ u_t017_023/c2_w0_bl u_t017_023/c2_w0_br u_t017_023/c2_w1_bl u_t017_023/c2_w1_br
+ u_t017_023/c2_r0_rbl u_t017_023/c2_r1_rbl u_t017_023/c3_w0_bl u_t017_023/c3_w0_br
+ u_t017_023/c3_w1_bl u_t017_023/c3_w1_br u_t017_023/c3_r0_rbl u_t017_023/c3_r1_rbl
+ u_t017_023/r0_w0_wl u_t017_023/r0_w1_wl u_t017_023/r0_r0_rwl u_t017_023/r0_r1_rwl
+ u_t017_023/r1_w0_wl u_t017_023/r1_w1_wl u_t017_023/r1_r0_rwl u_t017_023/r1_r1_rwl
+ u_t017_023/r2_w0_wl u_t017_023/r2_w1_wl u_t017_023/r2_r0_rwl u_t017_023/r2_r1_rwl
+ u_t017_023/r3_w0_wl u_t017_023/r3_w1_wl u_t017_023/r3_r0_rwl u_t017_023/r3_r1_rwl
+ VSS u_t017_031/VSS VSUBS detronyx_12t_2w2r_rc4_4x4_routed_5layer_direct
Xgf180mcu_as_sc_mcu7t3v3__inv_2_148 VSS gf180mcu_as_sc_mcu7t3v3__inv_2_99/VDD VSS
+ VSS gf180mcu_as_sc_mcu7t3v3__inv_2_150/VNW VSUBS gf180mcu_as_sc_mcu7t3v3__inv_2
Xgf180mcu_as_sc_mcu7t3v3__inv_2_104 gf180mcu_as_sc_mcu7t3v3__inv_2_96/VSS gf180mcu_as_sc_mcu7t3v3__inv_2_88/VSS
+ gf180mcu_as_sc_mcu7t3v3__inv_2_104/Y VSS gf180mcu_as_sc_mcu7t3v3__inv_2_88/VNW VSUBS
+ gf180mcu_as_sc_mcu7t3v3__inv_2
Xgf180mcu_as_sc_mcu7t3v3__inv_2_137 gf180mcu_as_sc_mcu7t3v3__inv_2_138/VDD VSS VSS
+ VSS gf180mcu_as_sc_mcu7t3v3__inv_2_138/VNW VSUBS gf180mcu_as_sc_mcu7t3v3__inv_2
Xgf180mcu_as_sc_mcu7t3v3__inv_2_126 gf180mcu_as_sc_mcu7t3v3__inv_2_126/VDD VSS VSS
+ VSS gf180mcu_as_sc_mcu7t3v3__inv_2_126/VNW VSUBS gf180mcu_as_sc_mcu7t3v3__inv_2
Xgf180mcu_as_sc_mcu7t3v3__inv_2_115 gf180mcu_as_sc_mcu7t3v3__inv_2_115/VDD gf180mcu_as_sc_mcu7t3v3__inv_2_119/VDD
+ gf180mcu_as_sc_mcu7t3v3__inv_2_115/Y VSS gf180mcu_as_sc_mcu7t3v3__inv_2_115/VNW
+ VSUBS gf180mcu_as_sc_mcu7t3v3__inv_2
Xgf180mcu_as_sc_mcu7t3v3__inv_2_159 gf180mcu_as_sc_mcu7t3v3__inv_2_196/VSS gf180mcu_as_sc_mcu7t3v3__inv_2_165/VDD
+ VSS VSS gf180mcu_as_sc_mcu7t3v3__inv_2_161/VNW VSUBS gf180mcu_as_sc_mcu7t3v3__inv_2
Xu_t008_023 u_t008_023/c0_w0_bl u_t008_023/c0_w0_br u_t008_023/c0_w1_bl u_t008_023/c0_w1_br
+ u_t008_023/c0_r0_rbl u_t008_023/c0_r1_rbl u_t008_023/c1_w0_bl u_t008_023/c1_w0_br
+ u_t008_023/c1_w1_bl u_t008_023/c1_w1_br u_t008_023/c1_r0_rbl u_t008_023/c1_r1_rbl
+ u_t008_023/c2_w0_bl u_t008_023/c2_w0_br u_t008_023/c2_w1_bl u_t008_023/c2_w1_br
+ u_t008_023/c2_r0_rbl u_t008_023/c2_r1_rbl u_t008_023/c3_w0_bl u_t008_023/c3_w0_br
+ u_t008_023/c3_w1_bl u_t008_023/c3_w1_br u_t008_023/c3_r0_rbl u_t008_023/c3_r1_rbl
+ u_t008_023/r0_w0_wl u_t008_023/r0_w1_wl u_t008_023/r0_r0_rwl u_t008_023/r0_r1_rwl
+ u_t008_023/r1_w0_wl u_t008_023/r1_w1_wl u_t008_023/r1_r0_rwl u_t008_023/r1_r1_rwl
+ u_t008_023/r2_w0_wl u_t008_023/r2_w1_wl u_t008_023/r2_r0_rwl u_t008_023/r2_r1_rwl
+ u_t008_023/r3_w0_wl u_t008_023/r3_w1_wl u_t008_023/r3_r0_rwl u_t008_023/r3_r1_rwl
+ VSS u_t008_031/VSS VSUBS detronyx_12t_2w2r_rc4_4x4_routed_5layer_direct
Xu_t008_012 u_t008_012/c0_w0_bl u_t008_012/c0_w0_br u_t008_012/c0_w1_bl u_t008_012/c0_w1_br
+ u_t008_012/c0_r0_rbl u_t008_012/c0_r1_rbl u_t008_012/c1_w0_bl u_t008_012/c1_w0_br
+ u_t008_012/c1_w1_bl u_t008_012/c1_w1_br u_t008_012/c1_r0_rbl u_t008_012/c1_r1_rbl
+ u_t008_012/c2_w0_bl u_t008_012/c2_w0_br u_t008_012/c2_w1_bl u_t008_012/c2_w1_br
+ u_t008_012/c2_r0_rbl u_t008_012/c2_r1_rbl u_t008_012/c3_w0_bl u_t008_012/c3_w0_br
+ u_t008_012/c3_w1_bl u_t008_012/c3_w1_br u_t008_012/c3_r0_rbl u_t008_012/c3_r1_rbl
+ u_t008_012/r0_w0_wl u_t008_012/r0_w1_wl u_t008_012/r0_r0_rwl u_t008_012/r0_r1_rwl
+ u_t008_012/r1_w0_wl u_t008_012/r1_w1_wl u_t008_012/r1_r0_rwl u_t008_012/r1_r1_rwl
+ u_t008_012/r2_w0_wl u_t008_012/r2_w1_wl u_t008_012/r2_r0_rwl u_t008_012/r2_r1_rwl
+ u_t008_012/r3_w0_wl u_t008_012/r3_w1_wl u_t008_012/r3_r0_rwl u_t008_012/r3_r1_rwl
+ u_t008_012/VDD u_t008_031/VSS VSUBS detronyx_12t_2w2r_rc4_4x4_routed_5layer_direct
Xu_t023_004 u_t023_004/c0_w0_bl u_t023_004/c0_w0_br u_t023_004/c0_w1_bl u_t023_004/c0_w1_br
+ u_t023_004/c0_r0_rbl u_t023_004/c0_r1_rbl u_t023_004/c1_w0_bl u_t023_004/c1_w0_br
+ u_t023_004/c1_w1_bl u_t023_004/c1_w1_br u_t023_004/c1_r0_rbl u_t023_004/c1_r1_rbl
+ u_t023_004/c2_w0_bl u_t023_004/c2_w0_br u_t023_004/c2_w1_bl u_t023_004/c2_w1_br
+ u_t023_004/c2_r0_rbl u_t023_004/c2_r1_rbl u_t023_004/c3_w0_bl u_t023_004/c3_w0_br
+ u_t023_004/c3_w1_bl u_t023_004/c3_w1_br u_t023_004/c3_r0_rbl u_t023_004/c3_r1_rbl
+ u_t023_004/r0_w0_wl u_t023_004/r0_w1_wl u_t023_004/r0_r0_rwl u_t023_004/r0_r1_rwl
+ u_t023_004/r1_w0_wl u_t023_004/r1_w1_wl u_t023_004/r1_r0_rwl u_t023_004/r1_r1_rwl
+ u_t023_004/r2_w0_wl u_t023_004/r2_w1_wl u_t023_004/r2_r0_rwl u_t023_004/r2_r1_rwl
+ u_t023_004/r3_w0_wl u_t023_004/r3_w1_wl u_t023_004/r3_r0_rwl u_t023_004/r3_r1_rwl
+ u_t023_004/VDD u_t023_004/VSS VSUBS detronyx_12t_2w2r_rc4_4x4_routed_5layer_direct
Xu_t008_001 u_t008_001/c0_w0_bl u_t008_001/c0_w0_br u_t008_001/c0_w1_bl u_t008_001/c0_w1_br
+ u_t008_001/c0_r0_rbl u_t008_001/c0_r1_rbl u_t008_001/c1_w0_bl u_t008_001/c1_w0_br
+ u_t008_001/c1_w1_bl u_t008_001/c1_w1_br u_t008_001/c1_r0_rbl u_t008_001/c1_r1_rbl
+ u_t008_001/c2_w0_bl u_t008_001/c2_w0_br u_t008_001/c2_w1_bl u_t008_001/c2_w1_br
+ u_t008_001/c2_r0_rbl u_t008_001/c2_r1_rbl u_t008_001/c3_w0_bl u_t008_001/c3_w0_br
+ u_t008_001/c3_w1_bl u_t008_001/c3_w1_br u_t008_001/c3_r0_rbl u_t008_001/c3_r1_rbl
+ u_t008_001/r0_w0_wl u_t008_001/r0_w1_wl u_t008_001/r0_r0_rwl u_t008_001/r0_r1_rwl
+ u_t008_001/r1_w0_wl u_t008_001/r1_w1_wl u_t008_001/r1_r0_rwl u_t008_001/r1_r1_rwl
+ u_t008_001/r2_w0_wl u_t008_001/r2_w1_wl u_t008_001/r2_r0_rwl u_t008_001/r2_r1_rwl
+ u_t008_001/r3_w0_wl u_t008_001/r3_w1_wl u_t008_001/r3_r0_rwl u_t008_001/r3_r1_rwl
+ VSS u_t008_031/VSS VSUBS detronyx_12t_2w2r_rc4_4x4_routed_5layer_direct
Xu_t023_026 u_t023_026/c0_w0_bl u_t023_026/c0_w0_br u_t023_026/c0_w1_bl u_t023_026/c0_w1_br
+ u_t023_026/c0_r0_rbl u_t023_026/c0_r1_rbl u_t023_026/c1_w0_bl u_t023_026/c1_w0_br
+ u_t023_026/c1_w1_bl u_t023_026/c1_w1_br u_t023_026/c1_r0_rbl u_t023_026/c1_r1_rbl
+ u_t023_026/c2_w0_bl u_t023_026/c2_w0_br u_t023_026/c2_w1_bl u_t023_026/c2_w1_br
+ u_t023_026/c2_r0_rbl u_t023_026/c2_r1_rbl u_t023_026/c3_w0_bl u_t023_026/c3_w0_br
+ u_t023_026/c3_w1_bl u_t023_026/c3_w1_br u_t023_026/c3_r0_rbl u_t023_026/c3_r1_rbl
+ u_t023_026/r0_w0_wl u_t023_026/r0_w1_wl u_t023_026/r0_r0_rwl u_t023_026/r0_r1_rwl
+ u_t023_026/r1_w0_wl u_t023_026/r1_w1_wl u_t023_026/r1_r0_rwl u_t023_026/r1_r1_rwl
+ u_t023_026/r2_w0_wl u_t023_026/r2_w1_wl u_t023_026/r2_r0_rwl u_t023_026/r2_r1_rwl
+ u_t023_026/r3_w0_wl u_t023_026/r3_w1_wl u_t023_026/r3_r0_rwl u_t023_026/r3_r1_rwl
+ u_t023_026/VDD u_t023_026/VSS VSUBS detronyx_12t_2w2r_rc4_4x4_routed_5layer_direct
Xu_t023_015 u_t023_015/c0_w0_bl u_t023_015/c0_w0_br u_t023_015/c0_w1_bl u_t023_015/c0_w1_br
+ u_t023_015/c0_r0_rbl u_t023_015/c0_r1_rbl u_t023_015/c1_w0_bl u_t023_015/c1_w0_br
+ u_t023_015/c1_w1_bl u_t023_015/c1_w1_br u_t023_015/c1_r0_rbl u_t023_015/c1_r1_rbl
+ u_t023_015/c2_w0_bl u_t023_015/c2_w0_br u_t023_015/c2_w1_bl u_t023_015/c2_w1_br
+ u_t023_015/c2_r0_rbl u_t023_015/c2_r1_rbl u_t023_015/c3_w0_bl u_t023_015/c3_w0_br
+ u_t023_015/c3_w1_bl u_t023_015/c3_w1_br u_t023_015/c3_r0_rbl u_t023_015/c3_r1_rbl
+ u_t023_015/r0_w0_wl u_t023_015/r0_w1_wl u_t023_015/r0_r0_rwl u_t023_015/r0_r1_rwl
+ u_t023_015/r1_w0_wl u_t023_015/r1_w1_wl u_t023_015/r1_r0_rwl u_t023_015/r1_r1_rwl
+ u_t023_015/r2_w0_wl u_t023_015/r2_w1_wl u_t023_015/r2_r0_rwl u_t023_015/r2_r1_rwl
+ u_t023_015/r3_w0_wl u_t023_015/r3_w1_wl u_t023_015/r3_r0_rwl u_t023_015/r3_r1_rwl
+ VSS u_t023_017/VSS VSUBS detronyx_12t_2w2r_rc4_4x4_routed_5layer_direct
Xgf180mcu_as_sc_mcu7t3v3__inv_2_671 gf180mcu_as_sc_mcu7t3v3__inv_2_671/VDD VSS gf180mcu_as_sc_mcu7t3v3__inv_2_671/Y
+ VSS gf180mcu_as_sc_mcu7t3v3__inv_2_671/VNW VSUBS gf180mcu_as_sc_mcu7t3v3__inv_2
Xgf180mcu_as_sc_mcu7t3v3__inv_2_660 gf180mcu_as_sc_mcu7t3v3__inv_2_684/VSS VSS gf180mcu_as_sc_mcu7t3v3__inv_2_660/Y
+ VSS gf180mcu_as_sc_mcu7t3v3__inv_2_660/VNW VSUBS gf180mcu_as_sc_mcu7t3v3__inv_2
Xgf180mcu_as_sc_mcu7t3v3__inv_2_682 gf180mcu_as_sc_mcu7t3v3__inv_2_741/VSS gf180mcu_as_sc_mcu7t3v3__inv_2_687/VDD
+ gf180mcu_as_sc_mcu7t3v3__inv_2_682/Y gf180mcu_as_sc_mcu7t3v3__inv_2_683/Y gf180mcu_as_sc_mcu7t3v3__inv_2_683/VNW
+ VSUBS gf180mcu_as_sc_mcu7t3v3__inv_2
Xgf180mcu_as_sc_mcu7t3v3__inv_2_693 gf180mcu_as_sc_mcu7t3v3__inv_2_695/VDD VSS gf180mcu_as_sc_mcu7t3v3__inv_2_693/Y
+ gf180mcu_as_sc_mcu7t3v3__inv_2_716/Y gf180mcu_as_sc_mcu7t3v3__inv_2_695/VNW VSUBS
+ gf180mcu_as_sc_mcu7t3v3__inv_2
Xu_t014_026 u_t014_026/c0_w0_bl u_t014_026/c0_w0_br u_t014_026/c0_w1_bl u_t014_026/c0_w1_br
+ u_t014_026/c0_r0_rbl u_t014_026/c0_r1_rbl u_t014_026/c1_w0_bl u_t014_026/c1_w0_br
+ u_t014_026/c1_w1_bl u_t014_026/c1_w1_br u_t014_026/c1_r0_rbl u_t014_026/c1_r1_rbl
+ u_t014_026/c2_w0_bl u_t014_026/c2_w0_br u_t014_026/c2_w1_bl u_t014_026/c2_w1_br
+ u_t014_026/c2_r0_rbl u_t014_026/c2_r1_rbl u_t014_026/c3_w0_bl u_t014_026/c3_w0_br
+ u_t014_026/c3_w1_bl u_t014_026/c3_w1_br u_t014_026/c3_r0_rbl u_t014_026/c3_r1_rbl
+ u_t014_026/r0_w0_wl u_t014_026/r0_w1_wl u_t014_026/r0_r0_rwl u_t014_026/r0_r1_rwl
+ u_t014_026/r1_w0_wl u_t014_026/r1_w1_wl u_t014_026/r1_r0_rwl u_t014_026/r1_r1_rwl
+ u_t014_026/r2_w0_wl u_t014_026/r2_w1_wl u_t014_026/r2_r0_rwl u_t014_026/r2_r1_rwl
+ u_t014_026/r3_w0_wl u_t014_026/r3_w1_wl u_t014_026/r3_r0_rwl u_t014_026/r3_r1_rwl
+ u_t014_026/VDD u_t014_026/VSS VSUBS detronyx_12t_2w2r_rc4_4x4_routed_5layer_direct
Xu_t014_015 u_t014_015/c0_w0_bl u_t014_015/c0_w0_br u_t014_015/c0_w1_bl u_t014_015/c0_w1_br
+ u_t014_015/c0_r0_rbl u_t014_015/c0_r1_rbl u_t014_015/c1_w0_bl u_t014_015/c1_w0_br
+ u_t014_015/c1_w1_bl u_t014_015/c1_w1_br u_t014_015/c1_r0_rbl u_t014_015/c1_r1_rbl
+ u_t014_015/c2_w0_bl u_t014_015/c2_w0_br u_t014_015/c2_w1_bl u_t014_015/c2_w1_br
+ u_t014_015/c2_r0_rbl u_t014_015/c2_r1_rbl u_t014_015/c3_w0_bl u_t014_015/c3_w0_br
+ u_t014_015/c3_w1_bl u_t014_015/c3_w1_br u_t014_015/c3_r0_rbl u_t014_015/c3_r1_rbl
+ u_t014_015/r0_w0_wl u_t014_015/r0_w1_wl u_t014_015/r0_r0_rwl u_t014_015/r0_r1_rwl
+ u_t014_015/r1_w0_wl u_t014_015/r1_w1_wl u_t014_015/r1_r0_rwl u_t014_015/r1_r1_rwl
+ u_t014_015/r2_w0_wl u_t014_015/r2_w1_wl u_t014_015/r2_r0_rwl u_t014_015/r2_r1_rwl
+ u_t014_015/r3_w0_wl u_t014_015/r3_w1_wl u_t014_015/r3_r0_rwl u_t014_015/r3_r1_rwl
+ VSS u_t014_017/VSS VSUBS detronyx_12t_2w2r_rc4_4x4_routed_5layer_direct
Xu_t014_004 u_t014_004/c0_w0_bl u_t014_004/c0_w0_br u_t014_004/c0_w1_bl u_t014_004/c0_w1_br
+ u_t014_004/c0_r0_rbl u_t014_004/c0_r1_rbl u_t014_004/c1_w0_bl u_t014_004/c1_w0_br
+ u_t014_004/c1_w1_bl u_t014_004/c1_w1_br u_t014_004/c1_r0_rbl u_t014_004/c1_r1_rbl
+ u_t014_004/c2_w0_bl u_t014_004/c2_w0_br u_t014_004/c2_w1_bl u_t014_004/c2_w1_br
+ u_t014_004/c2_r0_rbl u_t014_004/c2_r1_rbl u_t014_004/c3_w0_bl u_t014_004/c3_w0_br
+ u_t014_004/c3_w1_bl u_t014_004/c3_w1_br u_t014_004/c3_r0_rbl u_t014_004/c3_r1_rbl
+ u_t014_004/r0_w0_wl u_t014_004/r0_w1_wl u_t014_004/r0_r0_rwl u_t014_004/r0_r1_rwl
+ u_t014_004/r1_w0_wl u_t014_004/r1_w1_wl u_t014_004/r1_r0_rwl u_t014_004/r1_r1_rwl
+ u_t014_004/r2_w0_wl u_t014_004/r2_w1_wl u_t014_004/r2_r0_rwl u_t014_004/r2_r1_rwl
+ u_t014_004/r3_w0_wl u_t014_004/r3_w1_wl u_t014_004/r3_r0_rwl u_t014_004/r3_r1_rwl
+ u_t014_004/VDD u_t014_004/VSS VSUBS detronyx_12t_2w2r_rc4_4x4_routed_5layer_direct
Xgf180mcu_as_sc_mcu7t3v3__nand2_2_49 gf180mcu_as_sc_mcu7t3v3__nor2_2_8/VDD gf180mcu_as_sc_mcu7t3v3__nand3_2_32/VSS
+ VSS VSS VSS gf180mcu_as_sc_mcu7t3v3__nor2_2_8/VNW VSUBS gf180mcu_as_sc_mcu7t3v3__nand2_2
Xgf180mcu_as_sc_mcu7t3v3__nand2_2_27 gf180mcu_as_sc_mcu7t3v3__nor2_2_5/VDD gf180mcu_as_sc_mcu7t3v3__nand3_2_8/VSS
+ VSS VSS VSS gf180mcu_as_sc_mcu7t3v3__nor2_2_5/VNW VSUBS gf180mcu_as_sc_mcu7t3v3__nand2_2
Xgf180mcu_as_sc_mcu7t3v3__nand2_2_16 gf180mcu_as_sc_mcu7t3v3__nor2_2_6/VDD gf180mcu_as_sc_mcu7t3v3__nand3_2_3/VSS
+ VSS VSS VSS gf180mcu_as_sc_mcu7t3v3__nor2_2_6/VNW VSUBS gf180mcu_as_sc_mcu7t3v3__nand2_2
Xgf180mcu_as_sc_mcu7t3v3__nand2_2_38 gf180mcu_as_sc_mcu7t3v3__nand3_2_5/VDD gf180mcu_as_sc_mcu7t3v3__nor2_2_6/VSS
+ VSS VSS VSS gf180mcu_as_sc_mcu7t3v3__nand3_2_5/VNW VSUBS gf180mcu_as_sc_mcu7t3v3__nand2_2
Xu_t005_004 u_t005_004/c0_w0_bl u_t005_004/c0_w0_br u_t005_004/c0_w1_bl u_t005_004/c0_w1_br
+ u_t005_004/c0_r0_rbl u_t005_004/c0_r1_rbl u_t005_004/c1_w0_bl u_t005_004/c1_w0_br
+ u_t005_004/c1_w1_bl u_t005_004/c1_w1_br u_t005_004/c1_r0_rbl u_t005_004/c1_r1_rbl
+ u_t005_004/c2_w0_bl u_t005_004/c2_w0_br u_t005_004/c2_w1_bl u_t005_004/c2_w1_br
+ u_t005_004/c2_r0_rbl u_t005_004/c2_r1_rbl u_t005_004/c3_w0_bl u_t005_004/c3_w0_br
+ u_t005_004/c3_w1_bl u_t005_004/c3_w1_br u_t005_004/c3_r0_rbl u_t005_004/c3_r1_rbl
+ u_t005_004/r0_w0_wl u_t005_004/r0_w1_wl u_t005_004/r0_r0_rwl u_t005_004/r0_r1_rwl
+ u_t005_004/r1_w0_wl u_t005_004/r1_w1_wl u_t005_004/r1_r0_rwl u_t005_004/r1_r1_rwl
+ u_t005_004/r2_w0_wl u_t005_004/r2_w1_wl u_t005_004/r2_r0_rwl u_t005_004/r2_r1_rwl
+ u_t005_004/r3_w0_wl u_t005_004/r3_w1_wl u_t005_004/r3_r0_rwl u_t005_004/r3_r1_rwl
+ u_t005_004/VDD u_t005_031/VSS VSUBS detronyx_12t_2w2r_rc4_4x4_routed_5layer_direct
Xu_t020_029 u_t020_029/c0_w0_bl u_t020_029/c0_w0_br u_t020_029/c0_w1_bl u_t020_029/c0_w1_br
+ u_t020_029/c0_r0_rbl u_t020_029/c0_r1_rbl u_t020_029/c1_w0_bl u_t020_029/c1_w0_br
+ u_t020_029/c1_w1_bl u_t020_029/c1_w1_br u_t020_029/c1_r0_rbl u_t020_029/c1_r1_rbl
+ u_t020_029/c2_w0_bl u_t020_029/c2_w0_br u_t020_029/c2_w1_bl u_t020_029/c2_w1_br
+ u_t020_029/c2_r0_rbl u_t020_029/c2_r1_rbl u_t020_029/c3_w0_bl u_t020_029/c3_w0_br
+ u_t020_029/c3_w1_bl u_t020_029/c3_w1_br u_t020_029/c3_r0_rbl u_t020_029/c3_r1_rbl
+ u_t020_029/r0_w0_wl u_t020_029/r0_w1_wl u_t020_029/r0_r0_rwl u_t020_029/r0_r1_rwl
+ u_t020_029/r1_w0_wl u_t020_029/r1_w1_wl u_t020_029/r1_r0_rwl u_t020_029/r1_r1_rwl
+ u_t020_029/r2_w0_wl u_t020_029/r2_w1_wl u_t020_029/r2_r0_rwl u_t020_029/r2_r1_rwl
+ u_t020_029/r3_w0_wl u_t020_029/r3_w1_wl u_t020_029/r3_r0_rwl u_t020_029/r3_r1_rwl
+ u_t020_029/VDD u_t020_031/VSS VSUBS detronyx_12t_2w2r_rc4_4x4_routed_5layer_direct
Xu_t005_026 u_t005_026/c0_w0_bl u_t005_026/c0_w0_br u_t005_026/c0_w1_bl u_t005_026/c0_w1_br
+ u_t005_026/c0_r0_rbl u_t005_026/c0_r1_rbl u_t005_026/c1_w0_bl u_t005_026/c1_w0_br
+ u_t005_026/c1_w1_bl u_t005_026/c1_w1_br u_t005_026/c1_r0_rbl u_t005_026/c1_r1_rbl
+ u_t005_026/c2_w0_bl u_t005_026/c2_w0_br u_t005_026/c2_w1_bl u_t005_026/c2_w1_br
+ u_t005_026/c2_r0_rbl u_t005_026/c2_r1_rbl u_t005_026/c3_w0_bl u_t005_026/c3_w0_br
+ u_t005_026/c3_w1_bl u_t005_026/c3_w1_br u_t005_026/c3_r0_rbl u_t005_026/c3_r1_rbl
+ u_t005_026/r0_w0_wl u_t005_026/r0_w1_wl u_t005_026/r0_r0_rwl u_t005_026/r0_r1_rwl
+ u_t005_026/r1_w0_wl u_t005_026/r1_w1_wl u_t005_026/r1_r0_rwl u_t005_026/r1_r1_rwl
+ u_t005_026/r2_w0_wl u_t005_026/r2_w1_wl u_t005_026/r2_r0_rwl u_t005_026/r2_r1_rwl
+ u_t005_026/r3_w0_wl u_t005_026/r3_w1_wl u_t005_026/r3_r0_rwl u_t005_026/r3_r1_rwl
+ u_t005_026/VDD u_t005_031/VSS VSUBS detronyx_12t_2w2r_rc4_4x4_routed_5layer_direct
Xu_t020_018 u_t020_018/c0_w0_bl u_t020_018/c0_w0_br u_t020_018/c0_w1_bl u_t020_018/c0_w1_br
+ u_t020_018/c0_r0_rbl u_t020_018/c0_r1_rbl u_t020_018/c1_w0_bl u_t020_018/c1_w0_br
+ u_t020_018/c1_w1_bl u_t020_018/c1_w1_br u_t020_018/c1_r0_rbl u_t020_018/c1_r1_rbl
+ u_t020_018/c2_w0_bl u_t020_018/c2_w0_br u_t020_018/c2_w1_bl u_t020_018/c2_w1_br
+ u_t020_018/c2_r0_rbl u_t020_018/c2_r1_rbl u_t020_018/c3_w0_bl u_t020_018/c3_w0_br
+ u_t020_018/c3_w1_bl u_t020_018/c3_w1_br u_t020_018/c3_r0_rbl u_t020_018/c3_r1_rbl
+ u_t020_018/r0_w0_wl u_t020_018/r0_w1_wl u_t020_018/r0_r0_rwl u_t020_018/r0_r1_rwl
+ u_t020_018/r1_w0_wl u_t020_018/r1_w1_wl u_t020_018/r1_r0_rwl u_t020_018/r1_r1_rwl
+ u_t020_018/r2_w0_wl u_t020_018/r2_w1_wl u_t020_018/r2_r0_rwl u_t020_018/r2_r1_rwl
+ u_t020_018/r3_w0_wl u_t020_018/r3_w1_wl u_t020_018/r3_r0_rwl u_t020_018/r3_r1_rwl
+ u_t020_018/VDD u_t020_018/VSS VSUBS detronyx_12t_2w2r_rc4_4x4_routed_5layer_direct
Xu_t005_015 u_t005_015/c0_w0_bl u_t005_015/c0_w0_br u_t005_015/c0_w1_bl u_t005_015/c0_w1_br
+ u_t005_015/c0_r0_rbl u_t005_015/c0_r1_rbl u_t005_015/c1_w0_bl u_t005_015/c1_w0_br
+ u_t005_015/c1_w1_bl u_t005_015/c1_w1_br u_t005_015/c1_r0_rbl u_t005_015/c1_r1_rbl
+ u_t005_015/c2_w0_bl u_t005_015/c2_w0_br u_t005_015/c2_w1_bl u_t005_015/c2_w1_br
+ u_t005_015/c2_r0_rbl u_t005_015/c2_r1_rbl u_t005_015/c3_w0_bl u_t005_015/c3_w0_br
+ u_t005_015/c3_w1_bl u_t005_015/c3_w1_br u_t005_015/c3_r0_rbl u_t005_015/c3_r1_rbl
+ u_t005_015/r0_w0_wl u_t005_015/r0_w1_wl u_t005_015/r0_r0_rwl u_t005_015/r0_r1_rwl
+ u_t005_015/r1_w0_wl u_t005_015/r1_w1_wl u_t005_015/r1_r0_rwl u_t005_015/r1_r1_rwl
+ u_t005_015/r2_w0_wl u_t005_015/r2_w1_wl u_t005_015/r2_r0_rwl u_t005_015/r2_r1_rwl
+ u_t005_015/r3_w0_wl u_t005_015/r3_w1_wl u_t005_015/r3_r0_rwl u_t005_015/r3_r1_rwl
+ VSS u_t005_031/VSS VSUBS detronyx_12t_2w2r_rc4_4x4_routed_5layer_direct
Xu_t020_007 u_t020_007/c0_w0_bl u_t020_007/c0_w0_br u_t020_007/c0_w1_bl u_t020_007/c0_w1_br
+ u_t020_007/c0_r0_rbl u_t020_007/c0_r1_rbl u_t020_007/c1_w0_bl u_t020_007/c1_w0_br
+ u_t020_007/c1_w1_bl u_t020_007/c1_w1_br u_t020_007/c1_r0_rbl u_t020_007/c1_r1_rbl
+ u_t020_007/c2_w0_bl u_t020_007/c2_w0_br u_t020_007/c2_w1_bl u_t020_007/c2_w1_br
+ u_t020_007/c2_r0_rbl u_t020_007/c2_r1_rbl u_t020_007/c3_w0_bl u_t020_007/c3_w0_br
+ u_t020_007/c3_w1_bl u_t020_007/c3_w1_br u_t020_007/c3_r0_rbl u_t020_007/c3_r1_rbl
+ u_t020_007/r0_w0_wl u_t020_007/r0_w1_wl u_t020_007/r0_r0_rwl u_t020_007/r0_r1_rwl
+ u_t020_007/r1_w0_wl u_t020_007/r1_w1_wl u_t020_007/r1_r0_rwl u_t020_007/r1_r1_rwl
+ u_t020_007/r2_w0_wl u_t020_007/r2_w1_wl u_t020_007/r2_r0_rwl u_t020_007/r2_r1_rwl
+ u_t020_007/r3_w0_wl u_t020_007/r3_w1_wl u_t020_007/r3_r0_rwl u_t020_007/r3_r1_rwl
+ VSS u_t020_009/VSS VSUBS detronyx_12t_2w2r_rc4_4x4_routed_5layer_direct
Xgf180mcu_as_sc_mcu7t3v3__inv_2_490 gf180mcu_as_sc_mcu7t3v3__nor2_2_5/VDD gf180mcu_as_sc_mcu7t3v3__nor2_2_5/VSS
+ VSS VSS gf180mcu_as_sc_mcu7t3v3__nor2_2_5/VNW VSUBS gf180mcu_as_sc_mcu7t3v3__inv_2
Xu_t011_029 u_t011_029/c0_w0_bl u_t011_029/c0_w0_br u_t011_029/c0_w1_bl u_t011_029/c0_w1_br
+ u_t011_029/c0_r0_rbl u_t011_029/c0_r1_rbl u_t011_029/c1_w0_bl u_t011_029/c1_w0_br
+ u_t011_029/c1_w1_bl u_t011_029/c1_w1_br u_t011_029/c1_r0_rbl u_t011_029/c1_r1_rbl
+ u_t011_029/c2_w0_bl u_t011_029/c2_w0_br u_t011_029/c2_w1_bl u_t011_029/c2_w1_br
+ u_t011_029/c2_r0_rbl u_t011_029/c2_r1_rbl u_t011_029/c3_w0_bl u_t011_029/c3_w0_br
+ u_t011_029/c3_w1_bl u_t011_029/c3_w1_br u_t011_029/c3_r0_rbl u_t011_029/c3_r1_rbl
+ u_t011_029/r0_w0_wl u_t011_029/r0_w1_wl u_t011_029/r0_r0_rwl u_t011_029/r0_r1_rwl
+ u_t011_029/r1_w0_wl u_t011_029/r1_w1_wl u_t011_029/r1_r0_rwl u_t011_029/r1_r1_rwl
+ u_t011_029/r2_w0_wl u_t011_029/r2_w1_wl u_t011_029/r2_r0_rwl u_t011_029/r2_r1_rwl
+ u_t011_029/r3_w0_wl u_t011_029/r3_w1_wl u_t011_029/r3_r0_rwl u_t011_029/r3_r1_rwl
+ u_t011_029/VDD u_t011_031/VSS VSUBS detronyx_12t_2w2r_rc4_4x4_routed_5layer_direct
Xu_t011_018 u_t011_018/c0_w0_bl u_t011_018/c0_w0_br u_t011_018/c0_w1_bl u_t011_018/c0_w1_br
+ u_t011_018/c0_r0_rbl u_t011_018/c0_r1_rbl u_t011_018/c1_w0_bl u_t011_018/c1_w0_br
+ u_t011_018/c1_w1_bl u_t011_018/c1_w1_br u_t011_018/c1_r0_rbl u_t011_018/c1_r1_rbl
+ u_t011_018/c2_w0_bl u_t011_018/c2_w0_br u_t011_018/c2_w1_bl u_t011_018/c2_w1_br
+ u_t011_018/c2_r0_rbl u_t011_018/c2_r1_rbl u_t011_018/c3_w0_bl u_t011_018/c3_w0_br
+ u_t011_018/c3_w1_bl u_t011_018/c3_w1_br u_t011_018/c3_r0_rbl u_t011_018/c3_r1_rbl
+ u_t011_018/r0_w0_wl u_t011_018/r0_w1_wl u_t011_018/r0_r0_rwl u_t011_018/r0_r1_rwl
+ u_t011_018/r1_w0_wl u_t011_018/r1_w1_wl u_t011_018/r1_r0_rwl u_t011_018/r1_r1_rwl
+ u_t011_018/r2_w0_wl u_t011_018/r2_w1_wl u_t011_018/r2_r0_rwl u_t011_018/r2_r1_rwl
+ u_t011_018/r3_w0_wl u_t011_018/r3_w1_wl u_t011_018/r3_r0_rwl u_t011_018/r3_r1_rwl
+ u_t011_018/VDD u_t011_018/VSS VSUBS detronyx_12t_2w2r_rc4_4x4_routed_5layer_direct
Xu_t011_007 u_t011_007/c0_w0_bl u_t011_007/c0_w0_br u_t011_007/c0_w1_bl u_t011_007/c0_w1_br
+ u_t011_007/c0_r0_rbl u_t011_007/c0_r1_rbl u_t011_007/c1_w0_bl u_t011_007/c1_w0_br
+ u_t011_007/c1_w1_bl u_t011_007/c1_w1_br u_t011_007/c1_r0_rbl u_t011_007/c1_r1_rbl
+ u_t011_007/c2_w0_bl u_t011_007/c2_w0_br u_t011_007/c2_w1_bl u_t011_007/c2_w1_br
+ u_t011_007/c2_r0_rbl u_t011_007/c2_r1_rbl u_t011_007/c3_w0_bl u_t011_007/c3_w0_br
+ u_t011_007/c3_w1_bl u_t011_007/c3_w1_br u_t011_007/c3_r0_rbl u_t011_007/c3_r1_rbl
+ u_t011_007/r0_w0_wl u_t011_007/r0_w1_wl u_t011_007/r0_r0_rwl u_t011_007/r0_r1_rwl
+ u_t011_007/r1_w0_wl u_t011_007/r1_w1_wl u_t011_007/r1_r0_rwl u_t011_007/r1_r1_rwl
+ u_t011_007/r2_w0_wl u_t011_007/r2_w1_wl u_t011_007/r2_r0_rwl u_t011_007/r2_r1_rwl
+ u_t011_007/r3_w0_wl u_t011_007/r3_w1_wl u_t011_007/r3_r0_rwl u_t011_007/r3_r1_rwl
+ VSS u_t011_009/VSS VSUBS detronyx_12t_2w2r_rc4_4x4_routed_5layer_direct
Xu_t002_029 u_t002_029/c0_w0_bl u_t002_029/c0_w0_br u_t002_029/c0_w1_bl u_t002_029/c0_w1_br
+ u_t002_029/c0_r0_rbl u_t002_029/c0_r1_rbl u_t002_029/c1_w0_bl u_t002_029/c1_w0_br
+ u_t002_029/c1_w1_bl u_t002_029/c1_w1_br u_t002_029/c1_r0_rbl u_t002_029/c1_r1_rbl
+ u_t002_029/c2_w0_bl u_t002_029/c2_w0_br u_t002_029/c2_w1_bl u_t002_029/c2_w1_br
+ u_t002_029/c2_r0_rbl u_t002_029/c2_r1_rbl u_t002_029/c3_w0_bl u_t002_029/c3_w0_br
+ u_t002_029/c3_w1_bl u_t002_029/c3_w1_br u_t002_029/c3_r0_rbl u_t002_029/c3_r1_rbl
+ u_t002_029/r0_w0_wl u_t002_029/r0_w1_wl u_t002_029/r0_r0_rwl u_t002_029/r0_r1_rwl
+ u_t002_029/r1_w0_wl u_t002_029/r1_w1_wl u_t002_029/r1_r0_rwl u_t002_029/r1_r1_rwl
+ u_t002_029/r2_w0_wl u_t002_029/r2_w1_wl u_t002_029/r2_r0_rwl u_t002_029/r2_r1_rwl
+ u_t002_029/r3_w0_wl u_t002_029/r3_w1_wl u_t002_029/r3_r0_rwl u_t002_029/r3_r1_rwl
+ u_t002_029/VDD u_t002_031/VSS VSUBS detronyx_12t_2w2r_rc4_4x4_routed_5layer_direct
Xu_t002_018 u_t002_018/c0_w0_bl u_t002_018/c0_w0_br u_t002_018/c0_w1_bl u_t002_018/c0_w1_br
+ u_t002_018/c0_r0_rbl u_t002_018/c0_r1_rbl u_t002_018/c1_w0_bl u_t002_018/c1_w0_br
+ u_t002_018/c1_w1_bl u_t002_018/c1_w1_br u_t002_018/c1_r0_rbl u_t002_018/c1_r1_rbl
+ u_t002_018/c2_w0_bl u_t002_018/c2_w0_br u_t002_018/c2_w1_bl u_t002_018/c2_w1_br
+ u_t002_018/c2_r0_rbl u_t002_018/c2_r1_rbl u_t002_018/c3_w0_bl u_t002_018/c3_w0_br
+ u_t002_018/c3_w1_bl u_t002_018/c3_w1_br u_t002_018/c3_r0_rbl u_t002_018/c3_r1_rbl
+ u_t002_018/r0_w0_wl u_t002_018/r0_w1_wl u_t002_018/r0_r0_rwl u_t002_018/r0_r1_rwl
+ u_t002_018/r1_w0_wl u_t002_018/r1_w1_wl u_t002_018/r1_r0_rwl u_t002_018/r1_r1_rwl
+ u_t002_018/r2_w0_wl u_t002_018/r2_w1_wl u_t002_018/r2_r0_rwl u_t002_018/r2_r1_rwl
+ u_t002_018/r3_w0_wl u_t002_018/r3_w1_wl u_t002_018/r3_r0_rwl u_t002_018/r3_r1_rwl
+ u_t002_018/VDD u_t002_018/VSS VSUBS detronyx_12t_2w2r_rc4_4x4_routed_5layer_direct
Xu_t002_007 u_t002_007/c0_w0_bl u_t002_007/c0_w0_br u_t002_007/c0_w1_bl u_t002_007/c0_w1_br
+ u_t002_007/c0_r0_rbl u_t002_007/c0_r1_rbl u_t002_007/c1_w0_bl u_t002_007/c1_w0_br
+ u_t002_007/c1_w1_bl u_t002_007/c1_w1_br u_t002_007/c1_r0_rbl u_t002_007/c1_r1_rbl
+ u_t002_007/c2_w0_bl u_t002_007/c2_w0_br u_t002_007/c2_w1_bl u_t002_007/c2_w1_br
+ u_t002_007/c2_r0_rbl u_t002_007/c2_r1_rbl u_t002_007/c3_w0_bl u_t002_007/c3_w0_br
+ u_t002_007/c3_w1_bl u_t002_007/c3_w1_br u_t002_007/c3_r0_rbl u_t002_007/c3_r1_rbl
+ u_t002_007/r0_w0_wl u_t002_007/r0_w1_wl u_t002_007/r0_r0_rwl u_t002_007/r0_r1_rwl
+ u_t002_007/r1_w0_wl u_t002_007/r1_w1_wl u_t002_007/r1_r0_rwl u_t002_007/r1_r1_rwl
+ u_t002_007/r2_w0_wl u_t002_007/r2_w1_wl u_t002_007/r2_r0_rwl u_t002_007/r2_r1_rwl
+ u_t002_007/r3_w0_wl u_t002_007/r3_w1_wl u_t002_007/r3_r0_rwl u_t002_007/r3_r1_rwl
+ VSS u_t002_009/VSS VSUBS detronyx_12t_2w2r_rc4_4x4_routed_5layer_direct
Xgf180mcu_as_sc_mcu7t3v3__inv_2_1219 gf180mcu_as_sc_mcu7t3v3__nor2_2_8/VDD gf180mcu_as_sc_mcu7t3v3__nor2_2_8/VSS
+ VSS VSS gf180mcu_as_sc_mcu7t3v3__nor2_2_8/VNW VSUBS gf180mcu_as_sc_mcu7t3v3__inv_2
Xgf180mcu_as_sc_mcu7t3v3__inv_2_1208 gf180mcu_as_sc_mcu7t3v3__nand3_2_31/VDD gf180mcu_as_sc_mcu7t3v3__nor2_2_8/VSS
+ VSS VSS gf180mcu_as_sc_mcu7t3v3__nand3_2_31/VNW VSUBS gf180mcu_as_sc_mcu7t3v3__inv_2
Xgf180mcu_as_sc_mcu7t3v3__nand4_2_503 VSS gf180mcu_as_sc_mcu7t3v3__inv_2_1674/VDD
+ VSS VSS VSS VSS VSS gf180mcu_as_sc_mcu7t3v3__inv_2_1673/VNW VSUBS gf180mcu_as_sc_mcu7t3v3__nand4_2
Xgf180mcu_as_sc_mcu7t3v3__inv_2_68 gf180mcu_as_sc_mcu7t3v3__inv_2_69/VSS gf180mcu_as_sc_mcu7t3v3__inv_2_69/VSS
+ gf180mcu_as_sc_mcu7t3v3__inv_2_2/A gf180mcu_as_sc_mcu7t3v3__inv_2_2/A gf180mcu_as_sc_mcu7t3v3__inv_2_69/VNW
+ VSUBS gf180mcu_as_sc_mcu7t3v3__inv_2
Xgf180mcu_as_sc_mcu7t3v3__inv_2_57 gf180mcu_as_sc_mcu7t3v3__inv_2_9/VSS gf180mcu_as_sc_mcu7t3v3__inv_2_0/VSS
+ gf180mcu_as_sc_mcu7t3v3__inv_2_9/A VSS gf180mcu_as_sc_mcu7t3v3__inv_2_0/VNW VSUBS
+ gf180mcu_as_sc_mcu7t3v3__inv_2
Xgf180mcu_as_sc_mcu7t3v3__inv_2_13 gf180mcu_as_sc_mcu7t3v3__inv_2_0/VSS gf180mcu_as_sc_mcu7t3v3__inv_2_6/VSS
+ VSS gf180mcu_as_sc_mcu7t3v3__inv_2_9/A gf180mcu_as_sc_mcu7t3v3__inv_2_58/VNW VSUBS
+ gf180mcu_as_sc_mcu7t3v3__inv_2
Xgf180mcu_as_sc_mcu7t3v3__inv_2_24 gf180mcu_as_sc_mcu7t3v3__inv_2_77/VDD gf180mcu_as_sc_mcu7t3v3__inv_2_77/VSS
+ gf180mcu_as_sc_mcu7t3v3__inv_2_24/Y gf180mcu_as_sc_mcu7t3v3__inv_2_77/Y gf180mcu_as_sc_mcu7t3v3__inv_2_77/VNW
+ VSUBS gf180mcu_as_sc_mcu7t3v3__inv_2
Xgf180mcu_as_sc_mcu7t3v3__inv_2_35 gf180mcu_as_sc_mcu7t3v3__inv_2_73/VDD gf180mcu_as_sc_mcu7t3v3__inv_2_73/VDD
+ VSS gf180mcu_as_sc_mcu7t3v3__inv_2_77/Y gf180mcu_as_sc_mcu7t3v3__inv_2_72/VNW VSUBS
+ gf180mcu_as_sc_mcu7t3v3__inv_2
Xgf180mcu_as_sc_mcu7t3v3__inv_2_46 gf180mcu_as_sc_mcu7t3v3__inv_2_65/VDD gf180mcu_as_sc_mcu7t3v3__inv_2_66/VDD
+ gf180mcu_as_sc_mcu7t3v3__inv_2_66/Y gf180mcu_as_sc_mcu7t3v3__inv_2_66/Y gf180mcu_as_sc_mcu7t3v3__inv_2_65/VNW
+ VSUBS gf180mcu_as_sc_mcu7t3v3__inv_2
Xgf180mcu_as_sc_mcu7t3v3__inv_2_1005 VSS gf180mcu_as_sc_mcu7t3v3__inv_2_1011/VDD VSS
+ gf180mcu_as_sc_mcu7t3v3__inv_2_1294/Y gf180mcu_as_sc_mcu7t3v3__inv_2_1007/VNW VSUBS
+ gf180mcu_as_sc_mcu7t3v3__inv_2
Xgf180mcu_as_sc_mcu7t3v3__inv_2_1016 gf180mcu_as_sc_mcu7t3v3__inv_2_1016/VDD VSS gf180mcu_as_sc_mcu7t3v3__inv_2_1016/Y
+ VSS gf180mcu_as_sc_mcu7t3v3__inv_2_1016/VNW VSUBS gf180mcu_as_sc_mcu7t3v3__inv_2
Xgf180mcu_as_sc_mcu7t3v3__inv_2_1027 VSS VSS VSS gf180mcu_as_sc_mcu7t3v3__inv_2_1043/A
+ gf180mcu_as_sc_mcu7t3v3__inv_2_1035/VNW VSUBS gf180mcu_as_sc_mcu7t3v3__inv_2
Xgf180mcu_as_sc_mcu7t3v3__inv_2_79 gf180mcu_as_sc_mcu7t3v3__inv_2_96/VSS gf180mcu_as_sc_mcu7t3v3__inv_2_88/VSS
+ gf180mcu_as_sc_mcu7t3v3__inv_2_79/Y VSS gf180mcu_as_sc_mcu7t3v3__inv_2_88/VNW VSUBS
+ gf180mcu_as_sc_mcu7t3v3__inv_2
Xgf180mcu_as_sc_mcu7t3v3__inv_2_1049 VSS gf180mcu_as_sc_mcu7t3v3__inv_2_1056/VDD gf180mcu_as_sc_mcu7t3v3__inv_2_992/A
+ gf180mcu_as_sc_mcu7t3v3__inv_2_1050/Y gf180mcu_as_sc_mcu7t3v3__inv_2_1050/VNW VSUBS
+ gf180mcu_as_sc_mcu7t3v3__inv_2
Xgf180mcu_as_sc_mcu7t3v3__inv_2_1038 VSS gf180mcu_as_sc_mcu7t3v3__inv_2_1042/VDD gf180mcu_as_sc_mcu7t3v3__inv_2_1038/Y
+ VSS gf180mcu_as_sc_mcu7t3v3__inv_2_1038/VNW VSUBS gf180mcu_as_sc_mcu7t3v3__inv_2
Xgf180mcu_as_sc_mcu7t3v3__inv_2_1572 VSS gf180mcu_as_sc_mcu7t3v3__inv_2_1577/VDD VSS
+ VSS gf180mcu_as_sc_mcu7t3v3__inv_2_1573/VNW VSUBS gf180mcu_as_sc_mcu7t3v3__inv_2
Xgf180mcu_as_sc_mcu7t3v3__inv_2_1583 VSS gf180mcu_as_sc_mcu7t3v3__inv_2_1589/VDD VSS
+ VSS gf180mcu_as_sc_mcu7t3v3__inv_2_1585/VNW VSUBS gf180mcu_as_sc_mcu7t3v3__inv_2
Xgf180mcu_as_sc_mcu7t3v3__inv_2_1561 VSS VSS VSS VSS gf180mcu_as_sc_mcu7t3v3__inv_2_1561/VNW
+ VSUBS gf180mcu_as_sc_mcu7t3v3__inv_2
Xgf180mcu_as_sc_mcu7t3v3__inv_2_1594 gf180mcu_as_sc_mcu7t3v3__inv_2_1667/VSS VSS VSS
+ gf180mcu_as_sc_mcu7t3v3__inv_2_1682/Y gf180mcu_as_sc_mcu7t3v3__inv_2_1651/VNW VSUBS
+ gf180mcu_as_sc_mcu7t3v3__inv_2
Xgf180mcu_as_sc_mcu7t3v3__inv_2_1550 gf180mcu_as_sc_mcu7t3v3__inv_2_1551/VDD VSS gf180mcu_as_sc_mcu7t3v3__inv_2_1550/Y
+ VSS gf180mcu_as_sc_mcu7t3v3__inv_2_1551/VNW VSUBS gf180mcu_as_sc_mcu7t3v3__inv_2
Xgf180mcu_as_sc_mcu7t3v3__nand3_2_5 gf180mcu_as_sc_mcu7t3v3__nand3_2_5/VDD gf180mcu_as_sc_mcu7t3v3__nor2_2_6/VSS
+ VSS VSS VSS VSS gf180mcu_as_sc_mcu7t3v3__nand3_2_5/VNW VSUBS gf180mcu_as_sc_mcu7t3v3__nand3_2
Xgf180mcu_as_sc_mcu7t3v3__nand4_2_344 VSS gf180mcu_as_sc_mcu7t3v3__inv_2_1117/VDD
+ VSS VSS VSS VSS VSS gf180mcu_as_sc_mcu7t3v3__inv_2_1114/VNW VSUBS gf180mcu_as_sc_mcu7t3v3__nand4_2
Xgf180mcu_as_sc_mcu7t3v3__nand4_2_333 gf180mcu_as_sc_mcu7t3v3__inv_2_1146/VSS gf180mcu_as_sc_mcu7t3v3__inv_2_1105/VSS
+ VSS VSS VSS VSS VSS gf180mcu_as_sc_mcu7t3v3__inv_2_1105/VNW VSUBS gf180mcu_as_sc_mcu7t3v3__nand4_2
Xgf180mcu_as_sc_mcu7t3v3__nand4_2_322 VSS gf180mcu_as_sc_mcu7t3v3__inv_2_1080/VDD
+ VSS VSS VSS VSS VSS gf180mcu_as_sc_mcu7t3v3__inv_2_1076/VNW VSUBS gf180mcu_as_sc_mcu7t3v3__nand4_2
Xgf180mcu_as_sc_mcu7t3v3__nand4_2_311 gf180mcu_as_sc_mcu7t3v3__inv_2_1011/VDD gf180mcu_as_sc_mcu7t3v3__inv_2_1016/VDD
+ VSS VSS VSS VSS VSS gf180mcu_as_sc_mcu7t3v3__inv_2_1011/VNW VSUBS gf180mcu_as_sc_mcu7t3v3__nand4_2
Xgf180mcu_as_sc_mcu7t3v3__nand4_2_300 gf180mcu_as_sc_mcu7t3v3__inv_2_999/VSS gf180mcu_as_sc_mcu7t3v3__inv_2_987/VSS
+ VSS VSS VSS VSS VSS gf180mcu_as_sc_mcu7t3v3__inv_2_987/VNW VSUBS gf180mcu_as_sc_mcu7t3v3__nand4_2
Xgf180mcu_as_sc_mcu7t3v3__nand4_2_355 VSS VSS VSS VSS VSS VSS gf180mcu_as_sc_mcu7t3v3__nand4_2_355/Y
+ gf180mcu_as_sc_mcu7t3v3__inv_2_1282/VNW VSUBS gf180mcu_as_sc_mcu7t3v3__nand4_2
Xgf180mcu_as_sc_mcu7t3v3__nand4_2_377 VSS VSS VSS VSS VSS VSS gf180mcu_as_sc_mcu7t3v3__nand4_2_377/Y
+ gf180mcu_as_sc_mcu7t3v3__inv_2_1156/VNW VSUBS gf180mcu_as_sc_mcu7t3v3__nand4_2
Xgf180mcu_as_sc_mcu7t3v3__nand4_2_366 VSS VSS VSS VSS VSS VSS gf180mcu_as_sc_mcu7t3v3__nand4_2_366/Y
+ gf180mcu_as_sc_mcu7t3v3__inv_2_1178/VNW VSUBS gf180mcu_as_sc_mcu7t3v3__nand4_2
Xgf180mcu_as_sc_mcu7t3v3__nand4_2_399 gf180mcu_as_sc_mcu7t3v3__inv_2_1390/VDD gf180mcu_as_sc_mcu7t3v3__inv_2_1391/VDD
+ VSS VSS VSS VSS VSS gf180mcu_as_sc_mcu7t3v3__inv_2_1390/VNW VSUBS gf180mcu_as_sc_mcu7t3v3__nand4_2
Xgf180mcu_as_sc_mcu7t3v3__nand4_2_388 VSS gf180mcu_as_sc_mcu7t3v3__inv_2_1369/VDD
+ VSS VSS VSS VSS VSS gf180mcu_as_sc_mcu7t3v3__inv_2_1368/VNW VSUBS gf180mcu_as_sc_mcu7t3v3__nand4_2
Xu_t029_021 u_t029_021/c0_w0_bl u_t029_021/c0_w0_br u_t029_021/c0_w1_bl u_t029_021/c0_w1_br
+ u_t029_021/c0_r0_rbl u_t029_021/c0_r1_rbl u_t029_021/c1_w0_bl u_t029_021/c1_w0_br
+ u_t029_021/c1_w1_bl u_t029_021/c1_w1_br u_t029_021/c1_r0_rbl u_t029_021/c1_r1_rbl
+ u_t029_021/c2_w0_bl u_t029_021/c2_w0_br u_t029_021/c2_w1_bl u_t029_021/c2_w1_br
+ u_t029_021/c2_r0_rbl u_t029_021/c2_r1_rbl u_t029_021/c3_w0_bl u_t029_021/c3_w0_br
+ u_t029_021/c3_w1_bl u_t029_021/c3_w1_br u_t029_021/c3_r0_rbl u_t029_021/c3_r1_rbl
+ u_t029_021/r0_w0_wl u_t029_021/r0_w1_wl u_t029_021/r0_r0_rwl u_t029_021/r0_r1_rwl
+ u_t029_021/r1_w0_wl u_t029_021/r1_w1_wl u_t029_021/r1_r0_rwl u_t029_021/r1_r1_rwl
+ u_t029_021/r2_w0_wl u_t029_021/r2_w1_wl u_t029_021/r2_r0_rwl u_t029_021/r2_r1_rwl
+ u_t029_021/r3_w0_wl u_t029_021/r3_w1_wl u_t029_021/r3_r0_rwl u_t029_021/r3_r1_rwl
+ u_t029_021/VDD u_t029_031/VSS VSUBS detronyx_12t_2w2r_rc4_4x4_routed_5layer_direct
Xu_t029_010 u_t029_010/c0_w0_bl u_t029_010/c0_w0_br u_t029_010/c0_w1_bl u_t029_010/c0_w1_br
+ u_t029_010/c0_r0_rbl u_t029_010/c0_r1_rbl u_t029_010/c1_w0_bl u_t029_010/c1_w0_br
+ u_t029_010/c1_w1_bl u_t029_010/c1_w1_br u_t029_010/c1_r0_rbl u_t029_010/c1_r1_rbl
+ u_t029_010/c2_w0_bl u_t029_010/c2_w0_br u_t029_010/c2_w1_bl u_t029_010/c2_w1_br
+ u_t029_010/c2_r0_rbl u_t029_010/c2_r1_rbl u_t029_010/c3_w0_bl u_t029_010/c3_w0_br
+ u_t029_010/c3_w1_bl u_t029_010/c3_w1_br u_t029_010/c3_r0_rbl u_t029_010/c3_r1_rbl
+ u_t029_010/r0_w0_wl u_t029_010/r0_w1_wl u_t029_010/r0_r0_rwl u_t029_010/r0_r1_rwl
+ u_t029_010/r1_w0_wl u_t029_010/r1_w1_wl u_t029_010/r1_r0_rwl u_t029_010/r1_r1_rwl
+ u_t029_010/r2_w0_wl u_t029_010/r2_w1_wl u_t029_010/r2_r0_rwl u_t029_010/r2_r1_rwl
+ u_t029_010/r3_w0_wl u_t029_010/r3_w1_wl u_t029_010/r3_r0_rwl u_t029_010/r3_r1_rwl
+ VSS u_t029_031/VSS VSUBS detronyx_12t_2w2r_rc4_4x4_routed_5layer_direct
Xgf180mcu_as_sc_mcu7t3v3__inv_2_319 gf180mcu_as_sc_mcu7t3v3__inv_2_337/VDD gf180mcu_as_sc_mcu7t3v3__inv_2_338/VDD
+ VSS gf180mcu_as_sc_mcu7t3v3__inv_2_338/Y gf180mcu_as_sc_mcu7t3v3__inv_2_337/VNW
+ VSUBS gf180mcu_as_sc_mcu7t3v3__inv_2
Xgf180mcu_as_sc_mcu7t3v3__inv_2_308 VSS gf180mcu_as_sc_mcu7t3v3__inv_2_334/VDD gf180mcu_as_sc_mcu7t3v3__inv_2_308/Y
+ gf180mcu_as_sc_mcu7t3v3__inv_2_338/Y gf180mcu_as_sc_mcu7t3v3__inv_2_333/VNW VSUBS
+ gf180mcu_as_sc_mcu7t3v3__inv_2
Xgf180mcu_as_sc_mcu7t3v3__inv_2_1380 VSS VSS gf180mcu_as_sc_mcu7t3v3__inv_2_1691/Y
+ VSS gf180mcu_as_sc_mcu7t3v3__inv_2_1380/VNW VSUBS gf180mcu_as_sc_mcu7t3v3__inv_2
Xgf180mcu_as_sc_mcu7t3v3__inv_2_1391 gf180mcu_as_sc_mcu7t3v3__inv_2_1391/VDD VSS gf180mcu_as_sc_mcu7t3v3__inv_2_1398/Y
+ VSS gf180mcu_as_sc_mcu7t3v3__inv_2_1391/VNW VSUBS gf180mcu_as_sc_mcu7t3v3__inv_2
Xgf180mcu_as_sc_mcu7t3v3__inv_2_820 VSS VSS VSS VSS gf180mcu_as_sc_mcu7t3v3__inv_2_820/VNW
+ VSUBS gf180mcu_as_sc_mcu7t3v3__inv_2
Xgf180mcu_as_sc_mcu7t3v3__inv_2_842 VSS VSS gf180mcu_as_sc_mcu7t3v3__inv_2_842/Y VSS
+ gf180mcu_as_sc_mcu7t3v3__inv_2_843/VNW VSUBS gf180mcu_as_sc_mcu7t3v3__inv_2
Xgf180mcu_as_sc_mcu7t3v3__inv_2_831 VSS VSS VSS VSS gf180mcu_as_sc_mcu7t3v3__inv_2_832/VNW
+ VSUBS gf180mcu_as_sc_mcu7t3v3__inv_2
Xgf180mcu_as_sc_mcu7t3v3__inv_2_886 VSS VSS VSS VSS gf180mcu_as_sc_mcu7t3v3__inv_2_888/VNW
+ VSUBS gf180mcu_as_sc_mcu7t3v3__inv_2
Xgf180mcu_as_sc_mcu7t3v3__inv_2_875 VSS VSS VSS VSS gf180mcu_as_sc_mcu7t3v3__inv_2_876/VNW
+ VSUBS gf180mcu_as_sc_mcu7t3v3__inv_2
Xgf180mcu_as_sc_mcu7t3v3__inv_2_864 VSS VSS gf180mcu_as_sc_mcu7t3v3__inv_2_864/Y VSS
+ gf180mcu_as_sc_mcu7t3v3__inv_2_864/VNW VSUBS gf180mcu_as_sc_mcu7t3v3__inv_2
Xgf180mcu_as_sc_mcu7t3v3__inv_2_853 VSS VSS gf180mcu_as_sc_mcu7t3v3__inv_2_853/Y VSS
+ gf180mcu_as_sc_mcu7t3v3__inv_2_885/VNW VSUBS gf180mcu_as_sc_mcu7t3v3__inv_2
Xgf180mcu_as_sc_mcu7t3v3__inv_2_897 VSS VSS VSS VSS gf180mcu_as_sc_mcu7t3v3__inv_2_897/VNW
+ VSUBS gf180mcu_as_sc_mcu7t3v3__inv_2
Xgf180mcu_as_sc_mcu7t3v3__nand4_2_174 VSS gf180mcu_as_sc_mcu7t3v3__inv_2_626/VDD VSS
+ VSS VSS VSS VSS gf180mcu_as_sc_mcu7t3v3__inv_2_613/VNW VSUBS gf180mcu_as_sc_mcu7t3v3__nand4_2
Xgf180mcu_as_sc_mcu7t3v3__nand4_2_152 gf180mcu_as_sc_mcu7t3v3__inv_2_636/VSS VSS VSS
+ VSS VSS VSS VSS gf180mcu_as_sc_mcu7t3v3__inv_2_561/VNW VSUBS gf180mcu_as_sc_mcu7t3v3__nand4_2
Xgf180mcu_as_sc_mcu7t3v3__nand4_2_130 VSS VSS VSS VSS VSS VSS gf180mcu_as_sc_mcu7t3v3__nand4_2_130/Y
+ gf180mcu_as_sc_mcu7t3v3__inv_2_447/VNW VSUBS gf180mcu_as_sc_mcu7t3v3__nand4_2
Xgf180mcu_as_sc_mcu7t3v3__nand4_2_141 VSS VSS VSS VSS VSS VSS VSS gf180mcu_as_sc_mcu7t3v3__inv_2_502/VNW
+ VSUBS gf180mcu_as_sc_mcu7t3v3__nand4_2
Xgf180mcu_as_sc_mcu7t3v3__nand4_2_163 gf180mcu_as_sc_mcu7t3v3__inv_2_616/VDD gf180mcu_as_sc_mcu7t3v3__inv_2_616/VDD
+ VSS VSS VSS VSS VSS gf180mcu_as_sc_mcu7t3v3__inv_2_612/VNW VSUBS gf180mcu_as_sc_mcu7t3v3__nand4_2
Xgf180mcu_as_sc_mcu7t3v3__nand4_2_196 VSS gf180mcu_as_sc_mcu7t3v3__inv_2_741/VSS VSS
+ VSS VSS VSS VSS gf180mcu_as_sc_mcu7t3v3__inv_2_741/VNW VSUBS gf180mcu_as_sc_mcu7t3v3__nand4_2
Xgf180mcu_as_sc_mcu7t3v3__nand4_2_185 VSS gf180mcu_as_sc_mcu7t3v3__inv_2_719/VDD VSS
+ VSS VSS VSS VSS gf180mcu_as_sc_mcu7t3v3__inv_2_715/VNW VSUBS gf180mcu_as_sc_mcu7t3v3__nand4_2
Xu_t026_024 u_t026_024/c0_w0_bl u_t026_024/c0_w0_br u_t026_024/c0_w1_bl u_t026_024/c0_w1_br
+ u_t026_024/c0_r0_rbl u_t026_024/c0_r1_rbl u_t026_024/c1_w0_bl u_t026_024/c1_w0_br
+ u_t026_024/c1_w1_bl u_t026_024/c1_w1_br u_t026_024/c1_r0_rbl u_t026_024/c1_r1_rbl
+ u_t026_024/c2_w0_bl u_t026_024/c2_w0_br u_t026_024/c2_w1_bl u_t026_024/c2_w1_br
+ u_t026_024/c2_r0_rbl u_t026_024/c2_r1_rbl u_t026_024/c3_w0_bl u_t026_024/c3_w0_br
+ u_t026_024/c3_w1_bl u_t026_024/c3_w1_br u_t026_024/c3_r0_rbl u_t026_024/c3_r1_rbl
+ u_t026_024/r0_w0_wl u_t026_024/r0_w1_wl u_t026_024/r0_r0_rwl u_t026_024/r0_r1_rwl
+ u_t026_024/r1_w0_wl u_t026_024/r1_w1_wl u_t026_024/r1_r0_rwl u_t026_024/r1_r1_rwl
+ u_t026_024/r2_w0_wl u_t026_024/r2_w1_wl u_t026_024/r2_r0_rwl u_t026_024/r2_r1_rwl
+ u_t026_024/r3_w0_wl u_t026_024/r3_w1_wl u_t026_024/r3_r0_rwl u_t026_024/r3_r1_rwl
+ VSS u_t026_031/VSS VSUBS detronyx_12t_2w2r_rc4_4x4_routed_5layer_direct
Xu_t026_013 u_t026_013/c0_w0_bl u_t026_013/c0_w0_br u_t026_013/c0_w1_bl u_t026_013/c0_w1_br
+ u_t026_013/c0_r0_rbl u_t026_013/c0_r1_rbl u_t026_013/c1_w0_bl u_t026_013/c1_w0_br
+ u_t026_013/c1_w1_bl u_t026_013/c1_w1_br u_t026_013/c1_r0_rbl u_t026_013/c1_r1_rbl
+ u_t026_013/c2_w0_bl u_t026_013/c2_w0_br u_t026_013/c2_w1_bl u_t026_013/c2_w1_br
+ u_t026_013/c2_r0_rbl u_t026_013/c2_r1_rbl u_t026_013/c3_w0_bl u_t026_013/c3_w0_br
+ u_t026_013/c3_w1_bl u_t026_013/c3_w1_br u_t026_013/c3_r0_rbl u_t026_013/c3_r1_rbl
+ u_t026_013/r0_w0_wl u_t026_013/r0_w1_wl u_t026_013/r0_r0_rwl u_t026_013/r0_r1_rwl
+ u_t026_013/r1_w0_wl u_t026_013/r1_w1_wl u_t026_013/r1_r0_rwl u_t026_013/r1_r1_rwl
+ u_t026_013/r2_w0_wl u_t026_013/r2_w1_wl u_t026_013/r2_r0_rwl u_t026_013/r2_r1_rwl
+ u_t026_013/r3_w0_wl u_t026_013/r3_w1_wl u_t026_013/r3_r0_rwl u_t026_013/r3_r1_rwl
+ u_t026_013/VDD u_t026_031/VSS VSUBS detronyx_12t_2w2r_rc4_4x4_routed_5layer_direct
Xu_t026_002 u_t026_002/c0_w0_bl u_t026_002/c0_w0_br u_t026_002/c0_w1_bl u_t026_002/c0_w1_br
+ u_t026_002/c0_r0_rbl u_t026_002/c0_r1_rbl u_t026_002/c1_w0_bl u_t026_002/c1_w0_br
+ u_t026_002/c1_w1_bl u_t026_002/c1_w1_br u_t026_002/c1_r0_rbl u_t026_002/c1_r1_rbl
+ u_t026_002/c2_w0_bl u_t026_002/c2_w0_br u_t026_002/c2_w1_bl u_t026_002/c2_w1_br
+ u_t026_002/c2_r0_rbl u_t026_002/c2_r1_rbl u_t026_002/c3_w0_bl u_t026_002/c3_w0_br
+ u_t026_002/c3_w1_bl u_t026_002/c3_w1_br u_t026_002/c3_r0_rbl u_t026_002/c3_r1_rbl
+ u_t026_002/r0_w0_wl u_t026_002/r0_w1_wl u_t026_002/r0_r0_rwl u_t026_002/r0_r1_rwl
+ u_t026_002/r1_w0_wl u_t026_002/r1_w1_wl u_t026_002/r1_r0_rwl u_t026_002/r1_r1_rwl
+ u_t026_002/r2_w0_wl u_t026_002/r2_w1_wl u_t026_002/r2_r0_rwl u_t026_002/r2_r1_rwl
+ u_t026_002/r3_w0_wl u_t026_002/r3_w1_wl u_t026_002/r3_r0_rwl u_t026_002/r3_r1_rwl
+ VSS u_t026_031/VSS VSUBS detronyx_12t_2w2r_rc4_4x4_routed_5layer_direct
Xgf180mcu_as_sc_mcu7t3v3__nand4_2_91 gf180mcu_as_sc_mcu7t3v3__inv_2_357/VDD gf180mcu_as_sc_mcu7t3v3__inv_2_358/VDD
+ VSS VSS VSS VSS VSS gf180mcu_as_sc_mcu7t3v3__inv_2_357/VNW VSUBS gf180mcu_as_sc_mcu7t3v3__nand4_2
Xgf180mcu_as_sc_mcu7t3v3__nand4_2_80 gf180mcu_as_sc_mcu7t3v3__inv_2_233/VDD VSS VSS
+ VSS VSS VSS VSS gf180mcu_as_sc_mcu7t3v3__inv_2_233/VNW VSUBS gf180mcu_as_sc_mcu7t3v3__nand4_2
Xu_t017_024 u_t017_024/c0_w0_bl u_t017_024/c0_w0_br u_t017_024/c0_w1_bl u_t017_024/c0_w1_br
+ u_t017_024/c0_r0_rbl u_t017_024/c0_r1_rbl u_t017_024/c1_w0_bl u_t017_024/c1_w0_br
+ u_t017_024/c1_w1_bl u_t017_024/c1_w1_br u_t017_024/c1_r0_rbl u_t017_024/c1_r1_rbl
+ u_t017_024/c2_w0_bl u_t017_024/c2_w0_br u_t017_024/c2_w1_bl u_t017_024/c2_w1_br
+ u_t017_024/c2_r0_rbl u_t017_024/c2_r1_rbl u_t017_024/c3_w0_bl u_t017_024/c3_w0_br
+ u_t017_024/c3_w1_bl u_t017_024/c3_w1_br u_t017_024/c3_r0_rbl u_t017_024/c3_r1_rbl
+ u_t017_024/r0_w0_wl u_t017_024/r0_w1_wl u_t017_024/r0_r0_rwl u_t017_024/r0_r1_rwl
+ u_t017_024/r1_w0_wl u_t017_024/r1_w1_wl u_t017_024/r1_r0_rwl u_t017_024/r1_r1_rwl
+ u_t017_024/r2_w0_wl u_t017_024/r2_w1_wl u_t017_024/r2_r0_rwl u_t017_024/r2_r1_rwl
+ u_t017_024/r3_w0_wl u_t017_024/r3_w1_wl u_t017_024/r3_r0_rwl u_t017_024/r3_r1_rwl
+ VSS u_t017_031/VSS VSUBS detronyx_12t_2w2r_rc4_4x4_routed_5layer_direct
Xu_t017_013 u_t017_013/c0_w0_bl u_t017_013/c0_w0_br u_t017_013/c0_w1_bl u_t017_013/c0_w1_br
+ u_t017_013/c0_r0_rbl u_t017_013/c0_r1_rbl u_t017_013/c1_w0_bl u_t017_013/c1_w0_br
+ u_t017_013/c1_w1_bl u_t017_013/c1_w1_br u_t017_013/c1_r0_rbl u_t017_013/c1_r1_rbl
+ u_t017_013/c2_w0_bl u_t017_013/c2_w0_br u_t017_013/c2_w1_bl u_t017_013/c2_w1_br
+ u_t017_013/c2_r0_rbl u_t017_013/c2_r1_rbl u_t017_013/c3_w0_bl u_t017_013/c3_w0_br
+ u_t017_013/c3_w1_bl u_t017_013/c3_w1_br u_t017_013/c3_r0_rbl u_t017_013/c3_r1_rbl
+ u_t017_013/r0_w0_wl u_t017_013/r0_w1_wl u_t017_013/r0_r0_rwl u_t017_013/r0_r1_rwl
+ u_t017_013/r1_w0_wl u_t017_013/r1_w1_wl u_t017_013/r1_r0_rwl u_t017_013/r1_r1_rwl
+ u_t017_013/r2_w0_wl u_t017_013/r2_w1_wl u_t017_013/r2_r0_rwl u_t017_013/r2_r1_rwl
+ u_t017_013/r3_w0_wl u_t017_013/r3_w1_wl u_t017_013/r3_r0_rwl u_t017_013/r3_r1_rwl
+ u_t017_013/VDD u_t017_031/VSS VSUBS detronyx_12t_2w2r_rc4_4x4_routed_5layer_direct
Xu_t017_002 u_t017_002/c0_w0_bl u_t017_002/c0_w0_br u_t017_002/c0_w1_bl u_t017_002/c0_w1_br
+ u_t017_002/c0_r0_rbl u_t017_002/c0_r1_rbl u_t017_002/c1_w0_bl u_t017_002/c1_w0_br
+ u_t017_002/c1_w1_bl u_t017_002/c1_w1_br u_t017_002/c1_r0_rbl u_t017_002/c1_r1_rbl
+ u_t017_002/c2_w0_bl u_t017_002/c2_w0_br u_t017_002/c2_w1_bl u_t017_002/c2_w1_br
+ u_t017_002/c2_r0_rbl u_t017_002/c2_r1_rbl u_t017_002/c3_w0_bl u_t017_002/c3_w0_br
+ u_t017_002/c3_w1_bl u_t017_002/c3_w1_br u_t017_002/c3_r0_rbl u_t017_002/c3_r1_rbl
+ u_t017_002/r0_w0_wl u_t017_002/r0_w1_wl u_t017_002/r0_r0_rwl u_t017_002/r0_r1_rwl
+ u_t017_002/r1_w0_wl u_t017_002/r1_w1_wl u_t017_002/r1_r0_rwl u_t017_002/r1_r1_rwl
+ u_t017_002/r2_w0_wl u_t017_002/r2_w1_wl u_t017_002/r2_r0_rwl u_t017_002/r2_r1_rwl
+ u_t017_002/r3_w0_wl u_t017_002/r3_w1_wl u_t017_002/r3_r0_rwl u_t017_002/r3_r1_rwl
+ VSS u_t017_031/VSS VSUBS detronyx_12t_2w2r_rc4_4x4_routed_5layer_direct
Xgf180mcu_as_sc_mcu7t3v3__inv_2_105 gf180mcu_as_sc_mcu7t3v3__inv_2_151/VSS gf180mcu_as_sc_mcu7t3v3__inv_2_139/VSS
+ gf180mcu_as_sc_mcu7t3v3__inv_2_105/Y VSS gf180mcu_as_sc_mcu7t3v3__inv_2_139/VNW
+ VSUBS gf180mcu_as_sc_mcu7t3v3__inv_2
Xgf180mcu_as_sc_mcu7t3v3__inv_2_116 gf180mcu_as_sc_mcu7t3v3__inv_2_151/VSS gf180mcu_as_sc_mcu7t3v3__inv_2_151/VSS
+ VSS VSS gf180mcu_as_sc_mcu7t3v3__inv_2_123/VNW VSUBS gf180mcu_as_sc_mcu7t3v3__inv_2
Xgf180mcu_as_sc_mcu7t3v3__inv_2_149 VSS gf180mcu_as_sc_mcu7t3v3__inv_2_99/VDD gf180mcu_as_sc_mcu7t3v3__inv_2_149/Y
+ VSS gf180mcu_as_sc_mcu7t3v3__inv_2_150/VNW VSUBS gf180mcu_as_sc_mcu7t3v3__inv_2
Xgf180mcu_as_sc_mcu7t3v3__inv_2_138 gf180mcu_as_sc_mcu7t3v3__inv_2_138/VDD VSS VSS
+ VSS gf180mcu_as_sc_mcu7t3v3__inv_2_138/VNW VSUBS gf180mcu_as_sc_mcu7t3v3__inv_2
Xgf180mcu_as_sc_mcu7t3v3__inv_2_127 gf180mcu_as_sc_mcu7t3v3__inv_2_152/VSS gf180mcu_as_sc_mcu7t3v3__inv_2_152/VSS
+ VSS VSS gf180mcu_as_sc_mcu7t3v3__inv_2_152/VNW VSUBS gf180mcu_as_sc_mcu7t3v3__inv_2
Xu_t023_027 u_t023_027/c0_w0_bl u_t023_027/c0_w0_br u_t023_027/c0_w1_bl u_t023_027/c0_w1_br
+ u_t023_027/c0_r0_rbl u_t023_027/c0_r1_rbl u_t023_027/c1_w0_bl u_t023_027/c1_w0_br
+ u_t023_027/c1_w1_bl u_t023_027/c1_w1_br u_t023_027/c1_r0_rbl u_t023_027/c1_r1_rbl
+ u_t023_027/c2_w0_bl u_t023_027/c2_w0_br u_t023_027/c2_w1_bl u_t023_027/c2_w1_br
+ u_t023_027/c2_r0_rbl u_t023_027/c2_r1_rbl u_t023_027/c3_w0_bl u_t023_027/c3_w0_br
+ u_t023_027/c3_w1_bl u_t023_027/c3_w1_br u_t023_027/c3_r0_rbl u_t023_027/c3_r1_rbl
+ u_t023_027/r0_w0_wl u_t023_027/r0_w1_wl u_t023_027/r0_r0_rwl u_t023_027/r0_r1_rwl
+ u_t023_027/r1_w0_wl u_t023_027/r1_w1_wl u_t023_027/r1_r0_rwl u_t023_027/r1_r1_rwl
+ u_t023_027/r2_w0_wl u_t023_027/r2_w1_wl u_t023_027/r2_r0_rwl u_t023_027/r2_r1_rwl
+ u_t023_027/r3_w0_wl u_t023_027/r3_w1_wl u_t023_027/r3_r0_rwl u_t023_027/r3_r1_rwl
+ u_t023_027/VDD u_t023_027/VSS VSUBS detronyx_12t_2w2r_rc4_4x4_routed_5layer_direct
Xu_t008_024 u_t008_024/c0_w0_bl u_t008_024/c0_w0_br u_t008_024/c0_w1_bl u_t008_024/c0_w1_br
+ u_t008_024/c0_r0_rbl u_t008_024/c0_r1_rbl u_t008_024/c1_w0_bl u_t008_024/c1_w0_br
+ u_t008_024/c1_w1_bl u_t008_024/c1_w1_br u_t008_024/c1_r0_rbl u_t008_024/c1_r1_rbl
+ u_t008_024/c2_w0_bl u_t008_024/c2_w0_br u_t008_024/c2_w1_bl u_t008_024/c2_w1_br
+ u_t008_024/c2_r0_rbl u_t008_024/c2_r1_rbl u_t008_024/c3_w0_bl u_t008_024/c3_w0_br
+ u_t008_024/c3_w1_bl u_t008_024/c3_w1_br u_t008_024/c3_r0_rbl u_t008_024/c3_r1_rbl
+ u_t008_024/r0_w0_wl u_t008_024/r0_w1_wl u_t008_024/r0_r0_rwl u_t008_024/r0_r1_rwl
+ u_t008_024/r1_w0_wl u_t008_024/r1_w1_wl u_t008_024/r1_r0_rwl u_t008_024/r1_r1_rwl
+ u_t008_024/r2_w0_wl u_t008_024/r2_w1_wl u_t008_024/r2_r0_rwl u_t008_024/r2_r1_rwl
+ u_t008_024/r3_w0_wl u_t008_024/r3_w1_wl u_t008_024/r3_r0_rwl u_t008_024/r3_r1_rwl
+ VSS u_t008_031/VSS VSUBS detronyx_12t_2w2r_rc4_4x4_routed_5layer_direct
Xu_t023_016 u_t023_016/c0_w0_bl u_t023_016/c0_w0_br u_t023_016/c0_w1_bl u_t023_016/c0_w1_br
+ u_t023_016/c0_r0_rbl u_t023_016/c0_r1_rbl u_t023_016/c1_w0_bl u_t023_016/c1_w0_br
+ u_t023_016/c1_w1_bl u_t023_016/c1_w1_br u_t023_016/c1_r0_rbl u_t023_016/c1_r1_rbl
+ u_t023_016/c2_w0_bl u_t023_016/c2_w0_br u_t023_016/c2_w1_bl u_t023_016/c2_w1_br
+ u_t023_016/c2_r0_rbl u_t023_016/c2_r1_rbl u_t023_016/c3_w0_bl u_t023_016/c3_w0_br
+ u_t023_016/c3_w1_bl u_t023_016/c3_w1_br u_t023_016/c3_r0_rbl u_t023_016/c3_r1_rbl
+ u_t023_016/r0_w0_wl u_t023_016/r0_w1_wl u_t023_016/r0_r0_rwl u_t023_016/r0_r1_rwl
+ u_t023_016/r1_w0_wl u_t023_016/r1_w1_wl u_t023_016/r1_r0_rwl u_t023_016/r1_r1_rwl
+ u_t023_016/r2_w0_wl u_t023_016/r2_w1_wl u_t023_016/r2_r0_rwl u_t023_016/r2_r1_rwl
+ u_t023_016/r3_w0_wl u_t023_016/r3_w1_wl u_t023_016/r3_r0_rwl u_t023_016/r3_r1_rwl
+ VSS u_t023_017/VSS VSUBS detronyx_12t_2w2r_rc4_4x4_routed_5layer_direct
Xu_t008_013 u_t008_013/c0_w0_bl u_t008_013/c0_w0_br u_t008_013/c0_w1_bl u_t008_013/c0_w1_br
+ u_t008_013/c0_r0_rbl u_t008_013/c0_r1_rbl u_t008_013/c1_w0_bl u_t008_013/c1_w0_br
+ u_t008_013/c1_w1_bl u_t008_013/c1_w1_br u_t008_013/c1_r0_rbl u_t008_013/c1_r1_rbl
+ u_t008_013/c2_w0_bl u_t008_013/c2_w0_br u_t008_013/c2_w1_bl u_t008_013/c2_w1_br
+ u_t008_013/c2_r0_rbl u_t008_013/c2_r1_rbl u_t008_013/c3_w0_bl u_t008_013/c3_w0_br
+ u_t008_013/c3_w1_bl u_t008_013/c3_w1_br u_t008_013/c3_r0_rbl u_t008_013/c3_r1_rbl
+ u_t008_013/r0_w0_wl u_t008_013/r0_w1_wl u_t008_013/r0_r0_rwl u_t008_013/r0_r1_rwl
+ u_t008_013/r1_w0_wl u_t008_013/r1_w1_wl u_t008_013/r1_r0_rwl u_t008_013/r1_r1_rwl
+ u_t008_013/r2_w0_wl u_t008_013/r2_w1_wl u_t008_013/r2_r0_rwl u_t008_013/r2_r1_rwl
+ u_t008_013/r3_w0_wl u_t008_013/r3_w1_wl u_t008_013/r3_r0_rwl u_t008_013/r3_r1_rwl
+ u_t008_013/VDD u_t008_031/VSS VSUBS detronyx_12t_2w2r_rc4_4x4_routed_5layer_direct
Xu_t023_005 u_t023_005/c0_w0_bl u_t023_005/c0_w0_br u_t023_005/c0_w1_bl u_t023_005/c0_w1_br
+ u_t023_005/c0_r0_rbl u_t023_005/c0_r1_rbl u_t023_005/c1_w0_bl u_t023_005/c1_w0_br
+ u_t023_005/c1_w1_bl u_t023_005/c1_w1_br u_t023_005/c1_r0_rbl u_t023_005/c1_r1_rbl
+ u_t023_005/c2_w0_bl u_t023_005/c2_w0_br u_t023_005/c2_w1_bl u_t023_005/c2_w1_br
+ u_t023_005/c2_r0_rbl u_t023_005/c2_r1_rbl u_t023_005/c3_w0_bl u_t023_005/c3_w0_br
+ u_t023_005/c3_w1_bl u_t023_005/c3_w1_br u_t023_005/c3_r0_rbl u_t023_005/c3_r1_rbl
+ u_t023_005/r0_w0_wl u_t023_005/r0_w1_wl u_t023_005/r0_r0_rwl u_t023_005/r0_r1_rwl
+ u_t023_005/r1_w0_wl u_t023_005/r1_w1_wl u_t023_005/r1_r0_rwl u_t023_005/r1_r1_rwl
+ u_t023_005/r2_w0_wl u_t023_005/r2_w1_wl u_t023_005/r2_r0_rwl u_t023_005/r2_r1_rwl
+ u_t023_005/r3_w0_wl u_t023_005/r3_w1_wl u_t023_005/r3_r0_rwl u_t023_005/r3_r1_rwl
+ u_t023_005/VDD u_t023_005/VSS VSUBS detronyx_12t_2w2r_rc4_4x4_routed_5layer_direct
Xu_t008_002 u_t008_002/c0_w0_bl u_t008_002/c0_w0_br u_t008_002/c0_w1_bl u_t008_002/c0_w1_br
+ u_t008_002/c0_r0_rbl u_t008_002/c0_r1_rbl u_t008_002/c1_w0_bl u_t008_002/c1_w0_br
+ u_t008_002/c1_w1_bl u_t008_002/c1_w1_br u_t008_002/c1_r0_rbl u_t008_002/c1_r1_rbl
+ u_t008_002/c2_w0_bl u_t008_002/c2_w0_br u_t008_002/c2_w1_bl u_t008_002/c2_w1_br
+ u_t008_002/c2_r0_rbl u_t008_002/c2_r1_rbl u_t008_002/c3_w0_bl u_t008_002/c3_w0_br
+ u_t008_002/c3_w1_bl u_t008_002/c3_w1_br u_t008_002/c3_r0_rbl u_t008_002/c3_r1_rbl
+ u_t008_002/r0_w0_wl u_t008_002/r0_w1_wl u_t008_002/r0_r0_rwl u_t008_002/r0_r1_rwl
+ u_t008_002/r1_w0_wl u_t008_002/r1_w1_wl u_t008_002/r1_r0_rwl u_t008_002/r1_r1_rwl
+ u_t008_002/r2_w0_wl u_t008_002/r2_w1_wl u_t008_002/r2_r0_rwl u_t008_002/r2_r1_rwl
+ u_t008_002/r3_w0_wl u_t008_002/r3_w1_wl u_t008_002/r3_r0_rwl u_t008_002/r3_r1_rwl
+ VSS u_t008_031/VSS VSUBS detronyx_12t_2w2r_rc4_4x4_routed_5layer_direct
Xgf180mcu_as_sc_mcu7t3v3__inv_2_672 VSS VSS gf180mcu_as_sc_mcu7t3v3__inv_2_684/A gf180mcu_as_sc_mcu7t3v3__inv_2_676/Y
+ gf180mcu_as_sc_mcu7t3v3__inv_2_676/VNW VSUBS gf180mcu_as_sc_mcu7t3v3__inv_2
Xgf180mcu_as_sc_mcu7t3v3__inv_2_661 gf180mcu_as_sc_mcu7t3v3__inv_2_663/VDD VSS gf180mcu_as_sc_mcu7t3v3__inv_2_661/Y
+ gf180mcu_as_sc_mcu7t3v3__inv_2_661/A gf180mcu_as_sc_mcu7t3v3__inv_2_663/VNW VSUBS
+ gf180mcu_as_sc_mcu7t3v3__inv_2
Xgf180mcu_as_sc_mcu7t3v3__inv_2_650 gf180mcu_as_sc_mcu7t3v3__inv_2_651/VDD VSS gf180mcu_as_sc_mcu7t3v3__inv_2_739/A
+ gf180mcu_as_sc_mcu7t3v3__inv_2_651/Y gf180mcu_as_sc_mcu7t3v3__inv_2_651/VNW VSUBS
+ gf180mcu_as_sc_mcu7t3v3__inv_2
Xgf180mcu_as_sc_mcu7t3v3__inv_2_683 gf180mcu_as_sc_mcu7t3v3__inv_2_741/VSS gf180mcu_as_sc_mcu7t3v3__inv_2_687/VDD
+ gf180mcu_as_sc_mcu7t3v3__inv_2_683/Y VSS gf180mcu_as_sc_mcu7t3v3__inv_2_683/VNW
+ VSUBS gf180mcu_as_sc_mcu7t3v3__inv_2
Xgf180mcu_as_sc_mcu7t3v3__inv_2_694 gf180mcu_as_sc_mcu7t3v3__inv_2_695/VDD VSS gf180mcu_as_sc_mcu7t3v3__inv_2_694/Y
+ gf180mcu_as_sc_mcu7t3v3__inv_2_695/Y gf180mcu_as_sc_mcu7t3v3__inv_2_695/VNW VSUBS
+ gf180mcu_as_sc_mcu7t3v3__inv_2
Xgf180mcu_as_sc_mcu7t3v3__nand2_2_17 gf180mcu_as_sc_mcu7t3v3__nor2_2_5/VDD gf180mcu_as_sc_mcu7t3v3__nor2_2_5/VSS
+ VSS VSS VSS gf180mcu_as_sc_mcu7t3v3__nor2_2_5/VNW VSUBS gf180mcu_as_sc_mcu7t3v3__nand2_2
Xgf180mcu_as_sc_mcu7t3v3__nand2_2_28 gf180mcu_as_sc_mcu7t3v3__nor2_2_4/VDD gf180mcu_as_sc_mcu7t3v3__nand3_2_8/VSS
+ VSS VSS VSS gf180mcu_as_sc_mcu7t3v3__nor2_2_4/VNW VSUBS gf180mcu_as_sc_mcu7t3v3__nand2_2
Xu_t014_027 u_t014_027/c0_w0_bl u_t014_027/c0_w0_br u_t014_027/c0_w1_bl u_t014_027/c0_w1_br
+ u_t014_027/c0_r0_rbl u_t014_027/c0_r1_rbl u_t014_027/c1_w0_bl u_t014_027/c1_w0_br
+ u_t014_027/c1_w1_bl u_t014_027/c1_w1_br u_t014_027/c1_r0_rbl u_t014_027/c1_r1_rbl
+ u_t014_027/c2_w0_bl u_t014_027/c2_w0_br u_t014_027/c2_w1_bl u_t014_027/c2_w1_br
+ u_t014_027/c2_r0_rbl u_t014_027/c2_r1_rbl u_t014_027/c3_w0_bl u_t014_027/c3_w0_br
+ u_t014_027/c3_w1_bl u_t014_027/c3_w1_br u_t014_027/c3_r0_rbl u_t014_027/c3_r1_rbl
+ u_t014_027/r0_w0_wl u_t014_027/r0_w1_wl u_t014_027/r0_r0_rwl u_t014_027/r0_r1_rwl
+ u_t014_027/r1_w0_wl u_t014_027/r1_w1_wl u_t014_027/r1_r0_rwl u_t014_027/r1_r1_rwl
+ u_t014_027/r2_w0_wl u_t014_027/r2_w1_wl u_t014_027/r2_r0_rwl u_t014_027/r2_r1_rwl
+ u_t014_027/r3_w0_wl u_t014_027/r3_w1_wl u_t014_027/r3_r0_rwl u_t014_027/r3_r1_rwl
+ u_t014_027/VDD u_t014_027/VSS VSUBS detronyx_12t_2w2r_rc4_4x4_routed_5layer_direct
Xu_t014_016 u_t014_016/c0_w0_bl u_t014_016/c0_w0_br u_t014_016/c0_w1_bl u_t014_016/c0_w1_br
+ u_t014_016/c0_r0_rbl u_t014_016/c0_r1_rbl u_t014_016/c1_w0_bl u_t014_016/c1_w0_br
+ u_t014_016/c1_w1_bl u_t014_016/c1_w1_br u_t014_016/c1_r0_rbl u_t014_016/c1_r1_rbl
+ u_t014_016/c2_w0_bl u_t014_016/c2_w0_br u_t014_016/c2_w1_bl u_t014_016/c2_w1_br
+ u_t014_016/c2_r0_rbl u_t014_016/c2_r1_rbl u_t014_016/c3_w0_bl u_t014_016/c3_w0_br
+ u_t014_016/c3_w1_bl u_t014_016/c3_w1_br u_t014_016/c3_r0_rbl u_t014_016/c3_r1_rbl
+ u_t014_016/r0_w0_wl u_t014_016/r0_w1_wl u_t014_016/r0_r0_rwl u_t014_016/r0_r1_rwl
+ u_t014_016/r1_w0_wl u_t014_016/r1_w1_wl u_t014_016/r1_r0_rwl u_t014_016/r1_r1_rwl
+ u_t014_016/r2_w0_wl u_t014_016/r2_w1_wl u_t014_016/r2_r0_rwl u_t014_016/r2_r1_rwl
+ u_t014_016/r3_w0_wl u_t014_016/r3_w1_wl u_t014_016/r3_r0_rwl u_t014_016/r3_r1_rwl
+ VSS u_t014_017/VSS VSUBS detronyx_12t_2w2r_rc4_4x4_routed_5layer_direct
Xu_t014_005 u_t014_005/c0_w0_bl u_t014_005/c0_w0_br u_t014_005/c0_w1_bl u_t014_005/c0_w1_br
+ u_t014_005/c0_r0_rbl u_t014_005/c0_r1_rbl u_t014_005/c1_w0_bl u_t014_005/c1_w0_br
+ u_t014_005/c1_w1_bl u_t014_005/c1_w1_br u_t014_005/c1_r0_rbl u_t014_005/c1_r1_rbl
+ u_t014_005/c2_w0_bl u_t014_005/c2_w0_br u_t014_005/c2_w1_bl u_t014_005/c2_w1_br
+ u_t014_005/c2_r0_rbl u_t014_005/c2_r1_rbl u_t014_005/c3_w0_bl u_t014_005/c3_w0_br
+ u_t014_005/c3_w1_bl u_t014_005/c3_w1_br u_t014_005/c3_r0_rbl u_t014_005/c3_r1_rbl
+ u_t014_005/r0_w0_wl u_t014_005/r0_w1_wl u_t014_005/r0_r0_rwl u_t014_005/r0_r1_rwl
+ u_t014_005/r1_w0_wl u_t014_005/r1_w1_wl u_t014_005/r1_r0_rwl u_t014_005/r1_r1_rwl
+ u_t014_005/r2_w0_wl u_t014_005/r2_w1_wl u_t014_005/r2_r0_rwl u_t014_005/r2_r1_rwl
+ u_t014_005/r3_w0_wl u_t014_005/r3_w1_wl u_t014_005/r3_r0_rwl u_t014_005/r3_r1_rwl
+ u_t014_005/VDD u_t014_005/VSS VSUBS detronyx_12t_2w2r_rc4_4x4_routed_5layer_direct
Xgf180mcu_as_sc_mcu7t3v3__nand2_2_39 gf180mcu_as_sc_mcu7t3v3__nand3_2_5/VDD gf180mcu_as_sc_mcu7t3v3__nor2_2_4/VSS
+ VSS VSS VSS gf180mcu_as_sc_mcu7t3v3__nand3_2_5/VNW VSUBS gf180mcu_as_sc_mcu7t3v3__nand2_2
Xu_t005_027 u_t005_027/c0_w0_bl u_t005_027/c0_w0_br u_t005_027/c0_w1_bl u_t005_027/c0_w1_br
+ u_t005_027/c0_r0_rbl u_t005_027/c0_r1_rbl u_t005_027/c1_w0_bl u_t005_027/c1_w0_br
+ u_t005_027/c1_w1_bl u_t005_027/c1_w1_br u_t005_027/c1_r0_rbl u_t005_027/c1_r1_rbl
+ u_t005_027/c2_w0_bl u_t005_027/c2_w0_br u_t005_027/c2_w1_bl u_t005_027/c2_w1_br
+ u_t005_027/c2_r0_rbl u_t005_027/c2_r1_rbl u_t005_027/c3_w0_bl u_t005_027/c3_w0_br
+ u_t005_027/c3_w1_bl u_t005_027/c3_w1_br u_t005_027/c3_r0_rbl u_t005_027/c3_r1_rbl
+ u_t005_027/r0_w0_wl u_t005_027/r0_w1_wl u_t005_027/r0_r0_rwl u_t005_027/r0_r1_rwl
+ u_t005_027/r1_w0_wl u_t005_027/r1_w1_wl u_t005_027/r1_r0_rwl u_t005_027/r1_r1_rwl
+ u_t005_027/r2_w0_wl u_t005_027/r2_w1_wl u_t005_027/r2_r0_rwl u_t005_027/r2_r1_rwl
+ u_t005_027/r3_w0_wl u_t005_027/r3_w1_wl u_t005_027/r3_r0_rwl u_t005_027/r3_r1_rwl
+ u_t005_027/VDD u_t005_031/VSS VSUBS detronyx_12t_2w2r_rc4_4x4_routed_5layer_direct
Xu_t005_016 u_t005_016/c0_w0_bl u_t005_016/c0_w0_br u_t005_016/c0_w1_bl u_t005_016/c0_w1_br
+ u_t005_016/c0_r0_rbl u_t005_016/c0_r1_rbl u_t005_016/c1_w0_bl u_t005_016/c1_w0_br
+ u_t005_016/c1_w1_bl u_t005_016/c1_w1_br u_t005_016/c1_r0_rbl u_t005_016/c1_r1_rbl
+ u_t005_016/c2_w0_bl u_t005_016/c2_w0_br u_t005_016/c2_w1_bl u_t005_016/c2_w1_br
+ u_t005_016/c2_r0_rbl u_t005_016/c2_r1_rbl u_t005_016/c3_w0_bl u_t005_016/c3_w0_br
+ u_t005_016/c3_w1_bl u_t005_016/c3_w1_br u_t005_016/c3_r0_rbl u_t005_016/c3_r1_rbl
+ u_t005_016/r0_w0_wl u_t005_016/r0_w1_wl u_t005_016/r0_r0_rwl u_t005_016/r0_r1_rwl
+ u_t005_016/r1_w0_wl u_t005_016/r1_w1_wl u_t005_016/r1_r0_rwl u_t005_016/r1_r1_rwl
+ u_t005_016/r2_w0_wl u_t005_016/r2_w1_wl u_t005_016/r2_r0_rwl u_t005_016/r2_r1_rwl
+ u_t005_016/r3_w0_wl u_t005_016/r3_w1_wl u_t005_016/r3_r0_rwl u_t005_016/r3_r1_rwl
+ VSS u_t005_031/VSS VSUBS detronyx_12t_2w2r_rc4_4x4_routed_5layer_direct
Xu_t005_005 u_t005_005/c0_w0_bl u_t005_005/c0_w0_br u_t005_005/c0_w1_bl u_t005_005/c0_w1_br
+ u_t005_005/c0_r0_rbl u_t005_005/c0_r1_rbl u_t005_005/c1_w0_bl u_t005_005/c1_w0_br
+ u_t005_005/c1_w1_bl u_t005_005/c1_w1_br u_t005_005/c1_r0_rbl u_t005_005/c1_r1_rbl
+ u_t005_005/c2_w0_bl u_t005_005/c2_w0_br u_t005_005/c2_w1_bl u_t005_005/c2_w1_br
+ u_t005_005/c2_r0_rbl u_t005_005/c2_r1_rbl u_t005_005/c3_w0_bl u_t005_005/c3_w0_br
+ u_t005_005/c3_w1_bl u_t005_005/c3_w1_br u_t005_005/c3_r0_rbl u_t005_005/c3_r1_rbl
+ u_t005_005/r0_w0_wl u_t005_005/r0_w1_wl u_t005_005/r0_r0_rwl u_t005_005/r0_r1_rwl
+ u_t005_005/r1_w0_wl u_t005_005/r1_w1_wl u_t005_005/r1_r0_rwl u_t005_005/r1_r1_rwl
+ u_t005_005/r2_w0_wl u_t005_005/r2_w1_wl u_t005_005/r2_r0_rwl u_t005_005/r2_r1_rwl
+ u_t005_005/r3_w0_wl u_t005_005/r3_w1_wl u_t005_005/r3_r0_rwl u_t005_005/r3_r1_rwl
+ u_t005_005/VDD u_t005_031/VSS VSUBS detronyx_12t_2w2r_rc4_4x4_routed_5layer_direct
Xu_t020_019 u_t020_019/c0_w0_bl u_t020_019/c0_w0_br u_t020_019/c0_w1_bl u_t020_019/c0_w1_br
+ u_t020_019/c0_r0_rbl u_t020_019/c0_r1_rbl u_t020_019/c1_w0_bl u_t020_019/c1_w0_br
+ u_t020_019/c1_w1_bl u_t020_019/c1_w1_br u_t020_019/c1_r0_rbl u_t020_019/c1_r1_rbl
+ u_t020_019/c2_w0_bl u_t020_019/c2_w0_br u_t020_019/c2_w1_bl u_t020_019/c2_w1_br
+ u_t020_019/c2_r0_rbl u_t020_019/c2_r1_rbl u_t020_019/c3_w0_bl u_t020_019/c3_w0_br
+ u_t020_019/c3_w1_bl u_t020_019/c3_w1_br u_t020_019/c3_r0_rbl u_t020_019/c3_r1_rbl
+ u_t020_019/r0_w0_wl u_t020_019/r0_w1_wl u_t020_019/r0_r0_rwl u_t020_019/r0_r1_rwl
+ u_t020_019/r1_w0_wl u_t020_019/r1_w1_wl u_t020_019/r1_r0_rwl u_t020_019/r1_r1_rwl
+ u_t020_019/r2_w0_wl u_t020_019/r2_w1_wl u_t020_019/r2_r0_rwl u_t020_019/r2_r1_rwl
+ u_t020_019/r3_w0_wl u_t020_019/r3_w1_wl u_t020_019/r3_r0_rwl u_t020_019/r3_r1_rwl
+ u_t020_019/VDD u_t020_019/VSS VSUBS detronyx_12t_2w2r_rc4_4x4_routed_5layer_direct
Xu_t020_008 u_t020_008/c0_w0_bl u_t020_008/c0_w0_br u_t020_008/c0_w1_bl u_t020_008/c0_w1_br
+ u_t020_008/c0_r0_rbl u_t020_008/c0_r1_rbl u_t020_008/c1_w0_bl u_t020_008/c1_w0_br
+ u_t020_008/c1_w1_bl u_t020_008/c1_w1_br u_t020_008/c1_r0_rbl u_t020_008/c1_r1_rbl
+ u_t020_008/c2_w0_bl u_t020_008/c2_w0_br u_t020_008/c2_w1_bl u_t020_008/c2_w1_br
+ u_t020_008/c2_r0_rbl u_t020_008/c2_r1_rbl u_t020_008/c3_w0_bl u_t020_008/c3_w0_br
+ u_t020_008/c3_w1_bl u_t020_008/c3_w1_br u_t020_008/c3_r0_rbl u_t020_008/c3_r1_rbl
+ u_t020_008/r0_w0_wl u_t020_008/r0_w1_wl u_t020_008/r0_r0_rwl u_t020_008/r0_r1_rwl
+ u_t020_008/r1_w0_wl u_t020_008/r1_w1_wl u_t020_008/r1_r0_rwl u_t020_008/r1_r1_rwl
+ u_t020_008/r2_w0_wl u_t020_008/r2_w1_wl u_t020_008/r2_r0_rwl u_t020_008/r2_r1_rwl
+ u_t020_008/r3_w0_wl u_t020_008/r3_w1_wl u_t020_008/r3_r0_rwl u_t020_008/r3_r1_rwl
+ VSS u_t020_009/VSS VSUBS detronyx_12t_2w2r_rc4_4x4_routed_5layer_direct
Xu_t011_019 u_t011_019/c0_w0_bl u_t011_019/c0_w0_br u_t011_019/c0_w1_bl u_t011_019/c0_w1_br
+ u_t011_019/c0_r0_rbl u_t011_019/c0_r1_rbl u_t011_019/c1_w0_bl u_t011_019/c1_w0_br
+ u_t011_019/c1_w1_bl u_t011_019/c1_w1_br u_t011_019/c1_r0_rbl u_t011_019/c1_r1_rbl
+ u_t011_019/c2_w0_bl u_t011_019/c2_w0_br u_t011_019/c2_w1_bl u_t011_019/c2_w1_br
+ u_t011_019/c2_r0_rbl u_t011_019/c2_r1_rbl u_t011_019/c3_w0_bl u_t011_019/c3_w0_br
+ u_t011_019/c3_w1_bl u_t011_019/c3_w1_br u_t011_019/c3_r0_rbl u_t011_019/c3_r1_rbl
+ u_t011_019/r0_w0_wl u_t011_019/r0_w1_wl u_t011_019/r0_r0_rwl u_t011_019/r0_r1_rwl
+ u_t011_019/r1_w0_wl u_t011_019/r1_w1_wl u_t011_019/r1_r0_rwl u_t011_019/r1_r1_rwl
+ u_t011_019/r2_w0_wl u_t011_019/r2_w1_wl u_t011_019/r2_r0_rwl u_t011_019/r2_r1_rwl
+ u_t011_019/r3_w0_wl u_t011_019/r3_w1_wl u_t011_019/r3_r0_rwl u_t011_019/r3_r1_rwl
+ u_t011_019/VDD u_t011_019/VSS VSUBS detronyx_12t_2w2r_rc4_4x4_routed_5layer_direct
Xu_t011_008 u_t011_008/c0_w0_bl u_t011_008/c0_w0_br u_t011_008/c0_w1_bl u_t011_008/c0_w1_br
+ u_t011_008/c0_r0_rbl u_t011_008/c0_r1_rbl u_t011_008/c1_w0_bl u_t011_008/c1_w0_br
+ u_t011_008/c1_w1_bl u_t011_008/c1_w1_br u_t011_008/c1_r0_rbl u_t011_008/c1_r1_rbl
+ u_t011_008/c2_w0_bl u_t011_008/c2_w0_br u_t011_008/c2_w1_bl u_t011_008/c2_w1_br
+ u_t011_008/c2_r0_rbl u_t011_008/c2_r1_rbl u_t011_008/c3_w0_bl u_t011_008/c3_w0_br
+ u_t011_008/c3_w1_bl u_t011_008/c3_w1_br u_t011_008/c3_r0_rbl u_t011_008/c3_r1_rbl
+ u_t011_008/r0_w0_wl u_t011_008/r0_w1_wl u_t011_008/r0_r0_rwl u_t011_008/r0_r1_rwl
+ u_t011_008/r1_w0_wl u_t011_008/r1_w1_wl u_t011_008/r1_r0_rwl u_t011_008/r1_r1_rwl
+ u_t011_008/r2_w0_wl u_t011_008/r2_w1_wl u_t011_008/r2_r0_rwl u_t011_008/r2_r1_rwl
+ u_t011_008/r3_w0_wl u_t011_008/r3_w1_wl u_t011_008/r3_r0_rwl u_t011_008/r3_r1_rwl
+ VSS u_t011_009/VSS VSUBS detronyx_12t_2w2r_rc4_4x4_routed_5layer_direct
Xgf180mcu_as_sc_mcu7t3v3__inv_2_491 gf180mcu_as_sc_mcu7t3v3__nor2_2_6/VDD gf180mcu_as_sc_mcu7t3v3__nor2_2_6/VSS
+ VSS VSS gf180mcu_as_sc_mcu7t3v3__nor2_2_6/VNW VSUBS gf180mcu_as_sc_mcu7t3v3__inv_2
Xgf180mcu_as_sc_mcu7t3v3__inv_2_480 gf180mcu_as_sc_mcu7t3v3__nor2_2_6/VDD gf180mcu_as_sc_mcu7t3v3__nand3_2_3/VSS
+ VSS VSS gf180mcu_as_sc_mcu7t3v3__nor2_2_6/VNW VSUBS gf180mcu_as_sc_mcu7t3v3__inv_2
Xu_t010_030 u_t010_030/c0_w0_bl u_t010_030/c0_w0_br u_t010_030/c0_w1_bl u_t010_030/c0_w1_br
+ u_t010_030/c0_r0_rbl u_t010_030/c0_r1_rbl u_t010_030/c1_w0_bl u_t010_030/c1_w0_br
+ u_t010_030/c1_w1_bl u_t010_030/c1_w1_br u_t010_030/c1_r0_rbl u_t010_030/c1_r1_rbl
+ u_t010_030/c2_w0_bl u_t010_030/c2_w0_br u_t010_030/c2_w1_bl u_t010_030/c2_w1_br
+ u_t010_030/c2_r0_rbl u_t010_030/c2_r1_rbl u_t010_030/c3_w0_bl u_t010_030/c3_w0_br
+ u_t010_030/c3_w1_bl u_t010_030/c3_w1_br u_t010_030/c3_r0_rbl u_t010_030/c3_r1_rbl
+ u_t010_030/r0_w0_wl u_t010_030/r0_w1_wl u_t010_030/r0_r0_rwl u_t010_030/r0_r1_rwl
+ u_t010_030/r1_w0_wl u_t010_030/r1_w1_wl u_t010_030/r1_r0_rwl u_t010_030/r1_r1_rwl
+ u_t010_030/r2_w0_wl u_t010_030/r2_w1_wl u_t010_030/r2_r0_rwl u_t010_030/r2_r1_rwl
+ u_t010_030/r3_w0_wl u_t010_030/r3_w1_wl u_t010_030/r3_r0_rwl u_t010_030/r3_r1_rwl
+ VSS u_t010_031/VSS VSUBS detronyx_12t_2w2r_rc4_4x4_routed_5layer_direct
Xu_t002_019 u_t002_019/c0_w0_bl u_t002_019/c0_w0_br u_t002_019/c0_w1_bl u_t002_019/c0_w1_br
+ u_t002_019/c0_r0_rbl u_t002_019/c0_r1_rbl u_t002_019/c1_w0_bl u_t002_019/c1_w0_br
+ u_t002_019/c1_w1_bl u_t002_019/c1_w1_br u_t002_019/c1_r0_rbl u_t002_019/c1_r1_rbl
+ u_t002_019/c2_w0_bl u_t002_019/c2_w0_br u_t002_019/c2_w1_bl u_t002_019/c2_w1_br
+ u_t002_019/c2_r0_rbl u_t002_019/c2_r1_rbl u_t002_019/c3_w0_bl u_t002_019/c3_w0_br
+ u_t002_019/c3_w1_bl u_t002_019/c3_w1_br u_t002_019/c3_r0_rbl u_t002_019/c3_r1_rbl
+ u_t002_019/r0_w0_wl u_t002_019/r0_w1_wl u_t002_019/r0_r0_rwl u_t002_019/r0_r1_rwl
+ u_t002_019/r1_w0_wl u_t002_019/r1_w1_wl u_t002_019/r1_r0_rwl u_t002_019/r1_r1_rwl
+ u_t002_019/r2_w0_wl u_t002_019/r2_w1_wl u_t002_019/r2_r0_rwl u_t002_019/r2_r1_rwl
+ u_t002_019/r3_w0_wl u_t002_019/r3_w1_wl u_t002_019/r3_r0_rwl u_t002_019/r3_r1_rwl
+ u_t002_019/VDD u_t002_019/VSS VSUBS detronyx_12t_2w2r_rc4_4x4_routed_5layer_direct
Xu_t002_008 u_t002_008/c0_w0_bl u_t002_008/c0_w0_br u_t002_008/c0_w1_bl u_t002_008/c0_w1_br
+ u_t002_008/c0_r0_rbl u_t002_008/c0_r1_rbl u_t002_008/c1_w0_bl u_t002_008/c1_w0_br
+ u_t002_008/c1_w1_bl u_t002_008/c1_w1_br u_t002_008/c1_r0_rbl u_t002_008/c1_r1_rbl
+ u_t002_008/c2_w0_bl u_t002_008/c2_w0_br u_t002_008/c2_w1_bl u_t002_008/c2_w1_br
+ u_t002_008/c2_r0_rbl u_t002_008/c2_r1_rbl u_t002_008/c3_w0_bl u_t002_008/c3_w0_br
+ u_t002_008/c3_w1_bl u_t002_008/c3_w1_br u_t002_008/c3_r0_rbl u_t002_008/c3_r1_rbl
+ u_t002_008/r0_w0_wl u_t002_008/r0_w1_wl u_t002_008/r0_r0_rwl u_t002_008/r0_r1_rwl
+ u_t002_008/r1_w0_wl u_t002_008/r1_w1_wl u_t002_008/r1_r0_rwl u_t002_008/r1_r1_rwl
+ u_t002_008/r2_w0_wl u_t002_008/r2_w1_wl u_t002_008/r2_r0_rwl u_t002_008/r2_r1_rwl
+ u_t002_008/r3_w0_wl u_t002_008/r3_w1_wl u_t002_008/r3_r0_rwl u_t002_008/r3_r1_rwl
+ VSS u_t002_009/VSS VSUBS detronyx_12t_2w2r_rc4_4x4_routed_5layer_direct
Xu_t001_030 u_t001_030/c0_w0_bl u_t001_030/c0_w0_br u_t001_030/c0_w1_bl u_t001_030/c0_w1_br
+ u_t001_030/c0_r0_rbl u_t001_030/c0_r1_rbl u_t001_030/c1_w0_bl u_t001_030/c1_w0_br
+ u_t001_030/c1_w1_bl u_t001_030/c1_w1_br u_t001_030/c1_r0_rbl u_t001_030/c1_r1_rbl
+ u_t001_030/c2_w0_bl u_t001_030/c2_w0_br u_t001_030/c2_w1_bl u_t001_030/c2_w1_br
+ u_t001_030/c2_r0_rbl u_t001_030/c2_r1_rbl u_t001_030/c3_w0_bl u_t001_030/c3_w0_br
+ u_t001_030/c3_w1_bl u_t001_030/c3_w1_br u_t001_030/c3_r0_rbl u_t001_030/c3_r1_rbl
+ u_t001_030/r0_w0_wl u_t001_030/r0_w1_wl u_t001_030/r0_r0_rwl u_t001_030/r0_r1_rwl
+ u_t001_030/r1_w0_wl u_t001_030/r1_w1_wl u_t001_030/r1_r0_rwl u_t001_030/r1_r1_rwl
+ u_t001_030/r2_w0_wl u_t001_030/r2_w1_wl u_t001_030/r2_r0_rwl u_t001_030/r2_r1_rwl
+ u_t001_030/r3_w0_wl u_t001_030/r3_w1_wl u_t001_030/r3_r0_rwl u_t001_030/r3_r1_rwl
+ VSS u_t001_031/VSS VSUBS detronyx_12t_2w2r_rc4_4x4_routed_5layer_direct
Xgf180mcu_as_sc_mcu7t3v3__inv_2_1209 gf180mcu_as_sc_mcu7t3v3__nand3_2_31/VDD gf180mcu_as_sc_mcu7t3v3__nand3_2_31/VSS
+ VSS VSS gf180mcu_as_sc_mcu7t3v3__nand3_2_31/VNW VSUBS gf180mcu_as_sc_mcu7t3v3__inv_2
Xgf180mcu_as_sc_mcu7t3v3__nand4_2_504 gf180mcu_as_sc_mcu7t3v3__inv_2_1668/VDD gf180mcu_as_sc_mcu7t3v3__inv_2_1669/VDD
+ VSS VSS VSS VSS VSS gf180mcu_as_sc_mcu7t3v3__inv_2_1668/VNW VSUBS gf180mcu_as_sc_mcu7t3v3__nand4_2
Xgf180mcu_as_sc_mcu7t3v3__inv_2_1006 VSS gf180mcu_as_sc_mcu7t3v3__inv_2_1011/VDD gf180mcu_as_sc_mcu7t3v3__inv_2_1294/Y
+ gf180mcu_as_sc_mcu7t3v3__inv_2_1007/Y gf180mcu_as_sc_mcu7t3v3__inv_2_1007/VNW VSUBS
+ gf180mcu_as_sc_mcu7t3v3__inv_2
Xgf180mcu_as_sc_mcu7t3v3__inv_2_36 gf180mcu_as_sc_mcu7t3v3__inv_2_62/VDD gf180mcu_as_sc_mcu7t3v3__inv_2_69/VSS
+ VSS gf180mcu_as_sc_mcu7t3v3__inv_2_77/Y gf180mcu_as_sc_mcu7t3v3__inv_2_62/VNW VSUBS
+ gf180mcu_as_sc_mcu7t3v3__inv_2
Xgf180mcu_as_sc_mcu7t3v3__inv_2_69 gf180mcu_as_sc_mcu7t3v3__inv_2_69/VSS gf180mcu_as_sc_mcu7t3v3__inv_2_69/VSS
+ gf180mcu_as_sc_mcu7t3v3__inv_2_2/A VSS gf180mcu_as_sc_mcu7t3v3__inv_2_69/VNW VSUBS
+ gf180mcu_as_sc_mcu7t3v3__inv_2
Xgf180mcu_as_sc_mcu7t3v3__inv_2_14 gf180mcu_as_sc_mcu7t3v3__inv_2_0/VSS gf180mcu_as_sc_mcu7t3v3__inv_2_6/VSS
+ gf180mcu_as_sc_mcu7t3v3__inv_2_14/Y gf180mcu_as_sc_mcu7t3v3__inv_2_9/A gf180mcu_as_sc_mcu7t3v3__inv_2_58/VNW
+ VSUBS gf180mcu_as_sc_mcu7t3v3__inv_2
Xgf180mcu_as_sc_mcu7t3v3__inv_2_58 gf180mcu_as_sc_mcu7t3v3__inv_2_0/VSS gf180mcu_as_sc_mcu7t3v3__inv_2_6/VSS
+ gf180mcu_as_sc_mcu7t3v3__inv_2_9/A VSS gf180mcu_as_sc_mcu7t3v3__inv_2_58/VNW VSUBS
+ gf180mcu_as_sc_mcu7t3v3__inv_2
Xgf180mcu_as_sc_mcu7t3v3__inv_2_25 gf180mcu_as_sc_mcu7t3v3__inv_2_75/VDD VSS VSS gf180mcu_as_sc_mcu7t3v3__inv_2_77/Y
+ gf180mcu_as_sc_mcu7t3v3__inv_2_75/VNW VSUBS gf180mcu_as_sc_mcu7t3v3__inv_2
Xgf180mcu_as_sc_mcu7t3v3__inv_2_47 gf180mcu_as_sc_mcu7t3v3__inv_2_73/VDD gf180mcu_as_sc_mcu7t3v3__inv_2_74/VDD
+ gf180mcu_as_sc_mcu7t3v3__inv_2_47/Y gf180mcu_as_sc_mcu7t3v3__inv_2_77/Y gf180mcu_as_sc_mcu7t3v3__inv_2_73/VNW
+ VSUBS gf180mcu_as_sc_mcu7t3v3__inv_2
Xgf180mcu_as_sc_mcu7t3v3__inv_2_1039 VSS gf180mcu_as_sc_mcu7t3v3__inv_2_1053/VDD VSS
+ gf180mcu_as_sc_mcu7t3v3__inv_2_1052/A gf180mcu_as_sc_mcu7t3v3__inv_2_1039/VNW VSUBS
+ gf180mcu_as_sc_mcu7t3v3__inv_2
Xgf180mcu_as_sc_mcu7t3v3__inv_2_1017 VSS VSS VSS gf180mcu_as_sc_mcu7t3v3__inv_2_1043/A
+ gf180mcu_as_sc_mcu7t3v3__inv_2_1019/VNW VSUBS gf180mcu_as_sc_mcu7t3v3__inv_2
Xgf180mcu_as_sc_mcu7t3v3__inv_2_1028 gf180mcu_as_sc_mcu7t3v3__inv_2_1030/VDD gf180mcu_as_sc_mcu7t3v3__inv_2_1034/VDD
+ VSS gf180mcu_as_sc_mcu7t3v3__inv_2_992/A gf180mcu_as_sc_mcu7t3v3__inv_2_1030/VNW
+ VSUBS gf180mcu_as_sc_mcu7t3v3__inv_2
Xgf180mcu_as_sc_mcu7t3v3__inv_2_1562 VSS VSS VSS VSS gf180mcu_as_sc_mcu7t3v3__inv_2_1570/VNW
+ VSUBS gf180mcu_as_sc_mcu7t3v3__inv_2
Xgf180mcu_as_sc_mcu7t3v3__inv_2_1540 gf180mcu_as_sc_mcu7t3v3__inv_2_1592/VSS gf180mcu_as_sc_mcu7t3v3__inv_2_1548/VSS
+ VSS VSS gf180mcu_as_sc_mcu7t3v3__inv_2_1548/VNW VSUBS gf180mcu_as_sc_mcu7t3v3__inv_2
Xgf180mcu_as_sc_mcu7t3v3__inv_2_1551 gf180mcu_as_sc_mcu7t3v3__inv_2_1551/VDD VSS gf180mcu_as_sc_mcu7t3v3__inv_2_1551/Y
+ VSS gf180mcu_as_sc_mcu7t3v3__inv_2_1551/VNW VSUBS gf180mcu_as_sc_mcu7t3v3__inv_2
Xgf180mcu_as_sc_mcu7t3v3__inv_2_1573 VSS gf180mcu_as_sc_mcu7t3v3__inv_2_1577/VDD VSS
+ VSS gf180mcu_as_sc_mcu7t3v3__inv_2_1573/VNW VSUBS gf180mcu_as_sc_mcu7t3v3__inv_2
Xgf180mcu_as_sc_mcu7t3v3__inv_2_1584 VSS gf180mcu_as_sc_mcu7t3v3__inv_2_1589/VDD VSS
+ VSS gf180mcu_as_sc_mcu7t3v3__inv_2_1585/VNW VSUBS gf180mcu_as_sc_mcu7t3v3__inv_2
Xgf180mcu_as_sc_mcu7t3v3__inv_2_1595 gf180mcu_as_sc_mcu7t3v3__inv_2_1667/VSS VSS gf180mcu_as_sc_mcu7t3v3__inv_2_1682/Y
+ gf180mcu_as_sc_mcu7t3v3__inv_2_1682/Y gf180mcu_as_sc_mcu7t3v3__inv_2_1651/VNW VSUBS
+ gf180mcu_as_sc_mcu7t3v3__inv_2
Xgf180mcu_as_sc_mcu7t3v3__nand3_2_6 gf180mcu_as_sc_mcu7t3v3__nor2_2_4/VDD gf180mcu_as_sc_mcu7t3v3__nand3_2_8/VSS
+ VSS VSS VSS VSS gf180mcu_as_sc_mcu7t3v3__nor2_2_4/VNW VSUBS gf180mcu_as_sc_mcu7t3v3__nand3_2
Xgf180mcu_as_sc_mcu7t3v3__nand4_2_356 VSS VSS VSS VSS VSS VSS VSS gf180mcu_as_sc_mcu7t3v3__inv_2_1285/VNW
+ VSUBS gf180mcu_as_sc_mcu7t3v3__nand4_2
Xgf180mcu_as_sc_mcu7t3v3__nand4_2_345 gf180mcu_as_sc_mcu7t3v3__inv_2_1117/VDD VSS
+ VSS VSS VSS VSS VSS gf180mcu_as_sc_mcu7t3v3__inv_2_1117/VNW VSUBS gf180mcu_as_sc_mcu7t3v3__nand4_2
Xgf180mcu_as_sc_mcu7t3v3__nand4_2_334 gf180mcu_as_sc_mcu7t3v3__inv_2_1105/VSS VSS
+ VSS VSS VSS VSS VSS gf180mcu_as_sc_mcu7t3v3__inv_2_1093/VNW VSUBS gf180mcu_as_sc_mcu7t3v3__nand4_2
Xgf180mcu_as_sc_mcu7t3v3__nand4_2_323 gf180mcu_as_sc_mcu7t3v3__inv_2_1080/VDD gf180mcu_as_sc_mcu7t3v3__inv_2_1084/VDD
+ VSS VSS VSS VSS VSS gf180mcu_as_sc_mcu7t3v3__inv_2_1080/VNW VSUBS gf180mcu_as_sc_mcu7t3v3__nand4_2
Xgf180mcu_as_sc_mcu7t3v3__nand4_2_367 VSS VSS VSS VSS VSS VSS gf180mcu_as_sc_mcu7t3v3__nand4_2_367/Y
+ gf180mcu_as_sc_mcu7t3v3__inv_2_1182/VNW VSUBS gf180mcu_as_sc_mcu7t3v3__nand4_2
Xgf180mcu_as_sc_mcu7t3v3__nand4_2_378 gf180mcu_as_sc_mcu7t3v3__inv_2_1295/VDD VSS
+ VSS VSS VSS VSS VSS gf180mcu_as_sc_mcu7t3v3__inv_2_1295/VNW VSUBS gf180mcu_as_sc_mcu7t3v3__nand4_2
Xgf180mcu_as_sc_mcu7t3v3__nand4_2_312 VSS VSS VSS VSS VSS VSS VSS gf180mcu_as_sc_mcu7t3v3__inv_2_1015/VNW
+ VSUBS gf180mcu_as_sc_mcu7t3v3__nand4_2
Xgf180mcu_as_sc_mcu7t3v3__nand4_2_301 VSS VSS VSS VSS VSS VSS VSS gf180mcu_as_sc_mcu7t3v3__inv_2_1022/VNW
+ VSUBS gf180mcu_as_sc_mcu7t3v3__nand4_2
Xgf180mcu_as_sc_mcu7t3v3__nand4_2_389 gf180mcu_as_sc_mcu7t3v3__inv_2_1379/VDD VSS
+ VSS VSS VSS VSS VSS gf180mcu_as_sc_mcu7t3v3__inv_2_1379/VNW VSUBS gf180mcu_as_sc_mcu7t3v3__nand4_2
Xu_t029_022 u_t029_022/c0_w0_bl u_t029_022/c0_w0_br u_t029_022/c0_w1_bl u_t029_022/c0_w1_br
+ u_t029_022/c0_r0_rbl u_t029_022/c0_r1_rbl u_t029_022/c1_w0_bl u_t029_022/c1_w0_br
+ u_t029_022/c1_w1_bl u_t029_022/c1_w1_br u_t029_022/c1_r0_rbl u_t029_022/c1_r1_rbl
+ u_t029_022/c2_w0_bl u_t029_022/c2_w0_br u_t029_022/c2_w1_bl u_t029_022/c2_w1_br
+ u_t029_022/c2_r0_rbl u_t029_022/c2_r1_rbl u_t029_022/c3_w0_bl u_t029_022/c3_w0_br
+ u_t029_022/c3_w1_bl u_t029_022/c3_w1_br u_t029_022/c3_r0_rbl u_t029_022/c3_r1_rbl
+ u_t029_022/r0_w0_wl u_t029_022/r0_w1_wl u_t029_022/r0_r0_rwl u_t029_022/r0_r1_rwl
+ u_t029_022/r1_w0_wl u_t029_022/r1_w1_wl u_t029_022/r1_r0_rwl u_t029_022/r1_r1_rwl
+ u_t029_022/r2_w0_wl u_t029_022/r2_w1_wl u_t029_022/r2_r0_rwl u_t029_022/r2_r1_rwl
+ u_t029_022/r3_w0_wl u_t029_022/r3_w1_wl u_t029_022/r3_r0_rwl u_t029_022/r3_r1_rwl
+ VSS u_t029_031/VSS VSUBS detronyx_12t_2w2r_rc4_4x4_routed_5layer_direct
Xu_t029_011 u_t029_011/c0_w0_bl u_t029_011/c0_w0_br u_t029_011/c0_w1_bl u_t029_011/c0_w1_br
+ u_t029_011/c0_r0_rbl u_t029_011/c0_r1_rbl u_t029_011/c1_w0_bl u_t029_011/c1_w0_br
+ u_t029_011/c1_w1_bl u_t029_011/c1_w1_br u_t029_011/c1_r0_rbl u_t029_011/c1_r1_rbl
+ u_t029_011/c2_w0_bl u_t029_011/c2_w0_br u_t029_011/c2_w1_bl u_t029_011/c2_w1_br
+ u_t029_011/c2_r0_rbl u_t029_011/c2_r1_rbl u_t029_011/c3_w0_bl u_t029_011/c3_w0_br
+ u_t029_011/c3_w1_bl u_t029_011/c3_w1_br u_t029_011/c3_r0_rbl u_t029_011/c3_r1_rbl
+ u_t029_011/r0_w0_wl u_t029_011/r0_w1_wl u_t029_011/r0_r0_rwl u_t029_011/r0_r1_rwl
+ u_t029_011/r1_w0_wl u_t029_011/r1_w1_wl u_t029_011/r1_r0_rwl u_t029_011/r1_r1_rwl
+ u_t029_011/r2_w0_wl u_t029_011/r2_w1_wl u_t029_011/r2_r0_rwl u_t029_011/r2_r1_rwl
+ u_t029_011/r3_w0_wl u_t029_011/r3_w1_wl u_t029_011/r3_r0_rwl u_t029_011/r3_r1_rwl
+ u_t029_011/VDD u_t029_031/VSS VSUBS detronyx_12t_2w2r_rc4_4x4_routed_5layer_direct
Xu_t029_000 u_t029_000/c0_w0_bl u_t029_000/c0_w0_br u_t029_000/c0_w1_bl u_t029_000/c0_w1_br
+ u_t029_000/c0_r0_rbl u_t029_000/c0_r1_rbl u_t029_000/c1_w0_bl u_t029_000/c1_w0_br
+ u_t029_000/c1_w1_bl u_t029_000/c1_w1_br u_t029_000/c1_r0_rbl u_t029_000/c1_r1_rbl
+ u_t029_000/c2_w0_bl u_t029_000/c2_w0_br u_t029_000/c2_w1_bl u_t029_000/c2_w1_br
+ u_t029_000/c2_r0_rbl u_t029_000/c2_r1_rbl u_t029_000/c3_w0_bl u_t029_000/c3_w0_br
+ u_t029_000/c3_w1_bl u_t029_000/c3_w1_br u_t029_000/c3_r0_rbl u_t029_000/c3_r1_rbl
+ u_t029_000/r0_w0_wl u_t029_000/r0_w1_wl u_t029_000/r0_r0_rwl u_t029_000/r0_r1_rwl
+ u_t029_000/r1_w0_wl u_t029_000/r1_w1_wl u_t029_000/r1_r0_rwl u_t029_000/r1_r1_rwl
+ u_t029_000/r2_w0_wl u_t029_000/r2_w1_wl u_t029_000/r2_r0_rwl u_t029_000/r2_r1_rwl
+ u_t029_000/r3_w0_wl u_t029_000/r3_w1_wl u_t029_000/r3_r0_rwl u_t029_000/r3_r1_rwl
+ VSS u_t029_031/VSS VSUBS detronyx_12t_2w2r_rc4_4x4_routed_5layer_direct
Xgf180mcu_as_sc_mcu7t3v3__inv_2_309 gf180mcu_as_sc_mcu7t3v3__inv_2_344/VDD VSS gf180mcu_as_sc_mcu7t3v3__inv_2_309/Y
+ gf180mcu_as_sc_mcu7t3v3__inv_2_344/Y gf180mcu_as_sc_mcu7t3v3__inv_2_344/VNW VSUBS
+ gf180mcu_as_sc_mcu7t3v3__inv_2
Xgf180mcu_as_sc_mcu7t3v3__inv_2_1381 gf180mcu_as_sc_mcu7t3v3__inv_2_1400/VSS VSS gf180mcu_as_sc_mcu7t3v3__inv_2_1685/Y
+ VSS gf180mcu_as_sc_mcu7t3v3__inv_2_1381/VNW VSUBS gf180mcu_as_sc_mcu7t3v3__inv_2
Xgf180mcu_as_sc_mcu7t3v3__inv_2_1370 VSS VSS gf180mcu_as_sc_mcu7t3v3__inv_2_1379/Y
+ VSS gf180mcu_as_sc_mcu7t3v3__inv_2_1370/VNW VSUBS gf180mcu_as_sc_mcu7t3v3__inv_2
Xgf180mcu_as_sc_mcu7t3v3__inv_2_1392 VSS gf180mcu_as_sc_mcu7t3v3__inv_2_1393/VDD gf180mcu_as_sc_mcu7t3v3__inv_2_1398/Y
+ VSS gf180mcu_as_sc_mcu7t3v3__inv_2_1392/VNW VSUBS gf180mcu_as_sc_mcu7t3v3__inv_2
Xgf180mcu_as_sc_mcu7t3v3__inv_2_821 VSS VSS gf180mcu_as_sc_mcu7t3v3__inv_2_821/Y VSS
+ gf180mcu_as_sc_mcu7t3v3__inv_2_829/VNW VSUBS gf180mcu_as_sc_mcu7t3v3__inv_2
Xgf180mcu_as_sc_mcu7t3v3__inv_2_810 VSS VSS gf180mcu_as_sc_mcu7t3v3__inv_2_810/Y VSS
+ gf180mcu_as_sc_mcu7t3v3__inv_2_812/VNW VSUBS gf180mcu_as_sc_mcu7t3v3__inv_2
Xgf180mcu_as_sc_mcu7t3v3__inv_2_843 VSS VSS VSS VSS gf180mcu_as_sc_mcu7t3v3__inv_2_843/VNW
+ VSUBS gf180mcu_as_sc_mcu7t3v3__inv_2
Xgf180mcu_as_sc_mcu7t3v3__inv_2_832 VSS VSS gf180mcu_as_sc_mcu7t3v3__inv_2_832/Y VSS
+ gf180mcu_as_sc_mcu7t3v3__inv_2_832/VNW VSUBS gf180mcu_as_sc_mcu7t3v3__inv_2
Xgf180mcu_as_sc_mcu7t3v3__inv_2_854 VSS VSS VSS VSS gf180mcu_as_sc_mcu7t3v3__inv_2_856/VNW
+ VSUBS gf180mcu_as_sc_mcu7t3v3__inv_2
Xgf180mcu_as_sc_mcu7t3v3__inv_2_865 VSS VSS gf180mcu_as_sc_mcu7t3v3__inv_2_865/Y VSS
+ gf180mcu_as_sc_mcu7t3v3__inv_2_865/VNW VSUBS gf180mcu_as_sc_mcu7t3v3__inv_2
Xgf180mcu_as_sc_mcu7t3v3__inv_2_898 VSS VSS VSS VSS gf180mcu_as_sc_mcu7t3v3__inv_2_900/VNW
+ VSUBS gf180mcu_as_sc_mcu7t3v3__inv_2
Xgf180mcu_as_sc_mcu7t3v3__inv_2_887 VSS VSS VSS VSS gf180mcu_as_sc_mcu7t3v3__inv_2_888/VNW
+ VSUBS gf180mcu_as_sc_mcu7t3v3__inv_2
Xgf180mcu_as_sc_mcu7t3v3__inv_2_876 VSS VSS VSS VSS gf180mcu_as_sc_mcu7t3v3__inv_2_876/VNW
+ VSUBS gf180mcu_as_sc_mcu7t3v3__inv_2
Xu_t026_014 u_t026_014/c0_w0_bl u_t026_014/c0_w0_br u_t026_014/c0_w1_bl u_t026_014/c0_w1_br
+ u_t026_014/c0_r0_rbl u_t026_014/c0_r1_rbl u_t026_014/c1_w0_bl u_t026_014/c1_w0_br
+ u_t026_014/c1_w1_bl u_t026_014/c1_w1_br u_t026_014/c1_r0_rbl u_t026_014/c1_r1_rbl
+ u_t026_014/c2_w0_bl u_t026_014/c2_w0_br u_t026_014/c2_w1_bl u_t026_014/c2_w1_br
+ u_t026_014/c2_r0_rbl u_t026_014/c2_r1_rbl u_t026_014/c3_w0_bl u_t026_014/c3_w0_br
+ u_t026_014/c3_w1_bl u_t026_014/c3_w1_br u_t026_014/c3_r0_rbl u_t026_014/c3_r1_rbl
+ u_t026_014/r0_w0_wl u_t026_014/r0_w1_wl u_t026_014/r0_r0_rwl u_t026_014/r0_r1_rwl
+ u_t026_014/r1_w0_wl u_t026_014/r1_w1_wl u_t026_014/r1_r0_rwl u_t026_014/r1_r1_rwl
+ u_t026_014/r2_w0_wl u_t026_014/r2_w1_wl u_t026_014/r2_r0_rwl u_t026_014/r2_r1_rwl
+ u_t026_014/r3_w0_wl u_t026_014/r3_w1_wl u_t026_014/r3_r0_rwl u_t026_014/r3_r1_rwl
+ u_t026_014/VDD u_t026_031/VSS VSUBS detronyx_12t_2w2r_rc4_4x4_routed_5layer_direct
Xu_t026_003 u_t026_003/c0_w0_bl u_t026_003/c0_w0_br u_t026_003/c0_w1_bl u_t026_003/c0_w1_br
+ u_t026_003/c0_r0_rbl u_t026_003/c0_r1_rbl u_t026_003/c1_w0_bl u_t026_003/c1_w0_br
+ u_t026_003/c1_w1_bl u_t026_003/c1_w1_br u_t026_003/c1_r0_rbl u_t026_003/c1_r1_rbl
+ u_t026_003/c2_w0_bl u_t026_003/c2_w0_br u_t026_003/c2_w1_bl u_t026_003/c2_w1_br
+ u_t026_003/c2_r0_rbl u_t026_003/c2_r1_rbl u_t026_003/c3_w0_bl u_t026_003/c3_w0_br
+ u_t026_003/c3_w1_bl u_t026_003/c3_w1_br u_t026_003/c3_r0_rbl u_t026_003/c3_r1_rbl
+ u_t026_003/r0_w0_wl u_t026_003/r0_w1_wl u_t026_003/r0_r0_rwl u_t026_003/r0_r1_rwl
+ u_t026_003/r1_w0_wl u_t026_003/r1_w1_wl u_t026_003/r1_r0_rwl u_t026_003/r1_r1_rwl
+ u_t026_003/r2_w0_wl u_t026_003/r2_w1_wl u_t026_003/r2_r0_rwl u_t026_003/r2_r1_rwl
+ u_t026_003/r3_w0_wl u_t026_003/r3_w1_wl u_t026_003/r3_r0_rwl u_t026_003/r3_r1_rwl
+ u_t026_003/VDD u_t026_031/VSS VSUBS detronyx_12t_2w2r_rc4_4x4_routed_5layer_direct
Xgf180mcu_as_sc_mcu7t3v3__nand4_2_175 gf180mcu_as_sc_mcu7t3v3__inv_2_626/VDD VSS VSS
+ VSS VSS VSS VSS gf180mcu_as_sc_mcu7t3v3__inv_2_626/VNW VSUBS gf180mcu_as_sc_mcu7t3v3__nand4_2
Xgf180mcu_as_sc_mcu7t3v3__nand4_2_153 VSS gf180mcu_as_sc_mcu7t3v3__inv_2_572/VDD VSS
+ VSS VSS VSS VSS gf180mcu_as_sc_mcu7t3v3__inv_2_565/VNW VSUBS gf180mcu_as_sc_mcu7t3v3__nand4_2
Xgf180mcu_as_sc_mcu7t3v3__nand4_2_131 VSS VSS VSS VSS VSS VSS gf180mcu_as_sc_mcu7t3v3__nand4_2_131/Y
+ gf180mcu_as_sc_mcu7t3v3__inv_2_451/VNW VSUBS gf180mcu_as_sc_mcu7t3v3__nand4_2
Xgf180mcu_as_sc_mcu7t3v3__nand4_2_142 VSS VSS VSS VSS VSS VSS VSS gf180mcu_as_sc_mcu7t3v3__inv_2_506/VNW
+ VSUBS gf180mcu_as_sc_mcu7t3v3__nand4_2
Xgf180mcu_as_sc_mcu7t3v3__nand4_2_164 gf180mcu_as_sc_mcu7t3v3__inv_2_616/VDD gf180mcu_as_sc_mcu7t3v3__inv_2_620/VDD
+ VSS VSS VSS VSS VSS gf180mcu_as_sc_mcu7t3v3__inv_2_616/VNW VSUBS gf180mcu_as_sc_mcu7t3v3__nand4_2
Xgf180mcu_as_sc_mcu7t3v3__nand4_2_197 gf180mcu_as_sc_mcu7t3v3__inv_2_667/VDD gf180mcu_as_sc_mcu7t3v3__inv_2_671/VDD
+ VSS VSS VSS VSS VSS gf180mcu_as_sc_mcu7t3v3__inv_2_667/VNW VSUBS gf180mcu_as_sc_mcu7t3v3__nand4_2
Xgf180mcu_as_sc_mcu7t3v3__nand4_2_120 gf180mcu_as_sc_mcu7t3v3__inv_2_338/VDD VSS VSS
+ VSS VSS VSS VSS gf180mcu_as_sc_mcu7t3v3__inv_2_338/VNW VSUBS gf180mcu_as_sc_mcu7t3v3__nand4_2
Xgf180mcu_as_sc_mcu7t3v3__nand4_2_186 gf180mcu_as_sc_mcu7t3v3__inv_2_719/VDD gf180mcu_as_sc_mcu7t3v3__inv_2_723/VDD
+ VSS VSS VSS VSS VSS gf180mcu_as_sc_mcu7t3v3__inv_2_719/VNW VSUBS gf180mcu_as_sc_mcu7t3v3__nand4_2
Xu_t026_025 u_t026_025/c0_w0_bl u_t026_025/c0_w0_br u_t026_025/c0_w1_bl u_t026_025/c0_w1_br
+ u_t026_025/c0_r0_rbl u_t026_025/c0_r1_rbl u_t026_025/c1_w0_bl u_t026_025/c1_w0_br
+ u_t026_025/c1_w1_bl u_t026_025/c1_w1_br u_t026_025/c1_r0_rbl u_t026_025/c1_r1_rbl
+ u_t026_025/c2_w0_bl u_t026_025/c2_w0_br u_t026_025/c2_w1_bl u_t026_025/c2_w1_br
+ u_t026_025/c2_r0_rbl u_t026_025/c2_r1_rbl u_t026_025/c3_w0_bl u_t026_025/c3_w0_br
+ u_t026_025/c3_w1_bl u_t026_025/c3_w1_br u_t026_025/c3_r0_rbl u_t026_025/c3_r1_rbl
+ u_t026_025/r0_w0_wl u_t026_025/r0_w1_wl u_t026_025/r0_r0_rwl u_t026_025/r0_r1_rwl
+ u_t026_025/r1_w0_wl u_t026_025/r1_w1_wl u_t026_025/r1_r0_rwl u_t026_025/r1_r1_rwl
+ u_t026_025/r2_w0_wl u_t026_025/r2_w1_wl u_t026_025/r2_r0_rwl u_t026_025/r2_r1_rwl
+ u_t026_025/r3_w0_wl u_t026_025/r3_w1_wl u_t026_025/r3_r0_rwl u_t026_025/r3_r1_rwl
+ VSS u_t026_031/VSS VSUBS detronyx_12t_2w2r_rc4_4x4_routed_5layer_direct
Xgf180mcu_as_sc_mcu7t3v3__nand4_2_92 VSS gf180mcu_as_sc_mcu7t3v3__inv_2_350/VDD VSS
+ VSS VSS VSS VSS gf180mcu_as_sc_mcu7t3v3__inv_2_349/VNW VSUBS gf180mcu_as_sc_mcu7t3v3__nand4_2
Xgf180mcu_as_sc_mcu7t3v3__nand4_2_70 gf180mcu_as_sc_mcu7t3v3__inv_2_177/VDD VSS VSS
+ VSS VSS VSS gf180mcu_as_sc_mcu7t3v3__nand4_2_70/Y gf180mcu_as_sc_mcu7t3v3__inv_2_177/VNW
+ VSUBS gf180mcu_as_sc_mcu7t3v3__nand4_2
Xgf180mcu_as_sc_mcu7t3v3__nand4_2_81 VSS gf180mcu_as_sc_mcu7t3v3__inv_2_241/VDD VSS
+ VSS VSS VSS gf180mcu_as_sc_mcu7t3v3__nand4_2_81/Y gf180mcu_as_sc_mcu7t3v3__inv_2_237/VNW
+ VSUBS gf180mcu_as_sc_mcu7t3v3__nand4_2
Xu_t017_025 u_t017_025/c0_w0_bl u_t017_025/c0_w0_br u_t017_025/c0_w1_bl u_t017_025/c0_w1_br
+ u_t017_025/c0_r0_rbl u_t017_025/c0_r1_rbl u_t017_025/c1_w0_bl u_t017_025/c1_w0_br
+ u_t017_025/c1_w1_bl u_t017_025/c1_w1_br u_t017_025/c1_r0_rbl u_t017_025/c1_r1_rbl
+ u_t017_025/c2_w0_bl u_t017_025/c2_w0_br u_t017_025/c2_w1_bl u_t017_025/c2_w1_br
+ u_t017_025/c2_r0_rbl u_t017_025/c2_r1_rbl u_t017_025/c3_w0_bl u_t017_025/c3_w0_br
+ u_t017_025/c3_w1_bl u_t017_025/c3_w1_br u_t017_025/c3_r0_rbl u_t017_025/c3_r1_rbl
+ u_t017_025/r0_w0_wl u_t017_025/r0_w1_wl u_t017_025/r0_r0_rwl u_t017_025/r0_r1_rwl
+ u_t017_025/r1_w0_wl u_t017_025/r1_w1_wl u_t017_025/r1_r0_rwl u_t017_025/r1_r1_rwl
+ u_t017_025/r2_w0_wl u_t017_025/r2_w1_wl u_t017_025/r2_r0_rwl u_t017_025/r2_r1_rwl
+ u_t017_025/r3_w0_wl u_t017_025/r3_w1_wl u_t017_025/r3_r0_rwl u_t017_025/r3_r1_rwl
+ VSS u_t017_031/VSS VSUBS detronyx_12t_2w2r_rc4_4x4_routed_5layer_direct
Xu_t017_014 u_t017_014/c0_w0_bl u_t017_014/c0_w0_br u_t017_014/c0_w1_bl u_t017_014/c0_w1_br
+ u_t017_014/c0_r0_rbl u_t017_014/c0_r1_rbl u_t017_014/c1_w0_bl u_t017_014/c1_w0_br
+ u_t017_014/c1_w1_bl u_t017_014/c1_w1_br u_t017_014/c1_r0_rbl u_t017_014/c1_r1_rbl
+ u_t017_014/c2_w0_bl u_t017_014/c2_w0_br u_t017_014/c2_w1_bl u_t017_014/c2_w1_br
+ u_t017_014/c2_r0_rbl u_t017_014/c2_r1_rbl u_t017_014/c3_w0_bl u_t017_014/c3_w0_br
+ u_t017_014/c3_w1_bl u_t017_014/c3_w1_br u_t017_014/c3_r0_rbl u_t017_014/c3_r1_rbl
+ u_t017_014/r0_w0_wl u_t017_014/r0_w1_wl u_t017_014/r0_r0_rwl u_t017_014/r0_r1_rwl
+ u_t017_014/r1_w0_wl u_t017_014/r1_w1_wl u_t017_014/r1_r0_rwl u_t017_014/r1_r1_rwl
+ u_t017_014/r2_w0_wl u_t017_014/r2_w1_wl u_t017_014/r2_r0_rwl u_t017_014/r2_r1_rwl
+ u_t017_014/r3_w0_wl u_t017_014/r3_w1_wl u_t017_014/r3_r0_rwl u_t017_014/r3_r1_rwl
+ u_t017_014/VDD u_t017_031/VSS VSUBS detronyx_12t_2w2r_rc4_4x4_routed_5layer_direct
Xu_t017_003 u_t017_003/c0_w0_bl u_t017_003/c0_w0_br u_t017_003/c0_w1_bl u_t017_003/c0_w1_br
+ u_t017_003/c0_r0_rbl u_t017_003/c0_r1_rbl u_t017_003/c1_w0_bl u_t017_003/c1_w0_br
+ u_t017_003/c1_w1_bl u_t017_003/c1_w1_br u_t017_003/c1_r0_rbl u_t017_003/c1_r1_rbl
+ u_t017_003/c2_w0_bl u_t017_003/c2_w0_br u_t017_003/c2_w1_bl u_t017_003/c2_w1_br
+ u_t017_003/c2_r0_rbl u_t017_003/c2_r1_rbl u_t017_003/c3_w0_bl u_t017_003/c3_w0_br
+ u_t017_003/c3_w1_bl u_t017_003/c3_w1_br u_t017_003/c3_r0_rbl u_t017_003/c3_r1_rbl
+ u_t017_003/r0_w0_wl u_t017_003/r0_w1_wl u_t017_003/r0_r0_rwl u_t017_003/r0_r1_rwl
+ u_t017_003/r1_w0_wl u_t017_003/r1_w1_wl u_t017_003/r1_r0_rwl u_t017_003/r1_r1_rwl
+ u_t017_003/r2_w0_wl u_t017_003/r2_w1_wl u_t017_003/r2_r0_rwl u_t017_003/r2_r1_rwl
+ u_t017_003/r3_w0_wl u_t017_003/r3_w1_wl u_t017_003/r3_r0_rwl u_t017_003/r3_r1_rwl
+ u_t017_003/VDD u_t017_031/VSS VSUBS detronyx_12t_2w2r_rc4_4x4_routed_5layer_direct
Xgf180mcu_as_sc_mcu7t3v3__inv_2_128 VSS gf180mcu_as_sc_mcu7t3v3__inv_2_134/VDD VSS
+ VSS gf180mcu_as_sc_mcu7t3v3__inv_2_130/VNW VSUBS gf180mcu_as_sc_mcu7t3v3__inv_2
Xgf180mcu_as_sc_mcu7t3v3__inv_2_139 gf180mcu_as_sc_mcu7t3v3__inv_2_151/VSS gf180mcu_as_sc_mcu7t3v3__inv_2_139/VSS
+ gf180mcu_as_sc_mcu7t3v3__inv_2_139/Y VSS gf180mcu_as_sc_mcu7t3v3__inv_2_139/VNW
+ VSUBS gf180mcu_as_sc_mcu7t3v3__inv_2
Xgf180mcu_as_sc_mcu7t3v3__inv_2_106 gf180mcu_as_sc_mcu7t3v3__inv_2_151/VSS gf180mcu_as_sc_mcu7t3v3__inv_2_139/VSS
+ VSS VSS gf180mcu_as_sc_mcu7t3v3__inv_2_139/VNW VSUBS gf180mcu_as_sc_mcu7t3v3__inv_2
Xgf180mcu_as_sc_mcu7t3v3__inv_2_117 gf180mcu_as_sc_mcu7t3v3__inv_2_119/VDD gf180mcu_as_sc_mcu7t3v3__inv_2_152/VSS
+ VSS VSS gf180mcu_as_sc_mcu7t3v3__inv_2_119/VNW VSUBS gf180mcu_as_sc_mcu7t3v3__inv_2
Xu_t008_003 u_t008_003/c0_w0_bl u_t008_003/c0_w0_br u_t008_003/c0_w1_bl u_t008_003/c0_w1_br
+ u_t008_003/c0_r0_rbl u_t008_003/c0_r1_rbl u_t008_003/c1_w0_bl u_t008_003/c1_w0_br
+ u_t008_003/c1_w1_bl u_t008_003/c1_w1_br u_t008_003/c1_r0_rbl u_t008_003/c1_r1_rbl
+ u_t008_003/c2_w0_bl u_t008_003/c2_w0_br u_t008_003/c2_w1_bl u_t008_003/c2_w1_br
+ u_t008_003/c2_r0_rbl u_t008_003/c2_r1_rbl u_t008_003/c3_w0_bl u_t008_003/c3_w0_br
+ u_t008_003/c3_w1_bl u_t008_003/c3_w1_br u_t008_003/c3_r0_rbl u_t008_003/c3_r1_rbl
+ u_t008_003/r0_w0_wl u_t008_003/r0_w1_wl u_t008_003/r0_r0_rwl u_t008_003/r0_r1_rwl
+ u_t008_003/r1_w0_wl u_t008_003/r1_w1_wl u_t008_003/r1_r0_rwl u_t008_003/r1_r1_rwl
+ u_t008_003/r2_w0_wl u_t008_003/r2_w1_wl u_t008_003/r2_r0_rwl u_t008_003/r2_r1_rwl
+ u_t008_003/r3_w0_wl u_t008_003/r3_w1_wl u_t008_003/r3_r0_rwl u_t008_003/r3_r1_rwl
+ u_t008_003/VDD u_t008_031/VSS VSUBS detronyx_12t_2w2r_rc4_4x4_routed_5layer_direct
Xu_t023_028 u_t023_028/c0_w0_bl u_t023_028/c0_w0_br u_t023_028/c0_w1_bl u_t023_028/c0_w1_br
+ u_t023_028/c0_r0_rbl u_t023_028/c0_r1_rbl u_t023_028/c1_w0_bl u_t023_028/c1_w0_br
+ u_t023_028/c1_w1_bl u_t023_028/c1_w1_br u_t023_028/c1_r0_rbl u_t023_028/c1_r1_rbl
+ u_t023_028/c2_w0_bl u_t023_028/c2_w0_br u_t023_028/c2_w1_bl u_t023_028/c2_w1_br
+ u_t023_028/c2_r0_rbl u_t023_028/c2_r1_rbl u_t023_028/c3_w0_bl u_t023_028/c3_w0_br
+ u_t023_028/c3_w1_bl u_t023_028/c3_w1_br u_t023_028/c3_r0_rbl u_t023_028/c3_r1_rbl
+ u_t023_028/r0_w0_wl u_t023_028/r0_w1_wl u_t023_028/r0_r0_rwl u_t023_028/r0_r1_rwl
+ u_t023_028/r1_w0_wl u_t023_028/r1_w1_wl u_t023_028/r1_r0_rwl u_t023_028/r1_r1_rwl
+ u_t023_028/r2_w0_wl u_t023_028/r2_w1_wl u_t023_028/r2_r0_rwl u_t023_028/r2_r1_rwl
+ u_t023_028/r3_w0_wl u_t023_028/r3_w1_wl u_t023_028/r3_r0_rwl u_t023_028/r3_r1_rwl
+ u_t023_028/VDD u_t023_028/VSS VSUBS detronyx_12t_2w2r_rc4_4x4_routed_5layer_direct
Xu_t008_025 u_t008_025/c0_w0_bl u_t008_025/c0_w0_br u_t008_025/c0_w1_bl u_t008_025/c0_w1_br
+ u_t008_025/c0_r0_rbl u_t008_025/c0_r1_rbl u_t008_025/c1_w0_bl u_t008_025/c1_w0_br
+ u_t008_025/c1_w1_bl u_t008_025/c1_w1_br u_t008_025/c1_r0_rbl u_t008_025/c1_r1_rbl
+ u_t008_025/c2_w0_bl u_t008_025/c2_w0_br u_t008_025/c2_w1_bl u_t008_025/c2_w1_br
+ u_t008_025/c2_r0_rbl u_t008_025/c2_r1_rbl u_t008_025/c3_w0_bl u_t008_025/c3_w0_br
+ u_t008_025/c3_w1_bl u_t008_025/c3_w1_br u_t008_025/c3_r0_rbl u_t008_025/c3_r1_rbl
+ u_t008_025/r0_w0_wl u_t008_025/r0_w1_wl u_t008_025/r0_r0_rwl u_t008_025/r0_r1_rwl
+ u_t008_025/r1_w0_wl u_t008_025/r1_w1_wl u_t008_025/r1_r0_rwl u_t008_025/r1_r1_rwl
+ u_t008_025/r2_w0_wl u_t008_025/r2_w1_wl u_t008_025/r2_r0_rwl u_t008_025/r2_r1_rwl
+ u_t008_025/r3_w0_wl u_t008_025/r3_w1_wl u_t008_025/r3_r0_rwl u_t008_025/r3_r1_rwl
+ VSS u_t008_031/VSS VSUBS detronyx_12t_2w2r_rc4_4x4_routed_5layer_direct
Xu_t023_017 u_t023_017/c0_w0_bl u_t023_017/c0_w0_br u_t023_017/c0_w1_bl u_t023_017/c0_w1_br
+ u_t023_017/c0_r0_rbl u_t023_017/c0_r1_rbl u_t023_017/c1_w0_bl u_t023_017/c1_w0_br
+ u_t023_017/c1_w1_bl u_t023_017/c1_w1_br u_t023_017/c1_r0_rbl u_t023_017/c1_r1_rbl
+ u_t023_017/c2_w0_bl u_t023_017/c2_w0_br u_t023_017/c2_w1_bl u_t023_017/c2_w1_br
+ u_t023_017/c2_r0_rbl u_t023_017/c2_r1_rbl u_t023_017/c3_w0_bl u_t023_017/c3_w0_br
+ u_t023_017/c3_w1_bl u_t023_017/c3_w1_br u_t023_017/c3_r0_rbl u_t023_017/c3_r1_rbl
+ u_t023_017/r0_w0_wl u_t023_017/r0_w1_wl u_t023_017/r0_r0_rwl u_t023_017/r0_r1_rwl
+ u_t023_017/r1_w0_wl u_t023_017/r1_w1_wl u_t023_017/r1_r0_rwl u_t023_017/r1_r1_rwl
+ u_t023_017/r2_w0_wl u_t023_017/r2_w1_wl u_t023_017/r2_r0_rwl u_t023_017/r2_r1_rwl
+ u_t023_017/r3_w0_wl u_t023_017/r3_w1_wl u_t023_017/r3_r0_rwl u_t023_017/r3_r1_rwl
+ VSS u_t023_017/VSS VSUBS detronyx_12t_2w2r_rc4_4x4_routed_5layer_direct
Xu_t008_014 u_t008_014/c0_w0_bl u_t008_014/c0_w0_br u_t008_014/c0_w1_bl u_t008_014/c0_w1_br
+ u_t008_014/c0_r0_rbl u_t008_014/c0_r1_rbl u_t008_014/c1_w0_bl u_t008_014/c1_w0_br
+ u_t008_014/c1_w1_bl u_t008_014/c1_w1_br u_t008_014/c1_r0_rbl u_t008_014/c1_r1_rbl
+ u_t008_014/c2_w0_bl u_t008_014/c2_w0_br u_t008_014/c2_w1_bl u_t008_014/c2_w1_br
+ u_t008_014/c2_r0_rbl u_t008_014/c2_r1_rbl u_t008_014/c3_w0_bl u_t008_014/c3_w0_br
+ u_t008_014/c3_w1_bl u_t008_014/c3_w1_br u_t008_014/c3_r0_rbl u_t008_014/c3_r1_rbl
+ u_t008_014/r0_w0_wl u_t008_014/r0_w1_wl u_t008_014/r0_r0_rwl u_t008_014/r0_r1_rwl
+ u_t008_014/r1_w0_wl u_t008_014/r1_w1_wl u_t008_014/r1_r0_rwl u_t008_014/r1_r1_rwl
+ u_t008_014/r2_w0_wl u_t008_014/r2_w1_wl u_t008_014/r2_r0_rwl u_t008_014/r2_r1_rwl
+ u_t008_014/r3_w0_wl u_t008_014/r3_w1_wl u_t008_014/r3_r0_rwl u_t008_014/r3_r1_rwl
+ u_t008_014/VDD u_t008_031/VSS VSUBS detronyx_12t_2w2r_rc4_4x4_routed_5layer_direct
Xu_t023_006 u_t023_006/c0_w0_bl u_t023_006/c0_w0_br u_t023_006/c0_w1_bl u_t023_006/c0_w1_br
+ u_t023_006/c0_r0_rbl u_t023_006/c0_r1_rbl u_t023_006/c1_w0_bl u_t023_006/c1_w0_br
+ u_t023_006/c1_w1_bl u_t023_006/c1_w1_br u_t023_006/c1_r0_rbl u_t023_006/c1_r1_rbl
+ u_t023_006/c2_w0_bl u_t023_006/c2_w0_br u_t023_006/c2_w1_bl u_t023_006/c2_w1_br
+ u_t023_006/c2_r0_rbl u_t023_006/c2_r1_rbl u_t023_006/c3_w0_bl u_t023_006/c3_w0_br
+ u_t023_006/c3_w1_bl u_t023_006/c3_w1_br u_t023_006/c3_r0_rbl u_t023_006/c3_r1_rbl
+ u_t023_006/r0_w0_wl u_t023_006/r0_w1_wl u_t023_006/r0_r0_rwl u_t023_006/r0_r1_rwl
+ u_t023_006/r1_w0_wl u_t023_006/r1_w1_wl u_t023_006/r1_r0_rwl u_t023_006/r1_r1_rwl
+ u_t023_006/r2_w0_wl u_t023_006/r2_w1_wl u_t023_006/r2_r0_rwl u_t023_006/r2_r1_rwl
+ u_t023_006/r3_w0_wl u_t023_006/r3_w1_wl u_t023_006/r3_r0_rwl u_t023_006/r3_r1_rwl
+ u_t023_006/VDD u_t023_009/VSS VSUBS detronyx_12t_2w2r_rc4_4x4_routed_5layer_direct
Xgf180mcu_as_sc_mcu7t3v3__inv_2_673 VSS gf180mcu_as_sc_mcu7t3v3__inv_2_679/VDD gf180mcu_as_sc_mcu7t3v3__inv_2_673/Y
+ gf180mcu_as_sc_mcu7t3v3__inv_2_848/Y gf180mcu_as_sc_mcu7t3v3__inv_2_675/VNW VSUBS
+ gf180mcu_as_sc_mcu7t3v3__inv_2
Xgf180mcu_as_sc_mcu7t3v3__inv_2_640 VSS gf180mcu_as_sc_mcu7t3v3__inv_2_684/VSS gf180mcu_as_sc_mcu7t3v3__inv_2_640/Y
+ gf180mcu_as_sc_mcu7t3v3__inv_2_644/Y gf180mcu_as_sc_mcu7t3v3__inv_2_684/VNW VSUBS
+ gf180mcu_as_sc_mcu7t3v3__inv_2
Xgf180mcu_as_sc_mcu7t3v3__inv_2_684 VSS gf180mcu_as_sc_mcu7t3v3__inv_2_684/VSS gf180mcu_as_sc_mcu7t3v3__inv_2_684/Y
+ gf180mcu_as_sc_mcu7t3v3__inv_2_684/A gf180mcu_as_sc_mcu7t3v3__inv_2_684/VNW VSUBS
+ gf180mcu_as_sc_mcu7t3v3__inv_2
Xgf180mcu_as_sc_mcu7t3v3__inv_2_662 gf180mcu_as_sc_mcu7t3v3__inv_2_663/VDD VSS gf180mcu_as_sc_mcu7t3v3__inv_2_662/Y
+ gf180mcu_as_sc_mcu7t3v3__inv_2_663/Y gf180mcu_as_sc_mcu7t3v3__inv_2_663/VNW VSUBS
+ gf180mcu_as_sc_mcu7t3v3__inv_2
Xgf180mcu_as_sc_mcu7t3v3__inv_2_651 gf180mcu_as_sc_mcu7t3v3__inv_2_651/VDD VSS gf180mcu_as_sc_mcu7t3v3__inv_2_651/Y
+ VSS gf180mcu_as_sc_mcu7t3v3__inv_2_651/VNW VSUBS gf180mcu_as_sc_mcu7t3v3__inv_2
Xgf180mcu_as_sc_mcu7t3v3__inv_2_695 gf180mcu_as_sc_mcu7t3v3__inv_2_695/VDD VSS gf180mcu_as_sc_mcu7t3v3__inv_2_695/Y
+ VSS gf180mcu_as_sc_mcu7t3v3__inv_2_695/VNW VSUBS gf180mcu_as_sc_mcu7t3v3__inv_2
Xgf180mcu_as_sc_mcu7t3v3__nand2_2_18 gf180mcu_as_sc_mcu7t3v3__nor2_2_5/VDD gf180mcu_as_sc_mcu7t3v3__nand3_2_8/VSS
+ VSS VSS VSS gf180mcu_as_sc_mcu7t3v3__nor2_2_5/VNW VSUBS gf180mcu_as_sc_mcu7t3v3__nand2_2
Xgf180mcu_as_sc_mcu7t3v3__nand2_2_29 gf180mcu_as_sc_mcu7t3v3__nor2_2_4/VDD gf180mcu_as_sc_mcu7t3v3__nor2_2_4/VSS
+ VSS VSS VSS gf180mcu_as_sc_mcu7t3v3__nor2_2_4/VNW VSUBS gf180mcu_as_sc_mcu7t3v3__nand2_2
Xu_t014_028 u_t014_028/c0_w0_bl u_t014_028/c0_w0_br u_t014_028/c0_w1_bl u_t014_028/c0_w1_br
+ u_t014_028/c0_r0_rbl u_t014_028/c0_r1_rbl u_t014_028/c1_w0_bl u_t014_028/c1_w0_br
+ u_t014_028/c1_w1_bl u_t014_028/c1_w1_br u_t014_028/c1_r0_rbl u_t014_028/c1_r1_rbl
+ u_t014_028/c2_w0_bl u_t014_028/c2_w0_br u_t014_028/c2_w1_bl u_t014_028/c2_w1_br
+ u_t014_028/c2_r0_rbl u_t014_028/c2_r1_rbl u_t014_028/c3_w0_bl u_t014_028/c3_w0_br
+ u_t014_028/c3_w1_bl u_t014_028/c3_w1_br u_t014_028/c3_r0_rbl u_t014_028/c3_r1_rbl
+ u_t014_028/r0_w0_wl u_t014_028/r0_w1_wl u_t014_028/r0_r0_rwl u_t014_028/r0_r1_rwl
+ u_t014_028/r1_w0_wl u_t014_028/r1_w1_wl u_t014_028/r1_r0_rwl u_t014_028/r1_r1_rwl
+ u_t014_028/r2_w0_wl u_t014_028/r2_w1_wl u_t014_028/r2_r0_rwl u_t014_028/r2_r1_rwl
+ u_t014_028/r3_w0_wl u_t014_028/r3_w1_wl u_t014_028/r3_r0_rwl u_t014_028/r3_r1_rwl
+ u_t014_028/VDD u_t014_028/VSS VSUBS detronyx_12t_2w2r_rc4_4x4_routed_5layer_direct
Xu_t014_017 u_t014_017/c0_w0_bl u_t014_017/c0_w0_br u_t014_017/c0_w1_bl u_t014_017/c0_w1_br
+ u_t014_017/c0_r0_rbl u_t014_017/c0_r1_rbl u_t014_017/c1_w0_bl u_t014_017/c1_w0_br
+ u_t014_017/c1_w1_bl u_t014_017/c1_w1_br u_t014_017/c1_r0_rbl u_t014_017/c1_r1_rbl
+ u_t014_017/c2_w0_bl u_t014_017/c2_w0_br u_t014_017/c2_w1_bl u_t014_017/c2_w1_br
+ u_t014_017/c2_r0_rbl u_t014_017/c2_r1_rbl u_t014_017/c3_w0_bl u_t014_017/c3_w0_br
+ u_t014_017/c3_w1_bl u_t014_017/c3_w1_br u_t014_017/c3_r0_rbl u_t014_017/c3_r1_rbl
+ u_t014_017/r0_w0_wl u_t014_017/r0_w1_wl u_t014_017/r0_r0_rwl u_t014_017/r0_r1_rwl
+ u_t014_017/r1_w0_wl u_t014_017/r1_w1_wl u_t014_017/r1_r0_rwl u_t014_017/r1_r1_rwl
+ u_t014_017/r2_w0_wl u_t014_017/r2_w1_wl u_t014_017/r2_r0_rwl u_t014_017/r2_r1_rwl
+ u_t014_017/r3_w0_wl u_t014_017/r3_w1_wl u_t014_017/r3_r0_rwl u_t014_017/r3_r1_rwl
+ VSS u_t014_017/VSS VSUBS detronyx_12t_2w2r_rc4_4x4_routed_5layer_direct
Xu_t014_006 u_t014_006/c0_w0_bl u_t014_006/c0_w0_br u_t014_006/c0_w1_bl u_t014_006/c0_w1_br
+ u_t014_006/c0_r0_rbl u_t014_006/c0_r1_rbl u_t014_006/c1_w0_bl u_t014_006/c1_w0_br
+ u_t014_006/c1_w1_bl u_t014_006/c1_w1_br u_t014_006/c1_r0_rbl u_t014_006/c1_r1_rbl
+ u_t014_006/c2_w0_bl u_t014_006/c2_w0_br u_t014_006/c2_w1_bl u_t014_006/c2_w1_br
+ u_t014_006/c2_r0_rbl u_t014_006/c2_r1_rbl u_t014_006/c3_w0_bl u_t014_006/c3_w0_br
+ u_t014_006/c3_w1_bl u_t014_006/c3_w1_br u_t014_006/c3_r0_rbl u_t014_006/c3_r1_rbl
+ u_t014_006/r0_w0_wl u_t014_006/r0_w1_wl u_t014_006/r0_r0_rwl u_t014_006/r0_r1_rwl
+ u_t014_006/r1_w0_wl u_t014_006/r1_w1_wl u_t014_006/r1_r0_rwl u_t014_006/r1_r1_rwl
+ u_t014_006/r2_w0_wl u_t014_006/r2_w1_wl u_t014_006/r2_r0_rwl u_t014_006/r2_r1_rwl
+ u_t014_006/r3_w0_wl u_t014_006/r3_w1_wl u_t014_006/r3_r0_rwl u_t014_006/r3_r1_rwl
+ u_t014_006/VDD u_t014_009/VSS VSUBS detronyx_12t_2w2r_rc4_4x4_routed_5layer_direct
Xu_t005_028 u_t005_028/c0_w0_bl u_t005_028/c0_w0_br u_t005_028/c0_w1_bl u_t005_028/c0_w1_br
+ u_t005_028/c0_r0_rbl u_t005_028/c0_r1_rbl u_t005_028/c1_w0_bl u_t005_028/c1_w0_br
+ u_t005_028/c1_w1_bl u_t005_028/c1_w1_br u_t005_028/c1_r0_rbl u_t005_028/c1_r1_rbl
+ u_t005_028/c2_w0_bl u_t005_028/c2_w0_br u_t005_028/c2_w1_bl u_t005_028/c2_w1_br
+ u_t005_028/c2_r0_rbl u_t005_028/c2_r1_rbl u_t005_028/c3_w0_bl u_t005_028/c3_w0_br
+ u_t005_028/c3_w1_bl u_t005_028/c3_w1_br u_t005_028/c3_r0_rbl u_t005_028/c3_r1_rbl
+ u_t005_028/r0_w0_wl u_t005_028/r0_w1_wl u_t005_028/r0_r0_rwl u_t005_028/r0_r1_rwl
+ u_t005_028/r1_w0_wl u_t005_028/r1_w1_wl u_t005_028/r1_r0_rwl u_t005_028/r1_r1_rwl
+ u_t005_028/r2_w0_wl u_t005_028/r2_w1_wl u_t005_028/r2_r0_rwl u_t005_028/r2_r1_rwl
+ u_t005_028/r3_w0_wl u_t005_028/r3_w1_wl u_t005_028/r3_r0_rwl u_t005_028/r3_r1_rwl
+ u_t005_028/VDD u_t005_031/VSS VSUBS detronyx_12t_2w2r_rc4_4x4_routed_5layer_direct
Xu_t005_017 u_t005_017/c0_w0_bl u_t005_017/c0_w0_br u_t005_017/c0_w1_bl u_t005_017/c0_w1_br
+ u_t005_017/c0_r0_rbl u_t005_017/c0_r1_rbl u_t005_017/c1_w0_bl u_t005_017/c1_w0_br
+ u_t005_017/c1_w1_bl u_t005_017/c1_w1_br u_t005_017/c1_r0_rbl u_t005_017/c1_r1_rbl
+ u_t005_017/c2_w0_bl u_t005_017/c2_w0_br u_t005_017/c2_w1_bl u_t005_017/c2_w1_br
+ u_t005_017/c2_r0_rbl u_t005_017/c2_r1_rbl u_t005_017/c3_w0_bl u_t005_017/c3_w0_br
+ u_t005_017/c3_w1_bl u_t005_017/c3_w1_br u_t005_017/c3_r0_rbl u_t005_017/c3_r1_rbl
+ u_t005_017/r0_w0_wl u_t005_017/r0_w1_wl u_t005_017/r0_r0_rwl u_t005_017/r0_r1_rwl
+ u_t005_017/r1_w0_wl u_t005_017/r1_w1_wl u_t005_017/r1_r0_rwl u_t005_017/r1_r1_rwl
+ u_t005_017/r2_w0_wl u_t005_017/r2_w1_wl u_t005_017/r2_r0_rwl u_t005_017/r2_r1_rwl
+ u_t005_017/r3_w0_wl u_t005_017/r3_w1_wl u_t005_017/r3_r0_rwl u_t005_017/r3_r1_rwl
+ VSS u_t005_031/VSS VSUBS detronyx_12t_2w2r_rc4_4x4_routed_5layer_direct
Xu_t005_006 u_t005_006/c0_w0_bl u_t005_006/c0_w0_br u_t005_006/c0_w1_bl u_t005_006/c0_w1_br
+ u_t005_006/c0_r0_rbl u_t005_006/c0_r1_rbl u_t005_006/c1_w0_bl u_t005_006/c1_w0_br
+ u_t005_006/c1_w1_bl u_t005_006/c1_w1_br u_t005_006/c1_r0_rbl u_t005_006/c1_r1_rbl
+ u_t005_006/c2_w0_bl u_t005_006/c2_w0_br u_t005_006/c2_w1_bl u_t005_006/c2_w1_br
+ u_t005_006/c2_r0_rbl u_t005_006/c2_r1_rbl u_t005_006/c3_w0_bl u_t005_006/c3_w0_br
+ u_t005_006/c3_w1_bl u_t005_006/c3_w1_br u_t005_006/c3_r0_rbl u_t005_006/c3_r1_rbl
+ u_t005_006/r0_w0_wl u_t005_006/r0_w1_wl u_t005_006/r0_r0_rwl u_t005_006/r0_r1_rwl
+ u_t005_006/r1_w0_wl u_t005_006/r1_w1_wl u_t005_006/r1_r0_rwl u_t005_006/r1_r1_rwl
+ u_t005_006/r2_w0_wl u_t005_006/r2_w1_wl u_t005_006/r2_r0_rwl u_t005_006/r2_r1_rwl
+ u_t005_006/r3_w0_wl u_t005_006/r3_w1_wl u_t005_006/r3_r0_rwl u_t005_006/r3_r1_rwl
+ u_t005_006/VDD u_t005_031/VSS VSUBS detronyx_12t_2w2r_rc4_4x4_routed_5layer_direct
Xu_t020_009 u_t020_009/c0_w0_bl u_t020_009/c0_w0_br u_t020_009/c0_w1_bl u_t020_009/c0_w1_br
+ u_t020_009/c0_r0_rbl u_t020_009/c0_r1_rbl u_t020_009/c1_w0_bl u_t020_009/c1_w0_br
+ u_t020_009/c1_w1_bl u_t020_009/c1_w1_br u_t020_009/c1_r0_rbl u_t020_009/c1_r1_rbl
+ u_t020_009/c2_w0_bl u_t020_009/c2_w0_br u_t020_009/c2_w1_bl u_t020_009/c2_w1_br
+ u_t020_009/c2_r0_rbl u_t020_009/c2_r1_rbl u_t020_009/c3_w0_bl u_t020_009/c3_w0_br
+ u_t020_009/c3_w1_bl u_t020_009/c3_w1_br u_t020_009/c3_r0_rbl u_t020_009/c3_r1_rbl
+ u_t020_009/r0_w0_wl u_t020_009/r0_w1_wl u_t020_009/r0_r0_rwl u_t020_009/r0_r1_rwl
+ u_t020_009/r1_w0_wl u_t020_009/r1_w1_wl u_t020_009/r1_r0_rwl u_t020_009/r1_r1_rwl
+ u_t020_009/r2_w0_wl u_t020_009/r2_w1_wl u_t020_009/r2_r0_rwl u_t020_009/r2_r1_rwl
+ u_t020_009/r3_w0_wl u_t020_009/r3_w1_wl u_t020_009/r3_r0_rwl u_t020_009/r3_r1_rwl
+ VSS u_t020_009/VSS VSUBS detronyx_12t_2w2r_rc4_4x4_routed_5layer_direct
Xu_t011_009 u_t011_009/c0_w0_bl u_t011_009/c0_w0_br u_t011_009/c0_w1_bl u_t011_009/c0_w1_br
+ u_t011_009/c0_r0_rbl u_t011_009/c0_r1_rbl u_t011_009/c1_w0_bl u_t011_009/c1_w0_br
+ u_t011_009/c1_w1_bl u_t011_009/c1_w1_br u_t011_009/c1_r0_rbl u_t011_009/c1_r1_rbl
+ u_t011_009/c2_w0_bl u_t011_009/c2_w0_br u_t011_009/c2_w1_bl u_t011_009/c2_w1_br
+ u_t011_009/c2_r0_rbl u_t011_009/c2_r1_rbl u_t011_009/c3_w0_bl u_t011_009/c3_w0_br
+ u_t011_009/c3_w1_bl u_t011_009/c3_w1_br u_t011_009/c3_r0_rbl u_t011_009/c3_r1_rbl
+ u_t011_009/r0_w0_wl u_t011_009/r0_w1_wl u_t011_009/r0_r0_rwl u_t011_009/r0_r1_rwl
+ u_t011_009/r1_w0_wl u_t011_009/r1_w1_wl u_t011_009/r1_r0_rwl u_t011_009/r1_r1_rwl
+ u_t011_009/r2_w0_wl u_t011_009/r2_w1_wl u_t011_009/r2_r0_rwl u_t011_009/r2_r1_rwl
+ u_t011_009/r3_w0_wl u_t011_009/r3_w1_wl u_t011_009/r3_r0_rwl u_t011_009/r3_r1_rwl
+ VSS u_t011_009/VSS VSUBS detronyx_12t_2w2r_rc4_4x4_routed_5layer_direct
Xgf180mcu_as_sc_mcu7t3v3__inv_2_481 gf180mcu_as_sc_mcu7t3v3__nor2_2_4/VDD gf180mcu_as_sc_mcu7t3v3__nand3_2_8/VSS
+ VSS VSS gf180mcu_as_sc_mcu7t3v3__nor2_2_4/VNW VSUBS gf180mcu_as_sc_mcu7t3v3__inv_2
Xgf180mcu_as_sc_mcu7t3v3__inv_2_492 gf180mcu_as_sc_mcu7t3v3__nor2_2_6/VDD gf180mcu_as_sc_mcu7t3v3__nand3_2_3/VSS
+ VSS VSS gf180mcu_as_sc_mcu7t3v3__nor2_2_6/VNW VSUBS gf180mcu_as_sc_mcu7t3v3__inv_2
Xgf180mcu_as_sc_mcu7t3v3__inv_2_470 gf180mcu_as_sc_mcu7t3v3__nand3_2_5/VDD gf180mcu_as_sc_mcu7t3v3__nor2_2_6/VSS
+ VSS VSS gf180mcu_as_sc_mcu7t3v3__nand3_2_5/VNW VSUBS gf180mcu_as_sc_mcu7t3v3__inv_2
Xu_t010_031 u_t010_031/c0_w0_bl u_t010_031/c0_w0_br u_t010_031/c0_w1_bl u_t010_031/c0_w1_br
+ u_t010_031/c0_r0_rbl u_t010_031/c0_r1_rbl u_t010_031/c1_w0_bl u_t010_031/c1_w0_br
+ u_t010_031/c1_w1_bl u_t010_031/c1_w1_br u_t010_031/c1_r0_rbl u_t010_031/c1_r1_rbl
+ u_t010_031/c2_w0_bl u_t010_031/c2_w0_br u_t010_031/c2_w1_bl u_t010_031/c2_w1_br
+ u_t010_031/c2_r0_rbl u_t010_031/c2_r1_rbl u_t010_031/c3_w0_bl u_t010_031/c3_w0_br
+ u_t010_031/c3_w1_bl u_t010_031/c3_w1_br u_t010_031/c3_r0_rbl u_t010_031/c3_r1_rbl
+ u_t010_031/r0_w0_wl u_t010_031/r0_w1_wl u_t010_031/r0_r0_rwl u_t010_031/r0_r1_rwl
+ u_t010_031/r1_w0_wl u_t010_031/r1_w1_wl u_t010_031/r1_r0_rwl u_t010_031/r1_r1_rwl
+ u_t010_031/r2_w0_wl u_t010_031/r2_w1_wl u_t010_031/r2_r0_rwl u_t010_031/r2_r1_rwl
+ u_t010_031/r3_w0_wl u_t010_031/r3_w1_wl u_t010_031/r3_r0_rwl u_t010_031/r3_r1_rwl
+ VSS u_t010_031/VSS VSUBS detronyx_12t_2w2r_rc4_4x4_routed_5layer_direct
Xu_t010_020 u_t010_020/c0_w0_bl u_t010_020/c0_w0_br u_t010_020/c0_w1_bl u_t010_020/c0_w1_br
+ u_t010_020/c0_r0_rbl u_t010_020/c0_r1_rbl u_t010_020/c1_w0_bl u_t010_020/c1_w0_br
+ u_t010_020/c1_w1_bl u_t010_020/c1_w1_br u_t010_020/c1_r0_rbl u_t010_020/c1_r1_rbl
+ u_t010_020/c2_w0_bl u_t010_020/c2_w0_br u_t010_020/c2_w1_bl u_t010_020/c2_w1_br
+ u_t010_020/c2_r0_rbl u_t010_020/c2_r1_rbl u_t010_020/c3_w0_bl u_t010_020/c3_w0_br
+ u_t010_020/c3_w1_bl u_t010_020/c3_w1_br u_t010_020/c3_r0_rbl u_t010_020/c3_r1_rbl
+ u_t010_020/r0_w0_wl u_t010_020/r0_w1_wl u_t010_020/r0_r0_rwl u_t010_020/r0_r1_rwl
+ u_t010_020/r1_w0_wl u_t010_020/r1_w1_wl u_t010_020/r1_r0_rwl u_t010_020/r1_r1_rwl
+ u_t010_020/r2_w0_wl u_t010_020/r2_w1_wl u_t010_020/r2_r0_rwl u_t010_020/r2_r1_rwl
+ u_t010_020/r3_w0_wl u_t010_020/r3_w1_wl u_t010_020/r3_r0_rwl u_t010_020/r3_r1_rwl
+ u_t010_020/VDD u_t010_020/VSS VSUBS detronyx_12t_2w2r_rc4_4x4_routed_5layer_direct
Xu_t002_009 u_t002_009/c0_w0_bl u_t002_009/c0_w0_br u_t002_009/c0_w1_bl u_t002_009/c0_w1_br
+ u_t002_009/c0_r0_rbl u_t002_009/c0_r1_rbl u_t002_009/c1_w0_bl u_t002_009/c1_w0_br
+ u_t002_009/c1_w1_bl u_t002_009/c1_w1_br u_t002_009/c1_r0_rbl u_t002_009/c1_r1_rbl
+ u_t002_009/c2_w0_bl u_t002_009/c2_w0_br u_t002_009/c2_w1_bl u_t002_009/c2_w1_br
+ u_t002_009/c2_r0_rbl u_t002_009/c2_r1_rbl u_t002_009/c3_w0_bl u_t002_009/c3_w0_br
+ u_t002_009/c3_w1_bl u_t002_009/c3_w1_br u_t002_009/c3_r0_rbl u_t002_009/c3_r1_rbl
+ u_t002_009/r0_w0_wl u_t002_009/r0_w1_wl u_t002_009/r0_r0_rwl u_t002_009/r0_r1_rwl
+ u_t002_009/r1_w0_wl u_t002_009/r1_w1_wl u_t002_009/r1_r0_rwl u_t002_009/r1_r1_rwl
+ u_t002_009/r2_w0_wl u_t002_009/r2_w1_wl u_t002_009/r2_r0_rwl u_t002_009/r2_r1_rwl
+ u_t002_009/r3_w0_wl u_t002_009/r3_w1_wl u_t002_009/r3_r0_rwl u_t002_009/r3_r1_rwl
+ VSS u_t002_009/VSS VSUBS detronyx_12t_2w2r_rc4_4x4_routed_5layer_direct
Xu_t001_031 u_t001_031/c0_w0_bl u_t001_031/c0_w0_br u_t001_031/c0_w1_bl u_t001_031/c0_w1_br
+ u_t001_031/c0_r0_rbl u_t001_031/c0_r1_rbl u_t001_031/c1_w0_bl u_t001_031/c1_w0_br
+ u_t001_031/c1_w1_bl u_t001_031/c1_w1_br u_t001_031/c1_r0_rbl u_t001_031/c1_r1_rbl
+ u_t001_031/c2_w0_bl u_t001_031/c2_w0_br u_t001_031/c2_w1_bl u_t001_031/c2_w1_br
+ u_t001_031/c2_r0_rbl u_t001_031/c2_r1_rbl u_t001_031/c3_w0_bl u_t001_031/c3_w0_br
+ u_t001_031/c3_w1_bl u_t001_031/c3_w1_br u_t001_031/c3_r0_rbl u_t001_031/c3_r1_rbl
+ u_t001_031/r0_w0_wl u_t001_031/r0_w1_wl u_t001_031/r0_r0_rwl u_t001_031/r0_r1_rwl
+ u_t001_031/r1_w0_wl u_t001_031/r1_w1_wl u_t001_031/r1_r0_rwl u_t001_031/r1_r1_rwl
+ u_t001_031/r2_w0_wl u_t001_031/r2_w1_wl u_t001_031/r2_r0_rwl u_t001_031/r2_r1_rwl
+ u_t001_031/r3_w0_wl u_t001_031/r3_w1_wl u_t001_031/r3_r0_rwl u_t001_031/r3_r1_rwl
+ VSS u_t001_031/VSS VSUBS detronyx_12t_2w2r_rc4_4x4_routed_5layer_direct
Xu_t001_020 u_t001_020/c0_w0_bl u_t001_020/c0_w0_br u_t001_020/c0_w1_bl u_t001_020/c0_w1_br
+ u_t001_020/c0_r0_rbl u_t001_020/c0_r1_rbl u_t001_020/c1_w0_bl u_t001_020/c1_w0_br
+ u_t001_020/c1_w1_bl u_t001_020/c1_w1_br u_t001_020/c1_r0_rbl u_t001_020/c1_r1_rbl
+ u_t001_020/c2_w0_bl u_t001_020/c2_w0_br u_t001_020/c2_w1_bl u_t001_020/c2_w1_br
+ u_t001_020/c2_r0_rbl u_t001_020/c2_r1_rbl u_t001_020/c3_w0_bl u_t001_020/c3_w0_br
+ u_t001_020/c3_w1_bl u_t001_020/c3_w1_br u_t001_020/c3_r0_rbl u_t001_020/c3_r1_rbl
+ u_t001_020/r0_w0_wl u_t001_020/r0_w1_wl u_t001_020/r0_r0_rwl u_t001_020/r0_r1_rwl
+ u_t001_020/r1_w0_wl u_t001_020/r1_w1_wl u_t001_020/r1_r0_rwl u_t001_020/r1_r1_rwl
+ u_t001_020/r2_w0_wl u_t001_020/r2_w1_wl u_t001_020/r2_r0_rwl u_t001_020/r2_r1_rwl
+ u_t001_020/r3_w0_wl u_t001_020/r3_w1_wl u_t001_020/r3_r0_rwl u_t001_020/r3_r1_rwl
+ u_t001_020/VDD u_t001_031/VSS VSUBS detronyx_12t_2w2r_rc4_4x4_routed_5layer_direct
Xgf180mcu_as_sc_mcu7t3v3__inv_2_1700 gf180mcu_as_sc_mcu7t3v3__inv_2_990/VSS VSS gf180mcu_as_sc_mcu7t3v3__inv_2_1700/Y
+ VSS gf180mcu_as_sc_mcu7t3v3__inv_2_1700/VNW VSUBS gf180mcu_as_sc_mcu7t3v3__inv_2
Xgf180mcu_as_sc_mcu7t3v3__nand4_2_505 gf180mcu_as_sc_mcu7t3v3__inv_2_1671/VDD gf180mcu_as_sc_mcu7t3v3__inv_2_1672/VDD
+ VSS VSS VSS VSS VSS gf180mcu_as_sc_mcu7t3v3__inv_2_1671/VNW VSUBS gf180mcu_as_sc_mcu7t3v3__nand4_2
Xgf180mcu_as_sc_mcu7t3v3__inv_2_1007 VSS gf180mcu_as_sc_mcu7t3v3__inv_2_1011/VDD gf180mcu_as_sc_mcu7t3v3__inv_2_1007/Y
+ VSS gf180mcu_as_sc_mcu7t3v3__inv_2_1007/VNW VSUBS gf180mcu_as_sc_mcu7t3v3__inv_2
Xgf180mcu_as_sc_mcu7t3v3__inv_2_1018 VSS VSS gf180mcu_as_sc_mcu7t3v3__inv_2_1043/A
+ gf180mcu_as_sc_mcu7t3v3__inv_2_1019/Y gf180mcu_as_sc_mcu7t3v3__inv_2_1019/VNW VSUBS
+ gf180mcu_as_sc_mcu7t3v3__inv_2
Xgf180mcu_as_sc_mcu7t3v3__inv_2_1029 gf180mcu_as_sc_mcu7t3v3__inv_2_1030/VDD gf180mcu_as_sc_mcu7t3v3__inv_2_1034/VDD
+ gf180mcu_as_sc_mcu7t3v3__inv_2_1029/Y gf180mcu_as_sc_mcu7t3v3__inv_2_1030/Y gf180mcu_as_sc_mcu7t3v3__inv_2_1030/VNW
+ VSUBS gf180mcu_as_sc_mcu7t3v3__inv_2
Xgf180mcu_as_sc_mcu7t3v3__inv_2_37 gf180mcu_as_sc_mcu7t3v3__inv_2_62/VDD gf180mcu_as_sc_mcu7t3v3__inv_2_69/VSS
+ gf180mcu_as_sc_mcu7t3v3__inv_2_37/Y gf180mcu_as_sc_mcu7t3v3__inv_2_77/Y gf180mcu_as_sc_mcu7t3v3__inv_2_62/VNW
+ VSUBS gf180mcu_as_sc_mcu7t3v3__inv_2
Xgf180mcu_as_sc_mcu7t3v3__inv_2_15 gf180mcu_as_sc_mcu7t3v3__inv_2_69/VSS gf180mcu_as_sc_mcu7t3v3__inv_2_2/VDD
+ VSS gf180mcu_as_sc_mcu7t3v3__inv_2_2/A gf180mcu_as_sc_mcu7t3v3__inv_2_54/VNW VSUBS
+ gf180mcu_as_sc_mcu7t3v3__inv_2
Xgf180mcu_as_sc_mcu7t3v3__inv_2_59 gf180mcu_as_sc_mcu7t3v3__inv_2_77/VSS VSS gf180mcu_as_sc_mcu7t3v3__inv_2_77/Y
+ VSS gf180mcu_as_sc_mcu7t3v3__inv_2_59/VNW VSUBS gf180mcu_as_sc_mcu7t3v3__inv_2
Xgf180mcu_as_sc_mcu7t3v3__inv_2_26 gf180mcu_as_sc_mcu7t3v3__inv_2_75/VDD VSS gf180mcu_as_sc_mcu7t3v3__inv_2_77/Y
+ gf180mcu_as_sc_mcu7t3v3__inv_2_77/Y gf180mcu_as_sc_mcu7t3v3__inv_2_75/VNW VSUBS
+ gf180mcu_as_sc_mcu7t3v3__inv_2
Xgf180mcu_as_sc_mcu7t3v3__inv_2_48 gf180mcu_as_sc_mcu7t3v3__inv_2_66/VDD gf180mcu_as_sc_mcu7t3v3__inv_2_66/VSS
+ VSS gf180mcu_as_sc_mcu7t3v3__inv_2_66/Y gf180mcu_as_sc_mcu7t3v3__inv_2_66/VNW VSUBS
+ gf180mcu_as_sc_mcu7t3v3__inv_2
Xgf180mcu_as_sc_mcu7t3v3__inv_2_1563 gf180mcu_as_sc_mcu7t3v3__inv_2_1565/VDD gf180mcu_as_sc_mcu7t3v3__inv_2_1569/VDD
+ VSS VSS gf180mcu_as_sc_mcu7t3v3__inv_2_1565/VNW VSUBS gf180mcu_as_sc_mcu7t3v3__inv_2
Xgf180mcu_as_sc_mcu7t3v3__inv_2_1585 VSS gf180mcu_as_sc_mcu7t3v3__inv_2_1589/VDD VSS
+ VSS gf180mcu_as_sc_mcu7t3v3__inv_2_1585/VNW VSUBS gf180mcu_as_sc_mcu7t3v3__inv_2
Xgf180mcu_as_sc_mcu7t3v3__inv_2_1574 gf180mcu_as_sc_mcu7t3v3__inv_2_1586/VSS VSS gf180mcu_as_sc_mcu7t3v3__inv_2_1574/Y
+ VSS gf180mcu_as_sc_mcu7t3v3__inv_2_1574/VNW VSUBS gf180mcu_as_sc_mcu7t3v3__inv_2
Xgf180mcu_as_sc_mcu7t3v3__inv_2_1552 VSS gf180mcu_as_sc_mcu7t3v3__inv_2_1552/VSS gf180mcu_as_sc_mcu7t3v3__inv_2_1552/Y
+ VSS gf180mcu_as_sc_mcu7t3v3__inv_2_1552/VNW VSUBS gf180mcu_as_sc_mcu7t3v3__inv_2
Xgf180mcu_as_sc_mcu7t3v3__inv_2_1596 gf180mcu_as_sc_mcu7t3v3__inv_2_1667/VDD gf180mcu_as_sc_mcu7t3v3__inv_2_1667/VSS
+ VSS gf180mcu_as_sc_mcu7t3v3__inv_2_1682/Y gf180mcu_as_sc_mcu7t3v3__inv_2_1667/VNW
+ VSUBS gf180mcu_as_sc_mcu7t3v3__inv_2
Xgf180mcu_as_sc_mcu7t3v3__inv_2_1541 VSS VSS VSS VSS gf180mcu_as_sc_mcu7t3v3__inv_2_1543/VNW
+ VSUBS gf180mcu_as_sc_mcu7t3v3__inv_2
Xgf180mcu_as_sc_mcu7t3v3__inv_2_1530 VSS gf180mcu_as_sc_mcu7t3v3__inv_2_1532/VSS VSS
+ VSS gf180mcu_as_sc_mcu7t3v3__inv_2_1532/VNW VSUBS gf180mcu_as_sc_mcu7t3v3__inv_2
Xgf180mcu_as_sc_mcu7t3v3__nand3_2_7 gf180mcu_as_sc_mcu7t3v3__nor2_2_4/VDD gf180mcu_as_sc_mcu7t3v3__nor2_2_4/VSS
+ VSS VSS VSS VSS gf180mcu_as_sc_mcu7t3v3__nor2_2_4/VNW VSUBS gf180mcu_as_sc_mcu7t3v3__nand3_2
Xgf180mcu_as_sc_mcu7t3v3__nand4_2_335 gf180mcu_as_sc_mcu7t3v3__inv_2_1123/VDD gf180mcu_as_sc_mcu7t3v3__inv_2_1126/VDD
+ VSS VSS VSS VSS VSS gf180mcu_as_sc_mcu7t3v3__inv_2_1123/VNW VSUBS gf180mcu_as_sc_mcu7t3v3__nand4_2
Xgf180mcu_as_sc_mcu7t3v3__nand4_2_357 VSS VSS VSS VSS VSS VSS VSS gf180mcu_as_sc_mcu7t3v3__inv_2_1244/VNW
+ VSUBS gf180mcu_as_sc_mcu7t3v3__nand4_2
Xgf180mcu_as_sc_mcu7t3v3__nand4_2_346 VSS VSS VSS VSS VSS VSS VSS gf180mcu_as_sc_mcu7t3v3__inv_2_1120/VNW
+ VSUBS gf180mcu_as_sc_mcu7t3v3__nand4_2
Xgf180mcu_as_sc_mcu7t3v3__nand4_2_324 gf180mcu_as_sc_mcu7t3v3__inv_2_1084/VDD VSS
+ VSS VSS VSS VSS VSS gf180mcu_as_sc_mcu7t3v3__inv_2_1084/VNW VSUBS gf180mcu_as_sc_mcu7t3v3__nand4_2
Xgf180mcu_as_sc_mcu7t3v3__nand4_2_368 VSS VSS VSS VSS VSS VSS VSS gf180mcu_as_sc_mcu7t3v3__inv_2_1186/VNW
+ VSUBS gf180mcu_as_sc_mcu7t3v3__nand4_2
Xgf180mcu_as_sc_mcu7t3v3__nand4_2_379 VSS VSS VSS VSS VSS VSS VSS gf180mcu_as_sc_mcu7t3v3__inv_2_1298/VNW
+ VSUBS gf180mcu_as_sc_mcu7t3v3__nand4_2
Xgf180mcu_as_sc_mcu7t3v3__nand4_2_313 VSS VSS VSS VSS VSS VSS VSS gf180mcu_as_sc_mcu7t3v3__inv_2_1019/VNW
+ VSUBS gf180mcu_as_sc_mcu7t3v3__nand4_2
Xgf180mcu_as_sc_mcu7t3v3__nand4_2_302 VSS gf180mcu_as_sc_mcu7t3v3__inv_2_1030/VDD
+ VSS VSS VSS VSS VSS gf180mcu_as_sc_mcu7t3v3__inv_2_1026/VNW VSUBS gf180mcu_as_sc_mcu7t3v3__nand4_2
Xu_t029_023 u_t029_023/c0_w0_bl u_t029_023/c0_w0_br u_t029_023/c0_w1_bl u_t029_023/c0_w1_br
+ u_t029_023/c0_r0_rbl u_t029_023/c0_r1_rbl u_t029_023/c1_w0_bl u_t029_023/c1_w0_br
+ u_t029_023/c1_w1_bl u_t029_023/c1_w1_br u_t029_023/c1_r0_rbl u_t029_023/c1_r1_rbl
+ u_t029_023/c2_w0_bl u_t029_023/c2_w0_br u_t029_023/c2_w1_bl u_t029_023/c2_w1_br
+ u_t029_023/c2_r0_rbl u_t029_023/c2_r1_rbl u_t029_023/c3_w0_bl u_t029_023/c3_w0_br
+ u_t029_023/c3_w1_bl u_t029_023/c3_w1_br u_t029_023/c3_r0_rbl u_t029_023/c3_r1_rbl
+ u_t029_023/r0_w0_wl u_t029_023/r0_w1_wl u_t029_023/r0_r0_rwl u_t029_023/r0_r1_rwl
+ u_t029_023/r1_w0_wl u_t029_023/r1_w1_wl u_t029_023/r1_r0_rwl u_t029_023/r1_r1_rwl
+ u_t029_023/r2_w0_wl u_t029_023/r2_w1_wl u_t029_023/r2_r0_rwl u_t029_023/r2_r1_rwl
+ u_t029_023/r3_w0_wl u_t029_023/r3_w1_wl u_t029_023/r3_r0_rwl u_t029_023/r3_r1_rwl
+ VSS u_t029_031/VSS VSUBS detronyx_12t_2w2r_rc4_4x4_routed_5layer_direct
Xu_t029_012 u_t029_012/c0_w0_bl u_t029_012/c0_w0_br u_t029_012/c0_w1_bl u_t029_012/c0_w1_br
+ u_t029_012/c0_r0_rbl u_t029_012/c0_r1_rbl u_t029_012/c1_w0_bl u_t029_012/c1_w0_br
+ u_t029_012/c1_w1_bl u_t029_012/c1_w1_br u_t029_012/c1_r0_rbl u_t029_012/c1_r1_rbl
+ u_t029_012/c2_w0_bl u_t029_012/c2_w0_br u_t029_012/c2_w1_bl u_t029_012/c2_w1_br
+ u_t029_012/c2_r0_rbl u_t029_012/c2_r1_rbl u_t029_012/c3_w0_bl u_t029_012/c3_w0_br
+ u_t029_012/c3_w1_bl u_t029_012/c3_w1_br u_t029_012/c3_r0_rbl u_t029_012/c3_r1_rbl
+ u_t029_012/r0_w0_wl u_t029_012/r0_w1_wl u_t029_012/r0_r0_rwl u_t029_012/r0_r1_rwl
+ u_t029_012/r1_w0_wl u_t029_012/r1_w1_wl u_t029_012/r1_r0_rwl u_t029_012/r1_r1_rwl
+ u_t029_012/r2_w0_wl u_t029_012/r2_w1_wl u_t029_012/r2_r0_rwl u_t029_012/r2_r1_rwl
+ u_t029_012/r3_w0_wl u_t029_012/r3_w1_wl u_t029_012/r3_r0_rwl u_t029_012/r3_r1_rwl
+ u_t029_012/VDD u_t029_031/VSS VSUBS detronyx_12t_2w2r_rc4_4x4_routed_5layer_direct
Xu_t029_001 u_t029_001/c0_w0_bl u_t029_001/c0_w0_br u_t029_001/c0_w1_bl u_t029_001/c0_w1_br
+ u_t029_001/c0_r0_rbl u_t029_001/c0_r1_rbl u_t029_001/c1_w0_bl u_t029_001/c1_w0_br
+ u_t029_001/c1_w1_bl u_t029_001/c1_w1_br u_t029_001/c1_r0_rbl u_t029_001/c1_r1_rbl
+ u_t029_001/c2_w0_bl u_t029_001/c2_w0_br u_t029_001/c2_w1_bl u_t029_001/c2_w1_br
+ u_t029_001/c2_r0_rbl u_t029_001/c2_r1_rbl u_t029_001/c3_w0_bl u_t029_001/c3_w0_br
+ u_t029_001/c3_w1_bl u_t029_001/c3_w1_br u_t029_001/c3_r0_rbl u_t029_001/c3_r1_rbl
+ u_t029_001/r0_w0_wl u_t029_001/r0_w1_wl u_t029_001/r0_r0_rwl u_t029_001/r0_r1_rwl
+ u_t029_001/r1_w0_wl u_t029_001/r1_w1_wl u_t029_001/r1_r0_rwl u_t029_001/r1_r1_rwl
+ u_t029_001/r2_w0_wl u_t029_001/r2_w1_wl u_t029_001/r2_r0_rwl u_t029_001/r2_r1_rwl
+ u_t029_001/r3_w0_wl u_t029_001/r3_w1_wl u_t029_001/r3_r0_rwl u_t029_001/r3_r1_rwl
+ VSS u_t029_031/VSS VSUBS detronyx_12t_2w2r_rc4_4x4_routed_5layer_direct
Xgf180mcu_as_sc_mcu7t3v3__inv_2_1382 VSS gf180mcu_as_sc_mcu7t3v3__inv_2_1383/VDD gf180mcu_as_sc_mcu7t3v3__inv_2_1384/Y
+ VSS gf180mcu_as_sc_mcu7t3v3__inv_2_1382/VNW VSUBS gf180mcu_as_sc_mcu7t3v3__inv_2
Xgf180mcu_as_sc_mcu7t3v3__inv_2_1360 VSS VSS gf180mcu_as_sc_mcu7t3v3__inv_2_1387/Y
+ gf180mcu_as_sc_mcu7t3v3__inv_2_1387/Y gf180mcu_as_sc_mcu7t3v3__inv_2_1385/VNW VSUBS
+ gf180mcu_as_sc_mcu7t3v3__inv_2
Xgf180mcu_as_sc_mcu7t3v3__inv_2_1371 VSS gf180mcu_as_sc_mcu7t3v3__inv_2_1372/VDD gf180mcu_as_sc_mcu7t3v3__inv_2_1379/Y
+ VSS gf180mcu_as_sc_mcu7t3v3__inv_2_1371/VNW VSUBS gf180mcu_as_sc_mcu7t3v3__inv_2
Xgf180mcu_as_sc_mcu7t3v3__inv_2_1393 gf180mcu_as_sc_mcu7t3v3__inv_2_1393/VDD gf180mcu_as_sc_mcu7t3v3__inv_2_1394/VDD
+ gf180mcu_as_sc_mcu7t3v3__inv_2_1398/Y VSS gf180mcu_as_sc_mcu7t3v3__inv_2_1393/VNW
+ VSUBS gf180mcu_as_sc_mcu7t3v3__inv_2
Xgf180mcu_as_sc_mcu7t3v3__inv_2_844 VSS VSS gf180mcu_as_sc_mcu7t3v3__inv_2_844/Y VSS
+ gf180mcu_as_sc_mcu7t3v3__inv_2_846/VNW VSUBS gf180mcu_as_sc_mcu7t3v3__inv_2
Xgf180mcu_as_sc_mcu7t3v3__inv_2_833 VSS VSS gf180mcu_as_sc_mcu7t3v3__inv_2_833/Y VSS
+ gf180mcu_as_sc_mcu7t3v3__inv_2_833/VNW VSUBS gf180mcu_as_sc_mcu7t3v3__inv_2
Xgf180mcu_as_sc_mcu7t3v3__inv_2_811 VSS VSS VSS VSS gf180mcu_as_sc_mcu7t3v3__inv_2_812/VNW
+ VSUBS gf180mcu_as_sc_mcu7t3v3__inv_2
Xgf180mcu_as_sc_mcu7t3v3__inv_2_800 VSS VSS VSS VSS gf180mcu_as_sc_mcu7t3v3__inv_2_800/VNW
+ VSUBS gf180mcu_as_sc_mcu7t3v3__inv_2
Xgf180mcu_as_sc_mcu7t3v3__inv_2_822 VSS VSS gf180mcu_as_sc_mcu7t3v3__inv_2_822/Y VSS
+ gf180mcu_as_sc_mcu7t3v3__inv_2_824/VNW VSUBS gf180mcu_as_sc_mcu7t3v3__inv_2
Xgf180mcu_as_sc_mcu7t3v3__inv_2_888 VSS VSS VSS VSS gf180mcu_as_sc_mcu7t3v3__inv_2_888/VNW
+ VSUBS gf180mcu_as_sc_mcu7t3v3__inv_2
Xgf180mcu_as_sc_mcu7t3v3__inv_2_866 VSS VSS VSS VSS gf180mcu_as_sc_mcu7t3v3__inv_2_868/VNW
+ VSUBS gf180mcu_as_sc_mcu7t3v3__inv_2
Xgf180mcu_as_sc_mcu7t3v3__inv_2_855 VSS VSS VSS VSS gf180mcu_as_sc_mcu7t3v3__inv_2_856/VNW
+ VSUBS gf180mcu_as_sc_mcu7t3v3__inv_2
Xgf180mcu_as_sc_mcu7t3v3__inv_2_877 VSS VSS VSS VSS gf180mcu_as_sc_mcu7t3v3__inv_2_881/VNW
+ VSUBS gf180mcu_as_sc_mcu7t3v3__inv_2
Xgf180mcu_as_sc_mcu7t3v3__inv_2_899 VSS VSS VSS VSS gf180mcu_as_sc_mcu7t3v3__inv_2_900/VNW
+ VSUBS gf180mcu_as_sc_mcu7t3v3__inv_2
Xgf180mcu_as_sc_mcu7t3v3__nand4_2_110 VSS VSS VSS VSS VSS VSS VSS gf180mcu_as_sc_mcu7t3v3__inv_2_339/VNW
+ VSUBS gf180mcu_as_sc_mcu7t3v3__nand4_2
Xu_t026_026 u_t026_026/c0_w0_bl u_t026_026/c0_w0_br u_t026_026/c0_w1_bl u_t026_026/c0_w1_br
+ u_t026_026/c0_r0_rbl u_t026_026/c0_r1_rbl u_t026_026/c1_w0_bl u_t026_026/c1_w0_br
+ u_t026_026/c1_w1_bl u_t026_026/c1_w1_br u_t026_026/c1_r0_rbl u_t026_026/c1_r1_rbl
+ u_t026_026/c2_w0_bl u_t026_026/c2_w0_br u_t026_026/c2_w1_bl u_t026_026/c2_w1_br
+ u_t026_026/c2_r0_rbl u_t026_026/c2_r1_rbl u_t026_026/c3_w0_bl u_t026_026/c3_w0_br
+ u_t026_026/c3_w1_bl u_t026_026/c3_w1_br u_t026_026/c3_r0_rbl u_t026_026/c3_r1_rbl
+ u_t026_026/r0_w0_wl u_t026_026/r0_w1_wl u_t026_026/r0_r0_rwl u_t026_026/r0_r1_rwl
+ u_t026_026/r1_w0_wl u_t026_026/r1_w1_wl u_t026_026/r1_r0_rwl u_t026_026/r1_r1_rwl
+ u_t026_026/r2_w0_wl u_t026_026/r2_w1_wl u_t026_026/r2_r0_rwl u_t026_026/r2_r1_rwl
+ u_t026_026/r3_w0_wl u_t026_026/r3_w1_wl u_t026_026/r3_r0_rwl u_t026_026/r3_r1_rwl
+ u_t026_026/VDD u_t026_031/VSS VSUBS detronyx_12t_2w2r_rc4_4x4_routed_5layer_direct
Xu_t026_015 u_t026_015/c0_w0_bl u_t026_015/c0_w0_br u_t026_015/c0_w1_bl u_t026_015/c0_w1_br
+ u_t026_015/c0_r0_rbl u_t026_015/c0_r1_rbl u_t026_015/c1_w0_bl u_t026_015/c1_w0_br
+ u_t026_015/c1_w1_bl u_t026_015/c1_w1_br u_t026_015/c1_r0_rbl u_t026_015/c1_r1_rbl
+ u_t026_015/c2_w0_bl u_t026_015/c2_w0_br u_t026_015/c2_w1_bl u_t026_015/c2_w1_br
+ u_t026_015/c2_r0_rbl u_t026_015/c2_r1_rbl u_t026_015/c3_w0_bl u_t026_015/c3_w0_br
+ u_t026_015/c3_w1_bl u_t026_015/c3_w1_br u_t026_015/c3_r0_rbl u_t026_015/c3_r1_rbl
+ u_t026_015/r0_w0_wl u_t026_015/r0_w1_wl u_t026_015/r0_r0_rwl u_t026_015/r0_r1_rwl
+ u_t026_015/r1_w0_wl u_t026_015/r1_w1_wl u_t026_015/r1_r0_rwl u_t026_015/r1_r1_rwl
+ u_t026_015/r2_w0_wl u_t026_015/r2_w1_wl u_t026_015/r2_r0_rwl u_t026_015/r2_r1_rwl
+ u_t026_015/r3_w0_wl u_t026_015/r3_w1_wl u_t026_015/r3_r0_rwl u_t026_015/r3_r1_rwl
+ VSS u_t026_031/VSS VSUBS detronyx_12t_2w2r_rc4_4x4_routed_5layer_direct
Xu_t026_004 u_t026_004/c0_w0_bl u_t026_004/c0_w0_br u_t026_004/c0_w1_bl u_t026_004/c0_w1_br
+ u_t026_004/c0_r0_rbl u_t026_004/c0_r1_rbl u_t026_004/c1_w0_bl u_t026_004/c1_w0_br
+ u_t026_004/c1_w1_bl u_t026_004/c1_w1_br u_t026_004/c1_r0_rbl u_t026_004/c1_r1_rbl
+ u_t026_004/c2_w0_bl u_t026_004/c2_w0_br u_t026_004/c2_w1_bl u_t026_004/c2_w1_br
+ u_t026_004/c2_r0_rbl u_t026_004/c2_r1_rbl u_t026_004/c3_w0_bl u_t026_004/c3_w0_br
+ u_t026_004/c3_w1_bl u_t026_004/c3_w1_br u_t026_004/c3_r0_rbl u_t026_004/c3_r1_rbl
+ u_t026_004/r0_w0_wl u_t026_004/r0_w1_wl u_t026_004/r0_r0_rwl u_t026_004/r0_r1_rwl
+ u_t026_004/r1_w0_wl u_t026_004/r1_w1_wl u_t026_004/r1_r0_rwl u_t026_004/r1_r1_rwl
+ u_t026_004/r2_w0_wl u_t026_004/r2_w1_wl u_t026_004/r2_r0_rwl u_t026_004/r2_r1_rwl
+ u_t026_004/r3_w0_wl u_t026_004/r3_w1_wl u_t026_004/r3_r0_rwl u_t026_004/r3_r1_rwl
+ u_t026_004/VDD u_t026_031/VSS VSUBS detronyx_12t_2w2r_rc4_4x4_routed_5layer_direct
Xgf180mcu_as_sc_mcu7t3v3__nand4_2_154 gf180mcu_as_sc_mcu7t3v3__inv_2_572/VDD gf180mcu_as_sc_mcu7t3v3__inv_2_572/VDD
+ VSS VSS VSS VSS VSS gf180mcu_as_sc_mcu7t3v3__inv_2_569/VNW VSUBS gf180mcu_as_sc_mcu7t3v3__nand4_2
Xgf180mcu_as_sc_mcu7t3v3__nand4_2_132 VSS VSS VSS VSS VSS VSS VSS gf180mcu_as_sc_mcu7t3v3__inv_2_395/VNW
+ VSUBS gf180mcu_as_sc_mcu7t3v3__nand4_2
Xgf180mcu_as_sc_mcu7t3v3__nand4_2_143 VSS VSS VSS VSS VSS VSS gf180mcu_as_sc_mcu7t3v3__nand4_2_143/Y
+ gf180mcu_as_sc_mcu7t3v3__inv_2_510/VNW VSUBS gf180mcu_as_sc_mcu7t3v3__nand4_2
Xgf180mcu_as_sc_mcu7t3v3__nand4_2_165 gf180mcu_as_sc_mcu7t3v3__inv_2_620/VDD gf180mcu_as_sc_mcu7t3v3__inv_2_629/VDD
+ VSS VSS VSS VSS VSS gf180mcu_as_sc_mcu7t3v3__inv_2_620/VNW VSUBS gf180mcu_as_sc_mcu7t3v3__nand4_2
Xgf180mcu_as_sc_mcu7t3v3__nand4_2_176 gf180mcu_as_sc_mcu7t3v3__inv_2_849/VSS gf180mcu_as_sc_mcu7t3v3__inv_2_630/VDD
+ VSS VSS VSS VSS VSS gf180mcu_as_sc_mcu7t3v3__inv_2_617/VNW VSUBS gf180mcu_as_sc_mcu7t3v3__nand4_2
Xgf180mcu_as_sc_mcu7t3v3__nand4_2_198 gf180mcu_as_sc_mcu7t3v3__inv_2_671/VDD VSS VSS
+ VSS VSS VSS VSS gf180mcu_as_sc_mcu7t3v3__inv_2_671/VNW VSUBS gf180mcu_as_sc_mcu7t3v3__nand4_2
Xgf180mcu_as_sc_mcu7t3v3__nand4_2_60 gf180mcu_as_sc_mcu7t3v3__inv_2_188/VDD gf180mcu_as_sc_mcu7t3v3__inv_2_192/VDD
+ VSS VSS VSS VSS gf180mcu_as_sc_mcu7t3v3__nand4_2_60/Y gf180mcu_as_sc_mcu7t3v3__inv_2_188/VNW
+ VSUBS gf180mcu_as_sc_mcu7t3v3__nand4_2
Xgf180mcu_as_sc_mcu7t3v3__nand4_2_71 VSS gf180mcu_as_sc_mcu7t3v3__inv_2_260/VSS VSS
+ VSS VSS VSS gf180mcu_as_sc_mcu7t3v3__nand4_2_71/Y gf180mcu_as_sc_mcu7t3v3__inv_2_260/VNW
+ VSUBS gf180mcu_as_sc_mcu7t3v3__nand4_2
Xgf180mcu_as_sc_mcu7t3v3__nand4_2_121 VSS gf180mcu_as_sc_mcu7t3v3__inv_2_354/VDD VSS
+ VSS VSS VSS VSS gf180mcu_as_sc_mcu7t3v3__inv_2_348/VNW VSUBS gf180mcu_as_sc_mcu7t3v3__nand4_2
Xgf180mcu_as_sc_mcu7t3v3__nand4_2_187 gf180mcu_as_sc_mcu7t3v3__inv_2_723/VDD VSS VSS
+ VSS VSS VSS VSS gf180mcu_as_sc_mcu7t3v3__inv_2_723/VNW VSUBS gf180mcu_as_sc_mcu7t3v3__nand4_2
Xgf180mcu_as_sc_mcu7t3v3__nand4_2_93 VSS VSS VSS VSS VSS VSS VSS gf180mcu_as_sc_mcu7t3v3__inv_2_365/VNW
+ VSUBS gf180mcu_as_sc_mcu7t3v3__nand4_2
Xgf180mcu_as_sc_mcu7t3v3__nand4_2_82 gf180mcu_as_sc_mcu7t3v3__inv_2_241/VDD gf180mcu_as_sc_mcu7t3v3__inv_2_245/VDD
+ VSS VSS VSS VSS gf180mcu_as_sc_mcu7t3v3__nand4_2_82/Y gf180mcu_as_sc_mcu7t3v3__inv_2_241/VNW
+ VSUBS gf180mcu_as_sc_mcu7t3v3__nand4_2
Xu_t017_026 u_t017_026/c0_w0_bl u_t017_026/c0_w0_br u_t017_026/c0_w1_bl u_t017_026/c0_w1_br
+ u_t017_026/c0_r0_rbl u_t017_026/c0_r1_rbl u_t017_026/c1_w0_bl u_t017_026/c1_w0_br
+ u_t017_026/c1_w1_bl u_t017_026/c1_w1_br u_t017_026/c1_r0_rbl u_t017_026/c1_r1_rbl
+ u_t017_026/c2_w0_bl u_t017_026/c2_w0_br u_t017_026/c2_w1_bl u_t017_026/c2_w1_br
+ u_t017_026/c2_r0_rbl u_t017_026/c2_r1_rbl u_t017_026/c3_w0_bl u_t017_026/c3_w0_br
+ u_t017_026/c3_w1_bl u_t017_026/c3_w1_br u_t017_026/c3_r0_rbl u_t017_026/c3_r1_rbl
+ u_t017_026/r0_w0_wl u_t017_026/r0_w1_wl u_t017_026/r0_r0_rwl u_t017_026/r0_r1_rwl
+ u_t017_026/r1_w0_wl u_t017_026/r1_w1_wl u_t017_026/r1_r0_rwl u_t017_026/r1_r1_rwl
+ u_t017_026/r2_w0_wl u_t017_026/r2_w1_wl u_t017_026/r2_r0_rwl u_t017_026/r2_r1_rwl
+ u_t017_026/r3_w0_wl u_t017_026/r3_w1_wl u_t017_026/r3_r0_rwl u_t017_026/r3_r1_rwl
+ u_t017_026/VDD u_t017_031/VSS VSUBS detronyx_12t_2w2r_rc4_4x4_routed_5layer_direct
Xu_t017_015 u_t017_015/c0_w0_bl u_t017_015/c0_w0_br u_t017_015/c0_w1_bl u_t017_015/c0_w1_br
+ u_t017_015/c0_r0_rbl u_t017_015/c0_r1_rbl u_t017_015/c1_w0_bl u_t017_015/c1_w0_br
+ u_t017_015/c1_w1_bl u_t017_015/c1_w1_br u_t017_015/c1_r0_rbl u_t017_015/c1_r1_rbl
+ u_t017_015/c2_w0_bl u_t017_015/c2_w0_br u_t017_015/c2_w1_bl u_t017_015/c2_w1_br
+ u_t017_015/c2_r0_rbl u_t017_015/c2_r1_rbl u_t017_015/c3_w0_bl u_t017_015/c3_w0_br
+ u_t017_015/c3_w1_bl u_t017_015/c3_w1_br u_t017_015/c3_r0_rbl u_t017_015/c3_r1_rbl
+ u_t017_015/r0_w0_wl u_t017_015/r0_w1_wl u_t017_015/r0_r0_rwl u_t017_015/r0_r1_rwl
+ u_t017_015/r1_w0_wl u_t017_015/r1_w1_wl u_t017_015/r1_r0_rwl u_t017_015/r1_r1_rwl
+ u_t017_015/r2_w0_wl u_t017_015/r2_w1_wl u_t017_015/r2_r0_rwl u_t017_015/r2_r1_rwl
+ u_t017_015/r3_w0_wl u_t017_015/r3_w1_wl u_t017_015/r3_r0_rwl u_t017_015/r3_r1_rwl
+ VSS u_t017_031/VSS VSUBS detronyx_12t_2w2r_rc4_4x4_routed_5layer_direct
Xu_t017_004 u_t017_004/c0_w0_bl u_t017_004/c0_w0_br u_t017_004/c0_w1_bl u_t017_004/c0_w1_br
+ u_t017_004/c0_r0_rbl u_t017_004/c0_r1_rbl u_t017_004/c1_w0_bl u_t017_004/c1_w0_br
+ u_t017_004/c1_w1_bl u_t017_004/c1_w1_br u_t017_004/c1_r0_rbl u_t017_004/c1_r1_rbl
+ u_t017_004/c2_w0_bl u_t017_004/c2_w0_br u_t017_004/c2_w1_bl u_t017_004/c2_w1_br
+ u_t017_004/c2_r0_rbl u_t017_004/c2_r1_rbl u_t017_004/c3_w0_bl u_t017_004/c3_w0_br
+ u_t017_004/c3_w1_bl u_t017_004/c3_w1_br u_t017_004/c3_r0_rbl u_t017_004/c3_r1_rbl
+ u_t017_004/r0_w0_wl u_t017_004/r0_w1_wl u_t017_004/r0_r0_rwl u_t017_004/r0_r1_rwl
+ u_t017_004/r1_w0_wl u_t017_004/r1_w1_wl u_t017_004/r1_r0_rwl u_t017_004/r1_r1_rwl
+ u_t017_004/r2_w0_wl u_t017_004/r2_w1_wl u_t017_004/r2_r0_rwl u_t017_004/r2_r1_rwl
+ u_t017_004/r3_w0_wl u_t017_004/r3_w1_wl u_t017_004/r3_r0_rwl u_t017_004/r3_r1_rwl
+ u_t017_004/VDD u_t017_031/VSS VSUBS detronyx_12t_2w2r_rc4_4x4_routed_5layer_direct
Xgf180mcu_as_sc_mcu7t3v3__inv_2_129 VSS gf180mcu_as_sc_mcu7t3v3__inv_2_134/VDD VSS
+ VSS gf180mcu_as_sc_mcu7t3v3__inv_2_130/VNW VSUBS gf180mcu_as_sc_mcu7t3v3__inv_2
Xgf180mcu_as_sc_mcu7t3v3__inv_2_107 gf180mcu_as_sc_mcu7t3v3__inv_2_152/VSS gf180mcu_as_sc_mcu7t3v3__inv_2_151/VDD
+ VSS VSS gf180mcu_as_sc_mcu7t3v3__inv_2_135/VNW VSUBS gf180mcu_as_sc_mcu7t3v3__inv_2
Xgf180mcu_as_sc_mcu7t3v3__inv_2_118 gf180mcu_as_sc_mcu7t3v3__inv_2_119/VDD gf180mcu_as_sc_mcu7t3v3__inv_2_152/VSS
+ gf180mcu_as_sc_mcu7t3v3__inv_2_118/Y VSS gf180mcu_as_sc_mcu7t3v3__inv_2_119/VNW
+ VSUBS gf180mcu_as_sc_mcu7t3v3__inv_2
Xgf180mcu_as_sc_mcu7t3v3__inv_2_1190 VSS VSS gf180mcu_as_sc_mcu7t3v3__inv_2_1190/Y
+ VSS gf180mcu_as_sc_mcu7t3v3__inv_2_1190/VNW VSUBS gf180mcu_as_sc_mcu7t3v3__inv_2
Xu_t008_026 u_t008_026/c0_w0_bl u_t008_026/c0_w0_br u_t008_026/c0_w1_bl u_t008_026/c0_w1_br
+ u_t008_026/c0_r0_rbl u_t008_026/c0_r1_rbl u_t008_026/c1_w0_bl u_t008_026/c1_w0_br
+ u_t008_026/c1_w1_bl u_t008_026/c1_w1_br u_t008_026/c1_r0_rbl u_t008_026/c1_r1_rbl
+ u_t008_026/c2_w0_bl u_t008_026/c2_w0_br u_t008_026/c2_w1_bl u_t008_026/c2_w1_br
+ u_t008_026/c2_r0_rbl u_t008_026/c2_r1_rbl u_t008_026/c3_w0_bl u_t008_026/c3_w0_br
+ u_t008_026/c3_w1_bl u_t008_026/c3_w1_br u_t008_026/c3_r0_rbl u_t008_026/c3_r1_rbl
+ u_t008_026/r0_w0_wl u_t008_026/r0_w1_wl u_t008_026/r0_r0_rwl u_t008_026/r0_r1_rwl
+ u_t008_026/r1_w0_wl u_t008_026/r1_w1_wl u_t008_026/r1_r0_rwl u_t008_026/r1_r1_rwl
+ u_t008_026/r2_w0_wl u_t008_026/r2_w1_wl u_t008_026/r2_r0_rwl u_t008_026/r2_r1_rwl
+ u_t008_026/r3_w0_wl u_t008_026/r3_w1_wl u_t008_026/r3_r0_rwl u_t008_026/r3_r1_rwl
+ u_t008_026/VDD u_t008_031/VSS VSUBS detronyx_12t_2w2r_rc4_4x4_routed_5layer_direct
Xu_t008_015 u_t008_015/c0_w0_bl u_t008_015/c0_w0_br u_t008_015/c0_w1_bl u_t008_015/c0_w1_br
+ u_t008_015/c0_r0_rbl u_t008_015/c0_r1_rbl u_t008_015/c1_w0_bl u_t008_015/c1_w0_br
+ u_t008_015/c1_w1_bl u_t008_015/c1_w1_br u_t008_015/c1_r0_rbl u_t008_015/c1_r1_rbl
+ u_t008_015/c2_w0_bl u_t008_015/c2_w0_br u_t008_015/c2_w1_bl u_t008_015/c2_w1_br
+ u_t008_015/c2_r0_rbl u_t008_015/c2_r1_rbl u_t008_015/c3_w0_bl u_t008_015/c3_w0_br
+ u_t008_015/c3_w1_bl u_t008_015/c3_w1_br u_t008_015/c3_r0_rbl u_t008_015/c3_r1_rbl
+ u_t008_015/r0_w0_wl u_t008_015/r0_w1_wl u_t008_015/r0_r0_rwl u_t008_015/r0_r1_rwl
+ u_t008_015/r1_w0_wl u_t008_015/r1_w1_wl u_t008_015/r1_r0_rwl u_t008_015/r1_r1_rwl
+ u_t008_015/r2_w0_wl u_t008_015/r2_w1_wl u_t008_015/r2_r0_rwl u_t008_015/r2_r1_rwl
+ u_t008_015/r3_w0_wl u_t008_015/r3_w1_wl u_t008_015/r3_r0_rwl u_t008_015/r3_r1_rwl
+ VSS u_t008_031/VSS VSUBS detronyx_12t_2w2r_rc4_4x4_routed_5layer_direct
Xu_t008_004 u_t008_004/c0_w0_bl u_t008_004/c0_w0_br u_t008_004/c0_w1_bl u_t008_004/c0_w1_br
+ u_t008_004/c0_r0_rbl u_t008_004/c0_r1_rbl u_t008_004/c1_w0_bl u_t008_004/c1_w0_br
+ u_t008_004/c1_w1_bl u_t008_004/c1_w1_br u_t008_004/c1_r0_rbl u_t008_004/c1_r1_rbl
+ u_t008_004/c2_w0_bl u_t008_004/c2_w0_br u_t008_004/c2_w1_bl u_t008_004/c2_w1_br
+ u_t008_004/c2_r0_rbl u_t008_004/c2_r1_rbl u_t008_004/c3_w0_bl u_t008_004/c3_w0_br
+ u_t008_004/c3_w1_bl u_t008_004/c3_w1_br u_t008_004/c3_r0_rbl u_t008_004/c3_r1_rbl
+ u_t008_004/r0_w0_wl u_t008_004/r0_w1_wl u_t008_004/r0_r0_rwl u_t008_004/r0_r1_rwl
+ u_t008_004/r1_w0_wl u_t008_004/r1_w1_wl u_t008_004/r1_r0_rwl u_t008_004/r1_r1_rwl
+ u_t008_004/r2_w0_wl u_t008_004/r2_w1_wl u_t008_004/r2_r0_rwl u_t008_004/r2_r1_rwl
+ u_t008_004/r3_w0_wl u_t008_004/r3_w1_wl u_t008_004/r3_r0_rwl u_t008_004/r3_r1_rwl
+ u_t008_004/VDD u_t008_031/VSS VSUBS detronyx_12t_2w2r_rc4_4x4_routed_5layer_direct
Xu_t023_029 u_t023_029/c0_w0_bl u_t023_029/c0_w0_br u_t023_029/c0_w1_bl u_t023_029/c0_w1_br
+ u_t023_029/c0_r0_rbl u_t023_029/c0_r1_rbl u_t023_029/c1_w0_bl u_t023_029/c1_w0_br
+ u_t023_029/c1_w1_bl u_t023_029/c1_w1_br u_t023_029/c1_r0_rbl u_t023_029/c1_r1_rbl
+ u_t023_029/c2_w0_bl u_t023_029/c2_w0_br u_t023_029/c2_w1_bl u_t023_029/c2_w1_br
+ u_t023_029/c2_r0_rbl u_t023_029/c2_r1_rbl u_t023_029/c3_w0_bl u_t023_029/c3_w0_br
+ u_t023_029/c3_w1_bl u_t023_029/c3_w1_br u_t023_029/c3_r0_rbl u_t023_029/c3_r1_rbl
+ u_t023_029/r0_w0_wl u_t023_029/r0_w1_wl u_t023_029/r0_r0_rwl u_t023_029/r0_r1_rwl
+ u_t023_029/r1_w0_wl u_t023_029/r1_w1_wl u_t023_029/r1_r0_rwl u_t023_029/r1_r1_rwl
+ u_t023_029/r2_w0_wl u_t023_029/r2_w1_wl u_t023_029/r2_r0_rwl u_t023_029/r2_r1_rwl
+ u_t023_029/r3_w0_wl u_t023_029/r3_w1_wl u_t023_029/r3_r0_rwl u_t023_029/r3_r1_rwl
+ u_t023_029/VDD u_t023_031/VSS VSUBS detronyx_12t_2w2r_rc4_4x4_routed_5layer_direct
Xu_t023_018 u_t023_018/c0_w0_bl u_t023_018/c0_w0_br u_t023_018/c0_w1_bl u_t023_018/c0_w1_br
+ u_t023_018/c0_r0_rbl u_t023_018/c0_r1_rbl u_t023_018/c1_w0_bl u_t023_018/c1_w0_br
+ u_t023_018/c1_w1_bl u_t023_018/c1_w1_br u_t023_018/c1_r0_rbl u_t023_018/c1_r1_rbl
+ u_t023_018/c2_w0_bl u_t023_018/c2_w0_br u_t023_018/c2_w1_bl u_t023_018/c2_w1_br
+ u_t023_018/c2_r0_rbl u_t023_018/c2_r1_rbl u_t023_018/c3_w0_bl u_t023_018/c3_w0_br
+ u_t023_018/c3_w1_bl u_t023_018/c3_w1_br u_t023_018/c3_r0_rbl u_t023_018/c3_r1_rbl
+ u_t023_018/r0_w0_wl u_t023_018/r0_w1_wl u_t023_018/r0_r0_rwl u_t023_018/r0_r1_rwl
+ u_t023_018/r1_w0_wl u_t023_018/r1_w1_wl u_t023_018/r1_r0_rwl u_t023_018/r1_r1_rwl
+ u_t023_018/r2_w0_wl u_t023_018/r2_w1_wl u_t023_018/r2_r0_rwl u_t023_018/r2_r1_rwl
+ u_t023_018/r3_w0_wl u_t023_018/r3_w1_wl u_t023_018/r3_r0_rwl u_t023_018/r3_r1_rwl
+ u_t023_018/VDD u_t023_018/VSS VSUBS detronyx_12t_2w2r_rc4_4x4_routed_5layer_direct
Xu_t023_007 u_t023_007/c0_w0_bl u_t023_007/c0_w0_br u_t023_007/c0_w1_bl u_t023_007/c0_w1_br
+ u_t023_007/c0_r0_rbl u_t023_007/c0_r1_rbl u_t023_007/c1_w0_bl u_t023_007/c1_w0_br
+ u_t023_007/c1_w1_bl u_t023_007/c1_w1_br u_t023_007/c1_r0_rbl u_t023_007/c1_r1_rbl
+ u_t023_007/c2_w0_bl u_t023_007/c2_w0_br u_t023_007/c2_w1_bl u_t023_007/c2_w1_br
+ u_t023_007/c2_r0_rbl u_t023_007/c2_r1_rbl u_t023_007/c3_w0_bl u_t023_007/c3_w0_br
+ u_t023_007/c3_w1_bl u_t023_007/c3_w1_br u_t023_007/c3_r0_rbl u_t023_007/c3_r1_rbl
+ u_t023_007/r0_w0_wl u_t023_007/r0_w1_wl u_t023_007/r0_r0_rwl u_t023_007/r0_r1_rwl
+ u_t023_007/r1_w0_wl u_t023_007/r1_w1_wl u_t023_007/r1_r0_rwl u_t023_007/r1_r1_rwl
+ u_t023_007/r2_w0_wl u_t023_007/r2_w1_wl u_t023_007/r2_r0_rwl u_t023_007/r2_r1_rwl
+ u_t023_007/r3_w0_wl u_t023_007/r3_w1_wl u_t023_007/r3_r0_rwl u_t023_007/r3_r1_rwl
+ VSS u_t023_009/VSS VSUBS detronyx_12t_2w2r_rc4_4x4_routed_5layer_direct
Xgf180mcu_as_sc_mcu7t3v3__inv_2_630 gf180mcu_as_sc_mcu7t3v3__inv_2_630/VDD gf180mcu_as_sc_mcu7t3v3__inv_2_630/VSS
+ gf180mcu_as_sc_mcu7t3v3__inv_2_630/Y gf180mcu_as_sc_mcu7t3v3__inv_2_848/Y gf180mcu_as_sc_mcu7t3v3__inv_2_630/VNW
+ VSUBS gf180mcu_as_sc_mcu7t3v3__inv_2
Xgf180mcu_as_sc_mcu7t3v3__inv_2_674 VSS gf180mcu_as_sc_mcu7t3v3__inv_2_679/VDD gf180mcu_as_sc_mcu7t3v3__inv_2_848/Y
+ gf180mcu_as_sc_mcu7t3v3__inv_2_675/Y gf180mcu_as_sc_mcu7t3v3__inv_2_675/VNW VSUBS
+ gf180mcu_as_sc_mcu7t3v3__inv_2
Xgf180mcu_as_sc_mcu7t3v3__inv_2_652 gf180mcu_as_sc_mcu7t3v3__inv_2_684/VSS VSS gf180mcu_as_sc_mcu7t3v3__inv_2_652/Y
+ gf180mcu_as_sc_mcu7t3v3__inv_2_684/A gf180mcu_as_sc_mcu7t3v3__inv_2_660/VNW VSUBS
+ gf180mcu_as_sc_mcu7t3v3__inv_2
Xgf180mcu_as_sc_mcu7t3v3__inv_2_663 gf180mcu_as_sc_mcu7t3v3__inv_2_663/VDD VSS gf180mcu_as_sc_mcu7t3v3__inv_2_663/Y
+ VSS gf180mcu_as_sc_mcu7t3v3__inv_2_663/VNW VSUBS gf180mcu_as_sc_mcu7t3v3__inv_2
Xgf180mcu_as_sc_mcu7t3v3__inv_2_641 VSS gf180mcu_as_sc_mcu7t3v3__inv_2_647/VDD gf180mcu_as_sc_mcu7t3v3__inv_2_641/Y
+ gf180mcu_as_sc_mcu7t3v3__inv_2_739/A gf180mcu_as_sc_mcu7t3v3__inv_2_643/VNW VSUBS
+ gf180mcu_as_sc_mcu7t3v3__inv_2
Xgf180mcu_as_sc_mcu7t3v3__inv_2_685 gf180mcu_as_sc_mcu7t3v3__inv_2_687/VDD VSS gf180mcu_as_sc_mcu7t3v3__inv_2_685/Y
+ gf180mcu_as_sc_mcu7t3v3__inv_2_739/A gf180mcu_as_sc_mcu7t3v3__inv_2_687/VNW VSUBS
+ gf180mcu_as_sc_mcu7t3v3__inv_2
Xgf180mcu_as_sc_mcu7t3v3__inv_2_696 gf180mcu_as_sc_mcu7t3v3__inv_2_738/VSS VSS gf180mcu_as_sc_mcu7t3v3__inv_2_696/Y
+ gf180mcu_as_sc_mcu7t3v3__inv_2_737/A gf180mcu_as_sc_mcu7t3v3__inv_2_704/VNW VSUBS
+ gf180mcu_as_sc_mcu7t3v3__inv_2
Xu_t014_029 u_t014_029/c0_w0_bl u_t014_029/c0_w0_br u_t014_029/c0_w1_bl u_t014_029/c0_w1_br
+ u_t014_029/c0_r0_rbl u_t014_029/c0_r1_rbl u_t014_029/c1_w0_bl u_t014_029/c1_w0_br
+ u_t014_029/c1_w1_bl u_t014_029/c1_w1_br u_t014_029/c1_r0_rbl u_t014_029/c1_r1_rbl
+ u_t014_029/c2_w0_bl u_t014_029/c2_w0_br u_t014_029/c2_w1_bl u_t014_029/c2_w1_br
+ u_t014_029/c2_r0_rbl u_t014_029/c2_r1_rbl u_t014_029/c3_w0_bl u_t014_029/c3_w0_br
+ u_t014_029/c3_w1_bl u_t014_029/c3_w1_br u_t014_029/c3_r0_rbl u_t014_029/c3_r1_rbl
+ u_t014_029/r0_w0_wl u_t014_029/r0_w1_wl u_t014_029/r0_r0_rwl u_t014_029/r0_r1_rwl
+ u_t014_029/r1_w0_wl u_t014_029/r1_w1_wl u_t014_029/r1_r0_rwl u_t014_029/r1_r1_rwl
+ u_t014_029/r2_w0_wl u_t014_029/r2_w1_wl u_t014_029/r2_r0_rwl u_t014_029/r2_r1_rwl
+ u_t014_029/r3_w0_wl u_t014_029/r3_w1_wl u_t014_029/r3_r0_rwl u_t014_029/r3_r1_rwl
+ u_t014_029/VDD u_t014_031/VSS VSUBS detronyx_12t_2w2r_rc4_4x4_routed_5layer_direct
Xu_t014_018 u_t014_018/c0_w0_bl u_t014_018/c0_w0_br u_t014_018/c0_w1_bl u_t014_018/c0_w1_br
+ u_t014_018/c0_r0_rbl u_t014_018/c0_r1_rbl u_t014_018/c1_w0_bl u_t014_018/c1_w0_br
+ u_t014_018/c1_w1_bl u_t014_018/c1_w1_br u_t014_018/c1_r0_rbl u_t014_018/c1_r1_rbl
+ u_t014_018/c2_w0_bl u_t014_018/c2_w0_br u_t014_018/c2_w1_bl u_t014_018/c2_w1_br
+ u_t014_018/c2_r0_rbl u_t014_018/c2_r1_rbl u_t014_018/c3_w0_bl u_t014_018/c3_w0_br
+ u_t014_018/c3_w1_bl u_t014_018/c3_w1_br u_t014_018/c3_r0_rbl u_t014_018/c3_r1_rbl
+ u_t014_018/r0_w0_wl u_t014_018/r0_w1_wl u_t014_018/r0_r0_rwl u_t014_018/r0_r1_rwl
+ u_t014_018/r1_w0_wl u_t014_018/r1_w1_wl u_t014_018/r1_r0_rwl u_t014_018/r1_r1_rwl
+ u_t014_018/r2_w0_wl u_t014_018/r2_w1_wl u_t014_018/r2_r0_rwl u_t014_018/r2_r1_rwl
+ u_t014_018/r3_w0_wl u_t014_018/r3_w1_wl u_t014_018/r3_r0_rwl u_t014_018/r3_r1_rwl
+ u_t014_018/VDD u_t014_018/VSS VSUBS detronyx_12t_2w2r_rc4_4x4_routed_5layer_direct
Xu_t014_007 u_t014_007/c0_w0_bl u_t014_007/c0_w0_br u_t014_007/c0_w1_bl u_t014_007/c0_w1_br
+ u_t014_007/c0_r0_rbl u_t014_007/c0_r1_rbl u_t014_007/c1_w0_bl u_t014_007/c1_w0_br
+ u_t014_007/c1_w1_bl u_t014_007/c1_w1_br u_t014_007/c1_r0_rbl u_t014_007/c1_r1_rbl
+ u_t014_007/c2_w0_bl u_t014_007/c2_w0_br u_t014_007/c2_w1_bl u_t014_007/c2_w1_br
+ u_t014_007/c2_r0_rbl u_t014_007/c2_r1_rbl u_t014_007/c3_w0_bl u_t014_007/c3_w0_br
+ u_t014_007/c3_w1_bl u_t014_007/c3_w1_br u_t014_007/c3_r0_rbl u_t014_007/c3_r1_rbl
+ u_t014_007/r0_w0_wl u_t014_007/r0_w1_wl u_t014_007/r0_r0_rwl u_t014_007/r0_r1_rwl
+ u_t014_007/r1_w0_wl u_t014_007/r1_w1_wl u_t014_007/r1_r0_rwl u_t014_007/r1_r1_rwl
+ u_t014_007/r2_w0_wl u_t014_007/r2_w1_wl u_t014_007/r2_r0_rwl u_t014_007/r2_r1_rwl
+ u_t014_007/r3_w0_wl u_t014_007/r3_w1_wl u_t014_007/r3_r0_rwl u_t014_007/r3_r1_rwl
+ VSS u_t014_009/VSS VSUBS detronyx_12t_2w2r_rc4_4x4_routed_5layer_direct
Xgf180mcu_as_sc_mcu7t3v3__nand2_2_19 gf180mcu_as_sc_mcu7t3v3__nor2_2_4/VDD gf180mcu_as_sc_mcu7t3v3__nand3_2_8/VSS
+ VSS VSS VSS gf180mcu_as_sc_mcu7t3v3__nor2_2_4/VNW VSUBS gf180mcu_as_sc_mcu7t3v3__nand2_2
Xu_t005_029 u_t005_029/c0_w0_bl u_t005_029/c0_w0_br u_t005_029/c0_w1_bl u_t005_029/c0_w1_br
+ u_t005_029/c0_r0_rbl u_t005_029/c0_r1_rbl u_t005_029/c1_w0_bl u_t005_029/c1_w0_br
+ u_t005_029/c1_w1_bl u_t005_029/c1_w1_br u_t005_029/c1_r0_rbl u_t005_029/c1_r1_rbl
+ u_t005_029/c2_w0_bl u_t005_029/c2_w0_br u_t005_029/c2_w1_bl u_t005_029/c2_w1_br
+ u_t005_029/c2_r0_rbl u_t005_029/c2_r1_rbl u_t005_029/c3_w0_bl u_t005_029/c3_w0_br
+ u_t005_029/c3_w1_bl u_t005_029/c3_w1_br u_t005_029/c3_r0_rbl u_t005_029/c3_r1_rbl
+ u_t005_029/r0_w0_wl u_t005_029/r0_w1_wl u_t005_029/r0_r0_rwl u_t005_029/r0_r1_rwl
+ u_t005_029/r1_w0_wl u_t005_029/r1_w1_wl u_t005_029/r1_r0_rwl u_t005_029/r1_r1_rwl
+ u_t005_029/r2_w0_wl u_t005_029/r2_w1_wl u_t005_029/r2_r0_rwl u_t005_029/r2_r1_rwl
+ u_t005_029/r3_w0_wl u_t005_029/r3_w1_wl u_t005_029/r3_r0_rwl u_t005_029/r3_r1_rwl
+ u_t005_029/VDD u_t005_031/VSS VSUBS detronyx_12t_2w2r_rc4_4x4_routed_5layer_direct
Xu_t005_018 u_t005_018/c0_w0_bl u_t005_018/c0_w0_br u_t005_018/c0_w1_bl u_t005_018/c0_w1_br
+ u_t005_018/c0_r0_rbl u_t005_018/c0_r1_rbl u_t005_018/c1_w0_bl u_t005_018/c1_w0_br
+ u_t005_018/c1_w1_bl u_t005_018/c1_w1_br u_t005_018/c1_r0_rbl u_t005_018/c1_r1_rbl
+ u_t005_018/c2_w0_bl u_t005_018/c2_w0_br u_t005_018/c2_w1_bl u_t005_018/c2_w1_br
+ u_t005_018/c2_r0_rbl u_t005_018/c2_r1_rbl u_t005_018/c3_w0_bl u_t005_018/c3_w0_br
+ u_t005_018/c3_w1_bl u_t005_018/c3_w1_br u_t005_018/c3_r0_rbl u_t005_018/c3_r1_rbl
+ u_t005_018/r0_w0_wl u_t005_018/r0_w1_wl u_t005_018/r0_r0_rwl u_t005_018/r0_r1_rwl
+ u_t005_018/r1_w0_wl u_t005_018/r1_w1_wl u_t005_018/r1_r0_rwl u_t005_018/r1_r1_rwl
+ u_t005_018/r2_w0_wl u_t005_018/r2_w1_wl u_t005_018/r2_r0_rwl u_t005_018/r2_r1_rwl
+ u_t005_018/r3_w0_wl u_t005_018/r3_w1_wl u_t005_018/r3_r0_rwl u_t005_018/r3_r1_rwl
+ u_t005_018/VDD u_t005_031/VSS VSUBS detronyx_12t_2w2r_rc4_4x4_routed_5layer_direct
Xu_t005_007 u_t005_007/c0_w0_bl u_t005_007/c0_w0_br u_t005_007/c0_w1_bl u_t005_007/c0_w1_br
+ u_t005_007/c0_r0_rbl u_t005_007/c0_r1_rbl u_t005_007/c1_w0_bl u_t005_007/c1_w0_br
+ u_t005_007/c1_w1_bl u_t005_007/c1_w1_br u_t005_007/c1_r0_rbl u_t005_007/c1_r1_rbl
+ u_t005_007/c2_w0_bl u_t005_007/c2_w0_br u_t005_007/c2_w1_bl u_t005_007/c2_w1_br
+ u_t005_007/c2_r0_rbl u_t005_007/c2_r1_rbl u_t005_007/c3_w0_bl u_t005_007/c3_w0_br
+ u_t005_007/c3_w1_bl u_t005_007/c3_w1_br u_t005_007/c3_r0_rbl u_t005_007/c3_r1_rbl
+ u_t005_007/r0_w0_wl u_t005_007/r0_w1_wl u_t005_007/r0_r0_rwl u_t005_007/r0_r1_rwl
+ u_t005_007/r1_w0_wl u_t005_007/r1_w1_wl u_t005_007/r1_r0_rwl u_t005_007/r1_r1_rwl
+ u_t005_007/r2_w0_wl u_t005_007/r2_w1_wl u_t005_007/r2_r0_rwl u_t005_007/r2_r1_rwl
+ u_t005_007/r3_w0_wl u_t005_007/r3_w1_wl u_t005_007/r3_r0_rwl u_t005_007/r3_r1_rwl
+ VSS u_t005_031/VSS VSUBS detronyx_12t_2w2r_rc4_4x4_routed_5layer_direct
Xgf180mcu_as_sc_mcu7t3v3__inv_2_471 gf180mcu_as_sc_mcu7t3v3__nor2_2_5/VDD gf180mcu_as_sc_mcu7t3v3__nor2_2_5/VSS
+ gf180mcu_as_sc_mcu7t3v3__inv_2_471/Y VSS gf180mcu_as_sc_mcu7t3v3__nor2_2_5/VNW VSUBS
+ gf180mcu_as_sc_mcu7t3v3__inv_2
Xgf180mcu_as_sc_mcu7t3v3__inv_2_482 gf180mcu_as_sc_mcu7t3v3__nor2_2_5/VDD gf180mcu_as_sc_mcu7t3v3__nor2_2_5/VSS
+ VSS VSS gf180mcu_as_sc_mcu7t3v3__nor2_2_5/VNW VSUBS gf180mcu_as_sc_mcu7t3v3__inv_2
Xgf180mcu_as_sc_mcu7t3v3__inv_2_460 gf180mcu_as_sc_mcu7t3v3__nor2_2_5/VDD gf180mcu_as_sc_mcu7t3v3__nor2_2_5/VSS
+ VSS VSS gf180mcu_as_sc_mcu7t3v3__nor2_2_5/VNW VSUBS gf180mcu_as_sc_mcu7t3v3__inv_2
Xgf180mcu_as_sc_mcu7t3v3__inv_2_493 gf180mcu_as_sc_mcu7t3v3__nor2_2_4/VDD gf180mcu_as_sc_mcu7t3v3__nand3_2_8/VSS
+ VSS VSS gf180mcu_as_sc_mcu7t3v3__nor2_2_4/VNW VSUBS gf180mcu_as_sc_mcu7t3v3__inv_2
Xu_t010_021 u_t010_021/c0_w0_bl u_t010_021/c0_w0_br u_t010_021/c0_w1_bl u_t010_021/c0_w1_br
+ u_t010_021/c0_r0_rbl u_t010_021/c0_r1_rbl u_t010_021/c1_w0_bl u_t010_021/c1_w0_br
+ u_t010_021/c1_w1_bl u_t010_021/c1_w1_br u_t010_021/c1_r0_rbl u_t010_021/c1_r1_rbl
+ u_t010_021/c2_w0_bl u_t010_021/c2_w0_br u_t010_021/c2_w1_bl u_t010_021/c2_w1_br
+ u_t010_021/c2_r0_rbl u_t010_021/c2_r1_rbl u_t010_021/c3_w0_bl u_t010_021/c3_w0_br
+ u_t010_021/c3_w1_bl u_t010_021/c3_w1_br u_t010_021/c3_r0_rbl u_t010_021/c3_r1_rbl
+ u_t010_021/r0_w0_wl u_t010_021/r0_w1_wl u_t010_021/r0_r0_rwl u_t010_021/r0_r1_rwl
+ u_t010_021/r1_w0_wl u_t010_021/r1_w1_wl u_t010_021/r1_r0_rwl u_t010_021/r1_r1_rwl
+ u_t010_021/r2_w0_wl u_t010_021/r2_w1_wl u_t010_021/r2_r0_rwl u_t010_021/r2_r1_rwl
+ u_t010_021/r3_w0_wl u_t010_021/r3_w1_wl u_t010_021/r3_r0_rwl u_t010_021/r3_r1_rwl
+ u_t010_021/VDD u_t010_024/VSS VSUBS detronyx_12t_2w2r_rc4_4x4_routed_5layer_direct
Xu_t010_010 u_t010_010/c0_w0_bl u_t010_010/c0_w0_br u_t010_010/c0_w1_bl u_t010_010/c0_w1_br
+ u_t010_010/c0_r0_rbl u_t010_010/c0_r1_rbl u_t010_010/c1_w0_bl u_t010_010/c1_w0_br
+ u_t010_010/c1_w1_bl u_t010_010/c1_w1_br u_t010_010/c1_r0_rbl u_t010_010/c1_r1_rbl
+ u_t010_010/c2_w0_bl u_t010_010/c2_w0_br u_t010_010/c2_w1_bl u_t010_010/c2_w1_br
+ u_t010_010/c2_r0_rbl u_t010_010/c2_r1_rbl u_t010_010/c3_w0_bl u_t010_010/c3_w0_br
+ u_t010_010/c3_w1_bl u_t010_010/c3_w1_br u_t010_010/c3_r0_rbl u_t010_010/c3_r1_rbl
+ u_t010_010/r0_w0_wl u_t010_010/r0_w1_wl u_t010_010/r0_r0_rwl u_t010_010/r0_r1_rwl
+ u_t010_010/r1_w0_wl u_t010_010/r1_w1_wl u_t010_010/r1_r0_rwl u_t010_010/r1_r1_rwl
+ u_t010_010/r2_w0_wl u_t010_010/r2_w1_wl u_t010_010/r2_r0_rwl u_t010_010/r2_r1_rwl
+ u_t010_010/r3_w0_wl u_t010_010/r3_w1_wl u_t010_010/r3_r0_rwl u_t010_010/r3_r1_rwl
+ VSS u_t010_010/VSS VSUBS detronyx_12t_2w2r_rc4_4x4_routed_5layer_direct
Xu_t001_021 u_t001_021/c0_w0_bl u_t001_021/c0_w0_br u_t001_021/c0_w1_bl u_t001_021/c0_w1_br
+ u_t001_021/c0_r0_rbl u_t001_021/c0_r1_rbl u_t001_021/c1_w0_bl u_t001_021/c1_w0_br
+ u_t001_021/c1_w1_bl u_t001_021/c1_w1_br u_t001_021/c1_r0_rbl u_t001_021/c1_r1_rbl
+ u_t001_021/c2_w0_bl u_t001_021/c2_w0_br u_t001_021/c2_w1_bl u_t001_021/c2_w1_br
+ u_t001_021/c2_r0_rbl u_t001_021/c2_r1_rbl u_t001_021/c3_w0_bl u_t001_021/c3_w0_br
+ u_t001_021/c3_w1_bl u_t001_021/c3_w1_br u_t001_021/c3_r0_rbl u_t001_021/c3_r1_rbl
+ u_t001_021/r0_w0_wl u_t001_021/r0_w1_wl u_t001_021/r0_r0_rwl u_t001_021/r0_r1_rwl
+ u_t001_021/r1_w0_wl u_t001_021/r1_w1_wl u_t001_021/r1_r0_rwl u_t001_021/r1_r1_rwl
+ u_t001_021/r2_w0_wl u_t001_021/r2_w1_wl u_t001_021/r2_r0_rwl u_t001_021/r2_r1_rwl
+ u_t001_021/r3_w0_wl u_t001_021/r3_w1_wl u_t001_021/r3_r0_rwl u_t001_021/r3_r1_rwl
+ u_t001_021/VDD u_t001_031/VSS VSUBS detronyx_12t_2w2r_rc4_4x4_routed_5layer_direct
Xu_t001_010 u_t001_010/c0_w0_bl u_t001_010/c0_w0_br u_t001_010/c0_w1_bl u_t001_010/c0_w1_br
+ u_t001_010/c0_r0_rbl u_t001_010/c0_r1_rbl u_t001_010/c1_w0_bl u_t001_010/c1_w0_br
+ u_t001_010/c1_w1_bl u_t001_010/c1_w1_br u_t001_010/c1_r0_rbl u_t001_010/c1_r1_rbl
+ u_t001_010/c2_w0_bl u_t001_010/c2_w0_br u_t001_010/c2_w1_bl u_t001_010/c2_w1_br
+ u_t001_010/c2_r0_rbl u_t001_010/c2_r1_rbl u_t001_010/c3_w0_bl u_t001_010/c3_w0_br
+ u_t001_010/c3_w1_bl u_t001_010/c3_w1_br u_t001_010/c3_r0_rbl u_t001_010/c3_r1_rbl
+ u_t001_010/r0_w0_wl u_t001_010/r0_w1_wl u_t001_010/r0_r0_rwl u_t001_010/r0_r1_rwl
+ u_t001_010/r1_w0_wl u_t001_010/r1_w1_wl u_t001_010/r1_r0_rwl u_t001_010/r1_r1_rwl
+ u_t001_010/r2_w0_wl u_t001_010/r2_w1_wl u_t001_010/r2_r0_rwl u_t001_010/r2_r1_rwl
+ u_t001_010/r3_w0_wl u_t001_010/r3_w1_wl u_t001_010/r3_r0_rwl u_t001_010/r3_r1_rwl
+ VSS u_t001_031/VSS VSUBS detronyx_12t_2w2r_rc4_4x4_routed_5layer_direct
Xgf180mcu_as_sc_mcu7t3v3__inv_2_290 gf180mcu_as_sc_mcu7t3v3__inv_2_355/VDD gf180mcu_as_sc_mcu7t3v3__inv_2_356/VDD
+ gf180mcu_as_sc_mcu7t3v3__inv_2_358/Y gf180mcu_as_sc_mcu7t3v3__inv_2_358/Y gf180mcu_as_sc_mcu7t3v3__inv_2_355/VNW
+ VSUBS gf180mcu_as_sc_mcu7t3v3__inv_2
Xgf180mcu_as_sc_mcu7t3v3__nand4_2_506 VSS VSS VSS VSS VSS VSS VSS gf180mcu_as_sc_mcu7t3v3__inv_2_1676/VNW
+ VSUBS gf180mcu_as_sc_mcu7t3v3__nand4_2
Xgf180mcu_as_sc_mcu7t3v3__inv_2_16 gf180mcu_as_sc_mcu7t3v3__inv_2_69/VSS gf180mcu_as_sc_mcu7t3v3__inv_2_2/VDD
+ gf180mcu_as_sc_mcu7t3v3__inv_2_16/Y gf180mcu_as_sc_mcu7t3v3__inv_2_2/A gf180mcu_as_sc_mcu7t3v3__inv_2_54/VNW
+ VSUBS gf180mcu_as_sc_mcu7t3v3__inv_2
Xgf180mcu_as_sc_mcu7t3v3__inv_2_1008 gf180mcu_as_sc_mcu7t3v3__inv_2_1016/VDD VSS VSS
+ gf180mcu_as_sc_mcu7t3v3__inv_2_1294/Y gf180mcu_as_sc_mcu7t3v3__inv_2_1016/VNW VSUBS
+ gf180mcu_as_sc_mcu7t3v3__inv_2
Xgf180mcu_as_sc_mcu7t3v3__inv_2_1019 VSS VSS gf180mcu_as_sc_mcu7t3v3__inv_2_1019/Y
+ VSS gf180mcu_as_sc_mcu7t3v3__inv_2_1019/VNW VSUBS gf180mcu_as_sc_mcu7t3v3__inv_2
Xgf180mcu_as_sc_mcu7t3v3__inv_2_38 gf180mcu_as_sc_mcu7t3v3__inv_2_73/VDD gf180mcu_as_sc_mcu7t3v3__inv_2_73/VDD
+ gf180mcu_as_sc_mcu7t3v3__inv_2_77/Y gf180mcu_as_sc_mcu7t3v3__inv_2_77/Y gf180mcu_as_sc_mcu7t3v3__inv_2_72/VNW
+ VSUBS gf180mcu_as_sc_mcu7t3v3__inv_2
Xgf180mcu_as_sc_mcu7t3v3__inv_2_27 gf180mcu_as_sc_mcu7t3v3__inv_2_71/VDD gf180mcu_as_sc_mcu7t3v3__inv_2_73/VDD
+ VSS gf180mcu_as_sc_mcu7t3v3__inv_2_71/Y gf180mcu_as_sc_mcu7t3v3__inv_2_71/VNW VSUBS
+ gf180mcu_as_sc_mcu7t3v3__inv_2
Xgf180mcu_as_sc_mcu7t3v3__inv_2_49 gf180mcu_as_sc_mcu7t3v3__inv_2_66/VDD gf180mcu_as_sc_mcu7t3v3__inv_2_66/VSS
+ gf180mcu_as_sc_mcu7t3v3__inv_2_49/Y gf180mcu_as_sc_mcu7t3v3__inv_2_66/Y gf180mcu_as_sc_mcu7t3v3__inv_2_66/VNW
+ VSUBS gf180mcu_as_sc_mcu7t3v3__inv_2
Xgf180mcu_as_sc_mcu7t3v3__inv_2_1564 gf180mcu_as_sc_mcu7t3v3__inv_2_1565/VDD gf180mcu_as_sc_mcu7t3v3__inv_2_1569/VDD
+ gf180mcu_as_sc_mcu7t3v3__inv_2_1564/Y VSS gf180mcu_as_sc_mcu7t3v3__inv_2_1565/VNW
+ VSUBS gf180mcu_as_sc_mcu7t3v3__inv_2
Xgf180mcu_as_sc_mcu7t3v3__inv_2_1575 gf180mcu_as_sc_mcu7t3v3__inv_2_1577/VDD gf180mcu_as_sc_mcu7t3v3__inv_2_1581/VDD
+ VSS VSS gf180mcu_as_sc_mcu7t3v3__inv_2_1577/VNW VSUBS gf180mcu_as_sc_mcu7t3v3__inv_2
Xgf180mcu_as_sc_mcu7t3v3__inv_2_1586 VSS gf180mcu_as_sc_mcu7t3v3__inv_2_1586/VSS gf180mcu_as_sc_mcu7t3v3__inv_2_1586/Y
+ VSS gf180mcu_as_sc_mcu7t3v3__inv_2_1586/VNW VSUBS gf180mcu_as_sc_mcu7t3v3__inv_2
Xgf180mcu_as_sc_mcu7t3v3__inv_2_1597 gf180mcu_as_sc_mcu7t3v3__inv_2_1667/VDD gf180mcu_as_sc_mcu7t3v3__inv_2_1667/VSS
+ gf180mcu_as_sc_mcu7t3v3__inv_2_1597/Y gf180mcu_as_sc_mcu7t3v3__inv_2_1682/Y gf180mcu_as_sc_mcu7t3v3__inv_2_1667/VNW
+ VSUBS gf180mcu_as_sc_mcu7t3v3__inv_2
Xgf180mcu_as_sc_mcu7t3v3__inv_2_1542 VSS VSS VSS VSS gf180mcu_as_sc_mcu7t3v3__inv_2_1543/VNW
+ VSUBS gf180mcu_as_sc_mcu7t3v3__inv_2
Xgf180mcu_as_sc_mcu7t3v3__inv_2_1553 VSS VSS VSS VSS gf180mcu_as_sc_mcu7t3v3__inv_2_1553/VNW
+ VSUBS gf180mcu_as_sc_mcu7t3v3__inv_2
Xgf180mcu_as_sc_mcu7t3v3__inv_2_1520 VSS gf180mcu_as_sc_mcu7t3v3__inv_2_1524/VDD gf180mcu_as_sc_mcu7t3v3__inv_2_1520/Y
+ VSS gf180mcu_as_sc_mcu7t3v3__inv_2_1520/VNW VSUBS gf180mcu_as_sc_mcu7t3v3__inv_2
Xgf180mcu_as_sc_mcu7t3v3__inv_2_1531 VSS gf180mcu_as_sc_mcu7t3v3__inv_2_1532/VSS gf180mcu_as_sc_mcu7t3v3__inv_2_1531/Y
+ VSS gf180mcu_as_sc_mcu7t3v3__inv_2_1532/VNW VSUBS gf180mcu_as_sc_mcu7t3v3__inv_2
Xgf180mcu_as_sc_mcu7t3v3__nand3_2_8 gf180mcu_as_sc_mcu7t3v3__nor2_2_4/VDD gf180mcu_as_sc_mcu7t3v3__nand3_2_8/VSS
+ VSS VSS VSS VSS gf180mcu_as_sc_mcu7t3v3__nor2_2_4/VNW VSUBS gf180mcu_as_sc_mcu7t3v3__nand3_2
Xgf180mcu_as_sc_mcu7t3v3__nand4_2_336 gf180mcu_as_sc_mcu7t3v3__inv_2_1126/VDD VSS
+ VSS VSS VSS VSS VSS gf180mcu_as_sc_mcu7t3v3__inv_2_1126/VNW VSUBS gf180mcu_as_sc_mcu7t3v3__nand4_2
Xgf180mcu_as_sc_mcu7t3v3__nand4_2_358 VSS VSS VSS VSS VSS VSS gf180mcu_as_sc_mcu7t3v3__nand4_2_358/Y
+ gf180mcu_as_sc_mcu7t3v3__inv_2_1247/VNW VSUBS gf180mcu_as_sc_mcu7t3v3__nand4_2
Xgf180mcu_as_sc_mcu7t3v3__nand4_2_347 VSS gf180mcu_as_sc_mcu7t3v3__inv_2_1146/VSS
+ VSS VSS VSS VSS VSS gf180mcu_as_sc_mcu7t3v3__inv_2_1146/VNW VSUBS gf180mcu_as_sc_mcu7t3v3__nand4_2
Xgf180mcu_as_sc_mcu7t3v3__nand4_2_325 VSS VSS VSS VSS VSS VSS VSS gf180mcu_as_sc_mcu7t3v3__inv_2_1088/VNW
+ VSUBS gf180mcu_as_sc_mcu7t3v3__nand4_2
Xgf180mcu_as_sc_mcu7t3v3__nand4_2_369 VSS VSS VSS VSS VSS VSS gf180mcu_as_sc_mcu7t3v3__nand4_2_369/Y
+ gf180mcu_as_sc_mcu7t3v3__inv_2_1190/VNW VSUBS gf180mcu_as_sc_mcu7t3v3__nand4_2
Xgf180mcu_as_sc_mcu7t3v3__nand4_2_314 VSS VSS VSS VSS VSS VSS VSS gf180mcu_as_sc_mcu7t3v3__inv_2_1035/VNW
+ VSUBS gf180mcu_as_sc_mcu7t3v3__nand4_2
Xgf180mcu_as_sc_mcu7t3v3__nand4_2_303 gf180mcu_as_sc_mcu7t3v3__inv_2_1030/VDD gf180mcu_as_sc_mcu7t3v3__inv_2_1034/VDD
+ VSS VSS VSS VSS VSS gf180mcu_as_sc_mcu7t3v3__inv_2_1030/VNW VSUBS gf180mcu_as_sc_mcu7t3v3__nand4_2
Xu_t029_013 u_t029_013/c0_w0_bl u_t029_013/c0_w0_br u_t029_013/c0_w1_bl u_t029_013/c0_w1_br
+ u_t029_013/c0_r0_rbl u_t029_013/c0_r1_rbl u_t029_013/c1_w0_bl u_t029_013/c1_w0_br
+ u_t029_013/c1_w1_bl u_t029_013/c1_w1_br u_t029_013/c1_r0_rbl u_t029_013/c1_r1_rbl
+ u_t029_013/c2_w0_bl u_t029_013/c2_w0_br u_t029_013/c2_w1_bl u_t029_013/c2_w1_br
+ u_t029_013/c2_r0_rbl u_t029_013/c2_r1_rbl u_t029_013/c3_w0_bl u_t029_013/c3_w0_br
+ u_t029_013/c3_w1_bl u_t029_013/c3_w1_br u_t029_013/c3_r0_rbl u_t029_013/c3_r1_rbl
+ u_t029_013/r0_w0_wl u_t029_013/r0_w1_wl u_t029_013/r0_r0_rwl u_t029_013/r0_r1_rwl
+ u_t029_013/r1_w0_wl u_t029_013/r1_w1_wl u_t029_013/r1_r0_rwl u_t029_013/r1_r1_rwl
+ u_t029_013/r2_w0_wl u_t029_013/r2_w1_wl u_t029_013/r2_r0_rwl u_t029_013/r2_r1_rwl
+ u_t029_013/r3_w0_wl u_t029_013/r3_w1_wl u_t029_013/r3_r0_rwl u_t029_013/r3_r1_rwl
+ u_t029_013/VDD u_t029_031/VSS VSUBS detronyx_12t_2w2r_rc4_4x4_routed_5layer_direct
Xu_t029_002 u_t029_002/c0_w0_bl u_t029_002/c0_w0_br u_t029_002/c0_w1_bl u_t029_002/c0_w1_br
+ u_t029_002/c0_r0_rbl u_t029_002/c0_r1_rbl u_t029_002/c1_w0_bl u_t029_002/c1_w0_br
+ u_t029_002/c1_w1_bl u_t029_002/c1_w1_br u_t029_002/c1_r0_rbl u_t029_002/c1_r1_rbl
+ u_t029_002/c2_w0_bl u_t029_002/c2_w0_br u_t029_002/c2_w1_bl u_t029_002/c2_w1_br
+ u_t029_002/c2_r0_rbl u_t029_002/c2_r1_rbl u_t029_002/c3_w0_bl u_t029_002/c3_w0_br
+ u_t029_002/c3_w1_bl u_t029_002/c3_w1_br u_t029_002/c3_r0_rbl u_t029_002/c3_r1_rbl
+ u_t029_002/r0_w0_wl u_t029_002/r0_w1_wl u_t029_002/r0_r0_rwl u_t029_002/r0_r1_rwl
+ u_t029_002/r1_w0_wl u_t029_002/r1_w1_wl u_t029_002/r1_r0_rwl u_t029_002/r1_r1_rwl
+ u_t029_002/r2_w0_wl u_t029_002/r2_w1_wl u_t029_002/r2_r0_rwl u_t029_002/r2_r1_rwl
+ u_t029_002/r3_w0_wl u_t029_002/r3_w1_wl u_t029_002/r3_r0_rwl u_t029_002/r3_r1_rwl
+ VSS u_t029_031/VSS VSUBS detronyx_12t_2w2r_rc4_4x4_routed_5layer_direct
Xu_t029_024 u_t029_024/c0_w0_bl u_t029_024/c0_w0_br u_t029_024/c0_w1_bl u_t029_024/c0_w1_br
+ u_t029_024/c0_r0_rbl u_t029_024/c0_r1_rbl u_t029_024/c1_w0_bl u_t029_024/c1_w0_br
+ u_t029_024/c1_w1_bl u_t029_024/c1_w1_br u_t029_024/c1_r0_rbl u_t029_024/c1_r1_rbl
+ u_t029_024/c2_w0_bl u_t029_024/c2_w0_br u_t029_024/c2_w1_bl u_t029_024/c2_w1_br
+ u_t029_024/c2_r0_rbl u_t029_024/c2_r1_rbl u_t029_024/c3_w0_bl u_t029_024/c3_w0_br
+ u_t029_024/c3_w1_bl u_t029_024/c3_w1_br u_t029_024/c3_r0_rbl u_t029_024/c3_r1_rbl
+ u_t029_024/r0_w0_wl u_t029_024/r0_w1_wl u_t029_024/r0_r0_rwl u_t029_024/r0_r1_rwl
+ u_t029_024/r1_w0_wl u_t029_024/r1_w1_wl u_t029_024/r1_r0_rwl u_t029_024/r1_r1_rwl
+ u_t029_024/r2_w0_wl u_t029_024/r2_w1_wl u_t029_024/r2_r0_rwl u_t029_024/r2_r1_rwl
+ u_t029_024/r3_w0_wl u_t029_024/r3_w1_wl u_t029_024/r3_r0_rwl u_t029_024/r3_r1_rwl
+ VSS u_t029_031/VSS VSUBS detronyx_12t_2w2r_rc4_4x4_routed_5layer_direct
Xgf180mcu_as_sc_mcu7t3v3__inv_2_1350 VSS gf180mcu_as_sc_mcu7t3v3__inv_2_1383/VDD VSS
+ gf180mcu_as_sc_mcu7t3v3__inv_2_1384/Y gf180mcu_as_sc_mcu7t3v3__inv_2_1382/VNW VSUBS
+ gf180mcu_as_sc_mcu7t3v3__inv_2
Xgf180mcu_as_sc_mcu7t3v3__inv_2_1383 gf180mcu_as_sc_mcu7t3v3__inv_2_1383/VDD gf180mcu_as_sc_mcu7t3v3__inv_2_1384/VDD
+ gf180mcu_as_sc_mcu7t3v3__inv_2_1384/Y VSS gf180mcu_as_sc_mcu7t3v3__inv_2_1383/VNW
+ VSUBS gf180mcu_as_sc_mcu7t3v3__inv_2
Xgf180mcu_as_sc_mcu7t3v3__inv_2_1372 gf180mcu_as_sc_mcu7t3v3__inv_2_1372/VDD gf180mcu_as_sc_mcu7t3v3__inv_2_1373/VDD
+ gf180mcu_as_sc_mcu7t3v3__inv_2_1379/Y VSS gf180mcu_as_sc_mcu7t3v3__inv_2_1372/VNW
+ VSUBS gf180mcu_as_sc_mcu7t3v3__inv_2
Xgf180mcu_as_sc_mcu7t3v3__inv_2_1361 VSS gf180mcu_as_sc_mcu7t3v3__inv_2_1398/VSS VSS
+ gf180mcu_as_sc_mcu7t3v3__inv_2_1398/Y gf180mcu_as_sc_mcu7t3v3__inv_2_1398/VNW VSUBS
+ gf180mcu_as_sc_mcu7t3v3__inv_2
Xgf180mcu_as_sc_mcu7t3v3__inv_2_1394 gf180mcu_as_sc_mcu7t3v3__inv_2_1394/VDD VSS gf180mcu_as_sc_mcu7t3v3__inv_2_1398/Y
+ VSS gf180mcu_as_sc_mcu7t3v3__inv_2_1394/VNW VSUBS gf180mcu_as_sc_mcu7t3v3__inv_2
Xgf180mcu_as_sc_mcu7t3v3__inv_2_845 VSS VSS VSS VSS gf180mcu_as_sc_mcu7t3v3__inv_2_846/VNW
+ VSUBS gf180mcu_as_sc_mcu7t3v3__inv_2
Xgf180mcu_as_sc_mcu7t3v3__inv_2_801 VSS VSS VSS VSS gf180mcu_as_sc_mcu7t3v3__inv_2_833/VNW
+ VSUBS gf180mcu_as_sc_mcu7t3v3__inv_2
Xgf180mcu_as_sc_mcu7t3v3__inv_2_812 VSS VSS gf180mcu_as_sc_mcu7t3v3__inv_2_812/Y VSS
+ gf180mcu_as_sc_mcu7t3v3__inv_2_812/VNW VSUBS gf180mcu_as_sc_mcu7t3v3__inv_2
Xgf180mcu_as_sc_mcu7t3v3__inv_2_834 VSS VSS gf180mcu_as_sc_mcu7t3v3__inv_2_834/Y VSS
+ gf180mcu_as_sc_mcu7t3v3__inv_2_836/VNW VSUBS gf180mcu_as_sc_mcu7t3v3__inv_2
Xgf180mcu_as_sc_mcu7t3v3__inv_2_823 VSS VSS VSS VSS gf180mcu_as_sc_mcu7t3v3__inv_2_824/VNW
+ VSUBS gf180mcu_as_sc_mcu7t3v3__inv_2
Xgf180mcu_as_sc_mcu7t3v3__inv_2_878 VSS VSS VSS VSS gf180mcu_as_sc_mcu7t3v3__inv_2_880/VNW
+ VSUBS gf180mcu_as_sc_mcu7t3v3__inv_2
Xgf180mcu_as_sc_mcu7t3v3__inv_2_867 VSS VSS VSS VSS gf180mcu_as_sc_mcu7t3v3__inv_2_868/VNW
+ VSUBS gf180mcu_as_sc_mcu7t3v3__inv_2
Xgf180mcu_as_sc_mcu7t3v3__inv_2_856 VSS VSS gf180mcu_as_sc_mcu7t3v3__inv_2_856/Y VSS
+ gf180mcu_as_sc_mcu7t3v3__inv_2_856/VNW VSUBS gf180mcu_as_sc_mcu7t3v3__inv_2
Xgf180mcu_as_sc_mcu7t3v3__inv_2_889 VSS VSS VSS VSS gf180mcu_as_sc_mcu7t3v3__inv_2_897/VNW
+ VSUBS gf180mcu_as_sc_mcu7t3v3__inv_2
Xgf180mcu_as_sc_mcu7t3v3__nand4_2_133 VSS VSS VSS VSS VSS VSS gf180mcu_as_sc_mcu7t3v3__nand4_2_133/Y
+ gf180mcu_as_sc_mcu7t3v3__inv_2_448/VNW VSUBS gf180mcu_as_sc_mcu7t3v3__nand4_2
Xgf180mcu_as_sc_mcu7t3v3__nand4_2_144 VSS VSS VSS VSS VSS VSS VSS gf180mcu_as_sc_mcu7t3v3__inv_2_514/VNW
+ VSUBS gf180mcu_as_sc_mcu7t3v3__nand4_2
Xgf180mcu_as_sc_mcu7t3v3__nand4_2_122 gf180mcu_as_sc_mcu7t3v3__inv_2_368/VDD gf180mcu_as_sc_mcu7t3v3__inv_2_65/VDD
+ VSS VSS VSS VSS VSS gf180mcu_as_sc_mcu7t3v3__inv_2_368/VNW VSUBS gf180mcu_as_sc_mcu7t3v3__nand4_2
Xgf180mcu_as_sc_mcu7t3v3__nand4_2_100 gf180mcu_as_sc_mcu7t3v3__inv_2_353/VDD gf180mcu_as_sc_mcu7t3v3__inv_2_368/VDD
+ VSS VSS VSS VSS VSS gf180mcu_as_sc_mcu7t3v3__inv_2_353/VNW VSUBS gf180mcu_as_sc_mcu7t3v3__nand4_2
Xgf180mcu_as_sc_mcu7t3v3__nand4_2_111 VSS gf180mcu_as_sc_mcu7t3v3__inv_2_331/VDD VSS
+ VSS VSS VSS VSS gf180mcu_as_sc_mcu7t3v3__inv_2_330/VNW VSUBS gf180mcu_as_sc_mcu7t3v3__nand4_2
Xu_t026_027 u_t026_027/c0_w0_bl u_t026_027/c0_w0_br u_t026_027/c0_w1_bl u_t026_027/c0_w1_br
+ u_t026_027/c0_r0_rbl u_t026_027/c0_r1_rbl u_t026_027/c1_w0_bl u_t026_027/c1_w0_br
+ u_t026_027/c1_w1_bl u_t026_027/c1_w1_br u_t026_027/c1_r0_rbl u_t026_027/c1_r1_rbl
+ u_t026_027/c2_w0_bl u_t026_027/c2_w0_br u_t026_027/c2_w1_bl u_t026_027/c2_w1_br
+ u_t026_027/c2_r0_rbl u_t026_027/c2_r1_rbl u_t026_027/c3_w0_bl u_t026_027/c3_w0_br
+ u_t026_027/c3_w1_bl u_t026_027/c3_w1_br u_t026_027/c3_r0_rbl u_t026_027/c3_r1_rbl
+ u_t026_027/r0_w0_wl u_t026_027/r0_w1_wl u_t026_027/r0_r0_rwl u_t026_027/r0_r1_rwl
+ u_t026_027/r1_w0_wl u_t026_027/r1_w1_wl u_t026_027/r1_r0_rwl u_t026_027/r1_r1_rwl
+ u_t026_027/r2_w0_wl u_t026_027/r2_w1_wl u_t026_027/r2_r0_rwl u_t026_027/r2_r1_rwl
+ u_t026_027/r3_w0_wl u_t026_027/r3_w1_wl u_t026_027/r3_r0_rwl u_t026_027/r3_r1_rwl
+ u_t026_027/VDD u_t026_031/VSS VSUBS detronyx_12t_2w2r_rc4_4x4_routed_5layer_direct
Xu_t026_016 u_t026_016/c0_w0_bl u_t026_016/c0_w0_br u_t026_016/c0_w1_bl u_t026_016/c0_w1_br
+ u_t026_016/c0_r0_rbl u_t026_016/c0_r1_rbl u_t026_016/c1_w0_bl u_t026_016/c1_w0_br
+ u_t026_016/c1_w1_bl u_t026_016/c1_w1_br u_t026_016/c1_r0_rbl u_t026_016/c1_r1_rbl
+ u_t026_016/c2_w0_bl u_t026_016/c2_w0_br u_t026_016/c2_w1_bl u_t026_016/c2_w1_br
+ u_t026_016/c2_r0_rbl u_t026_016/c2_r1_rbl u_t026_016/c3_w0_bl u_t026_016/c3_w0_br
+ u_t026_016/c3_w1_bl u_t026_016/c3_w1_br u_t026_016/c3_r0_rbl u_t026_016/c3_r1_rbl
+ u_t026_016/r0_w0_wl u_t026_016/r0_w1_wl u_t026_016/r0_r0_rwl u_t026_016/r0_r1_rwl
+ u_t026_016/r1_w0_wl u_t026_016/r1_w1_wl u_t026_016/r1_r0_rwl u_t026_016/r1_r1_rwl
+ u_t026_016/r2_w0_wl u_t026_016/r2_w1_wl u_t026_016/r2_r0_rwl u_t026_016/r2_r1_rwl
+ u_t026_016/r3_w0_wl u_t026_016/r3_w1_wl u_t026_016/r3_r0_rwl u_t026_016/r3_r1_rwl
+ VSS u_t026_031/VSS VSUBS detronyx_12t_2w2r_rc4_4x4_routed_5layer_direct
Xu_t026_005 u_t026_005/c0_w0_bl u_t026_005/c0_w0_br u_t026_005/c0_w1_bl u_t026_005/c0_w1_br
+ u_t026_005/c0_r0_rbl u_t026_005/c0_r1_rbl u_t026_005/c1_w0_bl u_t026_005/c1_w0_br
+ u_t026_005/c1_w1_bl u_t026_005/c1_w1_br u_t026_005/c1_r0_rbl u_t026_005/c1_r1_rbl
+ u_t026_005/c2_w0_bl u_t026_005/c2_w0_br u_t026_005/c2_w1_bl u_t026_005/c2_w1_br
+ u_t026_005/c2_r0_rbl u_t026_005/c2_r1_rbl u_t026_005/c3_w0_bl u_t026_005/c3_w0_br
+ u_t026_005/c3_w1_bl u_t026_005/c3_w1_br u_t026_005/c3_r0_rbl u_t026_005/c3_r1_rbl
+ u_t026_005/r0_w0_wl u_t026_005/r0_w1_wl u_t026_005/r0_r0_rwl u_t026_005/r0_r1_rwl
+ u_t026_005/r1_w0_wl u_t026_005/r1_w1_wl u_t026_005/r1_r0_rwl u_t026_005/r1_r1_rwl
+ u_t026_005/r2_w0_wl u_t026_005/r2_w1_wl u_t026_005/r2_r0_rwl u_t026_005/r2_r1_rwl
+ u_t026_005/r3_w0_wl u_t026_005/r3_w1_wl u_t026_005/r3_r0_rwl u_t026_005/r3_r1_rwl
+ u_t026_005/VDD u_t026_031/VSS VSUBS detronyx_12t_2w2r_rc4_4x4_routed_5layer_direct
Xgf180mcu_as_sc_mcu7t3v3__nand4_2_166 VSS gf180mcu_as_sc_mcu7t3v3__inv_2_636/VSS VSS
+ VSS VSS VSS VSS gf180mcu_as_sc_mcu7t3v3__inv_2_594/VNW VSUBS gf180mcu_as_sc_mcu7t3v3__nand4_2
Xgf180mcu_as_sc_mcu7t3v3__nand4_2_177 gf180mcu_as_sc_mcu7t3v3__inv_2_636/VSS gf180mcu_as_sc_mcu7t3v3__inv_2_636/VSS
+ VSS VSS VSS VSS VSS gf180mcu_as_sc_mcu7t3v3__inv_2_636/VNW VSUBS gf180mcu_as_sc_mcu7t3v3__nand4_2
Xgf180mcu_as_sc_mcu7t3v3__nand4_2_155 gf180mcu_as_sc_mcu7t3v3__inv_2_572/VDD gf180mcu_as_sc_mcu7t3v3__inv_2_576/VDD
+ VSS VSS VSS VSS VSS gf180mcu_as_sc_mcu7t3v3__inv_2_572/VNW VSUBS gf180mcu_as_sc_mcu7t3v3__nand4_2
Xgf180mcu_as_sc_mcu7t3v3__nand4_2_50 gf180mcu_as_sc_mcu7t3v3__inv_2_151/VDD gf180mcu_as_sc_mcu7t3v3__inv_2_151/VSS
+ VSS VSS VSS VSS gf180mcu_as_sc_mcu7t3v3__nand4_2_50/Y gf180mcu_as_sc_mcu7t3v3__inv_2_151/VNW
+ VSUBS gf180mcu_as_sc_mcu7t3v3__nand4_2
Xgf180mcu_as_sc_mcu7t3v3__nand4_2_199 VSS gf180mcu_as_sc_mcu7t3v3__inv_2_679/VDD VSS
+ VSS VSS VSS VSS gf180mcu_as_sc_mcu7t3v3__inv_2_675/VNW VSUBS gf180mcu_as_sc_mcu7t3v3__nand4_2
Xgf180mcu_as_sc_mcu7t3v3__nand4_2_94 gf180mcu_as_sc_mcu7t3v3__inv_2_350/VDD gf180mcu_as_sc_mcu7t3v3__inv_2_351/VDD
+ VSS VSS VSS VSS VSS gf180mcu_as_sc_mcu7t3v3__inv_2_350/VNW VSUBS gf180mcu_as_sc_mcu7t3v3__nand4_2
Xgf180mcu_as_sc_mcu7t3v3__nand4_2_72 VSS VSS VSS VSS VSS VSS VSS gf180mcu_as_sc_mcu7t3v3__inv_2_193/VNW
+ VSUBS gf180mcu_as_sc_mcu7t3v3__nand4_2
Xgf180mcu_as_sc_mcu7t3v3__nand4_2_61 gf180mcu_as_sc_mcu7t3v3__inv_2_192/VDD VSS VSS
+ VSS VSS VSS VSS gf180mcu_as_sc_mcu7t3v3__inv_2_192/VNW VSUBS gf180mcu_as_sc_mcu7t3v3__nand4_2
Xgf180mcu_as_sc_mcu7t3v3__nand4_2_188 VSS gf180mcu_as_sc_mcu7t3v3__inv_2_727/VSS VSS
+ VSS VSS VSS VSS gf180mcu_as_sc_mcu7t3v3__inv_2_727/VNW VSUBS gf180mcu_as_sc_mcu7t3v3__nand4_2
Xgf180mcu_as_sc_mcu7t3v3__nand4_2_83 gf180mcu_as_sc_mcu7t3v3__inv_2_245/VDD VSS VSS
+ VSS VSS VSS VSS gf180mcu_as_sc_mcu7t3v3__inv_2_245/VNW VSUBS gf180mcu_as_sc_mcu7t3v3__nand4_2
Xu_t017_027 u_t017_027/c0_w0_bl u_t017_027/c0_w0_br u_t017_027/c0_w1_bl u_t017_027/c0_w1_br
+ u_t017_027/c0_r0_rbl u_t017_027/c0_r1_rbl u_t017_027/c1_w0_bl u_t017_027/c1_w0_br
+ u_t017_027/c1_w1_bl u_t017_027/c1_w1_br u_t017_027/c1_r0_rbl u_t017_027/c1_r1_rbl
+ u_t017_027/c2_w0_bl u_t017_027/c2_w0_br u_t017_027/c2_w1_bl u_t017_027/c2_w1_br
+ u_t017_027/c2_r0_rbl u_t017_027/c2_r1_rbl u_t017_027/c3_w0_bl u_t017_027/c3_w0_br
+ u_t017_027/c3_w1_bl u_t017_027/c3_w1_br u_t017_027/c3_r0_rbl u_t017_027/c3_r1_rbl
+ u_t017_027/r0_w0_wl u_t017_027/r0_w1_wl u_t017_027/r0_r0_rwl u_t017_027/r0_r1_rwl
+ u_t017_027/r1_w0_wl u_t017_027/r1_w1_wl u_t017_027/r1_r0_rwl u_t017_027/r1_r1_rwl
+ u_t017_027/r2_w0_wl u_t017_027/r2_w1_wl u_t017_027/r2_r0_rwl u_t017_027/r2_r1_rwl
+ u_t017_027/r3_w0_wl u_t017_027/r3_w1_wl u_t017_027/r3_r0_rwl u_t017_027/r3_r1_rwl
+ u_t017_027/VDD u_t017_031/VSS VSUBS detronyx_12t_2w2r_rc4_4x4_routed_5layer_direct
Xu_t017_016 u_t017_016/c0_w0_bl u_t017_016/c0_w0_br u_t017_016/c0_w1_bl u_t017_016/c0_w1_br
+ u_t017_016/c0_r0_rbl u_t017_016/c0_r1_rbl u_t017_016/c1_w0_bl u_t017_016/c1_w0_br
+ u_t017_016/c1_w1_bl u_t017_016/c1_w1_br u_t017_016/c1_r0_rbl u_t017_016/c1_r1_rbl
+ u_t017_016/c2_w0_bl u_t017_016/c2_w0_br u_t017_016/c2_w1_bl u_t017_016/c2_w1_br
+ u_t017_016/c2_r0_rbl u_t017_016/c2_r1_rbl u_t017_016/c3_w0_bl u_t017_016/c3_w0_br
+ u_t017_016/c3_w1_bl u_t017_016/c3_w1_br u_t017_016/c3_r0_rbl u_t017_016/c3_r1_rbl
+ u_t017_016/r0_w0_wl u_t017_016/r0_w1_wl u_t017_016/r0_r0_rwl u_t017_016/r0_r1_rwl
+ u_t017_016/r1_w0_wl u_t017_016/r1_w1_wl u_t017_016/r1_r0_rwl u_t017_016/r1_r1_rwl
+ u_t017_016/r2_w0_wl u_t017_016/r2_w1_wl u_t017_016/r2_r0_rwl u_t017_016/r2_r1_rwl
+ u_t017_016/r3_w0_wl u_t017_016/r3_w1_wl u_t017_016/r3_r0_rwl u_t017_016/r3_r1_rwl
+ VSS u_t017_031/VSS VSUBS detronyx_12t_2w2r_rc4_4x4_routed_5layer_direct
Xu_t017_005 u_t017_005/c0_w0_bl u_t017_005/c0_w0_br u_t017_005/c0_w1_bl u_t017_005/c0_w1_br
+ u_t017_005/c0_r0_rbl u_t017_005/c0_r1_rbl u_t017_005/c1_w0_bl u_t017_005/c1_w0_br
+ u_t017_005/c1_w1_bl u_t017_005/c1_w1_br u_t017_005/c1_r0_rbl u_t017_005/c1_r1_rbl
+ u_t017_005/c2_w0_bl u_t017_005/c2_w0_br u_t017_005/c2_w1_bl u_t017_005/c2_w1_br
+ u_t017_005/c2_r0_rbl u_t017_005/c2_r1_rbl u_t017_005/c3_w0_bl u_t017_005/c3_w0_br
+ u_t017_005/c3_w1_bl u_t017_005/c3_w1_br u_t017_005/c3_r0_rbl u_t017_005/c3_r1_rbl
+ u_t017_005/r0_w0_wl u_t017_005/r0_w1_wl u_t017_005/r0_r0_rwl u_t017_005/r0_r1_rwl
+ u_t017_005/r1_w0_wl u_t017_005/r1_w1_wl u_t017_005/r1_r0_rwl u_t017_005/r1_r1_rwl
+ u_t017_005/r2_w0_wl u_t017_005/r2_w1_wl u_t017_005/r2_r0_rwl u_t017_005/r2_r1_rwl
+ u_t017_005/r3_w0_wl u_t017_005/r3_w1_wl u_t017_005/r3_r0_rwl u_t017_005/r3_r1_rwl
+ u_t017_005/VDD u_t017_031/VSS VSUBS detronyx_12t_2w2r_rc4_4x4_routed_5layer_direct
Xgf180mcu_as_sc_mcu7t3v3__inv_2_108 gf180mcu_as_sc_mcu7t3v3__inv_2_152/VSS gf180mcu_as_sc_mcu7t3v3__inv_2_151/VDD
+ gf180mcu_as_sc_mcu7t3v3__inv_2_108/Y VSS gf180mcu_as_sc_mcu7t3v3__inv_2_135/VNW
+ VSUBS gf180mcu_as_sc_mcu7t3v3__inv_2
Xgf180mcu_as_sc_mcu7t3v3__inv_2_119 gf180mcu_as_sc_mcu7t3v3__inv_2_119/VDD gf180mcu_as_sc_mcu7t3v3__inv_2_152/VSS
+ gf180mcu_as_sc_mcu7t3v3__inv_2_119/Y VSS gf180mcu_as_sc_mcu7t3v3__inv_2_119/VNW
+ VSUBS gf180mcu_as_sc_mcu7t3v3__inv_2
Xgf180mcu_as_sc_mcu7t3v3__inv_2_1180 VSS VSS VSS VSS gf180mcu_as_sc_mcu7t3v3__inv_2_1182/VNW
+ VSUBS gf180mcu_as_sc_mcu7t3v3__inv_2
Xgf180mcu_as_sc_mcu7t3v3__inv_2_1191 VSS VSS gf180mcu_as_sc_mcu7t3v3__inv_2_1191/Y
+ VSS gf180mcu_as_sc_mcu7t3v3__inv_2_1191/VNW VSUBS gf180mcu_as_sc_mcu7t3v3__inv_2
Xu_t008_027 u_t008_027/c0_w0_bl u_t008_027/c0_w0_br u_t008_027/c0_w1_bl u_t008_027/c0_w1_br
+ u_t008_027/c0_r0_rbl u_t008_027/c0_r1_rbl u_t008_027/c1_w0_bl u_t008_027/c1_w0_br
+ u_t008_027/c1_w1_bl u_t008_027/c1_w1_br u_t008_027/c1_r0_rbl u_t008_027/c1_r1_rbl
+ u_t008_027/c2_w0_bl u_t008_027/c2_w0_br u_t008_027/c2_w1_bl u_t008_027/c2_w1_br
+ u_t008_027/c2_r0_rbl u_t008_027/c2_r1_rbl u_t008_027/c3_w0_bl u_t008_027/c3_w0_br
+ u_t008_027/c3_w1_bl u_t008_027/c3_w1_br u_t008_027/c3_r0_rbl u_t008_027/c3_r1_rbl
+ u_t008_027/r0_w0_wl u_t008_027/r0_w1_wl u_t008_027/r0_r0_rwl u_t008_027/r0_r1_rwl
+ u_t008_027/r1_w0_wl u_t008_027/r1_w1_wl u_t008_027/r1_r0_rwl u_t008_027/r1_r1_rwl
+ u_t008_027/r2_w0_wl u_t008_027/r2_w1_wl u_t008_027/r2_r0_rwl u_t008_027/r2_r1_rwl
+ u_t008_027/r3_w0_wl u_t008_027/r3_w1_wl u_t008_027/r3_r0_rwl u_t008_027/r3_r1_rwl
+ u_t008_027/VDD u_t008_031/VSS VSUBS detronyx_12t_2w2r_rc4_4x4_routed_5layer_direct
Xu_t008_016 u_t008_016/c0_w0_bl u_t008_016/c0_w0_br u_t008_016/c0_w1_bl u_t008_016/c0_w1_br
+ u_t008_016/c0_r0_rbl u_t008_016/c0_r1_rbl u_t008_016/c1_w0_bl u_t008_016/c1_w0_br
+ u_t008_016/c1_w1_bl u_t008_016/c1_w1_br u_t008_016/c1_r0_rbl u_t008_016/c1_r1_rbl
+ u_t008_016/c2_w0_bl u_t008_016/c2_w0_br u_t008_016/c2_w1_bl u_t008_016/c2_w1_br
+ u_t008_016/c2_r0_rbl u_t008_016/c2_r1_rbl u_t008_016/c3_w0_bl u_t008_016/c3_w0_br
+ u_t008_016/c3_w1_bl u_t008_016/c3_w1_br u_t008_016/c3_r0_rbl u_t008_016/c3_r1_rbl
+ u_t008_016/r0_w0_wl u_t008_016/r0_w1_wl u_t008_016/r0_r0_rwl u_t008_016/r0_r1_rwl
+ u_t008_016/r1_w0_wl u_t008_016/r1_w1_wl u_t008_016/r1_r0_rwl u_t008_016/r1_r1_rwl
+ u_t008_016/r2_w0_wl u_t008_016/r2_w1_wl u_t008_016/r2_r0_rwl u_t008_016/r2_r1_rwl
+ u_t008_016/r3_w0_wl u_t008_016/r3_w1_wl u_t008_016/r3_r0_rwl u_t008_016/r3_r1_rwl
+ VSS u_t008_031/VSS VSUBS detronyx_12t_2w2r_rc4_4x4_routed_5layer_direct
Xu_t008_005 u_t008_005/c0_w0_bl u_t008_005/c0_w0_br u_t008_005/c0_w1_bl u_t008_005/c0_w1_br
+ u_t008_005/c0_r0_rbl u_t008_005/c0_r1_rbl u_t008_005/c1_w0_bl u_t008_005/c1_w0_br
+ u_t008_005/c1_w1_bl u_t008_005/c1_w1_br u_t008_005/c1_r0_rbl u_t008_005/c1_r1_rbl
+ u_t008_005/c2_w0_bl u_t008_005/c2_w0_br u_t008_005/c2_w1_bl u_t008_005/c2_w1_br
+ u_t008_005/c2_r0_rbl u_t008_005/c2_r1_rbl u_t008_005/c3_w0_bl u_t008_005/c3_w0_br
+ u_t008_005/c3_w1_bl u_t008_005/c3_w1_br u_t008_005/c3_r0_rbl u_t008_005/c3_r1_rbl
+ u_t008_005/r0_w0_wl u_t008_005/r0_w1_wl u_t008_005/r0_r0_rwl u_t008_005/r0_r1_rwl
+ u_t008_005/r1_w0_wl u_t008_005/r1_w1_wl u_t008_005/r1_r0_rwl u_t008_005/r1_r1_rwl
+ u_t008_005/r2_w0_wl u_t008_005/r2_w1_wl u_t008_005/r2_r0_rwl u_t008_005/r2_r1_rwl
+ u_t008_005/r3_w0_wl u_t008_005/r3_w1_wl u_t008_005/r3_r0_rwl u_t008_005/r3_r1_rwl
+ u_t008_005/VDD u_t008_031/VSS VSUBS detronyx_12t_2w2r_rc4_4x4_routed_5layer_direct
Xgf180mcu_as_sc_mcu7t3v3__inv_2_620 gf180mcu_as_sc_mcu7t3v3__inv_2_620/VDD gf180mcu_as_sc_mcu7t3v3__inv_2_629/VDD
+ gf180mcu_as_sc_mcu7t3v3__inv_2_620/Y VSS gf180mcu_as_sc_mcu7t3v3__inv_2_620/VNW
+ VSUBS gf180mcu_as_sc_mcu7t3v3__inv_2
Xu_t031_030 u_t031_030/c0_w0_bl u_t031_030/c0_w0_br u_t031_030/c0_w1_bl u_t031_030/c0_w1_br
+ u_t031_030/c0_r0_rbl u_t031_030/c0_r1_rbl u_t031_030/c1_w0_bl u_t031_030/c1_w0_br
+ u_t031_030/c1_w1_bl u_t031_030/c1_w1_br u_t031_030/c1_r0_rbl u_t031_030/c1_r1_rbl
+ u_t031_030/c2_w0_bl u_t031_030/c2_w0_br u_t031_030/c2_w1_bl u_t031_030/c2_w1_br
+ u_t031_030/c2_r0_rbl u_t031_030/c2_r1_rbl u_t031_030/c3_w0_bl u_t031_030/c3_w0_br
+ u_t031_030/c3_w1_bl u_t031_030/c3_w1_br u_t031_030/c3_r0_rbl u_t031_030/c3_r1_rbl
+ u_t031_030/r0_w0_wl u_t031_030/r0_w1_wl u_t031_030/r0_r0_rwl u_t031_030/r0_r1_rwl
+ u_t031_030/r1_w0_wl u_t031_030/r1_w1_wl u_t031_030/r1_r0_rwl u_t031_030/r1_r1_rwl
+ u_t031_030/r2_w0_wl u_t031_030/r2_w1_wl u_t031_030/r2_r0_rwl u_t031_030/r2_r1_rwl
+ u_t031_030/r3_w0_wl u_t031_030/r3_w1_wl u_t031_030/r3_r0_rwl u_t031_030/r3_r1_rwl
+ VSS u_t031_031/VSS VSUBS detronyx_12t_2w2r_rc4_4x4_routed_5layer_direct
Xu_t023_019 u_t023_019/c0_w0_bl u_t023_019/c0_w0_br u_t023_019/c0_w1_bl u_t023_019/c0_w1_br
+ u_t023_019/c0_r0_rbl u_t023_019/c0_r1_rbl u_t023_019/c1_w0_bl u_t023_019/c1_w0_br
+ u_t023_019/c1_w1_bl u_t023_019/c1_w1_br u_t023_019/c1_r0_rbl u_t023_019/c1_r1_rbl
+ u_t023_019/c2_w0_bl u_t023_019/c2_w0_br u_t023_019/c2_w1_bl u_t023_019/c2_w1_br
+ u_t023_019/c2_r0_rbl u_t023_019/c2_r1_rbl u_t023_019/c3_w0_bl u_t023_019/c3_w0_br
+ u_t023_019/c3_w1_bl u_t023_019/c3_w1_br u_t023_019/c3_r0_rbl u_t023_019/c3_r1_rbl
+ u_t023_019/r0_w0_wl u_t023_019/r0_w1_wl u_t023_019/r0_r0_rwl u_t023_019/r0_r1_rwl
+ u_t023_019/r1_w0_wl u_t023_019/r1_w1_wl u_t023_019/r1_r0_rwl u_t023_019/r1_r1_rwl
+ u_t023_019/r2_w0_wl u_t023_019/r2_w1_wl u_t023_019/r2_r0_rwl u_t023_019/r2_r1_rwl
+ u_t023_019/r3_w0_wl u_t023_019/r3_w1_wl u_t023_019/r3_r0_rwl u_t023_019/r3_r1_rwl
+ u_t023_019/VDD u_t023_019/VSS VSUBS detronyx_12t_2w2r_rc4_4x4_routed_5layer_direct
Xu_t023_008 u_t023_008/c0_w0_bl u_t023_008/c0_w0_br u_t023_008/c0_w1_bl u_t023_008/c0_w1_br
+ u_t023_008/c0_r0_rbl u_t023_008/c0_r1_rbl u_t023_008/c1_w0_bl u_t023_008/c1_w0_br
+ u_t023_008/c1_w1_bl u_t023_008/c1_w1_br u_t023_008/c1_r0_rbl u_t023_008/c1_r1_rbl
+ u_t023_008/c2_w0_bl u_t023_008/c2_w0_br u_t023_008/c2_w1_bl u_t023_008/c2_w1_br
+ u_t023_008/c2_r0_rbl u_t023_008/c2_r1_rbl u_t023_008/c3_w0_bl u_t023_008/c3_w0_br
+ u_t023_008/c3_w1_bl u_t023_008/c3_w1_br u_t023_008/c3_r0_rbl u_t023_008/c3_r1_rbl
+ u_t023_008/r0_w0_wl u_t023_008/r0_w1_wl u_t023_008/r0_r0_rwl u_t023_008/r0_r1_rwl
+ u_t023_008/r1_w0_wl u_t023_008/r1_w1_wl u_t023_008/r1_r0_rwl u_t023_008/r1_r1_rwl
+ u_t023_008/r2_w0_wl u_t023_008/r2_w1_wl u_t023_008/r2_r0_rwl u_t023_008/r2_r1_rwl
+ u_t023_008/r3_w0_wl u_t023_008/r3_w1_wl u_t023_008/r3_r0_rwl u_t023_008/r3_r1_rwl
+ VSS u_t023_009/VSS VSUBS detronyx_12t_2w2r_rc4_4x4_routed_5layer_direct
Xgf180mcu_as_sc_mcu7t3v3__inv_2_631 gf180mcu_as_sc_mcu7t3v3__inv_2_633/VDD gf180mcu_as_sc_mcu7t3v3__inv_2_633/VSS
+ gf180mcu_as_sc_mcu7t3v3__inv_2_631/Y gf180mcu_as_sc_mcu7t3v3__inv_2_631/A gf180mcu_as_sc_mcu7t3v3__inv_2_633/VNW
+ VSUBS gf180mcu_as_sc_mcu7t3v3__inv_2
Xgf180mcu_as_sc_mcu7t3v3__inv_2_675 VSS gf180mcu_as_sc_mcu7t3v3__inv_2_679/VDD gf180mcu_as_sc_mcu7t3v3__inv_2_675/Y
+ VSS gf180mcu_as_sc_mcu7t3v3__inv_2_675/VNW VSUBS gf180mcu_as_sc_mcu7t3v3__inv_2
Xgf180mcu_as_sc_mcu7t3v3__inv_2_664 VSS VSS gf180mcu_as_sc_mcu7t3v3__inv_2_664/Y VSS
+ gf180mcu_as_sc_mcu7t3v3__inv_2_680/VNW VSUBS gf180mcu_as_sc_mcu7t3v3__inv_2
Xgf180mcu_as_sc_mcu7t3v3__inv_2_653 VSS gf180mcu_as_sc_mcu7t3v3__inv_2_659/VDD gf180mcu_as_sc_mcu7t3v3__inv_2_653/Y
+ gf180mcu_as_sc_mcu7t3v3__inv_2_661/A gf180mcu_as_sc_mcu7t3v3__inv_2_655/VNW VSUBS
+ gf180mcu_as_sc_mcu7t3v3__inv_2
Xgf180mcu_as_sc_mcu7t3v3__inv_2_642 VSS gf180mcu_as_sc_mcu7t3v3__inv_2_647/VDD gf180mcu_as_sc_mcu7t3v3__inv_2_739/A
+ gf180mcu_as_sc_mcu7t3v3__inv_2_643/Y gf180mcu_as_sc_mcu7t3v3__inv_2_643/VNW VSUBS
+ gf180mcu_as_sc_mcu7t3v3__inv_2
Xgf180mcu_as_sc_mcu7t3v3__inv_2_686 gf180mcu_as_sc_mcu7t3v3__inv_2_687/VDD VSS gf180mcu_as_sc_mcu7t3v3__inv_2_739/A
+ gf180mcu_as_sc_mcu7t3v3__inv_2_687/Y gf180mcu_as_sc_mcu7t3v3__inv_2_687/VNW VSUBS
+ gf180mcu_as_sc_mcu7t3v3__inv_2
Xgf180mcu_as_sc_mcu7t3v3__inv_2_697 VSS VSS gf180mcu_as_sc_mcu7t3v3__inv_2_697/Y gf180mcu_as_sc_mcu7t3v3__inv_2_739/A
+ gf180mcu_as_sc_mcu7t3v3__inv_2_699/VNW VSUBS gf180mcu_as_sc_mcu7t3v3__inv_2
Xu_t014_019 u_t014_019/c0_w0_bl u_t014_019/c0_w0_br u_t014_019/c0_w1_bl u_t014_019/c0_w1_br
+ u_t014_019/c0_r0_rbl u_t014_019/c0_r1_rbl u_t014_019/c1_w0_bl u_t014_019/c1_w0_br
+ u_t014_019/c1_w1_bl u_t014_019/c1_w1_br u_t014_019/c1_r0_rbl u_t014_019/c1_r1_rbl
+ u_t014_019/c2_w0_bl u_t014_019/c2_w0_br u_t014_019/c2_w1_bl u_t014_019/c2_w1_br
+ u_t014_019/c2_r0_rbl u_t014_019/c2_r1_rbl u_t014_019/c3_w0_bl u_t014_019/c3_w0_br
+ u_t014_019/c3_w1_bl u_t014_019/c3_w1_br u_t014_019/c3_r0_rbl u_t014_019/c3_r1_rbl
+ u_t014_019/r0_w0_wl u_t014_019/r0_w1_wl u_t014_019/r0_r0_rwl u_t014_019/r0_r1_rwl
+ u_t014_019/r1_w0_wl u_t014_019/r1_w1_wl u_t014_019/r1_r0_rwl u_t014_019/r1_r1_rwl
+ u_t014_019/r2_w0_wl u_t014_019/r2_w1_wl u_t014_019/r2_r0_rwl u_t014_019/r2_r1_rwl
+ u_t014_019/r3_w0_wl u_t014_019/r3_w1_wl u_t014_019/r3_r0_rwl u_t014_019/r3_r1_rwl
+ u_t014_019/VDD u_t014_019/VSS VSUBS detronyx_12t_2w2r_rc4_4x4_routed_5layer_direct
Xu_t014_008 u_t014_008/c0_w0_bl u_t014_008/c0_w0_br u_t014_008/c0_w1_bl u_t014_008/c0_w1_br
+ u_t014_008/c0_r0_rbl u_t014_008/c0_r1_rbl u_t014_008/c1_w0_bl u_t014_008/c1_w0_br
+ u_t014_008/c1_w1_bl u_t014_008/c1_w1_br u_t014_008/c1_r0_rbl u_t014_008/c1_r1_rbl
+ u_t014_008/c2_w0_bl u_t014_008/c2_w0_br u_t014_008/c2_w1_bl u_t014_008/c2_w1_br
+ u_t014_008/c2_r0_rbl u_t014_008/c2_r1_rbl u_t014_008/c3_w0_bl u_t014_008/c3_w0_br
+ u_t014_008/c3_w1_bl u_t014_008/c3_w1_br u_t014_008/c3_r0_rbl u_t014_008/c3_r1_rbl
+ u_t014_008/r0_w0_wl u_t014_008/r0_w1_wl u_t014_008/r0_r0_rwl u_t014_008/r0_r1_rwl
+ u_t014_008/r1_w0_wl u_t014_008/r1_w1_wl u_t014_008/r1_r0_rwl u_t014_008/r1_r1_rwl
+ u_t014_008/r2_w0_wl u_t014_008/r2_w1_wl u_t014_008/r2_r0_rwl u_t014_008/r2_r1_rwl
+ u_t014_008/r3_w0_wl u_t014_008/r3_w1_wl u_t014_008/r3_r0_rwl u_t014_008/r3_r1_rwl
+ VSS u_t014_009/VSS VSUBS detronyx_12t_2w2r_rc4_4x4_routed_5layer_direct
Xu_t022_030 u_t022_030/c0_w0_bl u_t022_030/c0_w0_br u_t022_030/c0_w1_bl u_t022_030/c0_w1_br
+ u_t022_030/c0_r0_rbl u_t022_030/c0_r1_rbl u_t022_030/c1_w0_bl u_t022_030/c1_w0_br
+ u_t022_030/c1_w1_bl u_t022_030/c1_w1_br u_t022_030/c1_r0_rbl u_t022_030/c1_r1_rbl
+ u_t022_030/c2_w0_bl u_t022_030/c2_w0_br u_t022_030/c2_w1_bl u_t022_030/c2_w1_br
+ u_t022_030/c2_r0_rbl u_t022_030/c2_r1_rbl u_t022_030/c3_w0_bl u_t022_030/c3_w0_br
+ u_t022_030/c3_w1_bl u_t022_030/c3_w1_br u_t022_030/c3_r0_rbl u_t022_030/c3_r1_rbl
+ u_t022_030/r0_w0_wl u_t022_030/r0_w1_wl u_t022_030/r0_r0_rwl u_t022_030/r0_r1_rwl
+ u_t022_030/r1_w0_wl u_t022_030/r1_w1_wl u_t022_030/r1_r0_rwl u_t022_030/r1_r1_rwl
+ u_t022_030/r2_w0_wl u_t022_030/r2_w1_wl u_t022_030/r2_r0_rwl u_t022_030/r2_r1_rwl
+ u_t022_030/r3_w0_wl u_t022_030/r3_w1_wl u_t022_030/r3_r0_rwl u_t022_030/r3_r1_rwl
+ VSS u_t022_031/VSS VSUBS detronyx_12t_2w2r_rc4_4x4_routed_5layer_direct
Xu_t013_030 u_t013_030/c0_w0_bl u_t013_030/c0_w0_br u_t013_030/c0_w1_bl u_t013_030/c0_w1_br
+ u_t013_030/c0_r0_rbl u_t013_030/c0_r1_rbl u_t013_030/c1_w0_bl u_t013_030/c1_w0_br
+ u_t013_030/c1_w1_bl u_t013_030/c1_w1_br u_t013_030/c1_r0_rbl u_t013_030/c1_r1_rbl
+ u_t013_030/c2_w0_bl u_t013_030/c2_w0_br u_t013_030/c2_w1_bl u_t013_030/c2_w1_br
+ u_t013_030/c2_r0_rbl u_t013_030/c2_r1_rbl u_t013_030/c3_w0_bl u_t013_030/c3_w0_br
+ u_t013_030/c3_w1_bl u_t013_030/c3_w1_br u_t013_030/c3_r0_rbl u_t013_030/c3_r1_rbl
+ u_t013_030/r0_w0_wl u_t013_030/r0_w1_wl u_t013_030/r0_r0_rwl u_t013_030/r0_r1_rwl
+ u_t013_030/r1_w0_wl u_t013_030/r1_w1_wl u_t013_030/r1_r0_rwl u_t013_030/r1_r1_rwl
+ u_t013_030/r2_w0_wl u_t013_030/r2_w1_wl u_t013_030/r2_r0_rwl u_t013_030/r2_r1_rwl
+ u_t013_030/r3_w0_wl u_t013_030/r3_w1_wl u_t013_030/r3_r0_rwl u_t013_030/r3_r1_rwl
+ VSS u_t013_031/VSS VSUBS detronyx_12t_2w2r_rc4_4x4_routed_5layer_direct
Xu_t005_019 u_t005_019/c0_w0_bl u_t005_019/c0_w0_br u_t005_019/c0_w1_bl u_t005_019/c0_w1_br
+ u_t005_019/c0_r0_rbl u_t005_019/c0_r1_rbl u_t005_019/c1_w0_bl u_t005_019/c1_w0_br
+ u_t005_019/c1_w1_bl u_t005_019/c1_w1_br u_t005_019/c1_r0_rbl u_t005_019/c1_r1_rbl
+ u_t005_019/c2_w0_bl u_t005_019/c2_w0_br u_t005_019/c2_w1_bl u_t005_019/c2_w1_br
+ u_t005_019/c2_r0_rbl u_t005_019/c2_r1_rbl u_t005_019/c3_w0_bl u_t005_019/c3_w0_br
+ u_t005_019/c3_w1_bl u_t005_019/c3_w1_br u_t005_019/c3_r0_rbl u_t005_019/c3_r1_rbl
+ u_t005_019/r0_w0_wl u_t005_019/r0_w1_wl u_t005_019/r0_r0_rwl u_t005_019/r0_r1_rwl
+ u_t005_019/r1_w0_wl u_t005_019/r1_w1_wl u_t005_019/r1_r0_rwl u_t005_019/r1_r1_rwl
+ u_t005_019/r2_w0_wl u_t005_019/r2_w1_wl u_t005_019/r2_r0_rwl u_t005_019/r2_r1_rwl
+ u_t005_019/r3_w0_wl u_t005_019/r3_w1_wl u_t005_019/r3_r0_rwl u_t005_019/r3_r1_rwl
+ u_t005_019/VDD u_t005_031/VSS VSUBS detronyx_12t_2w2r_rc4_4x4_routed_5layer_direct
Xu_t005_008 u_t005_008/c0_w0_bl u_t005_008/c0_w0_br u_t005_008/c0_w1_bl u_t005_008/c0_w1_br
+ u_t005_008/c0_r0_rbl u_t005_008/c0_r1_rbl u_t005_008/c1_w0_bl u_t005_008/c1_w0_br
+ u_t005_008/c1_w1_bl u_t005_008/c1_w1_br u_t005_008/c1_r0_rbl u_t005_008/c1_r1_rbl
+ u_t005_008/c2_w0_bl u_t005_008/c2_w0_br u_t005_008/c2_w1_bl u_t005_008/c2_w1_br
+ u_t005_008/c2_r0_rbl u_t005_008/c2_r1_rbl u_t005_008/c3_w0_bl u_t005_008/c3_w0_br
+ u_t005_008/c3_w1_bl u_t005_008/c3_w1_br u_t005_008/c3_r0_rbl u_t005_008/c3_r1_rbl
+ u_t005_008/r0_w0_wl u_t005_008/r0_w1_wl u_t005_008/r0_r0_rwl u_t005_008/r0_r1_rwl
+ u_t005_008/r1_w0_wl u_t005_008/r1_w1_wl u_t005_008/r1_r0_rwl u_t005_008/r1_r1_rwl
+ u_t005_008/r2_w0_wl u_t005_008/r2_w1_wl u_t005_008/r2_r0_rwl u_t005_008/r2_r1_rwl
+ u_t005_008/r3_w0_wl u_t005_008/r3_w1_wl u_t005_008/r3_r0_rwl u_t005_008/r3_r1_rwl
+ VSS u_t005_031/VSS VSUBS detronyx_12t_2w2r_rc4_4x4_routed_5layer_direct
Xgf180mcu_as_sc_mcu7t3v3__inv_2_450 VSS VSS gf180mcu_as_sc_mcu7t3v3__inv_2_450/Y VSS
+ gf180mcu_as_sc_mcu7t3v3__inv_2_450/VNW VSUBS gf180mcu_as_sc_mcu7t3v3__inv_2
Xgf180mcu_as_sc_mcu7t3v3__inv_2_472 gf180mcu_as_sc_mcu7t3v3__nor2_2_5/VDD gf180mcu_as_sc_mcu7t3v3__nand3_2_8/VSS
+ gf180mcu_as_sc_mcu7t3v3__inv_2_472/Y VSS gf180mcu_as_sc_mcu7t3v3__nor2_2_5/VNW VSUBS
+ gf180mcu_as_sc_mcu7t3v3__inv_2
Xgf180mcu_as_sc_mcu7t3v3__inv_2_461 gf180mcu_as_sc_mcu7t3v3__nor2_2_5/VDD gf180mcu_as_sc_mcu7t3v3__nand3_2_8/VSS
+ VSS VSS gf180mcu_as_sc_mcu7t3v3__nor2_2_5/VNW VSUBS gf180mcu_as_sc_mcu7t3v3__inv_2
Xu_t004_030 u_t004_030/c0_w0_bl u_t004_030/c0_w0_br u_t004_030/c0_w1_bl u_t004_030/c0_w1_br
+ u_t004_030/c0_r0_rbl u_t004_030/c0_r1_rbl u_t004_030/c1_w0_bl u_t004_030/c1_w0_br
+ u_t004_030/c1_w1_bl u_t004_030/c1_w1_br u_t004_030/c1_r0_rbl u_t004_030/c1_r1_rbl
+ u_t004_030/c2_w0_bl u_t004_030/c2_w0_br u_t004_030/c2_w1_bl u_t004_030/c2_w1_br
+ u_t004_030/c2_r0_rbl u_t004_030/c2_r1_rbl u_t004_030/c3_w0_bl u_t004_030/c3_w0_br
+ u_t004_030/c3_w1_bl u_t004_030/c3_w1_br u_t004_030/c3_r0_rbl u_t004_030/c3_r1_rbl
+ u_t004_030/r0_w0_wl u_t004_030/r0_w1_wl u_t004_030/r0_r0_rwl u_t004_030/r0_r1_rwl
+ u_t004_030/r1_w0_wl u_t004_030/r1_w1_wl u_t004_030/r1_r0_rwl u_t004_030/r1_r1_rwl
+ u_t004_030/r2_w0_wl u_t004_030/r2_w1_wl u_t004_030/r2_r0_rwl u_t004_030/r2_r1_rwl
+ u_t004_030/r3_w0_wl u_t004_030/r3_w1_wl u_t004_030/r3_r0_rwl u_t004_030/r3_r1_rwl
+ VSS u_t004_031/VSS VSUBS detronyx_12t_2w2r_rc4_4x4_routed_5layer_direct
Xgf180mcu_as_sc_mcu7t3v3__inv_2_483 gf180mcu_as_sc_mcu7t3v3__nor2_2_5/VDD gf180mcu_as_sc_mcu7t3v3__nand3_2_8/VSS
+ VSS VSS gf180mcu_as_sc_mcu7t3v3__nor2_2_5/VNW VSUBS gf180mcu_as_sc_mcu7t3v3__inv_2
Xgf180mcu_as_sc_mcu7t3v3__inv_2_494 gf180mcu_as_sc_mcu7t3v3__nor2_2_6/VDD gf180mcu_as_sc_mcu7t3v3__nor2_2_6/VSS
+ VSS VSS gf180mcu_as_sc_mcu7t3v3__nor2_2_6/VNW VSUBS gf180mcu_as_sc_mcu7t3v3__inv_2
Xu_t010_011 u_t010_011/c0_w0_bl u_t010_011/c0_w0_br u_t010_011/c0_w1_bl u_t010_011/c0_w1_br
+ u_t010_011/c0_r0_rbl u_t010_011/c0_r1_rbl u_t010_011/c1_w0_bl u_t010_011/c1_w0_br
+ u_t010_011/c1_w1_bl u_t010_011/c1_w1_br u_t010_011/c1_r0_rbl u_t010_011/c1_r1_rbl
+ u_t010_011/c2_w0_bl u_t010_011/c2_w0_br u_t010_011/c2_w1_bl u_t010_011/c2_w1_br
+ u_t010_011/c2_r0_rbl u_t010_011/c2_r1_rbl u_t010_011/c3_w0_bl u_t010_011/c3_w0_br
+ u_t010_011/c3_w1_bl u_t010_011/c3_w1_br u_t010_011/c3_r0_rbl u_t010_011/c3_r1_rbl
+ u_t010_011/r0_w0_wl u_t010_011/r0_w1_wl u_t010_011/r0_r0_rwl u_t010_011/r0_r1_rwl
+ u_t010_011/r1_w0_wl u_t010_011/r1_w1_wl u_t010_011/r1_r0_rwl u_t010_011/r1_r1_rwl
+ u_t010_011/r2_w0_wl u_t010_011/r2_w1_wl u_t010_011/r2_r0_rwl u_t010_011/r2_r1_rwl
+ u_t010_011/r3_w0_wl u_t010_011/r3_w1_wl u_t010_011/r3_r0_rwl u_t010_011/r3_r1_rwl
+ u_t010_011/VDD u_t010_011/VSS VSUBS detronyx_12t_2w2r_rc4_4x4_routed_5layer_direct
Xu_t010_000 u_t010_000/c0_w0_bl u_t010_000/c0_w0_br u_t010_000/c0_w1_bl u_t010_000/c0_w1_br
+ u_t010_000/c0_r0_rbl u_t010_000/c0_r1_rbl u_t010_000/c1_w0_bl u_t010_000/c1_w0_br
+ u_t010_000/c1_w1_bl u_t010_000/c1_w1_br u_t010_000/c1_r0_rbl u_t010_000/c1_r1_rbl
+ u_t010_000/c2_w0_bl u_t010_000/c2_w0_br u_t010_000/c2_w1_bl u_t010_000/c2_w1_br
+ u_t010_000/c2_r0_rbl u_t010_000/c2_r1_rbl u_t010_000/c3_w0_bl u_t010_000/c3_w0_br
+ u_t010_000/c3_w1_bl u_t010_000/c3_w1_br u_t010_000/c3_r0_rbl u_t010_000/c3_r1_rbl
+ u_t010_000/r0_w0_wl u_t010_000/r0_w1_wl u_t010_000/r0_r0_rwl u_t010_000/r0_r1_rwl
+ u_t010_000/r1_w0_wl u_t010_000/r1_w1_wl u_t010_000/r1_r0_rwl u_t010_000/r1_r1_rwl
+ u_t010_000/r2_w0_wl u_t010_000/r2_w1_wl u_t010_000/r2_r0_rwl u_t010_000/r2_r1_rwl
+ u_t010_000/r3_w0_wl u_t010_000/r3_w1_wl u_t010_000/r3_r0_rwl u_t010_000/r3_r1_rwl
+ VSS u_t010_002/VSS VSUBS detronyx_12t_2w2r_rc4_4x4_routed_5layer_direct
Xu_t010_022 u_t010_022/c0_w0_bl u_t010_022/c0_w0_br u_t010_022/c0_w1_bl u_t010_022/c0_w1_br
+ u_t010_022/c0_r0_rbl u_t010_022/c0_r1_rbl u_t010_022/c1_w0_bl u_t010_022/c1_w0_br
+ u_t010_022/c1_w1_bl u_t010_022/c1_w1_br u_t010_022/c1_r0_rbl u_t010_022/c1_r1_rbl
+ u_t010_022/c2_w0_bl u_t010_022/c2_w0_br u_t010_022/c2_w1_bl u_t010_022/c2_w1_br
+ u_t010_022/c2_r0_rbl u_t010_022/c2_r1_rbl u_t010_022/c3_w0_bl u_t010_022/c3_w0_br
+ u_t010_022/c3_w1_bl u_t010_022/c3_w1_br u_t010_022/c3_r0_rbl u_t010_022/c3_r1_rbl
+ u_t010_022/r0_w0_wl u_t010_022/r0_w1_wl u_t010_022/r0_r0_rwl u_t010_022/r0_r1_rwl
+ u_t010_022/r1_w0_wl u_t010_022/r1_w1_wl u_t010_022/r1_r0_rwl u_t010_022/r1_r1_rwl
+ u_t010_022/r2_w0_wl u_t010_022/r2_w1_wl u_t010_022/r2_r0_rwl u_t010_022/r2_r1_rwl
+ u_t010_022/r3_w0_wl u_t010_022/r3_w1_wl u_t010_022/r3_r0_rwl u_t010_022/r3_r1_rwl
+ VSS u_t010_024/VSS VSUBS detronyx_12t_2w2r_rc4_4x4_routed_5layer_direct
Xu_t001_022 u_t001_022/c0_w0_bl u_t001_022/c0_w0_br u_t001_022/c0_w1_bl u_t001_022/c0_w1_br
+ u_t001_022/c0_r0_rbl u_t001_022/c0_r1_rbl u_t001_022/c1_w0_bl u_t001_022/c1_w0_br
+ u_t001_022/c1_w1_bl u_t001_022/c1_w1_br u_t001_022/c1_r0_rbl u_t001_022/c1_r1_rbl
+ u_t001_022/c2_w0_bl u_t001_022/c2_w0_br u_t001_022/c2_w1_bl u_t001_022/c2_w1_br
+ u_t001_022/c2_r0_rbl u_t001_022/c2_r1_rbl u_t001_022/c3_w0_bl u_t001_022/c3_w0_br
+ u_t001_022/c3_w1_bl u_t001_022/c3_w1_br u_t001_022/c3_r0_rbl u_t001_022/c3_r1_rbl
+ u_t001_022/r0_w0_wl u_t001_022/r0_w1_wl u_t001_022/r0_r0_rwl u_t001_022/r0_r1_rwl
+ u_t001_022/r1_w0_wl u_t001_022/r1_w1_wl u_t001_022/r1_r0_rwl u_t001_022/r1_r1_rwl
+ u_t001_022/r2_w0_wl u_t001_022/r2_w1_wl u_t001_022/r2_r0_rwl u_t001_022/r2_r1_rwl
+ u_t001_022/r3_w0_wl u_t001_022/r3_w1_wl u_t001_022/r3_r0_rwl u_t001_022/r3_r1_rwl
+ VSS u_t001_031/VSS VSUBS detronyx_12t_2w2r_rc4_4x4_routed_5layer_direct
Xu_t001_011 u_t001_011/c0_w0_bl u_t001_011/c0_w0_br u_t001_011/c0_w1_bl u_t001_011/c0_w1_br
+ u_t001_011/c0_r0_rbl u_t001_011/c0_r1_rbl u_t001_011/c1_w0_bl u_t001_011/c1_w0_br
+ u_t001_011/c1_w1_bl u_t001_011/c1_w1_br u_t001_011/c1_r0_rbl u_t001_011/c1_r1_rbl
+ u_t001_011/c2_w0_bl u_t001_011/c2_w0_br u_t001_011/c2_w1_bl u_t001_011/c2_w1_br
+ u_t001_011/c2_r0_rbl u_t001_011/c2_r1_rbl u_t001_011/c3_w0_bl u_t001_011/c3_w0_br
+ u_t001_011/c3_w1_bl u_t001_011/c3_w1_br u_t001_011/c3_r0_rbl u_t001_011/c3_r1_rbl
+ u_t001_011/r0_w0_wl u_t001_011/r0_w1_wl u_t001_011/r0_r0_rwl u_t001_011/r0_r1_rwl
+ u_t001_011/r1_w0_wl u_t001_011/r1_w1_wl u_t001_011/r1_r0_rwl u_t001_011/r1_r1_rwl
+ u_t001_011/r2_w0_wl u_t001_011/r2_w1_wl u_t001_011/r2_r0_rwl u_t001_011/r2_r1_rwl
+ u_t001_011/r3_w0_wl u_t001_011/r3_w1_wl u_t001_011/r3_r0_rwl u_t001_011/r3_r1_rwl
+ u_t001_011/VDD u_t001_031/VSS VSUBS detronyx_12t_2w2r_rc4_4x4_routed_5layer_direct
Xu_t001_000 u_t001_000/c0_w0_bl u_t001_000/c0_w0_br u_t001_000/c0_w1_bl u_t001_000/c0_w1_br
+ u_t001_000/c0_r0_rbl u_t001_000/c0_r1_rbl u_t001_000/c1_w0_bl u_t001_000/c1_w0_br
+ u_t001_000/c1_w1_bl u_t001_000/c1_w1_br u_t001_000/c1_r0_rbl u_t001_000/c1_r1_rbl
+ u_t001_000/c2_w0_bl u_t001_000/c2_w0_br u_t001_000/c2_w1_bl u_t001_000/c2_w1_br
+ u_t001_000/c2_r0_rbl u_t001_000/c2_r1_rbl u_t001_000/c3_w0_bl u_t001_000/c3_w0_br
+ u_t001_000/c3_w1_bl u_t001_000/c3_w1_br u_t001_000/c3_r0_rbl u_t001_000/c3_r1_rbl
+ u_t001_000/r0_w0_wl u_t001_000/r0_w1_wl u_t001_000/r0_r0_rwl u_t001_000/r0_r1_rwl
+ u_t001_000/r1_w0_wl u_t001_000/r1_w1_wl u_t001_000/r1_r0_rwl u_t001_000/r1_r1_rwl
+ u_t001_000/r2_w0_wl u_t001_000/r2_w1_wl u_t001_000/r2_r0_rwl u_t001_000/r2_r1_rwl
+ u_t001_000/r3_w0_wl u_t001_000/r3_w1_wl u_t001_000/r3_r0_rwl u_t001_000/r3_r1_rwl
+ VSS u_t001_031/VSS VSUBS detronyx_12t_2w2r_rc4_4x4_routed_5layer_direct
Xgf180mcu_as_sc_mcu7t3v3__inv_2_291 gf180mcu_as_sc_mcu7t3v3__inv_2_363/VDD gf180mcu_as_sc_mcu7t3v3__inv_2_364/VDD
+ VSS gf180mcu_as_sc_mcu7t3v3__inv_2_364/Y gf180mcu_as_sc_mcu7t3v3__inv_2_363/VNW
+ VSUBS gf180mcu_as_sc_mcu7t3v3__inv_2
Xgf180mcu_as_sc_mcu7t3v3__inv_2_280 gf180mcu_as_sc_mcu7t3v3__inv_2_359/VDD gf180mcu_as_sc_mcu7t3v3__inv_2_360/VDD
+ gf180mcu_as_sc_mcu7t3v3__inv_2_361/Y gf180mcu_as_sc_mcu7t3v3__inv_2_361/Y gf180mcu_as_sc_mcu7t3v3__inv_2_359/VNW
+ VSUBS gf180mcu_as_sc_mcu7t3v3__inv_2
Xgf180mcu_as_sc_mcu7t3v3__nand4_2_507 VSS gf180mcu_as_sc_mcu7t3v3__inv_2_1682/VSS
+ VSS VSS VSS VSS VSS gf180mcu_as_sc_mcu7t3v3__inv_2_1682/VNW VSUBS gf180mcu_as_sc_mcu7t3v3__nand4_2
Xgf180mcu_as_sc_mcu7t3v3__inv_2_17 gf180mcu_as_sc_mcu7t3v3__inv_2_9/VSS gf180mcu_as_sc_mcu7t3v3__inv_2_0/VSS
+ VSS gf180mcu_as_sc_mcu7t3v3__inv_2_9/A gf180mcu_as_sc_mcu7t3v3__inv_2_0/VNW VSUBS
+ gf180mcu_as_sc_mcu7t3v3__inv_2
Xgf180mcu_as_sc_mcu7t3v3__inv_2_28 gf180mcu_as_sc_mcu7t3v3__inv_2_77/VSS VSS gf180mcu_as_sc_mcu7t3v3__inv_2_77/Y
+ gf180mcu_as_sc_mcu7t3v3__inv_2_77/Y gf180mcu_as_sc_mcu7t3v3__inv_2_59/VNW VSUBS
+ gf180mcu_as_sc_mcu7t3v3__inv_2
Xgf180mcu_as_sc_mcu7t3v3__inv_2_39 VSS gf180mcu_as_sc_mcu7t3v3__inv_2_77/VDD VSS gf180mcu_as_sc_mcu7t3v3__inv_2_77/Y
+ gf180mcu_as_sc_mcu7t3v3__inv_2_76/VNW VSUBS gf180mcu_as_sc_mcu7t3v3__inv_2
Xgf180mcu_as_sc_mcu7t3v3__inv_2_1009 gf180mcu_as_sc_mcu7t3v3__inv_2_1011/VDD gf180mcu_as_sc_mcu7t3v3__inv_2_1016/VDD
+ VSS gf180mcu_as_sc_mcu7t3v3__inv_2_1294/Y gf180mcu_as_sc_mcu7t3v3__inv_2_1011/VNW
+ VSUBS gf180mcu_as_sc_mcu7t3v3__inv_2
Xgf180mcu_as_sc_mcu7t3v3__inv_2_1510 gf180mcu_as_sc_mcu7t3v3__inv_2_1552/VSS gf180mcu_as_sc_mcu7t3v3__inv_2_1514/VDD
+ gf180mcu_as_sc_mcu7t3v3__inv_2_1510/Y VSS gf180mcu_as_sc_mcu7t3v3__inv_2_1510/VNW
+ VSUBS gf180mcu_as_sc_mcu7t3v3__inv_2
Xgf180mcu_as_sc_mcu7t3v3__inv_2_1565 gf180mcu_as_sc_mcu7t3v3__inv_2_1565/VDD gf180mcu_as_sc_mcu7t3v3__inv_2_1569/VDD
+ gf180mcu_as_sc_mcu7t3v3__inv_2_1565/Y VSS gf180mcu_as_sc_mcu7t3v3__inv_2_1565/VNW
+ VSUBS gf180mcu_as_sc_mcu7t3v3__inv_2
Xgf180mcu_as_sc_mcu7t3v3__inv_2_1576 gf180mcu_as_sc_mcu7t3v3__inv_2_1577/VDD gf180mcu_as_sc_mcu7t3v3__inv_2_1581/VDD
+ gf180mcu_as_sc_mcu7t3v3__inv_2_1576/Y VSS gf180mcu_as_sc_mcu7t3v3__inv_2_1577/VNW
+ VSUBS gf180mcu_as_sc_mcu7t3v3__inv_2
Xgf180mcu_as_sc_mcu7t3v3__inv_2_1587 gf180mcu_as_sc_mcu7t3v3__inv_2_1589/VDD gf180mcu_as_sc_mcu7t3v3__inv_2_1589/VSS
+ VSS VSS gf180mcu_as_sc_mcu7t3v3__inv_2_1589/VNW VSUBS gf180mcu_as_sc_mcu7t3v3__inv_2
Xgf180mcu_as_sc_mcu7t3v3__inv_2_1554 gf180mcu_as_sc_mcu7t3v3__inv_2_1586/VSS VSS gf180mcu_as_sc_mcu7t3v3__inv_2_1554/Y
+ VSS gf180mcu_as_sc_mcu7t3v3__inv_2_1574/VNW VSUBS gf180mcu_as_sc_mcu7t3v3__inv_2
Xgf180mcu_as_sc_mcu7t3v3__inv_2_1521 gf180mcu_as_sc_mcu7t3v3__inv_2_1548/VSS VSS VSS
+ VSS gf180mcu_as_sc_mcu7t3v3__inv_2_1525/VNW VSUBS gf180mcu_as_sc_mcu7t3v3__inv_2
Xgf180mcu_as_sc_mcu7t3v3__inv_2_1598 VSS gf180mcu_as_sc_mcu7t3v3__inv_2_1653/VDD VSS
+ gf180mcu_as_sc_mcu7t3v3__inv_2_1682/Y gf180mcu_as_sc_mcu7t3v3__inv_2_1652/VNW VSUBS
+ gf180mcu_as_sc_mcu7t3v3__inv_2
Xgf180mcu_as_sc_mcu7t3v3__inv_2_1543 VSS VSS VSS VSS gf180mcu_as_sc_mcu7t3v3__inv_2_1543/VNW
+ VSUBS gf180mcu_as_sc_mcu7t3v3__inv_2
Xgf180mcu_as_sc_mcu7t3v3__inv_2_1532 VSS gf180mcu_as_sc_mcu7t3v3__inv_2_1532/VSS gf180mcu_as_sc_mcu7t3v3__inv_2_1532/Y
+ VSS gf180mcu_as_sc_mcu7t3v3__inv_2_1532/VNW VSUBS gf180mcu_as_sc_mcu7t3v3__inv_2
Xgf180mcu_as_sc_mcu7t3v3__nand3_2_9 gf180mcu_as_sc_mcu7t3v3__nor2_2_4/VDD gf180mcu_as_sc_mcu7t3v3__nor2_2_4/VSS
+ VSS VSS VSS VSS gf180mcu_as_sc_mcu7t3v3__nor2_2_4/VNW VSUBS gf180mcu_as_sc_mcu7t3v3__nand3_2
Xgf180mcu_as_sc_mcu7t3v3__nand4_2_326 VSS gf180mcu_as_sc_mcu7t3v3__inv_2_1096/VDD
+ VSS VSS VSS VSS VSS gf180mcu_as_sc_mcu7t3v3__inv_2_1092/VNW VSUBS gf180mcu_as_sc_mcu7t3v3__nand4_2
Xgf180mcu_as_sc_mcu7t3v3__nand4_2_315 VSS VSS VSS VSS VSS VSS VSS gf180mcu_as_sc_mcu7t3v3__inv_2_1051/VNW
+ VSUBS gf180mcu_as_sc_mcu7t3v3__nand4_2
Xgf180mcu_as_sc_mcu7t3v3__nand4_2_304 gf180mcu_as_sc_mcu7t3v3__inv_2_1034/VDD VSS
+ VSS VSS VSS VSS VSS gf180mcu_as_sc_mcu7t3v3__inv_2_1034/VNW VSUBS gf180mcu_as_sc_mcu7t3v3__nand4_2
Xgf180mcu_as_sc_mcu7t3v3__nand4_2_337 VSS gf180mcu_as_sc_mcu7t3v3__inv_2_1132/VDD
+ VSS VSS VSS VSS VSS gf180mcu_as_sc_mcu7t3v3__inv_2_1129/VNW VSUBS gf180mcu_as_sc_mcu7t3v3__nand4_2
Xgf180mcu_as_sc_mcu7t3v3__nand4_2_359 VSS VSS VSS VSS VSS VSS gf180mcu_as_sc_mcu7t3v3__nand4_2_359/Y
+ gf180mcu_as_sc_mcu7t3v3__inv_2_1237/VNW VSUBS gf180mcu_as_sc_mcu7t3v3__nand4_2
Xgf180mcu_as_sc_mcu7t3v3__nand4_2_348 VSS VSS VSS VSS VSS VSS VSS gf180mcu_as_sc_mcu7t3v3__inv_2_1168/VNW
+ VSUBS gf180mcu_as_sc_mcu7t3v3__nand4_2
Xu_t029_025 u_t029_025/c0_w0_bl u_t029_025/c0_w0_br u_t029_025/c0_w1_bl u_t029_025/c0_w1_br
+ u_t029_025/c0_r0_rbl u_t029_025/c0_r1_rbl u_t029_025/c1_w0_bl u_t029_025/c1_w0_br
+ u_t029_025/c1_w1_bl u_t029_025/c1_w1_br u_t029_025/c1_r0_rbl u_t029_025/c1_r1_rbl
+ u_t029_025/c2_w0_bl u_t029_025/c2_w0_br u_t029_025/c2_w1_bl u_t029_025/c2_w1_br
+ u_t029_025/c2_r0_rbl u_t029_025/c2_r1_rbl u_t029_025/c3_w0_bl u_t029_025/c3_w0_br
+ u_t029_025/c3_w1_bl u_t029_025/c3_w1_br u_t029_025/c3_r0_rbl u_t029_025/c3_r1_rbl
+ u_t029_025/r0_w0_wl u_t029_025/r0_w1_wl u_t029_025/r0_r0_rwl u_t029_025/r0_r1_rwl
+ u_t029_025/r1_w0_wl u_t029_025/r1_w1_wl u_t029_025/r1_r0_rwl u_t029_025/r1_r1_rwl
+ u_t029_025/r2_w0_wl u_t029_025/r2_w1_wl u_t029_025/r2_r0_rwl u_t029_025/r2_r1_rwl
+ u_t029_025/r3_w0_wl u_t029_025/r3_w1_wl u_t029_025/r3_r0_rwl u_t029_025/r3_r1_rwl
+ VSS u_t029_031/VSS VSUBS detronyx_12t_2w2r_rc4_4x4_routed_5layer_direct
Xu_t029_014 u_t029_014/c0_w0_bl u_t029_014/c0_w0_br u_t029_014/c0_w1_bl u_t029_014/c0_w1_br
+ u_t029_014/c0_r0_rbl u_t029_014/c0_r1_rbl u_t029_014/c1_w0_bl u_t029_014/c1_w0_br
+ u_t029_014/c1_w1_bl u_t029_014/c1_w1_br u_t029_014/c1_r0_rbl u_t029_014/c1_r1_rbl
+ u_t029_014/c2_w0_bl u_t029_014/c2_w0_br u_t029_014/c2_w1_bl u_t029_014/c2_w1_br
+ u_t029_014/c2_r0_rbl u_t029_014/c2_r1_rbl u_t029_014/c3_w0_bl u_t029_014/c3_w0_br
+ u_t029_014/c3_w1_bl u_t029_014/c3_w1_br u_t029_014/c3_r0_rbl u_t029_014/c3_r1_rbl
+ u_t029_014/r0_w0_wl u_t029_014/r0_w1_wl u_t029_014/r0_r0_rwl u_t029_014/r0_r1_rwl
+ u_t029_014/r1_w0_wl u_t029_014/r1_w1_wl u_t029_014/r1_r0_rwl u_t029_014/r1_r1_rwl
+ u_t029_014/r2_w0_wl u_t029_014/r2_w1_wl u_t029_014/r2_r0_rwl u_t029_014/r2_r1_rwl
+ u_t029_014/r3_w0_wl u_t029_014/r3_w1_wl u_t029_014/r3_r0_rwl u_t029_014/r3_r1_rwl
+ u_t029_014/VDD u_t029_031/VSS VSUBS detronyx_12t_2w2r_rc4_4x4_routed_5layer_direct
Xu_t029_003 u_t029_003/c0_w0_bl u_t029_003/c0_w0_br u_t029_003/c0_w1_bl u_t029_003/c0_w1_br
+ u_t029_003/c0_r0_rbl u_t029_003/c0_r1_rbl u_t029_003/c1_w0_bl u_t029_003/c1_w0_br
+ u_t029_003/c1_w1_bl u_t029_003/c1_w1_br u_t029_003/c1_r0_rbl u_t029_003/c1_r1_rbl
+ u_t029_003/c2_w0_bl u_t029_003/c2_w0_br u_t029_003/c2_w1_bl u_t029_003/c2_w1_br
+ u_t029_003/c2_r0_rbl u_t029_003/c2_r1_rbl u_t029_003/c3_w0_bl u_t029_003/c3_w0_br
+ u_t029_003/c3_w1_bl u_t029_003/c3_w1_br u_t029_003/c3_r0_rbl u_t029_003/c3_r1_rbl
+ u_t029_003/r0_w0_wl u_t029_003/r0_w1_wl u_t029_003/r0_r0_rwl u_t029_003/r0_r1_rwl
+ u_t029_003/r1_w0_wl u_t029_003/r1_w1_wl u_t029_003/r1_r0_rwl u_t029_003/r1_r1_rwl
+ u_t029_003/r2_w0_wl u_t029_003/r2_w1_wl u_t029_003/r2_r0_rwl u_t029_003/r2_r1_rwl
+ u_t029_003/r3_w0_wl u_t029_003/r3_w1_wl u_t029_003/r3_r0_rwl u_t029_003/r3_r1_rwl
+ u_t029_003/VDD u_t029_031/VSS VSUBS detronyx_12t_2w2r_rc4_4x4_routed_5layer_direct
Xgf180mcu_as_sc_mcu7t3v3__inv_2_1351 VSS gf180mcu_as_sc_mcu7t3v3__inv_2_1383/VDD gf180mcu_as_sc_mcu7t3v3__inv_2_1384/Y
+ gf180mcu_as_sc_mcu7t3v3__inv_2_1384/Y gf180mcu_as_sc_mcu7t3v3__inv_2_1382/VNW VSUBS
+ gf180mcu_as_sc_mcu7t3v3__inv_2
Xgf180mcu_as_sc_mcu7t3v3__inv_2_1362 VSS gf180mcu_as_sc_mcu7t3v3__inv_2_1387/VDD VSS
+ gf180mcu_as_sc_mcu7t3v3__inv_2_1387/Y gf180mcu_as_sc_mcu7t3v3__inv_2_1386/VNW VSUBS
+ gf180mcu_as_sc_mcu7t3v3__inv_2
Xgf180mcu_as_sc_mcu7t3v3__inv_2_1340 gf180mcu_as_sc_mcu7t3v3__inv_2_1390/VDD gf180mcu_as_sc_mcu7t3v3__inv_2_1391/VDD
+ VSS gf180mcu_as_sc_mcu7t3v3__inv_2_1398/Y gf180mcu_as_sc_mcu7t3v3__inv_2_1390/VNW
+ VSUBS gf180mcu_as_sc_mcu7t3v3__inv_2
Xgf180mcu_as_sc_mcu7t3v3__inv_2_1384 gf180mcu_as_sc_mcu7t3v3__inv_2_1384/VDD VSS gf180mcu_as_sc_mcu7t3v3__inv_2_1384/Y
+ VSS gf180mcu_as_sc_mcu7t3v3__inv_2_1384/VNW VSUBS gf180mcu_as_sc_mcu7t3v3__inv_2
Xgf180mcu_as_sc_mcu7t3v3__inv_2_1373 gf180mcu_as_sc_mcu7t3v3__inv_2_1373/VDD VSS gf180mcu_as_sc_mcu7t3v3__inv_2_1379/Y
+ VSS gf180mcu_as_sc_mcu7t3v3__inv_2_1373/VNW VSUBS gf180mcu_as_sc_mcu7t3v3__inv_2
Xgf180mcu_as_sc_mcu7t3v3__inv_2_1395 gf180mcu_as_sc_mcu7t3v3__inv_2_1398/VSS gf180mcu_as_sc_mcu7t3v3__inv_2_1397/VSS
+ VSS gf180mcu_as_sc_mcu7t3v3__inv_2_1398/Y gf180mcu_as_sc_mcu7t3v3__inv_2_1397/VNW
+ VSUBS gf180mcu_as_sc_mcu7t3v3__inv_2
Xgf180mcu_as_sc_mcu7t3v3__inv_2_802 VSS VSS gf180mcu_as_sc_mcu7t3v3__inv_2_802/Y VSS
+ gf180mcu_as_sc_mcu7t3v3__inv_2_804/VNW VSUBS gf180mcu_as_sc_mcu7t3v3__inv_2
Xgf180mcu_as_sc_mcu7t3v3__inv_2_846 VSS VSS gf180mcu_as_sc_mcu7t3v3__inv_2_846/Y VSS
+ gf180mcu_as_sc_mcu7t3v3__inv_2_846/VNW VSUBS gf180mcu_as_sc_mcu7t3v3__inv_2
Xgf180mcu_as_sc_mcu7t3v3__inv_2_813 VSS VSS VSS VSS gf180mcu_as_sc_mcu7t3v3__inv_2_813/VNW
+ VSUBS gf180mcu_as_sc_mcu7t3v3__inv_2
Xgf180mcu_as_sc_mcu7t3v3__inv_2_835 VSS VSS VSS VSS gf180mcu_as_sc_mcu7t3v3__inv_2_836/VNW
+ VSUBS gf180mcu_as_sc_mcu7t3v3__inv_2
Xgf180mcu_as_sc_mcu7t3v3__inv_2_824 VSS VSS VSS VSS gf180mcu_as_sc_mcu7t3v3__inv_2_824/VNW
+ VSUBS gf180mcu_as_sc_mcu7t3v3__inv_2
Xgf180mcu_as_sc_mcu7t3v3__inv_2_857 VSS VSS gf180mcu_as_sc_mcu7t3v3__inv_2_857/Y VSS
+ gf180mcu_as_sc_mcu7t3v3__inv_2_865/VNW VSUBS gf180mcu_as_sc_mcu7t3v3__inv_2
Xgf180mcu_as_sc_mcu7t3v3__inv_2_879 VSS VSS VSS VSS gf180mcu_as_sc_mcu7t3v3__inv_2_880/VNW
+ VSUBS gf180mcu_as_sc_mcu7t3v3__inv_2
Xgf180mcu_as_sc_mcu7t3v3__inv_2_868 VSS VSS gf180mcu_as_sc_mcu7t3v3__inv_2_868/Y VSS
+ gf180mcu_as_sc_mcu7t3v3__inv_2_868/VNW VSUBS gf180mcu_as_sc_mcu7t3v3__inv_2
Xgf180mcu_as_sc_mcu7t3v3__nand4_2_145 VSS VSS VSS VSS VSS VSS VSS gf180mcu_as_sc_mcu7t3v3__inv_2_518/VNW
+ VSUBS gf180mcu_as_sc_mcu7t3v3__nand4_2
Xgf180mcu_as_sc_mcu7t3v3__nand4_2_156 gf180mcu_as_sc_mcu7t3v3__inv_2_576/VDD gf180mcu_as_sc_mcu7t3v3__inv_2_584/VDD
+ VSS VSS VSS VSS VSS gf180mcu_as_sc_mcu7t3v3__inv_2_576/VNW VSUBS gf180mcu_as_sc_mcu7t3v3__nand4_2
Xgf180mcu_as_sc_mcu7t3v3__nand4_2_167 gf180mcu_as_sc_mcu7t3v3__inv_2_629/VDD gf180mcu_as_sc_mcu7t3v3__inv_2_629/VDD
+ VSS VSS VSS VSS VSS gf180mcu_as_sc_mcu7t3v3__inv_2_625/VNW VSUBS gf180mcu_as_sc_mcu7t3v3__nand4_2
Xgf180mcu_as_sc_mcu7t3v3__nand4_2_134 VSS VSS VSS VSS VSS VSS gf180mcu_as_sc_mcu7t3v3__nand4_2_134/Y
+ gf180mcu_as_sc_mcu7t3v3__inv_2_522/VNW VSUBS gf180mcu_as_sc_mcu7t3v3__nand4_2
Xgf180mcu_as_sc_mcu7t3v3__nand4_2_123 gf180mcu_as_sc_mcu7t3v3__inv_2_371/VDD gf180mcu_as_sc_mcu7t3v3__inv_2_371/VSS
+ VSS VSS VSS VSS VSS gf180mcu_as_sc_mcu7t3v3__inv_2_371/VNW VSUBS gf180mcu_as_sc_mcu7t3v3__nand4_2
Xgf180mcu_as_sc_mcu7t3v3__nand4_2_101 gf180mcu_as_sc_mcu7t3v3__inv_2_364/VDD VSS VSS
+ VSS VSS VSS VSS gf180mcu_as_sc_mcu7t3v3__inv_2_364/VNW VSUBS gf180mcu_as_sc_mcu7t3v3__nand4_2
Xgf180mcu_as_sc_mcu7t3v3__nand4_2_112 gf180mcu_as_sc_mcu7t3v3__inv_2_334/VDD gf180mcu_as_sc_mcu7t3v3__inv_2_335/VDD
+ VSS VSS VSS VSS VSS gf180mcu_as_sc_mcu7t3v3__inv_2_334/VNW VSUBS gf180mcu_as_sc_mcu7t3v3__nand4_2
Xu_t026_028 u_t026_028/c0_w0_bl u_t026_028/c0_w0_br u_t026_028/c0_w1_bl u_t026_028/c0_w1_br
+ u_t026_028/c0_r0_rbl u_t026_028/c0_r1_rbl u_t026_028/c1_w0_bl u_t026_028/c1_w0_br
+ u_t026_028/c1_w1_bl u_t026_028/c1_w1_br u_t026_028/c1_r0_rbl u_t026_028/c1_r1_rbl
+ u_t026_028/c2_w0_bl u_t026_028/c2_w0_br u_t026_028/c2_w1_bl u_t026_028/c2_w1_br
+ u_t026_028/c2_r0_rbl u_t026_028/c2_r1_rbl u_t026_028/c3_w0_bl u_t026_028/c3_w0_br
+ u_t026_028/c3_w1_bl u_t026_028/c3_w1_br u_t026_028/c3_r0_rbl u_t026_028/c3_r1_rbl
+ u_t026_028/r0_w0_wl u_t026_028/r0_w1_wl u_t026_028/r0_r0_rwl u_t026_028/r0_r1_rwl
+ u_t026_028/r1_w0_wl u_t026_028/r1_w1_wl u_t026_028/r1_r0_rwl u_t026_028/r1_r1_rwl
+ u_t026_028/r2_w0_wl u_t026_028/r2_w1_wl u_t026_028/r2_r0_rwl u_t026_028/r2_r1_rwl
+ u_t026_028/r3_w0_wl u_t026_028/r3_w1_wl u_t026_028/r3_r0_rwl u_t026_028/r3_r1_rwl
+ u_t026_028/VDD u_t026_031/VSS VSUBS detronyx_12t_2w2r_rc4_4x4_routed_5layer_direct
Xu_t026_017 u_t026_017/c0_w0_bl u_t026_017/c0_w0_br u_t026_017/c0_w1_bl u_t026_017/c0_w1_br
+ u_t026_017/c0_r0_rbl u_t026_017/c0_r1_rbl u_t026_017/c1_w0_bl u_t026_017/c1_w0_br
+ u_t026_017/c1_w1_bl u_t026_017/c1_w1_br u_t026_017/c1_r0_rbl u_t026_017/c1_r1_rbl
+ u_t026_017/c2_w0_bl u_t026_017/c2_w0_br u_t026_017/c2_w1_bl u_t026_017/c2_w1_br
+ u_t026_017/c2_r0_rbl u_t026_017/c2_r1_rbl u_t026_017/c3_w0_bl u_t026_017/c3_w0_br
+ u_t026_017/c3_w1_bl u_t026_017/c3_w1_br u_t026_017/c3_r0_rbl u_t026_017/c3_r1_rbl
+ u_t026_017/r0_w0_wl u_t026_017/r0_w1_wl u_t026_017/r0_r0_rwl u_t026_017/r0_r1_rwl
+ u_t026_017/r1_w0_wl u_t026_017/r1_w1_wl u_t026_017/r1_r0_rwl u_t026_017/r1_r1_rwl
+ u_t026_017/r2_w0_wl u_t026_017/r2_w1_wl u_t026_017/r2_r0_rwl u_t026_017/r2_r1_rwl
+ u_t026_017/r3_w0_wl u_t026_017/r3_w1_wl u_t026_017/r3_r0_rwl u_t026_017/r3_r1_rwl
+ VSS u_t026_031/VSS VSUBS detronyx_12t_2w2r_rc4_4x4_routed_5layer_direct
Xu_t026_006 u_t026_006/c0_w0_bl u_t026_006/c0_w0_br u_t026_006/c0_w1_bl u_t026_006/c0_w1_br
+ u_t026_006/c0_r0_rbl u_t026_006/c0_r1_rbl u_t026_006/c1_w0_bl u_t026_006/c1_w0_br
+ u_t026_006/c1_w1_bl u_t026_006/c1_w1_br u_t026_006/c1_r0_rbl u_t026_006/c1_r1_rbl
+ u_t026_006/c2_w0_bl u_t026_006/c2_w0_br u_t026_006/c2_w1_bl u_t026_006/c2_w1_br
+ u_t026_006/c2_r0_rbl u_t026_006/c2_r1_rbl u_t026_006/c3_w0_bl u_t026_006/c3_w0_br
+ u_t026_006/c3_w1_bl u_t026_006/c3_w1_br u_t026_006/c3_r0_rbl u_t026_006/c3_r1_rbl
+ u_t026_006/r0_w0_wl u_t026_006/r0_w1_wl u_t026_006/r0_r0_rwl u_t026_006/r0_r1_rwl
+ u_t026_006/r1_w0_wl u_t026_006/r1_w1_wl u_t026_006/r1_r0_rwl u_t026_006/r1_r1_rwl
+ u_t026_006/r2_w0_wl u_t026_006/r2_w1_wl u_t026_006/r2_r0_rwl u_t026_006/r2_r1_rwl
+ u_t026_006/r3_w0_wl u_t026_006/r3_w1_wl u_t026_006/r3_r0_rwl u_t026_006/r3_r1_rwl
+ u_t026_006/VDD u_t026_031/VSS VSUBS detronyx_12t_2w2r_rc4_4x4_routed_5layer_direct
Xgf180mcu_as_sc_mcu7t3v3__nand4_2_40 gf180mcu_as_sc_mcu7t3v3__inv_2_134/VDD gf180mcu_as_sc_mcu7t3v3__inv_2_138/VDD
+ VSS VSS VSS VSS gf180mcu_as_sc_mcu7t3v3__nand4_2_40/Y gf180mcu_as_sc_mcu7t3v3__inv_2_134/VNW
+ VSUBS gf180mcu_as_sc_mcu7t3v3__nand4_2
Xgf180mcu_as_sc_mcu7t3v3__nand4_2_51 gf180mcu_as_sc_mcu7t3v3__inv_2_151/VSS gf180mcu_as_sc_mcu7t3v3__inv_2_151/VSS
+ VSS VSS VSS VSS VSS gf180mcu_as_sc_mcu7t3v3__inv_2_123/VNW VSUBS gf180mcu_as_sc_mcu7t3v3__nand4_2
Xgf180mcu_as_sc_mcu7t3v3__nand4_2_178 VSS gf180mcu_as_sc_mcu7t3v3__inv_2_667/VDD VSS
+ VSS VSS VSS VSS gf180mcu_as_sc_mcu7t3v3__inv_2_639/VNW VSUBS gf180mcu_as_sc_mcu7t3v3__nand4_2
Xgf180mcu_as_sc_mcu7t3v3__nand4_2_62 VSS gf180mcu_as_sc_mcu7t3v3__inv_2_196/VSS VSS
+ VSS VSS VSS VSS gf180mcu_as_sc_mcu7t3v3__inv_2_196/VNW VSUBS gf180mcu_as_sc_mcu7t3v3__nand4_2
Xgf180mcu_as_sc_mcu7t3v3__nand4_2_95 gf180mcu_as_sc_mcu7t3v3__inv_2_358/VDD gf180mcu_as_sc_mcu7t3v3__inv_2_359/VDD
+ VSS VSS VSS VSS VSS gf180mcu_as_sc_mcu7t3v3__inv_2_358/VNW VSUBS gf180mcu_as_sc_mcu7t3v3__nand4_2
Xgf180mcu_as_sc_mcu7t3v3__nand4_2_73 gf180mcu_as_sc_mcu7t3v3__inv_2_260/VSS gf180mcu_as_sc_mcu7t3v3__inv_2_205/VDD
+ VSS VSS VSS VSS gf180mcu_as_sc_mcu7t3v3__nand4_2_73/Y gf180mcu_as_sc_mcu7t3v3__inv_2_174/VNW
+ VSUBS gf180mcu_as_sc_mcu7t3v3__nand4_2
Xgf180mcu_as_sc_mcu7t3v3__nand4_2_189 gf180mcu_as_sc_mcu7t3v3__inv_2_731/VDD VSS VSS
+ VSS VSS VSS VSS gf180mcu_as_sc_mcu7t3v3__inv_2_731/VNW VSUBS gf180mcu_as_sc_mcu7t3v3__nand4_2
Xgf180mcu_as_sc_mcu7t3v3__nand4_2_84 VSS gf180mcu_as_sc_mcu7t3v3__inv_2_257/VDD VSS
+ VSS VSS VSS VSS gf180mcu_as_sc_mcu7t3v3__inv_2_249/VNW VSUBS gf180mcu_as_sc_mcu7t3v3__nand4_2
Xu_t017_028 u_t017_028/c0_w0_bl u_t017_028/c0_w0_br u_t017_028/c0_w1_bl u_t017_028/c0_w1_br
+ u_t017_028/c0_r0_rbl u_t017_028/c0_r1_rbl u_t017_028/c1_w0_bl u_t017_028/c1_w0_br
+ u_t017_028/c1_w1_bl u_t017_028/c1_w1_br u_t017_028/c1_r0_rbl u_t017_028/c1_r1_rbl
+ u_t017_028/c2_w0_bl u_t017_028/c2_w0_br u_t017_028/c2_w1_bl u_t017_028/c2_w1_br
+ u_t017_028/c2_r0_rbl u_t017_028/c2_r1_rbl u_t017_028/c3_w0_bl u_t017_028/c3_w0_br
+ u_t017_028/c3_w1_bl u_t017_028/c3_w1_br u_t017_028/c3_r0_rbl u_t017_028/c3_r1_rbl
+ u_t017_028/r0_w0_wl u_t017_028/r0_w1_wl u_t017_028/r0_r0_rwl u_t017_028/r0_r1_rwl
+ u_t017_028/r1_w0_wl u_t017_028/r1_w1_wl u_t017_028/r1_r0_rwl u_t017_028/r1_r1_rwl
+ u_t017_028/r2_w0_wl u_t017_028/r2_w1_wl u_t017_028/r2_r0_rwl u_t017_028/r2_r1_rwl
+ u_t017_028/r3_w0_wl u_t017_028/r3_w1_wl u_t017_028/r3_r0_rwl u_t017_028/r3_r1_rwl
+ u_t017_028/VDD u_t017_031/VSS VSUBS detronyx_12t_2w2r_rc4_4x4_routed_5layer_direct
Xu_t017_017 u_t017_017/c0_w0_bl u_t017_017/c0_w0_br u_t017_017/c0_w1_bl u_t017_017/c0_w1_br
+ u_t017_017/c0_r0_rbl u_t017_017/c0_r1_rbl u_t017_017/c1_w0_bl u_t017_017/c1_w0_br
+ u_t017_017/c1_w1_bl u_t017_017/c1_w1_br u_t017_017/c1_r0_rbl u_t017_017/c1_r1_rbl
+ u_t017_017/c2_w0_bl u_t017_017/c2_w0_br u_t017_017/c2_w1_bl u_t017_017/c2_w1_br
+ u_t017_017/c2_r0_rbl u_t017_017/c2_r1_rbl u_t017_017/c3_w0_bl u_t017_017/c3_w0_br
+ u_t017_017/c3_w1_bl u_t017_017/c3_w1_br u_t017_017/c3_r0_rbl u_t017_017/c3_r1_rbl
+ u_t017_017/r0_w0_wl u_t017_017/r0_w1_wl u_t017_017/r0_r0_rwl u_t017_017/r0_r1_rwl
+ u_t017_017/r1_w0_wl u_t017_017/r1_w1_wl u_t017_017/r1_r0_rwl u_t017_017/r1_r1_rwl
+ u_t017_017/r2_w0_wl u_t017_017/r2_w1_wl u_t017_017/r2_r0_rwl u_t017_017/r2_r1_rwl
+ u_t017_017/r3_w0_wl u_t017_017/r3_w1_wl u_t017_017/r3_r0_rwl u_t017_017/r3_r1_rwl
+ VSS u_t017_031/VSS VSUBS detronyx_12t_2w2r_rc4_4x4_routed_5layer_direct
Xu_t017_006 u_t017_006/c0_w0_bl u_t017_006/c0_w0_br u_t017_006/c0_w1_bl u_t017_006/c0_w1_br
+ u_t017_006/c0_r0_rbl u_t017_006/c0_r1_rbl u_t017_006/c1_w0_bl u_t017_006/c1_w0_br
+ u_t017_006/c1_w1_bl u_t017_006/c1_w1_br u_t017_006/c1_r0_rbl u_t017_006/c1_r1_rbl
+ u_t017_006/c2_w0_bl u_t017_006/c2_w0_br u_t017_006/c2_w1_bl u_t017_006/c2_w1_br
+ u_t017_006/c2_r0_rbl u_t017_006/c2_r1_rbl u_t017_006/c3_w0_bl u_t017_006/c3_w0_br
+ u_t017_006/c3_w1_bl u_t017_006/c3_w1_br u_t017_006/c3_r0_rbl u_t017_006/c3_r1_rbl
+ u_t017_006/r0_w0_wl u_t017_006/r0_w1_wl u_t017_006/r0_r0_rwl u_t017_006/r0_r1_rwl
+ u_t017_006/r1_w0_wl u_t017_006/r1_w1_wl u_t017_006/r1_r0_rwl u_t017_006/r1_r1_rwl
+ u_t017_006/r2_w0_wl u_t017_006/r2_w1_wl u_t017_006/r2_r0_rwl u_t017_006/r2_r1_rwl
+ u_t017_006/r3_w0_wl u_t017_006/r3_w1_wl u_t017_006/r3_r0_rwl u_t017_006/r3_r1_rwl
+ u_t017_006/VDD u_t017_031/VSS VSUBS detronyx_12t_2w2r_rc4_4x4_routed_5layer_direct
Xgf180mcu_as_sc_mcu7t3v3__inv_2_109 gf180mcu_as_sc_mcu7t3v3__inv_2_371/VSS gf180mcu_as_sc_mcu7t3v3__inv_2_115/VDD
+ VSS VSS gf180mcu_as_sc_mcu7t3v3__inv_2_111/VNW VSUBS gf180mcu_as_sc_mcu7t3v3__inv_2
Xgf180mcu_as_sc_mcu7t3v3__inv_2_1170 VSS VSS VSS VSS gf180mcu_as_sc_mcu7t3v3__inv_2_1171/VNW
+ VSUBS gf180mcu_as_sc_mcu7t3v3__inv_2
Xgf180mcu_as_sc_mcu7t3v3__inv_2_1181 VSS VSS VSS VSS gf180mcu_as_sc_mcu7t3v3__inv_2_1182/VNW
+ VSUBS gf180mcu_as_sc_mcu7t3v3__inv_2
Xgf180mcu_as_sc_mcu7t3v3__inv_2_1192 VSS VSS VSS VSS gf180mcu_as_sc_mcu7t3v3__inv_2_1194/VNW
+ VSUBS gf180mcu_as_sc_mcu7t3v3__inv_2
Xu_t008_028 u_t008_028/c0_w0_bl u_t008_028/c0_w0_br u_t008_028/c0_w1_bl u_t008_028/c0_w1_br
+ u_t008_028/c0_r0_rbl u_t008_028/c0_r1_rbl u_t008_028/c1_w0_bl u_t008_028/c1_w0_br
+ u_t008_028/c1_w1_bl u_t008_028/c1_w1_br u_t008_028/c1_r0_rbl u_t008_028/c1_r1_rbl
+ u_t008_028/c2_w0_bl u_t008_028/c2_w0_br u_t008_028/c2_w1_bl u_t008_028/c2_w1_br
+ u_t008_028/c2_r0_rbl u_t008_028/c2_r1_rbl u_t008_028/c3_w0_bl u_t008_028/c3_w0_br
+ u_t008_028/c3_w1_bl u_t008_028/c3_w1_br u_t008_028/c3_r0_rbl u_t008_028/c3_r1_rbl
+ u_t008_028/r0_w0_wl u_t008_028/r0_w1_wl u_t008_028/r0_r0_rwl u_t008_028/r0_r1_rwl
+ u_t008_028/r1_w0_wl u_t008_028/r1_w1_wl u_t008_028/r1_r0_rwl u_t008_028/r1_r1_rwl
+ u_t008_028/r2_w0_wl u_t008_028/r2_w1_wl u_t008_028/r2_r0_rwl u_t008_028/r2_r1_rwl
+ u_t008_028/r3_w0_wl u_t008_028/r3_w1_wl u_t008_028/r3_r0_rwl u_t008_028/r3_r1_rwl
+ u_t008_028/VDD u_t008_031/VSS VSUBS detronyx_12t_2w2r_rc4_4x4_routed_5layer_direct
Xu_t008_017 u_t008_017/c0_w0_bl u_t008_017/c0_w0_br u_t008_017/c0_w1_bl u_t008_017/c0_w1_br
+ u_t008_017/c0_r0_rbl u_t008_017/c0_r1_rbl u_t008_017/c1_w0_bl u_t008_017/c1_w0_br
+ u_t008_017/c1_w1_bl u_t008_017/c1_w1_br u_t008_017/c1_r0_rbl u_t008_017/c1_r1_rbl
+ u_t008_017/c2_w0_bl u_t008_017/c2_w0_br u_t008_017/c2_w1_bl u_t008_017/c2_w1_br
+ u_t008_017/c2_r0_rbl u_t008_017/c2_r1_rbl u_t008_017/c3_w0_bl u_t008_017/c3_w0_br
+ u_t008_017/c3_w1_bl u_t008_017/c3_w1_br u_t008_017/c3_r0_rbl u_t008_017/c3_r1_rbl
+ u_t008_017/r0_w0_wl u_t008_017/r0_w1_wl u_t008_017/r0_r0_rwl u_t008_017/r0_r1_rwl
+ u_t008_017/r1_w0_wl u_t008_017/r1_w1_wl u_t008_017/r1_r0_rwl u_t008_017/r1_r1_rwl
+ u_t008_017/r2_w0_wl u_t008_017/r2_w1_wl u_t008_017/r2_r0_rwl u_t008_017/r2_r1_rwl
+ u_t008_017/r3_w0_wl u_t008_017/r3_w1_wl u_t008_017/r3_r0_rwl u_t008_017/r3_r1_rwl
+ VSS u_t008_031/VSS VSUBS detronyx_12t_2w2r_rc4_4x4_routed_5layer_direct
Xu_t023_009 u_t023_009/c0_w0_bl u_t023_009/c0_w0_br u_t023_009/c0_w1_bl u_t023_009/c0_w1_br
+ u_t023_009/c0_r0_rbl u_t023_009/c0_r1_rbl u_t023_009/c1_w0_bl u_t023_009/c1_w0_br
+ u_t023_009/c1_w1_bl u_t023_009/c1_w1_br u_t023_009/c1_r0_rbl u_t023_009/c1_r1_rbl
+ u_t023_009/c2_w0_bl u_t023_009/c2_w0_br u_t023_009/c2_w1_bl u_t023_009/c2_w1_br
+ u_t023_009/c2_r0_rbl u_t023_009/c2_r1_rbl u_t023_009/c3_w0_bl u_t023_009/c3_w0_br
+ u_t023_009/c3_w1_bl u_t023_009/c3_w1_br u_t023_009/c3_r0_rbl u_t023_009/c3_r1_rbl
+ u_t023_009/r0_w0_wl u_t023_009/r0_w1_wl u_t023_009/r0_r0_rwl u_t023_009/r0_r1_rwl
+ u_t023_009/r1_w0_wl u_t023_009/r1_w1_wl u_t023_009/r1_r0_rwl u_t023_009/r1_r1_rwl
+ u_t023_009/r2_w0_wl u_t023_009/r2_w1_wl u_t023_009/r2_r0_rwl u_t023_009/r2_r1_rwl
+ u_t023_009/r3_w0_wl u_t023_009/r3_w1_wl u_t023_009/r3_r0_rwl u_t023_009/r3_r1_rwl
+ VSS u_t023_009/VSS VSUBS detronyx_12t_2w2r_rc4_4x4_routed_5layer_direct
Xu_t008_006 u_t008_006/c0_w0_bl u_t008_006/c0_w0_br u_t008_006/c0_w1_bl u_t008_006/c0_w1_br
+ u_t008_006/c0_r0_rbl u_t008_006/c0_r1_rbl u_t008_006/c1_w0_bl u_t008_006/c1_w0_br
+ u_t008_006/c1_w1_bl u_t008_006/c1_w1_br u_t008_006/c1_r0_rbl u_t008_006/c1_r1_rbl
+ u_t008_006/c2_w0_bl u_t008_006/c2_w0_br u_t008_006/c2_w1_bl u_t008_006/c2_w1_br
+ u_t008_006/c2_r0_rbl u_t008_006/c2_r1_rbl u_t008_006/c3_w0_bl u_t008_006/c3_w0_br
+ u_t008_006/c3_w1_bl u_t008_006/c3_w1_br u_t008_006/c3_r0_rbl u_t008_006/c3_r1_rbl
+ u_t008_006/r0_w0_wl u_t008_006/r0_w1_wl u_t008_006/r0_r0_rwl u_t008_006/r0_r1_rwl
+ u_t008_006/r1_w0_wl u_t008_006/r1_w1_wl u_t008_006/r1_r0_rwl u_t008_006/r1_r1_rwl
+ u_t008_006/r2_w0_wl u_t008_006/r2_w1_wl u_t008_006/r2_r0_rwl u_t008_006/r2_r1_rwl
+ u_t008_006/r3_w0_wl u_t008_006/r3_w1_wl u_t008_006/r3_r0_rwl u_t008_006/r3_r1_rwl
+ u_t008_006/VDD u_t008_031/VSS VSUBS detronyx_12t_2w2r_rc4_4x4_routed_5layer_direct
Xgf180mcu_as_sc_mcu7t3v3__inv_2_621 gf180mcu_as_sc_mcu7t3v3__inv_2_626/VDD VSS gf180mcu_as_sc_mcu7t3v3__inv_2_621/Y
+ gf180mcu_as_sc_mcu7t3v3__inv_2_631/A gf180mcu_as_sc_mcu7t3v3__inv_2_626/VNW VSUBS
+ gf180mcu_as_sc_mcu7t3v3__inv_2
Xgf180mcu_as_sc_mcu7t3v3__inv_2_632 gf180mcu_as_sc_mcu7t3v3__inv_2_633/VDD gf180mcu_as_sc_mcu7t3v3__inv_2_633/VSS
+ gf180mcu_as_sc_mcu7t3v3__inv_2_632/Y gf180mcu_as_sc_mcu7t3v3__inv_2_633/Y gf180mcu_as_sc_mcu7t3v3__inv_2_633/VNW
+ VSUBS gf180mcu_as_sc_mcu7t3v3__inv_2
Xgf180mcu_as_sc_mcu7t3v3__inv_2_610 gf180mcu_as_sc_mcu7t3v3__inv_2_616/VDD gf180mcu_as_sc_mcu7t3v3__inv_2_616/VDD
+ gf180mcu_as_sc_mcu7t3v3__inv_2_610/Y gf180mcu_as_sc_mcu7t3v3__inv_2_618/A gf180mcu_as_sc_mcu7t3v3__inv_2_612/VNW
+ VSUBS gf180mcu_as_sc_mcu7t3v3__inv_2
Xgf180mcu_as_sc_mcu7t3v3__inv_2_654 VSS gf180mcu_as_sc_mcu7t3v3__inv_2_659/VDD gf180mcu_as_sc_mcu7t3v3__inv_2_661/A
+ gf180mcu_as_sc_mcu7t3v3__inv_2_655/Y gf180mcu_as_sc_mcu7t3v3__inv_2_655/VNW VSUBS
+ gf180mcu_as_sc_mcu7t3v3__inv_2
Xgf180mcu_as_sc_mcu7t3v3__inv_2_643 VSS gf180mcu_as_sc_mcu7t3v3__inv_2_647/VDD gf180mcu_as_sc_mcu7t3v3__inv_2_643/Y
+ VSS gf180mcu_as_sc_mcu7t3v3__inv_2_643/VNW VSUBS gf180mcu_as_sc_mcu7t3v3__inv_2
Xu_t031_031 u_t031_031/c0_w0_bl u_t031_031/c0_w0_br u_t031_031/c0_w1_bl u_t031_031/c0_w1_br
+ u_t031_031/c0_r0_rbl u_t031_031/c0_r1_rbl u_t031_031/c1_w0_bl u_t031_031/c1_w0_br
+ u_t031_031/c1_w1_bl u_t031_031/c1_w1_br u_t031_031/c1_r0_rbl u_t031_031/c1_r1_rbl
+ u_t031_031/c2_w0_bl u_t031_031/c2_w0_br u_t031_031/c2_w1_bl u_t031_031/c2_w1_br
+ u_t031_031/c2_r0_rbl u_t031_031/c2_r1_rbl u_t031_031/c3_w0_bl u_t031_031/c3_w0_br
+ u_t031_031/c3_w1_bl u_t031_031/c3_w1_br u_t031_031/c3_r0_rbl u_t031_031/c3_r1_rbl
+ u_t031_031/r0_w0_wl u_t031_031/r0_w1_wl u_t031_031/r0_r0_rwl u_t031_031/r0_r1_rwl
+ u_t031_031/r1_w0_wl u_t031_031/r1_w1_wl u_t031_031/r1_r0_rwl u_t031_031/r1_r1_rwl
+ u_t031_031/r2_w0_wl u_t031_031/r2_w1_wl u_t031_031/r2_r0_rwl u_t031_031/r2_r1_rwl
+ u_t031_031/r3_w0_wl u_t031_031/r3_w1_wl u_t031_031/r3_r0_rwl u_t031_031/r3_r1_rwl
+ VSS u_t031_031/VSS VSUBS detronyx_12t_2w2r_rc4_4x4_routed_5layer_direct
Xu_t031_020 u_t031_020/c0_w0_bl u_t031_020/c0_w0_br u_t031_020/c0_w1_bl u_t031_020/c0_w1_br
+ u_t031_020/c0_r0_rbl u_t031_020/c0_r1_rbl u_t031_020/c1_w0_bl u_t031_020/c1_w0_br
+ u_t031_020/c1_w1_bl u_t031_020/c1_w1_br u_t031_020/c1_r0_rbl u_t031_020/c1_r1_rbl
+ u_t031_020/c2_w0_bl u_t031_020/c2_w0_br u_t031_020/c2_w1_bl u_t031_020/c2_w1_br
+ u_t031_020/c2_r0_rbl u_t031_020/c2_r1_rbl u_t031_020/c3_w0_bl u_t031_020/c3_w0_br
+ u_t031_020/c3_w1_bl u_t031_020/c3_w1_br u_t031_020/c3_r0_rbl u_t031_020/c3_r1_rbl
+ u_t031_020/r0_w0_wl u_t031_020/r0_w1_wl u_t031_020/r0_r0_rwl u_t031_020/r0_r1_rwl
+ u_t031_020/r1_w0_wl u_t031_020/r1_w1_wl u_t031_020/r1_r0_rwl u_t031_020/r1_r1_rwl
+ u_t031_020/r2_w0_wl u_t031_020/r2_w1_wl u_t031_020/r2_r0_rwl u_t031_020/r2_r1_rwl
+ u_t031_020/r3_w0_wl u_t031_020/r3_w1_wl u_t031_020/r3_r0_rwl u_t031_020/r3_r1_rwl
+ u_t031_020/VDD u_t031_020/VSS VSUBS detronyx_12t_2w2r_rc4_4x4_routed_5layer_direct
Xgf180mcu_as_sc_mcu7t3v3__inv_2_665 gf180mcu_as_sc_mcu7t3v3__inv_2_667/VDD gf180mcu_as_sc_mcu7t3v3__inv_2_671/VDD
+ gf180mcu_as_sc_mcu7t3v3__inv_2_665/Y gf180mcu_as_sc_mcu7t3v3__inv_2_848/Y gf180mcu_as_sc_mcu7t3v3__inv_2_667/VNW
+ VSUBS gf180mcu_as_sc_mcu7t3v3__inv_2
Xgf180mcu_as_sc_mcu7t3v3__inv_2_676 VSS VSS gf180mcu_as_sc_mcu7t3v3__inv_2_676/Y VSS
+ gf180mcu_as_sc_mcu7t3v3__inv_2_676/VNW VSUBS gf180mcu_as_sc_mcu7t3v3__inv_2
Xgf180mcu_as_sc_mcu7t3v3__inv_2_687 gf180mcu_as_sc_mcu7t3v3__inv_2_687/VDD VSS gf180mcu_as_sc_mcu7t3v3__inv_2_687/Y
+ VSS gf180mcu_as_sc_mcu7t3v3__inv_2_687/VNW VSUBS gf180mcu_as_sc_mcu7t3v3__inv_2
Xgf180mcu_as_sc_mcu7t3v3__inv_2_698 VSS VSS gf180mcu_as_sc_mcu7t3v3__inv_2_739/A gf180mcu_as_sc_mcu7t3v3__inv_2_699/Y
+ gf180mcu_as_sc_mcu7t3v3__inv_2_699/VNW VSUBS gf180mcu_as_sc_mcu7t3v3__inv_2
Xu_t022_031 u_t022_031/c0_w0_bl u_t022_031/c0_w0_br u_t022_031/c0_w1_bl u_t022_031/c0_w1_br
+ u_t022_031/c0_r0_rbl u_t022_031/c0_r1_rbl u_t022_031/c1_w0_bl u_t022_031/c1_w0_br
+ u_t022_031/c1_w1_bl u_t022_031/c1_w1_br u_t022_031/c1_r0_rbl u_t022_031/c1_r1_rbl
+ u_t022_031/c2_w0_bl u_t022_031/c2_w0_br u_t022_031/c2_w1_bl u_t022_031/c2_w1_br
+ u_t022_031/c2_r0_rbl u_t022_031/c2_r1_rbl u_t022_031/c3_w0_bl u_t022_031/c3_w0_br
+ u_t022_031/c3_w1_bl u_t022_031/c3_w1_br u_t022_031/c3_r0_rbl u_t022_031/c3_r1_rbl
+ u_t022_031/r0_w0_wl u_t022_031/r0_w1_wl u_t022_031/r0_r0_rwl u_t022_031/r0_r1_rwl
+ u_t022_031/r1_w0_wl u_t022_031/r1_w1_wl u_t022_031/r1_r0_rwl u_t022_031/r1_r1_rwl
+ u_t022_031/r2_w0_wl u_t022_031/r2_w1_wl u_t022_031/r2_r0_rwl u_t022_031/r2_r1_rwl
+ u_t022_031/r3_w0_wl u_t022_031/r3_w1_wl u_t022_031/r3_r0_rwl u_t022_031/r3_r1_rwl
+ VSS u_t022_031/VSS VSUBS detronyx_12t_2w2r_rc4_4x4_routed_5layer_direct
Xu_t022_020 u_t022_020/c0_w0_bl u_t022_020/c0_w0_br u_t022_020/c0_w1_bl u_t022_020/c0_w1_br
+ u_t022_020/c0_r0_rbl u_t022_020/c0_r1_rbl u_t022_020/c1_w0_bl u_t022_020/c1_w0_br
+ u_t022_020/c1_w1_bl u_t022_020/c1_w1_br u_t022_020/c1_r0_rbl u_t022_020/c1_r1_rbl
+ u_t022_020/c2_w0_bl u_t022_020/c2_w0_br u_t022_020/c2_w1_bl u_t022_020/c2_w1_br
+ u_t022_020/c2_r0_rbl u_t022_020/c2_r1_rbl u_t022_020/c3_w0_bl u_t022_020/c3_w0_br
+ u_t022_020/c3_w1_bl u_t022_020/c3_w1_br u_t022_020/c3_r0_rbl u_t022_020/c3_r1_rbl
+ u_t022_020/r0_w0_wl u_t022_020/r0_w1_wl u_t022_020/r0_r0_rwl u_t022_020/r0_r1_rwl
+ u_t022_020/r1_w0_wl u_t022_020/r1_w1_wl u_t022_020/r1_r0_rwl u_t022_020/r1_r1_rwl
+ u_t022_020/r2_w0_wl u_t022_020/r2_w1_wl u_t022_020/r2_r0_rwl u_t022_020/r2_r1_rwl
+ u_t022_020/r3_w0_wl u_t022_020/r3_w1_wl u_t022_020/r3_r0_rwl u_t022_020/r3_r1_rwl
+ u_t022_020/VDD u_t022_031/VSS VSUBS detronyx_12t_2w2r_rc4_4x4_routed_5layer_direct
Xu_t014_009 u_t014_009/c0_w0_bl u_t014_009/c0_w0_br u_t014_009/c0_w1_bl u_t014_009/c0_w1_br
+ u_t014_009/c0_r0_rbl u_t014_009/c0_r1_rbl u_t014_009/c1_w0_bl u_t014_009/c1_w0_br
+ u_t014_009/c1_w1_bl u_t014_009/c1_w1_br u_t014_009/c1_r0_rbl u_t014_009/c1_r1_rbl
+ u_t014_009/c2_w0_bl u_t014_009/c2_w0_br u_t014_009/c2_w1_bl u_t014_009/c2_w1_br
+ u_t014_009/c2_r0_rbl u_t014_009/c2_r1_rbl u_t014_009/c3_w0_bl u_t014_009/c3_w0_br
+ u_t014_009/c3_w1_bl u_t014_009/c3_w1_br u_t014_009/c3_r0_rbl u_t014_009/c3_r1_rbl
+ u_t014_009/r0_w0_wl u_t014_009/r0_w1_wl u_t014_009/r0_r0_rwl u_t014_009/r0_r1_rwl
+ u_t014_009/r1_w0_wl u_t014_009/r1_w1_wl u_t014_009/r1_r0_rwl u_t014_009/r1_r1_rwl
+ u_t014_009/r2_w0_wl u_t014_009/r2_w1_wl u_t014_009/r2_r0_rwl u_t014_009/r2_r1_rwl
+ u_t014_009/r3_w0_wl u_t014_009/r3_w1_wl u_t014_009/r3_r0_rwl u_t014_009/r3_r1_rwl
+ VSS u_t014_009/VSS VSUBS detronyx_12t_2w2r_rc4_4x4_routed_5layer_direct
Xu_t005_009 u_t005_009/c0_w0_bl u_t005_009/c0_w0_br u_t005_009/c0_w1_bl u_t005_009/c0_w1_br
+ u_t005_009/c0_r0_rbl u_t005_009/c0_r1_rbl u_t005_009/c1_w0_bl u_t005_009/c1_w0_br
+ u_t005_009/c1_w1_bl u_t005_009/c1_w1_br u_t005_009/c1_r0_rbl u_t005_009/c1_r1_rbl
+ u_t005_009/c2_w0_bl u_t005_009/c2_w0_br u_t005_009/c2_w1_bl u_t005_009/c2_w1_br
+ u_t005_009/c2_r0_rbl u_t005_009/c2_r1_rbl u_t005_009/c3_w0_bl u_t005_009/c3_w0_br
+ u_t005_009/c3_w1_bl u_t005_009/c3_w1_br u_t005_009/c3_r0_rbl u_t005_009/c3_r1_rbl
+ u_t005_009/r0_w0_wl u_t005_009/r0_w1_wl u_t005_009/r0_r0_rwl u_t005_009/r0_r1_rwl
+ u_t005_009/r1_w0_wl u_t005_009/r1_w1_wl u_t005_009/r1_r0_rwl u_t005_009/r1_r1_rwl
+ u_t005_009/r2_w0_wl u_t005_009/r2_w1_wl u_t005_009/r2_r0_rwl u_t005_009/r2_r1_rwl
+ u_t005_009/r3_w0_wl u_t005_009/r3_w1_wl u_t005_009/r3_r0_rwl u_t005_009/r3_r1_rwl
+ VSS u_t005_031/VSS VSUBS detronyx_12t_2w2r_rc4_4x4_routed_5layer_direct
Xu_t013_031 u_t013_031/c0_w0_bl u_t013_031/c0_w0_br u_t013_031/c0_w1_bl u_t013_031/c0_w1_br
+ u_t013_031/c0_r0_rbl u_t013_031/c0_r1_rbl u_t013_031/c1_w0_bl u_t013_031/c1_w0_br
+ u_t013_031/c1_w1_bl u_t013_031/c1_w1_br u_t013_031/c1_r0_rbl u_t013_031/c1_r1_rbl
+ u_t013_031/c2_w0_bl u_t013_031/c2_w0_br u_t013_031/c2_w1_bl u_t013_031/c2_w1_br
+ u_t013_031/c2_r0_rbl u_t013_031/c2_r1_rbl u_t013_031/c3_w0_bl u_t013_031/c3_w0_br
+ u_t013_031/c3_w1_bl u_t013_031/c3_w1_br u_t013_031/c3_r0_rbl u_t013_031/c3_r1_rbl
+ u_t013_031/r0_w0_wl u_t013_031/r0_w1_wl u_t013_031/r0_r0_rwl u_t013_031/r0_r1_rwl
+ u_t013_031/r1_w0_wl u_t013_031/r1_w1_wl u_t013_031/r1_r0_rwl u_t013_031/r1_r1_rwl
+ u_t013_031/r2_w0_wl u_t013_031/r2_w1_wl u_t013_031/r2_r0_rwl u_t013_031/r2_r1_rwl
+ u_t013_031/r3_w0_wl u_t013_031/r3_w1_wl u_t013_031/r3_r0_rwl u_t013_031/r3_r1_rwl
+ VSS u_t013_031/VSS VSUBS detronyx_12t_2w2r_rc4_4x4_routed_5layer_direct
Xu_t013_020 u_t013_020/c0_w0_bl u_t013_020/c0_w0_br u_t013_020/c0_w1_bl u_t013_020/c0_w1_br
+ u_t013_020/c0_r0_rbl u_t013_020/c0_r1_rbl u_t013_020/c1_w0_bl u_t013_020/c1_w0_br
+ u_t013_020/c1_w1_bl u_t013_020/c1_w1_br u_t013_020/c1_r0_rbl u_t013_020/c1_r1_rbl
+ u_t013_020/c2_w0_bl u_t013_020/c2_w0_br u_t013_020/c2_w1_bl u_t013_020/c2_w1_br
+ u_t013_020/c2_r0_rbl u_t013_020/c2_r1_rbl u_t013_020/c3_w0_bl u_t013_020/c3_w0_br
+ u_t013_020/c3_w1_bl u_t013_020/c3_w1_br u_t013_020/c3_r0_rbl u_t013_020/c3_r1_rbl
+ u_t013_020/r0_w0_wl u_t013_020/r0_w1_wl u_t013_020/r0_r0_rwl u_t013_020/r0_r1_rwl
+ u_t013_020/r1_w0_wl u_t013_020/r1_w1_wl u_t013_020/r1_r0_rwl u_t013_020/r1_r1_rwl
+ u_t013_020/r2_w0_wl u_t013_020/r2_w1_wl u_t013_020/r2_r0_rwl u_t013_020/r2_r1_rwl
+ u_t013_020/r3_w0_wl u_t013_020/r3_w1_wl u_t013_020/r3_r0_rwl u_t013_020/r3_r1_rwl
+ u_t013_020/VDD u_t013_031/VSS VSUBS detronyx_12t_2w2r_rc4_4x4_routed_5layer_direct
Xu_t004_031 u_t004_031/c0_w0_bl u_t004_031/c0_w0_br u_t004_031/c0_w1_bl u_t004_031/c0_w1_br
+ u_t004_031/c0_r0_rbl u_t004_031/c0_r1_rbl u_t004_031/c1_w0_bl u_t004_031/c1_w0_br
+ u_t004_031/c1_w1_bl u_t004_031/c1_w1_br u_t004_031/c1_r0_rbl u_t004_031/c1_r1_rbl
+ u_t004_031/c2_w0_bl u_t004_031/c2_w0_br u_t004_031/c2_w1_bl u_t004_031/c2_w1_br
+ u_t004_031/c2_r0_rbl u_t004_031/c2_r1_rbl u_t004_031/c3_w0_bl u_t004_031/c3_w0_br
+ u_t004_031/c3_w1_bl u_t004_031/c3_w1_br u_t004_031/c3_r0_rbl u_t004_031/c3_r1_rbl
+ u_t004_031/r0_w0_wl u_t004_031/r0_w1_wl u_t004_031/r0_r0_rwl u_t004_031/r0_r1_rwl
+ u_t004_031/r1_w0_wl u_t004_031/r1_w1_wl u_t004_031/r1_r0_rwl u_t004_031/r1_r1_rwl
+ u_t004_031/r2_w0_wl u_t004_031/r2_w1_wl u_t004_031/r2_r0_rwl u_t004_031/r2_r1_rwl
+ u_t004_031/r3_w0_wl u_t004_031/r3_w1_wl u_t004_031/r3_r0_rwl u_t004_031/r3_r1_rwl
+ VSS u_t004_031/VSS VSUBS detronyx_12t_2w2r_rc4_4x4_routed_5layer_direct
Xu_t004_020 u_t004_020/c0_w0_bl u_t004_020/c0_w0_br u_t004_020/c0_w1_bl u_t004_020/c0_w1_br
+ u_t004_020/c0_r0_rbl u_t004_020/c0_r1_rbl u_t004_020/c1_w0_bl u_t004_020/c1_w0_br
+ u_t004_020/c1_w1_bl u_t004_020/c1_w1_br u_t004_020/c1_r0_rbl u_t004_020/c1_r1_rbl
+ u_t004_020/c2_w0_bl u_t004_020/c2_w0_br u_t004_020/c2_w1_bl u_t004_020/c2_w1_br
+ u_t004_020/c2_r0_rbl u_t004_020/c2_r1_rbl u_t004_020/c3_w0_bl u_t004_020/c3_w0_br
+ u_t004_020/c3_w1_bl u_t004_020/c3_w1_br u_t004_020/c3_r0_rbl u_t004_020/c3_r1_rbl
+ u_t004_020/r0_w0_wl u_t004_020/r0_w1_wl u_t004_020/r0_r0_rwl u_t004_020/r0_r1_rwl
+ u_t004_020/r1_w0_wl u_t004_020/r1_w1_wl u_t004_020/r1_r0_rwl u_t004_020/r1_r1_rwl
+ u_t004_020/r2_w0_wl u_t004_020/r2_w1_wl u_t004_020/r2_r0_rwl u_t004_020/r2_r1_rwl
+ u_t004_020/r3_w0_wl u_t004_020/r3_w1_wl u_t004_020/r3_r0_rwl u_t004_020/r3_r1_rwl
+ u_t004_020/VDD u_t004_031/VSS VSUBS detronyx_12t_2w2r_rc4_4x4_routed_5layer_direct
Xgf180mcu_as_sc_mcu7t3v3__inv_2_451 VSS VSS VSS VSS gf180mcu_as_sc_mcu7t3v3__inv_2_451/VNW
+ VSUBS gf180mcu_as_sc_mcu7t3v3__inv_2
Xgf180mcu_as_sc_mcu7t3v3__inv_2_462 gf180mcu_as_sc_mcu7t3v3__nor2_2_5/VDD gf180mcu_as_sc_mcu7t3v3__nor2_2_5/VSS
+ VSS VSS gf180mcu_as_sc_mcu7t3v3__nor2_2_5/VNW VSUBS gf180mcu_as_sc_mcu7t3v3__inv_2
Xgf180mcu_as_sc_mcu7t3v3__inv_2_473 gf180mcu_as_sc_mcu7t3v3__nor2_2_4/VDD gf180mcu_as_sc_mcu7t3v3__nand3_2_8/VSS
+ gf180mcu_as_sc_mcu7t3v3__inv_2_473/Y VSS gf180mcu_as_sc_mcu7t3v3__nor2_2_4/VNW VSUBS
+ gf180mcu_as_sc_mcu7t3v3__inv_2
Xgf180mcu_as_sc_mcu7t3v3__inv_2_484 gf180mcu_as_sc_mcu7t3v3__nor2_2_4/VDD gf180mcu_as_sc_mcu7t3v3__nor2_2_4/VSS
+ VSS VSS gf180mcu_as_sc_mcu7t3v3__nor2_2_4/VNW VSUBS gf180mcu_as_sc_mcu7t3v3__inv_2
Xgf180mcu_as_sc_mcu7t3v3__inv_2_495 gf180mcu_as_sc_mcu7t3v3__nor2_2_4/VDD gf180mcu_as_sc_mcu7t3v3__nor2_2_4/VSS
+ VSS VSS gf180mcu_as_sc_mcu7t3v3__nor2_2_4/VNW VSUBS gf180mcu_as_sc_mcu7t3v3__inv_2
Xgf180mcu_as_sc_mcu7t3v3__inv_2_440 gf180mcu_as_sc_mcu7t3v3__nand3_2_5/VDD gf180mcu_as_sc_mcu7t3v3__nor2_2_6/VSS
+ VSS VSS gf180mcu_as_sc_mcu7t3v3__nand3_2_5/VNW VSUBS gf180mcu_as_sc_mcu7t3v3__inv_2
Xu_t010_023 u_t010_023/c0_w0_bl u_t010_023/c0_w0_br u_t010_023/c0_w1_bl u_t010_023/c0_w1_br
+ u_t010_023/c0_r0_rbl u_t010_023/c0_r1_rbl u_t010_023/c1_w0_bl u_t010_023/c1_w0_br
+ u_t010_023/c1_w1_bl u_t010_023/c1_w1_br u_t010_023/c1_r0_rbl u_t010_023/c1_r1_rbl
+ u_t010_023/c2_w0_bl u_t010_023/c2_w0_br u_t010_023/c2_w1_bl u_t010_023/c2_w1_br
+ u_t010_023/c2_r0_rbl u_t010_023/c2_r1_rbl u_t010_023/c3_w0_bl u_t010_023/c3_w0_br
+ u_t010_023/c3_w1_bl u_t010_023/c3_w1_br u_t010_023/c3_r0_rbl u_t010_023/c3_r1_rbl
+ u_t010_023/r0_w0_wl u_t010_023/r0_w1_wl u_t010_023/r0_r0_rwl u_t010_023/r0_r1_rwl
+ u_t010_023/r1_w0_wl u_t010_023/r1_w1_wl u_t010_023/r1_r0_rwl u_t010_023/r1_r1_rwl
+ u_t010_023/r2_w0_wl u_t010_023/r2_w1_wl u_t010_023/r2_r0_rwl u_t010_023/r2_r1_rwl
+ u_t010_023/r3_w0_wl u_t010_023/r3_w1_wl u_t010_023/r3_r0_rwl u_t010_023/r3_r1_rwl
+ VSS u_t010_024/VSS VSUBS detronyx_12t_2w2r_rc4_4x4_routed_5layer_direct
Xu_t010_012 u_t010_012/c0_w0_bl u_t010_012/c0_w0_br u_t010_012/c0_w1_bl u_t010_012/c0_w1_br
+ u_t010_012/c0_r0_rbl u_t010_012/c0_r1_rbl u_t010_012/c1_w0_bl u_t010_012/c1_w0_br
+ u_t010_012/c1_w1_bl u_t010_012/c1_w1_br u_t010_012/c1_r0_rbl u_t010_012/c1_r1_rbl
+ u_t010_012/c2_w0_bl u_t010_012/c2_w0_br u_t010_012/c2_w1_bl u_t010_012/c2_w1_br
+ u_t010_012/c2_r0_rbl u_t010_012/c2_r1_rbl u_t010_012/c3_w0_bl u_t010_012/c3_w0_br
+ u_t010_012/c3_w1_bl u_t010_012/c3_w1_br u_t010_012/c3_r0_rbl u_t010_012/c3_r1_rbl
+ u_t010_012/r0_w0_wl u_t010_012/r0_w1_wl u_t010_012/r0_r0_rwl u_t010_012/r0_r1_rwl
+ u_t010_012/r1_w0_wl u_t010_012/r1_w1_wl u_t010_012/r1_r0_rwl u_t010_012/r1_r1_rwl
+ u_t010_012/r2_w0_wl u_t010_012/r2_w1_wl u_t010_012/r2_r0_rwl u_t010_012/r2_r1_rwl
+ u_t010_012/r3_w0_wl u_t010_012/r3_w1_wl u_t010_012/r3_r0_rwl u_t010_012/r3_r1_rwl
+ u_t010_012/VDD u_t010_012/VSS VSUBS detronyx_12t_2w2r_rc4_4x4_routed_5layer_direct
Xu_t010_001 u_t010_001/c0_w0_bl u_t010_001/c0_w0_br u_t010_001/c0_w1_bl u_t010_001/c0_w1_br
+ u_t010_001/c0_r0_rbl u_t010_001/c0_r1_rbl u_t010_001/c1_w0_bl u_t010_001/c1_w0_br
+ u_t010_001/c1_w1_bl u_t010_001/c1_w1_br u_t010_001/c1_r0_rbl u_t010_001/c1_r1_rbl
+ u_t010_001/c2_w0_bl u_t010_001/c2_w0_br u_t010_001/c2_w1_bl u_t010_001/c2_w1_br
+ u_t010_001/c2_r0_rbl u_t010_001/c2_r1_rbl u_t010_001/c3_w0_bl u_t010_001/c3_w0_br
+ u_t010_001/c3_w1_bl u_t010_001/c3_w1_br u_t010_001/c3_r0_rbl u_t010_001/c3_r1_rbl
+ u_t010_001/r0_w0_wl u_t010_001/r0_w1_wl u_t010_001/r0_r0_rwl u_t010_001/r0_r1_rwl
+ u_t010_001/r1_w0_wl u_t010_001/r1_w1_wl u_t010_001/r1_r0_rwl u_t010_001/r1_r1_rwl
+ u_t010_001/r2_w0_wl u_t010_001/r2_w1_wl u_t010_001/r2_r0_rwl u_t010_001/r2_r1_rwl
+ u_t010_001/r3_w0_wl u_t010_001/r3_w1_wl u_t010_001/r3_r0_rwl u_t010_001/r3_r1_rwl
+ VSS u_t010_002/VSS VSUBS detronyx_12t_2w2r_rc4_4x4_routed_5layer_direct
Xu_t001_023 u_t001_023/c0_w0_bl u_t001_023/c0_w0_br u_t001_023/c0_w1_bl u_t001_023/c0_w1_br
+ u_t001_023/c0_r0_rbl u_t001_023/c0_r1_rbl u_t001_023/c1_w0_bl u_t001_023/c1_w0_br
+ u_t001_023/c1_w1_bl u_t001_023/c1_w1_br u_t001_023/c1_r0_rbl u_t001_023/c1_r1_rbl
+ u_t001_023/c2_w0_bl u_t001_023/c2_w0_br u_t001_023/c2_w1_bl u_t001_023/c2_w1_br
+ u_t001_023/c2_r0_rbl u_t001_023/c2_r1_rbl u_t001_023/c3_w0_bl u_t001_023/c3_w0_br
+ u_t001_023/c3_w1_bl u_t001_023/c3_w1_br u_t001_023/c3_r0_rbl u_t001_023/c3_r1_rbl
+ u_t001_023/r0_w0_wl u_t001_023/r0_w1_wl u_t001_023/r0_r0_rwl u_t001_023/r0_r1_rwl
+ u_t001_023/r1_w0_wl u_t001_023/r1_w1_wl u_t001_023/r1_r0_rwl u_t001_023/r1_r1_rwl
+ u_t001_023/r2_w0_wl u_t001_023/r2_w1_wl u_t001_023/r2_r0_rwl u_t001_023/r2_r1_rwl
+ u_t001_023/r3_w0_wl u_t001_023/r3_w1_wl u_t001_023/r3_r0_rwl u_t001_023/r3_r1_rwl
+ VSS u_t001_031/VSS VSUBS detronyx_12t_2w2r_rc4_4x4_routed_5layer_direct
Xu_t001_012 u_t001_012/c0_w0_bl u_t001_012/c0_w0_br u_t001_012/c0_w1_bl u_t001_012/c0_w1_br
+ u_t001_012/c0_r0_rbl u_t001_012/c0_r1_rbl u_t001_012/c1_w0_bl u_t001_012/c1_w0_br
+ u_t001_012/c1_w1_bl u_t001_012/c1_w1_br u_t001_012/c1_r0_rbl u_t001_012/c1_r1_rbl
+ u_t001_012/c2_w0_bl u_t001_012/c2_w0_br u_t001_012/c2_w1_bl u_t001_012/c2_w1_br
+ u_t001_012/c2_r0_rbl u_t001_012/c2_r1_rbl u_t001_012/c3_w0_bl u_t001_012/c3_w0_br
+ u_t001_012/c3_w1_bl u_t001_012/c3_w1_br u_t001_012/c3_r0_rbl u_t001_012/c3_r1_rbl
+ u_t001_012/r0_w0_wl u_t001_012/r0_w1_wl u_t001_012/r0_r0_rwl u_t001_012/r0_r1_rwl
+ u_t001_012/r1_w0_wl u_t001_012/r1_w1_wl u_t001_012/r1_r0_rwl u_t001_012/r1_r1_rwl
+ u_t001_012/r2_w0_wl u_t001_012/r2_w1_wl u_t001_012/r2_r0_rwl u_t001_012/r2_r1_rwl
+ u_t001_012/r3_w0_wl u_t001_012/r3_w1_wl u_t001_012/r3_r0_rwl u_t001_012/r3_r1_rwl
+ u_t001_012/VDD u_t001_031/VSS VSUBS detronyx_12t_2w2r_rc4_4x4_routed_5layer_direct
Xu_t001_001 u_t001_001/c0_w0_bl u_t001_001/c0_w0_br u_t001_001/c0_w1_bl u_t001_001/c0_w1_br
+ u_t001_001/c0_r0_rbl u_t001_001/c0_r1_rbl u_t001_001/c1_w0_bl u_t001_001/c1_w0_br
+ u_t001_001/c1_w1_bl u_t001_001/c1_w1_br u_t001_001/c1_r0_rbl u_t001_001/c1_r1_rbl
+ u_t001_001/c2_w0_bl u_t001_001/c2_w0_br u_t001_001/c2_w1_bl u_t001_001/c2_w1_br
+ u_t001_001/c2_r0_rbl u_t001_001/c2_r1_rbl u_t001_001/c3_w0_bl u_t001_001/c3_w0_br
+ u_t001_001/c3_w1_bl u_t001_001/c3_w1_br u_t001_001/c3_r0_rbl u_t001_001/c3_r1_rbl
+ u_t001_001/r0_w0_wl u_t001_001/r0_w1_wl u_t001_001/r0_r0_rwl u_t001_001/r0_r1_rwl
+ u_t001_001/r1_w0_wl u_t001_001/r1_w1_wl u_t001_001/r1_r0_rwl u_t001_001/r1_r1_rwl
+ u_t001_001/r2_w0_wl u_t001_001/r2_w1_wl u_t001_001/r2_r0_rwl u_t001_001/r2_r1_rwl
+ u_t001_001/r3_w0_wl u_t001_001/r3_w1_wl u_t001_001/r3_r0_rwl u_t001_001/r3_r1_rwl
+ VSS u_t001_031/VSS VSUBS detronyx_12t_2w2r_rc4_4x4_routed_5layer_direct
Xgf180mcu_as_sc_mcu7t3v3__inv_2_281 gf180mcu_as_sc_mcu7t3v3__inv_2_353/VDD gf180mcu_as_sc_mcu7t3v3__inv_2_368/VDD
+ VSS gf180mcu_as_sc_mcu7t3v3__inv_2_66/Y gf180mcu_as_sc_mcu7t3v3__inv_2_353/VNW VSUBS
+ gf180mcu_as_sc_mcu7t3v3__inv_2
Xgf180mcu_as_sc_mcu7t3v3__inv_2_270 gf180mcu_as_sc_mcu7t3v3__inv_2_350/VDD gf180mcu_as_sc_mcu7t3v3__inv_2_351/VDD
+ gf180mcu_as_sc_mcu7t3v3__inv_2_270/Y gf180mcu_as_sc_mcu7t3v3__inv_2_66/Y gf180mcu_as_sc_mcu7t3v3__inv_2_350/VNW
+ VSUBS gf180mcu_as_sc_mcu7t3v3__inv_2
Xgf180mcu_as_sc_mcu7t3v3__inv_2_292 gf180mcu_as_sc_mcu7t3v3__inv_2_363/VDD gf180mcu_as_sc_mcu7t3v3__inv_2_364/VDD
+ gf180mcu_as_sc_mcu7t3v3__inv_2_292/Y gf180mcu_as_sc_mcu7t3v3__inv_2_364/Y gf180mcu_as_sc_mcu7t3v3__inv_2_363/VNW
+ VSUBS gf180mcu_as_sc_mcu7t3v3__inv_2
Xgf180mcu_as_sc_mcu7t3v3__nand4_2_508 gf180mcu_as_sc_mcu7t3v3__inv_2_1688/VDD VSS
+ VSS VSS VSS VSS VSS gf180mcu_as_sc_mcu7t3v3__inv_2_1688/VNW VSUBS gf180mcu_as_sc_mcu7t3v3__nand4_2
Xgf180mcu_as_sc_mcu7t3v3__inv_2_18 gf180mcu_as_sc_mcu7t3v3__inv_2_77/VSS VSS VSS gf180mcu_as_sc_mcu7t3v3__inv_2_77/Y
+ gf180mcu_as_sc_mcu7t3v3__inv_2_59/VNW VSUBS gf180mcu_as_sc_mcu7t3v3__inv_2
Xgf180mcu_as_sc_mcu7t3v3__inv_2_29 gf180mcu_as_sc_mcu7t3v3__inv_2_71/VDD gf180mcu_as_sc_mcu7t3v3__inv_2_73/VDD
+ gf180mcu_as_sc_mcu7t3v3__inv_2_29/Y gf180mcu_as_sc_mcu7t3v3__inv_2_71/Y gf180mcu_as_sc_mcu7t3v3__inv_2_71/VNW
+ VSUBS gf180mcu_as_sc_mcu7t3v3__inv_2
Xgf180mcu_as_sc_mcu7t3v3__inv_2_1544 gf180mcu_as_sc_mcu7t3v3__inv_2_1592/VSS gf180mcu_as_sc_mcu7t3v3__inv_2_1548/VSS
+ gf180mcu_as_sc_mcu7t3v3__inv_2_1544/Y VSS gf180mcu_as_sc_mcu7t3v3__inv_2_1548/VNW
+ VSUBS gf180mcu_as_sc_mcu7t3v3__inv_2
Xgf180mcu_as_sc_mcu7t3v3__inv_2_1511 gf180mcu_as_sc_mcu7t3v3__inv_2_1548/VSS VSS VSS
+ VSS gf180mcu_as_sc_mcu7t3v3__inv_2_1525/VNW VSUBS gf180mcu_as_sc_mcu7t3v3__inv_2
Xgf180mcu_as_sc_mcu7t3v3__inv_2_1533 gf180mcu_as_sc_mcu7t3v3__inv_2_1535/VDD gf180mcu_as_sc_mcu7t3v3__inv_2_1539/VDD
+ VSS VSS gf180mcu_as_sc_mcu7t3v3__inv_2_1535/VNW VSUBS gf180mcu_as_sc_mcu7t3v3__inv_2
Xgf180mcu_as_sc_mcu7t3v3__inv_2_1522 gf180mcu_as_sc_mcu7t3v3__inv_2_1524/VDD VSS VSS
+ VSS gf180mcu_as_sc_mcu7t3v3__inv_2_1524/VNW VSUBS gf180mcu_as_sc_mcu7t3v3__inv_2
Xgf180mcu_as_sc_mcu7t3v3__inv_2_1500 gf180mcu_as_sc_mcu7t3v3__inv_2_1502/VDD gf180mcu_as_sc_mcu7t3v3__inv_2_1502/VSS
+ VSS VSS gf180mcu_as_sc_mcu7t3v3__inv_2_1502/VNW VSUBS gf180mcu_as_sc_mcu7t3v3__inv_2
.ends

.subckt gf180mcu_3v3_12t_2r2w_sram_512x32
Xdetronyx_12t_write_driver_rc1_44 detronyx_12t_write_driver_rc1_44/VDD VSUBS detronyx_12t_write_driver_rc1_44/din
+ detronyx_12t_write_driver_rc1_9/wen detronyx_12t_write_driver_rc1_44/wbl0 detronyx_12t_write_driver_rc1_9/wen
+ detronyx_12t_write_driver_rc1
Xdetronyx_12t_write_driver_rc1_33 detronyx_12t_write_driver_rc1_33/VDD VSUBS detronyx_12t_write_driver_rc1_9/wen
+ detronyx_12t_write_driver_rc1_9/wen detronyx_12t_write_driver_rc1_9/wen detronyx_12t_write_driver_rc1_9/wen
+ detronyx_12t_write_driver_rc1
Xdetronyx_12t_write_driver_rc1_11 detronyx_12t_write_driver_rc1_11/VDD VSUBS detronyx_12t_write_driver_rc1_11/din
+ detronyx_12t_write_driver_rc1_9/wen detronyx_12t_write_driver_rc1_11/wbl0 detronyx_12t_write_driver_rc1_9/wen
+ detronyx_12t_write_driver_rc1
Xdetronyx_12t_write_driver_rc1_22 detronyx_12t_write_driver_rc1_22/VDD VSUBS detronyx_12t_write_driver_rc1_9/wen
+ detronyx_12t_write_driver_rc1_9/wen detronyx_12t_write_driver_rc1_9/wen detronyx_12t_write_driver_rc1_9/wen
+ detronyx_12t_write_driver_rc1
Xdetronyx_12t_write_driver_rc1_55 detronyx_12t_write_driver_rc1_55/VDD VSUBS detronyx_12t_write_driver_rc1_55/din
+ detronyx_12t_write_driver_rc1_9/wen detronyx_12t_write_driver_rc1_55/wbl0 detronyx_12t_write_driver_rc1_9/wen
+ detronyx_12t_write_driver_rc1
Xdetronyx_12t_precharge_sense_rc1_62 detronyx_12t_precharge_sense_rc1_62/VDD VSUBS
+ detronyx_12t_write_driver_rc1_9/wen detronyx_12t_write_driver_rc1_9/wen detronyx_12t_write_driver_rc1_9/wen
+ detronyx_12t_write_driver_rc1_9/wen detronyx_12t_precharge_sense_rc1
Xdetronyx_12t_precharge_sense_rc1_40 detronyx_12t_precharge_sense_rc1_40/VDD VSUBS
+ detronyx_12t_write_driver_rc1_9/wen detronyx_12t_write_driver_rc1_9/wen detronyx_12t_write_driver_rc1_9/wen
+ detronyx_12t_write_driver_rc1_9/wen detronyx_12t_precharge_sense_rc1
Xdetronyx_12t_precharge_sense_rc1_51 detronyx_12t_precharge_sense_rc1_51/VDD VSUBS
+ detronyx_12t_write_driver_rc1_9/wen detronyx_12t_write_driver_rc1_9/wen detronyx_12t_write_driver_rc1_9/wen
+ detronyx_12t_write_driver_rc1_9/wen detronyx_12t_precharge_sense_rc1
Xdetronyx_12t_write_driver_rc1_45 detronyx_12t_write_driver_rc1_45/VDD VSUBS detronyx_12t_write_driver_rc1_45/din
+ detronyx_12t_write_driver_rc1_9/wen detronyx_12t_write_driver_rc1_45/wbl0 detronyx_12t_write_driver_rc1_9/wen
+ detronyx_12t_write_driver_rc1
Xdetronyx_12t_write_driver_rc1_34 detronyx_12t_write_driver_rc1_34/VDD VSUBS detronyx_12t_write_driver_rc1_9/wen
+ detronyx_12t_write_driver_rc1_9/wen detronyx_12t_write_driver_rc1_9/wen detronyx_12t_write_driver_rc1_9/wen
+ detronyx_12t_write_driver_rc1
Xdetronyx_12t_write_driver_rc1_23 detronyx_12t_write_driver_rc1_23/VDD VSUBS detronyx_12t_write_driver_rc1_9/wen
+ detronyx_12t_write_driver_rc1_9/wen detronyx_12t_write_driver_rc1_9/wen detronyx_12t_write_driver_rc1_9/wen
+ detronyx_12t_write_driver_rc1
Xdetronyx_12t_write_driver_rc1_12 detronyx_12t_write_driver_rc1_12/VDD VSUBS detronyx_12t_write_driver_rc1_12/din
+ detronyx_12t_write_driver_rc1_9/wen detronyx_12t_write_driver_rc1_12/wbl0 detronyx_12t_write_driver_rc1_9/wen
+ detronyx_12t_write_driver_rc1
Xdetronyx_12t_write_driver_rc1_56 detronyx_12t_write_driver_rc1_56/VDD VSUBS detronyx_12t_write_driver_rc1_56/din
+ detronyx_12t_write_driver_rc1_9/wen detronyx_12t_write_driver_rc1_56/wbl0 detronyx_12t_write_driver_rc1_9/wen
+ detronyx_12t_write_driver_rc1
Xdetronyx_12t_precharge_sense_rc1_41 detronyx_12t_precharge_sense_rc1_41/VDD VSUBS
+ detronyx_12t_write_driver_rc1_9/wen detronyx_12t_write_driver_rc1_9/wen detronyx_12t_write_driver_rc1_9/wen
+ detronyx_12t_write_driver_rc1_9/wen detronyx_12t_precharge_sense_rc1
Xdetronyx_12t_precharge_sense_rc1_52 detronyx_12t_precharge_sense_rc1_52/VDD VSUBS
+ detronyx_12t_write_driver_rc1_9/wen detronyx_12t_precharge_sense_rc1_52/ren detronyx_12t_precharge_sense_rc1_52/ren
+ detronyx_12t_write_driver_rc1_9/wen detronyx_12t_precharge_sense_rc1
Xdetronyx_12t_precharge_sense_rc1_63 detronyx_12t_precharge_sense_rc1_63/VDD VSUBS
+ detronyx_12t_write_driver_rc1_9/wen detronyx_12t_write_driver_rc1_9/wen detronyx_12t_write_driver_rc1_9/wen
+ detronyx_12t_write_driver_rc1_9/wen detronyx_12t_precharge_sense_rc1
Xdetronyx_12t_precharge_sense_rc1_30 detronyx_12t_precharge_sense_rc1_30/VDD VSUBS
+ detronyx_12t_write_driver_rc1_9/wen detronyx_12t_precharge_sense_rc1_30/ren detronyx_12t_precharge_sense_rc1_30/ren
+ detronyx_12t_write_driver_rc1_9/wen detronyx_12t_precharge_sense_rc1
Xdetronyx_12t_write_driver_rc1_46 detronyx_12t_write_driver_rc1_46/VDD VSUBS detronyx_12t_write_driver_rc1_46/din
+ detronyx_12t_write_driver_rc1_9/wen detronyx_12t_write_driver_rc1_46/wbl0 detronyx_12t_write_driver_rc1_9/wen
+ detronyx_12t_write_driver_rc1
Xdetronyx_12t_write_driver_rc1_35 detronyx_12t_write_driver_rc1_35/VDD VSUBS detronyx_12t_write_driver_rc1_9/wen
+ detronyx_12t_write_driver_rc1_9/wen detronyx_12t_write_driver_rc1_9/wen detronyx_12t_write_driver_rc1_9/wen
+ detronyx_12t_write_driver_rc1
Xdetronyx_12t_write_driver_rc1_57 detronyx_12t_write_driver_rc1_57/VDD VSUBS detronyx_12t_write_driver_rc1_9/wen
+ detronyx_12t_write_driver_rc1_9/wen detronyx_12t_write_driver_rc1_9/wen detronyx_12t_write_driver_rc1_9/wen
+ detronyx_12t_write_driver_rc1
Xdetronyx_12t_write_driver_rc1_13 detronyx_12t_write_driver_rc1_13/VDD VSUBS detronyx_12t_write_driver_rc1_9/wen
+ detronyx_12t_write_driver_rc1_9/wen detronyx_12t_write_driver_rc1_9/wen detronyx_12t_write_driver_rc1_9/wen
+ detronyx_12t_write_driver_rc1
Xdetronyx_12t_write_driver_rc1_24 detronyx_12t_write_driver_rc1_24/VDD VSUBS detronyx_12t_write_driver_rc1_24/din
+ detronyx_12t_write_driver_rc1_9/wen detronyx_12t_write_driver_rc1_24/wbl0 detronyx_12t_write_driver_rc1_9/wen
+ detronyx_12t_write_driver_rc1
Xdetronyx_12t_precharge_sense_rc1_42 detronyx_12t_precharge_sense_rc1_42/VDD VSUBS
+ detronyx_12t_write_driver_rc1_9/wen detronyx_12t_write_driver_rc1_9/wen detronyx_12t_write_driver_rc1_9/wen
+ detronyx_12t_write_driver_rc1_9/wen detronyx_12t_precharge_sense_rc1
Xdetronyx_12t_precharge_sense_rc1_53 detronyx_12t_precharge_sense_rc1_53/VDD VSUBS
+ detronyx_12t_write_driver_rc1_9/wen detronyx_12t_precharge_sense_rc1_53/ren detronyx_12t_precharge_sense_rc1_53/ren
+ detronyx_12t_write_driver_rc1_9/wen detronyx_12t_precharge_sense_rc1
Xdetronyx_12t_precharge_sense_rc1_20 detronyx_12t_precharge_sense_rc1_20/VDD VSUBS
+ detronyx_12t_write_driver_rc1_9/wen detronyx_12t_write_driver_rc1_9/wen detronyx_12t_write_driver_rc1_9/wen
+ detronyx_12t_write_driver_rc1_9/wen detronyx_12t_precharge_sense_rc1
Xdetronyx_12t_precharge_sense_rc1_31 detronyx_12t_precharge_sense_rc1_31/VDD VSUBS
+ detronyx_12t_write_driver_rc1_9/wen detronyx_12t_write_driver_rc1_9/wen detronyx_12t_write_driver_rc1_9/wen
+ detronyx_12t_write_driver_rc1_9/wen detronyx_12t_precharge_sense_rc1
Xdetronyx_12t_write_driver_rc1_25 detronyx_12t_write_driver_rc1_25/VDD VSUBS detronyx_12t_write_driver_rc1_9/wen
+ detronyx_12t_write_driver_rc1_9/wen detronyx_12t_write_driver_rc1_25/wbl0 detronyx_12t_write_driver_rc1_25/wbr0
+ detronyx_12t_write_driver_rc1
Xdetronyx_12t_write_driver_rc1_47 detronyx_12t_write_driver_rc1_47/VDD VSUBS detronyx_12t_write_driver_rc1_47/din
+ detronyx_12t_write_driver_rc1_9/wen detronyx_12t_write_driver_rc1_47/wbl0 detronyx_12t_write_driver_rc1_9/wen
+ detronyx_12t_write_driver_rc1
Xdetronyx_12t_write_driver_rc1_36 detronyx_12t_write_driver_rc1_36/VDD VSUBS detronyx_12t_write_driver_rc1_9/wen
+ detronyx_12t_write_driver_rc1_9/wen detronyx_12t_write_driver_rc1_9/wen detronyx_12t_write_driver_rc1_9/wen
+ detronyx_12t_write_driver_rc1
Xdetronyx_12t_write_driver_rc1_58 detronyx_12t_write_driver_rc1_58/VDD VSUBS detronyx_12t_write_driver_rc1_9/wen
+ detronyx_12t_write_driver_rc1_9/wen detronyx_12t_write_driver_rc1_9/wen detronyx_12t_write_driver_rc1_9/wen
+ detronyx_12t_write_driver_rc1
Xdetronyx_12t_write_driver_rc1_14 detronyx_12t_write_driver_rc1_14/VDD VSUBS detronyx_12t_write_driver_rc1_9/wen
+ detronyx_12t_write_driver_rc1_9/wen detronyx_12t_write_driver_rc1_9/wen detronyx_12t_write_driver_rc1_9/wen
+ detronyx_12t_write_driver_rc1
Xdetronyx_12t_precharge_sense_rc1_43 detronyx_12t_precharge_sense_rc1_43/VDD VSUBS
+ detronyx_12t_write_driver_rc1_9/wen detronyx_12t_write_driver_rc1_9/wen detronyx_12t_write_driver_rc1_9/wen
+ detronyx_12t_write_driver_rc1_9/wen detronyx_12t_precharge_sense_rc1
Xdetronyx_12t_precharge_sense_rc1_54 detronyx_12t_precharge_sense_rc1_54/VDD VSUBS
+ detronyx_12t_write_driver_rc1_9/wen detronyx_12t_precharge_sense_rc1_54/ren detronyx_12t_precharge_sense_rc1_54/ren
+ detronyx_12t_write_driver_rc1_9/wen detronyx_12t_precharge_sense_rc1
Xdetronyx_12t_precharge_sense_rc1_21 detronyx_12t_precharge_sense_rc1_21/VDD VSUBS
+ detronyx_12t_write_driver_rc1_9/wen detronyx_12t_write_driver_rc1_9/wen detronyx_12t_write_driver_rc1_9/wen
+ detronyx_12t_write_driver_rc1_9/wen detronyx_12t_precharge_sense_rc1
Xdetronyx_12t_precharge_sense_rc1_10 detronyx_12t_precharge_sense_rc1_10/VDD VSUBS
+ detronyx_12t_write_driver_rc1_9/wen detronyx_12t_write_driver_rc1_9/wen detronyx_12t_write_driver_rc1_9/wen
+ detronyx_12t_write_driver_rc1_9/wen detronyx_12t_precharge_sense_rc1
Xdetronyx_12t_precharge_sense_rc1_32 detronyx_12t_precharge_sense_rc1_32/VDD VSUBS
+ detronyx_12t_write_driver_rc1_9/wen detronyx_12t_write_driver_rc1_9/wen detronyx_12t_write_driver_rc1_9/wen
+ detronyx_12t_write_driver_rc1_9/wen detronyx_12t_precharge_sense_rc1
Xdetronyx_12t_write_driver_rc1_26 detronyx_12t_write_driver_rc1_26/VDD VSUBS detronyx_12t_write_driver_rc1_9/wen
+ detronyx_12t_write_driver_rc1_9/wen detronyx_12t_write_driver_rc1_9/wen detronyx_12t_write_driver_rc1_9/wen
+ detronyx_12t_write_driver_rc1
Xdetronyx_12t_write_driver_rc1_48 detronyx_12t_write_driver_rc1_48/VDD VSUBS detronyx_12t_write_driver_rc1_48/din
+ detronyx_12t_write_driver_rc1_9/wen detronyx_12t_write_driver_rc1_48/wbl0 detronyx_12t_write_driver_rc1_9/wen
+ detronyx_12t_write_driver_rc1
Xdetronyx_12t_write_driver_rc1_37 detronyx_12t_write_driver_rc1_37/VDD VSUBS detronyx_12t_write_driver_rc1_9/wen
+ detronyx_12t_write_driver_rc1_9/wen detronyx_12t_write_driver_rc1_9/wen detronyx_12t_write_driver_rc1_9/wen
+ detronyx_12t_write_driver_rc1
Xdetronyx_12t_write_driver_rc1_15 detronyx_12t_write_driver_rc1_15/VDD VSUBS detronyx_12t_write_driver_rc1_9/wen
+ detronyx_12t_write_driver_rc1_9/wen detronyx_12t_write_driver_rc1_9/wen detronyx_12t_write_driver_rc1_9/wen
+ detronyx_12t_write_driver_rc1
Xdetronyx_12t_write_driver_rc1_59 detronyx_12t_write_driver_rc1_59/VDD VSUBS detronyx_12t_write_driver_rc1_9/wen
+ detronyx_12t_write_driver_rc1_9/wen detronyx_12t_write_driver_rc1_9/wen detronyx_12t_write_driver_rc1_9/wen
+ detronyx_12t_write_driver_rc1
Xdetronyx_12t_precharge_sense_rc1_44 detronyx_12t_precharge_sense_rc1_44/VDD VSUBS
+ detronyx_12t_write_driver_rc1_9/wen detronyx_12t_write_driver_rc1_9/wen detronyx_12t_write_driver_rc1_9/wen
+ detronyx_12t_write_driver_rc1_9/wen detronyx_12t_precharge_sense_rc1
Xdetronyx_12t_precharge_sense_rc1_55 detronyx_12t_precharge_sense_rc1_55/VDD VSUBS
+ detronyx_12t_write_driver_rc1_9/wen detronyx_12t_precharge_sense_rc1_55/ren detronyx_12t_precharge_sense_rc1_55/ren
+ detronyx_12t_write_driver_rc1_9/wen detronyx_12t_precharge_sense_rc1
Xdetronyx_12t_precharge_sense_rc1_22 detronyx_12t_precharge_sense_rc1_22/VDD VSUBS
+ detronyx_12t_write_driver_rc1_9/wen detronyx_12t_write_driver_rc1_9/wen detronyx_12t_write_driver_rc1_9/wen
+ detronyx_12t_write_driver_rc1_9/wen detronyx_12t_precharge_sense_rc1
Xdetronyx_12t_precharge_sense_rc1_33 detronyx_12t_precharge_sense_rc1_33/VDD VSUBS
+ detronyx_12t_write_driver_rc1_9/wen detronyx_12t_write_driver_rc1_9/wen detronyx_12t_write_driver_rc1_9/wen
+ detronyx_12t_write_driver_rc1_9/wen detronyx_12t_precharge_sense_rc1
Xdetronyx_12t_precharge_sense_rc1_11 detronyx_12t_precharge_sense_rc1_11/VDD VSUBS
+ detronyx_12t_write_driver_rc1_9/wen detronyx_12t_write_driver_rc1_9/wen detronyx_12t_write_driver_rc1_9/wen
+ detronyx_12t_write_driver_rc1_9/wen detronyx_12t_precharge_sense_rc1
Xdetronyx_12t_write_driver_rc1_27 detronyx_12t_write_driver_rc1_27/VDD VSUBS detronyx_12t_write_driver_rc1_9/wen
+ detronyx_12t_write_driver_rc1_9/wen detronyx_12t_write_driver_rc1_9/wen detronyx_12t_write_driver_rc1_9/wen
+ detronyx_12t_write_driver_rc1
Xdetronyx_12t_write_driver_rc1_49 detronyx_12t_write_driver_rc1_49/VDD VSUBS detronyx_12t_write_driver_rc1_49/din
+ detronyx_12t_write_driver_rc1_9/wen detronyx_12t_write_driver_rc1_49/wbl0 detronyx_12t_write_driver_rc1_9/wen
+ detronyx_12t_write_driver_rc1
Xdetronyx_12t_write_driver_rc1_38 detronyx_12t_write_driver_rc1_38/VDD VSUBS detronyx_12t_write_driver_rc1_9/wen
+ detronyx_12t_write_driver_rc1_9/wen detronyx_12t_write_driver_rc1_9/wen detronyx_12t_write_driver_rc1_9/wen
+ detronyx_12t_write_driver_rc1
Xdetronyx_12t_write_driver_rc1_16 detronyx_12t_write_driver_rc1_16/VDD VSUBS detronyx_12t_write_driver_rc1_9/wen
+ detronyx_12t_write_driver_rc1_9/wen detronyx_12t_write_driver_rc1_9/wen detronyx_12t_write_driver_rc1_9/wen
+ detronyx_12t_write_driver_rc1
Xdetronyx_12t_precharge_sense_rc1_45 detronyx_12t_precharge_sense_rc1_45/VDD VSUBS
+ detronyx_12t_write_driver_rc1_9/wen detronyx_12t_write_driver_rc1_9/wen detronyx_12t_write_driver_rc1_9/wen
+ detronyx_12t_write_driver_rc1_9/wen detronyx_12t_precharge_sense_rc1
Xdetronyx_12t_precharge_sense_rc1_56 detronyx_12t_precharge_sense_rc1_56/VDD VSUBS
+ detronyx_12t_write_driver_rc1_9/wen detronyx_12t_write_driver_rc1_9/wen detronyx_12t_write_driver_rc1_9/wen
+ detronyx_12t_write_driver_rc1_9/wen detronyx_12t_precharge_sense_rc1
Xdetronyx_12t_precharge_sense_rc1_23 detronyx_12t_precharge_sense_rc1_23/VDD VSUBS
+ detronyx_12t_write_driver_rc1_9/wen detronyx_12t_precharge_sense_rc1_23/ren detronyx_12t_precharge_sense_rc1_23/ren
+ detronyx_12t_write_driver_rc1_9/wen detronyx_12t_precharge_sense_rc1
Xdetronyx_12t_precharge_sense_rc1_12 detronyx_12t_precharge_sense_rc1_12/VDD VSUBS
+ detronyx_12t_write_driver_rc1_9/wen detronyx_12t_write_driver_rc1_9/wen detronyx_12t_write_driver_rc1_9/wen
+ detronyx_12t_write_driver_rc1_9/wen detronyx_12t_precharge_sense_rc1
Xdetronyx_12t_precharge_sense_rc1_34 detronyx_12t_precharge_sense_rc1_34/VDD VSUBS
+ detronyx_12t_write_driver_rc1_9/wen detronyx_12t_precharge_sense_rc1_34/ren detronyx_12t_precharge_sense_rc1_34/ren
+ detronyx_12t_write_driver_rc1_9/wen detronyx_12t_precharge_sense_rc1
Xdetronyx_12t_write_driver_rc1_28 detronyx_12t_write_driver_rc1_28/VDD VSUBS detronyx_12t_write_driver_rc1_9/wen
+ detronyx_12t_write_driver_rc1_9/wen detronyx_12t_write_driver_rc1_9/wen detronyx_12t_write_driver_rc1_9/wen
+ detronyx_12t_write_driver_rc1
Xdetronyx_12t_write_driver_rc1_39 detronyx_12t_write_driver_rc1_39/VDD VSUBS detronyx_12t_write_driver_rc1_9/wen
+ detronyx_12t_write_driver_rc1_9/wen detronyx_12t_write_driver_rc1_9/wen detronyx_12t_write_driver_rc1_9/wen
+ detronyx_12t_write_driver_rc1
Xdetronyx_12t_write_driver_rc1_17 detronyx_12t_write_driver_rc1_17/VDD VSUBS detronyx_12t_write_driver_rc1_9/wen
+ detronyx_12t_write_driver_rc1_9/wen detronyx_12t_write_driver_rc1_9/wen detronyx_12t_write_driver_rc1_9/wen
+ detronyx_12t_write_driver_rc1
Xdetronyx_12t_precharge_sense_rc1_46 detronyx_12t_precharge_sense_rc1_46/VDD VSUBS
+ detronyx_12t_write_driver_rc1_9/wen detronyx_12t_write_driver_rc1_9/wen detronyx_12t_write_driver_rc1_9/wen
+ detronyx_12t_write_driver_rc1_9/wen detronyx_12t_precharge_sense_rc1
Xdetronyx_12t_precharge_sense_rc1_57 detronyx_12t_precharge_sense_rc1_57/VDD VSUBS
+ detronyx_12t_write_driver_rc1_9/wen detronyx_12t_write_driver_rc1_9/wen detronyx_12t_write_driver_rc1_9/wen
+ detronyx_12t_write_driver_rc1_9/wen detronyx_12t_precharge_sense_rc1
Xdetronyx_12t_precharge_sense_rc1_24 detronyx_12t_precharge_sense_rc1_24/VDD VSUBS
+ detronyx_12t_write_driver_rc1_9/wen detronyx_12t_write_driver_rc1_9/wen detronyx_12t_write_driver_rc1_9/wen
+ detronyx_12t_write_driver_rc1_9/wen detronyx_12t_precharge_sense_rc1
Xdetronyx_12t_precharge_sense_rc1_13 detronyx_12t_precharge_sense_rc1_13/VDD VSUBS
+ detronyx_12t_write_driver_rc1_9/wen detronyx_12t_write_driver_rc1_9/wen detronyx_12t_write_driver_rc1_9/wen
+ detronyx_12t_write_driver_rc1_9/wen detronyx_12t_precharge_sense_rc1
Xdetronyx_12t_precharge_sense_rc1_35 detronyx_12t_precharge_sense_rc1_35/VDD VSUBS
+ detronyx_12t_write_driver_rc1_9/wen detronyx_12t_precharge_sense_rc1_35/ren detronyx_12t_precharge_sense_rc1_35/ren
+ detronyx_12t_write_driver_rc1_9/wen detronyx_12t_precharge_sense_rc1
Xdetronyx_12t_write_driver_rc1_29 detronyx_12t_write_driver_rc1_29/VDD VSUBS detronyx_12t_write_driver_rc1_9/wen
+ detronyx_12t_write_driver_rc1_9/wen detronyx_12t_write_driver_rc1_9/wen detronyx_12t_write_driver_rc1_9/wen
+ detronyx_12t_write_driver_rc1
Xdetronyx_12t_write_driver_rc1_18 detronyx_12t_write_driver_rc1_18/VDD VSUBS detronyx_12t_write_driver_rc1_9/wen
+ detronyx_12t_write_driver_rc1_9/wen detronyx_12t_write_driver_rc1_9/wen detronyx_12t_write_driver_rc1_9/wen
+ detronyx_12t_write_driver_rc1
Xdetronyx_12t_precharge_sense_rc1_47 detronyx_12t_precharge_sense_rc1_47/VDD VSUBS
+ detronyx_12t_write_driver_rc1_9/wen detronyx_12t_write_driver_rc1_9/wen detronyx_12t_write_driver_rc1_9/wen
+ detronyx_12t_write_driver_rc1_9/wen detronyx_12t_precharge_sense_rc1
Xdetronyx_12t_precharge_sense_rc1_58 detronyx_12t_precharge_sense_rc1_58/VDD VSUBS
+ detronyx_12t_write_driver_rc1_9/wen detronyx_12t_write_driver_rc1_9/wen detronyx_12t_write_driver_rc1_9/wen
+ detronyx_12t_write_driver_rc1_9/wen detronyx_12t_precharge_sense_rc1
Xdetronyx_12t_precharge_sense_rc1_25 detronyx_12t_precharge_sense_rc1_25/VDD VSUBS
+ detronyx_12t_write_driver_rc1_9/wen detronyx_12t_write_driver_rc1_9/wen detronyx_12t_write_driver_rc1_9/wen
+ detronyx_12t_write_driver_rc1_9/wen detronyx_12t_precharge_sense_rc1
Xdetronyx_12t_precharge_sense_rc1_36 detronyx_12t_precharge_sense_rc1_36/VDD VSUBS
+ detronyx_12t_write_driver_rc1_9/wen detronyx_12t_precharge_sense_rc1_36/ren detronyx_12t_precharge_sense_rc1_36/ren
+ detronyx_12t_write_driver_rc1_9/wen detronyx_12t_precharge_sense_rc1
Xdetronyx_12t_precharge_sense_rc1_14 detronyx_12t_precharge_sense_rc1_14/VDD VSUBS
+ detronyx_12t_write_driver_rc1_9/wen detronyx_12t_write_driver_rc1_9/wen detronyx_12t_write_driver_rc1_9/wen
+ detronyx_12t_write_driver_rc1_9/wen detronyx_12t_precharge_sense_rc1
Xdetronyx_12t_write_driver_rc1_19 detronyx_12t_write_driver_rc1_19/VDD VSUBS detronyx_12t_write_driver_rc1_9/wen
+ detronyx_12t_write_driver_rc1_9/wen detronyx_12t_write_driver_rc1_9/wen detronyx_12t_write_driver_rc1_9/wen
+ detronyx_12t_write_driver_rc1
Xdetronyx_12t_precharge_sense_rc1_37 detronyx_12t_precharge_sense_rc1_37/VDD VSUBS
+ detronyx_12t_write_driver_rc1_9/wen detronyx_12t_write_driver_rc1_9/wen detronyx_12t_write_driver_rc1_9/wen
+ detronyx_12t_write_driver_rc1_9/wen detronyx_12t_precharge_sense_rc1
Xdetronyx_12t_precharge_sense_rc1_48 detronyx_12t_precharge_sense_rc1_48/VDD VSUBS
+ detronyx_12t_write_driver_rc1_9/wen detronyx_12t_write_driver_rc1_9/wen detronyx_12t_write_driver_rc1_9/wen
+ detronyx_12t_write_driver_rc1_9/wen detronyx_12t_precharge_sense_rc1
Xdetronyx_12t_precharge_sense_rc1_59 detronyx_12t_precharge_sense_rc1_59/VDD VSUBS
+ detronyx_12t_write_driver_rc1_9/wen detronyx_12t_precharge_sense_rc1_59/ren detronyx_12t_precharge_sense_rc1_59/ren
+ detronyx_12t_write_driver_rc1_9/wen detronyx_12t_precharge_sense_rc1
Xdetronyx_12t_precharge_sense_rc1_26 detronyx_12t_precharge_sense_rc1_26/VDD VSUBS
+ detronyx_12t_write_driver_rc1_9/wen detronyx_12t_write_driver_rc1_9/wen detronyx_12t_write_driver_rc1_9/wen
+ detronyx_12t_write_driver_rc1_9/wen detronyx_12t_precharge_sense_rc1
Xdetronyx_12t_precharge_sense_rc1_15 detronyx_12t_precharge_sense_rc1_15/VDD VSUBS
+ detronyx_12t_write_driver_rc1_9/wen detronyx_12t_write_driver_rc1_9/wen detronyx_12t_write_driver_rc1_9/wen
+ detronyx_12t_write_driver_rc1_9/wen detronyx_12t_precharge_sense_rc1
Xdetronyx_12t_precharge_sense_rc1_49 detronyx_12t_precharge_sense_rc1_49/VDD VSUBS
+ detronyx_12t_write_driver_rc1_9/wen detronyx_12t_write_driver_rc1_9/wen detronyx_12t_write_driver_rc1_9/wen
+ detronyx_12t_write_driver_rc1_9/wen detronyx_12t_precharge_sense_rc1
Xdetronyx_12t_precharge_sense_rc1_38 detronyx_12t_precharge_sense_rc1_38/VDD VSUBS
+ detronyx_12t_write_driver_rc1_9/wen detronyx_12t_write_driver_rc1_9/wen detronyx_12t_write_driver_rc1_9/wen
+ detronyx_12t_write_driver_rc1_9/wen detronyx_12t_precharge_sense_rc1
Xdetronyx_12t_precharge_sense_rc1_27 detronyx_12t_precharge_sense_rc1_27/VDD VSUBS
+ detronyx_12t_write_driver_rc1_9/wen detronyx_12t_write_driver_rc1_9/wen detronyx_12t_write_driver_rc1_9/wen
+ detronyx_12t_write_driver_rc1_9/wen detronyx_12t_precharge_sense_rc1
Xdetronyx_12t_precharge_sense_rc1_16 detronyx_12t_precharge_sense_rc1_16/VDD VSUBS
+ detronyx_12t_write_driver_rc1_9/wen detronyx_12t_write_driver_rc1_9/wen detronyx_12t_write_driver_rc1_9/wen
+ detronyx_12t_write_driver_rc1_9/wen detronyx_12t_precharge_sense_rc1
Xdetronyx_12t_precharge_sense_rc1_39 detronyx_12t_precharge_sense_rc1_39/VDD VSUBS
+ detronyx_12t_write_driver_rc1_9/wen detronyx_12t_write_driver_rc1_9/wen detronyx_12t_write_driver_rc1_9/wen
+ detronyx_12t_write_driver_rc1_9/wen detronyx_12t_precharge_sense_rc1
Xdetronyx_12t_precharge_sense_rc1_17 detronyx_12t_precharge_sense_rc1_17/VDD VSUBS
+ detronyx_12t_write_driver_rc1_9/wen detronyx_12t_write_driver_rc1_9/wen detronyx_12t_write_driver_rc1_9/wen
+ detronyx_12t_write_driver_rc1_9/wen detronyx_12t_precharge_sense_rc1
Xdetronyx_12t_precharge_sense_rc1_28 detronyx_12t_precharge_sense_rc1_28/VDD VSUBS
+ detronyx_12t_precharge_sense_rc1_28/dout detronyx_12t_write_driver_rc1_9/wen detronyx_12t_write_driver_rc1_9/wen
+ detronyx_12t_precharge_sense_rc1_28/dout detronyx_12t_precharge_sense_rc1
Xdetronyx_12t_precharge_sense_rc1_18 detronyx_12t_precharge_sense_rc1_18/VDD VSUBS
+ detronyx_12t_write_driver_rc1_9/wen detronyx_12t_write_driver_rc1_9/wen detronyx_12t_write_driver_rc1_9/wen
+ detronyx_12t_write_driver_rc1_9/wen detronyx_12t_precharge_sense_rc1
Xdetronyx_12t_precharge_sense_rc1_29 detronyx_12t_precharge_sense_rc1_29/VDD VSUBS
+ detronyx_12t_write_driver_rc1_9/wen detronyx_12t_precharge_sense_rc1_29/ren detronyx_12t_precharge_sense_rc1_29/ren
+ detronyx_12t_write_driver_rc1_9/wen detronyx_12t_precharge_sense_rc1
Xdetronyx_12t_precharge_sense_rc1_19 detronyx_12t_precharge_sense_rc1_19/VDD VSUBS
+ detronyx_12t_write_driver_rc1_9/wen detronyx_12t_write_driver_rc1_9/wen detronyx_12t_write_driver_rc1_9/wen
+ detronyx_12t_write_driver_rc1_9/wen detronyx_12t_precharge_sense_rc1
Xdetronyx_12t_write_driver_rc1_0 detronyx_12t_write_driver_rc1_0/VDD VSUBS detronyx_12t_write_driver_rc1_9/wen
+ detronyx_12t_write_driver_rc1_9/wen detronyx_12t_write_driver_rc1_9/wen detronyx_12t_write_driver_rc1_9/wen
+ detronyx_12t_write_driver_rc1
Xdetronyx_12t_write_driver_rc1_1 detronyx_12t_write_driver_rc1_1/VDD VSUBS detronyx_12t_write_driver_rc1_1/din
+ detronyx_12t_write_driver_rc1_9/wen detronyx_12t_write_driver_rc1_1/wbl0 detronyx_12t_write_driver_rc1_9/wen
+ detronyx_12t_write_driver_rc1
Xdetronyx_12t_write_driver_rc1_2 detronyx_12t_write_driver_rc1_2/VDD VSUBS detronyx_12t_write_driver_rc1_2/din
+ detronyx_12t_write_driver_rc1_9/wen detronyx_12t_write_driver_rc1_2/wbl0 detronyx_12t_write_driver_rc1_9/wen
+ detronyx_12t_write_driver_rc1
Xdetronyx_12t_write_driver_rc1_3 detronyx_12t_write_driver_rc1_3/VDD VSUBS detronyx_12t_write_driver_rc1_3/din
+ detronyx_12t_write_driver_rc1_9/wen detronyx_12t_write_driver_rc1_3/wbl0 detronyx_12t_write_driver_rc1_9/wen
+ detronyx_12t_write_driver_rc1
Xdetronyx_12t_precharge_sense_rc1_0 detronyx_12t_precharge_sense_rc1_0/VDD VSUBS detronyx_12t_write_driver_rc1_9/wen
+ detronyx_12t_precharge_sense_rc1_0/ren detronyx_12t_precharge_sense_rc1_0/ren detronyx_12t_write_driver_rc1_9/wen
+ detronyx_12t_precharge_sense_rc1
Xdetronyx_12t_write_driver_rc1_4 detronyx_12t_write_driver_rc1_4/VDD VSUBS detronyx_12t_write_driver_rc1_4/din
+ detronyx_12t_write_driver_rc1_9/wen detronyx_12t_write_driver_rc1_4/wbl0 detronyx_12t_write_driver_rc1_9/wen
+ detronyx_12t_write_driver_rc1
Xdetronyx_12t_precharge_sense_rc1_1 detronyx_12t_precharge_sense_rc1_1/VDD VSUBS detronyx_12t_write_driver_rc1_9/wen
+ detronyx_12t_write_driver_rc1_9/wen detronyx_12t_write_driver_rc1_9/wen detronyx_12t_write_driver_rc1_9/wen
+ detronyx_12t_precharge_sense_rc1
Xdetronyx_12t_write_driver_rc1_5 detronyx_12t_write_driver_rc1_5/VDD VSUBS detronyx_12t_write_driver_rc1_5/din
+ detronyx_12t_write_driver_rc1_9/wen detronyx_12t_write_driver_rc1_5/wbl0 detronyx_12t_write_driver_rc1_9/wen
+ detronyx_12t_write_driver_rc1
Xdetronyx_12t_precharge_sense_rc1_2 detronyx_12t_precharge_sense_rc1_2/VDD VSUBS detronyx_12t_write_driver_rc1_9/wen
+ detronyx_12t_write_driver_rc1_9/wen detronyx_12t_write_driver_rc1_9/wen detronyx_12t_write_driver_rc1_9/wen
+ detronyx_12t_precharge_sense_rc1
Xdetronyx_12t_write_driver_rc1_6 detronyx_12t_write_driver_rc1_6/VDD VSUBS detronyx_12t_write_driver_rc1_6/din
+ detronyx_12t_write_driver_rc1_9/wen detronyx_12t_write_driver_rc1_6/wbl0 detronyx_12t_write_driver_rc1_9/wen
+ detronyx_12t_write_driver_rc1
Xdetronyx_12t_precharge_sense_rc1_3 detronyx_12t_precharge_sense_rc1_3/VDD VSUBS detronyx_12t_write_driver_rc1_9/wen
+ detronyx_12t_write_driver_rc1_9/wen detronyx_12t_write_driver_rc1_9/wen detronyx_12t_write_driver_rc1_9/wen
+ detronyx_12t_precharge_sense_rc1
Xdetronyx_12t_write_driver_rc1_7 detronyx_12t_write_driver_rc1_7/VDD VSUBS detronyx_12t_write_driver_rc1_7/din
+ detronyx_12t_write_driver_rc1_9/wen detronyx_12t_write_driver_rc1_7/wbl0 detronyx_12t_write_driver_rc1_9/wen
+ detronyx_12t_write_driver_rc1
Xdetronyx_12t_precharge_sense_rc1_4 detronyx_12t_precharge_sense_rc1_4/VDD VSUBS detronyx_12t_write_driver_rc1_9/wen
+ detronyx_12t_precharge_sense_rc1_4/ren detronyx_12t_precharge_sense_rc1_4/ren detronyx_12t_write_driver_rc1_9/wen
+ detronyx_12t_precharge_sense_rc1
Xdetronyx_12t_write_driver_rc1_8 detronyx_12t_write_driver_rc1_8/VDD VSUBS detronyx_12t_write_driver_rc1_8/din
+ detronyx_12t_write_driver_rc1_9/wen detronyx_12t_write_driver_rc1_8/wbl0 detronyx_12t_write_driver_rc1_9/wen
+ detronyx_12t_write_driver_rc1
Xdetronyx_12t_precharge_sense_rc1_5 detronyx_12t_precharge_sense_rc1_5/VDD VSUBS detronyx_12t_write_driver_rc1_9/wen
+ detronyx_12t_precharge_sense_rc1_5/ren detronyx_12t_precharge_sense_rc1_5/ren detronyx_12t_write_driver_rc1_9/wen
+ detronyx_12t_precharge_sense_rc1
Xdetronyx_12t_write_driver_rc1_9 detronyx_12t_write_driver_rc1_9/VDD VSUBS detronyx_12t_write_driver_rc1_9/din
+ detronyx_12t_write_driver_rc1_9/wen detronyx_12t_write_driver_rc1_9/wbl0 detronyx_12t_write_driver_rc1_9/wen
+ detronyx_12t_write_driver_rc1
Xdetronyx_12t_precharge_sense_rc1_6 detronyx_12t_precharge_sense_rc1_6/VDD VSUBS detronyx_12t_write_driver_rc1_9/wen
+ detronyx_12t_precharge_sense_rc1_6/ren detronyx_12t_precharge_sense_rc1_6/ren detronyx_12t_write_driver_rc1_9/wen
+ detronyx_12t_precharge_sense_rc1
Xdetronyx_12t_precharge_sense_rc1_7 detronyx_12t_precharge_sense_rc1_7/VDD VSUBS detronyx_12t_write_driver_rc1_9/wen
+ detronyx_12t_write_driver_rc1_9/wen detronyx_12t_write_driver_rc1_9/wen detronyx_12t_write_driver_rc1_9/wen
+ detronyx_12t_precharge_sense_rc1
Xdetronyx_12t_precharge_sense_rc1_8 detronyx_12t_precharge_sense_rc1_8/VDD VSUBS detronyx_12t_write_driver_rc1_9/wen
+ detronyx_12t_write_driver_rc1_9/wen detronyx_12t_write_driver_rc1_9/wen detronyx_12t_write_driver_rc1_9/wen
+ detronyx_12t_precharge_sense_rc1
Xdetronyx_12t_precharge_sense_rc1_9 detronyx_12t_precharge_sense_rc1_9/VDD VSUBS detronyx_12t_write_driver_rc1_9/wen
+ detronyx_12t_write_driver_rc1_9/wen detronyx_12t_write_driver_rc1_9/wen detronyx_12t_write_driver_rc1_9/wen
+ detronyx_12t_precharge_sense_rc1
Xgf180mcu_3v3_12t_2r2w_sram_512x32_array_control_core_0 gf180mcu_3v3_12t_2r2w_sram_512x32_array_control_core_0/clk
+ detronyx_12t_write_driver_rc1_56/din detronyx_12t_write_driver_rc1_9/wen detronyx_12t_write_driver_rc1_55/din
+ detronyx_12t_write_driver_rc1_9/wen detronyx_12t_write_driver_rc1_54/din detronyx_12t_write_driver_rc1_9/wen
+ detronyx_12t_write_driver_rc1_53/din detronyx_12t_write_driver_rc1_9/wen detronyx_12t_write_driver_rc1_52/din
+ detronyx_12t_write_driver_rc1_9/wen detronyx_12t_write_driver_rc1_51/din detronyx_12t_write_driver_rc1_9/wen
+ detronyx_12t_write_driver_rc1_50/din detronyx_12t_write_driver_rc1_9/wen detronyx_12t_write_driver_rc1_49/din
+ detronyx_12t_write_driver_rc1_9/wen detronyx_12t_write_driver_rc1_48/din detronyx_12t_write_driver_rc1_9/wen
+ detronyx_12t_write_driver_rc1_47/din detronyx_12t_write_driver_rc1_9/wen detronyx_12t_write_driver_rc1_46/din
+ detronyx_12t_write_driver_rc1_9/wen detronyx_12t_write_driver_rc1_45/din detronyx_12t_write_driver_rc1_9/wen
+ detronyx_12t_write_driver_rc1_44/din detronyx_12t_write_driver_rc1_9/wen detronyx_12t_write_driver_rc1_43/din
+ detronyx_12t_write_driver_rc1_9/wen detronyx_12t_write_driver_rc1_42/din detronyx_12t_write_driver_rc1_9/wen
+ detronyx_12t_write_driver_rc1_41/din detronyx_12t_write_driver_rc1_9/wen detronyx_12t_write_driver_rc1_4/din
+ detronyx_12t_write_driver_rc1_9/wen detronyx_12t_write_driver_rc1_3/din detronyx_12t_write_driver_rc1_9/wen
+ detronyx_12t_write_driver_rc1_2/din detronyx_12t_write_driver_rc1_9/wen detronyx_12t_write_driver_rc1_1/din
+ detronyx_12t_write_driver_rc1_9/wen detronyx_12t_write_driver_rc1_12/din detronyx_12t_write_driver_rc1_9/wen
+ detronyx_12t_write_driver_rc1_11/din detronyx_12t_write_driver_rc1_9/wen detronyx_12t_write_driver_rc1_10/din
+ detronyx_12t_write_driver_rc1_9/wen detronyx_12t_write_driver_rc1_9/din detronyx_12t_write_driver_rc1_9/wen
+ detronyx_12t_write_driver_rc1_8/din detronyx_12t_write_driver_rc1_9/wen detronyx_12t_write_driver_rc1_7/din
+ detronyx_12t_write_driver_rc1_9/wen detronyx_12t_write_driver_rc1_6/din detronyx_12t_write_driver_rc1_9/wen
+ detronyx_12t_write_driver_rc1_5/din detronyx_12t_write_driver_rc1_9/wen detronyx_12t_write_driver_rc1_63/din
+ detronyx_12t_write_driver_rc1_9/wen detronyx_12t_write_driver_rc1_60/din detronyx_12t_write_driver_rc1_9/wen
+ detronyx_12t_write_driver_rc1_24/din detronyx_12t_write_driver_rc1_9/wen detronyx_12t_write_driver_rc1_61/din
+ detronyx_12t_write_driver_rc1_9/wen detronyx_12t_write_driver_rc1_9/wen gf180mcu_3v3_12t_2r2w_sram_512x32_array_control_core_0/r0_data[2]
+ detronyx_12t_write_driver_rc1_9/wen gf180mcu_3v3_12t_2r2w_sram_512x32_array_control_core_0/r0_data[4]
+ detronyx_12t_write_driver_rc1_9/wen gf180mcu_3v3_12t_2r2w_sram_512x32_array_control_core_0/r0_data[6]
+ detronyx_12t_write_driver_rc1_9/wen gf180mcu_3v3_12t_2r2w_sram_512x32_array_control_core_0/r0_data[8]
+ detronyx_12t_write_driver_rc1_9/wen gf180mcu_3v3_12t_2r2w_sram_512x32_array_control_core_0/r0_data[10]
+ detronyx_12t_write_driver_rc1_9/wen gf180mcu_3v3_12t_2r2w_sram_512x32_array_control_core_0/r0_data[12]
+ detronyx_12t_write_driver_rc1_9/wen gf180mcu_3v3_12t_2r2w_sram_512x32_array_control_core_0/r0_data[14]
+ detronyx_12t_write_driver_rc1_9/wen gf180mcu_3v3_12t_2r2w_sram_512x32_array_control_core_0/r0_data[16]
+ detronyx_12t_write_driver_rc1_9/wen gf180mcu_3v3_12t_2r2w_sram_512x32_array_control_core_0/r0_data[18]
+ detronyx_12t_write_driver_rc1_9/wen gf180mcu_3v3_12t_2r2w_sram_512x32_array_control_core_0/r0_data[20]
+ detronyx_12t_write_driver_rc1_9/wen gf180mcu_3v3_12t_2r2w_sram_512x32_array_control_core_0/r0_data[22]
+ detronyx_12t_write_driver_rc1_9/wen gf180mcu_3v3_12t_2r2w_sram_512x32_array_control_core_0/r0_data[24]
+ detronyx_12t_write_driver_rc1_9/wen gf180mcu_3v3_12t_2r2w_sram_512x32_array_control_core_0/r0_data[26]
+ detronyx_12t_write_driver_rc1_9/wen gf180mcu_3v3_12t_2r2w_sram_512x32_array_control_core_0/r0_data[28]
+ detronyx_12t_write_driver_rc1_9/wen gf180mcu_3v3_12t_2r2w_sram_512x32_array_control_core_0/r0_data[30]
+ detronyx_12t_write_driver_rc1_9/wen gf180mcu_3v3_12t_2r2w_sram_512x32_array_control_core_0/r0_data[0]
+ gf180mcu_3v3_12t_2r2w_sram_512x32_array_control_core_0/r1_data[2] detronyx_12t_write_driver_rc1_9/wen
+ gf180mcu_3v3_12t_2r2w_sram_512x32_array_control_core_0/r1_data[4] detronyx_12t_write_driver_rc1_9/wen
+ gf180mcu_3v3_12t_2r2w_sram_512x32_array_control_core_0/r1_data[6] detronyx_12t_write_driver_rc1_9/wen
+ gf180mcu_3v3_12t_2r2w_sram_512x32_array_control_core_0/r1_data[8] detronyx_12t_write_driver_rc1_9/wen
+ gf180mcu_3v3_12t_2r2w_sram_512x32_array_control_core_0/r1_data[10] detronyx_12t_write_driver_rc1_9/wen
+ gf180mcu_3v3_12t_2r2w_sram_512x32_array_control_core_0/r1_data[12] detronyx_12t_write_driver_rc1_9/wen
+ gf180mcu_3v3_12t_2r2w_sram_512x32_array_control_core_0/r1_data[14] detronyx_12t_write_driver_rc1_9/wen
+ gf180mcu_3v3_12t_2r2w_sram_512x32_array_control_core_0/r1_data[16] detronyx_12t_write_driver_rc1_9/wen
+ gf180mcu_3v3_12t_2r2w_sram_512x32_array_control_core_0/r1_data[18] detronyx_12t_write_driver_rc1_9/wen
+ gf180mcu_3v3_12t_2r2w_sram_512x32_array_control_core_0/r1_data[20] detronyx_12t_write_driver_rc1_9/wen
+ gf180mcu_3v3_12t_2r2w_sram_512x32_array_control_core_0/r1_data[22] detronyx_12t_write_driver_rc1_9/wen
+ gf180mcu_3v3_12t_2r2w_sram_512x32_array_control_core_0/r1_data[24] detronyx_12t_write_driver_rc1_9/wen
+ gf180mcu_3v3_12t_2r2w_sram_512x32_array_control_core_0/r1_data[26] detronyx_12t_write_driver_rc1_9/wen
+ gf180mcu_3v3_12t_2r2w_sram_512x32_array_control_core_0/r1_data[28] detronyx_12t_write_driver_rc1_9/wen
+ gf180mcu_3v3_12t_2r2w_sram_512x32_array_control_core_0/r1_data[30] detronyx_12t_precharge_sense_rc1_28/dout
+ gf180mcu_3v3_12t_2r2w_sram_512x32_array_control_core_0/r1_data[0] detronyx_12t_write_driver_rc1_9/wen
+ detronyx_12t_write_driver_rc1_9/wen detronyx_12t_write_driver_rc1_9/wen detronyx_12t_write_driver_rc1_9/wen
+ detronyx_12t_write_driver_rc1_9/wen detronyx_12t_write_driver_rc1_9/wen detronyx_12t_write_driver_rc1_9/wen
+ detronyx_12t_write_driver_rc1_9/wen gf180mcu_3v3_12t_2r2w_sram_512x32_array_control_core_0/u_t017_003/c1_w1_bl
+ gf180mcu_3v3_12t_2r2w_sram_512x32_array_control_core_0/u_t010_017/c1_w1_bl detronyx_12t_write_driver_rc1_9/wen
+ detronyx_12t_write_driver_rc1_9/wen gf180mcu_3v3_12t_2r2w_sram_512x32_array_control_core_0/u_t030_030/r3_w0_wl
+ detronyx_12t_write_driver_rc1_9/wen gf180mcu_3v3_12t_2r2w_sram_512x32_array_control_core_0/u_t030_030/c3_w0_bl
+ detronyx_12t_write_driver_rc1_9/wen detronyx_12t_write_driver_rc1_9/wen gf180mcu_3v3_12t_2r2w_sram_512x32_array_control_core_0/u_t002_023/c3_w1_bl
+ detronyx_12t_write_driver_rc1_9/wen detronyx_12t_write_driver_rc1_9/wen detronyx_12t_write_driver_rc1_9/wen
+ detronyx_12t_write_driver_rc1_9/wen detronyx_12t_write_driver_rc1_9/wen gf180mcu_3v3_12t_2r2w_sram_512x32_array_control_core_0/u_t009_017/c1_w1_bl
+ detronyx_12t_write_driver_rc1_9/wen detronyx_12t_write_driver_rc1_9/wen detronyx_12t_write_driver_rc1_9/wen
+ gf180mcu_3v3_12t_2r2w_sram_512x32_array_control_core_0/u_t028_030/r1_w0_wl gf180mcu_3v3_12t_2r2w_sram_512x32_array_control_core_0/u_t004_003/VDD
+ detronyx_12t_write_driver_rc1_9/wen gf180mcu_3v3_12t_2r2w_sram_512x32_array_control_core_0/u_t030_000/r3_w1_wl
+ detronyx_12t_write_driver_rc1_9/wen detronyx_12t_write_driver_rc1_9/wen detronyx_12t_write_driver_rc1_9/wen
+ gf180mcu_3v3_12t_2r2w_sram_512x32_array_control_core_0/u_t004_003/VDD detronyx_12t_write_driver_rc1_9/wen
+ gf180mcu_3v3_12t_2r2w_sram_512x32_array_control_core_0/u_t018_031/r3_w0_wl detronyx_12t_write_driver_rc1_9/wen
+ gf180mcu_3v3_12t_2r2w_sram_512x32_array_control_core_0/u_t014_022/c3_w1_bl gf180mcu_3v3_12t_2r2w_sram_512x32_array_control_core_0/u_t005_030/r3_w0_wl
+ detronyx_12t_write_driver_rc1_9/wen detronyx_12t_write_driver_rc1_9/wen detronyx_12t_write_driver_rc1_9/wen
+ detronyx_12t_write_driver_rc1_9/wen gf180mcu_3v3_12t_2r2w_sram_512x32_array_control_core_0/u_t006_031/r2_w0_wl
+ detronyx_12t_write_driver_rc1_9/wen detronyx_12t_write_driver_rc1_9/wen detronyx_12t_write_driver_rc1_9/wen
+ detronyx_12t_write_driver_rc1_9/wen gf180mcu_3v3_12t_2r2w_sram_512x32_array_control_core_0/u_t021_010/c3_w1_bl
+ gf180mcu_3v3_12t_2r2w_sram_512x32_array_control_core_0/u_t027_015/c1_w1_bl detronyx_12t_write_driver_rc1_9/wen
+ detronyx_12t_write_driver_rc1_9/wen detronyx_12t_write_driver_rc1_9/wen gf180mcu_3v3_12t_2r2w_sram_512x32_array_control_core_0/u_t017_016/c3_w1_bl
+ detronyx_12t_write_driver_rc1_9/wen gf180mcu_3v3_12t_2r2w_sram_512x32_array_control_core_0/u_t022_023/c1_w0_bl
+ gf180mcu_3v3_12t_2r2w_sram_512x32_array_control_core_0/u_t018_010/c3_w1_bl gf180mcu_3v3_12t_2r2w_sram_512x32_array_control_core_0/u_t004_000/r0_w1_wl
+ gf180mcu_3v3_12t_2r2w_sram_512x32_array_control_core_0/u_t013_024/c3_w0_bl detronyx_12t_write_driver_rc1_9/wen
+ detronyx_12t_write_driver_rc1_9/wen detronyx_12t_write_driver_rc1_9/wen detronyx_12t_write_driver_rc1_9/wen
+ gf180mcu_3v3_12t_2r2w_sram_512x32_array_control_core_0/u_t026_002/r3_w1_wl gf180mcu_3v3_12t_2r2w_sram_512x32_array_control_core_0/u_t002_008/c3_w1_bl
+ detronyx_12t_write_driver_rc1_9/wen detronyx_12t_write_driver_rc1_9/wen detronyx_12t_write_driver_rc1_9/wen
+ gf180mcu_3v3_12t_2r2w_sram_512x32_array_control_core_0/u_t013_001/c1_w1_bl detronyx_12t_write_driver_rc1_9/wen
+ gf180mcu_3v3_12t_2r2w_sram_512x32_array_control_core_0/u_t026_017/c1_w1_bl gf180mcu_3v3_12t_2r2w_sram_512x32_array_control_core_0/u_t014_002/r2_w1_wl
+ detronyx_12t_write_driver_rc1_9/wen gf180mcu_3v3_12t_2r2w_sram_512x32_array_control_core_0/u_t015_018/c3_w1_bl
+ detronyx_12t_write_driver_rc1_9/wen gf180mcu_3v3_12t_2r2w_sram_512x32_array_control_core_0/u_t026_011/c1_w1_bl
+ gf180mcu_3v3_12t_2r2w_sram_512x32_array_control_core_0/u_t004_003/r3_w1_wl gf180mcu_3v3_12t_2r2w_sram_512x32_array_control_core_0/a_17000_120600#
+ gf180mcu_3v3_12t_2r2w_sram_512x32_array_control_core_0/u_t021_025/c1_w0_bl detronyx_12t_write_driver_rc1_9/wen
+ detronyx_12t_write_driver_rc1_9/wen gf180mcu_3v3_12t_2r2w_sram_512x32_array_control_core_0/u_t005_015/c1_w1_bl
+ detronyx_12t_write_driver_rc1_9/wen detronyx_12t_write_driver_rc1_9/wen gf180mcu_3v3_12t_2r2w_sram_512x32_array_control_core_0/a_200_39400#
+ gf180mcu_3v3_12t_2r2w_sram_512x32_array_control_core_0/u_t004_018/VDD gf180mcu_3v3_12t_2r2w_sram_512x32_array_control_core_0/u_t010_009/c1_w1_bl
+ detronyx_12t_write_driver_rc1_9/wen gf180mcu_3v3_12t_2r2w_sram_512x32_array_control_core_0/a_22600_95400#
+ detronyx_12t_write_driver_rc1_9/wen detronyx_12t_write_driver_rc1_9/wen gf180mcu_3v3_12t_2r2w_sram_512x32_array_control_core_0/u_t018_025/c1_w0_bl
+ detronyx_12t_write_driver_rc1_9/wen gf180mcu_3v3_12t_2r2w_sram_512x32_array_control_core_0/u_t030_022/c3_w1_bl
+ gf180mcu_3v3_12t_2r2w_sram_512x32_array_control_core_0/u_t013_003/c1_w1_bl detronyx_12t_write_driver_rc1_9/wen
+ detronyx_12t_write_driver_rc1_9/wen detronyx_12t_write_driver_rc1_9/wen detronyx_12t_write_driver_rc1_9/wen
+ detronyx_12t_write_driver_rc1_9/wen detronyx_12t_write_driver_rc1_9/wen gf180mcu_3v3_12t_2r2w_sram_512x32_array_control_core_0/u_t026_030/c3_w0_bl
+ gf180mcu_3v3_12t_2r2w_sram_512x32_array_control_core_0/u_t009_009/c1_w1_bl detronyx_12t_write_driver_rc1_9/wen
+ detronyx_12t_write_driver_rc1_9/wen detronyx_12t_write_driver_rc1_9/wen detronyx_12t_write_driver_rc1_9/wen
+ detronyx_12t_write_driver_rc1_9/wen detronyx_12t_write_driver_rc1_9/wen gf180mcu_3v3_12t_2r2w_sram_512x32_array_control_core_0/u_t009_003/c1_w1_bl
+ gf180mcu_3v3_12t_2r2w_sram_512x32_array_control_core_0/u_t026_031/r3_w0_wl detronyx_12t_write_driver_rc1_9/wen
+ gf180mcu_3v3_12t_2r2w_sram_512x32_array_control_core_0/u_t005_017/c1_w1_bl detronyx_12t_write_driver_rc1_9/wen
+ detronyx_12t_write_driver_rc1_9/wen detronyx_12t_write_driver_rc1_9/wen gf180mcu_3v3_12t_2r2w_sram_512x32_array_control_core_0/u_t013_031/r3_w0_wl
+ detronyx_12t_write_driver_rc1_9/wen detronyx_12t_write_driver_rc1_9/wen detronyx_12t_write_driver_rc1_9/wen
+ detronyx_12t_write_driver_rc1_9/wen detronyx_12t_write_driver_rc1_9/wen detronyx_12t_write_driver_rc1_9/wen
+ detronyx_12t_write_driver_rc1_9/wen detronyx_12t_write_driver_rc1_9/wen gf180mcu_3v3_12t_2r2w_sram_512x32_array_control_core_0/u_t023_000/r2_w1_wl
+ detronyx_12t_write_driver_rc1_9/wen detronyx_12t_write_driver_rc1_9/wen detronyx_12t_write_driver_rc1_9/wen
+ gf180mcu_3v3_12t_2r2w_sram_512x32_array_control_core_0/u_t009_022/c3_w1_bl detronyx_12t_write_driver_rc1_9/wen
+ detronyx_12t_write_driver_rc1_9/wen gf180mcu_3v3_12t_2r2w_sram_512x32_array_control_core_0/u_t022_015/c1_w1_bl
+ detronyx_12t_write_driver_rc1_9/wen gf180mcu_3v3_12t_2r2w_sram_512x32_array_control_core_0/u_t011_000/r1_w1_wl
+ detronyx_12t_write_driver_rc1_9/wen detronyx_12t_write_driver_rc1_9/wen detronyx_12t_write_driver_rc1_9/wen
+ gf180mcu_3v3_12t_2r2w_sram_512x32_array_control_core_0/u_t013_016/c3_w1_bl gf180mcu_3v3_12t_2r2w_sram_512x32_array_control_core_0/u_t029_007/c3_w1_bl
+ detronyx_12t_write_driver_rc1_9/wen gf180mcu_3v3_12t_2r2w_sram_512x32_array_control_core_0/u_t013_010/c3_w1_bl
+ detronyx_12t_write_driver_rc1_9/wen detronyx_12t_write_driver_rc1_9/wen detronyx_12t_write_driver_rc1_9/wen
+ detronyx_12t_write_driver_rc1_9/wen detronyx_12t_write_driver_rc1_9/wen detronyx_12t_write_driver_rc1_9/wen
+ gf180mcu_3v3_12t_2r2w_sram_512x32_array_control_core_0/u_t015_023/c1_w0_bl gf180mcu_3v3_12t_2r2w_sram_512x32_array_control_core_0/u_t021_002/r3_w1_wl
+ detronyx_12t_write_driver_rc1_9/wen detronyx_12t_write_driver_rc1_9/wen detronyx_12t_write_driver_rc1_9/wen
+ gf180mcu_3v3_12t_2r2w_sram_512x32_array_control_core_0/a_22600_3000# detronyx_12t_write_driver_rc1_9/wen
+ gf180mcu_3v3_12t_2r2w_sram_512x32_array_control_core_0/u_t005_024/c3_w0_bl gf180mcu_3v3_12t_2r2w_sram_512x32_array_control_core_0/a_14200_45000#
+ gf180mcu_3v3_12t_2r2w_sram_512x32_array_control_core_0/u_t021_017/c1_w1_bl gf180mcu_3v3_12t_2r2w_sram_512x32_array_control_core_0/u_t029_001/r0_w1_wl
+ detronyx_12t_write_driver_rc1_9/wen detronyx_12t_write_driver_rc1_9/wen gf180mcu_3v3_12t_2r2w_sram_512x32_array_control_core_0/u_t010_018/c3_w1_bl
+ gf180mcu_3v3_12t_2r2w_sram_512x32_array_control_core_0/u_t021_011/c1_w1_bl gf180mcu_3v3_12t_2r2w_sram_512x32_array_control_core_0/u_t006_001/c1_w1_bl
+ gf180mcu_3v3_12t_2r2w_sram_512x32_array_control_core_0/u_t027_009/c3_w1_bl detronyx_12t_write_driver_rc1_9/wen
+ detronyx_12t_write_driver_rc1_9/wen detronyx_12t_write_driver_rc1_9/wen detronyx_12t_write_driver_rc1_9/wen
+ gf180mcu_3v3_12t_2r2w_sram_512x32_array_control_core_0/u_t018_017/c1_w1_bl detronyx_12t_write_driver_rc1_9/wen
+ gf180mcu_3v3_12t_2r2w_sram_512x32_array_control_core_0/u_t007_002/r1_w1_wl detronyx_12t_write_driver_rc1_9/wen
+ gf180mcu_3v3_12t_2r2w_sram_512x32_array_control_core_0/u_t009_018/c3_w1_bl gf180mcu_3v3_12t_2r2w_sram_512x32_array_control_core_0/u_t019_011/c1_w1_bl
+ gf180mcu_3v3_12t_2r2w_sram_512x32_array_control_core_0/u_t026_022/c3_w1_bl gf180mcu_3v3_12t_2r2w_sram_512x32_array_control_core_0/u_t013_025/c1_w0_bl
+ detronyx_12t_write_driver_rc1_9/wen detronyx_12t_write_driver_rc1_9/wen detronyx_12t_write_driver_rc1_9/wen
+ detronyx_12t_write_driver_rc1_9/wen detronyx_12t_write_driver_rc1_9/wen detronyx_12t_write_driver_rc1_9/wen
+ gf180mcu_3v3_12t_2r2w_sram_512x32_array_control_core_0/u_t004_009/c1_w1_bl detronyx_12t_write_driver_rc1_9/wen
+ detronyx_12t_write_driver_rc1_9/wen detronyx_12t_write_driver_rc1_9/wen detronyx_12t_write_driver_rc1_9/wen
+ detronyx_12t_write_driver_rc1_9/wen gf180mcu_3v3_12t_2r2w_sram_512x32_array_control_core_0/u_t004_003/c1_w1_bl
+ detronyx_12t_write_driver_rc1_9/wen detronyx_12t_write_driver_rc1_9/wen detronyx_12t_write_driver_rc1_9/wen
+ gf180mcu_3v3_12t_2r2w_sram_512x32_array_control_core_0/u_t017_030/c3_w0_bl gf180mcu_3v3_12t_2r2w_sram_512x32_array_control_core_0/u_t030_018/c1_w1_bl
+ detronyx_12t_write_driver_rc1_9/wen gf180mcu_3v3_12t_2r2w_sram_512x32_array_control_core_0/u_t028_030/r1_w0_wl
+ gf180mcu_3v3_12t_2r2w_sram_512x32_array_control_core_0/u_t004_003/VDD gf180mcu_3v3_12t_2r2w_sram_512x32_array_control_core_0/u_t030_000/r3_w1_wl
+ detronyx_12t_write_driver_rc1_9/wen detronyx_12t_write_driver_rc1_9/wen detronyx_12t_write_driver_rc1_9/wen
+ detronyx_12t_write_driver_rc1_9/wen gf180mcu_3v3_12t_2r2w_sram_512x32_array_control_core_0/a_200_92600#
+ gf180mcu_3v3_12t_2r2w_sram_512x32_array_control_core_0/a_22600_120600# gf180mcu_3v3_12t_2r2w_sram_512x32_array_control_core_0/u_t018_031/r3_w0_wl
+ detronyx_12t_write_driver_rc1_9/wen gf180mcu_3v3_12t_2r2w_sram_512x32_array_control_core_0/a_200_19800#
+ detronyx_12t_write_driver_rc1_9/wen detronyx_12t_write_driver_rc1_9/wen gf180mcu_3v3_12t_2r2w_sram_512x32_array_control_core_0/u_t016_030/r1_w0_wl
+ detronyx_12t_write_driver_rc1_9/wen gf180mcu_3v3_12t_2r2w_sram_512x32_array_control_core_0/u_t030_018/c1_w1_bl
+ detronyx_12t_write_driver_rc1_9/wen detronyx_12t_write_driver_rc1_9/wen gf180mcu_3v3_12t_2r2w_sram_512x32_array_control_core_0/a_22600_75800#
+ detronyx_12t_write_driver_rc1_9/wen gf180mcu_3v3_12t_2r2w_sram_512x32_array_control_core_0/u_t006_031/r2_w0_wl
+ detronyx_12t_write_driver_rc1_9/wen detronyx_12t_write_driver_rc1_9/wen gf180mcu_3v3_12t_2r2w_sram_512x32_array_control_core_0/u_t002_022/c3_w1_bl
+ detronyx_12t_write_driver_rc1_9/wen detronyx_12t_write_driver_rc1_9/wen detronyx_12t_write_driver_rc1_9/wen
+ gf180mcu_3v3_12t_2r2w_sram_512x32_array_control_core_0/u_t026_031/r3_w0_wl detronyx_12t_write_driver_rc1_9/wen
+ detronyx_12t_write_driver_rc1_9/wen gf180mcu_3v3_12t_2r2w_sram_512x32_array_control_core_0/u_t025_007/c3_w1_bl
+ gf180mcu_3v3_12t_2r2w_sram_512x32_array_control_core_0/u_t015_015/c1_w1_bl detronyx_12t_write_driver_rc1_9/wen
+ gf180mcu_3v3_12t_2r2w_sram_512x32_array_control_core_0/u_t005_016/c3_w1_bl gf180mcu_3v3_12t_2r2w_sram_512x32_array_control_core_0/u_t010_023/c1_w0_bl
+ detronyx_12t_write_driver_rc1_9/wen gf180mcu_3v3_12t_2r2w_sram_512x32_array_control_core_0/u_t006_010/c3_w1_bl
+ gf180mcu_3v3_12t_2r2w_sram_512x32_array_control_core_0/u_t026_002/r3_w1_wl detronyx_12t_precharge_sense_rc1_35/ren
+ detronyx_12t_write_driver_rc1_9/wen detronyx_12t_write_driver_rc1_9/wen gf180mcu_3v3_12t_2r2w_sram_512x32_array_control_core_0/u_t024_001/r1_w1_wl
+ detronyx_12t_write_driver_rc1_9/wen detronyx_12t_write_driver_rc1_9/wen gf180mcu_3v3_12t_2r2w_sram_512x32_array_control_core_0/u_t014_002/r2_w1_wl
+ gf180mcu_3v3_12t_2r2w_sram_512x32_array_control_core_0/u_t009_023/c1_w0_bl detronyx_12t_write_driver_rc1_9/wen
+ detronyx_12t_write_driver_rc1_9/wen gf180mcu_3v3_12t_2r2w_sram_512x32_array_control_core_0/u_t001_001/c1_w1_bl
+ gf180mcu_3v3_12t_2r2w_sram_512x32_array_control_core_0/u_t022_009/c3_w1_bl detronyx_12t_write_driver_rc1_9/wen
+ gf180mcu_3v3_12t_2r2w_sram_512x32_array_control_core_0/u_t013_017/c1_w1_bl gf180mcu_3v3_12t_2r2w_sram_512x32_array_control_core_0/u_t002_002/r2_w1_wl
+ gf180mcu_3v3_12t_2r2w_sram_512x32_array_control_core_0/a_14200_109400# gf180mcu_3v3_12t_2r2w_sram_512x32_array_control_core_0/u_t004_018/c3_w1_bl
+ gf180mcu_3v3_12t_2r2w_sram_512x32_array_control_core_0/u_t014_011/c1_w1_bl detronyx_12t_write_driver_rc1_9/wen
+ detronyx_12t_write_driver_rc1_9/wen gf180mcu_3v3_12t_2r2w_sram_512x32_array_control_core_0/u_t026_016/c1_w1_bl
+ detronyx_12t_write_driver_rc1_9/wen detronyx_12t_write_driver_rc1_9/wen detronyx_12t_write_driver_rc1_9/wen
+ detronyx_12t_write_driver_rc1_9/wen gf180mcu_3v3_12t_2r2w_sram_512x32_array_control_core_0/u_t006_025/c1_w0_bl
+ detronyx_12t_write_driver_rc1_9/wen detronyx_12t_write_driver_rc1_9/wen gf180mcu_3v3_12t_2r2w_sram_512x32_array_control_core_0/u_t017_022/c3_w1_bl
+ detronyx_12t_write_driver_rc1_9/wen gf180mcu_3v3_12t_2r2w_sram_512x32_array_control_core_0/a_14200_25400#
+ detronyx_12t_write_driver_rc1_9/wen detronyx_12t_write_driver_rc1_9/wen detronyx_12t_write_driver_rc1_9/wen
+ detronyx_12t_write_driver_rc1_9/wen detronyx_12t_write_driver_rc1_9/wen detronyx_12t_write_driver_rc1_9/wen
+ gf180mcu_3v3_12t_2r2w_sram_512x32_array_control_core_0/u_t013_030/c3_w0_bl detronyx_12t_write_driver_rc1_9/wen
+ detronyx_12t_write_driver_rc1_9/wen detronyx_12t_write_driver_rc1_9/wen gf180mcu_3v3_12t_2r2w_sram_512x32_array_control_core_0/u_t023_030/r2_w0_wl
+ detronyx_12t_write_driver_rc1_9/wen detronyx_12t_write_driver_rc1_9/wen detronyx_12t_write_driver_rc1_9/wen
+ detronyx_12t_write_driver_rc1_9/wen detronyx_12t_write_driver_rc1_9/wen gf180mcu_3v3_12t_2r2w_sram_512x32_array_control_core_0/u_t013_031/r3_w0_wl
+ detronyx_12t_write_driver_rc1_9/wen detronyx_12t_write_driver_rc1_9/wen detronyx_12t_write_driver_rc1_9/wen
+ detronyx_12t_write_driver_rc1_9/wen gf180mcu_3v3_12t_2r2w_sram_512x32_array_control_core_0/u_t011_030/r1_w0_wl
+ gf180mcu_3v3_12t_2r2w_sram_512x32_array_control_core_0/u_t023_018/c1_w1_bl detronyx_12t_write_driver_rc1_9/wen
+ detronyx_12t_write_driver_rc1_9/wen detronyx_12t_write_driver_rc1_9/wen gf180mcu_3v3_12t_2r2w_sram_512x32_array_control_core_0/u_t001_031/r3_w0_wl
+ detronyx_12t_write_driver_rc1_9/wen detronyx_12t_write_driver_rc1_9/wen detronyx_12t_write_driver_rc1_9/wen
+ detronyx_12t_write_driver_rc1_9/wen gf180mcu_3v3_12t_2r2w_sram_512x32_array_control_core_0/u_t021_031/r3_w0_wl
+ gf180mcu_3v3_12t_2r2w_sram_512x32_array_control_core_0/u_t009_030/r3_w0_wl detronyx_12t_write_driver_rc1_9/wen
+ detronyx_12t_write_driver_rc1_9/wen detronyx_12t_write_driver_rc1_9/wen detronyx_12t_write_driver_rc1_9/wen
+ detronyx_12t_write_driver_rc1_9/wen detronyx_12t_write_driver_rc1_9/wen gf180mcu_3v3_12t_2r2w_sram_512x32_array_control_core_0/u_t026_029/c3_w0_bl
+ detronyx_12t_write_driver_rc1_9/wen gf180mcu_3v3_12t_2r2w_sram_512x32_array_control_core_0/u_t010_015/c1_w1_bl
+ gf180mcu_3v3_12t_2r2w_sram_512x32_array_control_core_0/u_t027_023/c3_w1_bl gf180mcu_3v3_12t_2r2w_sram_512x32_array_control_core_0/u_t018_031/r3_w0_wl
+ detronyx_12t_precharge_sense_rc1_6/ren gf180mcu_3v3_12t_2r2w_sram_512x32_array_control_core_0/u_t009_000/r3_w1_wl
+ detronyx_12t_write_driver_rc1_9/wen detronyx_12t_write_driver_rc1_9/wen detronyx_12t_write_driver_rc1_9/wen
+ detronyx_12t_write_driver_rc1_9/wen detronyx_12t_write_driver_rc1_9/wen detronyx_12t_write_driver_rc1_9/wen
+ detronyx_12t_write_driver_rc1_9/wen gf180mcu_3v3_12t_2r2w_sram_512x32_array_control_core_0/u_t017_007/c3_w1_bl
+ gf180mcu_3v3_12t_2r2w_sram_512x32_array_control_core_0/u_t001_010/c3_w1_bl gf180mcu_3v3_12t_2r2w_sram_512x32_array_control_core_0/u_t021_002/r3_w1_wl
+ gf180mcu_3v3_12t_2r2w_sram_512x32_array_control_core_0/u_t009_015/c1_w1_bl detronyx_12t_write_driver_rc1_9/wen
+ detronyx_12t_write_driver_rc1_9/wen detronyx_12t_write_driver_rc1_9/wen detronyx_12t_write_driver_rc1_9/wen
+ detronyx_12t_write_driver_rc1_9/wen detronyx_12t_write_driver_rc1_9/wen gf180mcu_3v3_12t_2r2w_sram_512x32_array_control_core_0/u_t005_023/c1_w0_bl
+ detronyx_12t_write_driver_rc1_9/wen gf180mcu_3v3_12t_2r2w_sram_512x32_array_control_core_0/u_t017_001/r0_w1_wl
+ detronyx_12t_write_driver_rc1_9/wen gf180mcu_3v3_12t_2r2w_sram_512x32_array_control_core_0/u_t026_025/c3_w0_bl
+ gf180mcu_3v3_12t_2r2w_sram_512x32_array_control_core_0/u_t025_008/c1_w1_bl detronyx_12t_write_driver_rc1_9/wen
+ detronyx_12t_write_driver_rc1_9/wen gf180mcu_3v3_12t_2r2w_sram_512x32_array_control_core_0/u_t015_009/c3_w1_bl
+ detronyx_12t_write_driver_rc1_9/wen gf180mcu_3v3_12t_2r2w_sram_512x32_array_control_core_0/u_t006_017/c1_w1_bl
+ gf180mcu_3v3_12t_2r2w_sram_512x32_array_control_core_0/u_t026_002/c1_w1_bl gf180mcu_3v3_12t_2r2w_sram_512x32_array_control_core_0/u_t021_016/c1_w1_bl
+ detronyx_12t_write_driver_rc1_9/wen gf180mcu_3v3_12t_2r2w_sram_512x32_array_control_core_0/u_t027_003/r2_w1_wl
+ gf180mcu_3v3_12t_2r2w_sram_512x32_array_control_core_0/u_t009_011/c1_w1_bl detronyx_12t_write_driver_rc1_9/wen
+ gf180mcu_3v3_12t_2r2w_sram_512x32_array_control_core_0/u_t001_025/c1_w0_bl gf180mcu_3v3_12t_2r2w_sram_512x32_array_control_core_0/u_t013_022/c3_w1_bl
+ detronyx_12t_write_driver_rc1_9/wen gf180mcu_3v3_12t_2r2w_sram_512x32_array_control_core_0/u_t030_030/r3_w0_wl
+ detronyx_12t_write_driver_rc1_9/wen gf180mcu_3v3_12t_2r2w_sram_512x32_array_control_core_0/u_t018_016/c1_w1_bl
+ detronyx_12t_write_driver_rc1_9/wen gf180mcu_3v3_12t_2r2w_sram_512x32_array_control_core_0/u_t015_003/r1_w1_wl
+ detronyx_12t_write_driver_rc1_9/wen detronyx_12t_write_driver_rc1_9/wen detronyx_12t_write_driver_rc1_9/wen
+ detronyx_12t_write_driver_rc1_9/wen detronyx_12t_write_driver_rc1_9/wen detronyx_12t_write_driver_rc1_9/wen
+ detronyx_12t_write_driver_rc1_9/wen detronyx_12t_write_driver_rc1_9/wen detronyx_12t_write_driver_rc1_9/wen
+ gf180mcu_3v3_12t_2r2w_sram_512x32_array_control_core_0/u_t005_030/c3_w0_bl gf180mcu_3v3_12t_2r2w_sram_512x32_array_control_core_0/u_t016_030/r1_w0_wl
+ detronyx_12t_write_driver_rc1_9/wen detronyx_12t_write_driver_rc1_9/wen detronyx_12t_write_driver_rc1_9/wen
+ detronyx_12t_write_driver_rc1_9/wen detronyx_12t_write_driver_rc1_9/wen detronyx_12t_write_driver_rc1_9/wen
+ gf180mcu_3v3_12t_2r2w_sram_512x32_array_control_core_0/u_t004_030/r3_w0_wl gf180mcu_3v3_12t_2r2w_sram_512x32_array_control_core_0/u_t027_015/c3_w1_bl
+ gf180mcu_3v3_12t_2r2w_sram_512x32_array_control_core_0/u_t017_018/c1_w1_bl detronyx_12t_write_driver_rc1_9/wen
+ detronyx_12t_write_driver_rc1_9/wen gf180mcu_3v3_12t_2r2w_sram_512x32_array_control_core_0/u_t021_029/c3_w0_bl
+ detronyx_12t_write_driver_rc1_9/wen detronyx_12t_write_driver_rc1_9/wen gf180mcu_3v3_12t_2r2w_sram_512x32_array_control_core_0/a_200_28200#
+ gf180mcu_3v3_12t_2r2w_sram_512x32_array_control_core_0/u_t017_000/r0_w1_wl detronyx_12t_write_driver_rc1_9/wen
+ detronyx_12t_write_driver_rc1_9/wen detronyx_12t_write_driver_rc1_9/wen detronyx_12t_write_driver_rc1_9/wen
+ detronyx_12t_write_driver_rc1_9/wen gf180mcu_3v3_12t_2r2w_sram_512x32_array_control_core_0/a_22600_84200#
+ gf180mcu_3v3_12t_2r2w_sram_512x32_array_control_core_0/u_t022_023/c3_w1_bl detronyx_12t_write_driver_rc1_9/wen
+ gf180mcu_3v3_12t_2r2w_sram_512x32_array_control_core_0/u_t013_031/r3_w0_wl detronyx_12t_write_driver_rc1_9/wen
+ detronyx_12t_write_driver_rc1_9/wen detronyx_12t_write_driver_rc1_9/wen gf180mcu_3v3_12t_2r2w_sram_512x32_array_control_core_0/u_t019_029/c3_w0_bl
+ detronyx_12t_write_driver_rc1_9/wen gf180mcu_3v3_12t_2r2w_sram_512x32_array_control_core_0/u_t012_007/c3_w1_bl
+ gf180mcu_3v3_12t_2r2w_sram_512x32_array_control_core_0/u_t004_015/c1_w1_bl detronyx_12t_write_driver_rc1_9/wen
+ detronyx_12t_write_driver_rc1_9/wen gf180mcu_3v3_12t_2r2w_sram_512x32_array_control_core_0/u_t024_001/r1_w1_wl
+ detronyx_12t_write_driver_rc1_9/wen detronyx_12t_write_driver_rc1_9/wen gf180mcu_3v3_12t_2r2w_sram_512x32_array_control_core_0/u_t025_017/c3_w1_bl
+ detronyx_12t_write_driver_rc1_9/wen gf180mcu_3v3_12t_2r2w_sram_512x32_array_control_core_0/u_t030_024/c1_w0_bl
+ detronyx_12t_write_driver_rc1_9/wen detronyx_12t_write_driver_rc1_9/wen detronyx_12t_write_driver_rc1_9/wen
+ detronyx_12t_write_driver_rc1_9/wen gf180mcu_3v3_12t_2r2w_sram_512x32_array_control_core_0/u_t012_001/r0_w1_wl
+ gf180mcu_3v3_12t_2r2w_sram_512x32_array_control_core_0/u_t021_025/c3_w0_bl gf180mcu_3v3_12t_2r2w_sram_512x32_array_control_core_0/u_t002_002/r2_w1_wl
+ gf180mcu_3v3_12t_2r2w_sram_512x32_array_control_core_0/u_t021_008/c1_w1_bl detronyx_12t_write_driver_rc1_9/wen
+ gf180mcu_3v3_12t_2r2w_sram_512x32_array_control_core_0/u_t030_024/c1_w0_bl gf180mcu_3v3_12t_2r2w_sram_512x32_array_control_core_0/u_t010_009/c3_w1_bl
+ detronyx_12t_write_driver_rc1_9/wen gf180mcu_3v3_12t_2r2w_sram_512x32_array_control_core_0/u_t001_017/c1_w1_bl
+ gf180mcu_3v3_12t_2r2w_sram_512x32_array_control_core_0/u_t021_002/c1_w1_bl gf180mcu_3v3_12t_2r2w_sram_512x32_array_control_core_0/u_t018_025/c3_w0_bl
+ detronyx_12t_write_driver_rc1_9/wen gf180mcu_3v3_12t_2r2w_sram_512x32_array_control_core_0/u_t018_008/c1_w1_bl
+ gf180mcu_3v3_12t_2r2w_sram_512x32_array_control_core_0/u_t002_011/c1_w1_bl detronyx_12t_write_driver_rc1_9/wen
+ detronyx_12t_write_driver_rc1_9/wen detronyx_12t_write_driver_rc1_9/wen detronyx_12t_write_driver_rc1_9/wen
+ gf180mcu_3v3_12t_2r2w_sram_512x32_array_control_core_0/u_t009_009/c3_w1_bl detronyx_12t_write_driver_rc1_9/wen
+ gf180mcu_3v3_12t_2r2w_sram_512x32_array_control_core_0/u_t019_002/c1_w1_bl gf180mcu_3v3_12t_2r2w_sram_512x32_array_control_core_0/u_t013_016/c1_w1_bl
+ detronyx_12t_write_driver_rc1_9/wen detronyx_12t_write_driver_rc1_9/wen detronyx_12t_write_driver_rc1_9/wen
+ detronyx_12t_write_driver_rc1_9/wen detronyx_12t_write_driver_rc1_9/wen detronyx_12t_write_driver_rc1_9/wen
+ gf180mcu_3v3_12t_2r2w_sram_512x32_array_control_core_0/u_t005_022/c3_w1_bl gf180mcu_3v3_12t_2r2w_sram_512x32_array_control_core_0/u_t023_030/r2_w0_wl
+ gf180mcu_3v3_12t_2r2w_sram_512x32_array_control_core_0/u_t026_026/c1_w0_bl detronyx_12t_write_driver_rc1_9/wen
+ gf180mcu_3v3_12t_2r2w_sram_512x32_array_control_core_0/u_t008_003/r0_w1_wl detronyx_12t_precharge_sense_rc1_29/ren
+ detronyx_12t_write_driver_rc1_9/wen detronyx_12t_write_driver_rc1_9/wen detronyx_12t_write_driver_rc1_9/wen
+ detronyx_12t_write_driver_rc1_9/wen gf180mcu_3v3_12t_2r2w_sram_512x32_array_control_core_0/u_t011_030/r1_w0_wl
+ detronyx_12t_write_driver_rc1_9/wen detronyx_12t_write_driver_rc1_9/wen detronyx_12t_write_driver_rc1_9/wen
+ detronyx_12t_write_driver_rc1_9/wen detronyx_12t_write_driver_rc1_9/wen gf180mcu_3v3_12t_2r2w_sram_512x32_array_control_core_0/u_t001_031/r3_w0_wl
+ detronyx_12t_write_driver_rc1_9/wen detronyx_12t_write_driver_rc1_9/wen detronyx_12t_write_driver_rc1_9/wen
+ gf180mcu_3v3_12t_2r2w_sram_512x32_array_control_core_0/u_t022_015/c3_w1_bl gf180mcu_3v3_12t_2r2w_sram_512x32_array_control_core_0/u_t013_018/c1_w1_bl
+ detronyx_12t_write_driver_rc1_9/wen detronyx_12t_write_driver_rc1_9/wen detronyx_12t_write_driver_rc1_9/wen
+ detronyx_12t_write_driver_rc1_9/wen detronyx_12t_write_driver_rc1_9/wen detronyx_12t_write_driver_rc1_9/wen
+ detronyx_12t_write_driver_rc1_9/wen detronyx_12t_write_driver_rc1_9/wen gf180mcu_3v3_12t_2r2w_sram_512x32_array_control_core_0/u_t009_018/c1_w1_bl
+ detronyx_12t_write_driver_rc1_9/wen gf180mcu_3v3_12t_2r2w_sram_512x32_array_control_core_0/u_t014_029/c3_w0_bl
+ gf180mcu_3v3_12t_2r2w_sram_512x32_array_control_core_0/u_t009_000/r3_w1_wl gf180mcu_3v3_12t_2r2w_sram_512x32_array_control_core_0/u_t030_031/r3_w0_wl
+ detronyx_12t_write_driver_rc1_9/wen detronyx_12t_write_driver_rc1_9/wen detronyx_12t_write_driver_rc1_9/wen
+ gf180mcu_3v3_12t_2r2w_sram_512x32_array_control_core_0/u_t026_022/c1_w0_bl gf180mcu_3v3_12t_2r2w_sram_512x32_array_control_core_0/u_t015_023/c3_w1_bl
+ gf180mcu_3v3_12t_2r2w_sram_512x32_array_control_core_0/u_t006_031/r2_w0_wl gf180mcu_3v3_12t_2r2w_sram_512x32_array_control_core_0/u_t030_016/c1_w1_bl
+ detronyx_12t_write_driver_rc1_9/wen detronyx_12t_write_driver_rc1_9/wen gf180mcu_3v3_12t_2r2w_sram_512x32_array_control_core_0/u_t021_017/c3_w1_bl
+ gf180mcu_3v3_12t_2r2w_sram_512x32_array_control_core_0/u_t005_007/c3_w1_bl detronyx_12t_write_driver_rc1_9/wen
+ detronyx_12t_write_driver_rc1_9/wen detronyx_12t_write_driver_rc1_9/wen detronyx_12t_write_driver_rc1_9/wen
+ detronyx_12t_write_driver_rc1_9/wen gf180mcu_3v3_12t_2r2w_sram_512x32_array_control_core_0/u_t030_016/c1_w1_bl
+ gf180mcu_3v3_12t_2r2w_sram_512x32_array_control_core_0/a_200_81400# detronyx_12t_write_driver_rc1_9/wen
+ gf180mcu_3v3_12t_2r2w_sram_512x32_array_control_core_0/u_t018_017/c3_w1_bl detronyx_12t_write_driver_rc1_9/wen
+ detronyx_12t_write_driver_rc1_9/wen gf180mcu_3v3_12t_2r2w_sram_512x32_array_control_core_0/u_t030_010/c1_w1_bl
+ gf180mcu_3v3_12t_2r2w_sram_512x32_array_control_core_0/u_t023_024/c1_w0_bl gf180mcu_3v3_12t_2r2w_sram_512x32_array_control_core_0/a_22600_64600#
+ detronyx_12t_write_driver_rc1_9/wen detronyx_12t_write_driver_rc1_9/wen detronyx_12t_write_driver_rc1_9/wen
+ gf180mcu_3v3_12t_2r2w_sram_512x32_array_control_core_0/u_t013_025/c3_w0_bl detronyx_12t_write_driver_rc1_9/wen
+ detronyx_12t_write_driver_rc1_9/wen gf180mcu_3v3_12t_2r2w_sram_512x32_array_control_core_0/u_t013_008/c1_w1_bl
+ gf180mcu_3v3_12t_2r2w_sram_512x32_array_control_core_0/u_t027_003/r2_w1_wl gf180mcu_3v3_12t_2r2w_sram_512x32_array_control_core_0/u_t004_009/c3_w1_bl
+ gf180mcu_3v3_12t_2r2w_sram_512x32_array_control_core_0/u_t030_030/r3_w0_wl detronyx_12t_write_driver_rc1_9/wen
+ gf180mcu_3v3_12t_2r2w_sram_512x32_array_control_core_0/u_t014_002/c1_w1_bl detronyx_12t_write_driver_rc1_9/wen
+ detronyx_12t_write_driver_rc1_9/wen gf180mcu_3v3_12t_2r2w_sram_512x32_array_control_core_0/u_t026_018/c1_w1_bl
+ detronyx_12t_write_driver_rc1_9/wen gf180mcu_3v3_12t_2r2w_sram_512x32_array_control_core_0/u_t015_003/r1_w1_wl
+ detronyx_12t_precharge_sense_rc1_0/ren detronyx_12t_write_driver_rc1_9/wen detronyx_12t_write_driver_rc1_9/wen
+ detronyx_12t_write_driver_rc1_9/wen detronyx_12t_write_driver_rc1_9/wen detronyx_12t_write_driver_rc1_9/wen
+ gf180mcu_3v3_12t_2r2w_sram_512x32_array_control_core_0/u_t021_026/c1_w0_bl gf180mcu_3v3_12t_2r2w_sram_512x32_array_control_core_0/u_t004_003/VDD
+ gf180mcu_3v3_12t_2r2w_sram_512x32_array_control_core_0/u_t006_016/c1_w1_bl detronyx_12t_write_driver_rc1_9/wen
+ gf180mcu_3v3_12t_2r2w_sram_512x32_array_control_core_0/u_t003_003/r1_w1_wl detronyx_12t_write_driver_rc1_9/wen
+ detronyx_12t_write_driver_rc1_9/wen detronyx_12t_write_driver_rc1_9/wen detronyx_12t_write_driver_rc1_9/wen
+ detronyx_12t_write_driver_rc1_9/wen detronyx_12t_write_driver_rc1_9/wen gf180mcu_3v3_12t_2r2w_sram_512x32_array_control_core_0/u_t019_026/c1_w0_bl
+ detronyx_12t_write_driver_rc1_9/wen detronyx_12t_write_driver_rc1_9/wen detronyx_12t_write_driver_rc1_9/wen
+ detronyx_12t_write_driver_rc1_9/wen detronyx_12t_write_driver_rc1_9/wen detronyx_12t_write_driver_rc1_9/wen
+ gf180mcu_3v3_12t_2r2w_sram_512x32_array_control_core_0/u_t026_031/r3_w0_wl detronyx_12t_write_driver_rc1_9/wen
+ detronyx_12t_write_driver_rc1_9/wen detronyx_12t_write_driver_rc1_9/wen detronyx_12t_write_driver_rc1_9/wen
+ gf180mcu_3v3_12t_2r2w_sram_512x32_array_control_core_0/u_t005_018/c1_w1_bl gf180mcu_3v3_12t_2r2w_sram_512x32_array_control_core_0/u_t015_015/c3_w1_bl
+ detronyx_12t_write_driver_rc1_9/wen gf180mcu_3v3_12t_2r2w_sram_512x32_array_control_core_0/u_t004_000/r3_w1_wl
+ gf180mcu_3v3_12t_2r2w_sram_512x32_array_control_core_0/u_t026_031/r3_w0_wl gf180mcu_3v3_12t_2r2w_sram_512x32_array_control_core_0/u_t021_022/c1_w0_bl
+ detronyx_12t_write_driver_rc1_9/wen detronyx_12t_write_driver_rc1_9/wen gf180mcu_3v3_12t_2r2w_sram_512x32_array_control_core_0/u_t004_018/VDD
+ gf180mcu_3v3_12t_2r2w_sram_512x32_array_control_core_0/u_t010_023/c3_w1_bl detronyx_12t_write_driver_rc1_9/wen
+ gf180mcu_3v3_12t_2r2w_sram_512x32_array_control_core_0/u_t001_031/r3_w0_wl detronyx_12t_write_driver_rc1_9/wen
+ gf180mcu_3v3_12t_2r2w_sram_512x32_array_control_core_0/a_14200_14200# detronyx_12t_write_driver_rc1_9/wen
+ gf180mcu_3v3_12t_2r2w_sram_512x32_array_control_core_0/u_t009_029/c3_w0_bl gf180mcu_3v3_12t_2r2w_sram_512x32_array_control_core_0/u_t018_022/c1_w0_bl
+ detronyx_12t_write_driver_rc1_9/wen gf180mcu_3v3_12t_2r2w_sram_512x32_array_control_core_0/u_t000_007/c3_w1_bl
+ detronyx_12t_write_driver_rc1_9/wen detronyx_12t_write_driver_rc1_9/wen gf180mcu_3v3_12t_2r2w_sram_512x32_array_control_core_0/u_t009_023/c3_w1_bl
+ gf180mcu_3v3_12t_2r2w_sram_512x32_array_control_core_0/u_t023_016/c1_w1_bl detronyx_12t_write_driver_rc1_9/wen
+ detronyx_12t_write_driver_rc1_9/wen detronyx_12t_write_driver_rc1_9/wen gf180mcu_3v3_12t_2r2w_sram_512x32_array_control_core_0/u_t013_017/c3_w1_bl
+ detronyx_12t_write_driver_rc1_9/wen gf180mcu_3v3_12t_2r2w_sram_512x32_array_control_core_0/u_t025_010/c1_w1_bl
+ detronyx_12t_write_driver_rc1_9/wen detronyx_12t_write_driver_rc1_9/wen detronyx_12t_write_driver_rc1_9/wen
+ detronyx_12t_write_driver_rc1_9/wen detronyx_12t_precharge_sense_rc1_61/ren detronyx_12t_write_driver_rc1_9/wen
+ gf180mcu_3v3_12t_2r2w_sram_512x32_array_control_core_0/u_t002_018/VSS gf180mcu_3v3_12t_2r2w_sram_512x32_array_control_core_0/u_t022_003/r3_w1_wl
+ gf180mcu_3v3_12t_2r2w_sram_512x32_array_control_core_0/u_t017_024/c1_w0_bl gf180mcu_3v3_12t_2r2w_sram_512x32_array_control_core_0/u_t002_003/VSS
+ detronyx_12t_write_driver_rc1_9/wen gf180mcu_3v3_12t_2r2w_sram_512x32_array_control_core_0/u_t006_025/c3_w0_bl
+ detronyx_12t_write_driver_rc1_9/wen detronyx_12t_write_driver_rc1_9/wen gf180mcu_3v3_12t_2r2w_sram_512x32_array_control_core_0/u_t021_018/c1_w1_bl
+ gf180mcu_3v3_12t_2r2w_sram_512x32_array_control_core_0/u_t006_008/c1_w1_bl gf180mcu_3v3_12t_2r2w_sram_512x32_array_control_core_0/u_t010_003/r2_w1_wl
+ detronyx_12t_write_driver_rc1_9/wen detronyx_12t_write_driver_rc1_9/wen detronyx_12t_write_driver_rc1_9/wen
+ detronyx_12t_write_driver_rc1_9/wen gf180mcu_3v3_12t_2r2w_sram_512x32_array_control_core_0/u_t007_002/c1_w1_bl
+ detronyx_12t_write_driver_rc1_9/wen gf180mcu_3v3_12t_2r2w_sram_512x32_array_control_core_0/u_t001_016/c1_w1_bl
+ detronyx_12t_write_driver_rc1_9/wen detronyx_12t_write_driver_rc1_9/wen gf180mcu_3v3_12t_2r2w_sram_512x32_array_control_core_0/a_200_61800#
+ gf180mcu_3v3_12t_2r2w_sram_512x32_array_control_core_0/u_t019_018/c1_w1_bl detronyx_12t_write_driver_rc1_9/wen
+ gf180mcu_3v3_12t_2r2w_sram_512x32_array_control_core_0/u_t002_025/VSS detronyx_12t_write_driver_rc1_9/wen
+ detronyx_12t_write_driver_rc1_9/wen detronyx_12t_write_driver_rc1_9/wen detronyx_12t_write_driver_rc1_9/wen
+ detronyx_12t_write_driver_rc1_9/wen gf180mcu_3v3_12t_2r2w_sram_512x32_array_control_core_0/u_t014_026/c1_w0_bl
+ gf180mcu_3v3_12t_2r2w_sram_512x32_array_control_core_0/u_t026_023/c3_w1_bl gf180mcu_3v3_12t_2r2w_sram_512x32_array_control_core_0/u_t030_030/r3_w0_wl
+ detronyx_12t_write_driver_rc1_9/wen detronyx_12t_write_driver_rc1_9/wen detronyx_12t_write_driver_rc1_9/wen
+ detronyx_12t_write_driver_rc1_9/wen detronyx_12t_write_driver_rc1_9/wen gf180mcu_3v3_12t_2r2w_sram_512x32_array_control_core_0/u_t021_031/r3_w0_wl
+ gf180mcu_3v3_12t_2r2w_sram_512x32_array_control_core_0/u_t009_030/r3_w0_wl detronyx_12t_write_driver_rc1_9/wen
+ detronyx_12t_write_driver_rc1_9/wen detronyx_12t_write_driver_rc1_9/wen detronyx_12t_write_driver_rc1_9/wen
+ detronyx_12t_write_driver_rc1_9/wen detronyx_12t_write_driver_rc1_9/wen detronyx_12t_write_driver_rc1_9/wen
+ detronyx_12t_write_driver_rc1_9/wen detronyx_12t_write_driver_rc1_9/wen gf180mcu_3v3_12t_2r2w_sram_512x32_array_control_core_0/u_t028_030/r1_w0_wl
+ gf180mcu_3v3_12t_2r2w_sram_512x32_array_control_core_0/u_t010_015/c3_w1_bl gf180mcu_3v3_12t_2r2w_sram_512x32_array_control_core_0/u_t018_031/r3_w0_wl
+ detronyx_12t_write_driver_rc1_9/wen detronyx_12t_write_driver_rc1_9/wen detronyx_12t_write_driver_rc1_9/wen
+ detronyx_12t_write_driver_rc1_9/wen detronyx_12t_write_driver_rc1_9/wen detronyx_12t_write_driver_rc1_9/wen
+ detronyx_12t_write_driver_rc1_9/wen detronyx_12t_write_driver_rc1_9/wen detronyx_12t_write_driver_rc1_9/wen
+ detronyx_12t_write_driver_rc1_9/wen detronyx_12t_write_driver_rc1_9/wen gf180mcu_3v3_12t_2r2w_sram_512x32_array_control_core_0/u_t009_015/c3_w1_bl
+ gf180mcu_3v3_12t_2r2w_sram_512x32_array_control_core_0/u_t002_029/c3_w0_bl gf180mcu_3v3_12t_2r2w_sram_512x32_array_control_core_0/u_t017_031/r3_w0_wl
+ gf180mcu_3v3_12t_2r2w_sram_512x32_array_control_core_0/u_t004_018/VDD detronyx_12t_write_driver_rc1_9/wen
+ detronyx_12t_write_driver_rc1_9/wen gf180mcu_3v3_12t_2r2w_sram_512x32_array_control_core_0/u_t013_022/c1_w0_bl
+ gf180mcu_3v3_12t_2r2w_sram_512x32_array_control_core_0/u_t029_001/r3_w1_wl gf180mcu_3v3_12t_2r2w_sram_512x32_array_control_core_0/u_t004_003/VDD
+ gf180mcu_3v3_12t_2r2w_sram_512x32_array_control_core_0/u_t005_023/c3_w1_bl detronyx_12t_write_driver_rc1_9/wen
+ detronyx_12t_write_driver_rc1_9/wen detronyx_12t_write_driver_rc1_9/wen gf180mcu_3v3_12t_2r2w_sram_512x32_array_control_core_0/u_t017_001/r3_w1_wl
+ gf180mcu_3v3_12t_2r2w_sram_512x32_array_control_core_0/a_19800_120600# gf180mcu_3v3_12t_2r2w_sram_512x32_array_control_core_0/u_t025_008/c3_w1_bl
+ gf180mcu_3v3_12t_2r2w_sram_512x32_array_control_core_0/u_t017_016/c1_w1_bl gf180mcu_3v3_12t_2r2w_sram_512x32_array_control_core_0/u_t030_015/c1_w1_bl
+ detronyx_12t_write_driver_rc1_9/wen gf180mcu_3v3_12t_2r2w_sram_512x32_array_control_core_0/u_t006_017/c3_w1_bl
+ gf180mcu_3v3_12t_2r2w_sram_512x32_array_control_core_0/u_t017_010/c1_w1_bl gf180mcu_3v3_12t_2r2w_sram_512x32_array_control_core_0/u_t013_024/c1_w0_bl
+ detronyx_12t_write_driver_rc1_9/wen detronyx_12t_write_driver_rc1_9/wen gf180mcu_3v3_12t_2r2w_sram_512x32_array_control_core_0/a_200_17000#
+ gf180mcu_3v3_12t_2r2w_sram_512x32_array_control_core_0/u_t001_025/c3_w0_bl gf180mcu_3v3_12t_2r2w_sram_512x32_array_control_core_0/u_t030_015/c1_w1_bl
+ gf180mcu_3v3_12t_2r2w_sram_512x32_array_control_core_0/u_t025_002/r0_w1_wl gf180mcu_3v3_12t_2r2w_sram_512x32_array_control_core_0/a_22600_73000#
+ gf180mcu_3v3_12t_2r2w_sram_512x32_array_control_core_0/u_t001_008/c1_w1_bl gf180mcu_3v3_12t_2r2w_sram_512x32_array_control_core_0/u_t009_024/c1_w0_bl
+ detronyx_12t_write_driver_rc1_9/wen gf180mcu_3v3_12t_2r2w_sram_512x32_array_control_core_0/u_t002_002/c1_w1_bl
+ gf180mcu_3v3_12t_2r2w_sram_512x32_array_control_core_0/u_t014_018/c1_w1_bl detronyx_12t_write_driver_rc1_9/wen
+ gf180mcu_3v3_12t_2r2w_sram_512x32_array_control_core_0/u_t003_003/r1_w1_wl detronyx_12t_write_driver_rc1_9/wen
+ detronyx_12t_write_driver_rc1_9/wen detronyx_12t_write_driver_rc1_9/wen detronyx_12t_write_driver_rc1_9/wen
+ gf180mcu_3v3_12t_2r2w_sram_512x32_array_control_core_0/u_t017_030/r3_w0_wl gf180mcu_3v3_12t_2r2w_sram_512x32_array_control_core_0/u_t021_023/c3_w1_bl
+ detronyx_12t_write_driver_rc1_9/wen detronyx_12t_write_driver_rc1_9/wen detronyx_12t_write_driver_rc1_9/wen
+ gf180mcu_3v3_12t_2r2w_sram_512x32_array_control_core_0/u_t026_017/c1_w1_bl detronyx_12t_write_driver_rc1_9/wen
+ detronyx_12t_write_driver_rc1_9/wen detronyx_12t_write_driver_rc1_9/wen detronyx_12t_write_driver_rc1_9/wen
+ detronyx_12t_write_driver_rc1_9/wen detronyx_12t_write_driver_rc1_9/wen detronyx_12t_write_driver_rc1_9/wen
+ gf180mcu_3v3_12t_2r2w_sram_512x32_array_control_core_0/u_t009_026/c1_w0_bl detronyx_12t_write_driver_rc1_9/wen
+ detronyx_12t_write_driver_rc1_9/wen gf180mcu_3v3_12t_2r2w_sram_512x32_array_control_core_0/u_t018_023/c3_w1_bl
+ detronyx_12t_write_driver_rc1_9/wen detronyx_12t_write_driver_rc1_9/wen gf180mcu_3v3_12t_2r2w_sram_512x32_array_control_core_0/u_t023_030/r2_w0_wl
+ detronyx_12t_write_driver_rc1_9/wen detronyx_12t_write_driver_rc1_9/wen detronyx_12t_write_driver_rc1_9/wen
+ detronyx_12t_write_driver_rc1_9/wen gf180mcu_3v3_12t_2r2w_sram_512x32_array_control_core_0/u_t013_031/r3_w0_wl
+ detronyx_12t_write_driver_rc1_9/wen detronyx_12t_write_driver_rc1_9/wen gf180mcu_3v3_12t_2r2w_sram_512x32_array_control_core_0/u_t026_031/r3_w0_wl
+ detronyx_12t_write_driver_rc1_9/wen detronyx_12t_write_driver_rc1_9/wen detronyx_12t_write_driver_rc1_9/wen
+ detronyx_12t_write_driver_rc1_9/wen gf180mcu_3v3_12t_2r2w_sram_512x32_array_control_core_0/u_t004_015/c3_w1_bl
+ detronyx_12t_write_driver_rc1_9/wen detronyx_12t_write_driver_rc1_9/wen detronyx_12t_write_driver_rc1_9/wen
+ detronyx_12t_write_driver_rc1_9/wen gf180mcu_3v3_12t_2r2w_sram_512x32_array_control_core_0/u_t013_031/r3_w0_wl
+ detronyx_12t_write_driver_rc1_9/wen detronyx_12t_write_driver_rc1_9/wen detronyx_12t_write_driver_rc1_9/wen
+ gf180mcu_3v3_12t_2r2w_sram_512x32_array_control_core_0/u_t025_001/r0_w1_wl detronyx_12t_write_driver_rc1_9/wen
+ detronyx_12t_write_driver_rc1_9/wen detronyx_12t_write_driver_rc1_9/wen detronyx_12t_write_driver_rc1_9/wen
+ detronyx_12t_write_driver_rc1_9/wen gf180mcu_3v3_12t_2r2w_sram_512x32_array_control_core_0/u_t030_024/c3_w0_bl
+ gf180mcu_3v3_12t_2r2w_sram_512x32_array_control_core_0/u_t006_022/c1_w0_bl detronyx_12t_write_driver_rc1_9/wen
+ detronyx_12t_write_driver_rc1_9/wen detronyx_12t_write_driver_rc1_9/wen gf180mcu_3v3_12t_2r2w_sram_512x32_array_control_core_0/u_t021_008/c3_w1_bl
+ gf180mcu_3v3_12t_2r2w_sram_512x32_array_control_core_0/u_t013_016/c1_w1_bl detronyx_12t_write_driver_rc1_9/wen
+ gf180mcu_3v3_12t_2r2w_sram_512x32_array_control_core_0/u_t030_024/c3_w0_bl gf180mcu_3v3_12t_2r2w_sram_512x32_array_control_core_0/u_t001_017/c3_w1_bl
+ gf180mcu_3v3_12t_2r2w_sram_512x32_array_control_core_0/u_t013_010/c1_w1_bl detronyx_12t_write_driver_rc1_9/wen
+ detronyx_12t_write_driver_rc1_9/wen detronyx_12t_write_driver_rc1_9/wen detronyx_12t_write_driver_rc1_9/wen
+ gf180mcu_3v3_12t_2r2w_sram_512x32_array_control_core_0/u_t018_008/c3_w1_bl gf180mcu_3v3_12t_2r2w_sram_512x32_array_control_core_0/u_t022_003/r3_w1_wl
+ detronyx_12t_write_driver_rc1_9/wen gf180mcu_3v3_12t_2r2w_sram_512x32_array_control_core_0/u_t009_016/c1_w1_bl
+ gf180mcu_3v3_12t_2r2w_sram_512x32_array_control_core_0/u_t029_001/c1_w1_bl detronyx_12t_write_driver_rc1_9/wen
+ detronyx_12t_write_driver_rc1_9/wen gf180mcu_3v3_12t_2r2w_sram_512x32_array_control_core_0/u_t023_015/c1_w1_bl
+ gf180mcu_3v3_12t_2r2w_sram_512x32_array_control_core_0/u_t020_002/r1_w1_wl detronyx_12t_write_driver_rc1_9/wen
+ detronyx_12t_write_driver_rc1_9/wen detronyx_12t_write_driver_rc1_9/wen gf180mcu_3v3_12t_2r2w_sram_512x32_array_control_core_0/u_t010_003/r2_w1_wl
+ gf180mcu_3v3_12t_2r2w_sram_512x32_array_control_core_0/u_t005_024/c1_w0_bl detronyx_12t_write_driver_rc1_9/wen
+ detronyx_12t_write_driver_rc1_9/wen detronyx_12t_write_driver_rc1_9/wen detronyx_12t_write_driver_rc1_9/wen
+ detronyx_12t_write_driver_rc1_9/wen detronyx_12t_write_driver_rc1_9/wen detronyx_12t_write_driver_rc1_9/wen
+ gf180mcu_3v3_12t_2r2w_sram_512x32_array_control_core_0/u_t026_009/c1_w1_bl detronyx_12t_write_driver_rc1_9/wen
+ detronyx_12t_write_driver_rc1_9/wen detronyx_12t_write_driver_rc1_9/wen detronyx_12t_write_driver_rc1_9/wen
+ detronyx_12t_write_driver_rc1_9/wen detronyx_12t_write_driver_rc1_9/wen detronyx_12t_write_driver_rc1_9/wen
+ gf180mcu_3v3_12t_2r2w_sram_512x32_array_control_core_0/u_t009_018/c1_w1_bl gf180mcu_3v3_12t_2r2w_sram_512x32_array_control_core_0/u_t027_003/c1_w1_bl
+ detronyx_12t_write_driver_rc1_9/wen gf180mcu_3v3_12t_2r2w_sram_512x32_array_control_core_0/u_t021_017/c1_w1_bl
+ detronyx_12t_write_driver_rc1_9/wen gf180mcu_3v3_12t_2r2w_sram_512x32_array_control_core_0/a_200_70200#
+ detronyx_12t_write_driver_rc1_9/wen detronyx_12t_write_driver_rc1_9/wen gf180mcu_3v3_12t_2r2w_sram_512x32_array_control_core_0/u_t013_023/c3_w1_bl
+ gf180mcu_3v3_12t_2r2w_sram_512x32_array_control_core_0/u_t002_026/c1_w0_bl gf180mcu_3v3_12t_2r2w_sram_512x32_array_control_core_0/u_t009_030/r3_w0_wl
+ detronyx_12t_write_driver_rc1_9/wen detronyx_12t_write_driver_rc1_9/wen detronyx_12t_write_driver_rc1_9/wen
+ gf180mcu_3v3_12t_2r2w_sram_512x32_array_control_core_0/a_22600_53400# gf180mcu_3v3_12t_2r2w_sram_512x32_array_control_core_0/u_t019_017/c1_w1_bl
+ detronyx_12t_write_driver_rc1_9/wen detronyx_12t_write_driver_rc1_9/wen detronyx_12t_write_driver_rc1_9/wen
+ detronyx_12t_write_driver_rc1_9/wen detronyx_12t_write_driver_rc1_9/wen detronyx_12t_write_driver_rc1_9/wen
+ gf180mcu_3v3_12t_2r2w_sram_512x32_array_control_core_0/u_t026_022/c3_w1_bl gf180mcu_3v3_12t_2r2w_sram_512x32_array_control_core_0/u_t016_030/r1_w0_wl
+ detronyx_12t_write_driver_rc1_9/wen detronyx_12t_write_driver_rc1_9/wen detronyx_12t_write_driver_rc1_9/wen
+ detronyx_12t_write_driver_rc1_9/wen gf180mcu_3v3_12t_2r2w_sram_512x32_array_control_core_0/u_t006_031/r2_w0_wl
+ gf180mcu_3v3_12t_2r2w_sram_512x32_array_control_core_0/u_t030_016/c3_w1_bl detronyx_12t_write_driver_rc1_9/wen
+ detronyx_12t_write_driver_rc1_9/wen detronyx_12t_write_driver_rc1_9/wen detronyx_12t_write_driver_rc1_9/wen
+ detronyx_12t_write_driver_rc1_9/wen detronyx_12t_write_driver_rc1_9/wen detronyx_12t_write_driver_rc1_9/wen
+ gf180mcu_3v3_12t_2r2w_sram_512x32_array_control_core_0/u_t027_000/r2_w1_wl detronyx_12t_write_driver_rc1_9/wen
+ gf180mcu_3v3_12t_2r2w_sram_512x32_array_control_core_0/u_t030_016/c3_w1_bl detronyx_12t_write_driver_rc1_9/wen
+ detronyx_12t_write_driver_rc1_9/wen gf180mcu_3v3_12t_2r2w_sram_512x32_array_control_core_0/u_t001_022/c1_w0_bl
+ gf180mcu_3v3_12t_2r2w_sram_512x32_array_control_core_0/u_t017_001/r3_w1_wl gf180mcu_3v3_12t_2r2w_sram_512x32_array_control_core_0/u_t030_010/c3_w1_bl
+ detronyx_12t_write_driver_rc1_9/wen gf180mcu_3v3_12t_2r2w_sram_512x32_array_control_core_0/u_t015_000/r1_w1_wl
+ gf180mcu_3v3_12t_2r2w_sram_512x32_array_control_core_0/u_t023_024/c3_w0_bl gf180mcu_3v3_12t_2r2w_sram_512x32_array_control_core_0/u_t005_001/r3_w1_wl
+ detronyx_12t_write_driver_rc1_9/wen detronyx_12t_write_driver_rc1_9/wen gf180mcu_3v3_12t_2r2w_sram_512x32_array_control_core_0/u_t013_008/c3_w1_bl
+ gf180mcu_3v3_12t_2r2w_sram_512x32_array_control_core_0/u_t005_016/c1_w1_bl gf180mcu_3v3_12t_2r2w_sram_512x32_array_control_core_0/u_t025_001/c1_w1_bl
+ detronyx_12t_write_driver_rc1_9/wen gf180mcu_3v3_12t_2r2w_sram_512x32_array_control_core_0/u_t005_010/c1_w1_bl
+ detronyx_12t_write_driver_rc1_9/wen detronyx_12t_write_driver_rc1_9/wen gf180mcu_3v3_12t_2r2w_sram_512x32_array_control_core_0/u_t026_018/c3_w1_bl
+ detronyx_12t_write_driver_rc1_9/wen detronyx_12t_write_driver_rc1_9/wen detronyx_12t_write_driver_rc1_9/wen
+ detronyx_12t_write_driver_rc1_9/wen detronyx_12t_write_driver_rc1_9/wen gf180mcu_3v3_12t_2r2w_sram_512x32_array_control_core_0/u_t017_015/c1_w1_bl
+ detronyx_12t_write_driver_rc1_9/wen detronyx_12t_write_driver_rc1_9/wen detronyx_12t_write_driver_rc1_9/wen
+ gf180mcu_3v3_12t_2r2w_sram_512x32_array_control_core_0/u_t004_003/VDD gf180mcu_3v3_12t_2r2w_sram_512x32_array_control_core_0/u_t021_009/c1_w1_bl
+ detronyx_12t_write_driver_rc1_9/wen detronyx_12t_write_driver_rc1_9/wen detronyx_12t_write_driver_rc1_9/wen
+ gf180mcu_3v3_12t_2r2w_sram_512x32_array_control_core_0/u_t030_025/c1_w0_bl detronyx_12t_write_driver_rc1_9/wen
+ detronyx_12t_write_driver_rc1_9/wen gf180mcu_3v3_12t_2r2w_sram_512x32_array_control_core_0/u_t002_018/c1_w1_bl
+ gf180mcu_3v3_12t_2r2w_sram_512x32_array_control_core_0/u_t022_003/c1_w1_bl detronyx_12t_write_driver_rc1_9/wen
+ detronyx_12t_write_driver_rc1_9/wen detronyx_12t_write_driver_rc1_9/wen detronyx_12t_write_driver_rc1_9/wen
+ detronyx_12t_write_driver_rc1_9/wen gf180mcu_3v3_12t_2r2w_sram_512x32_array_control_core_0/u_t019_009/c1_w1_bl
+ detronyx_12t_write_driver_rc1_9/wen detronyx_12t_write_driver_rc1_9/wen gf180mcu_3v3_12t_2r2w_sram_512x32_array_control_core_0/u_t004_030/r3_w0_wl
+ detronyx_12t_write_driver_rc1_9/wen gf180mcu_3v3_12t_2r2w_sram_512x32_array_control_core_0/u_t014_017/c1_w1_bl
+ detronyx_12t_write_driver_rc1_9/wen detronyx_12t_write_driver_rc1_9/wen detronyx_12t_write_driver_rc1_9/wen
+ detronyx_12t_write_driver_rc1_9/wen detronyx_12t_write_driver_rc1_9/wen detronyx_12t_write_driver_rc1_9/wen
+ detronyx_12t_write_driver_rc1_9/wen gf180mcu_3v3_12t_2r2w_sram_512x32_array_control_core_0/u_t004_003/VDD
+ detronyx_12t_write_driver_rc1_9/wen gf180mcu_3v3_12t_2r2w_sram_512x32_array_control_core_0/u_t006_023/c3_w1_bl
+ gf180mcu_3v3_12t_2r2w_sram_512x32_array_control_core_0/u_t021_022/c3_w1_bl detronyx_12t_write_driver_rc1_9/wen
+ detronyx_12t_write_driver_rc1_9/wen detronyx_12t_write_driver_rc1_9/wen gf180mcu_3v3_12t_2r2w_sram_512x32_array_control_core_0/u_t011_030/r1_w0_wl
+ detronyx_12t_write_driver_rc1_9/wen gf180mcu_3v3_12t_2r2w_sram_512x32_array_control_core_0/u_t004_018/VDD
+ detronyx_12t_write_driver_rc1_9/wen detronyx_12t_write_driver_rc1_9/wen detronyx_12t_write_driver_rc1_9/wen
+ gf180mcu_3v3_12t_2r2w_sram_512x32_array_control_core_0/u_t001_031/r3_w0_wl detronyx_12t_write_driver_rc1_9/wen
+ detronyx_12t_write_driver_rc1_9/wen detronyx_12t_write_driver_rc1_9/wen gf180mcu_3v3_12t_2r2w_sram_512x32_array_control_core_0/u_t013_031/r3_w0_wl
+ detronyx_12t_write_driver_rc1_9/wen detronyx_12t_write_driver_rc1_9/wen gf180mcu_3v3_12t_2r2w_sram_512x32_array_control_core_0/u_t018_022/c3_w1_bl
+ detronyx_12t_write_driver_rc1_9/wen gf180mcu_3v3_12t_2r2w_sram_512x32_array_control_core_0/u_t009_030/r3_w0_wl
+ detronyx_12t_write_driver_rc1_9/wen detronyx_12t_write_driver_rc1_9/wen detronyx_12t_write_driver_rc1_9/wen
+ detronyx_12t_write_driver_rc1_9/wen detronyx_12t_write_driver_rc1_9/wen detronyx_12t_write_driver_rc1_9/wen
+ detronyx_12t_write_driver_rc1_9/wen gf180mcu_3v3_12t_2r2w_sram_512x32_array_control_core_0/u_t023_016/c3_w1_bl
+ gf180mcu_3v3_12t_2r2w_sram_512x32_array_control_core_0/a_200_50600# detronyx_12t_write_driver_rc1_9/wen
+ gf180mcu_3v3_12t_2r2w_sram_512x32_array_control_core_0/u_t012_001/r3_w1_wl detronyx_12t_write_driver_rc1_9/wen
+ detronyx_12t_write_driver_rc1_9/wen detronyx_12t_write_driver_rc1_9/wen gf180mcu_3v3_12t_2r2w_sram_512x32_array_control_core_0/u_t025_010/c3_w1_bl
+ gf180mcu_3v3_12t_2r2w_sram_512x32_array_control_core_0/a_22600_33800# detronyx_12t_write_driver_rc1_9/wen
+ gf180mcu_3v3_12t_2r2w_sram_512x32_array_control_core_0/u_t000_001/r3_w1_wl detronyx_12t_write_driver_rc1_9/wen
+ gf180mcu_3v3_12t_2r2w_sram_512x32_array_control_core_0/u_t026_023/c1_w0_bl gf180mcu_3v3_12t_2r2w_sram_512x32_array_control_core_0/u_t008_000/r0_w1_wl
+ gf180mcu_3v3_12t_2r2w_sram_512x32_array_control_core_0/u_t017_024/c3_w0_bl detronyx_12t_write_driver_rc1_9/wen
+ detronyx_12t_write_driver_rc1_9/wen detronyx_12t_write_driver_rc1_9/wen gf180mcu_3v3_12t_2r2w_sram_512x32_array_control_core_0/u_t020_002/r1_w1_wl
+ detronyx_12t_write_driver_rc1_9/wen gf180mcu_3v3_12t_2r2w_sram_512x32_array_control_core_0/u_t021_018/c3_w1_bl
+ gf180mcu_3v3_12t_2r2w_sram_512x32_array_control_core_0/a_22600_200# gf180mcu_3v3_12t_2r2w_sram_512x32_array_control_core_0/u_t006_008/c3_w1_bl
+ gf180mcu_3v3_12t_2r2w_sram_512x32_array_control_core_0/u_t017_001/c1_w1_bl gf180mcu_3v3_12t_2r2w_sram_512x32_array_control_core_0/u_t013_015/c1_w1_bl
+ detronyx_12t_write_driver_rc1_9/wen gf180mcu_3v3_12t_2r2w_sram_512x32_array_control_core_0/u_t030_017/c1_w1_bl
+ gf180mcu_3v3_12t_2r2w_sram_512x32_array_control_core_0/u_t018_002/r2_w1_wl detronyx_12t_write_driver_rc1_9/wen
+ gf180mcu_3v3_12t_2r2w_sram_512x32_array_control_core_0/u_t019_018/c3_w1_bl detronyx_12t_write_driver_rc1_9/wen
+ gf180mcu_3v3_12t_2r2w_sram_512x32_array_control_core_0/a_200_89800# gf180mcu_3v3_12t_2r2w_sram_512x32_array_control_core_0/a_22600_117800#
+ gf180mcu_3v3_12t_2r2w_sram_512x32_array_control_core_0/u_t008_003/r3_w1_wl detronyx_12t_write_driver_rc1_9/wen
+ gf180mcu_3v3_12t_2r2w_sram_512x32_array_control_core_0/u_t026_025/c1_w0_bl detronyx_12t_write_driver_rc1_9/wen
+ gf180mcu_3v3_12t_2r2w_sram_512x32_array_control_core_0/u_t009_015/c1_w1_bl detronyx_12t_write_driver_rc1_9/wen
+ detronyx_12t_write_driver_rc1_9/wen gf180mcu_3v3_12t_2r2w_sram_512x32_array_control_core_0/u_t014_009/c1_w1_bl
+ gf180mcu_3v3_12t_2r2w_sram_512x32_array_control_core_0/u_t030_030/c3_w0_bl detronyx_12t_write_driver_rc1_9/wen
+ detronyx_12t_write_driver_rc1_9/wen detronyx_12t_write_driver_rc1_9/wen detronyx_12t_write_driver_rc1_9/wen
+ detronyx_12t_write_driver_rc1_9/wen detronyx_12t_write_driver_rc1_9/wen gf180mcu_3v3_12t_2r2w_sram_512x32_array_control_core_0/u_t015_003/c1_w1_bl
+ detronyx_12t_write_driver_rc1_9/wen detronyx_12t_write_driver_rc1_9/wen detronyx_12t_write_driver_rc1_9/wen
+ detronyx_12t_write_driver_rc1_9/wen gf180mcu_3v3_12t_2r2w_sram_512x32_array_control_core_0/u_t030_030/c3_w0_bl
+ detronyx_12t_write_driver_rc1_9/wen gf180mcu_3v3_12t_2r2w_sram_512x32_array_control_core_0/u_t001_023/c3_w1_bl
+ gf180mcu_3v3_12t_2r2w_sram_512x32_array_control_core_0/u_t004_003/VDD detronyx_12t_write_driver_rc1_9/wen
+ detronyx_12t_write_driver_rc1_9/wen detronyx_12t_write_driver_rc1_9/wen gf180mcu_3v3_12t_2r2w_sram_512x32_array_control_core_0/u_t030_031/r3_w0_wl
+ detronyx_12t_write_driver_rc1_9/wen detronyx_12t_write_driver_rc1_9/wen detronyx_12t_write_driver_rc1_9/wen
+ gf180mcu_3v3_12t_2r2w_sram_512x32_array_control_core_0/u_t009_017/c1_w1_bl detronyx_12t_write_driver_rc1_9/wen
+ detronyx_12t_write_driver_rc1_9/wen detronyx_12t_write_driver_rc1_9/wen detronyx_12t_write_driver_rc1_9/wen
+ detronyx_12t_write_driver_rc1_9/wen detronyx_12t_write_driver_rc1_9/wen detronyx_12t_write_driver_rc1_9/wen
+ gf180mcu_3v3_12t_2r2w_sram_512x32_array_control_core_0/u_t013_022/c3_w1_bl gf180mcu_3v3_12t_2r2w_sram_512x32_array_control_core_0/u_t004_030/r3_w0_wl
+ detronyx_12t_write_driver_rc1_9/wen detronyx_12t_write_driver_rc1_9/wen gf180mcu_3v3_12t_2r2w_sram_512x32_array_control_core_0/u_t027_000/r2_w1_wl
+ detronyx_12t_write_driver_rc1_9/wen detronyx_12t_write_driver_rc1_9/wen gf180mcu_3v3_12t_2r2w_sram_512x32_array_control_core_0/u_t026_015/c1_w1_bl
+ detronyx_12t_write_driver_rc1_9/wen gf180mcu_3v3_12t_2r2w_sram_512x32_array_control_core_0/u_t015_000/r1_w1_wl
+ detronyx_12t_write_driver_rc1_9/wen detronyx_12t_write_driver_rc1_9/wen detronyx_12t_write_driver_rc1_9/wen
+ gf180mcu_3v3_12t_2r2w_sram_512x32_array_control_core_0/u_t017_016/c3_w1_bl gf180mcu_3v3_12t_2r2w_sram_512x32_array_control_core_0/u_t005_001/r3_w1_wl
+ gf180mcu_3v3_12t_2r2w_sram_512x32_array_control_core_0/u_t021_023/c1_w0_bl gf180mcu_3v3_12t_2r2w_sram_512x32_array_control_core_0/u_t017_010/c3_w1_bl
+ gf180mcu_3v3_12t_2r2w_sram_512x32_array_control_core_0/u_t003_000/r1_w1_wl gf180mcu_3v3_12t_2r2w_sram_512x32_array_control_core_0/u_t013_024/c3_w0_bl
+ detronyx_12t_write_driver_rc1_9/wen detronyx_12t_write_driver_rc1_9/wen gf180mcu_3v3_12t_2r2w_sram_512x32_array_control_core_0/a_14200_95400#
+ detronyx_12t_write_driver_rc1_9/wen gf180mcu_3v3_12t_2r2w_sram_512x32_array_control_core_0/u_t019_023/c1_w0_bl
+ gf180mcu_3v3_12t_2r2w_sram_512x32_array_control_core_0/u_t001_008/c3_w1_bl gf180mcu_3v3_12t_2r2w_sram_512x32_array_control_core_0/u_t012_001/c1_w1_bl
+ detronyx_12t_write_driver_rc1_9/wen gf180mcu_3v3_12t_2r2w_sram_512x32_array_control_core_0/u_t009_024/c3_w0_bl
+ detronyx_12t_write_driver_rc1_9/wen detronyx_12t_write_driver_rc1_9/wen gf180mcu_3v3_12t_2r2w_sram_512x32_array_control_core_0/u_t026_017/c1_w1_bl
+ detronyx_12t_write_driver_rc1_9/wen detronyx_12t_write_driver_rc1_9/wen detronyx_12t_write_driver_rc1_9/wen
+ gf180mcu_3v3_12t_2r2w_sram_512x32_array_control_core_0/u_t014_018/c3_w1_bl detronyx_12t_write_driver_rc1_9/wen
+ detronyx_12t_write_driver_rc1_9/wen gf180mcu_3v3_12t_2r2w_sram_512x32_array_control_core_0/u_t025_011/c1_w1_bl
+ gf180mcu_3v3_12t_2r2w_sram_512x32_array_control_core_0/u_t004_003/r0_w1_wl gf180mcu_3v3_12t_2r2w_sram_512x32_array_control_core_0/u_t030_022/c3_w1_bl
+ detronyx_12t_write_driver_rc1_9/wen detronyx_12t_write_driver_rc1_9/wen gf180mcu_3v3_12t_2r2w_sram_512x32_array_control_core_0/u_t004_015/c1_w1_bl
+ detronyx_12t_write_driver_rc1_9/wen detronyx_12t_write_driver_rc1_9/wen detronyx_12t_write_driver_rc1_9/wen
+ detronyx_12t_write_driver_rc1_9/wen gf180mcu_3v3_12t_2r2w_sram_512x32_array_control_core_0/u_t017_025/c1_w0_bl
+ detronyx_12t_write_driver_rc1_9/wen detronyx_12t_write_driver_rc1_9/wen gf180mcu_3v3_12t_2r2w_sram_512x32_array_control_core_0/u_t030_022/c3_w1_bl
+ gf180mcu_3v3_12t_2r2w_sram_512x32_array_control_core_0/u_t010_003/c1_w1_bl detronyx_12t_write_driver_rc1_9/wen
+ detronyx_12t_write_driver_rc1_9/wen detronyx_12t_write_driver_rc1_9/wen detronyx_12t_write_driver_rc1_9/wen
+ detronyx_12t_write_driver_rc1_9/wen detronyx_12t_write_driver_rc1_9/wen gf180mcu_3v3_12t_2r2w_sram_512x32_array_control_core_0/u_t023_030/c3_w0_bl
+ gf180mcu_3v3_12t_2r2w_sram_512x32_array_control_core_0/u_t009_009/c1_w1_bl detronyx_12t_write_driver_rc1_9/wen
+ detronyx_12t_write_driver_rc1_9/wen detronyx_12t_write_driver_rc1_9/wen detronyx_12t_write_driver_rc1_9/wen
+ detronyx_12t_write_driver_rc1_9/wen detronyx_12t_write_driver_rc1_9/wen detronyx_12t_write_driver_rc1_9/wen
+ detronyx_12t_write_driver_rc1_9/wen gf180mcu_3v3_12t_2r2w_sram_512x32_array_control_core_0/u_t009_003/c1_w1_bl
+ gf180mcu_3v3_12t_2r2w_sram_512x32_array_control_core_0/u_t002_017/c1_w1_bl detronyx_12t_write_driver_rc1_9/wen
+ detronyx_12t_write_driver_rc1_9/wen detronyx_12t_write_driver_rc1_9/wen detronyx_12t_write_driver_rc1_9/wen
+ detronyx_12t_write_driver_rc1_9/wen detronyx_12t_write_driver_rc1_9/wen detronyx_12t_write_driver_rc1_9/wen
+ detronyx_12t_write_driver_rc1_9/wen detronyx_12t_write_driver_rc1_9/wen detronyx_12t_write_driver_rc1_9/wen
+ detronyx_12t_write_driver_rc1_9/wen gf180mcu_3v3_12t_2r2w_sram_512x32_array_control_core_0/u_t022_000/r3_w1_wl
+ detronyx_12t_write_driver_rc1_9/wen detronyx_12t_write_driver_rc1_9/wen detronyx_12t_write_driver_rc1_9/wen
+ detronyx_12t_write_driver_rc1_9/wen gf180mcu_3v3_12t_2r2w_sram_512x32_array_control_core_0/u_t006_022/c3_w1_bl
+ detronyx_12t_write_driver_rc1_9/wen gf180mcu_3v3_12t_2r2w_sram_512x32_array_control_core_0/u_t030_007/c3_w1_bl
+ gf180mcu_3v3_12t_2r2w_sram_512x32_array_control_core_0/u_t021_015/c1_w1_bl gf180mcu_3v3_12t_2r2w_sram_512x32_array_control_core_0/u_t010_000/r2_w1_wl
+ detronyx_12t_write_driver_rc1_9/wen detronyx_12t_write_driver_rc1_9/wen gf180mcu_3v3_12t_2r2w_sram_512x32_array_control_core_0/u_t030_031/r3_w0_wl
+ gf180mcu_3v3_12t_2r2w_sram_512x32_array_control_core_0/u_t013_016/c3_w1_bl detronyx_12t_write_driver_rc1_9/wen
+ detronyx_12t_write_driver_rc1_9/wen gf180mcu_3v3_12t_2r2w_sram_512x32_array_control_core_0/u_t000_001/r3_w1_wl
+ detronyx_12t_write_driver_rc1_9/wen gf180mcu_3v3_12t_2r2w_sram_512x32_array_control_core_0/u_t028_007/c3_w1_bl
+ detronyx_12t_write_driver_rc1_9/wen gf180mcu_3v3_12t_2r2w_sram_512x32_array_control_core_0/u_t013_010/c3_w1_bl
+ gf180mcu_3v3_12t_2r2w_sram_512x32_array_control_core_0/u_t019_015/c1_w1_bl detronyx_12t_write_driver_rc1_9/wen
+ detronyx_12t_write_driver_rc1_9/wen gf180mcu_3v3_12t_2r2w_sram_512x32_array_control_core_0/u_t009_016/c3_w1_bl
+ gf180mcu_3v3_12t_2r2w_sram_512x32_array_control_core_0/a_22600_42200# detronyx_12t_write_driver_rc1_9/wen
+ gf180mcu_3v3_12t_2r2w_sram_512x32_array_control_core_0/u_t014_023/c1_w0_bl detronyx_12t_write_driver_rc1_9/wen
+ detronyx_12t_write_driver_rc1_9/wen gf180mcu_3v3_12t_2r2w_sram_512x32_array_control_core_0/u_t005_024/c3_w0_bl
+ detronyx_12t_write_driver_rc1_9/wen gf180mcu_3v3_12t_2r2w_sram_512x32_array_control_core_0/u_t028_001/r1_w1_wl
+ detronyx_12t_write_driver_rc1_9/wen detronyx_12t_write_driver_rc1_9/wen detronyx_12t_write_driver_rc1_9/wen
+ detronyx_12t_write_driver_rc1_9/wen gf180mcu_3v3_12t_2r2w_sram_512x32_array_control_core_0/u_t018_002/r2_w1_wl
+ detronyx_12t_write_driver_rc1_9/wen gf180mcu_3v3_12t_2r2w_sram_512x32_array_control_core_0/u_t021_011/c1_w1_bl
+ gf180mcu_3v3_12t_2r2w_sram_512x32_array_control_core_0/u_t005_001/c1_w1_bl gf180mcu_3v3_12t_2r2w_sram_512x32_array_control_core_0/u_t026_009/c3_w1_bl
+ detronyx_12t_write_driver_rc1_9/wen detronyx_12t_write_driver_rc1_9/wen gf180mcu_3v3_12t_2r2w_sram_512x32_array_control_core_0/u_t017_017/c1_w1_bl
+ detronyx_12t_write_driver_rc1_9/wen detronyx_12t_write_driver_rc1_9/wen gf180mcu_3v3_12t_2r2w_sram_512x32_array_control_core_0/u_t006_002/r2_w1_wl
+ gf180mcu_3v3_12t_2r2w_sram_512x32_array_control_core_0/u_t009_018/c3_w1_bl gf180mcu_3v3_12t_2r2w_sram_512x32_array_control_core_0/u_t018_011/c1_w1_bl
+ gf180mcu_3v3_12t_2r2w_sram_512x32_array_control_core_0/u_t023_022/c3_w1_bl gf180mcu_3v3_12t_2r2w_sram_512x32_array_control_core_0/u_t013_025/c1_w0_bl
+ detronyx_12t_write_driver_rc1_9/wen detronyx_12t_write_driver_rc1_9/wen detronyx_12t_write_driver_rc1_9/wen
+ detronyx_12t_write_driver_rc1_9/wen gf180mcu_3v3_12t_2r2w_sram_512x32_array_control_core_0/a_200_98200#
+ gf180mcu_3v3_12t_2r2w_sram_512x32_array_control_core_0/u_t030_016/c1_w1_bl gf180mcu_3v3_12t_2r2w_sram_512x32_array_control_core_0/a_14200_75800#
+ gf180mcu_3v3_12t_2r2w_sram_512x32_array_control_core_0/u_t002_009/c1_w1_bl detronyx_12t_write_driver_rc1_9/wen
+ detronyx_12t_write_driver_rc1_9/wen detronyx_12t_write_driver_rc1_9/wen detronyx_12t_write_driver_rc1_9/wen
+ detronyx_12t_write_driver_rc1_9/wen detronyx_12t_write_driver_rc1_9/wen detronyx_12t_write_driver_rc1_9/wen
+ gf180mcu_3v3_12t_2r2w_sram_512x32_array_control_core_0/u_t004_003/c1_w1_bl detronyx_12t_write_driver_rc1_9/wen
+ detronyx_12t_write_driver_rc1_9/wen detronyx_12t_write_driver_rc1_9/wen gf180mcu_3v3_12t_2r2w_sram_512x32_array_control_core_0/u_t017_030/c3_w0_bl
+ detronyx_12t_write_driver_rc1_9/wen gf180mcu_3v3_12t_2r2w_sram_512x32_array_control_core_0/u_t002_003/VSS
+ gf180mcu_3v3_12t_2r2w_sram_512x32_array_control_core_0/u_t027_030/r2_w0_wl detronyx_12t_write_driver_rc1_9/wen
+ detronyx_12t_write_driver_rc1_9/wen gf180mcu_3v3_12t_2r2w_sram_512x32_array_control_core_0/u_t017_031/r3_w0_wl
+ detronyx_12t_write_driver_rc1_9/wen detronyx_12t_write_driver_rc1_9/wen detronyx_12t_write_driver_rc1_9/wen
+ detronyx_12t_write_driver_rc1_9/wen gf180mcu_3v3_12t_2r2w_sram_512x32_array_control_core_0/u_t027_018/c1_w1_bl
+ detronyx_12t_write_driver_rc1_9/wen detronyx_12t_write_driver_rc1_9/wen detronyx_12t_write_driver_rc1_9/wen
+ detronyx_12t_write_driver_rc1_9/wen gf180mcu_3v3_12t_2r2w_sram_512x32_array_control_core_0/u_t005_031/r3_w0_wl
+ detronyx_12t_write_driver_rc1_9/wen detronyx_12t_write_driver_rc1_9/wen gf180mcu_3v3_12t_2r2w_sram_512x32_array_control_core_0/u_t001_022/c3_w1_bl
+ detronyx_12t_write_driver_rc1_9/wen detronyx_12t_write_driver_rc1_9/wen detronyx_12t_write_driver_rc1_9/wen
+ detronyx_12t_write_driver_rc1_9/wen detronyx_12t_write_driver_rc1_9/wen gf180mcu_3v3_12t_2r2w_sram_512x32_array_control_core_0/u_t026_031/r3_w0_wl
+ detronyx_12t_write_driver_rc1_9/wen detronyx_12t_write_driver_rc1_9/wen detronyx_12t_write_driver_rc1_9/wen
+ detronyx_12t_write_driver_rc1_9/wen detronyx_12t_write_driver_rc1_9/wen detronyx_12t_write_driver_rc1_9/wen
+ gf180mcu_3v3_12t_2r2w_sram_512x32_array_control_core_0/a_17000_200# gf180mcu_3v3_12t_2r2w_sram_512x32_array_control_core_0/u_t023_007/c3_w1_bl
+ detronyx_12t_write_driver_rc1_9/wen gf180mcu_3v3_12t_2r2w_sram_512x32_array_control_core_0/u_t014_015/c1_w1_bl
+ gf180mcu_3v3_12t_2r2w_sram_512x32_array_control_core_0/u_t003_000/r1_w1_wl gf180mcu_3v3_12t_2r2w_sram_512x32_array_control_core_0/u_t004_016/c3_w1_bl
+ detronyx_12t_write_driver_rc1_9/wen gf180mcu_3v3_12t_2r2w_sram_512x32_array_control_core_0/u_t004_003/VDD
+ detronyx_12t_write_driver_rc1_9/wen detronyx_12t_write_driver_rc1_9/wen gf180mcu_3v3_12t_2r2w_sram_512x32_array_control_core_0/u_t005_010/c3_w1_bl
+ gf180mcu_3v3_12t_2r2w_sram_512x32_array_control_core_0/u_t025_002/r3_w1_wl detronyx_12t_write_driver_rc1_9/wen
+ detronyx_12t_write_driver_rc1_9/wen detronyx_12t_write_driver_rc1_9/wen detronyx_12t_write_driver_rc1_9/wen
+ gf180mcu_3v3_12t_2r2w_sram_512x32_array_control_core_0/u_t009_023/c1_w0_bl gf180mcu_3v3_12t_2r2w_sram_512x32_array_control_core_0/u_t013_002/r3_w1_wl
+ detronyx_12t_write_driver_rc1_9/wen detronyx_12t_write_driver_rc1_9/wen gf180mcu_3v3_12t_2r2w_sram_512x32_array_control_core_0/u_t000_001/c1_w1_bl
+ gf180mcu_3v3_12t_2r2w_sram_512x32_array_control_core_0/u_t021_009/c3_w1_bl gf180mcu_3v3_12t_2r2w_sram_512x32_array_control_core_0/u_t013_017/c1_w1_bl
+ detronyx_12t_write_driver_rc1_9/wen gf180mcu_3v3_12t_2r2w_sram_512x32_array_control_core_0/u_t030_025/c3_w0_bl
+ gf180mcu_3v3_12t_2r2w_sram_512x32_array_control_core_0/u_t002_018/c3_w1_bl detronyx_12t_write_driver_rc1_9/wen
+ detronyx_12t_write_driver_rc1_9/wen gf180mcu_3v3_12t_2r2w_sram_512x32_array_control_core_0/u_t013_011/c1_w1_bl
+ gf180mcu_3v3_12t_2r2w_sram_512x32_array_control_core_0/u_t030_008/c1_w1_bl detronyx_12t_write_driver_rc1_9/wen
+ detronyx_12t_write_driver_rc1_9/wen gf180mcu_3v3_12t_2r2w_sram_512x32_array_control_core_0/u_t019_009/c3_w1_bl
+ detronyx_12t_write_driver_rc1_9/wen detronyx_12t_write_driver_rc1_9/wen gf180mcu_3v3_12t_2r2w_sram_512x32_array_control_core_0/u_t026_016/c1_w1_bl
+ detronyx_12t_write_driver_rc1_9/wen gf180mcu_3v3_12t_2r2w_sram_512x32_array_control_core_0/a_22600_22600#
+ gf180mcu_3v3_12t_2r2w_sram_512x32_array_control_core_0/u_t021_003/r0_w1_wl detronyx_12t_write_driver_rc1_9/wen
+ gf180mcu_3v3_12t_2r2w_sram_512x32_array_control_core_0/u_t005_025/c1_w0_bl detronyx_12t_write_driver_rc1_9/wen
+ detronyx_12t_write_driver_rc1_9/wen gf180mcu_3v3_12t_2r2w_sram_512x32_array_control_core_0/u_t017_022/c3_w1_bl
+ detronyx_12t_write_driver_rc1_9/wen detronyx_12t_write_driver_rc1_9/wen detronyx_12t_write_driver_rc1_9/wen
+ detronyx_12t_write_driver_rc1_9/wen detronyx_12t_write_driver_rc1_9/wen gf180mcu_3v3_12t_2r2w_sram_512x32_array_control_core_0/u_t013_030/c3_w0_bl
+ detronyx_12t_write_driver_rc1_9/wen detronyx_12t_write_driver_rc1_9/wen detronyx_12t_write_driver_rc1_9/wen
+ detronyx_12t_write_driver_rc1_9/wen gf180mcu_3v3_12t_2r2w_sram_512x32_array_control_core_0/u_t004_018/VDD
+ detronyx_12t_write_driver_rc1_9/wen detronyx_12t_write_driver_rc1_9/wen gf180mcu_3v3_12t_2r2w_sram_512x32_array_control_core_0/u_t013_031/r3_w0_wl
+ detronyx_12t_write_driver_rc1_9/wen detronyx_12t_write_driver_rc1_9/wen detronyx_12t_write_driver_rc1_9/wen
+ detronyx_12t_write_driver_rc1_9/wen gf180mcu_3v3_12t_2r2w_sram_512x32_array_control_core_0/u_t009_030/c3_w0_bl
+ gf180mcu_3v3_12t_2r2w_sram_512x32_array_control_core_0/u_t022_018/c1_w1_bl detronyx_12t_write_driver_rc1_9/wen
+ gf180mcu_3v3_12t_2r2w_sram_512x32_array_control_core_0/u_t022_000/r3_w1_wl detronyx_12t_write_driver_rc1_9/wen
+ detronyx_12t_write_driver_rc1_9/wen detronyx_12t_write_driver_rc1_9/wen detronyx_12t_write_driver_rc1_9/wen
+ detronyx_12t_write_driver_rc1_9/wen detronyx_12t_write_driver_rc1_9/wen gf180mcu_3v3_12t_2r2w_sram_512x32_array_control_core_0/a_22600_106600#
+ gf180mcu_3v3_12t_2r2w_sram_512x32_array_control_core_0/a_200_78600# gf180mcu_3v3_12t_2r2w_sram_512x32_array_control_core_0/u_t009_030/r3_w0_wl
+ gf180mcu_3v3_12t_2r2w_sram_512x32_array_control_core_0/u_t010_000/r2_w1_wl detronyx_12t_write_driver_rc1_9/wen
+ detronyx_12t_write_driver_rc1_9/wen detronyx_12t_write_driver_rc1_9/wen detronyx_12t_write_driver_rc1_9/wen
+ gf180mcu_3v3_12t_2r2w_sram_512x32_array_control_core_0/u_t026_029/c3_w0_bl gf180mcu_3v3_12t_2r2w_sram_512x32_array_control_core_0/u_t026_023/c3_w1_bl
+ detronyx_12t_write_driver_rc1_9/wen gf180mcu_3v3_12t_2r2w_sram_512x32_array_control_core_0/u_t017_031/r3_w0_wl
+ detronyx_12t_write_driver_rc1_9/wen detronyx_12t_write_driver_rc1_9/wen detronyx_12t_write_driver_rc1_9/wen
+ detronyx_12t_write_driver_rc1_9/wen gf180mcu_3v3_12t_2r2w_sram_512x32_array_control_core_0/u_t016_007/c3_w1_bl
+ detronyx_12t_precharge_sense_rc1_52/ren gf180mcu_3v3_12t_2r2w_sram_512x32_array_control_core_0/u_t021_002/r0_w1_wl
+ gf180mcu_3v3_12t_2r2w_sram_512x32_array_control_core_0/u_t009_015/c1_w1_bl detronyx_12t_write_driver_rc1_9/wen
+ detronyx_12t_write_driver_rc1_9/wen gf180mcu_3v3_12t_2r2w_sram_512x32_array_control_core_0/u_t028_001/r1_w1_wl
+ gf180mcu_3v3_12t_2r2w_sram_512x32_array_control_core_0/u_t030_017/c3_w1_bl gf180mcu_3v3_12t_2r2w_sram_512x32_array_control_core_0/u_t002_023/c1_w0_bl
+ detronyx_12t_write_driver_rc1_9/wen detronyx_12t_write_driver_rc1_9/wen detronyx_12t_write_driver_rc1_9/wen
+ detronyx_12t_write_driver_rc1_9/wen detronyx_12t_write_driver_rc1_9/wen gf180mcu_3v3_12t_2r2w_sram_512x32_array_control_core_0/u_t016_001/r0_w1_wl
+ gf180mcu_3v3_12t_2r2w_sram_512x32_array_control_core_0/u_t026_025/c3_w0_bl detronyx_12t_write_driver_rc1_9/wen
+ gf180mcu_3v3_12t_2r2w_sram_512x32_array_control_core_0/u_t006_002/r2_w1_wl gf180mcu_3v3_12t_2r2w_sram_512x32_array_control_core_0/u_t025_008/c1_w1_bl
+ detronyx_12t_write_driver_rc1_9/wen gf180mcu_3v3_12t_2r2w_sram_512x32_array_control_core_0/u_t014_009/c3_w1_bl
+ detronyx_12t_write_driver_rc1_9/wen gf180mcu_3v3_12t_2r2w_sram_512x32_array_control_core_0/u_t005_017/c1_w1_bl
+ gf180mcu_3v3_12t_2r2w_sram_512x32_array_control_core_0/u_t025_002/c1_w1_bl detronyx_12t_write_driver_rc1_9/wen
+ gf180mcu_3v3_12t_2r2w_sram_512x32_array_control_core_0/u_t006_011/c1_w1_bl detronyx_12t_write_driver_rc1_9/wen
+ gf180mcu_3v3_12t_2r2w_sram_512x32_array_control_core_0/u_t013_022/c3_w1_bl detronyx_12t_write_driver_rc1_9/wen
+ detronyx_12t_write_driver_rc1_9/wen detronyx_12t_write_driver_rc1_9/wen gf180mcu_3v3_12t_2r2w_sram_512x32_array_control_core_0/u_t004_003/VDD
+ gf180mcu_3v3_12t_2r2w_sram_512x32_array_control_core_0/u_t017_016/c1_w1_bl detronyx_12t_write_driver_rc1_9/wen
+ detronyx_12t_write_driver_rc1_9/wen detronyx_12t_write_driver_rc1_9/wen gf180mcu_3v3_12t_2r2w_sram_512x32_array_control_core_0/u_t009_022/c3_w1_bl
+ detronyx_12t_write_driver_rc1_9/wen gf180mcu_3v3_12t_2r2w_sram_512x32_array_control_core_0/u_t027_030/r2_w0_wl
+ detronyx_12t_write_driver_rc1_9/wen detronyx_12t_write_driver_rc1_9/wen gf180mcu_3v3_12t_2r2w_sram_512x32_array_control_core_0/a_14200_84200#
+ detronyx_12t_write_driver_rc1_9/wen detronyx_12t_write_driver_rc1_9/wen detronyx_12t_write_driver_rc1_9/wen
+ detronyx_12t_write_driver_rc1_9/wen detronyx_12t_write_driver_rc1_9/wen gf180mcu_3v3_12t_2r2w_sram_512x32_array_control_core_0/u_t005_030/c3_w0_bl
+ gf180mcu_3v3_12t_2r2w_sram_512x32_array_control_core_0/u_t015_030/r2_w0_wl detronyx_12t_write_driver_rc1_9/wen
+ detronyx_12t_write_driver_rc1_9/wen detronyx_12t_write_driver_rc1_9/wen detronyx_12t_write_driver_rc1_9/wen
+ detronyx_12t_write_driver_rc1_9/wen gf180mcu_3v3_12t_2r2w_sram_512x32_array_control_core_0/u_t005_031/r3_w0_wl
+ detronyx_12t_write_driver_rc1_9/wen detronyx_12t_write_driver_rc1_9/wen gf180mcu_3v3_12t_2r2w_sram_512x32_array_control_core_0/u_t003_030/r1_w0_wl
+ gf180mcu_3v3_12t_2r2w_sram_512x32_array_control_core_0/u_t015_018/c1_w1_bl gf180mcu_3v3_12t_2r2w_sram_512x32_array_control_core_0/u_t026_015/c3_w1_bl
+ detronyx_12t_write_driver_rc1_9/wen gf180mcu_3v3_12t_2r2w_sram_512x32_array_control_core_0/u_t021_029/c3_w0_bl
+ detronyx_12t_write_driver_rc1_9/wen detronyx_12t_write_driver_rc1_9/wen detronyx_12t_write_driver_rc1_9/wen
+ detronyx_12t_write_driver_rc1_9/wen detronyx_12t_write_driver_rc1_9/wen detronyx_12t_write_driver_rc1_9/wen
+ detronyx_12t_write_driver_rc1_9/wen gf180mcu_3v3_12t_2r2w_sram_512x32_array_control_core_0/u_t021_023/c3_w1_bl
+ gf180mcu_3v3_12t_2r2w_sram_512x32_array_control_core_0/u_t004_018/VDD gf180mcu_3v3_12t_2r2w_sram_512x32_array_control_core_0/u_t013_031/r3_w0_wl
+ detronyx_12t_write_driver_rc1_9/wen detronyx_12t_write_driver_rc1_9/wen detronyx_12t_write_driver_rc1_9/wen
+ gf180mcu_3v3_12t_2r2w_sram_512x32_array_control_core_0/u_t018_029/c3_w0_bl detronyx_12t_write_driver_rc1_9/wen
+ gf180mcu_3v3_12t_2r2w_sram_512x32_array_control_core_0/u_t030_022/c1_w0_bl detronyx_12t_write_driver_rc1_9/wen
+ gf180mcu_3v3_12t_2r2w_sram_512x32_array_control_core_0/u_t011_007/c3_w1_bl gf180mcu_3v3_12t_2r2w_sram_512x32_array_control_core_0/gf180mcu_as_sc_mcu7t3v3__inv_2_992/A
+ gf180mcu_3v3_12t_2r2w_sram_512x32_array_control_core_0/u_t002_015/c1_w1_bl detronyx_12t_write_driver_rc1_9/wen
+ gf180mcu_3v3_12t_2r2w_sram_512x32_array_control_core_0/u_t019_023/c3_w1_bl detronyx_12t_write_driver_rc1_9/wen
+ detronyx_12t_write_driver_rc1_9/wen gf180mcu_3v3_12t_2r2w_sram_512x32_array_control_core_0/u_t023_001/r2_w1_wl
+ detronyx_12t_write_driver_rc1_9/wen detronyx_12t_write_driver_rc1_9/wen detronyx_12t_write_driver_rc1_9/wen
+ gf180mcu_3v3_12t_2r2w_sram_512x32_array_control_core_0/u_t025_017/c3_w1_bl detronyx_12t_write_driver_rc1_9/wen
+ gf180mcu_3v3_12t_2r2w_sram_512x32_array_control_core_0/u_t009_007/c3_w1_bl gf180mcu_3v3_12t_2r2w_sram_512x32_array_control_core_0/u_t013_002/r3_w1_wl
+ detronyx_12t_write_driver_rc1_9/wen detronyx_12t_write_driver_rc1_9/wen detronyx_12t_write_driver_rc1_9/wen
+ detronyx_12t_write_driver_rc1_9/wen detronyx_12t_write_driver_rc1_9/wen gf180mcu_3v3_12t_2r2w_sram_512x32_array_control_core_0/u_t011_001/r1_w1_wl
+ detronyx_12t_write_driver_rc1_9/wen gf180mcu_3v3_12t_2r2w_sram_512x32_array_control_core_0/u_t001_002/r2_w1_wl
+ detronyx_12t_write_driver_rc1_9/wen gf180mcu_3v3_12t_2r2w_sram_512x32_array_control_core_0/u_t027_024/c1_w0_bl
+ gf180mcu_3v3_12t_2r2w_sram_512x32_array_control_core_0/u_t020_002/c1_w1_bl detronyx_12t_write_driver_rc1_9/wen
+ detronyx_12t_write_driver_rc1_9/wen gf180mcu_3v3_12t_2r2w_sram_512x32_array_control_core_0/u_t017_025/c3_w0_bl
+ detronyx_12t_write_driver_rc1_9/wen gf180mcu_3v3_12t_2r2w_sram_512x32_array_control_core_0/u_t017_008/c1_w1_bl
+ gf180mcu_3v3_12t_2r2w_sram_512x32_array_control_core_0/u_t001_011/c1_w1_bl detronyx_12t_write_driver_rc1_9/wen
+ detronyx_12t_write_driver_rc1_9/wen detronyx_12t_write_driver_rc1_9/wen detronyx_12t_write_driver_rc1_9/wen
+ gf180mcu_3v3_12t_2r2w_sram_512x32_array_control_core_0/u_t009_009/c3_w1_bl detronyx_12t_write_driver_rc1_9/wen
+ gf180mcu_3v3_12t_2r2w_sram_512x32_array_control_core_0/u_t018_002/c1_w1_bl gf180mcu_3v3_12t_2r2w_sram_512x32_array_control_core_0/u_t013_016/c1_w1_bl
+ detronyx_12t_write_driver_rc1_9/wen detronyx_12t_write_driver_rc1_9/wen detronyx_12t_write_driver_rc1_9/wen
+ gf180mcu_3v3_12t_2r2w_sram_512x32_array_control_core_0/u_t019_003/r1_w1_wl gf180mcu_3v3_12t_2r2w_sram_512x32_array_control_core_0/u_t005_022/c3_w1_bl
+ gf180mcu_3v3_12t_2r2w_sram_512x32_array_control_core_0/u_t022_030/r3_w0_wl detronyx_12t_write_driver_rc1_9/wen
+ gf180mcu_3v3_12t_2r2w_sram_512x32_array_control_core_0/a_22600_31000# detronyx_12t_write_driver_rc1_9/wen
+ detronyx_12t_write_driver_rc1_9/wen gf180mcu_3v3_12t_2r2w_sram_512x32_array_control_core_0/u_t026_026/c1_w0_bl
+ detronyx_12t_write_driver_rc1_9/wen detronyx_12t_write_driver_rc1_9/wen detronyx_12t_write_driver_rc1_9/wen
+ gf180mcu_3v3_12t_2r2w_sram_512x32_array_control_core_0/u_t007_003/r1_w1_wl detronyx_12t_write_driver_rc1_9/wen
+ detronyx_12t_write_driver_rc1_9/wen detronyx_12t_write_driver_rc1_9/wen detronyx_12t_write_driver_rc1_9/wen
+ gf180mcu_3v3_12t_2r2w_sram_512x32_array_control_core_0/u_t010_030/r2_w0_wl detronyx_12t_write_driver_rc1_9/wen
+ detronyx_12t_write_driver_rc1_9/wen detronyx_12t_write_driver_rc1_9/wen detronyx_12t_write_driver_rc1_9/wen
+ detronyx_12t_write_driver_rc1_9/wen detronyx_12t_write_driver_rc1_9/wen detronyx_12t_write_driver_rc1_9/wen
+ detronyx_12t_write_driver_rc1_9/wen detronyx_12t_write_driver_rc1_9/wen detronyx_12t_write_driver_rc1_9/wen
+ gf180mcu_3v3_12t_2r2w_sram_512x32_array_control_core_0/u_t010_018/c1_w1_bl gf180mcu_3v3_12t_2r2w_sram_512x32_array_control_core_0/u_t021_015/c3_w1_bl
+ gf180mcu_3v3_12t_2r2w_sram_512x32_array_control_core_0/u_t030_031/r3_w0_wl detronyx_12t_write_driver_rc1_9/wen
+ gf180mcu_3v3_12t_2r2w_sram_512x32_array_control_core_0/u_t030_031/r3_w0_wl detronyx_12t_write_driver_rc1_9/wen
+ detronyx_12t_write_driver_rc1_9/wen detronyx_12t_write_driver_rc1_9/wen detronyx_12t_write_driver_rc1_9/wen
+ detronyx_12t_write_driver_rc1_9/wen detronyx_12t_write_driver_rc1_9/wen detronyx_12t_write_driver_rc1_9/wen
+ gf180mcu_3v3_12t_2r2w_sram_512x32_array_control_core_0/u_t019_015/c3_w1_bl gf180mcu_3v3_12t_2r2w_sram_512x32_array_control_core_0/u_t009_018/c1_w1_bl
+ detronyx_12t_write_driver_rc1_9/wen gf180mcu_3v3_12t_2r2w_sram_512x32_array_control_core_0/u_t013_029/c3_w0_bl
+ gf180mcu_3v3_12t_2r2w_sram_512x32_array_control_core_0/u_t030_031/r3_w0_wl gf180mcu_3v3_12t_2r2w_sram_512x32_array_control_core_0/u_t008_000/r3_w1_wl
+ gf180mcu_3v3_12t_2r2w_sram_512x32_array_control_core_0/a_200_87000# gf180mcu_3v3_12t_2r2w_sram_512x32_array_control_core_0/a_22600_115000#
+ gf180mcu_3v3_12t_2r2w_sram_512x32_array_control_core_0/u_t030_001/r3_w1_wl detronyx_12t_write_driver_rc1_9/wen
+ gf180mcu_3v3_12t_2r2w_sram_512x32_array_control_core_0/u_t026_022/c1_w0_bl detronyx_12t_write_driver_rc1_9/wen
+ gf180mcu_3v3_12t_2r2w_sram_512x32_array_control_core_0/a_14200_64600# gf180mcu_3v3_12t_2r2w_sram_512x32_array_control_core_0/u_t014_023/c3_w1_bl
+ detronyx_12t_write_driver_rc1_9/wen gf180mcu_3v3_12t_2r2w_sram_512x32_array_control_core_0/u_t005_031/r3_w0_wl
+ detronyx_12t_write_driver_rc1_9/wen detronyx_12t_write_driver_rc1_9/wen gf180mcu_3v3_12t_2r2w_sram_512x32_array_control_core_0/u_t004_007/c3_w1_bl
+ gf180mcu_3v3_12t_2r2w_sram_512x32_array_control_core_0/u_t030_010/c1_w1_bl detronyx_12t_write_driver_rc1_9/wen
+ detronyx_12t_write_driver_rc1_9/wen detronyx_12t_write_driver_rc1_9/wen detronyx_12t_write_driver_rc1_9/wen
+ detronyx_12t_write_driver_rc1_9/wen gf180mcu_3v3_12t_2r2w_sram_512x32_array_control_core_0/u_t027_016/c1_w1_bl
+ detronyx_12t_write_driver_rc1_9/wen detronyx_12t_write_driver_rc1_9/wen gf180mcu_3v3_12t_2r2w_sram_512x32_array_control_core_0/u_t017_017/c3_w1_bl
+ detronyx_12t_write_driver_rc1_9/wen gf180mcu_3v3_12t_2r2w_sram_512x32_array_control_core_0/u_t030_010/c1_w1_bl
+ gf180mcu_3v3_12t_2r2w_sram_512x32_array_control_core_0/u_t022_024/c1_w0_bl detronyx_12t_write_driver_rc1_9/wen
+ detronyx_12t_write_driver_rc1_9/wen gf180mcu_3v3_12t_2r2w_sram_512x32_array_control_core_0/u_t004_001/r0_w1_wl
+ gf180mcu_3v3_12t_2r2w_sram_512x32_array_control_core_0/u_t013_025/c3_w0_bl detronyx_12t_write_driver_rc1_9/wen
+ gf180mcu_3v3_12t_2r2w_sram_512x32_array_control_core_0/u_t013_008/c1_w1_bl detronyx_12t_write_driver_rc1_9/wen
+ gf180mcu_3v3_12t_2r2w_sram_512x32_array_control_core_0/u_t026_003/r3_w1_wl gf180mcu_3v3_12t_2r2w_sram_512x32_array_control_core_0/u_t002_009/c3_w1_bl
+ detronyx_12t_write_driver_rc1_9/wen detronyx_12t_write_driver_rc1_9/wen detronyx_12t_write_driver_rc1_9/wen
+ gf180mcu_3v3_12t_2r2w_sram_512x32_array_control_core_0/u_t013_002/c1_w1_bl gf180mcu_3v3_12t_2r2w_sram_512x32_array_control_core_0/gf180mcu_as_sc_mcu7t3v3__inv_2_2/A
+ detronyx_12t_write_driver_rc1_9/wen detronyx_12t_write_driver_rc1_9/wen gf180mcu_3v3_12t_2r2w_sram_512x32_array_control_core_0/u_t026_018/c1_w1_bl
+ detronyx_12t_write_driver_rc1_9/wen detronyx_12t_write_driver_rc1_9/wen gf180mcu_3v3_12t_2r2w_sram_512x32_array_control_core_0/u_t014_003/r2_w1_wl
+ detronyx_12t_write_driver_rc1_9/wen detronyx_12t_write_driver_rc1_9/wen detronyx_12t_write_driver_rc1_9/wen
+ detronyx_12t_write_driver_rc1_9/wen detronyx_12t_write_driver_rc1_9/wen detronyx_12t_write_driver_rc1_9/wen
+ detronyx_12t_write_driver_rc1_9/wen gf180mcu_3v3_12t_2r2w_sram_512x32_array_control_core_0/u_t021_026/c1_w0_bl
+ gf180mcu_3v3_12t_2r2w_sram_512x32_array_control_core_0/u_t002_003/VSS detronyx_12t_write_driver_rc1_9/wen
+ gf180mcu_3v3_12t_2r2w_sram_512x32_array_control_core_0/u_t005_016/c1_w1_bl detronyx_12t_write_driver_rc1_9/wen
+ detronyx_12t_write_driver_rc1_9/wen detronyx_12t_write_driver_rc1_9/wen detronyx_12t_write_driver_rc1_9/wen
+ gf180mcu_3v3_12t_2r2w_sram_512x32_array_control_core_0/u_t015_030/r2_w0_wl detronyx_12t_write_driver_rc1_9/wen
+ detronyx_12t_write_driver_rc1_9/wen detronyx_12t_write_driver_rc1_9/wen gf180mcu_3v3_12t_2r2w_sram_512x32_array_control_core_0/u_t018_026/c1_w0_bl
+ detronyx_12t_write_driver_rc1_9/wen gf180mcu_3v3_12t_2r2w_sram_512x32_array_control_core_0/u_t030_023/c3_w1_bl
+ detronyx_12t_write_driver_rc1_9/wen detronyx_12t_write_driver_rc1_9/wen detronyx_12t_write_driver_rc1_9/wen
+ detronyx_12t_write_driver_rc1_9/wen gf180mcu_3v3_12t_2r2w_sram_512x32_array_control_core_0/u_t003_030/r1_w0_wl
+ detronyx_12t_write_driver_rc1_9/wen detronyx_12t_write_driver_rc1_9/wen detronyx_12t_write_driver_rc1_9/wen
+ detronyx_12t_write_driver_rc1_9/wen gf180mcu_3v3_12t_2r2w_sram_512x32_array_control_core_0/u_t026_031/r3_w0_wl
+ detronyx_12t_write_driver_rc1_9/wen detronyx_12t_write_driver_rc1_9/wen detronyx_12t_write_driver_rc1_9/wen
+ detronyx_12t_write_driver_rc1_9/wen detronyx_12t_write_driver_rc1_9/wen detronyx_12t_write_driver_rc1_9/wen
+ detronyx_12t_write_driver_rc1_9/wen detronyx_12t_write_driver_rc1_9/wen detronyx_12t_write_driver_rc1_9/wen
+ gf180mcu_3v3_12t_2r2w_sram_512x32_array_control_core_0/u_t005_018/c1_w1_bl gf180mcu_3v3_12t_2r2w_sram_512x32_array_control_core_0/u_t014_015/c3_w1_bl
+ detronyx_12t_write_driver_rc1_9/wen gf180mcu_3v3_12t_2r2w_sram_512x32_array_control_core_0/u_t004_000/r0_w1_wl
+ gf180mcu_3v3_12t_2r2w_sram_512x32_array_control_core_0/a_22600_11400# detronyx_12t_write_driver_rc1_9/wen
+ gf180mcu_3v3_12t_2r2w_sram_512x32_array_control_core_0/u_t002_018/VSS detronyx_12t_write_driver_rc1_9/wen
+ gf180mcu_3v3_12t_2r2w_sram_512x32_array_control_core_0/a_25400_200# detronyx_12t_write_driver_rc1_9/wen
+ detronyx_12t_write_driver_rc1_9/wen detronyx_12t_write_driver_rc1_9/wen detronyx_12t_write_driver_rc1_9/wen
+ gf180mcu_3v3_12t_2r2w_sram_512x32_array_control_core_0/u_t006_029/c3_w0_bl detronyx_12t_write_driver_rc1_9/wen
+ gf180mcu_3v3_12t_2r2w_sram_512x32_array_control_core_0/u_t017_022/c1_w0_bl gf180mcu_3v3_12t_2r2w_sram_512x32_array_control_core_0/u_t023_001/r2_w1_wl
+ detronyx_12t_write_driver_rc1_9/wen detronyx_12t_write_driver_rc1_9/wen gf180mcu_3v3_12t_2r2w_sram_512x32_array_control_core_0/u_t009_023/c3_w1_bl
+ detronyx_12t_write_driver_rc1_9/wen gf180mcu_3v3_12t_2r2w_sram_512x32_array_control_core_0/u_t022_016/c1_w1_bl
+ gf180mcu_3v3_12t_2r2w_sram_512x32_array_control_core_0/u_t011_001/r1_w1_wl detronyx_12t_write_driver_rc1_9/wen
+ detronyx_12t_write_driver_rc1_9/wen detronyx_12t_write_driver_rc1_9/wen gf180mcu_3v3_12t_2r2w_sram_512x32_array_control_core_0/u_t013_017/c3_w1_bl
+ gf180mcu_3v3_12t_2r2w_sram_512x32_array_control_core_0/u_t023_010/c1_w1_bl detronyx_12t_write_driver_rc1_9/wen
+ gf180mcu_3v3_12t_2r2w_sram_512x32_array_control_core_0/u_t030_008/c3_w1_bl detronyx_12t_write_driver_rc1_9/wen
+ detronyx_12t_write_driver_rc1_9/wen detronyx_12t_write_driver_rc1_9/wen detronyx_12t_write_driver_rc1_9/wen
+ gf180mcu_3v3_12t_2r2w_sram_512x32_array_control_core_0/a_200_67400# gf180mcu_3v3_12t_2r2w_sram_512x32_array_control_core_0/u_t021_003/r3_w1_wl
+ gf180mcu_3v3_12t_2r2w_sram_512x32_array_control_core_0/u_t015_024/c1_w0_bl detronyx_12t_write_driver_rc1_9/wen
+ gf180mcu_3v3_12t_2r2w_sram_512x32_array_control_core_0/a_200_103800# detronyx_12t_write_driver_rc1_9/wen
+ gf180mcu_3v3_12t_2r2w_sram_512x32_array_control_core_0/u_t005_025/c3_w0_bl gf180mcu_3v3_12t_2r2w_sram_512x32_array_control_core_0/u_t021_018/c1_w1_bl
+ gf180mcu_3v3_12t_2r2w_sram_512x32_array_control_core_0/u_t029_002/r0_w1_wl gf180mcu_3v3_12t_2r2w_sram_512x32_array_control_core_0/u_t005_008/c1_w1_bl
+ detronyx_12t_write_driver_rc1_9/wen detronyx_12t_write_driver_rc1_9/wen detronyx_12t_write_driver_rc1_9/wen
+ gf180mcu_3v3_12t_2r2w_sram_512x32_array_control_core_0/u_t006_002/c1_w1_bl gf180mcu_3v3_12t_2r2w_sram_512x32_array_control_core_0/u_t022_030/r3_w0_wl
+ detronyx_12t_write_driver_rc1_9/wen detronyx_12t_write_driver_rc1_9/wen detronyx_12t_write_driver_rc1_9/wen
+ gf180mcu_3v3_12t_2r2w_sram_512x32_array_control_core_0/u_t018_018/c1_w1_bl gf180mcu_3v3_12t_2r2w_sram_512x32_array_control_core_0/a_19800_200#
+ detronyx_12t_write_driver_rc1_9/wen gf180mcu_3v3_12t_2r2w_sram_512x32_array_control_core_0/u_t007_003/r1_w1_wl
+ detronyx_12t_write_driver_rc1_9/wen detronyx_12t_write_driver_rc1_9/wen gf180mcu_3v3_12t_2r2w_sram_512x32_array_control_core_0/u_t010_030/r2_w0_wl
+ detronyx_12t_write_driver_rc1_9/wen detronyx_12t_write_driver_rc1_9/wen gf180mcu_3v3_12t_2r2w_sram_512x32_array_control_core_0/u_t013_026/c1_w0_bl
+ gf180mcu_3v3_12t_2r2w_sram_512x32_array_control_core_0/u_t026_023/c3_w1_bl detronyx_12t_write_driver_rc1_9/wen
+ detronyx_12t_write_driver_rc1_9/wen detronyx_12t_write_driver_rc1_9/wen detronyx_12t_write_driver_rc1_9/wen
+ detronyx_12t_write_driver_rc1_9/wen detronyx_12t_write_driver_rc1_9/wen detronyx_12t_write_driver_rc1_9/wen
+ detronyx_12t_write_driver_rc1_9/wen detronyx_12t_write_driver_rc1_9/wen detronyx_12t_write_driver_rc1_9/wen
+ detronyx_12t_write_driver_rc1_9/wen detronyx_12t_write_driver_rc1_9/wen detronyx_12t_write_driver_rc1_9/wen
+ detronyx_12t_write_driver_rc1_9/wen detronyx_12t_write_driver_rc1_9/wen detronyx_12t_write_driver_rc1_9/wen
+ gf180mcu_3v3_12t_2r2w_sram_512x32_array_control_core_0/u_t027_030/r2_w0_wl gf180mcu_3v3_12t_2r2w_sram_512x32_array_control_core_0/u_t017_031/r3_w0_wl
+ detronyx_12t_write_driver_rc1_9/wen detronyx_12t_write_driver_rc1_9/wen gf180mcu_3v3_12t_2r2w_sram_512x32_array_control_core_0/u_t030_031/r3_w0_wl
+ detronyx_12t_write_driver_rc1_9/wen detronyx_12t_write_driver_rc1_9/wen gf180mcu_3v3_12t_2r2w_sram_512x32_array_control_core_0/u_t030_001/r3_w1_wl
+ detronyx_12t_write_driver_rc1_9/wen detronyx_12t_write_driver_rc1_9/wen detronyx_12t_write_driver_rc1_9/wen
+ detronyx_12t_write_driver_rc1_9/wen gf180mcu_3v3_12t_2r2w_sram_512x32_array_control_core_0/u_t009_015/c3_w1_bl
+ gf180mcu_3v3_12t_2r2w_sram_512x32_array_control_core_0/u_t001_029/c3_w0_bl gf180mcu_3v3_12t_2r2w_sram_512x32_array_control_core_0/u_t017_031/r3_w0_wl
+ detronyx_12t_write_driver_rc1_9/wen detronyx_12t_write_driver_rc1_9/wen detronyx_12t_write_driver_rc1_9/wen
+ gf180mcu_3v3_12t_2r2w_sram_512x32_array_control_core_0/u_t013_022/c1_w0_bl detronyx_12t_write_driver_rc1_9/wen
+ gf180mcu_3v3_12t_2r2w_sram_512x32_array_control_core_0/u_t002_023/c3_w1_bl detronyx_12t_write_driver_rc1_9/wen
+ detronyx_12t_write_driver_rc1_9/wen detronyx_12t_write_driver_rc1_9/wen gf180mcu_3v3_12t_2r2w_sram_512x32_array_control_core_0/a_14200_73000#
+ detronyx_12t_write_driver_rc1_9/wen detronyx_12t_write_driver_rc1_9/wen detronyx_12t_write_driver_rc1_9/wen
+ detronyx_12t_write_driver_rc1_9/wen gf180mcu_3v3_12t_2r2w_sram_512x32_array_control_core_0/u_t025_008/c3_w1_bl
+ gf180mcu_3v3_12t_2r2w_sram_512x32_array_control_core_0/u_t015_016/c1_w1_bl detronyx_12t_write_driver_rc1_9/wen
+ gf180mcu_3v3_12t_2r2w_sram_512x32_array_control_core_0/u_t005_017/c3_w1_bl gf180mcu_3v3_12t_2r2w_sram_512x32_array_control_core_0/u_t017_010/c1_w1_bl
+ gf180mcu_3v3_12t_2r2w_sram_512x32_array_control_core_0/u_t010_024/c1_w0_bl detronyx_12t_write_driver_rc1_9/wen
+ detronyx_12t_write_driver_rc1_9/wen gf180mcu_3v3_12t_2r2w_sram_512x32_array_control_core_0/u_t026_003/r3_w1_wl
+ detronyx_12t_write_driver_rc1_9/wen detronyx_12t_precharge_sense_rc1_34/ren gf180mcu_3v3_12t_2r2w_sram_512x32_array_control_core_0/u_t027_015/c1_w1_bl
+ gf180mcu_3v3_12t_2r2w_sram_512x32_array_control_core_0/u_t024_002/r1_w1_wl detronyx_12t_write_driver_rc1_9/wen
+ gf180mcu_3v3_12t_2r2w_sram_512x32_array_control_core_0/u_t014_003/r2_w1_wl gf180mcu_3v3_12t_2r2w_sram_512x32_array_control_core_0/u_t009_024/c1_w0_bl
+ detronyx_12t_write_driver_rc1_9/wen detronyx_12t_write_driver_rc1_9/wen gf180mcu_3v3_12t_2r2w_sram_512x32_array_control_core_0/u_t001_002/c1_w1_bl
+ gf180mcu_3v3_12t_2r2w_sram_512x32_array_control_core_0/u_t013_018/c1_w1_bl gf180mcu_3v3_12t_2r2w_sram_512x32_array_control_core_0/u_t002_003/r2_w1_wl
+ gf180mcu_3v3_12t_2r2w_sram_512x32_array_control_core_0/gf180mcu_as_sc_mcu7t3v3__inv_2_1685/Y
+ detronyx_12t_write_driver_rc1_9/wen detronyx_12t_write_driver_rc1_9/wen detronyx_12t_write_driver_rc1_9/wen
+ detronyx_12t_write_driver_rc1_9/wen detronyx_12t_write_driver_rc1_9/wen detronyx_12t_write_driver_rc1_9/wen
+ gf180mcu_3v3_12t_2r2w_sram_512x32_array_control_core_0/a_200_47800# gf180mcu_3v3_12t_2r2w_sram_512x32_array_control_core_0/u_t026_017/c1_w1_bl
+ detronyx_12t_write_driver_rc1_9/wen detronyx_12t_write_driver_rc1_9/wen detronyx_12t_write_driver_rc1_9/wen
+ detronyx_12t_write_driver_rc1_9/wen detronyx_12t_write_driver_rc1_9/wen gf180mcu_3v3_12t_2r2w_sram_512x32_array_control_core_0/u_t006_026/c1_w0_bl
+ detronyx_12t_write_driver_rc1_9/wen detronyx_12t_write_driver_rc1_9/wen gf180mcu_3v3_12t_2r2w_sram_512x32_array_control_core_0/u_t017_023/c3_w1_bl
+ detronyx_12t_write_driver_rc1_9/wen detronyx_12t_write_driver_rc1_9/wen detronyx_12t_write_driver_rc1_9/wen
+ gf180mcu_3v3_12t_2r2w_sram_512x32_array_control_core_0/u_t022_030/r3_w0_wl detronyx_12t_write_driver_rc1_9/wen
+ detronyx_12t_write_driver_rc1_9/wen detronyx_12t_write_driver_rc1_9/wen detronyx_12t_write_driver_rc1_9/wen
+ gf180mcu_3v3_12t_2r2w_sram_512x32_array_control_core_0/u_t013_031/r3_w0_wl detronyx_12t_write_driver_rc1_9/wen
+ detronyx_12t_write_driver_rc1_9/wen gf180mcu_3v3_12t_2r2w_sram_512x32_array_control_core_0/u_t023_031/r2_w0_wl
+ detronyx_12t_write_driver_rc1_9/wen detronyx_12t_write_driver_rc1_9/wen detronyx_12t_write_driver_rc1_9/wen
+ detronyx_12t_write_driver_rc1_9/wen gf180mcu_3v3_12t_2r2w_sram_512x32_array_control_core_0/u_t030_022/c3_w1_bl
+ detronyx_12t_write_driver_rc1_9/wen gf180mcu_3v3_12t_2r2w_sram_512x32_array_control_core_0/u_t002_015/c3_w1_bl
+ detronyx_12t_write_driver_rc1_9/wen detronyx_12t_write_driver_rc1_9/wen detronyx_12t_write_driver_rc1_9/wen
+ gf180mcu_3v3_12t_2r2w_sram_512x32_array_control_core_0/u_t013_031/r3_w0_wl detronyx_12t_write_driver_rc1_9/wen
+ detronyx_12t_write_driver_rc1_9/wen detronyx_12t_write_driver_rc1_9/wen detronyx_12t_write_driver_rc1_9/wen
+ detronyx_12t_write_driver_rc1_9/wen detronyx_12t_write_driver_rc1_9/wen gf180mcu_3v3_12t_2r2w_sram_512x32_array_control_core_0/u_t021_000/r0_w1_wl
+ gf180mcu_3v3_12t_2r2w_sram_512x32_array_control_core_0/u_t009_031/r3_w0_wl detronyx_12t_write_driver_rc1_9/wen
+ gf180mcu_3v3_12t_2r2w_sram_512x32_array_control_core_0/u_t005_022/c1_w0_bl detronyx_12t_write_driver_rc1_9/wen
+ detronyx_12t_write_driver_rc1_9/wen detronyx_12t_write_driver_rc1_9/wen detronyx_12t_write_driver_rc1_9/wen
+ gf180mcu_3v3_12t_2r2w_sram_512x32_array_control_core_0/u_t010_016/c1_w1_bl gf180mcu_3v3_12t_2r2w_sram_512x32_array_control_core_0/u_t030_001/c1_w1_bl
+ detronyx_12t_write_driver_rc1_9/wen gf180mcu_3v3_12t_2r2w_sram_512x32_array_control_core_0/u_t027_024/c3_w0_bl
+ detronyx_12t_precharge_sense_rc1_5/ren gf180mcu_3v3_12t_2r2w_sram_512x32_array_control_core_0/u_t009_001/r3_w1_wl
+ detronyx_12t_write_driver_rc1_9/wen gf180mcu_3v3_12t_2r2w_sram_512x32_array_control_core_0/u_t013_010/c1_w1_bl
+ detronyx_12t_write_driver_rc1_9/wen detronyx_12t_write_driver_rc1_9/wen detronyx_12t_write_driver_rc1_9/wen
+ detronyx_12t_write_driver_rc1_9/wen gf180mcu_3v3_12t_2r2w_sram_512x32_array_control_core_0/u_t017_008/c3_w1_bl
+ gf180mcu_3v3_12t_2r2w_sram_512x32_array_control_core_0/u_t021_003/r3_w1_wl detronyx_12t_write_driver_rc1_9/wen
+ gf180mcu_3v3_12t_2r2w_sram_512x32_array_control_core_0/u_t028_001/c1_w1_bl gf180mcu_3v3_12t_2r2w_sram_512x32_array_control_core_0/u_t009_016/c1_w1_bl
+ gf180mcu_3v3_12t_2r2w_sram_512x32_array_control_core_0/u_t022_015/c1_w1_bl detronyx_12t_write_driver_rc1_9/wen
+ detronyx_12t_write_driver_rc1_9/wen gf180mcu_3v3_12t_2r2w_sram_512x32_array_control_core_0/u_t009_010/c1_w1_bl
+ gf180mcu_3v3_12t_2r2w_sram_512x32_array_control_core_0/u_t005_024/c1_w0_bl detronyx_12t_write_driver_rc1_9/wen
+ gf180mcu_3v3_12t_2r2w_sram_512x32_array_control_core_0/a_14200_53400# detronyx_12t_write_driver_rc1_9/wen
+ gf180mcu_3v3_12t_2r2w_sram_512x32_array_control_core_0/u_t017_002/r0_w1_wl detronyx_12t_write_driver_rc1_9/wen
+ detronyx_12t_write_driver_rc1_9/wen detronyx_12t_write_driver_rc1_9/wen gf180mcu_3v3_12t_2r2w_sram_512x32_array_control_core_0/a_200_112200#
+ gf180mcu_3v3_12t_2r2w_sram_512x32_array_control_core_0/a_22600_59000# detronyx_12t_write_driver_rc1_9/wen
+ gf180mcu_3v3_12t_2r2w_sram_512x32_array_control_core_0/u_t025_009/c1_w1_bl detronyx_12t_write_driver_rc1_9/wen
+ detronyx_12t_write_driver_rc1_9/wen detronyx_12t_write_driver_rc1_9/wen detronyx_12t_write_driver_rc1_9/wen
+ detronyx_12t_write_driver_rc1_9/wen gf180mcu_3v3_12t_2r2w_sram_512x32_array_control_core_0/u_t006_018/c1_w1_bl
+ gf180mcu_3v3_12t_2r2w_sram_512x32_array_control_core_0/u_t026_003/c1_w1_bl gf180mcu_3v3_12t_2r2w_sram_512x32_array_control_core_0/u_t021_017/c1_w1_bl
+ detronyx_12t_write_driver_rc1_9/wen detronyx_12t_write_driver_rc1_9/wen detronyx_12t_write_driver_rc1_9/wen
+ detronyx_12t_write_driver_rc1_9/wen gf180mcu_3v3_12t_2r2w_sram_512x32_array_control_core_0/u_t001_026/c1_w0_bl
+ gf180mcu_3v3_12t_2r2w_sram_512x32_array_control_core_0/u_t013_023/c3_w1_bl gf180mcu_3v3_12t_2r2w_sram_512x32_array_control_core_0/u_t009_030/r3_w0_wl
+ gf180mcu_3v3_12t_2r2w_sram_512x32_array_control_core_0/u_t030_031/r3_w0_wl detronyx_12t_write_driver_rc1_9/wen
+ detronyx_12t_write_driver_rc1_9/wen detronyx_12t_write_driver_rc1_9/wen gf180mcu_3v3_12t_2r2w_sram_512x32_array_control_core_0/u_t018_017/c1_w1_bl
+ detronyx_12t_write_driver_rc1_9/wen detronyx_12t_write_driver_rc1_9/wen detronyx_12t_write_driver_rc1_9/wen
+ detronyx_12t_write_driver_rc1_9/wen detronyx_12t_write_driver_rc1_9/wen detronyx_12t_write_driver_rc1_9/wen
+ detronyx_12t_write_driver_rc1_9/wen detronyx_12t_write_driver_rc1_9/wen detronyx_12t_write_driver_rc1_9/wen
+ detronyx_12t_write_driver_rc1_9/wen detronyx_12t_write_driver_rc1_9/wen detronyx_12t_write_driver_rc1_9/wen
+ gf180mcu_3v3_12t_2r2w_sram_512x32_array_control_core_0/u_t026_022/c3_w1_bl gf180mcu_3v3_12t_2r2w_sram_512x32_array_control_core_0/u_t015_030/r2_w0_wl
+ detronyx_12t_write_driver_rc1_9/wen detronyx_12t_write_driver_rc1_9/wen gf180mcu_3v3_12t_2r2w_sram_512x32_array_control_core_0/u_t005_031/r3_w0_wl
+ gf180mcu_3v3_12t_2r2w_sram_512x32_array_control_core_0/u_t017_031/r3_w0_wl detronyx_12t_write_driver_rc1_9/wen
+ detronyx_12t_write_driver_rc1_9/wen detronyx_12t_write_driver_rc1_9/wen gf180mcu_3v3_12t_2r2w_sram_512x32_array_control_core_0/u_t030_010/c3_w1_bl
+ detronyx_12t_write_driver_rc1_9/wen detronyx_12t_write_driver_rc1_9/wen detronyx_12t_write_driver_rc1_9/wen
+ gf180mcu_3v3_12t_2r2w_sram_512x32_array_control_core_0/u_t005_031/r3_w0_wl detronyx_12t_write_driver_rc1_9/wen
+ detronyx_12t_write_driver_rc1_9/wen gf180mcu_3v3_12t_2r2w_sram_512x32_array_control_core_0/u_t027_016/c3_w1_bl
+ detronyx_12t_write_driver_rc1_9/wen gf180mcu_3v3_12t_2r2w_sram_512x32_array_control_core_0/u_t017_001/r0_w1_wl
+ gf180mcu_3v3_12t_2r2w_sram_512x32_array_control_core_0/u_t004_003/VDD detronyx_12t_write_driver_rc1_9/wen
+ detronyx_12t_write_driver_rc1_9/wen gf180mcu_3v3_12t_2r2w_sram_512x32_array_control_core_0/u_t030_010/c3_w1_bl
+ detronyx_12t_write_driver_rc1_9/wen gf180mcu_3v3_12t_2r2w_sram_512x32_array_control_core_0/u_t022_024/c3_w0_bl
+ detronyx_12t_write_driver_rc1_9/wen detronyx_12t_write_driver_rc1_9/wen detronyx_12t_write_driver_rc1_9/wen
+ detronyx_12t_write_driver_rc1_9/wen detronyx_12t_write_driver_rc1_9/wen gf180mcu_3v3_12t_2r2w_sram_512x32_array_control_core_0/u_t013_008/c3_w1_bl
+ detronyx_12t_write_driver_rc1_9/wen gf180mcu_3v3_12t_2r2w_sram_512x32_array_control_core_0/u_t023_001/c1_w1_bl
+ gf180mcu_3v3_12t_2r2w_sram_512x32_array_control_core_0/u_t005_016/c1_w1_bl detronyx_12t_write_driver_rc1_9/wen
+ gf180mcu_3v3_12t_2r2w_sram_512x32_array_control_core_0/u_t024_002/r1_w1_wl gf180mcu_3v3_12t_2r2w_sram_512x32_array_control_core_0/u_t004_010/c1_w1_bl
+ detronyx_12t_write_driver_rc1_9/wen detronyx_12t_write_driver_rc1_9/wen gf180mcu_3v3_12t_2r2w_sram_512x32_array_control_core_0/u_t025_018/c3_w1_bl
+ gf180mcu_3v3_12t_2r2w_sram_512x32_array_control_core_0/u_t030_025/c1_w0_bl gf180mcu_3v3_12t_2r2w_sram_512x32_array_control_core_0/u_t015_015/c1_w1_bl
+ detronyx_12t_write_driver_rc1_9/wen detronyx_12t_write_driver_rc1_9/wen detronyx_12t_write_driver_rc1_9/wen
+ gf180mcu_3v3_12t_2r2w_sram_512x32_array_control_core_0/u_t012_002/r0_w1_wl detronyx_12t_write_driver_rc1_9/wen
+ detronyx_12t_write_driver_rc1_9/wen gf180mcu_3v3_12t_2r2w_sram_512x32_array_control_core_0/u_t002_003/r2_w1_wl
+ gf180mcu_3v3_12t_2r2w_sram_512x32_array_control_core_0/u_t021_009/c1_w1_bl detronyx_12t_write_driver_rc1_9/wen
+ detronyx_12t_write_driver_rc1_9/wen detronyx_12t_write_driver_rc1_9/wen detronyx_12t_write_driver_rc1_9/wen
+ detronyx_12t_write_driver_rc1_9/wen gf180mcu_3v3_12t_2r2w_sram_512x32_array_control_core_0/u_t030_025/c1_w0_bl
+ gf180mcu_3v3_12t_2r2w_sram_512x32_array_control_core_0/u_t001_018/c1_w1_bl gf180mcu_3v3_12t_2r2w_sram_512x32_array_control_core_0/u_t021_003/c1_w1_bl
+ detronyx_12t_write_driver_rc1_9/wen detronyx_12t_write_driver_rc1_9/wen gf180mcu_3v3_12t_2r2w_sram_512x32_array_control_core_0/u_t018_009/c1_w1_bl
+ detronyx_12t_write_driver_rc1_9/wen detronyx_12t_write_driver_rc1_9/wen detronyx_12t_write_driver_rc1_9/wen
+ detronyx_12t_write_driver_rc1_9/wen detronyx_12t_write_driver_rc1_9/wen detronyx_12t_write_driver_rc1_9/wen
+ detronyx_12t_write_driver_rc1_9/wen detronyx_12t_write_driver_rc1_9/wen gf180mcu_3v3_12t_2r2w_sram_512x32_array_control_core_0/u_t019_003/c1_w1_bl
+ gf180mcu_3v3_12t_2r2w_sram_512x32_array_control_core_0/u_t013_017/c1_w1_bl detronyx_12t_write_driver_rc1_9/wen
+ detronyx_12t_write_driver_rc1_9/wen detronyx_12t_write_driver_rc1_9/wen detronyx_12t_write_driver_rc1_9/wen
+ detronyx_12t_write_driver_rc1_9/wen gf180mcu_3v3_12t_2r2w_sram_512x32_array_control_core_0/u_t004_018/VDD
+ detronyx_12t_write_driver_rc1_9/wen detronyx_12t_write_driver_rc1_9/wen gf180mcu_3v3_12t_2r2w_sram_512x32_array_control_core_0/a_200_56200#
+ gf180mcu_3v3_12t_2r2w_sram_512x32_array_control_core_0/u_t005_023/c3_w1_bl gf180mcu_3v3_12t_2r2w_sram_512x32_array_control_core_0/u_t023_031/r2_w0_wl
+ gf180mcu_3v3_12t_2r2w_sram_512x32_array_control_core_0/a_14200_33800# detronyx_12t_write_driver_rc1_9/wen
+ gf180mcu_3v3_12t_2r2w_sram_512x32_array_control_core_0/u_t010_030/r2_w0_wl detronyx_12t_write_driver_rc1_9/wen
+ gf180mcu_3v3_12t_2r2w_sram_512x32_array_control_core_0/u_t002_018/VSS gf180mcu_3v3_12t_2r2w_sram_512x32_array_control_core_0/a_22600_39400#
+ detronyx_12t_write_driver_rc1_9/wen gf180mcu_3v3_12t_2r2w_sram_512x32_array_control_core_0/a_19800_3000#
+ detronyx_12t_write_driver_rc1_9/wen detronyx_12t_write_driver_rc1_9/wen detronyx_12t_write_driver_rc1_9/wen
+ detronyx_12t_write_driver_rc1_9/wen gf180mcu_3v3_12t_2r2w_sram_512x32_array_control_core_0/u_t013_031/r3_w0_wl
+ detronyx_12t_write_driver_rc1_9/wen gf180mcu_3v3_12t_2r2w_sram_512x32_array_control_core_0/u_t017_022/c3_w1_bl
+ detronyx_12t_write_driver_rc1_9/wen gf180mcu_3v3_12t_2r2w_sram_512x32_array_control_core_0/u_t009_030/r3_w0_wl
+ detronyx_12t_write_driver_rc1_9/wen detronyx_12t_write_driver_rc1_9/wen detronyx_12t_write_driver_rc1_9/wen
+ detronyx_12t_write_driver_rc1_9/wen gf180mcu_3v3_12t_2r2w_sram_512x32_array_control_core_0/u_t022_016/c3_w1_bl
+ detronyx_12t_write_driver_rc1_9/wen detronyx_12t_write_driver_rc1_9/wen detronyx_12t_write_driver_rc1_9/wen
+ detronyx_12t_write_driver_rc1_9/wen detronyx_12t_write_driver_rc1_9/wen gf180mcu_3v3_12t_2r2w_sram_512x32_array_control_core_0/u_t023_010/c3_w1_bl
+ detronyx_12t_write_driver_rc1_9/wen gf180mcu_3v3_12t_2r2w_sram_512x32_array_control_core_0/u_t019_000/r1_w1_wl
+ detronyx_12t_write_driver_rc1_9/wen gf180mcu_3v3_12t_2r2w_sram_512x32_array_control_core_0/u_t009_001/r3_w1_wl
+ detronyx_12t_write_driver_rc1_9/wen detronyx_12t_write_driver_rc1_9/wen gf180mcu_3v3_12t_2r2w_sram_512x32_array_control_core_0/u_t026_023/c1_w0_bl
+ detronyx_12t_write_driver_rc1_9/wen gf180mcu_3v3_12t_2r2w_sram_512x32_array_control_core_0/u_t007_000/r1_w1_wl
+ gf180mcu_3v3_12t_2r2w_sram_512x32_array_control_core_0/u_t015_024/c3_w0_bl gf180mcu_3v3_12t_2r2w_sram_512x32_array_control_core_0/u_t030_017/c1_w1_bl
+ detronyx_12t_write_driver_rc1_9/wen gf180mcu_3v3_12t_2r2w_sram_512x32_array_control_core_0/u_t021_018/c3_w1_bl
+ gf180mcu_3v3_12t_2r2w_sram_512x32_array_control_core_0/u_t005_008/c3_w1_bl detronyx_12t_write_driver_rc1_9/wen
+ detronyx_12t_write_driver_rc1_9/wen gf180mcu_3v3_12t_2r2w_sram_512x32_array_control_core_0/u_t016_001/c1_w1_bl
+ gf180mcu_3v3_12t_2r2w_sram_512x32_array_control_core_0/u_t010_015/c1_w1_bl detronyx_12t_write_driver_rc1_9/wen
+ gf180mcu_3v3_12t_2r2w_sram_512x32_array_control_core_0/u_t030_017/c1_w1_bl gf180mcu_3v3_12t_2r2w_sram_512x32_array_control_core_0/u_t018_018/c3_w1_bl
+ detronyx_12t_write_driver_rc1_9/wen gf180mcu_3v3_12t_2r2w_sram_512x32_array_control_core_0/u_t030_011/c1_w1_bl
+ detronyx_12t_write_driver_rc1_9/wen gf180mcu_3v3_12t_2r2w_sram_512x32_array_control_core_0/u_t023_025/c1_w0_bl
+ detronyx_12t_write_driver_rc1_9/wen gf180mcu_3v3_12t_2r2w_sram_512x32_array_control_core_0/u_t009_015/c1_w1_bl
+ detronyx_12t_write_driver_rc1_9/wen detronyx_12t_write_driver_rc1_9/wen gf180mcu_3v3_12t_2r2w_sram_512x32_array_control_core_0/gf180mcu_as_sc_mcu7t3v3__inv_2_1379/Y
+ detronyx_12t_write_driver_rc1_9/wen detronyx_12t_write_driver_rc1_9/wen gf180mcu_3v3_12t_2r2w_sram_512x32_array_control_core_0/u_t013_009/c1_w1_bl
+ detronyx_12t_write_driver_rc1_9/wen detronyx_12t_write_driver_rc1_9/wen detronyx_12t_write_driver_rc1_9/wen
+ detronyx_12t_write_driver_rc1_9/wen gf180mcu_3v3_12t_2r2w_sram_512x32_array_control_core_0/u_t030_031/r3_w0_wl
+ gf180mcu_3v3_12t_2r2w_sram_512x32_array_control_core_0/u_t014_003/c1_w1_bl detronyx_12t_write_driver_rc1_9/wen
+ detronyx_12t_write_driver_rc1_9/wen detronyx_12t_write_driver_rc1_9/wen gf180mcu_3v3_12t_2r2w_sram_512x32_array_control_core_0/u_t027_030/c3_w0_bl
+ detronyx_12t_write_driver_rc1_9/wen detronyx_12t_precharge_sense_rc1_36/ren gf180mcu_3v3_12t_2r2w_sram_512x32_array_control_core_0/u_t002_003/VSS
+ detronyx_12t_write_driver_rc1_9/wen detronyx_12t_write_driver_rc1_9/wen detronyx_12t_write_driver_rc1_9/wen
+ detronyx_12t_write_driver_rc1_9/wen detronyx_12t_write_driver_rc1_9/wen detronyx_12t_write_driver_rc1_9/wen
+ gf180mcu_3v3_12t_2r2w_sram_512x32_array_control_core_0/u_t006_017/c1_w1_bl detronyx_12t_write_driver_rc1_9/wen
+ detronyx_12t_write_driver_rc1_9/wen detronyx_12t_write_driver_rc1_9/wen detronyx_12t_write_driver_rc1_9/wen
+ detronyx_12t_write_driver_rc1_9/wen detronyx_12t_write_driver_rc1_9/wen detronyx_12t_write_driver_rc1_9/wen
+ detronyx_12t_write_driver_rc1_9/wen gf180mcu_3v3_12t_2r2w_sram_512x32_array_control_core_0/u_t013_022/c3_w1_bl
+ detronyx_12t_write_driver_rc1_9/wen gf180mcu_3v3_12t_2r2w_sram_512x32_array_control_core_0/u_t003_030/r1_w0_wl
+ detronyx_12t_write_driver_rc1_9/wen detronyx_12t_write_driver_rc1_9/wen detronyx_12t_write_driver_rc1_9/wen
+ detronyx_12t_write_driver_rc1_9/wen gf180mcu_3v3_12t_2r2w_sram_512x32_array_control_core_0/u_t026_000/r3_w1_wl
+ detronyx_12t_write_driver_rc1_9/wen detronyx_12t_write_driver_rc1_9/wen gf180mcu_3v3_12t_2r2w_sram_512x32_array_control_core_0/u_t025_015/c1_w1_bl
+ detronyx_12t_write_driver_rc1_9/wen gf180mcu_3v3_12t_2r2w_sram_512x32_array_control_core_0/u_t014_000/r2_w1_wl
+ detronyx_12t_write_driver_rc1_9/wen detronyx_12t_write_driver_rc1_9/wen gf180mcu_3v3_12t_2r2w_sram_512x32_array_control_core_0/u_t015_016/c3_w1_bl
+ gf180mcu_3v3_12t_2r2w_sram_512x32_array_control_core_0/a_25400_3000# gf180mcu_3v3_12t_2r2w_sram_512x32_array_control_core_0/u_t004_001/r3_w1_wl
+ gf180mcu_3v3_12t_2r2w_sram_512x32_array_control_core_0/a_200_36600# gf180mcu_3v3_12t_2r2w_sram_512x32_array_control_core_0/u_t021_023/c1_w0_bl
+ detronyx_12t_write_driver_rc1_9/wen gf180mcu_3v3_12t_2r2w_sram_512x32_array_control_core_0/u_t017_010/c3_w1_bl
+ detronyx_12t_write_driver_rc1_9/wen gf180mcu_3v3_12t_2r2w_sram_512x32_array_control_core_0/a_22600_92600#
+ gf180mcu_3v3_12t_2r2w_sram_512x32_array_control_core_0/u_t010_024/c3_w0_bl detronyx_12t_write_driver_rc1_9/wen
+ gf180mcu_3v3_12t_2r2w_sram_512x32_array_control_core_0/a_22600_19800# detronyx_12t_write_driver_rc1_9/wen
+ detronyx_12t_write_driver_rc1_9/wen gf180mcu_3v3_12t_2r2w_sram_512x32_array_control_core_0/u_t018_023/c1_w0_bl
+ detronyx_12t_precharge_sense_rc1_54/ren detronyx_12t_write_driver_rc1_9/wen gf180mcu_3v3_12t_2r2w_sram_512x32_array_control_core_0/u_t011_001/c1_w1_bl
+ detronyx_12t_write_driver_rc1_9/wen gf180mcu_3v3_12t_2r2w_sram_512x32_array_control_core_0/u_t009_024/c3_w0_bl
+ detronyx_12t_write_driver_rc1_9/wen gf180mcu_3v3_12t_2r2w_sram_512x32_array_control_core_0/u_t023_017/c1_w1_bl
+ detronyx_12t_write_driver_rc1_9/wen gf180mcu_3v3_12t_2r2w_sram_512x32_array_control_core_0/u_t013_018/c3_w1_bl
+ gf180mcu_3v3_12t_2r2w_sram_512x32_array_control_core_0/u_t025_011/c1_w1_bl gf180mcu_3v3_12t_2r2w_sram_512x32_array_control_core_0/u_t002_003/VSS
+ gf180mcu_3v3_12t_2r2w_sram_512x32_array_control_core_0/u_t009_001/c1_w1_bl detronyx_12t_write_driver_rc1_9/wen
+ gf180mcu_3v3_12t_2r2w_sram_512x32_array_control_core_0/u_t004_015/c1_w1_bl detronyx_12t_write_driver_rc1_9/wen
+ detronyx_12t_precharge_sense_rc1_60/ren detronyx_12t_write_driver_rc1_9/wen detronyx_12t_write_driver_rc1_9/wen
+ detronyx_12t_write_driver_rc1_9/wen detronyx_12t_write_driver_rc1_9/wen gf180mcu_3v3_12t_2r2w_sram_512x32_array_control_core_0/u_t017_025/c1_w0_bl
+ detronyx_12t_write_driver_rc1_9/wen gf180mcu_3v3_12t_2r2w_sram_512x32_array_control_core_0/u_t027_022/c3_w1_bl
+ detronyx_12t_write_driver_rc1_9/wen detronyx_12t_write_driver_rc1_9/wen detronyx_12t_write_driver_rc1_9/wen
+ gf180mcu_3v3_12t_2r2w_sram_512x32_array_control_core_0/u_t022_030/c3_w0_bl gf180mcu_3v3_12t_2r2w_sram_512x32_array_control_core_0/u_t006_009/c1_w1_bl
+ detronyx_12t_write_driver_rc1_9/wen detronyx_12t_write_driver_rc1_9/wen detronyx_12t_write_driver_rc1_9/wen
+ detronyx_12t_write_driver_rc1_9/wen detronyx_12t_write_driver_rc1_9/wen detronyx_12t_write_driver_rc1_9/wen
+ detronyx_12t_write_driver_rc1_9/wen gf180mcu_3v3_12t_2r2w_sram_512x32_array_control_core_0/u_t009_003/c1_w1_bl
+ detronyx_12t_write_driver_rc1_9/wen gf180mcu_3v3_12t_2r2w_sram_512x32_array_control_core_0/u_t001_017/c1_w1_bl
+ detronyx_12t_write_driver_rc1_9/wen detronyx_12t_write_driver_rc1_9/wen detronyx_12t_write_driver_rc1_9/wen
+ gf180mcu_3v3_12t_2r2w_sram_512x32_array_control_core_0/u_t021_030/r3_w0_wl detronyx_12t_write_driver_rc1_9/wen
+ detronyx_12t_write_driver_rc1_9/wen detronyx_12t_write_driver_rc1_9/wen detronyx_12t_write_driver_rc1_9/wen
+ detronyx_12t_write_driver_rc1_9/wen detronyx_12t_write_driver_rc1_9/wen detronyx_12t_write_driver_rc1_9/wen
+ detronyx_12t_write_driver_rc1_9/wen gf180mcu_3v3_12t_2r2w_sram_512x32_array_control_core_0/u_t030_031/r3_w0_wl
+ detronyx_12t_write_driver_rc1_9/wen detronyx_12t_write_driver_rc1_9/wen detronyx_12t_write_driver_rc1_9/wen
+ gf180mcu_3v3_12t_2r2w_sram_512x32_array_control_core_0/a_14200_42200# gf180mcu_3v3_12t_2r2w_sram_512x32_array_control_core_0/u_t021_000/r3_w1_wl
+ detronyx_12t_write_driver_rc1_9/wen detronyx_12t_write_driver_rc1_9/wen detronyx_12t_write_driver_rc1_9/wen
+ detronyx_12t_write_driver_rc1_9/wen gf180mcu_3v3_12t_2r2w_sram_512x32_array_control_core_0/a_200_101000#
+ gf180mcu_3v3_12t_2r2w_sram_512x32_array_control_core_0/u_t009_031/r3_w0_wl gf180mcu_3v3_12t_2r2w_sram_512x32_array_control_core_0/u_t005_022/c3_w1_bl
+ detronyx_12t_write_driver_rc1_9/wen detronyx_12t_write_driver_rc1_9/wen gf180mcu_3v3_12t_2r2w_sram_512x32_array_control_core_0/u_t021_015/c1_w1_bl
+ detronyx_12t_write_driver_rc1_9/wen detronyx_12t_write_driver_rc1_9/wen gf180mcu_3v3_12t_2r2w_sram_512x32_array_control_core_0/u_t030_031/r3_w0_wl
+ gf180mcu_3v3_12t_2r2w_sram_512x32_array_control_core_0/u_t010_016/c3_w1_bl gf180mcu_3v3_12t_2r2w_sram_512x32_array_control_core_0/u_t027_007/c3_w1_bl
+ detronyx_12t_write_driver_rc1_9/wen detronyx_12t_write_driver_rc1_9/wen gf180mcu_3v3_12t_2r2w_sram_512x32_array_control_core_0/u_t013_010/c3_w1_bl
+ detronyx_12t_write_driver_rc1_9/wen gf180mcu_3v3_12t_2r2w_sram_512x32_array_control_core_0/u_t018_015/c1_w1_bl
+ detronyx_12t_write_driver_rc1_9/wen detronyx_12t_write_driver_rc1_9/wen gf180mcu_3v3_12t_2r2w_sram_512x32_array_control_core_0/u_t007_000/r1_w1_wl
+ detronyx_12t_write_driver_rc1_9/wen gf180mcu_3v3_12t_2r2w_sram_512x32_array_control_core_0/u_t009_016/c3_w1_bl
+ detronyx_12t_write_driver_rc1_9/wen gf180mcu_3v3_12t_2r2w_sram_512x32_array_control_core_0/u_t013_023/c1_w0_bl
+ detronyx_12t_write_driver_rc1_9/wen gf180mcu_3v3_12t_2r2w_sram_512x32_array_control_core_0/u_t009_010/c3_w1_bl
+ gf180mcu_3v3_12t_2r2w_sram_512x32_array_control_core_0/u_t029_002/r3_w1_wl gf180mcu_3v3_12t_2r2w_sram_512x32_array_control_core_0/u_t005_024/c3_w0_bl
+ detronyx_12t_write_driver_rc1_9/wen gf180mcu_3v3_12t_2r2w_sram_512x32_array_control_core_0/u_t017_002/r3_w1_wl
+ detronyx_12t_write_driver_rc1_9/wen gf180mcu_3v3_12t_2r2w_sram_512x32_array_control_core_0/u_t004_001/c1_w1_bl
+ detronyx_12t_write_driver_rc1_9/wen gf180mcu_3v3_12t_2r2w_sram_512x32_array_control_core_0/u_t025_009/c3_w1_bl
+ gf180mcu_3v3_12t_2r2w_sram_512x32_array_control_core_0/u_t017_017/c1_w1_bl detronyx_12t_write_driver_rc1_9/wen
+ gf180mcu_3v3_12t_2r2w_sram_512x32_array_control_core_0/u_t030_016/c1_w1_bl gf180mcu_3v3_12t_2r2w_sram_512x32_array_control_core_0/u_t006_018/c3_w1_bl
+ detronyx_12t_write_driver_rc1_9/wen gf180mcu_3v3_12t_2r2w_sram_512x32_array_control_core_0/u_t017_011/c1_w1_bl
+ gf180mcu_3v3_12t_2r2w_sram_512x32_array_control_core_0/u_t022_022/c3_w1_bl gf180mcu_3v3_12t_2r2w_sram_512x32_array_control_core_0/u_t013_025/c1_w0_bl
+ detronyx_12t_write_driver_rc1_9/wen detronyx_12t_write_driver_rc1_9/wen detronyx_12t_write_driver_rc1_9/wen
+ detronyx_12t_write_driver_rc1_9/wen gf180mcu_3v3_12t_2r2w_sram_512x32_array_control_core_0/u_t030_016/c1_w1_bl
+ gf180mcu_3v3_12t_2r2w_sram_512x32_array_control_core_0/u_t025_003/r0_w1_wl detronyx_12t_write_driver_rc1_9/wen
+ gf180mcu_3v3_12t_2r2w_sram_512x32_array_control_core_0/u_t001_009/c1_w1_bl gf180mcu_3v3_12t_2r2w_sram_512x32_array_control_core_0/u_t004_018/VDD
+ detronyx_12t_write_driver_rc1_9/wen detronyx_12t_write_driver_rc1_9/wen gf180mcu_3v3_12t_2r2w_sram_512x32_array_control_core_0/u_t009_025/c1_w0_bl
+ detronyx_12t_write_driver_rc1_9/wen detronyx_12t_write_driver_rc1_9/wen detronyx_12t_write_driver_rc1_9/wen
+ detronyx_12t_write_driver_rc1_9/wen gf180mcu_3v3_12t_2r2w_sram_512x32_array_control_core_0/u_t002_003/c1_w1_bl
+ detronyx_12t_write_driver_rc1_9/wen gf180mcu_3v3_12t_2r2w_sram_512x32_array_control_core_0/u_t015_030/c3_w0_bl
+ detronyx_12t_write_driver_rc1_9/wen gf180mcu_3v3_12t_2r2w_sram_512x32_array_control_core_0/a_28200_200#
+ detronyx_12t_write_driver_rc1_9/wen detronyx_12t_write_driver_rc1_9/wen detronyx_12t_write_driver_rc1_9/wen
+ gf180mcu_3v3_12t_2r2w_sram_512x32_array_control_core_0/u_t017_031/r3_w0_wl detronyx_12t_write_driver_rc1_9/wen
+ detronyx_12t_write_driver_rc1_9/wen detronyx_12t_write_driver_rc1_9/wen gf180mcu_3v3_12t_2r2w_sram_512x32_array_control_core_0/u_t026_018/c1_w1_bl
+ detronyx_12t_write_driver_rc1_9/wen detronyx_12t_write_driver_rc1_9/wen detronyx_12t_write_driver_rc1_9/wen
+ detronyx_12t_write_driver_rc1_9/wen detronyx_12t_write_driver_rc1_9/wen detronyx_12t_write_driver_rc1_9/wen
+ gf180mcu_3v3_12t_2r2w_sram_512x32_array_control_core_0/u_t026_000/r3_w1_wl detronyx_12t_write_driver_rc1_9/wen
+ detronyx_12t_write_driver_rc1_9/wen detronyx_12t_precharge_sense_rc1_0/ren detronyx_12t_write_driver_rc1_9/wen
+ detronyx_12t_write_driver_rc1_9/wen detronyx_12t_write_driver_rc1_9/wen gf180mcu_3v3_12t_2r2w_sram_512x32_array_control_core_0/u_t004_003/VDD
+ detronyx_12t_write_driver_rc1_9/wen gf180mcu_3v3_12t_2r2w_sram_512x32_array_control_core_0/u_t023_031/r2_w0_wl
+ detronyx_12t_write_driver_rc1_9/wen gf180mcu_3v3_12t_2r2w_sram_512x32_array_control_core_0/u_t014_000/r2_w1_wl
+ detronyx_12t_write_driver_rc1_9/wen detronyx_12t_write_driver_rc1_9/wen detronyx_12t_write_driver_rc1_9/wen
+ gf180mcu_3v3_12t_2r2w_sram_512x32_array_control_core_0/u_t030_029/c3_w0_bl gf180mcu_3v3_12t_2r2w_sram_512x32_array_control_core_0/a_14200_106600#
+ gf180mcu_3v3_12t_2r2w_sram_512x32_array_control_core_0/u_t022_007/c3_w1_bl detronyx_12t_write_driver_rc1_9/wen
+ gf180mcu_3v3_12t_2r2w_sram_512x32_array_control_core_0/u_t013_015/c1_w1_bl gf180mcu_3v3_12t_2r2w_sram_512x32_array_control_core_0/u_t002_000/r2_w1_wl
+ gf180mcu_3v3_12t_2r2w_sram_512x32_array_control_core_0/u_t004_016/c3_w1_bl detronyx_12t_write_driver_rc1_9/wen
+ detronyx_12t_write_driver_rc1_9/wen detronyx_12t_write_driver_rc1_9/wen detronyx_12t_write_driver_rc1_9/wen
+ gf180mcu_3v3_12t_2r2w_sram_512x32_array_control_core_0/u_t004_010/c3_w1_bl gf180mcu_3v3_12t_2r2w_sram_512x32_array_control_core_0/u_t025_002/r0_w1_wl
+ detronyx_12t_write_driver_rc1_9/wen detronyx_12t_write_driver_rc1_9/wen gf180mcu_3v3_12t_2r2w_sram_512x32_array_control_core_0/a_200_45000#
+ gf180mcu_3v3_12t_2r2w_sram_512x32_array_control_core_0/u_t030_025/c3_w0_bl gf180mcu_3v3_12t_2r2w_sram_512x32_array_control_core_0/a_14200_22600#
+ detronyx_12t_write_driver_rc1_9/wen gf180mcu_3v3_12t_2r2w_sram_512x32_array_control_core_0/u_t006_023/c1_w0_bl
+ gf180mcu_3v3_12t_2r2w_sram_512x32_array_control_core_0/u_t030_008/c1_w1_bl detronyx_12t_write_driver_rc1_9/wen
+ gf180mcu_3v3_12t_2r2w_sram_512x32_array_control_core_0/a_22600_28200# gf180mcu_3v3_12t_2r2w_sram_512x32_array_control_core_0/u_t021_009/c3_w1_bl
+ gf180mcu_3v3_12t_2r2w_sram_512x32_array_control_core_0/u_t013_017/c1_w1_bl detronyx_12t_write_driver_rc1_9/wen
+ detronyx_12t_write_driver_rc1_9/wen gf180mcu_3v3_12t_2r2w_sram_512x32_array_control_core_0/u_t030_025/c3_w0_bl
+ gf180mcu_3v3_12t_2r2w_sram_512x32_array_control_core_0/u_t001_018/c3_w1_bl gf180mcu_3v3_12t_2r2w_sram_512x32_array_control_core_0/u_t030_008/c1_w1_bl
+ gf180mcu_3v3_12t_2r2w_sram_512x32_array_control_core_0/u_t013_011/c1_w1_bl detronyx_12t_write_driver_rc1_9/wen
+ detronyx_12t_write_driver_rc1_9/wen gf180mcu_3v3_12t_2r2w_sram_512x32_array_control_core_0/u_t018_009/c3_w1_bl
+ detronyx_12t_write_driver_rc1_9/wen detronyx_12t_write_driver_rc1_9/wen detronyx_12t_write_driver_rc1_9/wen
+ gf180mcu_3v3_12t_2r2w_sram_512x32_array_control_core_0/u_t029_002/c1_w1_bl gf180mcu_3v3_12t_2r2w_sram_512x32_array_control_core_0/u_t009_017/c1_w1_bl
+ detronyx_12t_write_driver_rc1_9/wen gf180mcu_3v3_12t_2r2w_sram_512x32_array_control_core_0/u_t023_016/c1_w1_bl
+ detronyx_12t_write_driver_rc1_9/wen gf180mcu_3v3_12t_2r2w_sram_512x32_array_control_core_0/u_t020_003/r1_w1_wl
+ detronyx_12t_write_driver_rc1_9/wen gf180mcu_3v3_12t_2r2w_sram_512x32_array_control_core_0/u_t002_003/VSS
+ detronyx_12t_write_driver_rc1_9/wen gf180mcu_3v3_12t_2r2w_sram_512x32_array_control_core_0/u_t005_025/c1_w0_bl
+ gf180mcu_3v3_12t_2r2w_sram_512x32_array_control_core_0/u_t015_022/c3_w1_bl detronyx_12t_write_driver_rc1_9/wen
+ detronyx_12t_write_driver_rc1_9/wen detronyx_12t_write_driver_rc1_9/wen detronyx_12t_write_driver_rc1_9/wen
+ detronyx_12t_write_driver_rc1_9/wen detronyx_12t_write_driver_rc1_9/wen detronyx_12t_write_driver_rc1_9/wen
+ gf180mcu_3v3_12t_2r2w_sram_512x32_array_control_core_0/u_t010_030/c3_w0_bl detronyx_12t_write_driver_rc1_9/wen
+ detronyx_12t_write_driver_rc1_9/wen detronyx_12t_write_driver_rc1_9/wen detronyx_12t_write_driver_rc1_9/wen
+ detronyx_12t_write_driver_rc1_9/wen detronyx_12t_write_driver_rc1_9/wen detronyx_12t_write_driver_rc1_9/wen
+ detronyx_12t_write_driver_rc1_9/wen detronyx_12t_write_driver_rc1_9/wen detronyx_12t_write_driver_rc1_9/wen
+ detronyx_12t_write_driver_rc1_9/wen detronyx_12t_write_driver_rc1_9/wen gf180mcu_3v3_12t_2r2w_sram_512x32_array_control_core_0/u_t021_018/c1_w1_bl
+ gf180mcu_3v3_12t_2r2w_sram_512x32_array_control_core_0/u_t009_030/c3_w0_bl gf180mcu_3v3_12t_2r2w_sram_512x32_array_control_core_0/u_t019_030/r2_w0_wl
+ gf180mcu_3v3_12t_2r2w_sram_512x32_array_control_core_0/u_t021_000/r3_w1_wl detronyx_12t_write_driver_rc1_9/wen
+ detronyx_12t_write_driver_rc1_9/wen detronyx_12t_write_driver_rc1_9/wen detronyx_12t_write_driver_rc1_9/wen
+ gf180mcu_3v3_12t_2r2w_sram_512x32_array_control_core_0/u_t009_031/r3_w0_wl detronyx_12t_write_driver_rc1_9/wen
+ detronyx_12t_write_driver_rc1_9/wen gf180mcu_3v3_12t_2r2w_sram_512x32_array_control_core_0/u_t007_030/r1_w0_wl
+ gf180mcu_3v3_12t_2r2w_sram_512x32_array_control_core_0/u_t019_018/c1_w1_bl detronyx_12t_write_driver_rc1_9/wen
+ detronyx_12t_write_driver_rc1_9/wen detronyx_12t_write_driver_rc1_9/wen gf180mcu_3v3_12t_2r2w_sram_512x32_array_control_core_0/u_t026_029/c3_w0_bl
+ detronyx_12t_write_driver_rc1_9/wen gf180mcu_3v3_12t_2r2w_sram_512x32_array_control_core_0/u_t026_023/c3_w1_bl
+ gf180mcu_3v3_12t_2r2w_sram_512x32_array_control_core_0/u_t017_031/r3_w0_wl detronyx_12t_write_driver_rc1_9/wen
+ detronyx_12t_write_driver_rc1_9/wen gf180mcu_3v3_12t_2r2w_sram_512x32_array_control_core_0/u_t030_017/c3_w1_bl
+ gf180mcu_3v3_12t_2r2w_sram_512x32_array_control_core_0/u_t015_007/c3_w1_bl gf180mcu_3v3_12t_2r2w_sram_512x32_array_control_core_0/u_t006_015/c1_w1_bl
+ detronyx_12t_write_driver_rc1_9/wen detronyx_12t_write_driver_rc1_9/wen detronyx_12t_write_driver_rc1_9/wen
+ gf180mcu_3v3_12t_2r2w_sram_512x32_array_control_core_0/u_t027_001/r2_w1_wl gf180mcu_3v3_12t_2r2w_sram_512x32_array_control_core_0/u_t030_017/c3_w1_bl
+ gf180mcu_3v3_12t_2r2w_sram_512x32_array_control_core_0/u_t001_023/c1_w0_bl detronyx_12t_write_driver_rc1_9/wen
+ gf180mcu_3v3_12t_2r2w_sram_512x32_array_control_core_0/u_t017_002/r3_w1_wl detronyx_12t_write_driver_rc1_9/wen
+ detronyx_12t_write_driver_rc1_9/wen detronyx_12t_write_driver_rc1_9/wen gf180mcu_3v3_12t_2r2w_sram_512x32_array_control_core_0/u_t015_001/r1_w1_wl
+ gf180mcu_3v3_12t_2r2w_sram_512x32_array_control_core_0/u_t023_025/c3_w0_bl detronyx_12t_write_driver_rc1_9/wen
+ gf180mcu_3v3_12t_2r2w_sram_512x32_array_control_core_0/u_t005_002/r3_w1_wl gf180mcu_3v3_12t_2r2w_sram_512x32_array_control_core_0/u_t023_008/c1_w1_bl
+ detronyx_12t_write_driver_rc1_9/wen gf180mcu_3v3_12t_2r2w_sram_512x32_array_control_core_0/u_t013_009/c3_w1_bl
+ gf180mcu_3v3_12t_2r2w_sram_512x32_array_control_core_0/u_t005_017/c1_w1_bl gf180mcu_3v3_12t_2r2w_sram_512x32_array_control_core_0/u_t025_002/c1_w1_bl
+ detronyx_12t_write_driver_rc1_9/wen detronyx_12t_write_driver_rc1_9/wen detronyx_12t_write_driver_rc1_9/wen
+ gf180mcu_3v3_12t_2r2w_sram_512x32_array_control_core_0/u_t005_011/c1_w1_bl detronyx_12t_write_driver_rc1_9/wen
+ detronyx_12t_write_driver_rc1_9/wen detronyx_12t_write_driver_rc1_9/wen gf180mcu_3v3_12t_2r2w_sram_512x32_array_control_core_0/u_t010_022/c3_w1_bl
+ detronyx_12t_write_driver_rc1_9/wen detronyx_12t_write_driver_rc1_9/wen gf180mcu_3v3_12t_2r2w_sram_512x32_array_control_core_0/a_200_25400#
+ detronyx_12t_write_driver_rc1_9/wen gf180mcu_3v3_12t_2r2w_sram_512x32_array_control_core_0/u_t002_003/VSS
+ gf180mcu_3v3_12t_2r2w_sram_512x32_array_control_core_0/u_t017_016/c1_w1_bl detronyx_12t_write_driver_rc1_9/wen
+ detronyx_12t_write_driver_rc1_9/wen gf180mcu_3v3_12t_2r2w_sram_512x32_array_control_core_0/a_22600_81400#
+ detronyx_12t_write_driver_rc1_9/wen gf180mcu_3v3_12t_2r2w_sram_512x32_array_control_core_0/u_t009_022/c3_w1_bl
+ gf180mcu_3v3_12t_2r2w_sram_512x32_array_control_core_0/u_t026_030/r3_w0_wl detronyx_12t_write_driver_rc1_9/wen
+ detronyx_12t_write_driver_rc1_9/wen detronyx_12t_write_driver_rc1_9/wen gf180mcu_3v3_12t_2r2w_sram_512x32_array_control_core_0/u_t030_026/c1_w0_bl
+ detronyx_12t_write_driver_rc1_9/wen detronyx_12t_write_driver_rc1_9/wen detronyx_12t_write_driver_rc1_9/wen
+ detronyx_12t_write_driver_rc1_9/wen gf180mcu_3v3_12t_2r2w_sram_512x32_array_control_core_0/u_t005_030/c3_w0_bl
+ detronyx_12t_write_driver_rc1_9/wen detronyx_12t_write_driver_rc1_9/wen detronyx_12t_write_driver_rc1_9/wen
+ gf180mcu_3v3_12t_2r2w_sram_512x32_array_control_core_0/u_t005_031/r3_w0_wl detronyx_12t_write_driver_rc1_9/wen
+ detronyx_12t_write_driver_rc1_9/wen gf180mcu_3v3_12t_2r2w_sram_512x32_array_control_core_0/u_t014_018/c1_w1_bl
+ gf180mcu_3v3_12t_2r2w_sram_512x32_array_control_core_0/u_t025_015/c3_w1_bl detronyx_12t_write_driver_rc1_9/wen
+ detronyx_12t_write_driver_rc1_9/wen detronyx_12t_write_driver_rc1_9/wen gf180mcu_3v3_12t_2r2w_sram_512x32_array_control_core_0/u_t030_022/c1_w0_bl
+ detronyx_12t_write_driver_rc1_9/wen detronyx_12t_write_driver_rc1_9/wen detronyx_12t_write_driver_rc1_9/wen
+ detronyx_12t_write_driver_rc1_9/wen gf180mcu_3v3_12t_2r2w_sram_512x32_array_control_core_0/u_t021_023/c3_w1_bl
+ gf180mcu_3v3_12t_2r2w_sram_512x32_array_control_core_0/u_t002_018/VSS gf180mcu_3v3_12t_2r2w_sram_512x32_array_control_core_0/u_t013_031/r3_w0_wl
+ detronyx_12t_write_driver_rc1_9/wen gf180mcu_3v3_12t_2r2w_sram_512x32_array_control_core_0/u_t002_000/r2_w1_wl
+ detronyx_12t_write_driver_rc1_9/wen detronyx_12t_write_driver_rc1_9/wen gf180mcu_3v3_12t_2r2w_sram_512x32_array_control_core_0/u_t017_029/c3_w0_bl
+ gf180mcu_3v3_12t_2r2w_sram_512x32_array_control_core_0/u_t030_022/c1_w0_bl detronyx_12t_write_driver_rc1_9/wen
+ gf180mcu_3v3_12t_2r2w_sram_512x32_array_control_core_0/u_t010_007/c3_w1_bl gf180mcu_3v3_12t_2r2w_sram_512x32_array_control_core_0/u_t001_015/c1_w1_bl
+ gf180mcu_3v3_12t_2r2w_sram_512x32_array_control_core_0/u_t018_023/c3_w1_bl gf180mcu_3v3_12t_2r2w_sram_512x32_array_control_core_0/u_t009_031/r3_w0_wl
+ gf180mcu_3v3_12t_2r2w_sram_512x32_array_control_core_0/a_14200_115000# detronyx_12t_write_driver_rc1_9/wen
+ detronyx_12t_write_driver_rc1_9/wen detronyx_12t_write_driver_rc1_9/wen detronyx_12t_write_driver_rc1_9/wen
+ detronyx_12t_write_driver_rc1_9/wen gf180mcu_3v3_12t_2r2w_sram_512x32_array_control_core_0/u_t023_017/c3_w1_bl
+ detronyx_12t_write_driver_rc1_9/wen gf180mcu_3v3_12t_2r2w_sram_512x32_array_control_core_0/u_t012_002/r3_w1_wl
+ gf180mcu_3v3_12t_2r2w_sram_512x32_array_control_core_0/u_t008_007/c3_w1_bl detronyx_12t_write_driver_rc1_9/wen
+ detronyx_12t_write_driver_rc1_9/wen detronyx_12t_write_driver_rc1_9/wen detronyx_12t_write_driver_rc1_9/wen
+ gf180mcu_3v3_12t_2r2w_sram_512x32_array_control_core_0/u_t000_002/r3_w1_wl gf180mcu_3v3_12t_2r2w_sram_512x32_array_control_core_0/u_t004_018/VDD
+ detronyx_12t_write_driver_rc1_9/wen detronyx_12t_write_driver_rc1_9/wen detronyx_12t_write_driver_rc1_9/wen
+ gf180mcu_3v3_12t_2r2w_sram_512x32_array_control_core_0/a_14200_31000# gf180mcu_3v3_12t_2r2w_sram_512x32_array_control_core_0/u_t026_024/c1_w0_bl
+ gf180mcu_3v3_12t_2r2w_sram_512x32_array_control_core_0/u_t004_003/VDD gf180mcu_3v3_12t_2r2w_sram_512x32_array_control_core_0/u_t008_001/r0_w1_wl
+ gf180mcu_3v3_12t_2r2w_sram_512x32_array_control_core_0/u_t017_025/c3_w0_bl gf180mcu_3v3_12t_2r2w_sram_512x32_array_control_core_0/gf180mcu_as_sc_mcu7t3v3__inv_2_1294/Y
+ detronyx_12t_write_driver_rc1_9/wen gf180mcu_3v3_12t_2r2w_sram_512x32_array_control_core_0/u_t017_008/c1_w1_bl
+ gf180mcu_3v3_12t_2r2w_sram_512x32_array_control_core_0/u_t020_003/r1_w1_wl detronyx_12t_write_driver_rc1_9/wen
+ detronyx_12t_write_driver_rc1_9/wen detronyx_12t_write_driver_rc1_9/wen gf180mcu_3v3_12t_2r2w_sram_512x32_array_control_core_0/u_t006_009/c3_w1_bl
+ detronyx_12t_write_driver_rc1_9/wen gf180mcu_3v3_12t_2r2w_sram_512x32_array_control_core_0/u_t017_002/c1_w1_bl
+ gf180mcu_3v3_12t_2r2w_sram_512x32_array_control_core_0/u_t013_016/c1_w1_bl detronyx_12t_write_driver_rc1_9/wen
+ detronyx_12t_write_driver_rc1_9/wen detronyx_12t_write_driver_rc1_9/wen gf180mcu_3v3_12t_2r2w_sram_512x32_array_control_core_0/u_t030_018/c1_w1_bl
+ gf180mcu_3v3_12t_2r2w_sram_512x32_array_control_core_0/u_t018_003/r2_w1_wl detronyx_12t_write_driver_rc1_9/wen
+ detronyx_12t_write_driver_rc1_9/wen gf180mcu_3v3_12t_2r2w_sram_512x32_array_control_core_0/u_t005_022/c3_w1_bl
+ detronyx_12t_write_driver_rc1_9/wen detronyx_12t_write_driver_rc1_9/wen detronyx_12t_write_driver_rc1_9/wen
+ gf180mcu_3v3_12t_2r2w_sram_512x32_array_control_core_0/u_t026_026/c1_w0_bl detronyx_12t_write_driver_rc1_9/wen
+ gf180mcu_3v3_12t_2r2w_sram_512x32_array_control_core_0/u_t009_016/c1_w1_bl detronyx_12t_write_driver_rc1_9/wen
+ detronyx_12t_write_driver_rc1_9/wen detronyx_12t_write_driver_rc1_9/wen detronyx_12t_write_driver_rc1_9/wen
+ detronyx_12t_write_driver_rc1_9/wen gf180mcu_3v3_12t_2r2w_sram_512x32_array_control_core_0/u_t030_031/r3_w0_wl
+ detronyx_12t_write_driver_rc1_9/wen gf180mcu_3v3_12t_2r2w_sram_512x32_array_control_core_0/u_t019_030/r2_w0_wl
+ detronyx_12t_write_driver_rc1_9/wen detronyx_12t_write_driver_rc1_9/wen detronyx_12t_write_driver_rc1_9/wen
+ detronyx_12t_write_driver_rc1_9/wen detronyx_12t_write_driver_rc1_9/wen detronyx_12t_write_driver_rc1_9/wen
+ detronyx_12t_write_driver_rc1_9/wen gf180mcu_3v3_12t_2r2w_sram_512x32_array_control_core_0/u_t021_015/c3_w1_bl
+ gf180mcu_3v3_12t_2r2w_sram_512x32_array_control_core_0/u_t007_030/r1_w0_wl detronyx_12t_write_driver_rc1_9/wen
+ gf180mcu_3v3_12t_2r2w_sram_512x32_array_control_core_0/u_t030_031/r3_w0_wl detronyx_12t_write_driver_rc1_9/wen
+ detronyx_12t_write_driver_rc1_9/wen detronyx_12t_write_driver_rc1_9/wen detronyx_12t_write_driver_rc1_9/wen
+ gf180mcu_3v3_12t_2r2w_sram_512x32_array_control_core_0/a_22600_61800# detronyx_12t_write_driver_rc1_9/wen
+ gf180mcu_3v3_12t_2r2w_sram_512x32_array_control_core_0/u_t018_015/c3_w1_bl gf180mcu_3v3_12t_2r2w_sram_512x32_array_control_core_0/u_t009_018/c1_w1_bl
+ gf180mcu_3v3_12t_2r2w_sram_512x32_array_control_core_0/u_t013_029/c3_w0_bl detronyx_12t_write_driver_rc1_9/wen
+ detronyx_12t_write_driver_rc1_9/wen detronyx_12t_write_driver_rc1_9/wen gf180mcu_3v3_12t_2r2w_sram_512x32_array_control_core_0/u_t023_022/c1_w0_bl
+ gf180mcu_3v3_12t_2r2w_sram_512x32_array_control_core_0/u_t013_023/c3_w1_bl gf180mcu_3v3_12t_2r2w_sram_512x32_array_control_core_0/u_t005_031/r3_w0_wl
+ detronyx_12t_write_driver_rc1_9/wen detronyx_12t_write_driver_rc1_9/wen gf180mcu_3v3_12t_2r2w_sram_512x32_array_control_core_0/u_t027_001/r2_w1_wl
+ gf180mcu_3v3_12t_2r2w_sram_512x32_array_control_core_0/u_t004_007/c3_w1_bl gf180mcu_3v3_12t_2r2w_sram_512x32_array_control_core_0/u_t026_016/c1_w1_bl
+ gf180mcu_3v3_12t_2r2w_sram_512x32_array_control_core_0/u_t015_001/r1_w1_wl detronyx_12t_write_driver_rc1_9/wen
+ detronyx_12t_write_driver_rc1_9/wen gf180mcu_3v3_12t_2r2w_sram_512x32_array_control_core_0/u_t017_017/c3_w1_bl
+ detronyx_12t_write_driver_rc1_9/wen gf180mcu_3v3_12t_2r2w_sram_512x32_array_control_core_0/u_t027_010/c1_w1_bl
+ gf180mcu_3v3_12t_2r2w_sram_512x32_array_control_core_0/u_t005_002/r3_w1_wl gf180mcu_3v3_12t_2r2w_sram_512x32_array_control_core_0/u_t021_024/c1_w0_bl
+ detronyx_12t_write_driver_rc1_9/wen detronyx_12t_write_driver_rc1_9/wen detronyx_12t_write_driver_rc1_9/wen
+ gf180mcu_3v3_12t_2r2w_sram_512x32_array_control_core_0/u_t003_001/r1_w1_wl gf180mcu_3v3_12t_2r2w_sram_512x32_array_control_core_0/u_t013_025/c3_w0_bl
+ gf180mcu_3v3_12t_2r2w_sram_512x32_array_control_core_0/u_t013_008/c1_w1_bl gf180mcu_3v3_12t_2r2w_sram_512x32_array_control_core_0/u_t019_024/c1_w0_bl
+ gf180mcu_3v3_12t_2r2w_sram_512x32_array_control_core_0/u_t001_009/c3_w1_bl gf180mcu_3v3_12t_2r2w_sram_512x32_array_control_core_0/u_t012_002/c1_w1_bl
+ detronyx_12t_write_driver_rc1_9/wen gf180mcu_3v3_12t_2r2w_sram_512x32_array_control_core_0/u_t009_025/c3_w0_bl
+ detronyx_12t_write_driver_rc1_9/wen gf180mcu_3v3_12t_2r2w_sram_512x32_array_control_core_0/u_t026_018/c1_w1_bl
+ detronyx_12t_write_driver_rc1_9/wen gf180mcu_3v3_12t_2r2w_sram_512x32_array_control_core_0/u_t009_008/c1_w1_bl
+ detronyx_12t_write_driver_rc1_9/wen detronyx_12t_write_driver_rc1_9/wen detronyx_12t_write_driver_rc1_9/wen
+ detronyx_12t_write_driver_rc1_9/wen detronyx_12t_write_driver_rc1_9/wen detronyx_12t_write_driver_rc1_9/wen
+ detronyx_12t_write_driver_rc1_9/wen gf180mcu_3v3_12t_2r2w_sram_512x32_array_control_core_0/u_t026_030/r3_w0_wl
+ detronyx_12t_write_driver_rc1_9/wen gf180mcu_3v3_12t_2r2w_sram_512x32_array_control_core_0/u_t030_023/c3_w1_bl
+ gf180mcu_3v3_12t_2r2w_sram_512x32_array_control_core_0/u_t005_016/c1_w1_bl detronyx_12t_write_driver_rc1_9/wen
+ detronyx_12t_write_driver_rc1_9/wen detronyx_12t_write_driver_rc1_9/wen gf180mcu_3v3_12t_2r2w_sram_512x32_array_control_core_0/a_14200_11400#
+ gf180mcu_3v3_12t_2r2w_sram_512x32_array_control_core_0/u_t014_030/r2_w0_wl detronyx_12t_write_driver_rc1_9/wen
+ detronyx_12t_write_driver_rc1_9/wen detronyx_12t_write_driver_rc1_9/wen gf180mcu_3v3_12t_2r2w_sram_512x32_array_control_core_0/u_t017_026/c1_w0_bl
+ detronyx_12t_write_driver_rc1_9/wen gf180mcu_3v3_12t_2r2w_sram_512x32_array_control_core_0/u_t030_023/c3_w1_bl
+ gf180mcu_3v3_12t_2r2w_sram_512x32_array_control_core_0/a_22600_17000# detronyx_12t_write_driver_rc1_9/wen
+ detronyx_12t_write_driver_rc1_9/wen detronyx_12t_write_driver_rc1_9/wen gf180mcu_3v3_12t_2r2w_sram_512x32_array_control_core_0/u_t002_030/r2_w0_wl
+ detronyx_12t_write_driver_rc1_9/wen detronyx_12t_write_driver_rc1_9/wen detronyx_12t_write_driver_rc1_9/wen
+ detronyx_12t_write_driver_rc1_9/wen detronyx_12t_write_driver_rc1_9/wen gf180mcu_3v3_12t_2r2w_sram_512x32_array_control_core_0/u_t023_031/r2_w0_wl
+ detronyx_12t_write_driver_rc1_9/wen gf180mcu_3v3_12t_2r2w_sram_512x32_array_control_core_0/u_t004_003/VDD
+ detronyx_12t_write_driver_rc1_9/wen detronyx_12t_write_driver_rc1_9/wen detronyx_12t_write_driver_rc1_9/wen
+ detronyx_12t_write_driver_rc1_9/wen detronyx_12t_write_driver_rc1_9/wen detronyx_12t_write_driver_rc1_9/wen
+ detronyx_12t_write_driver_rc1_9/wen gf180mcu_3v3_12t_2r2w_sram_512x32_array_control_core_0/u_t002_018/c1_w1_bl
+ gf180mcu_3v3_12t_2r2w_sram_512x32_array_control_core_0/u_t013_015/c3_w1_bl detronyx_12t_write_driver_rc1_9/wen
+ detronyx_12t_write_driver_rc1_9/wen detronyx_12t_write_driver_rc1_9/wen detronyx_12t_write_driver_rc1_9/wen
+ detronyx_12t_write_driver_rc1_9/wen detronyx_12t_write_driver_rc1_9/wen detronyx_12t_write_driver_rc1_9/wen
+ detronyx_12t_write_driver_rc1_9/wen detronyx_12t_write_driver_rc1_9/wen detronyx_12t_write_driver_rc1_9/wen
+ detronyx_12t_write_driver_rc1_9/wen gf180mcu_3v3_12t_2r2w_sram_512x32_array_control_core_0/u_t005_029/c3_w0_bl
+ detronyx_12t_write_driver_rc1_9/wen gf180mcu_3v3_12t_2r2w_sram_512x32_array_control_core_0/u_t022_001/r3_w1_wl
+ gf180mcu_3v3_12t_2r2w_sram_512x32_array_control_core_0/u_t017_022/c1_w0_bl detronyx_12t_write_driver_rc1_9/wen
+ gf180mcu_3v3_12t_2r2w_sram_512x32_array_control_core_0/a_22600_8600# detronyx_12t_write_driver_rc1_9/wen
+ gf180mcu_3v3_12t_2r2w_sram_512x32_array_control_core_0/u_t006_023/c3_w1_bl gf180mcu_3v3_12t_2r2w_sram_512x32_array_control_core_0/u_t030_008/c3_w1_bl
+ detronyx_12t_write_driver_rc1_9/wen gf180mcu_3v3_12t_2r2w_sram_512x32_array_control_core_0/u_t021_016/c1_w1_bl
+ gf180mcu_3v3_12t_2r2w_sram_512x32_array_control_core_0/a_200_109400# gf180mcu_3v3_12t_2r2w_sram_512x32_array_control_core_0/u_t010_001/r2_w1_wl
+ detronyx_12t_write_driver_rc1_9/wen detronyx_12t_write_driver_rc1_9/wen gf180mcu_3v3_12t_2r2w_sram_512x32_array_control_core_0/u_t013_017/c3_w1_bl
+ gf180mcu_3v3_12t_2r2w_sram_512x32_array_control_core_0/u_t022_010/c1_w1_bl gf180mcu_3v3_12t_2r2w_sram_512x32_array_control_core_0/u_t000_002/r3_w1_wl
+ gf180mcu_3v3_12t_2r2w_sram_512x32_array_control_core_0/u_t030_008/c3_w1_bl detronyx_12t_write_driver_rc1_9/wen
+ detronyx_12t_write_driver_rc1_9/wen gf180mcu_3v3_12t_2r2w_sram_512x32_array_control_core_0/u_t019_016/c1_w1_bl
+ gf180mcu_3v3_12t_2r2w_sram_512x32_array_control_core_0/u_t009_017/c3_w1_bl detronyx_12t_write_driver_rc1_9/wen
+ gf180mcu_3v3_12t_2r2w_sram_512x32_array_control_core_0/u_t014_024/c1_w0_bl detronyx_12t_write_driver_rc1_9/wen
+ detronyx_12t_write_driver_rc1_9/wen gf180mcu_3v3_12t_2r2w_sram_512x32_array_control_core_0/u_t005_025/c3_w0_bl
+ gf180mcu_3v3_12t_2r2w_sram_512x32_array_control_core_0/u_t028_002/r1_w1_wl gf180mcu_3v3_12t_2r2w_sram_512x32_array_control_core_0/u_t004_008/c1_w1_bl
+ detronyx_12t_write_driver_rc1_9/wen gf180mcu_3v3_12t_2r2w_sram_512x32_array_control_core_0/u_t018_003/r2_w1_wl
+ detronyx_12t_write_driver_rc1_9/wen detronyx_12t_write_driver_rc1_9/wen detronyx_12t_write_driver_rc1_9/wen
+ gf180mcu_3v3_12t_2r2w_sram_512x32_array_control_core_0/u_t021_030/r3_w0_wl gf180mcu_3v3_12t_2r2w_sram_512x32_array_control_core_0/u_t005_002/c1_w1_bl
+ detronyx_12t_write_driver_rc1_9/wen detronyx_12t_write_driver_rc1_9/wen gf180mcu_3v3_12t_2r2w_sram_512x32_array_control_core_0/u_t017_018/c1_w1_bl
+ detronyx_12t_write_driver_rc1_9/wen gf180mcu_3v3_12t_2r2w_sram_512x32_array_control_core_0/u_t006_003/r2_w1_wl
+ detronyx_12t_write_driver_rc1_9/wen detronyx_12t_write_driver_rc1_9/wen detronyx_12t_write_driver_rc1_9/wen
+ detronyx_12t_write_driver_rc1_9/wen gf180mcu_3v3_12t_2r2w_sram_512x32_array_control_core_0/u_t023_023/c3_w1_bl
+ gf180mcu_3v3_12t_2r2w_sram_512x32_array_control_core_0/u_t013_026/c1_w0_bl detronyx_12t_write_driver_rc1_9/wen
+ detronyx_12t_write_driver_rc1_9/wen detronyx_12t_write_driver_rc1_9/wen gf180mcu_3v3_12t_2r2w_sram_512x32_array_control_core_0/u_t030_017/c1_w1_bl
+ detronyx_12t_write_driver_rc1_9/wen detronyx_12t_write_driver_rc1_9/wen detronyx_12t_write_driver_rc1_9/wen
+ detronyx_12t_write_driver_rc1_9/wen detronyx_12t_write_driver_rc1_9/wen detronyx_12t_write_driver_rc1_9/wen
+ detronyx_12t_write_driver_rc1_9/wen detronyx_12t_write_driver_rc1_9/wen detronyx_12t_write_driver_rc1_9/wen
+ detronyx_12t_write_driver_rc1_9/wen gf180mcu_3v3_12t_2r2w_sram_512x32_array_control_core_0/u_t026_030/r3_w0_wl
+ detronyx_12t_write_driver_rc1_9/wen detronyx_12t_write_driver_rc1_9/wen detronyx_12t_write_driver_rc1_9/wen
+ gf180mcu_3v3_12t_2r2w_sram_512x32_array_control_core_0/u_t017_031/r3_w0_wl detronyx_12t_write_driver_rc1_9/wen
+ detronyx_12t_write_driver_rc1_9/wen gf180mcu_3v3_12t_2r2w_sram_512x32_array_control_core_0/u_t027_031/r2_w0_wl
+ detronyx_12t_write_driver_rc1_9/wen detronyx_12t_write_driver_rc1_9/wen detronyx_12t_write_driver_rc1_9/wen
+ detronyx_12t_write_driver_rc1_9/wen detronyx_12t_write_driver_rc1_9/wen detronyx_12t_write_driver_rc1_9/wen
+ gf180mcu_3v3_12t_2r2w_sram_512x32_array_control_core_0/u_t006_015/c3_w1_bl gf180mcu_3v3_12t_2r2w_sram_512x32_array_control_core_0/a_200_14200#
+ detronyx_12t_write_driver_rc1_9/wen detronyx_12t_precharge_sense_rc1_30/ren detronyx_12t_write_driver_rc1_9/wen
+ detronyx_12t_write_driver_rc1_9/wen detronyx_12t_write_driver_rc1_9/wen gf180mcu_3v3_12t_2r2w_sram_512x32_array_control_core_0/u_t013_022/c1_w0_bl
+ gf180mcu_3v3_12t_2r2w_sram_512x32_array_control_core_0/a_22600_70200# gf180mcu_3v3_12t_2r2w_sram_512x32_array_control_core_0/u_t001_023/c3_w1_bl
+ gf180mcu_3v3_12t_2r2w_sram_512x32_array_control_core_0/u_t004_003/VDD detronyx_12t_write_driver_rc1_9/wen
+ detronyx_12t_write_driver_rc1_9/wen gf180mcu_3v3_12t_2r2w_sram_512x32_array_control_core_0/u_t025_000/r0_w1_wl
+ detronyx_12t_write_driver_rc1_9/wen detronyx_12t_write_driver_rc1_9/wen gf180mcu_3v3_12t_2r2w_sram_512x32_array_control_core_0/u_t009_022/c1_w0_bl
+ detronyx_12t_write_driver_rc1_9/wen detronyx_12t_write_driver_rc1_9/wen gf180mcu_3v3_12t_2r2w_sram_512x32_array_control_core_0/u_t023_008/c3_w1_bl
+ gf180mcu_3v3_12t_2r2w_sram_512x32_array_control_core_0/u_t014_016/c1_w1_bl gf180mcu_3v3_12t_2r2w_sram_512x32_array_control_core_0/u_t003_001/r1_w1_wl
+ gf180mcu_3v3_12t_2r2w_sram_512x32_array_control_core_0/u_t004_017/c3_w1_bl gf180mcu_3v3_12t_2r2w_sram_512x32_array_control_core_0/u_t015_010/c1_w1_bl
+ detronyx_12t_write_driver_rc1_9/wen detronyx_12t_write_driver_rc1_9/wen detronyx_12t_write_driver_rc1_9/wen
+ detronyx_12t_write_driver_rc1_9/wen detronyx_12t_write_driver_rc1_9/wen gf180mcu_3v3_12t_2r2w_sram_512x32_array_control_core_0/u_t025_003/r3_w1_wl
+ detronyx_12t_write_driver_rc1_9/wen detronyx_12t_write_driver_rc1_9/wen detronyx_12t_write_driver_rc1_9/wen
+ gf180mcu_3v3_12t_2r2w_sram_512x32_array_control_core_0/u_t026_015/c1_w1_bl detronyx_12t_write_driver_rc1_9/wen
+ detronyx_12t_write_driver_rc1_9/wen gf180mcu_3v3_12t_2r2w_sram_512x32_array_control_core_0/u_t013_003/r3_w1_wl
+ gf180mcu_3v3_12t_2r2w_sram_512x32_array_control_core_0/u_t009_024/c1_w0_bl detronyx_12t_write_driver_rc1_9/wen
+ detronyx_12t_write_driver_rc1_9/wen gf180mcu_3v3_12t_2r2w_sram_512x32_array_control_core_0/u_t000_002/c1_w1_bl
+ gf180mcu_3v3_12t_2r2w_sram_512x32_array_control_core_0/u_t013_018/c1_w1_bl detronyx_12t_write_driver_rc1_9/wen
+ detronyx_12t_write_driver_rc1_9/wen detronyx_12t_write_driver_rc1_9/wen detronyx_12t_write_driver_rc1_9/wen
+ detronyx_12t_write_driver_rc1_9/wen detronyx_12t_write_driver_rc1_9/wen gf180mcu_3v3_12t_2r2w_sram_512x32_array_control_core_0/u_t030_009/c1_w1_bl
+ detronyx_12t_write_driver_rc1_9/wen detronyx_12t_write_driver_rc1_9/wen detronyx_12t_write_driver_rc1_9/wen
+ detronyx_12t_write_driver_rc1_9/wen gf180mcu_3v3_12t_2r2w_sram_512x32_array_control_core_0/u_t026_017/c1_w1_bl
+ gf180mcu_3v3_12t_2r2w_sram_512x32_array_control_core_0/u_t004_018/VDD detronyx_12t_write_driver_rc1_9/wen
+ detronyx_12t_write_driver_rc1_9/wen detronyx_12t_write_driver_rc1_9/wen detronyx_12t_write_driver_rc1_9/wen
+ gf180mcu_3v3_12t_2r2w_sram_512x32_array_control_core_0/u_t002_030/r2_w0_wl gf180mcu_3v3_12t_2r2w_sram_512x32_array_control_core_0/u_t005_026/c1_w0_bl
+ detronyx_12t_write_driver_rc1_9/wen detronyx_12t_write_driver_rc1_9/wen gf180mcu_3v3_12t_2r2w_sram_512x32_array_control_core_0/u_t017_023/c3_w1_bl
+ gf180mcu_3v3_12t_2r2w_sram_512x32_array_control_core_0/u_t030_022/c3_w1_bl detronyx_12t_write_driver_rc1_9/wen
+ detronyx_12t_write_driver_rc1_9/wen gf180mcu_3v3_12t_2r2w_sram_512x32_array_control_core_0/u_t021_030/r3_w0_wl
+ detronyx_12t_write_driver_rc1_9/wen detronyx_12t_write_driver_rc1_9/wen detronyx_12t_write_driver_rc1_9/wen
+ detronyx_12t_write_driver_rc1_9/wen detronyx_12t_write_driver_rc1_9/wen gf180mcu_3v3_12t_2r2w_sram_512x32_array_control_core_0/u_t013_031/r3_w0_wl
+ detronyx_12t_write_driver_rc1_9/wen detronyx_12t_write_driver_rc1_9/wen detronyx_12t_write_driver_rc1_9/wen
+ detronyx_12t_write_driver_rc1_9/wen gf180mcu_3v3_12t_2r2w_sram_512x32_array_control_core_0/u_t030_022/c3_w1_bl
+ detronyx_12t_write_driver_rc1_9/wen gf180mcu_3v3_12t_2r2w_sram_512x32_array_control_core_0/u_t019_030/r2_w0_wl
+ gf180mcu_3v3_12t_2r2w_sram_512x32_array_control_core_0/u_t001_015/c3_w1_bl detronyx_12t_write_driver_rc1_9/wen
+ detronyx_12t_write_driver_rc1_9/wen detronyx_12t_write_driver_rc1_9/wen gf180mcu_3v3_12t_2r2w_sram_512x32_array_control_core_0/u_t009_031/r3_w0_wl
+ detronyx_12t_write_driver_rc1_9/wen detronyx_12t_write_driver_rc1_9/wen detronyx_12t_write_driver_rc1_9/wen
+ gf180mcu_3v3_12t_2r2w_sram_512x32_array_control_core_0/u_t022_001/r3_w1_wl detronyx_12t_write_driver_rc1_9/wen
+ detronyx_12t_write_driver_rc1_9/wen detronyx_12t_write_driver_rc1_9/wen detronyx_12t_write_driver_rc1_9/wen
+ gf180mcu_3v3_12t_2r2w_sram_512x32_array_control_core_0/u_t020_000/r1_w1_wl gf180mcu_3v3_12t_2r2w_sram_512x32_array_control_core_0/u_t009_031/r3_w0_wl
+ gf180mcu_3v3_12t_2r2w_sram_512x32_array_control_core_0/u_t010_001/r2_w1_wl gf180mcu_3v3_12t_2r2w_sram_512x32_array_control_core_0/u_t005_022/c1_w0_bl
+ detronyx_12t_write_driver_rc1_9/wen detronyx_12t_write_driver_rc1_9/wen gf180mcu_3v3_12t_2r2w_sram_512x32_array_control_core_0/u_t026_024/c3_w0_bl
+ detronyx_12t_write_driver_rc1_9/wen gf180mcu_3v3_12t_2r2w_sram_512x32_array_control_core_0/a_14200_59000#
+ detronyx_12t_write_driver_rc1_9/wen gf180mcu_3v3_12t_2r2w_sram_512x32_array_control_core_0/u_t010_010/c1_w1_bl
+ detronyx_12t_write_driver_rc1_9/wen detronyx_12t_write_driver_rc1_9/wen gf180mcu_3v3_12t_2r2w_sram_512x32_array_control_core_0/u_t017_008/c3_w1_bl
+ gf180mcu_3v3_12t_2r2w_sram_512x32_array_control_core_0/u_t021_003/r0_w1_wl detronyx_12t_write_driver_rc1_9/wen
+ gf180mcu_3v3_12t_2r2w_sram_512x32_array_control_core_0/u_t009_016/c1_w1_bl gf180mcu_3v3_12t_2r2w_sram_512x32_array_control_core_0/u_t027_001/c1_w1_bl
+ detronyx_12t_write_driver_rc1_9/wen gf180mcu_3v3_12t_2r2w_sram_512x32_array_control_core_0/u_t021_015/c1_w1_bl
+ gf180mcu_3v3_12t_2r2w_sram_512x32_array_control_core_0/u_t009_010/c1_w1_bl gf180mcu_3v3_12t_2r2w_sram_512x32_array_control_core_0/u_t028_002/r1_w1_wl
+ gf180mcu_3v3_12t_2r2w_sram_512x32_array_control_core_0/a_22600_50600# gf180mcu_3v3_12t_2r2w_sram_512x32_array_control_core_0/u_t030_018/c3_w1_bl
+ gf180mcu_3v3_12t_2r2w_sram_512x32_array_control_core_0/u_t002_024/c1_w0_bl detronyx_12t_write_driver_rc1_9/wen
+ detronyx_12t_write_driver_rc1_9/wen gf180mcu_3v3_12t_2r2w_sram_512x32_array_control_core_0/u_t019_015/c1_w1_bl
+ detronyx_12t_write_driver_rc1_9/wen gf180mcu_3v3_12t_2r2w_sram_512x32_array_control_core_0/u_t016_002/r0_w1_wl
+ detronyx_12t_write_driver_rc1_9/wen gf180mcu_3v3_12t_2r2w_sram_512x32_array_control_core_0/a_200_8600#
+ gf180mcu_3v3_12t_2r2w_sram_512x32_array_control_core_0/u_t006_003/r2_w1_wl gf180mcu_3v3_12t_2r2w_sram_512x32_array_control_core_0/u_t025_009/c1_w1_bl
+ detronyx_12t_write_driver_rc1_9/wen detronyx_12t_write_driver_rc1_9/wen detronyx_12t_write_driver_rc1_9/wen
+ detronyx_12t_write_driver_rc1_9/wen gf180mcu_3v3_12t_2r2w_sram_512x32_array_control_core_0/u_t005_018/c1_w1_bl
+ detronyx_12t_write_driver_rc1_9/wen gf180mcu_3v3_12t_2r2w_sram_512x32_array_control_core_0/u_t025_003/c1_w1_bl
+ detronyx_12t_write_driver_rc1_9/wen detronyx_12t_write_driver_rc1_9/wen detronyx_12t_write_driver_rc1_9/wen
+ detronyx_12t_write_driver_rc1_9/wen gf180mcu_3v3_12t_2r2w_sram_512x32_array_control_core_0/u_t013_023/c3_w1_bl
+ detronyx_12t_write_driver_rc1_9/wen detronyx_12t_write_driver_rc1_9/wen gf180mcu_3v3_12t_2r2w_sram_512x32_array_control_core_0/u_t017_017/c1_w1_bl
+ detronyx_12t_write_driver_rc1_9/wen detronyx_12t_write_driver_rc1_9/wen detronyx_12t_write_driver_rc1_9/wen
+ detronyx_12t_write_driver_rc1_9/wen detronyx_12t_write_driver_rc1_9/wen detronyx_12t_write_driver_rc1_9/wen
+ detronyx_12t_write_driver_rc1_9/wen gf180mcu_3v3_12t_2r2w_sram_512x32_array_control_core_0/a_22600_89800#
+ gf180mcu_3v3_12t_2r2w_sram_512x32_array_control_core_0/u_t009_023/c3_w1_bl gf180mcu_3v3_12t_2r2w_sram_512x32_array_control_core_0/u_t027_031/r2_w0_wl
+ detronyx_12t_write_driver_rc1_9/wen gf180mcu_3v3_12t_2r2w_sram_512x32_array_control_core_0/u_t023_022/c3_w1_bl
+ gf180mcu_3v3_12t_2r2w_sram_512x32_array_control_core_0/u_t014_030/r2_w0_wl detronyx_12t_write_driver_rc1_9/wen
+ detronyx_12t_write_driver_rc1_9/wen detronyx_12t_write_driver_rc1_9/wen detronyx_12t_write_driver_rc1_9/wen
+ gf180mcu_3v3_12t_2r2w_sram_512x32_array_control_core_0/u_t005_031/r3_w0_wl gf180mcu_3v3_12t_2r2w_sram_512x32_array_control_core_0/u_t015_031/r2_w0_wl
+ detronyx_12t_write_driver_rc1_9/wen detronyx_12t_write_driver_rc1_9/wen detronyx_12t_write_driver_rc1_9/wen
+ detronyx_12t_write_driver_rc1_9/wen detronyx_12t_write_driver_rc1_9/wen detronyx_12t_write_driver_rc1_9/wen
+ detronyx_12t_write_driver_rc1_9/wen detronyx_12t_write_driver_rc1_9/wen gf180mcu_3v3_12t_2r2w_sram_512x32_array_control_core_0/u_t005_031/r3_w0_wl
+ detronyx_12t_write_driver_rc1_9/wen gf180mcu_3v3_12t_2r2w_sram_512x32_array_control_core_0/u_t026_016/c3_w1_bl
+ detronyx_12t_write_driver_rc1_9/wen gf180mcu_3v3_12t_2r2w_sram_512x32_array_control_core_0/u_t002_003/VSS
+ detronyx_12t_write_driver_rc1_9/wen detronyx_12t_write_driver_rc1_9/wen gf180mcu_3v3_12t_2r2w_sram_512x32_array_control_core_0/u_t027_010/c3_w1_bl
+ detronyx_12t_write_driver_rc1_9/wen gf180mcu_3v3_12t_2r2w_sram_512x32_array_control_core_0/u_t021_024/c3_w0_bl
+ gf180mcu_3v3_12t_2r2w_sram_512x32_array_control_core_0/gf180mcu_as_sc_mcu7t3v3__inv_2_1682/Y
+ detronyx_12t_write_driver_rc1_9/wen detronyx_12t_write_driver_rc1_9/wen detronyx_12t_write_driver_rc1_9/wen
+ detronyx_12t_write_driver_rc1_9/wen detronyx_12t_write_driver_rc1_9/wen detronyx_12t_write_driver_rc1_9/wen
+ gf180mcu_3v3_12t_2r2w_sram_512x32_array_control_core_0/u_t030_023/c1_w0_bl gf180mcu_3v3_12t_2r2w_sram_512x32_array_control_core_0/u_t013_008/c3_w1_bl
+ gf180mcu_3v3_12t_2r2w_sram_512x32_array_control_core_0/u_t022_001/c1_w1_bl gf180mcu_3v3_12t_2r2w_sram_512x32_array_control_core_0/u_t002_016/c1_w1_bl
+ detronyx_12t_write_driver_rc1_9/wen gf180mcu_3v3_12t_2r2w_sram_512x32_array_control_core_0/u_t019_024/c3_w0_bl
+ detronyx_12t_write_driver_rc1_9/wen detronyx_12t_write_driver_rc1_9/wen detronyx_12t_write_driver_rc1_9/wen
+ gf180mcu_3v3_12t_2r2w_sram_512x32_array_control_core_0/u_t023_002/r2_w1_wl gf180mcu_3v3_12t_2r2w_sram_512x32_array_control_core_0/u_t004_010/c1_w1_bl
+ detronyx_12t_write_driver_rc1_9/wen detronyx_12t_write_driver_rc1_9/wen gf180mcu_3v3_12t_2r2w_sram_512x32_array_control_core_0/u_t025_018/c3_w1_bl
+ detronyx_12t_write_driver_rc1_9/wen gf180mcu_3v3_12t_2r2w_sram_512x32_array_control_core_0/u_t013_003/r3_w1_wl
+ gf180mcu_3v3_12t_2r2w_sram_512x32_array_control_core_0/u_t009_008/c3_w1_bl detronyx_12t_write_driver_rc1_9/wen
+ detronyx_12t_write_driver_rc1_9/wen gf180mcu_3v3_12t_2r2w_sram_512x32_array_control_core_0/u_t014_015/c1_w1_bl
+ detronyx_12t_write_driver_rc1_9/wen detronyx_12t_write_driver_rc1_9/wen detronyx_12t_write_driver_rc1_9/wen
+ gf180mcu_3v3_12t_2r2w_sram_512x32_array_control_core_0/u_t011_002/r1_w1_wl detronyx_12t_write_driver_rc1_9/wen
+ gf180mcu_3v3_12t_2r2w_sram_512x32_array_control_core_0/u_t001_003/r2_w1_wl detronyx_12t_write_driver_rc1_9/wen
+ detronyx_12t_write_driver_rc1_9/wen detronyx_12t_write_driver_rc1_9/wen gf180mcu_3v3_12t_2r2w_sram_512x32_array_control_core_0/u_t027_025/c1_w0_bl
+ gf180mcu_3v3_12t_2r2w_sram_512x32_array_control_core_0/u_t002_018/VSS detronyx_12t_write_driver_rc1_9/wen
+ gf180mcu_3v3_12t_2r2w_sram_512x32_array_control_core_0/u_t021_003/c1_w1_bl detronyx_12t_write_driver_rc1_9/wen
+ detronyx_12t_write_driver_rc1_9/wen gf180mcu_3v3_12t_2r2w_sram_512x32_array_control_core_0/a_14200_39400#
+ detronyx_12t_write_driver_rc1_9/wen detronyx_12t_write_driver_rc1_9/wen gf180mcu_3v3_12t_2r2w_sram_512x32_array_control_core_0/u_t017_009/c1_w1_bl
+ detronyx_12t_write_driver_rc1_9/wen detronyx_12t_write_driver_rc1_9/wen detronyx_12t_write_driver_rc1_9/wen
+ detronyx_12t_write_driver_rc1_9/wen detronyx_12t_write_driver_rc1_9/wen detronyx_12t_write_driver_rc1_9/wen
+ detronyx_12t_write_driver_rc1_9/wen gf180mcu_3v3_12t_2r2w_sram_512x32_array_control_core_0/u_t018_003/c1_w1_bl
+ gf180mcu_3v3_12t_2r2w_sram_512x32_array_control_core_0/u_t013_017/c1_w1_bl detronyx_12t_write_driver_rc1_9/wen
+ detronyx_12t_write_driver_rc1_9/wen detronyx_12t_write_driver_rc1_9/wen detronyx_12t_write_driver_rc1_9/wen
+ gf180mcu_3v3_12t_2r2w_sram_512x32_array_control_core_0/u_t002_018/VSS detronyx_12t_write_driver_rc1_9/wen
+ gf180mcu_3v3_12t_2r2w_sram_512x32_array_control_core_0/u_t005_023/c3_w1_bl gf180mcu_3v3_12t_2r2w_sram_512x32_array_control_core_0/u_t022_031/r3_w0_wl
+ detronyx_12t_write_driver_rc1_9/wen detronyx_12t_write_driver_rc1_9/wen detronyx_12t_write_driver_rc1_9/wen
+ detronyx_12t_write_driver_rc1_9/wen detronyx_12t_write_driver_rc1_9/wen detronyx_12t_write_driver_rc1_9/wen
+ detronyx_12t_write_driver_rc1_9/wen detronyx_12t_write_driver_rc1_9/wen detronyx_12t_write_driver_rc1_9/wen
+ gf180mcu_3v3_12t_2r2w_sram_512x32_array_control_core_0/u_t010_031/r2_w0_wl gf180mcu_3v3_12t_2r2w_sram_512x32_array_control_core_0/u_t017_022/c3_w1_bl
+ detronyx_12t_write_driver_rc1_9/wen detronyx_12t_write_driver_rc1_9/wen gf180mcu_3v3_12t_2r2w_sram_512x32_array_control_core_0/u_t007_030/r1_w0_wl
+ detronyx_12t_write_driver_rc1_9/wen gf180mcu_3v3_12t_2r2w_sram_512x32_array_control_core_0/u_t020_000/r1_w1_wl
+ detronyx_12t_write_driver_rc1_9/wen detronyx_12t_write_driver_rc1_9/wen gf180mcu_3v3_12t_2r2w_sram_512x32_array_control_core_0/u_t021_016/c3_w1_bl
+ detronyx_12t_write_driver_rc1_9/wen detronyx_12t_write_driver_rc1_9/wen detronyx_12t_write_driver_rc1_9/wen
+ detronyx_12t_write_driver_rc1_9/wen detronyx_12t_write_driver_rc1_9/wen gf180mcu_3v3_12t_2r2w_sram_512x32_array_control_core_0/u_t022_010/c3_w1_bl
+ gf180mcu_3v3_12t_2r2w_sram_512x32_array_control_core_0/u_t030_015/c1_w1_bl detronyx_12t_write_driver_rc1_9/wen
+ gf180mcu_3v3_12t_2r2w_sram_512x32_array_control_core_0/u_t018_000/r2_w1_wl detronyx_12t_write_driver_rc1_9/wen
+ detronyx_12t_write_driver_rc1_9/wen gf180mcu_3v3_12t_2r2w_sram_512x32_array_control_core_0/u_t019_016/c3_w1_bl
+ detronyx_12t_write_driver_rc1_9/wen gf180mcu_3v3_12t_2r2w_sram_512x32_array_control_core_0/u_t008_001/r3_w1_wl
+ gf180mcu_3v3_12t_2r2w_sram_512x32_array_control_core_0/u_t030_002/r3_w1_wl gf180mcu_3v3_12t_2r2w_sram_512x32_array_control_core_0/u_t026_023/c1_w0_bl
+ detronyx_12t_write_driver_rc1_9/wen gf180mcu_3v3_12t_2r2w_sram_512x32_array_control_core_0/u_t014_024/c3_w0_bl
+ detronyx_12t_write_driver_rc1_9/wen detronyx_12t_write_driver_rc1_9/wen detronyx_12t_write_driver_rc1_9/wen
+ gf180mcu_3v3_12t_2r2w_sram_512x32_array_control_core_0/u_t004_008/c3_w1_bl gf180mcu_3v3_12t_2r2w_sram_512x32_array_control_core_0/u_t030_011/c1_w1_bl
+ detronyx_12t_write_driver_rc1_9/wen gf180mcu_3v3_12t_2r2w_sram_512x32_array_control_core_0/u_t015_001/c1_w1_bl
+ detronyx_12t_write_driver_rc1_9/wen detronyx_12t_write_driver_rc1_9/wen gf180mcu_3v3_12t_2r2w_sram_512x32_array_control_core_0/u_t027_017/c1_w1_bl
+ detronyx_12t_write_driver_rc1_9/wen gf180mcu_3v3_12t_2r2w_sram_512x32_array_control_core_0/u_t017_018/c3_w1_bl
+ detronyx_12t_write_driver_rc1_9/wen detronyx_12t_write_driver_rc1_9/wen gf180mcu_3v3_12t_2r2w_sram_512x32_array_control_core_0/u_t030_011/c1_w1_bl
+ gf180mcu_3v3_12t_2r2w_sram_512x32_array_control_core_0/u_t022_025/c1_w0_bl gf180mcu_3v3_12t_2r2w_sram_512x32_array_control_core_0/u_t009_015/c1_w1_bl
+ detronyx_12t_write_driver_rc1_9/wen gf180mcu_3v3_12t_2r2w_sram_512x32_array_control_core_0/u_t004_002/r0_w1_wl
+ detronyx_12t_write_driver_rc1_9/wen gf180mcu_3v3_12t_2r2w_sram_512x32_array_control_core_0/u_t013_009/c1_w1_bl
+ detronyx_12t_write_driver_rc1_9/wen detronyx_12t_write_driver_rc1_9/wen detronyx_12t_write_driver_rc1_9/wen
+ gf180mcu_3v3_12t_2r2w_sram_512x32_array_control_core_0/u_t013_003/c1_w1_bl detronyx_12t_write_driver_rc1_9/wen
+ detronyx_12t_write_driver_rc1_9/wen detronyx_12t_write_driver_rc1_9/wen detronyx_12t_write_driver_rc1_9/wen
+ detronyx_12t_write_driver_rc1_9/wen detronyx_12t_write_driver_rc1_9/wen gf180mcu_3v3_12t_2r2w_sram_512x32_array_control_core_0/u_t026_030/c3_w0_bl
+ detronyx_12t_write_driver_rc1_9/wen detronyx_12t_write_driver_rc1_9/wen detronyx_12t_write_driver_rc1_9/wen
+ detronyx_12t_write_driver_rc1_9/wen detronyx_12t_write_driver_rc1_9/wen detronyx_12t_write_driver_rc1_9/wen
+ detronyx_12t_write_driver_rc1_9/wen detronyx_12t_write_driver_rc1_9/wen gf180mcu_3v3_12t_2r2w_sram_512x32_array_control_core_0/u_t005_017/c1_w1_bl
+ detronyx_12t_write_driver_rc1_9/wen gf180mcu_3v3_12t_2r2w_sram_512x32_array_control_core_0/a_28200_120600#
+ detronyx_12t_write_driver_rc1_9/wen detronyx_12t_write_driver_rc1_9/wen gf180mcu_3v3_12t_2r2w_sram_512x32_array_control_core_0/u_t025_030/r3_w0_wl
+ detronyx_12t_write_driver_rc1_9/wen detronyx_12t_write_driver_rc1_9/wen gf180mcu_3v3_12t_2r2w_sram_512x32_array_control_core_0/u_t015_031/r2_w0_wl
+ detronyx_12t_write_driver_rc1_9/wen detronyx_12t_write_driver_rc1_9/wen gf180mcu_3v3_12t_2r2w_sram_512x32_array_control_core_0/u_t013_022/c3_w1_bl
+ detronyx_12t_write_driver_rc1_9/wen detronyx_12t_write_driver_rc1_9/wen gf180mcu_3v3_12t_2r2w_sram_512x32_array_control_core_0/a_14200_92600#
+ detronyx_12t_write_driver_rc1_9/wen gf180mcu_3v3_12t_2r2w_sram_512x32_array_control_core_0/u_t002_030/r2_w0_wl
+ gf180mcu_3v3_12t_2r2w_sram_512x32_array_control_core_0/a_14200_19800# detronyx_12t_write_driver_rc1_9/wen
+ detronyx_12t_write_driver_rc1_9/wen gf180mcu_3v3_12t_2r2w_sram_512x32_array_control_core_0/a_22600_98200#
+ detronyx_12t_write_driver_rc1_9/wen gf180mcu_3v3_12t_2r2w_sram_512x32_array_control_core_0/u_t005_031/r3_w0_wl
+ detronyx_12t_write_driver_rc1_9/wen detronyx_12t_write_driver_rc1_9/wen detronyx_12t_write_driver_rc1_9/wen
+ detronyx_12t_write_driver_rc1_9/wen detronyx_12t_write_driver_rc1_9/wen detronyx_12t_write_driver_rc1_9/wen
+ gf180mcu_3v3_12t_2r2w_sram_512x32_array_control_core_0/u_t009_022/c3_w1_bl detronyx_12t_write_driver_rc1_9/wen
+ detronyx_12t_write_driver_rc1_9/wen gf180mcu_3v3_12t_2r2w_sram_512x32_array_control_core_0/u_t025_015/c1_w1_bl
+ detronyx_12t_write_driver_rc1_9/wen detronyx_12t_write_driver_rc1_9/wen detronyx_12t_write_driver_rc1_9/wen
+ detronyx_12t_write_driver_rc1_9/wen gf180mcu_3v3_12t_2r2w_sram_512x32_array_control_core_0/u_t014_016/c3_w1_bl
+ gf180mcu_3v3_12t_2r2w_sram_512x32_array_control_core_0/u_t004_001/r0_w1_wl detronyx_12t_write_driver_rc1_9/wen
+ detronyx_12t_write_driver_rc1_9/wen gf180mcu_3v3_12t_2r2w_sram_512x32_array_control_core_0/u_t015_010/c3_w1_bl
+ detronyx_12t_write_driver_rc1_9/wen detronyx_12t_write_driver_rc1_9/wen detronyx_12t_write_driver_rc1_9/wen
+ gf180mcu_3v3_12t_2r2w_sram_512x32_array_control_core_0/u_t023_002/r2_w1_wl gf180mcu_3v3_12t_2r2w_sram_512x32_array_control_core_0/u_t017_023/c1_w0_bl
+ detronyx_12t_write_driver_rc1_9/wen detronyx_12t_write_driver_rc1_9/wen gf180mcu_3v3_12t_2r2w_sram_512x32_array_control_core_0/u_t010_001/c1_w1_bl
+ gf180mcu_3v3_12t_2r2w_sram_512x32_array_control_core_0/u_t009_024/c3_w0_bl detronyx_12t_write_driver_rc1_9/wen
+ detronyx_12t_write_driver_rc1_9/wen detronyx_12t_write_driver_rc1_9/wen gf180mcu_3v3_12t_2r2w_sram_512x32_array_control_core_0/u_t022_017/c1_w1_bl
+ detronyx_12t_write_driver_rc1_9/wen gf180mcu_3v3_12t_2r2w_sram_512x32_array_control_core_0/u_t011_002/r1_w1_wl
+ detronyx_12t_write_driver_rc1_9/wen detronyx_12t_write_driver_rc1_9/wen gf180mcu_3v3_12t_2r2w_sram_512x32_array_control_core_0/u_t013_018/c3_w1_bl
+ detronyx_12t_write_driver_rc1_9/wen gf180mcu_3v3_12t_2r2w_sram_512x32_array_control_core_0/u_t023_011/c1_w1_bl
+ gf180mcu_3v3_12t_2r2w_sram_512x32_array_control_core_0/u_t008_001/c1_w1_bl gf180mcu_3v3_12t_2r2w_sram_512x32_array_control_core_0/gf180mcu_as_sc_mcu7t3v3__inv_2_635/Y
+ gf180mcu_3v3_12t_2r2w_sram_512x32_array_control_core_0/u_t030_009/c3_w1_bl gf180mcu_3v3_12t_2r2w_sram_512x32_array_control_core_0/u_t002_015/c1_w1_bl
+ detronyx_12t_write_driver_rc1_9/wen detronyx_12t_write_driver_rc1_9/wen detronyx_12t_write_driver_rc1_9/wen
+ gf180mcu_3v3_12t_2r2w_sram_512x32_array_control_core_0/u_t015_025/c1_w0_bl gf180mcu_3v3_12t_2r2w_sram_512x32_array_control_core_0/u_t026_022/c3_w1_bl
+ detronyx_12t_write_driver_rc1_9/wen detronyx_12t_write_driver_rc1_9/wen detronyx_12t_write_driver_rc1_9/wen
+ detronyx_12t_write_driver_rc1_9/wen gf180mcu_3v3_12t_2r2w_sram_512x32_array_control_core_0/u_t029_003/r0_w1_wl
+ gf180mcu_3v3_12t_2r2w_sram_512x32_array_control_core_0/u_t021_030/c3_w0_bl gf180mcu_3v3_12t_2r2w_sram_512x32_array_control_core_0/u_t005_009/c1_w1_bl
+ detronyx_12t_write_driver_rc1_9/wen detronyx_12t_write_driver_rc1_9/wen detronyx_12t_write_driver_rc1_9/wen
+ detronyx_12t_write_driver_rc1_9/wen detronyx_12t_write_driver_rc1_9/wen detronyx_12t_write_driver_rc1_9/wen
+ gf180mcu_3v3_12t_2r2w_sram_512x32_array_control_core_0/u_t006_003/c1_w1_bl gf180mcu_3v3_12t_2r2w_sram_512x32_array_control_core_0/u_t022_031/r3_w0_wl
+ detronyx_12t_write_driver_rc1_9/wen detronyx_12t_write_driver_rc1_9/wen gf180mcu_3v3_12t_2r2w_sram_512x32_array_control_core_0/u_t020_030/r1_w0_wl
+ gf180mcu_3v3_12t_2r2w_sram_512x32_array_control_core_0/u_t019_030/c3_w0_bl detronyx_12t_write_driver_rc1_9/wen
+ detronyx_12t_write_driver_rc1_9/wen gf180mcu_3v3_12t_2r2w_sram_512x32_array_control_core_0/u_t010_031/r2_w0_wl
+ detronyx_12t_write_driver_rc1_9/wen detronyx_12t_write_driver_rc1_9/wen detronyx_12t_write_driver_rc1_9/wen
+ detronyx_12t_write_driver_rc1_9/wen detronyx_12t_write_driver_rc1_9/wen detronyx_12t_write_driver_rc1_9/wen
+ detronyx_12t_write_driver_rc1_9/wen detronyx_12t_write_driver_rc1_9/wen detronyx_12t_write_driver_rc1_9/wen
+ detronyx_12t_write_driver_rc1_9/wen detronyx_12t_write_driver_rc1_9/wen detronyx_12t_write_driver_rc1_9/wen
+ detronyx_12t_write_driver_rc1_9/wen detronyx_12t_write_driver_rc1_9/wen detronyx_12t_write_driver_rc1_9/wen
+ detronyx_12t_write_driver_rc1_9/wen detronyx_12t_write_driver_rc1_9/wen gf180mcu_3v3_12t_2r2w_sram_512x32_array_control_core_0/u_t005_022/c3_w1_bl
+ detronyx_12t_write_driver_rc1_9/wen detronyx_12t_write_driver_rc1_9/wen gf180mcu_3v3_12t_2r2w_sram_512x32_array_control_core_0/u_t027_031/r2_w0_wl
+ gf180mcu_3v3_12t_2r2w_sram_512x32_array_control_core_0/u_t018_000/r2_w1_wl gf180mcu_3v3_12t_2r2w_sram_512x32_array_control_core_0/u_t026_007/c3_w1_bl
+ gf180mcu_3v3_12t_2r2w_sram_512x32_array_control_core_0/u_t030_002/r3_w1_wl gf180mcu_3v3_12t_2r2w_sram_512x32_array_control_core_0/u_t010_010/c3_w1_bl
+ gf180mcu_3v3_12t_2r2w_sram_512x32_array_control_core_0/u_t017_015/c1_w1_bl detronyx_12t_write_driver_rc1_9/wen
+ detronyx_12t_write_driver_rc1_9/wen detronyx_12t_write_driver_rc1_9/wen gf180mcu_3v3_12t_2r2w_sram_512x32_array_control_core_0/u_t006_000/r2_w1_wl
+ gf180mcu_3v3_12t_2r2w_sram_512x32_array_control_core_0/u_t009_016/c3_w1_bl gf180mcu_3v3_12t_2r2w_sram_512x32_array_control_core_0/a_200_95400#
+ gf180mcu_3v3_12t_2r2w_sram_512x32_array_control_core_0/u_t013_023/c1_w0_bl detronyx_12t_write_driver_rc1_9/wen
+ gf180mcu_3v3_12t_2r2w_sram_512x32_array_control_core_0/u_t009_010/c3_w1_bl gf180mcu_3v3_12t_2r2w_sram_512x32_array_control_core_0/u_t002_024/c3_w0_bl
+ detronyx_12t_write_driver_rc1_9/wen detronyx_12t_write_driver_rc1_9/wen detronyx_12t_write_driver_rc1_9/wen
+ gf180mcu_3v3_12t_2r2w_sram_512x32_array_control_core_0/a_22600_78600# detronyx_12t_write_driver_rc1_9/wen
+ detronyx_12t_write_driver_rc1_9/wen detronyx_12t_write_driver_rc1_9/wen detronyx_12t_write_driver_rc1_9/wen
+ gf180mcu_3v3_12t_2r2w_sram_512x32_array_control_core_0/u_t004_001/c1_w1_bl gf180mcu_3v3_12t_2r2w_sram_512x32_array_control_core_0/u_t025_009/c3_w1_bl
+ gf180mcu_3v3_12t_2r2w_sram_512x32_array_control_core_0/u_t015_017/c1_w1_bl detronyx_12t_write_driver_rc1_9/wen
+ gf180mcu_3v3_12t_2r2w_sram_512x32_array_control_core_0/u_t005_018/c3_w1_bl gf180mcu_3v3_12t_2r2w_sram_512x32_array_control_core_0/u_t017_011/c1_w1_bl
+ gf180mcu_3v3_12t_2r2w_sram_512x32_array_control_core_0/u_t010_025/c1_w0_bl gf180mcu_3v3_12t_2r2w_sram_512x32_array_control_core_0/u_t021_022/c3_w1_bl
+ detronyx_12t_write_driver_rc1_9/wen detronyx_12t_write_driver_rc1_9/wen detronyx_12t_write_driver_rc1_9/wen
+ detronyx_12t_write_driver_rc1_9/wen gf180mcu_3v3_12t_2r2w_sram_512x32_array_control_core_0/u_t027_016/c1_w1_bl
+ gf180mcu_3v3_12t_2r2w_sram_512x32_array_control_core_0/u_t024_003/r1_w1_wl detronyx_12t_write_driver_rc1_9/wen
+ detronyx_12t_write_driver_rc1_9/wen detronyx_12t_write_driver_rc1_9/wen detronyx_12t_write_driver_rc1_9/wen
+ gf180mcu_3v3_12t_2r2w_sram_512x32_array_control_core_0/u_t009_025/c1_w0_bl detronyx_12t_write_driver_rc1_9/wen
+ detronyx_12t_write_driver_rc1_9/wen gf180mcu_3v3_12t_2r2w_sram_512x32_array_control_core_0/u_t019_022/c3_w1_bl
+ gf180mcu_3v3_12t_2r2w_sram_512x32_array_control_core_0/u_t001_003/c1_w1_bl detronyx_12t_write_driver_rc1_9/wen
+ detronyx_12t_write_driver_rc1_9/wen detronyx_12t_write_driver_rc1_9/wen gf180mcu_3v3_12t_2r2w_sram_512x32_array_control_core_0/u_t014_030/c3_w0_bl
+ detronyx_12t_write_driver_rc1_9/wen detronyx_12t_write_driver_rc1_9/wen detronyx_12t_write_driver_rc1_9/wen
+ detronyx_12t_write_driver_rc1_9/wen detronyx_12t_write_driver_rc1_9/wen detronyx_12t_write_driver_rc1_9/wen
+ detronyx_12t_write_driver_rc1_9/wen detronyx_12t_write_driver_rc1_9/wen gf180mcu_3v3_12t_2r2w_sram_512x32_array_control_core_0/u_t013_030/r3_w0_wl
+ detronyx_12t_write_driver_rc1_9/wen gf180mcu_3v3_12t_2r2w_sram_512x32_array_control_core_0/u_t026_018/c1_w1_bl
+ gf180mcu_3v3_12t_2r2w_sram_512x32_array_control_core_0/u_t004_003/VDD detronyx_12t_write_driver_rc1_9/wen
+ detronyx_12t_write_driver_rc1_9/wen gf180mcu_3v3_12t_2r2w_sram_512x32_array_control_core_0/u_t030_029/c3_w0_bl
+ gf180mcu_3v3_12t_2r2w_sram_512x32_array_control_core_0/u_t025_000/r3_w1_wl detronyx_12t_write_driver_rc1_9/wen
+ detronyx_12t_write_driver_rc1_9/wen detronyx_12t_write_driver_rc1_9/wen detronyx_12t_write_driver_rc1_9/wen
+ detronyx_12t_write_driver_rc1_9/wen gf180mcu_3v3_12t_2r2w_sram_512x32_array_control_core_0/u_t002_003/VSS
+ detronyx_12t_write_driver_rc1_9/wen gf180mcu_3v3_12t_2r2w_sram_512x32_array_control_core_0/u_t022_031/r3_w0_wl
+ gf180mcu_3v3_12t_2r2w_sram_512x32_array_control_core_0/gf180mcu_as_sc_mcu7t3v3__inv_2_361/Y
+ detronyx_12t_write_driver_rc1_9/wen gf180mcu_3v3_12t_2r2w_sram_512x32_array_control_core_0/u_t013_000/r3_w1_wl
+ detronyx_12t_write_driver_rc1_9/wen detronyx_12t_write_driver_rc1_9/wen detronyx_12t_write_driver_rc1_9/wen
+ gf180mcu_3v3_12t_2r2w_sram_512x32_array_control_core_0/a_14200_28200# gf180mcu_3v3_12t_2r2w_sram_512x32_array_control_core_0/u_t030_029/c3_w0_bl
+ gf180mcu_3v3_12t_2r2w_sram_512x32_array_control_core_0/u_t021_007/c3_w1_bl detronyx_12t_write_driver_rc1_9/wen
+ detronyx_12t_write_driver_rc1_9/wen gf180mcu_3v3_12t_2r2w_sram_512x32_array_control_core_0/u_t013_015/c1_w1_bl
+ gf180mcu_3v3_12t_2r2w_sram_512x32_array_control_core_0/u_t030_023/c3_w1_bl gf180mcu_3v3_12t_2r2w_sram_512x32_array_control_core_0/u_t002_016/c3_w1_bl
+ detronyx_12t_write_driver_rc1_9/wen detronyx_12t_write_driver_rc1_9/wen detronyx_12t_write_driver_rc1_9/wen
+ detronyx_12t_write_driver_rc1_9/wen gf180mcu_3v3_12t_2r2w_sram_512x32_array_control_core_0/u_t019_007/c3_w1_bl
+ gf180mcu_3v3_12t_2r2w_sram_512x32_array_control_core_0/u_t004_010/c3_w1_bl detronyx_12t_write_driver_rc1_9/wen
+ detronyx_12t_write_driver_rc1_9/wen detronyx_12t_write_driver_rc1_9/wen gf180mcu_3v3_12t_2r2w_sram_512x32_array_control_core_0/u_t021_001/r0_w1_wl
+ detronyx_12t_write_driver_rc1_9/wen detronyx_12t_write_driver_rc1_9/wen gf180mcu_3v3_12t_2r2w_sram_512x32_array_control_core_0/u_t005_023/c1_w0_bl
+ detronyx_12t_write_driver_rc1_9/wen gf180mcu_3v3_12t_2r2w_sram_512x32_array_control_core_0/u_t010_017/c1_w1_bl
+ gf180mcu_3v3_12t_2r2w_sram_512x32_array_control_core_0/u_t030_002/c1_w1_bl detronyx_12t_write_driver_rc1_9/wen
+ gf180mcu_3v3_12t_2r2w_sram_512x32_array_control_core_0/u_t027_025/c3_w0_bl detronyx_12t_precharge_sense_rc1_4/ren
+ gf180mcu_3v3_12t_2r2w_sram_512x32_array_control_core_0/u_t009_002/r3_w1_wl gf180mcu_3v3_12t_2r2w_sram_512x32_array_control_core_0/u_t027_008/c1_w1_bl
+ gf180mcu_3v3_12t_2r2w_sram_512x32_array_control_core_0/u_t013_011/c1_w1_bl detronyx_12t_write_driver_rc1_9/wen
+ detronyx_12t_write_driver_rc1_9/wen detronyx_12t_write_driver_rc1_9/wen gf180mcu_3v3_12t_2r2w_sram_512x32_array_control_core_0/u_t017_009/c3_w1_bl
+ detronyx_12t_write_driver_rc1_9/wen detronyx_12t_write_driver_rc1_9/wen detronyx_12t_write_driver_rc1_9/wen
+ gf180mcu_3v3_12t_2r2w_sram_512x32_array_control_core_0/u_t028_002/c1_w1_bl gf180mcu_3v3_12t_2r2w_sram_512x32_array_control_core_0/u_t009_017/c1_w1_bl
+ gf180mcu_3v3_12t_2r2w_sram_512x32_array_control_core_0/u_t022_016/c1_w1_bl gf180mcu_3v3_12t_2r2w_sram_512x32_array_control_core_0/a_200_75800#
+ gf180mcu_3v3_12t_2r2w_sram_512x32_array_control_core_0/a_22600_103800# detronyx_12t_write_driver_rc1_9/wen
+ gf180mcu_3v3_12t_2r2w_sram_512x32_array_control_core_0/u_t009_011/c1_w1_bl gf180mcu_3v3_12t_2r2w_sram_512x32_array_control_core_0/u_t014_022/c3_w1_bl
+ gf180mcu_3v3_12t_2r2w_sram_512x32_array_control_core_0/u_t005_025/c1_w0_bl detronyx_12t_write_driver_rc1_9/wen
+ detronyx_12t_write_driver_rc1_9/wen detronyx_12t_write_driver_rc1_9/wen detronyx_12t_write_driver_rc1_9/wen
+ gf180mcu_3v3_12t_2r2w_sram_512x32_array_control_core_0/u_t017_003/r0_w1_wl detronyx_12t_write_driver_rc1_9/wen
+ detronyx_12t_write_driver_rc1_9/wen gf180mcu_3v3_12t_2r2w_sram_512x32_array_control_core_0/u_t020_030/r1_w0_wl
+ detronyx_12t_write_driver_rc1_9/wen detronyx_12t_write_driver_rc1_9/wen detronyx_12t_write_driver_rc1_9/wen
+ detronyx_12t_write_driver_rc1_9/wen detronyx_12t_write_driver_rc1_9/wen detronyx_12t_write_driver_rc1_9/wen
+ detronyx_12t_write_driver_rc1_9/wen detronyx_12t_write_driver_rc1_9/wen detronyx_12t_write_driver_rc1_9/wen
+ gf180mcu_3v3_12t_2r2w_sram_512x32_array_control_core_0/u_t021_018/c1_w1_bl gf180mcu_3v3_12t_2r2w_sram_512x32_array_control_core_0/u_t009_030/c3_w0_bl
+ detronyx_12t_write_driver_rc1_9/wen gf180mcu_3v3_12t_2r2w_sram_512x32_array_control_core_0/u_t021_000/r0_w1_wl
+ detronyx_12t_write_driver_rc1_9/wen detronyx_12t_write_driver_rc1_9/wen detronyx_12t_write_driver_rc1_9/wen
+ detronyx_12t_write_driver_rc1_9/wen gf180mcu_3v3_12t_2r2w_sram_512x32_array_control_core_0/u_t009_031/r3_w0_wl
+ detronyx_12t_write_driver_rc1_9/wen detronyx_12t_write_driver_rc1_9/wen detronyx_12t_write_driver_rc1_9/wen
+ gf180mcu_3v3_12t_2r2w_sram_512x32_array_control_core_0/u_t018_018/c1_w1_bl gf180mcu_3v3_12t_2r2w_sram_512x32_array_control_core_0/u_t030_015/c3_w1_bl
+ detronyx_12t_write_driver_rc1_9/wen detronyx_12t_write_driver_rc1_9/wen gf180mcu_3v3_12t_2r2w_sram_512x32_array_control_core_0/u_t023_029/c3_w0_bl
+ detronyx_12t_write_driver_rc1_9/wen detronyx_12t_write_driver_rc1_9/wen detronyx_12t_write_driver_rc1_9/wen
+ detronyx_12t_write_driver_rc1_9/wen detronyx_12t_write_driver_rc1_9/wen detronyx_12t_write_driver_rc1_9/wen
+ gf180mcu_3v3_12t_2r2w_sram_512x32_array_control_core_0/u_t026_023/c3_w1_bl detronyx_12t_write_driver_rc1_9/wen
+ gf180mcu_3v3_12t_2r2w_sram_512x32_array_control_core_0/u_t015_031/r2_w0_wl gf180mcu_3v3_12t_2r2w_sram_512x32_array_control_core_0/u_t006_000/r2_w1_wl
+ detronyx_12t_write_driver_rc1_9/wen detronyx_12t_write_driver_rc1_9/wen detronyx_12t_write_driver_rc1_9/wen
+ detronyx_12t_write_driver_rc1_9/wen gf180mcu_3v3_12t_2r2w_sram_512x32_array_control_core_0/u_t014_007/c3_w1_bl
+ detronyx_12t_write_driver_rc1_9/wen gf180mcu_3v3_12t_2r2w_sram_512x32_array_control_core_0/u_t005_015/c1_w1_bl
+ detronyx_12t_write_driver_rc1_9/wen detronyx_12t_write_driver_rc1_9/wen detronyx_12t_write_driver_rc1_9/wen
+ gf180mcu_3v3_12t_2r2w_sram_512x32_array_control_core_0/u_t027_017/c3_w1_bl detronyx_12t_write_driver_rc1_9/wen
+ detronyx_12t_write_driver_rc1_9/wen gf180mcu_3v3_12t_2r2w_sram_512x32_array_control_core_0/u_t017_002/r0_w1_wl
+ detronyx_12t_write_driver_rc1_9/wen detronyx_12t_write_driver_rc1_9/wen detronyx_12t_write_driver_rc1_9/wen
+ detronyx_12t_write_driver_rc1_9/wen detronyx_12t_write_driver_rc1_9/wen detronyx_12t_write_driver_rc1_9/wen
+ detronyx_12t_write_driver_rc1_9/wen gf180mcu_3v3_12t_2r2w_sram_512x32_array_control_core_0/u_t022_025/c3_w0_bl
+ gf180mcu_3v3_12t_2r2w_sram_512x32_array_control_core_0/a_14200_81400# gf180mcu_3v3_12t_2r2w_sram_512x32_array_control_core_0/u_t022_008/c1_w1_bl
+ detronyx_12t_write_driver_rc1_9/wen detronyx_12t_write_driver_rc1_9/wen gf180mcu_3v3_12t_2r2w_sram_512x32_array_control_core_0/a_22600_87000#
+ gf180mcu_3v3_12t_2r2w_sram_512x32_array_control_core_0/u_t013_009/c3_w1_bl detronyx_12t_write_driver_rc1_9/wen
+ gf180mcu_3v3_12t_2r2w_sram_512x32_array_control_core_0/u_t023_002/c1_w1_bl gf180mcu_3v3_12t_2r2w_sram_512x32_array_control_core_0/u_t005_017/c1_w1_bl
+ detronyx_12t_write_driver_rc1_9/wen gf180mcu_3v3_12t_2r2w_sram_512x32_array_control_core_0/u_t024_003/r1_w1_wl
+ gf180mcu_3v3_12t_2r2w_sram_512x32_array_control_core_0/u_t004_011/c1_w1_bl detronyx_12t_write_driver_rc1_9/wen
+ detronyx_12t_write_driver_rc1_9/wen detronyx_12t_write_driver_rc1_9/wen detronyx_12t_write_driver_rc1_9/wen
+ gf180mcu_3v3_12t_2r2w_sram_512x32_array_control_core_0/u_t030_026/c1_w0_bl gf180mcu_3v3_12t_2r2w_sram_512x32_array_control_core_0/u_t015_016/c1_w1_bl
+ detronyx_12t_write_driver_rc1_9/wen detronyx_12t_write_driver_rc1_9/wen detronyx_12t_write_driver_rc1_9/wen
+ detronyx_12t_write_driver_rc1_9/wen gf180mcu_3v3_12t_2r2w_sram_512x32_array_control_core_0/u_t012_003/r0_w1_wl
+ detronyx_12t_write_driver_rc1_9/wen detronyx_12t_write_driver_rc1_9/wen detronyx_12t_write_driver_rc1_9/wen
+ detronyx_12t_write_driver_rc1_9/wen detronyx_12t_write_driver_rc1_9/wen gf180mcu_3v3_12t_2r2w_sram_512x32_array_control_core_0/u_t009_022/c3_w1_bl
+ detronyx_12t_write_driver_rc1_9/wen detronyx_12t_write_driver_rc1_9/wen gf180mcu_3v3_12t_2r2w_sram_512x32_array_control_core_0/u_t030_026/c1_w0_bl
+ detronyx_12t_write_driver_rc1_9/wen detronyx_12t_write_driver_rc1_9/wen detronyx_12t_write_driver_rc1_9/wen
+ detronyx_12t_write_driver_rc1_9/wen gf180mcu_3v3_12t_2r2w_sram_512x32_array_control_core_0/u_t002_030/c3_w0_bl
+ detronyx_12t_write_driver_rc1_9/wen detronyx_12t_write_driver_rc1_9/wen detronyx_12t_write_driver_rc1_9/wen
+ detronyx_12t_write_driver_rc1_9/wen detronyx_12t_write_driver_rc1_9/wen detronyx_12t_write_driver_rc1_9/wen
+ detronyx_12t_write_driver_rc1_9/wen detronyx_12t_write_driver_rc1_9/wen detronyx_12t_write_driver_rc1_9/wen
+ detronyx_12t_write_driver_rc1_9/wen detronyx_12t_write_driver_rc1_9/wen detronyx_12t_write_driver_rc1_9/wen
+ gf180mcu_3v3_12t_2r2w_sram_512x32_array_control_core_0/u_t013_018/c1_w1_bl gf180mcu_3v3_12t_2r2w_sram_512x32_array_control_core_0/u_t025_015/c3_w1_bl
+ detronyx_12t_write_driver_rc1_9/wen gf180mcu_3v3_12t_2r2w_sram_512x32_array_control_core_0/u_t013_000/r3_w1_wl
+ detronyx_12t_write_driver_rc1_9/wen detronyx_12t_write_driver_rc1_9/wen detronyx_12t_write_driver_rc1_9/wen
+ gf180mcu_3v3_12t_2r2w_sram_512x32_array_control_core_0/u_t010_031/r2_w0_wl detronyx_12t_write_driver_rc1_9/wen
+ detronyx_12t_write_driver_rc1_9/wen detronyx_12t_write_driver_rc1_9/wen gf180mcu_3v3_12t_2r2w_sram_512x32_array_control_core_0/u_t001_000/r2_w1_wl
+ detronyx_12t_write_driver_rc1_9/wen detronyx_12t_write_driver_rc1_9/wen gf180mcu_3v3_12t_2r2w_sram_512x32_array_control_core_0/u_t017_029/c3_w0_bl
+ gf180mcu_3v3_12t_2r2w_sram_512x32_array_control_core_0/u_t027_022/c1_w0_bl detronyx_12t_write_driver_rc1_9/wen
+ detronyx_12t_write_driver_rc1_9/wen gf180mcu_3v3_12t_2r2w_sram_512x32_array_control_core_0/u_t017_023/c3_w1_bl
+ gf180mcu_3v3_12t_2r2w_sram_512x32_array_control_core_0/u_t009_031/r3_w0_wl detronyx_12t_write_driver_rc1_9/wen
+ detronyx_12t_write_driver_rc1_9/wen detronyx_12t_write_driver_rc1_9/wen gf180mcu_3v3_12t_2r2w_sram_512x32_array_control_core_0/u_t022_017/c3_w1_bl
+ detronyx_12t_write_driver_rc1_9/wen gf180mcu_3v3_12t_2r2w_sram_512x32_array_control_core_0/u_t007_007/c3_w1_bl
+ detronyx_12t_write_driver_rc1_9/wen detronyx_12t_write_driver_rc1_9/wen detronyx_12t_write_driver_rc1_9/wen
+ detronyx_12t_write_driver_rc1_9/wen detronyx_12t_write_driver_rc1_9/wen gf180mcu_3v3_12t_2r2w_sram_512x32_array_control_core_0/u_t019_001/r1_w1_wl
+ detronyx_12t_write_driver_rc1_9/wen detronyx_12t_write_driver_rc1_9/wen detronyx_12t_write_driver_rc1_9/wen
+ detronyx_12t_write_driver_rc1_9/wen gf180mcu_3v3_12t_2r2w_sram_512x32_array_control_core_0/u_t009_002/r3_w1_wl
+ detronyx_12t_write_driver_rc1_9/wen gf180mcu_3v3_12t_2r2w_sram_512x32_array_control_core_0/u_t026_024/c1_w0_bl
+ detronyx_12t_write_driver_rc1_9/wen gf180mcu_3v3_12t_2r2w_sram_512x32_array_control_core_0/u_t007_001/r1_w1_wl
+ gf180mcu_3v3_12t_2r2w_sram_512x32_array_control_core_0/u_t015_025/c3_w0_bl detronyx_12t_write_driver_rc1_9/wen
+ gf180mcu_3v3_12t_2r2w_sram_512x32_array_control_core_0/u_t030_018/c1_w1_bl gf180mcu_3v3_12t_2r2w_sram_512x32_array_control_core_0/u_t015_008/c1_w1_bl
+ detronyx_12t_write_driver_rc1_9/wen detronyx_12t_write_driver_rc1_9/wen detronyx_12t_write_driver_rc1_9/wen
+ gf180mcu_3v3_12t_2r2w_sram_512x32_array_control_core_0/u_t005_009/c3_w1_bl detronyx_12t_write_driver_rc1_9/wen
+ detronyx_12t_write_driver_rc1_9/wen detronyx_12t_write_driver_rc1_9/wen gf180mcu_3v3_12t_2r2w_sram_512x32_array_control_core_0/u_t016_002/c1_w1_bl
+ gf180mcu_3v3_12t_2r2w_sram_512x32_array_control_core_0/u_t010_016/c1_w1_bl detronyx_12t_write_driver_rc1_9/wen
+ detronyx_12t_write_driver_rc1_9/wen gf180mcu_3v3_12t_2r2w_sram_512x32_array_control_core_0/u_t030_018/c1_w1_bl
+ gf180mcu_3v3_12t_2r2w_sram_512x32_array_control_core_0/u_t002_003/VSS detronyx_12t_write_driver_rc1_9/wen
+ gf180mcu_3v3_12t_2r2w_sram_512x32_array_control_core_0/u_t002_022/c3_w1_bl detronyx_12t_write_driver_rc1_9/wen
+ detronyx_12t_write_driver_rc1_9/wen detronyx_12t_write_driver_rc1_9/wen gf180mcu_3v3_12t_2r2w_sram_512x32_array_control_core_0/a_200_84200#
+ gf180mcu_3v3_12t_2r2w_sram_512x32_array_control_core_0/a_22600_112200# gf180mcu_3v3_12t_2r2w_sram_512x32_array_control_core_0/u_t023_026/c1_w0_bl
+ detronyx_12t_write_driver_rc1_9/wen gf180mcu_3v3_12t_2r2w_sram_512x32_array_control_core_0/a_14200_61800#
+ gf180mcu_3v3_12t_2r2w_sram_512x32_array_control_core_0/u_t009_016/c1_w1_bl detronyx_12t_write_driver_rc1_9/wen
+ detronyx_12t_write_driver_rc1_9/wen detronyx_12t_write_driver_rc1_9/wen detronyx_12t_write_driver_rc1_9/wen
+ gf180mcu_3v3_12t_2r2w_sram_512x32_array_control_core_0/a_22600_67400# detronyx_12t_write_driver_rc1_9/wen
+ detronyx_12t_write_driver_rc1_9/wen detronyx_12t_write_driver_rc1_9/wen gf180mcu_3v3_12t_2r2w_sram_512x32_array_control_core_0/u_t018_030/r3_w0_wl
+ detronyx_12t_write_driver_rc1_9/wen detronyx_12t_write_driver_rc1_9/wen detronyx_12t_write_driver_rc1_9/wen
+ detronyx_12t_write_driver_rc1_9/wen detronyx_12t_write_driver_rc1_9/wen detronyx_12t_write_driver_rc1_9/wen
+ gf180mcu_3v3_12t_2r2w_sram_512x32_array_control_core_0/u_t006_030/r2_w0_wl detronyx_12t_write_driver_rc1_9/wen
+ gf180mcu_3v3_12t_2r2w_sram_512x32_array_control_core_0/u_t027_031/r2_w0_wl detronyx_12t_write_driver_rc1_9/wen
+ detronyx_12t_write_driver_rc1_9/wen detronyx_12t_write_driver_rc1_9/wen detronyx_12t_write_driver_rc1_9/wen
+ detronyx_12t_write_driver_rc1_9/wen gf180mcu_3v3_12t_2r2w_sram_512x32_array_control_core_0/u_t006_018/c1_w1_bl
+ gf180mcu_3v3_12t_2r2w_sram_512x32_array_control_core_0/u_t017_015/c3_w1_bl gf180mcu_3v3_12t_2r2w_sram_512x32_array_control_core_0/u_t013_029/c3_w0_bl
+ detronyx_12t_write_driver_rc1_9/wen detronyx_12t_write_driver_rc1_9/wen gf180mcu_3v3_12t_2r2w_sram_512x32_array_control_core_0/u_t022_022/c1_w0_bl
+ gf180mcu_3v3_12t_2r2w_sram_512x32_array_control_core_0/gf180mcu_as_sc_mcu7t3v3__inv_2_988/A
+ gf180mcu_3v3_12t_2r2w_sram_512x32_array_control_core_0/u_t013_023/c3_w1_bl detronyx_12t_write_driver_rc1_9/wen
+ gf180mcu_3v3_12t_2r2w_sram_512x32_array_control_core_0/u_t005_031/r3_w0_wl detronyx_12t_write_driver_rc1_9/wen
+ detronyx_12t_write_driver_rc1_9/wen gf180mcu_3v3_12t_2r2w_sram_512x32_array_control_core_0/u_t009_029/c3_w0_bl
+ gf180mcu_3v3_12t_2r2w_sram_512x32_array_control_core_0/u_t026_001/r3_w1_wl gf180mcu_3v3_12t_2r2w_sram_512x32_array_control_core_0/u_t002_007/c3_w1_bl
+ detronyx_12t_write_driver_rc1_9/wen gf180mcu_3v3_12t_2r2w_sram_512x32_array_control_core_0/u_t026_016/c1_w1_bl
+ gf180mcu_3v3_12t_2r2w_sram_512x32_array_control_core_0/u_t014_001/r2_w1_wl detronyx_12t_write_driver_rc1_9/wen
+ gf180mcu_3v3_12t_2r2w_sram_512x32_array_control_core_0/u_t015_017/c3_w1_bl gf180mcu_3v3_12t_2r2w_sram_512x32_array_control_core_0/u_t026_010/c1_w1_bl
+ gf180mcu_3v3_12t_2r2w_sram_512x32_array_control_core_0/u_t004_002/r3_w1_wl gf180mcu_3v3_12t_2r2w_sram_512x32_array_control_core_0/u_t021_024/c1_w0_bl
+ detronyx_12t_write_driver_rc1_9/wen detronyx_12t_write_driver_rc1_9/wen detronyx_12t_write_driver_rc1_9/wen
+ detronyx_12t_write_driver_rc1_9/wen gf180mcu_3v3_12t_2r2w_sram_512x32_array_control_core_0/u_t010_025/c3_w0_bl
+ detronyx_12t_write_driver_rc1_9/wen gf180mcu_3v3_12t_2r2w_sram_512x32_array_control_core_0/u_t010_008/c1_w1_bl
+ gf180mcu_3v3_12t_2r2w_sram_512x32_array_control_core_0/u_t018_024/c1_w0_bl detronyx_12t_write_driver_rc1_9/wen
+ detronyx_12t_precharge_sense_rc1_53/ren gf180mcu_3v3_12t_2r2w_sram_512x32_array_control_core_0/a_14200_17000#
+ gf180mcu_3v3_12t_2r2w_sram_512x32_array_control_core_0/u_t011_002/c1_w1_bl detronyx_12t_write_driver_rc1_9/wen
+ detronyx_12t_write_driver_rc1_9/wen gf180mcu_3v3_12t_2r2w_sram_512x32_array_control_core_0/u_t009_025/c3_w0_bl
+ detronyx_12t_write_driver_rc1_9/wen detronyx_12t_write_driver_rc1_9/wen detronyx_12t_write_driver_rc1_9/wen
+ gf180mcu_3v3_12t_2r2w_sram_512x32_array_control_core_0/u_t023_018/c1_w1_bl gf180mcu_3v3_12t_2r2w_sram_512x32_array_control_core_0/u_t009_008/c1_w1_bl
+ detronyx_12t_write_driver_rc1_9/wen detronyx_12t_write_driver_rc1_9/wen detronyx_12t_write_driver_rc1_9/wen
+ detronyx_12t_write_driver_rc1_9/wen detronyx_12t_write_driver_rc1_9/wen detronyx_12t_write_driver_rc1_9/wen
+ gf180mcu_3v3_12t_2r2w_sram_512x32_array_control_core_0/u_t025_030/r3_w0_wl gf180mcu_3v3_12t_2r2w_sram_512x32_array_control_core_0/u_t009_002/c1_w1_bl
+ detronyx_12t_write_driver_rc1_9/wen gf180mcu_3v3_12t_2r2w_sram_512x32_array_control_core_0/u_t005_016/c1_w1_bl
+ detronyx_12t_write_driver_rc1_9/wen detronyx_12t_write_driver_rc1_9/wen detronyx_12t_precharge_sense_rc1_59/ren
+ detronyx_12t_write_driver_rc1_9/wen detronyx_12t_write_driver_rc1_9/wen detronyx_12t_write_driver_rc1_9/wen
+ gf180mcu_3v3_12t_2r2w_sram_512x32_array_control_core_0/u_t013_030/r3_w0_wl detronyx_12t_write_driver_rc1_9/wen
+ detronyx_12t_write_driver_rc1_9/wen gf180mcu_3v3_12t_2r2w_sram_512x32_array_control_core_0/u_t027_023/c3_w1_bl
+ gf180mcu_3v3_12t_2r2w_sram_512x32_array_control_core_0/u_t017_026/c1_w0_bl detronyx_12t_write_driver_rc1_9/wen
+ detronyx_12t_write_driver_rc1_9/wen detronyx_12t_write_driver_rc1_9/wen detronyx_12t_write_driver_rc1_9/wen
+ detronyx_12t_write_driver_rc1_9/wen detronyx_12t_write_driver_rc1_9/wen detronyx_12t_write_driver_rc1_9/wen
+ gf180mcu_3v3_12t_2r2w_sram_512x32_array_control_core_0/u_t022_031/r3_w0_wl detronyx_12t_write_driver_rc1_9/wen
+ detronyx_12t_write_driver_rc1_9/wen detronyx_12t_write_driver_rc1_9/wen detronyx_12t_write_driver_rc1_9/wen
+ detronyx_12t_write_driver_rc1_9/wen detronyx_12t_write_driver_rc1_9/wen detronyx_12t_write_driver_rc1_9/wen
+ detronyx_12t_write_driver_rc1_9/wen gf180mcu_3v3_12t_2r2w_sram_512x32_array_control_core_0/u_t001_018/c1_w1_bl
+ gf180mcu_3v3_12t_2r2w_sram_512x32_array_control_core_0/u_t013_015/c3_w1_bl gf180mcu_3v3_12t_2r2w_sram_512x32_array_control_core_0/u_t021_031/r3_w0_wl
+ detronyx_12t_write_driver_rc1_9/wen detronyx_12t_write_driver_rc1_9/wen detronyx_12t_write_driver_rc1_9/wen
+ gf180mcu_3v3_12t_2r2w_sram_512x32_array_control_core_0/a_200_64600# detronyx_12t_write_driver_rc1_9/wen
+ detronyx_12t_write_driver_rc1_9/wen detronyx_12t_write_driver_rc1_9/wen detronyx_12t_write_driver_rc1_9/wen
+ detronyx_12t_write_driver_rc1_9/wen detronyx_12t_write_driver_rc1_9/wen gf180mcu_3v3_12t_2r2w_sram_512x32_array_control_core_0/a_22600_47800#
+ gf180mcu_3v3_12t_2r2w_sram_512x32_array_control_core_0/u_t005_029/c3_w0_bl detronyx_12t_write_driver_rc1_9/wen
+ gf180mcu_3v3_12t_2r2w_sram_512x32_array_control_core_0/u_t015_022/c1_w0_bl gf180mcu_3v3_12t_2r2w_sram_512x32_array_control_core_0/u_t021_001/r3_w1_wl
+ detronyx_12t_write_driver_rc1_9/wen detronyx_12t_write_driver_rc1_9/wen gf180mcu_3v3_12t_2r2w_sram_512x32_array_control_core_0/u_t005_023/c3_w1_bl
+ gf180mcu_3v3_12t_2r2w_sram_512x32_array_control_core_0/u_t021_016/c1_w1_bl gf180mcu_3v3_12t_2r2w_sram_512x32_array_control_core_0/u_t029_000/r0_w1_wl
+ detronyx_12t_write_driver_rc1_9/wen detronyx_12t_write_driver_rc1_9/wen gf180mcu_3v3_12t_2r2w_sram_512x32_array_control_core_0/u_t010_017/c3_w1_bl
+ gf180mcu_3v3_12t_2r2w_sram_512x32_array_control_core_0/u_t021_010/c1_w1_bl gf180mcu_3v3_12t_2r2w_sram_512x32_array_control_core_0/u_t027_008/c3_w1_bl
+ detronyx_12t_write_driver_rc1_9/wen detronyx_12t_write_driver_rc1_9/wen detronyx_12t_write_driver_rc1_9/wen
+ gf180mcu_3v3_12t_2r2w_sram_512x32_array_control_core_0/u_t018_016/c1_w1_bl detronyx_12t_write_driver_rc1_9/wen
+ gf180mcu_3v3_12t_2r2w_sram_512x32_array_control_core_0/u_t007_001/r1_w1_wl detronyx_12t_write_driver_rc1_9/wen
+ gf180mcu_3v3_12t_2r2w_sram_512x32_array_control_core_0/u_t009_017/c3_w1_bl gf180mcu_3v3_12t_2r2w_sram_512x32_array_control_core_0/u_t019_010/c1_w1_bl
+ gf180mcu_3v3_12t_2r2w_sram_512x32_array_control_core_0/u_t013_024/c1_w0_bl detronyx_12t_write_driver_rc1_9/wen
+ gf180mcu_3v3_12t_2r2w_sram_512x32_array_control_core_0/u_t029_003/r3_w1_wl detronyx_12t_write_driver_rc1_9/wen
+ detronyx_12t_write_driver_rc1_9/wen detronyx_12t_write_driver_rc1_9/wen gf180mcu_3v3_12t_2r2w_sram_512x32_array_control_core_0/u_t005_025/c3_w0_bl
+ detronyx_12t_write_driver_rc1_9/wen gf180mcu_3v3_12t_2r2w_sram_512x32_array_control_core_0/u_t004_008/c1_w1_bl
+ detronyx_12t_write_driver_rc1_9/wen gf180mcu_3v3_12t_2r2w_sram_512x32_array_control_core_0/u_t017_003/r3_w1_wl
+ gf180mcu_3v3_12t_2r2w_sram_512x32_array_control_core_0/u_t002_025/VSS detronyx_12t_write_driver_rc1_9/wen
+ gf180mcu_3v3_12t_2r2w_sram_512x32_array_control_core_0/u_t004_002/c1_w1_bl detronyx_12t_write_driver_rc1_9/wen
+ gf180mcu_3v3_12t_2r2w_sram_512x32_array_control_core_0/u_t017_018/c1_w1_bl detronyx_12t_write_driver_rc1_9/wen
+ gf180mcu_3v3_12t_2r2w_sram_512x32_array_control_core_0/u_t030_017/c1_w1_bl detronyx_12t_write_driver_rc1_9/wen
+ detronyx_12t_write_driver_rc1_9/wen detronyx_12t_write_driver_rc1_9/wen detronyx_12t_write_driver_rc1_9/wen
+ gf180mcu_3v3_12t_2r2w_sram_512x32_array_control_core_0/u_t018_030/r3_w0_wl gf180mcu_3v3_12t_2r2w_sram_512x32_array_control_core_0/u_t013_026/c1_w0_bl
+ gf180mcu_3v3_12t_2r2w_sram_512x32_array_control_core_0/u_t022_023/c3_w1_bl detronyx_12t_write_driver_rc1_9/wen
+ detronyx_12t_write_driver_rc1_9/wen detronyx_12t_write_driver_rc1_9/wen detronyx_12t_write_driver_rc1_9/wen
+ detronyx_12t_write_driver_rc1_9/wen gf180mcu_3v3_12t_2r2w_sram_512x32_array_control_core_0/u_t030_017/c1_w1_bl
+ detronyx_12t_write_driver_rc1_9/wen detronyx_12t_write_driver_rc1_9/wen detronyx_12t_write_driver_rc1_9/wen
+ detronyx_12t_write_driver_rc1_9/wen gf180mcu_3v3_12t_2r2w_sram_512x32_array_control_core_0/a_14200_70200#
+ gf180mcu_3v3_12t_2r2w_sram_512x32_array_control_core_0/u_t006_030/r2_w0_wl detronyx_12t_write_driver_rc1_9/wen
+ detronyx_12t_write_driver_rc1_9/wen gf180mcu_3v3_12t_2r2w_sram_512x32_array_control_core_0/u_t009_026/c1_w0_bl
+ detronyx_12t_write_driver_rc1_9/wen detronyx_12t_write_driver_rc1_9/wen detronyx_12t_write_driver_rc1_9/wen
+ detronyx_12t_write_driver_rc1_9/wen gf180mcu_3v3_12t_2r2w_sram_512x32_array_control_core_0/u_t025_030/r3_w0_wl
+ detronyx_12t_write_driver_rc1_9/wen gf180mcu_3v3_12t_2r2w_sram_512x32_array_control_core_0/u_t015_031/r2_w0_wl
+ detronyx_12t_write_driver_rc1_9/wen detronyx_12t_write_driver_rc1_9/wen detronyx_12t_write_driver_rc1_9/wen
+ detronyx_12t_write_driver_rc1_9/wen detronyx_12t_write_driver_rc1_9/wen gf180mcu_3v3_12t_2r2w_sram_512x32_array_control_core_0/gf180mcu_as_sc_mcu7t3v3__inv_2_631/A
+ gf180mcu_3v3_12t_2r2w_sram_512x32_array_control_core_0/u_t005_015/c3_w1_bl detronyx_12t_write_driver_rc1_9/wen
+ detronyx_12t_write_driver_rc1_9/wen detronyx_12t_write_driver_rc1_9/wen detronyx_12t_write_driver_rc1_9/wen
+ gf180mcu_3v3_12t_2r2w_sram_512x32_array_control_core_0/u_t010_022/c1_w0_bl detronyx_12t_write_driver_rc1_9/wen
+ gf180mcu_3v3_12t_2r2w_sram_512x32_array_control_core_0/a_17000_3000# gf180mcu_3v3_12t_2r2w_sram_512x32_array_control_core_0/u_t002_003/VSS
+ detronyx_12t_write_driver_rc1_9/wen gf180mcu_3v3_12t_2r2w_sram_512x32_array_control_core_0/u_t026_001/r3_w1_wl
+ gf180mcu_3v3_12t_2r2w_sram_512x32_array_control_core_0/u_t002_003/VSS detronyx_12t_precharge_sense_rc1_36/ren
+ gf180mcu_3v3_12t_2r2w_sram_512x32_array_control_core_0/u_t002_003/VSS detronyx_12t_write_driver_rc1_9/wen
+ gf180mcu_3v3_12t_2r2w_sram_512x32_array_control_core_0/u_t024_000/r1_w1_wl detronyx_12t_write_driver_rc1_9/wen
+ detronyx_12t_write_driver_rc1_9/wen detronyx_12t_write_driver_rc1_9/wen gf180mcu_3v3_12t_2r2w_sram_512x32_array_control_core_0/u_t014_001/r2_w1_wl
+ gf180mcu_3v3_12t_2r2w_sram_512x32_array_control_core_0/u_t009_022/c1_w0_bl detronyx_12t_write_driver_rc1_9/wen
+ detronyx_12t_write_driver_rc1_9/wen gf180mcu_3v3_12t_2r2w_sram_512x32_array_control_core_0/u_t022_008/c3_w1_bl
+ detronyx_12t_write_driver_rc1_9/wen gf180mcu_3v3_12t_2r2w_sram_512x32_array_control_core_0/u_t013_016/c1_w1_bl
+ detronyx_12t_write_driver_rc1_9/wen gf180mcu_3v3_12t_2r2w_sram_512x32_array_control_core_0/u_t002_001/r2_w1_wl
+ gf180mcu_3v3_12t_2r2w_sram_512x32_array_control_core_0/u_t004_017/c3_w1_bl gf180mcu_3v3_12t_2r2w_sram_512x32_array_control_core_0/u_t014_010/c1_w1_bl
+ detronyx_12t_write_driver_rc1_9/wen detronyx_12t_write_driver_rc1_9/wen gf180mcu_3v3_12t_2r2w_sram_512x32_array_control_core_0/u_t025_003/r0_w1_wl
+ detronyx_12t_write_driver_rc1_9/wen gf180mcu_3v3_12t_2r2w_sram_512x32_array_control_core_0/u_t025_015/c1_w1_bl
+ detronyx_12t_write_driver_rc1_9/wen detronyx_12t_write_driver_rc1_9/wen detronyx_12t_write_driver_rc1_9/wen
+ gf180mcu_3v3_12t_2r2w_sram_512x32_array_control_core_0/u_t006_024/c1_w0_bl gf180mcu_3v3_12t_2r2w_sram_512x32_array_control_core_0/u_t030_009/c1_w1_bl
+ detronyx_12t_write_driver_rc1_9/wen detronyx_12t_write_driver_rc1_9/wen detronyx_12t_write_driver_rc1_9/wen
+ detronyx_12t_write_driver_rc1_9/wen gf180mcu_3v3_12t_2r2w_sram_512x32_array_control_core_0/u_t013_018/c1_w1_bl
+ detronyx_12t_write_driver_rc1_9/wen detronyx_12t_write_driver_rc1_9/wen detronyx_12t_write_driver_rc1_9/wen
+ detronyx_12t_write_driver_rc1_9/wen gf180mcu_3v3_12t_2r2w_sram_512x32_array_control_core_0/u_t030_009/c1_w1_bl
+ detronyx_12t_write_driver_rc1_9/wen detronyx_12t_write_driver_rc1_9/wen detronyx_12t_write_driver_rc1_9/wen
+ gf180mcu_3v3_12t_2r2w_sram_512x32_array_control_core_0/u_t013_030/r3_w0_wl detronyx_12t_write_driver_rc1_9/wen
+ detronyx_12t_write_driver_rc1_9/wen detronyx_12t_write_driver_rc1_9/wen gf180mcu_3v3_12t_2r2w_sram_512x32_array_control_core_0/u_t030_003/c1_w1_bl
+ gf180mcu_3v3_12t_2r2w_sram_512x32_array_control_core_0/u_t009_018/c1_w1_bl detronyx_12t_write_driver_rc1_9/wen
+ gf180mcu_3v3_12t_2r2w_sram_512x32_array_control_core_0/u_t023_017/c1_w1_bl detronyx_12t_write_driver_rc1_9/wen
+ detronyx_12t_write_driver_rc1_9/wen gf180mcu_3v3_12t_2r2w_sram_512x32_array_control_core_0/u_t001_030/r3_w0_wl
+ detronyx_12t_write_driver_rc1_9/wen detronyx_12t_write_driver_rc1_9/wen gf180mcu_3v3_12t_2r2w_sram_512x32_array_control_core_0/u_t015_023/c3_w1_bl
+ gf180mcu_3v3_12t_2r2w_sram_512x32_array_control_core_0/u_t005_026/c1_w0_bl gf180mcu_3v3_12t_2r2w_sram_512x32_array_control_core_0/u_t002_003/VSS
+ detronyx_12t_write_driver_rc1_9/wen gf180mcu_3v3_12t_2r2w_sram_512x32_array_control_core_0/u_t020_030/r1_w0_wl
+ detronyx_12t_write_driver_rc1_9/wen detronyx_12t_write_driver_rc1_9/wen detronyx_12t_write_driver_rc1_9/wen
+ detronyx_12t_write_driver_rc1_9/wen detronyx_12t_write_driver_rc1_9/wen detronyx_12t_write_driver_rc1_9/wen
+ gf180mcu_3v3_12t_2r2w_sram_512x32_array_control_core_0/u_t010_031/r2_w0_wl detronyx_12t_write_driver_rc1_9/wen
+ detronyx_12t_write_driver_rc1_9/wen detronyx_12t_write_driver_rc1_9/wen gf180mcu_3v3_12t_2r2w_sram_512x32_array_control_core_0/u_t027_022/c3_w1_bl
+ detronyx_12t_write_driver_rc1_9/wen gf180mcu_3v3_12t_2r2w_sram_512x32_array_control_core_0/u_t018_030/r3_w0_wl
+ detronyx_12t_write_driver_rc1_9/wen detronyx_12t_precharge_sense_rc1_23/ren detronyx_12t_write_driver_rc1_9/wen
+ detronyx_12t_write_driver_rc1_9/wen detronyx_12t_write_driver_rc1_9/wen detronyx_12t_write_driver_rc1_9/wen
+ gf180mcu_3v3_12t_2r2w_sram_512x32_array_control_core_0/u_t009_031/r3_w0_wl detronyx_12t_write_driver_rc1_9/wen
+ gf180mcu_3v3_12t_2r2w_sram_512x32_array_control_core_0/u_t019_031/r2_w0_wl detronyx_12t_write_driver_rc1_9/wen
+ gf180mcu_3v3_12t_2r2w_sram_512x32_array_control_core_0/u_t021_001/r3_w1_wl detronyx_12t_write_driver_rc1_9/wen
+ detronyx_12t_write_driver_rc1_9/wen detronyx_12t_write_driver_rc1_9/wen gf180mcu_3v3_12t_2r2w_sram_512x32_array_control_core_0/gf180mcu_as_sc_mcu7t3v3__inv_2_1691/Y
+ detronyx_12t_write_driver_rc1_9/wen detronyx_12t_write_driver_rc1_9/wen gf180mcu_3v3_12t_2r2w_sram_512x32_array_control_core_0/a_200_73000#
+ gf180mcu_3v3_12t_2r2w_sram_512x32_array_control_core_0/a_22600_101000# gf180mcu_3v3_12t_2r2w_sram_512x32_array_control_core_0/u_t009_031/r3_w0_wl
+ gf180mcu_3v3_12t_2r2w_sram_512x32_array_control_core_0/u_t002_018/VSS gf180mcu_3v3_12t_2r2w_sram_512x32_array_control_core_0/a_14200_50600#
+ gf180mcu_3v3_12t_2r2w_sram_512x32_array_control_core_0/u_t005_022/c1_w0_bl detronyx_12t_write_driver_rc1_9/wen
+ detronyx_12t_write_driver_rc1_9/wen gf180mcu_3v3_12t_2r2w_sram_512x32_array_control_core_0/u_t002_003/VSS
+ gf180mcu_3v3_12t_2r2w_sram_512x32_array_control_core_0/a_22600_56200# detronyx_12t_write_driver_rc1_9/wen
+ gf180mcu_3v3_12t_2r2w_sram_512x32_array_control_core_0/u_t017_000/r0_w1_wl gf180mcu_3v3_12t_2r2w_sram_512x32_array_control_core_0/u_t026_024/c3_w0_bl
+ detronyx_12t_write_driver_rc1_9/wen gf180mcu_3v3_12t_2r2w_sram_512x32_array_control_core_0/u_t030_018/c3_w1_bl
+ detronyx_12t_write_driver_rc1_9/wen gf180mcu_3v3_12t_2r2w_sram_512x32_array_control_core_0/u_t015_008/c3_w1_bl
+ gf180mcu_3v3_12t_2r2w_sram_512x32_array_control_core_0/u_t006_016/c1_w1_bl gf180mcu_3v3_12t_2r2w_sram_512x32_array_control_core_0/u_t026_001/c1_w1_bl
+ gf180mcu_3v3_12t_2r2w_sram_512x32_array_control_core_0/u_t021_015/c1_w1_bl detronyx_12t_write_driver_rc1_9/wen
+ gf180mcu_3v3_12t_2r2w_sram_512x32_array_control_core_0/u_t027_002/r2_w1_wl gf180mcu_3v3_12t_2r2w_sram_512x32_array_control_core_0/u_t009_010/c1_w1_bl
+ detronyx_12t_write_driver_rc1_9/wen gf180mcu_3v3_12t_2r2w_sram_512x32_array_control_core_0/u_t001_024/c1_w0_bl
+ gf180mcu_3v3_12t_2r2w_sram_512x32_array_control_core_0/u_t030_018/c3_w1_bl detronyx_12t_write_driver_rc1_9/wen
+ gf180mcu_3v3_12t_2r2w_sram_512x32_array_control_core_0/u_t017_003/r3_w1_wl detronyx_12t_write_driver_rc1_9/wen
+ gf180mcu_3v3_12t_2r2w_sram_512x32_array_control_core_0/u_t018_015/c1_w1_bl detronyx_12t_write_driver_rc1_9/wen
+ detronyx_12t_write_driver_rc1_9/wen detronyx_12t_write_driver_rc1_9/wen gf180mcu_3v3_12t_2r2w_sram_512x32_array_control_core_0/u_t015_002/r1_w1_wl
+ detronyx_12t_write_driver_rc1_9/wen detronyx_12t_write_driver_rc1_9/wen gf180mcu_3v3_12t_2r2w_sram_512x32_array_control_core_0/u_t005_003/r3_w1_wl
+ gf180mcu_3v3_12t_2r2w_sram_512x32_array_control_core_0/u_t023_009/c1_w1_bl gf180mcu_3v3_12t_2r2w_sram_512x32_array_control_core_0/a_14200_89800#
+ detronyx_12t_write_driver_rc1_9/wen detronyx_12t_write_driver_rc1_9/wen gf180mcu_3v3_12t_2r2w_sram_512x32_array_control_core_0/u_t025_003/c1_w1_bl
+ gf180mcu_3v3_12t_2r2w_sram_512x32_array_control_core_0/u_t005_018/c1_w1_bl detronyx_12t_write_driver_rc1_9/wen
+ detronyx_12t_write_driver_rc1_9/wen detronyx_12t_write_driver_rc1_9/wen gf180mcu_3v3_12t_2r2w_sram_512x32_array_control_core_0/u_t004_018/VDD
+ gf180mcu_3v3_12t_2r2w_sram_512x32_array_control_core_0/u_t010_023/c3_w1_bl detronyx_12t_write_driver_rc1_9/wen
+ detronyx_12t_write_driver_rc1_9/wen detronyx_12t_write_driver_rc1_9/wen detronyx_12t_write_driver_rc1_9/wen
+ gf180mcu_3v3_12t_2r2w_sram_512x32_array_control_core_0/u_t017_017/c1_w1_bl detronyx_12t_write_driver_rc1_9/wen
+ detronyx_12t_write_driver_rc1_9/wen detronyx_12t_write_driver_rc1_9/wen detronyx_12t_write_driver_rc1_9/wen
+ detronyx_12t_write_driver_rc1_9/wen detronyx_12t_write_driver_rc1_9/wen gf180mcu_3v3_12t_2r2w_sram_512x32_array_control_core_0/u_t009_023/c3_w1_bl
+ gf180mcu_3v3_12t_2r2w_sram_512x32_array_control_core_0/u_t026_031/r3_w0_wl gf180mcu_3v3_12t_2r2w_sram_512x32_array_control_core_0/gf180mcu_as_sc_mcu7t3v3__inv_2_1144/A
+ gf180mcu_3v3_12t_2r2w_sram_512x32_array_control_core_0/u_t022_022/c3_w1_bl detronyx_12t_write_driver_rc1_9/wen
+ detronyx_12t_write_driver_rc1_9/wen gf180mcu_3v3_12t_2r2w_sram_512x32_array_control_core_0/u_t013_030/r3_w0_wl
+ detronyx_12t_write_driver_rc1_9/wen detronyx_12t_write_driver_rc1_9/wen detronyx_12t_write_driver_rc1_9/wen
+ gf180mcu_3v3_12t_2r2w_sram_512x32_array_control_core_0/u_t005_031/r3_w0_wl gf180mcu_3v3_12t_2r2w_sram_512x32_array_control_core_0/gf180mcu_as_sc_mcu7t3v3__inv_2_1294/Y
+ detronyx_12t_write_driver_rc1_9/wen detronyx_12t_write_driver_rc1_9/wen detronyx_12t_write_driver_rc1_9/wen
+ detronyx_12t_write_driver_rc1_9/wen detronyx_12t_write_driver_rc1_9/wen detronyx_12t_write_driver_rc1_9/wen
+ detronyx_12t_write_driver_rc1_9/wen detronyx_12t_write_driver_rc1_9/wen gf180mcu_3v3_12t_2r2w_sram_512x32_array_control_core_0/u_t024_000/r1_w1_wl
+ detronyx_12t_write_driver_rc1_9/wen detronyx_12t_write_driver_rc1_9/wen detronyx_12t_write_driver_rc1_9/wen
+ gf180mcu_3v3_12t_2r2w_sram_512x32_array_control_core_0/u_t025_016/c3_w1_bl detronyx_12t_write_driver_rc1_9/wen
+ detronyx_12t_write_driver_rc1_9/wen detronyx_12t_write_driver_rc1_9/wen gf180mcu_3v3_12t_2r2w_sram_512x32_array_control_core_0/u_t030_023/c1_w0_bl
+ detronyx_12t_write_driver_rc1_9/wen detronyx_12t_write_driver_rc1_9/wen gf180mcu_3v3_12t_2r2w_sram_512x32_array_control_core_0/u_t026_010/c3_w1_bl
+ gf180mcu_3v3_12t_2r2w_sram_512x32_array_control_core_0/u_t021_024/c3_w0_bl gf180mcu_3v3_12t_2r2w_sram_512x32_array_control_core_0/u_t012_000/r0_w1_wl
+ detronyx_12t_write_driver_rc1_9/wen gf180mcu_3v3_12t_2r2w_sram_512x32_array_control_core_0/u_t002_001/r2_w1_wl
+ detronyx_12t_write_driver_rc1_9/wen detronyx_12t_write_driver_rc1_9/wen gf180mcu_3v3_12t_2r2w_sram_512x32_array_control_core_0/u_t030_023/c1_w0_bl
+ gf180mcu_3v3_12t_2r2w_sram_512x32_array_control_core_0/u_t010_008/c3_w1_bl gf180mcu_3v3_12t_2r2w_sram_512x32_array_control_core_0/u_t021_001/c1_w1_bl
+ gf180mcu_3v3_12t_2r2w_sram_512x32_array_control_core_0/u_t001_016/c1_w1_bl gf180mcu_3v3_12t_2r2w_sram_512x32_array_control_core_0/u_t018_024/c3_w0_bl
+ detronyx_12t_write_driver_rc1_9/wen detronyx_12t_write_driver_rc1_9/wen gf180mcu_3v3_12t_2r2w_sram_512x32_array_control_core_0/u_t002_010/c1_w1_bl
+ detronyx_12t_write_driver_rc1_9/wen detronyx_12t_write_driver_rc1_9/wen gf180mcu_3v3_12t_2r2w_sram_512x32_array_control_core_0/u_t023_018/c3_w1_bl
+ gf180mcu_3v3_12t_2r2w_sram_512x32_array_control_core_0/u_t012_003/r3_w1_wl gf180mcu_3v3_12t_2r2w_sram_512x32_array_control_core_0/u_t009_008/c3_w1_bl
+ gf180mcu_3v3_12t_2r2w_sram_512x32_array_control_core_0/u_t019_001/c1_w1_bl gf180mcu_3v3_12t_2r2w_sram_512x32_array_control_core_0/u_t013_015/c1_w1_bl
+ detronyx_12t_write_driver_rc1_9/wen gf180mcu_3v3_12t_2r2w_sram_512x32_array_control_core_0/a_200_53400#
+ detronyx_12t_write_driver_rc1_9/wen detronyx_12t_write_driver_rc1_9/wen detronyx_12t_write_driver_rc1_9/wen
+ gf180mcu_3v3_12t_2r2w_sram_512x32_array_control_core_0/u_t000_003/r3_w1_wl detronyx_12t_write_driver_rc1_9/wen
+ gf180mcu_3v3_12t_2r2w_sram_512x32_array_control_core_0/a_22600_36600# detronyx_12t_write_driver_rc1_9/wen
+ gf180mcu_3v3_12t_2r2w_sram_512x32_array_control_core_0/u_t026_025/c1_w0_bl detronyx_12t_write_driver_rc1_9/wen
+ detronyx_12t_write_driver_rc1_9/wen gf180mcu_3v3_12t_2r2w_sram_512x32_array_control_core_0/u_t008_002/r0_w1_wl
+ detronyx_12t_write_driver_rc1_9/wen detronyx_12t_write_driver_rc1_9/wen gf180mcu_3v3_12t_2r2w_sram_512x32_array_control_core_0/u_t017_009/c1_w1_bl
+ detronyx_12t_write_driver_rc1_9/wen detronyx_12t_write_driver_rc1_9/wen detronyx_12t_write_driver_rc1_9/wen
+ detronyx_12t_write_driver_rc1_9/wen gf180mcu_3v3_12t_2r2w_sram_512x32_array_control_core_0/u_t001_030/r3_w0_wl
+ detronyx_12t_write_driver_rc1_9/wen detronyx_12t_write_driver_rc1_9/wen detronyx_12t_write_driver_rc1_9/wen
+ gf180mcu_3v3_12t_2r2w_sram_512x32_array_control_core_0/u_t017_003/c1_w1_bl gf180mcu_3v3_12t_2r2w_sram_512x32_array_control_core_0/u_t013_017/c1_w1_bl
+ detronyx_12t_write_driver_rc1_9/wen detronyx_12t_write_driver_rc1_9/wen detronyx_12t_write_driver_rc1_9/wen
+ gf180mcu_3v3_12t_2r2w_sram_512x32_array_control_core_0/u_t005_023/c3_w1_bl detronyx_12t_write_driver_rc1_9/wen
+ detronyx_12t_write_driver_rc1_9/wen detronyx_12t_write_driver_rc1_9/wen detronyx_12t_write_driver_rc1_9/wen
+ detronyx_12t_write_driver_rc1_9/wen detronyx_12t_write_driver_rc1_9/wen gf180mcu_3v3_12t_2r2w_sram_512x32_array_control_core_0/u_t009_017/c1_w1_bl
+ detronyx_12t_write_driver_rc1_9/wen detronyx_12t_write_driver_rc1_9/wen gf180mcu_3v3_12t_2r2w_sram_512x32_array_control_core_0/u_t030_030/r3_w0_wl
+ detronyx_12t_write_driver_rc1_9/wen detronyx_12t_write_driver_rc1_9/wen detronyx_12t_write_driver_rc1_9/wen
+ gf180mcu_3v3_12t_2r2w_sram_512x32_array_control_core_0/u_t004_018/VDD gf180mcu_3v3_12t_2r2w_sram_512x32_array_control_core_0/u_t019_031/r2_w0_wl
+ detronyx_12t_write_driver_rc1_9/wen detronyx_12t_write_driver_rc1_9/wen gf180mcu_3v3_12t_2r2w_sram_512x32_array_control_core_0/u_t015_022/c3_w1_bl
+ gf180mcu_3v3_12t_2r2w_sram_512x32_array_control_core_0/a_28200_3000# gf180mcu_3v3_12t_2r2w_sram_512x32_array_control_core_0/u_t006_030/r2_w0_wl
+ gf180mcu_3v3_12t_2r2w_sram_512x32_array_control_core_0/u_t030_015/c1_w1_bl detronyx_12t_write_driver_rc1_9/wen
+ detronyx_12t_write_driver_rc1_9/wen gf180mcu_3v3_12t_2r2w_sram_512x32_array_control_core_0/u_t021_016/c3_w1_bl
+ gf180mcu_3v3_12t_2r2w_sram_512x32_array_control_core_0/u_t009_031/r3_w0_wl detronyx_12t_write_driver_rc1_9/wen
+ detronyx_12t_write_driver_rc1_9/wen gf180mcu_3v3_12t_2r2w_sram_512x32_array_control_core_0/u_t021_010/c3_w1_bl
+ gf180mcu_3v3_12t_2r2w_sram_512x32_array_control_core_0/u_t030_015/c1_w1_bl detronyx_12t_write_driver_rc1_9/wen
+ detronyx_12t_write_driver_rc1_9/wen detronyx_12t_write_driver_rc1_9/wen gf180mcu_3v3_12t_2r2w_sram_512x32_array_control_core_0/u_t018_016/c3_w1_bl
+ detronyx_12t_write_driver_rc1_9/wen detronyx_12t_write_driver_rc1_9/wen detronyx_12t_write_driver_rc1_9/wen
+ gf180mcu_3v3_12t_2r2w_sram_512x32_array_control_core_0/u_t023_023/c1_w0_bl gf180mcu_3v3_12t_2r2w_sram_512x32_array_control_core_0/u_t019_010/c3_w1_bl
+ gf180mcu_3v3_12t_2r2w_sram_512x32_array_control_core_0/u_t013_024/c3_w0_bl detronyx_12t_write_driver_rc1_9/wen
+ gf180mcu_3v3_12t_2r2w_sram_512x32_array_control_core_0/u_t027_002/r2_w1_wl gf180mcu_3v3_12t_2r2w_sram_512x32_array_control_core_0/u_t004_008/c3_w1_bl
+ gf180mcu_3v3_12t_2r2w_sram_512x32_array_control_core_0/u_t014_001/c1_w1_bl gf180mcu_3v3_12t_2r2w_sram_512x32_array_control_core_0/u_t026_017/c1_w1_bl
+ gf180mcu_3v3_12t_2r2w_sram_512x32_array_control_core_0/u_t015_002/r1_w1_wl gf180mcu_3v3_12t_2r2w_sram_512x32_array_control_core_0/u_t017_018/c3_w1_bl
+ detronyx_12t_write_driver_rc1_9/wen detronyx_12t_write_driver_rc1_9/wen detronyx_12t_write_driver_rc1_9/wen
+ gf180mcu_3v3_12t_2r2w_sram_512x32_array_control_core_0/u_t027_011/c1_w1_bl gf180mcu_3v3_12t_2r2w_sram_512x32_array_control_core_0/u_t005_003/r3_w1_wl
+ detronyx_12t_write_driver_rc1_9/wen gf180mcu_3v3_12t_2r2w_sram_512x32_array_control_core_0/u_t021_025/c1_w0_bl
+ detronyx_12t_write_driver_rc1_9/wen gf180mcu_3v3_12t_2r2w_sram_512x32_array_control_core_0/u_t006_015/c1_w1_bl
+ detronyx_12t_write_driver_rc1_9/wen gf180mcu_3v3_12t_2r2w_sram_512x32_array_control_core_0/u_t003_002/r1_w1_wl
+ detronyx_12t_write_driver_rc1_9/wen gf180mcu_3v3_12t_2r2w_sram_512x32_array_control_core_0/u_t013_009/c1_w1_bl
+ detronyx_12t_write_driver_rc1_9/wen detronyx_12t_write_driver_rc1_9/wen detronyx_12t_write_driver_rc1_9/wen
+ gf180mcu_3v3_12t_2r2w_sram_512x32_array_control_core_0/u_t019_025/c1_w0_bl detronyx_12t_write_driver_rc1_9/wen
+ gf180mcu_3v3_12t_2r2w_sram_512x32_array_control_core_0/u_t013_003/c1_w1_bl detronyx_12t_write_driver_rc1_9/wen
+ gf180mcu_3v3_12t_2r2w_sram_512x32_array_control_core_0/a_14200_98200# detronyx_12t_write_driver_rc1_9/wen
+ detronyx_12t_write_driver_rc1_9/wen detronyx_12t_write_driver_rc1_9/wen detronyx_12t_write_driver_rc1_9/wen
+ gf180mcu_3v3_12t_2r2w_sram_512x32_array_control_core_0/u_t009_009/c1_w1_bl gf180mcu_3v3_12t_2r2w_sram_512x32_array_control_core_0/u_t026_030/c3_w0_bl
+ detronyx_12t_write_driver_rc1_9/wen detronyx_12t_precharge_sense_rc1_28/dout detronyx_12t_write_driver_rc1_9/wen
+ detronyx_12t_write_driver_rc1_9/wen detronyx_12t_write_driver_rc1_9/wen gf180mcu_3v3_12t_2r2w_sram_512x32_array_control_core_0/a_200_33800#
+ gf180mcu_3v3_12t_2r2w_sram_512x32_array_control_core_0/u_t026_031/r3_w0_wl detronyx_12t_write_driver_rc1_9/wen
+ gf180mcu_3v3_12t_2r2w_sram_512x32_array_control_core_0/u_t005_017/c1_w1_bl detronyx_12t_write_driver_rc1_9/wen
+ detronyx_12t_write_driver_rc1_9/wen gf180mcu_3v3_12t_2r2w_sram_512x32_array_control_core_0/u_t024_030/r1_w0_wl
+ detronyx_12t_write_driver_rc1_9/wen detronyx_12t_write_driver_rc1_9/wen gf180mcu_3v3_12t_2r2w_sram_512x32_array_control_core_0/u_t002_003/VSS
+ gf180mcu_3v3_12t_2r2w_sram_512x32_array_control_core_0/u_t014_031/r2_w0_wl detronyx_12t_write_driver_rc1_9/wen
+ detronyx_12t_write_driver_rc1_9/wen detronyx_12t_write_driver_rc1_9/wen gf180mcu_3v3_12t_2r2w_sram_512x32_array_control_core_0/u_t010_022/c3_w1_bl
+ detronyx_12t_write_driver_rc1_9/wen detronyx_12t_write_driver_rc1_9/wen gf180mcu_3v3_12t_2r2w_sram_512x32_array_control_core_0/u_t001_030/r3_w0_wl
+ detronyx_12t_write_driver_rc1_9/wen detronyx_12t_write_driver_rc1_9/wen gf180mcu_3v3_12t_2r2w_sram_512x32_array_control_core_0/u_t002_031/r2_w0_wl
+ detronyx_12t_write_driver_rc1_9/wen detronyx_12t_write_driver_rc1_9/wen detronyx_12t_write_driver_rc1_9/wen
+ detronyx_12t_write_driver_rc1_9/wen detronyx_12t_write_driver_rc1_9/wen gf180mcu_3v3_12t_2r2w_sram_512x32_array_control_core_0/u_t009_022/c3_w1_bl
+ detronyx_12t_write_driver_rc1_9/wen detronyx_12t_write_driver_rc1_9/wen gf180mcu_3v3_12t_2r2w_sram_512x32_array_control_core_0/u_t023_015/c1_w1_bl
+ detronyx_12t_write_driver_rc1_9/wen detronyx_12t_write_driver_rc1_9/wen detronyx_12t_write_driver_rc1_9/wen
+ gf180mcu_3v3_12t_2r2w_sram_512x32_array_control_core_0/u_t013_016/c3_w1_bl detronyx_12t_write_driver_rc1_9/wen
+ detronyx_12t_write_driver_rc1_9/wen detronyx_12t_write_driver_rc1_9/wen gf180mcu_3v3_12t_2r2w_sram_512x32_array_control_core_0/u_t014_010/c3_w1_bl
+ detronyx_12t_write_driver_rc1_9/wen detronyx_12t_write_driver_rc1_9/wen detronyx_12t_write_driver_rc1_9/wen
+ gf180mcu_3v3_12t_2r2w_sram_512x32_array_control_core_0/u_t022_002/r3_w1_wl gf180mcu_3v3_12t_2r2w_sram_512x32_array_control_core_0/u_t017_023/c1_w0_bl
+ detronyx_12t_write_driver_rc1_9/wen detronyx_12t_write_driver_rc1_9/wen gf180mcu_3v3_12t_2r2w_sram_512x32_array_control_core_0/u_t006_024/c3_w0_bl
+ gf180mcu_3v3_12t_2r2w_sram_512x32_array_control_core_0/u_t030_009/c3_w1_bl gf180mcu_3v3_12t_2r2w_sram_512x32_array_control_core_0/a_25400_120600#
+ detronyx_12t_write_driver_rc1_9/wen detronyx_12t_write_driver_rc1_9/wen gf180mcu_3v3_12t_2r2w_sram_512x32_array_control_core_0/u_t021_017/c1_w1_bl
+ detronyx_12t_write_driver_rc1_9/wen detronyx_12t_write_driver_rc1_9/wen gf180mcu_3v3_12t_2r2w_sram_512x32_array_control_core_0/u_t010_002/r2_w1_wl
+ detronyx_12t_write_driver_rc1_9/wen gf180mcu_3v3_12t_2r2w_sram_512x32_array_control_core_0/u_t013_018/c3_w1_bl
+ gf180mcu_3v3_12t_2r2w_sram_512x32_array_control_core_0/u_t022_011/c1_w1_bl gf180mcu_3v3_12t_2r2w_sram_512x32_array_control_core_0/u_t000_003/r3_w1_wl
+ gf180mcu_3v3_12t_2r2w_sram_512x32_array_control_core_0/u_t007_001/c1_w1_bl detronyx_12t_write_driver_rc1_9/wen
+ gf180mcu_3v3_12t_2r2w_sram_512x32_array_control_core_0/u_t001_015/c1_w1_bl gf180mcu_3v3_12t_2r2w_sram_512x32_array_control_core_0/u_t030_009/c3_w1_bl
+ detronyx_12t_write_driver_rc1_9/wen detronyx_12t_write_driver_rc1_9/wen gf180mcu_3v3_12t_2r2w_sram_512x32_array_control_core_0/u_t019_017/c1_w1_bl
+ detronyx_12t_write_driver_rc1_9/wen detronyx_12t_write_driver_rc1_9/wen gf180mcu_3v3_12t_2r2w_sram_512x32_array_control_core_0/u_t009_018/c3_w1_bl
+ gf180mcu_3v3_12t_2r2w_sram_512x32_array_control_core_0/gf180mcu_as_sc_mcu7t3v3__inv_2_341/Y
+ gf180mcu_3v3_12t_2r2w_sram_512x32_array_control_core_0/u_t004_003/VDD detronyx_12t_write_driver_rc1_9/wen
+ gf180mcu_3v3_12t_2r2w_sram_512x32_array_control_core_0/u_t014_025/c1_w0_bl gf180mcu_3v3_12t_2r2w_sram_512x32_array_control_core_0/u_t026_022/c3_w1_bl
+ detronyx_12t_write_driver_rc1_9/wen gf180mcu_3v3_12t_2r2w_sram_512x32_array_control_core_0/a_22600_45000#
+ gf180mcu_3v3_12t_2r2w_sram_512x32_array_control_core_0/u_t028_003/r1_w1_wl gf180mcu_3v3_12t_2r2w_sram_512x32_array_control_core_0/u_t021_030/c3_w0_bl
+ gf180mcu_3v3_12t_2r2w_sram_512x32_array_control_core_0/u_t004_009/c1_w1_bl detronyx_12t_write_driver_rc1_9/wen
+ detronyx_12t_write_driver_rc1_9/wen detronyx_12t_write_driver_rc1_9/wen detronyx_12t_write_driver_rc1_9/wen
+ detronyx_12t_write_driver_rc1_9/wen detronyx_12t_write_driver_rc1_9/wen detronyx_12t_write_driver_rc1_9/wen
+ detronyx_12t_write_driver_rc1_9/wen gf180mcu_3v3_12t_2r2w_sram_512x32_array_control_core_0/u_t021_031/r3_w0_wl
+ gf180mcu_3v3_12t_2r2w_sram_512x32_array_control_core_0/u_t005_003/c1_w1_bl detronyx_12t_write_driver_rc1_9/wen
+ detronyx_12t_write_driver_rc1_9/wen detronyx_12t_write_driver_rc1_9/wen gf180mcu_3v3_12t_2r2w_sram_512x32_array_control_core_0/u_t018_030/c3_w0_bl
+ detronyx_12t_write_driver_rc1_9/wen detronyx_12t_write_driver_rc1_9/wen detronyx_12t_write_driver_rc1_9/wen
+ detronyx_12t_write_driver_rc1_9/wen detronyx_12t_write_driver_rc1_9/wen detronyx_12t_write_driver_rc1_9/wen
+ detronyx_12t_write_driver_rc1_9/wen detronyx_12t_write_driver_rc1_9/wen detronyx_12t_write_driver_rc1_9/wen
+ detronyx_12t_write_driver_rc1_9/wen detronyx_12t_write_driver_rc1_9/wen gf180mcu_3v3_12t_2r2w_sram_512x32_array_control_core_0/u_t017_030/r3_w0_wl
+ gf180mcu_3v3_12t_2r2w_sram_512x32_array_control_core_0/u_t030_018/c1_w1_bl detronyx_12t_write_driver_rc1_9/wen
+ detronyx_12t_write_driver_rc1_9/wen detronyx_12t_write_driver_rc1_9/wen gf180mcu_3v3_12t_2r2w_sram_512x32_array_control_core_0/u_t029_000/r3_w1_wl
+ gf180mcu_3v3_12t_2r2w_sram_512x32_array_control_core_0/gf180mcu_as_sc_mcu7t3v3__inv_2_1685/Y
+ detronyx_12t_write_driver_rc1_9/wen detronyx_12t_write_driver_rc1_9/wen gf180mcu_3v3_12t_2r2w_sram_512x32_array_control_core_0/u_t005_022/c3_w1_bl
+ detronyx_12t_write_driver_rc1_9/wen gf180mcu_3v3_12t_2r2w_sram_512x32_array_control_core_0/a_14200_78600#
+ detronyx_12t_write_driver_rc1_9/wen detronyx_12t_write_driver_rc1_9/wen detronyx_12t_write_driver_rc1_9/wen
+ gf180mcu_3v3_12t_2r2w_sram_512x32_array_control_core_0/u_t026_031/r3_w0_wl gf180mcu_3v3_12t_2r2w_sram_512x32_array_control_core_0/u_t017_000/r3_w1_wl
+ gf180mcu_3v3_12t_2r2w_sram_512x32_array_control_core_0/u_t025_007/c3_w1_bl gf180mcu_3v3_12t_2r2w_sram_512x32_array_control_core_0/u_t017_015/c1_w1_bl
+ detronyx_12t_write_driver_rc1_9/wen detronyx_12t_write_driver_rc1_9/wen gf180mcu_3v3_12t_2r2w_sram_512x32_array_control_core_0/u_t006_016/c3_w1_bl
+ gf180mcu_3v3_12t_2r2w_sram_512x32_array_control_core_0/u_t013_023/c1_w0_bl detronyx_12t_write_driver_rc1_9/wen
+ gf180mcu_3v3_12t_2r2w_sram_512x32_array_control_core_0/u_t009_010/c3_w1_bl gf180mcu_3v3_12t_2r2w_sram_512x32_array_control_core_0/gf180mcu_as_sc_mcu7t3v3__inv_2_661/A
+ gf180mcu_3v3_12t_2r2w_sram_512x32_array_control_core_0/u_t001_024/c3_w0_bl detronyx_12t_write_driver_rc1_9/wen
+ detronyx_12t_write_driver_rc1_9/wen gf180mcu_3v3_12t_2r2w_sram_512x32_array_control_core_0/u_t025_001/r0_w1_wl
+ detronyx_12t_write_driver_rc1_9/wen gf180mcu_3v3_12t_2r2w_sram_512x32_array_control_core_0/u_t009_023/c1_w0_bl
+ detronyx_12t_write_driver_rc1_9/wen gf180mcu_3v3_12t_2r2w_sram_512x32_array_control_core_0/u_t002_001/c1_w1_bl
+ gf180mcu_3v3_12t_2r2w_sram_512x32_array_control_core_0/u_t004_018/VDD detronyx_12t_write_driver_rc1_9/wen
+ gf180mcu_3v3_12t_2r2w_sram_512x32_array_control_core_0/u_t023_009/c3_w1_bl gf180mcu_3v3_12t_2r2w_sram_512x32_array_control_core_0/u_t004_018/VDD
+ gf180mcu_3v3_12t_2r2w_sram_512x32_array_control_core_0/u_t014_017/c1_w1_bl detronyx_12t_write_driver_rc1_9/wen
+ detronyx_12t_write_driver_rc1_9/wen gf180mcu_3v3_12t_2r2w_sram_512x32_array_control_core_0/u_t003_002/r1_w1_wl
+ gf180mcu_3v3_12t_2r2w_sram_512x32_array_control_core_0/u_t004_018/c3_w1_bl detronyx_12t_write_driver_rc1_9/wen
+ detronyx_12t_write_driver_rc1_9/wen gf180mcu_3v3_12t_2r2w_sram_512x32_array_control_core_0/u_t015_011/c1_w1_bl
+ detronyx_12t_write_driver_rc1_9/wen gf180mcu_3v3_12t_2r2w_sram_512x32_array_control_core_0/u_t021_022/c3_w1_bl
+ detronyx_12t_write_driver_rc1_9/wen detronyx_12t_write_driver_rc1_9/wen detronyx_12t_write_driver_rc1_9/wen
+ gf180mcu_3v3_12t_2r2w_sram_512x32_array_control_core_0/u_t004_018/VDD gf180mcu_3v3_12t_2r2w_sram_512x32_array_control_core_0/u_t026_016/c1_w1_bl
+ detronyx_12t_write_driver_rc1_9/wen detronyx_12t_write_driver_rc1_9/wen detronyx_12t_write_driver_rc1_9/wen
+ detronyx_12t_write_driver_rc1_9/wen detronyx_12t_write_driver_rc1_9/wen gf180mcu_3v3_12t_2r2w_sram_512x32_array_control_core_0/u_t009_025/c1_w0_bl
+ detronyx_12t_write_driver_rc1_9/wen detronyx_12t_write_driver_rc1_9/wen gf180mcu_3v3_12t_2r2w_sram_512x32_array_control_core_0/u_t018_022/c3_w1_bl
+ detronyx_12t_write_driver_rc1_9/wen detronyx_12t_write_driver_rc1_9/wen detronyx_12t_write_driver_rc1_9/wen
+ gf180mcu_3v3_12t_2r2w_sram_512x32_array_control_core_0/a_14200_103800# detronyx_12t_write_driver_rc1_9/wen
+ detronyx_12t_write_driver_rc1_9/wen gf180mcu_3v3_12t_2r2w_sram_512x32_array_control_core_0/u_t013_030/c3_w0_bl
+ detronyx_12t_write_driver_rc1_9/wen detronyx_12t_write_driver_rc1_9/wen gf180mcu_3v3_12t_2r2w_sram_512x32_array_control_core_0/u_t024_030/r1_w0_wl
+ detronyx_12t_write_driver_rc1_9/wen detronyx_12t_write_driver_rc1_9/wen detronyx_12t_write_driver_rc1_9/wen
+ detronyx_12t_write_driver_rc1_9/wen detronyx_12t_write_driver_rc1_9/wen gf180mcu_3v3_12t_2r2w_sram_512x32_array_control_core_0/u_t012_030/r1_w0_wl
+ detronyx_12t_write_driver_rc1_9/wen gf180mcu_3v3_12t_2r2w_sram_512x32_array_control_core_0/u_t026_018/c1_w1_bl
+ gf180mcu_3v3_12t_2r2w_sram_512x32_array_control_core_0/a_200_42200# gf180mcu_3v3_12t_2r2w_sram_512x32_array_control_core_0/u_t002_003/VSS
+ detronyx_12t_write_driver_rc1_9/wen detronyx_12t_write_driver_rc1_9/wen detronyx_12t_write_driver_rc1_9/wen
+ gf180mcu_3v3_12t_2r2w_sram_512x32_array_control_core_0/u_t025_000/r0_w1_wl detronyx_12t_write_driver_rc1_9/wen
+ gf180mcu_3v3_12t_2r2w_sram_512x32_array_control_core_0/u_t002_031/r2_w0_wl detronyx_12t_write_driver_rc1_9/wen
+ detronyx_12t_write_driver_rc1_9/wen detronyx_12t_write_driver_rc1_9/wen detronyx_12t_write_driver_rc1_9/wen
+ detronyx_12t_write_driver_rc1_9/wen gf180mcu_3v3_12t_2r2w_sram_512x32_array_control_core_0/a_22600_25400#
+ detronyx_12t_write_driver_rc1_9/wen gf180mcu_3v3_12t_2r2w_sram_512x32_array_control_core_0/u_t030_023/c3_w1_bl
+ gf180mcu_3v3_12t_2r2w_sram_512x32_array_control_core_0/u_t021_031/r3_w0_wl detronyx_12t_write_driver_rc1_9/wen
+ detronyx_12t_write_driver_rc1_9/wen detronyx_12t_write_driver_rc1_9/wen detronyx_12t_write_driver_rc1_9/wen
+ gf180mcu_3v3_12t_2r2w_sram_512x32_array_control_core_0/u_t027_029/c3_w0_bl gf180mcu_3v3_12t_2r2w_sram_512x32_array_control_core_0/a_14200_8600#
+ gf180mcu_3v3_12t_2r2w_sram_512x32_array_control_core_0/u_t020_007/c3_w1_bl detronyx_12t_write_driver_rc1_9/wen
+ gf180mcu_3v3_12t_2r2w_sram_512x32_array_control_core_0/u_t013_015/c1_w1_bl gf180mcu_3v3_12t_2r2w_sram_512x32_array_control_core_0/u_t030_023/c3_w1_bl
+ gf180mcu_3v3_12t_2r2w_sram_512x32_array_control_core_0/u_t019_031/r2_w0_wl detronyx_12t_write_driver_rc1_9/wen
+ gf180mcu_3v3_12t_2r2w_sram_512x32_array_control_core_0/u_t001_016/c3_w1_bl detronyx_12t_write_driver_rc1_9/wen
+ detronyx_12t_write_driver_rc1_9/wen detronyx_12t_write_driver_rc1_9/wen detronyx_12t_write_driver_rc1_9/wen
+ detronyx_12t_write_driver_rc1_9/wen detronyx_12t_write_driver_rc1_9/wen gf180mcu_3v3_12t_2r2w_sram_512x32_array_control_core_0/u_t002_010/c3_w1_bl
+ gf180mcu_3v3_12t_2r2w_sram_512x32_array_control_core_0/u_t018_007/c3_w1_bl gf180mcu_3v3_12t_2r2w_sram_512x32_array_control_core_0/u_t022_002/r3_w1_wl
+ gf180mcu_3v3_12t_2r2w_sram_512x32_array_control_core_0/u_t009_015/c1_w1_bl detronyx_12t_write_driver_rc1_9/wen
+ detronyx_12t_write_driver_rc1_9/wen detronyx_12t_write_driver_rc1_9/wen gf180mcu_3v3_12t_2r2w_sram_512x32_array_control_core_0/u_t020_001/r1_w1_wl
+ detronyx_12t_write_driver_rc1_9/wen gf180mcu_3v3_12t_2r2w_sram_512x32_array_control_core_0/u_t010_002/r2_w1_wl
+ gf180mcu_3v3_12t_2r2w_sram_512x32_array_control_core_0/u_t005_023/c1_w0_bl detronyx_12t_write_driver_rc1_9/wen
+ detronyx_12t_write_driver_rc1_9/wen gf180mcu_3v3_12t_2r2w_sram_512x32_array_control_core_0/a_22600_109400#
+ detronyx_12t_write_driver_rc1_9/wen gf180mcu_3v3_12t_2r2w_sram_512x32_array_control_core_0/u_t026_025/c3_w0_bl
+ detronyx_12t_write_driver_rc1_9/wen gf180mcu_3v3_12t_2r2w_sram_512x32_array_control_core_0/u_t026_008/c1_w1_bl
+ gf180mcu_3v3_12t_2r2w_sram_512x32_array_control_core_0/u_t010_011/c1_w1_bl detronyx_12t_write_driver_rc1_9/wen
+ detronyx_12t_write_driver_rc1_9/wen detronyx_12t_write_driver_rc1_9/wen gf180mcu_3v3_12t_2r2w_sram_512x32_array_control_core_0/u_t017_009/c3_w1_bl
+ detronyx_12t_write_driver_rc1_9/wen detronyx_12t_write_driver_rc1_9/wen gf180mcu_3v3_12t_2r2w_sram_512x32_array_control_core_0/u_t009_017/c1_w1_bl
+ gf180mcu_3v3_12t_2r2w_sram_512x32_array_control_core_0/u_t027_002/c1_w1_bl detronyx_12t_write_driver_rc1_9/wen
+ gf180mcu_3v3_12t_2r2w_sram_512x32_array_control_core_0/u_t021_016/c1_w1_bl detronyx_12t_write_driver_rc1_9/wen
+ gf180mcu_3v3_12t_2r2w_sram_512x32_array_control_core_0/gf180mcu_as_sc_mcu7t3v3__inv_2_1094/A
+ gf180mcu_3v3_12t_2r2w_sram_512x32_array_control_core_0/u_t009_011/c1_w1_bl gf180mcu_3v3_12t_2r2w_sram_512x32_array_control_core_0/u_t028_003/r1_w1_wl
+ detronyx_12t_write_driver_rc1_9/wen gf180mcu_3v3_12t_2r2w_sram_512x32_array_control_core_0/u_t002_025/c1_w0_bl
+ gf180mcu_3v3_12t_2r2w_sram_512x32_array_control_core_0/u_t013_022/c3_w1_bl detronyx_12t_write_driver_rc1_9/wen
+ detronyx_12t_write_driver_rc1_9/wen gf180mcu_3v3_12t_2r2w_sram_512x32_array_control_core_0/u_t019_016/c1_w1_bl
+ gf180mcu_3v3_12t_2r2w_sram_512x32_array_control_core_0/u_t016_003/r0_w1_wl detronyx_12t_write_driver_rc1_9/wen
+ detronyx_12t_write_driver_rc1_9/wen detronyx_12t_write_driver_rc1_9/wen detronyx_12t_write_driver_rc1_9/wen
+ detronyx_12t_write_driver_rc1_9/wen detronyx_12t_write_driver_rc1_9/wen detronyx_12t_write_driver_rc1_9/wen
+ detronyx_12t_write_driver_rc1_9/wen detronyx_12t_write_driver_rc1_9/wen gf180mcu_3v3_12t_2r2w_sram_512x32_array_control_core_0/u_t006_030/c3_w0_bl
+ gf180mcu_3v3_12t_2r2w_sram_512x32_array_control_core_0/u_t030_015/c3_w1_bl detronyx_12t_write_driver_rc1_9/wen
+ detronyx_12t_write_driver_rc1_9/wen detronyx_12t_write_driver_rc1_9/wen detronyx_12t_write_driver_rc1_9/wen
+ gf180mcu_3v3_12t_2r2w_sram_512x32_array_control_core_0/u_t017_018/c1_w1_bl gf180mcu_3v3_12t_2r2w_sram_512x32_array_control_core_0/u_t030_015/c3_w1_bl
+ detronyx_12t_write_driver_rc1_9/wen detronyx_12t_write_driver_rc1_9/wen gf180mcu_3v3_12t_2r2w_sram_512x32_array_control_core_0/u_t022_029/c3_w0_bl
+ detronyx_12t_write_driver_rc1_9/wen gf180mcu_3v3_12t_2r2w_sram_512x32_array_control_core_0/u_t017_000/r3_w1_wl
+ detronyx_12t_write_driver_rc1_9/wen detronyx_12t_write_driver_rc1_9/wen detronyx_12t_write_driver_rc1_9/wen
+ detronyx_12t_write_driver_rc1_9/wen gf180mcu_3v3_12t_2r2w_sram_512x32_array_control_core_0/u_t023_023/c3_w1_bl
+ detronyx_12t_write_driver_rc1_9/wen gf180mcu_3v3_12t_2r2w_sram_512x32_array_control_core_0/u_t014_031/r2_w0_wl
+ gf180mcu_3v3_12t_2r2w_sram_512x32_array_control_core_0/gf180mcu_as_sc_mcu7t3v3__inv_2_1657/Y
+ gf180mcu_3v3_12t_2r2w_sram_512x32_array_control_core_0/u_t005_000/r3_w1_wl detronyx_12t_write_driver_rc1_9/wen
+ detronyx_12t_write_driver_rc1_9/wen detronyx_12t_write_driver_rc1_9/wen gf180mcu_3v3_12t_2r2w_sram_512x32_array_control_core_0/a_14200_87000#
+ gf180mcu_3v3_12t_2r2w_sram_512x32_array_control_core_0/u_t013_007/c3_w1_bl gf180mcu_3v3_12t_2r2w_sram_512x32_array_control_core_0/u_t004_015/c1_w1_bl
+ detronyx_12t_write_driver_rc1_9/wen detronyx_12t_write_driver_rc1_9/wen detronyx_12t_write_driver_rc1_9/wen
+ gf180mcu_3v3_12t_2r2w_sram_512x32_array_control_core_0/a_200_22600# detronyx_12t_write_driver_rc1_9/wen
+ gf180mcu_3v3_12t_2r2w_sram_512x32_array_control_core_0/u_t026_017/c3_w1_bl detronyx_12t_write_driver_rc1_9/wen
+ detronyx_12t_write_driver_rc1_9/wen detronyx_12t_write_driver_rc1_9/wen detronyx_12t_write_driver_rc1_9/wen
+ detronyx_12t_write_driver_rc1_9/wen detronyx_12t_write_driver_rc1_9/wen detronyx_12t_write_driver_rc1_9/wen
+ gf180mcu_3v3_12t_2r2w_sram_512x32_array_control_core_0/u_t021_025/c3_w0_bl gf180mcu_3v3_12t_2r2w_sram_512x32_array_control_core_0/u_t021_008/c1_w1_bl
+ detronyx_12t_write_driver_rc1_9/wen detronyx_12t_write_driver_rc1_9/wen gf180mcu_3v3_12t_2r2w_sram_512x32_array_control_core_0/u_t030_024/c1_w0_bl
+ gf180mcu_3v3_12t_2r2w_sram_512x32_array_control_core_0/u_t013_009/c3_w1_bl gf180mcu_3v3_12t_2r2w_sram_512x32_array_control_core_0/u_t022_002/c1_w1_bl
+ gf180mcu_3v3_12t_2r2w_sram_512x32_array_control_core_0/u_t002_017/c1_w1_bl detronyx_12t_write_driver_rc1_9/wen
+ gf180mcu_3v3_12t_2r2w_sram_512x32_array_control_core_0/u_t019_025/c3_w0_bl gf180mcu_3v3_12t_2r2w_sram_512x32_array_control_core_0/gf180mcu_as_sc_mcu7t3v3__inv_2_1052/A
+ detronyx_12t_write_driver_rc1_9/wen detronyx_12t_write_driver_rc1_9/wen gf180mcu_3v3_12t_2r2w_sram_512x32_array_control_core_0/u_t019_008/c1_w1_bl
+ gf180mcu_3v3_12t_2r2w_sram_512x32_array_control_core_0/u_t023_003/r2_w1_wl gf180mcu_3v3_12t_2r2w_sram_512x32_array_control_core_0/u_t004_011/c1_w1_bl
+ detronyx_12t_write_driver_rc1_9/wen detronyx_12t_write_driver_rc1_9/wen gf180mcu_3v3_12t_2r2w_sram_512x32_array_control_core_0/u_t009_009/c3_w1_bl
+ detronyx_12t_write_driver_rc1_9/wen gf180mcu_3v3_12t_2r2w_sram_512x32_array_control_core_0/u_t014_016/c1_w1_bl
+ detronyx_12t_write_driver_rc1_9/wen detronyx_12t_write_driver_rc1_9/wen detronyx_12t_write_driver_rc1_9/wen
+ gf180mcu_3v3_12t_2r2w_sram_512x32_array_control_core_0/u_t011_003/r1_w1_wl detronyx_12t_write_driver_rc1_9/wen
+ detronyx_12t_write_driver_rc1_9/wen detronyx_12t_write_driver_rc1_9/wen gf180mcu_3v3_12t_2r2w_sram_512x32_array_control_core_0/u_t006_022/c3_w1_bl
+ detronyx_12t_write_driver_rc1_9/wen detronyx_12t_write_driver_rc1_9/wen detronyx_12t_write_driver_rc1_9/wen
+ gf180mcu_3v3_12t_2r2w_sram_512x32_array_control_core_0/u_t027_026/c1_w0_bl gf180mcu_3v3_12t_2r2w_sram_512x32_array_control_core_0/gf180mcu_as_sc_mcu7t3v3__inv_2_1675/Y
+ detronyx_12t_write_driver_rc1_9/wen detronyx_12t_write_driver_rc1_9/wen detronyx_12t_write_driver_rc1_9/wen
+ detronyx_12t_write_driver_rc1_9/wen gf180mcu_3v3_12t_2r2w_sram_512x32_array_control_core_0/u_t001_030/c3_w0_bl
+ detronyx_12t_write_driver_rc1_9/wen detronyx_12t_write_driver_rc1_9/wen gf180mcu_3v3_12t_2r2w_sram_512x32_array_control_core_0/u_t012_030/r1_w0_wl
+ detronyx_12t_write_driver_rc1_9/wen detronyx_12t_write_driver_rc1_9/wen gf180mcu_3v3_12t_2r2w_sram_512x32_array_control_core_0/a_14200_112200#
+ detronyx_12t_write_driver_rc1_9/wen detronyx_12t_write_driver_rc1_9/wen detronyx_12t_write_driver_rc1_9/wen
+ detronyx_12t_write_driver_rc1_9/wen detronyx_12t_write_driver_rc1_9/wen detronyx_12t_write_driver_rc1_9/wen
+ detronyx_12t_write_driver_rc1_9/wen detronyx_12t_write_driver_rc1_9/wen detronyx_12t_write_driver_rc1_9/wen
+ gf180mcu_3v3_12t_2r2w_sram_512x32_array_control_core_0/u_t013_018/c1_w1_bl gf180mcu_3v3_12t_2r2w_sram_512x32_array_control_core_0/u_t023_015/c3_w1_bl
+ detronyx_12t_write_driver_rc1_9/wen gf180mcu_3v3_12t_2r2w_sram_512x32_array_control_core_0/u_t012_000/r3_w1_wl
+ detronyx_12t_write_driver_rc1_9/wen detronyx_12t_write_driver_rc1_9/wen detronyx_12t_write_driver_rc1_9/wen
+ detronyx_12t_write_driver_rc1_9/wen detronyx_12t_write_driver_rc1_9/wen detronyx_12t_write_driver_rc1_9/wen
+ detronyx_12t_write_driver_rc1_9/wen detronyx_12t_write_driver_rc1_9/wen gf180mcu_3v3_12t_2r2w_sram_512x32_array_control_core_0/u_t000_000/r3_w1_wl
+ detronyx_12t_write_driver_rc1_9/wen gf180mcu_3v3_12t_2r2w_sram_512x32_array_control_core_0/u_t015_029/c3_w0_bl
+ detronyx_12t_write_driver_rc1_9/wen gf180mcu_3v3_12t_2r2w_sram_512x32_array_control_core_0/u_t026_022/c1_w0_bl
+ detronyx_12t_write_driver_rc1_9/wen gf180mcu_3v3_12t_2r2w_sram_512x32_array_control_core_0/u_t017_023/c3_w1_bl
+ gf180mcu_3v3_12t_2r2w_sram_512x32_array_control_core_0/u_t009_031/r3_w0_wl detronyx_12t_write_driver_rc1_9/wen
+ detronyx_12t_write_driver_rc1_9/wen detronyx_12t_write_driver_rc1_9/wen gf180mcu_3v3_12t_2r2w_sram_512x32_array_control_core_0/u_t020_001/r1_w1_wl
+ detronyx_12t_write_driver_rc1_9/wen gf180mcu_3v3_12t_2r2w_sram_512x32_array_control_core_0/u_t021_017/c3_w1_bl
+ detronyx_12t_write_driver_rc1_9/wen gf180mcu_3v3_12t_2r2w_sram_512x32_array_control_core_0/u_t006_007/c3_w1_bl
+ detronyx_12t_write_driver_rc1_9/wen detronyx_12t_write_driver_rc1_9/wen detronyx_12t_write_driver_rc1_9/wen
+ detronyx_12t_write_driver_rc1_9/wen gf180mcu_3v3_12t_2r2w_sram_512x32_array_control_core_0/u_t030_016/c1_w1_bl
+ gf180mcu_3v3_12t_2r2w_sram_512x32_array_control_core_0/u_t018_001/r2_w1_wl detronyx_12t_write_driver_rc1_9/wen
+ detronyx_12t_write_driver_rc1_9/wen gf180mcu_3v3_12t_2r2w_sram_512x32_array_control_core_0/u_t019_017/c3_w1_bl
+ detronyx_12t_write_driver_rc1_9/wen gf180mcu_3v3_12t_2r2w_sram_512x32_array_control_core_0/u_t008_002/r3_w1_wl
+ gf180mcu_3v3_12t_2r2w_sram_512x32_array_control_core_0/u_t030_003/r3_w1_wl gf180mcu_3v3_12t_2r2w_sram_512x32_array_control_core_0/u_t026_024/c1_w0_bl
+ detronyx_12t_write_driver_rc1_9/wen gf180mcu_3v3_12t_2r2w_sram_512x32_array_control_core_0/u_t014_025/c3_w0_bl
+ gf180mcu_3v3_12t_2r2w_sram_512x32_array_control_core_0/a_14200_67400# gf180mcu_3v3_12t_2r2w_sram_512x32_array_control_core_0/u_t014_008/c1_w1_bl
+ detronyx_12t_write_driver_rc1_9/wen gf180mcu_3v3_12t_2r2w_sram_512x32_array_control_core_0/u_t004_009/c3_w1_bl
+ detronyx_12t_write_driver_rc1_9/wen gf180mcu_3v3_12t_2r2w_sram_512x32_array_control_core_0/u_t002_025/VSS
+ detronyx_12t_write_driver_rc1_9/wen gf180mcu_3v3_12t_2r2w_sram_512x32_array_control_core_0/u_t015_002/c1_w1_bl
+ detronyx_12t_write_driver_rc1_9/wen detronyx_12t_write_driver_rc1_9/wen gf180mcu_3v3_12t_2r2w_sram_512x32_array_control_core_0/u_t027_018/c1_w1_bl
+ detronyx_12t_write_driver_rc1_9/wen detronyx_12t_write_driver_rc1_9/wen detronyx_12t_write_driver_rc1_9/wen
+ gf180mcu_3v3_12t_2r2w_sram_512x32_array_control_core_0/u_t001_022/c3_w1_bl detronyx_12t_write_driver_rc1_9/wen
+ detronyx_12t_write_driver_rc1_9/wen detronyx_12t_write_driver_rc1_9/wen detronyx_12t_write_driver_rc1_9/wen
+ detronyx_12t_write_driver_rc1_9/wen gf180mcu_3v3_12t_2r2w_sram_512x32_array_control_core_0/u_t022_026/c1_w0_bl
+ gf180mcu_3v3_12t_2r2w_sram_512x32_array_control_core_0/u_t030_030/r3_w0_wl detronyx_12t_write_driver_rc1_9/wen
+ gf180mcu_3v3_12t_2r2w_sram_512x32_array_control_core_0/u_t009_016/c1_w1_bl detronyx_12t_write_driver_rc1_9/wen
+ gf180mcu_3v3_12t_2r2w_sram_512x32_array_control_core_0/u_t004_003/r0_w1_wl detronyx_12t_write_driver_rc1_9/wen
+ detronyx_12t_write_driver_rc1_9/wen detronyx_12t_write_driver_rc1_9/wen detronyx_12t_write_driver_rc1_9/wen
+ detronyx_12t_write_driver_rc1_9/wen detronyx_12t_write_driver_rc1_9/wen detronyx_12t_write_driver_rc1_9/wen
+ detronyx_12t_write_driver_rc1_9/wen detronyx_12t_write_driver_rc1_9/wen detronyx_12t_write_driver_rc1_9/wen
+ detronyx_12t_write_driver_rc1_9/wen gf180mcu_3v3_12t_2r2w_sram_512x32_array_control_core_0/u_t026_031/r3_w0_wl
+ detronyx_12t_write_driver_rc1_9/wen detronyx_12t_write_driver_rc1_9/wen detronyx_12t_write_driver_rc1_9/wen
+ detronyx_12t_write_driver_rc1_9/wen detronyx_12t_write_driver_rc1_9/wen detronyx_12t_write_driver_rc1_9/wen
+ gf180mcu_3v3_12t_2r2w_sram_512x32_array_control_core_0/u_t017_015/c3_w1_bl gf180mcu_3v3_12t_2r2w_sram_512x32_array_control_core_0/u_t005_018/c1_w1_bl
+ gf180mcu_3v3_12t_2r2w_sram_512x32_array_control_core_0/u_t010_029/c3_w0_bl detronyx_12t_write_driver_rc1_9/wen
+ gf180mcu_3v3_12t_2r2w_sram_512x32_array_control_core_0/u_t005_000/r3_w1_wl gf180mcu_3v3_12t_2r2w_sram_512x32_array_control_core_0/u_t026_031/r3_w0_wl
+ gf180mcu_3v3_12t_2r2w_sram_512x32_array_control_core_0/u_t021_022/c1_w0_bl detronyx_12t_write_driver_rc1_9/wen
+ gf180mcu_3v3_12t_2r2w_sram_512x32_array_control_core_0/gf180mcu_as_sc_mcu7t3v3__inv_2_1398/Y
+ gf180mcu_3v3_12t_2r2w_sram_512x32_array_control_core_0/u_t013_023/c3_w1_bl detronyx_12t_write_driver_rc1_9/wen
+ gf180mcu_3v3_12t_2r2w_sram_512x32_array_control_core_0/u_t002_031/r2_w0_wl detronyx_12t_write_driver_rc1_9/wen
+ gf180mcu_3v3_12t_2r2w_sram_512x32_array_control_core_0/u_t009_029/c3_w0_bl gf180mcu_3v3_12t_2r2w_sram_512x32_array_control_core_0/u_t019_022/c1_w0_bl
+ detronyx_12t_write_driver_rc1_9/wen gf180mcu_3v3_12t_2r2w_sram_512x32_array_control_core_0/u_t001_007/c3_w1_bl
+ detronyx_12t_write_driver_rc1_9/wen gf180mcu_3v3_12t_2r2w_sram_512x32_array_control_core_0/u_t009_023/c3_w1_bl
+ detronyx_12t_write_driver_rc1_9/wen gf180mcu_3v3_12t_2r2w_sram_512x32_array_control_core_0/u_t026_016/c1_w1_bl
+ detronyx_12t_write_driver_rc1_9/wen detronyx_12t_write_driver_rc1_9/wen detronyx_12t_write_driver_rc1_9/wen
+ detronyx_12t_write_driver_rc1_9/wen gf180mcu_3v3_12t_2r2w_sram_512x32_array_control_core_0/gf180mcu_as_sc_mcu7t3v3__inv_2_739/A
+ gf180mcu_3v3_12t_2r2w_sram_512x32_array_control_core_0/u_t014_017/c3_w1_bl gf180mcu_3v3_12t_2r2w_sram_512x32_array_control_core_0/u_t025_010/c1_w1_bl
+ detronyx_12t_write_driver_rc1_9/wen gf180mcu_3v3_12t_2r2w_sram_512x32_array_control_core_0/u_t004_002/r0_w1_wl
+ detronyx_12t_write_driver_rc1_9/wen detronyx_12t_write_driver_rc1_9/wen gf180mcu_3v3_12t_2r2w_sram_512x32_array_control_core_0/a_200_31000#
+ detronyx_12t_write_driver_rc1_9/wen detronyx_12t_write_driver_rc1_9/wen detronyx_12t_write_driver_rc1_9/wen
+ gf180mcu_3v3_12t_2r2w_sram_512x32_array_control_core_0/a_22600_14200# gf180mcu_3v3_12t_2r2w_sram_512x32_array_control_core_0/u_t004_018/VDD
+ gf180mcu_3v3_12t_2r2w_sram_512x32_array_control_core_0/u_t023_003/r2_w1_wl gf180mcu_3v3_12t_2r2w_sram_512x32_array_control_core_0/u_t017_024/c1_w0_bl
+ detronyx_12t_write_driver_rc1_9/wen gf180mcu_3v3_12t_2r2w_sram_512x32_array_control_core_0/u_t010_002/c1_w1_bl
+ gf180mcu_3v3_12t_2r2w_sram_512x32_array_control_core_0/u_t009_025/c3_w0_bl detronyx_12t_write_driver_rc1_9/wen
+ detronyx_12t_write_driver_rc1_9/wen gf180mcu_3v3_12t_2r2w_sram_512x32_array_control_core_0/u_t022_018/c1_w1_bl
+ detronyx_12t_write_driver_rc1_9/wen gf180mcu_3v3_12t_2r2w_sram_512x32_array_control_core_0/u_t009_008/c1_w1_bl
+ gf180mcu_3v3_12t_2r2w_sram_512x32_array_control_core_0/u_t011_003/r1_w1_wl gf180mcu_3v3_12t_2r2w_sram_512x32_array_control_core_0/gf180mcu_as_sc_mcu7t3v3__inv_2_997/Y
+ detronyx_12t_write_driver_rc1_9/wen detronyx_12t_write_driver_rc1_9/wen detronyx_12t_write_driver_rc1_9/wen
+ detronyx_12t_write_driver_rc1_9/wen detronyx_12t_write_driver_rc1_9/wen detronyx_12t_write_driver_rc1_9/wen
+ detronyx_12t_write_driver_rc1_9/wen detronyx_12t_write_driver_rc1_9/wen detronyx_12t_write_driver_rc1_9/wen
+ detronyx_12t_write_driver_rc1_9/wen gf180mcu_3v3_12t_2r2w_sram_512x32_array_control_core_0/u_t008_002/c1_w1_bl
+ detronyx_12t_write_driver_rc1_9/wen gf180mcu_3v3_12t_2r2w_sram_512x32_array_control_core_0/u_t002_016/c1_w1_bl
+ detronyx_12t_write_driver_rc1_9/wen detronyx_12t_write_driver_rc1_9/wen detronyx_12t_write_driver_rc1_9/wen
+ detronyx_12t_write_driver_rc1_9/wen detronyx_12t_write_driver_rc1_9/wen gf180mcu_3v3_12t_2r2w_sram_512x32_array_control_core_0/u_t015_026/c1_w0_bl
+ gf180mcu_3v3_12t_2r2w_sram_512x32_array_control_core_0/u_t026_023/c3_w1_bl gf180mcu_3v3_12t_2r2w_sram_512x32_array_control_core_0/a_22600_5800#
+ detronyx_12t_write_driver_rc1_9/wen detronyx_12t_write_driver_rc1_9/wen detronyx_12t_write_driver_rc1_9/wen
+ detronyx_12t_write_driver_rc1_9/wen gf180mcu_3v3_12t_2r2w_sram_512x32_array_control_core_0/a_14200_47800#
+ detronyx_12t_write_driver_rc1_9/wen detronyx_12t_write_driver_rc1_9/wen detronyx_12t_write_driver_rc1_9/wen
+ detronyx_12t_write_driver_rc1_9/wen gf180mcu_3v3_12t_2r2w_sram_512x32_array_control_core_0/a_200_106600#
+ detronyx_12t_write_driver_rc1_9/wen detronyx_12t_write_driver_rc1_9/wen gf180mcu_3v3_12t_2r2w_sram_512x32_array_control_core_0/u_t021_031/r3_w0_wl
+ detronyx_12t_write_driver_rc1_9/wen detronyx_12t_write_driver_rc1_9/wen detronyx_12t_write_driver_rc1_9/wen
+ detronyx_12t_write_driver_rc1_9/wen detronyx_12t_write_driver_rc1_9/wen detronyx_12t_write_driver_rc1_9/wen
+ detronyx_12t_write_driver_rc1_9/wen detronyx_12t_write_driver_rc1_9/wen detronyx_12t_write_driver_rc1_9/wen
+ gf180mcu_3v3_12t_2r2w_sram_512x32_array_control_core_0/u_t030_030/r3_w0_wl detronyx_12t_write_driver_rc1_9/wen
+ gf180mcu_3v3_12t_2r2w_sram_512x32_array_control_core_0/u_t013_015/c3_w1_bl gf180mcu_3v3_12t_2r2w_sram_512x32_array_control_core_0/u_t000_000/r3_w1_wl
+ gf180mcu_3v3_12t_2r2w_sram_512x32_array_control_core_0/u_t021_031/r3_w0_wl gf180mcu_3v3_12t_2r2w_sram_512x32_array_control_core_0/u_t019_031/r2_w0_wl
+ detronyx_12t_write_driver_rc1_9/wen detronyx_12t_write_driver_rc1_9/wen detronyx_12t_write_driver_rc1_9/wen
+ detronyx_12t_write_driver_rc1_9/wen detronyx_12t_write_driver_rc1_9/wen detronyx_12t_write_driver_rc1_9/wen
+ detronyx_12t_write_driver_rc1_9/wen detronyx_12t_write_driver_rc1_9/wen detronyx_12t_write_driver_rc1_9/wen
+ gf180mcu_3v3_12t_2r2w_sram_512x32_array_control_core_0/u_t009_015/c3_w1_bl detronyx_12t_write_driver_rc1_9/wen
+ gf180mcu_3v3_12t_2r2w_sram_512x32_array_control_core_0/u_t005_029/c3_w0_bl detronyx_12t_write_driver_rc1_9/wen
+ detronyx_12t_write_driver_rc1_9/wen detronyx_12t_write_driver_rc1_9/wen gf180mcu_3v3_12t_2r2w_sram_512x32_array_control_core_0/u_t014_022/c1_w0_bl
+ gf180mcu_3v3_12t_2r2w_sram_512x32_array_control_core_0/u_t005_023/c3_w1_bl detronyx_12t_write_driver_rc1_9/wen
+ gf180mcu_3v3_12t_2r2w_sram_512x32_array_control_core_0/gf180mcu_as_sc_mcu7t3v3__inv_2_739/A
+ detronyx_12t_write_driver_rc1_9/wen gf180mcu_3v3_12t_2r2w_sram_512x32_array_control_core_0/u_t028_000/r1_w1_wl
+ detronyx_12t_write_driver_rc1_9/wen detronyx_12t_write_driver_rc1_9/wen gf180mcu_3v3_12t_2r2w_sram_512x32_array_control_core_0/u_t018_001/r2_w1_wl
+ gf180mcu_3v3_12t_2r2w_sram_512x32_array_control_core_0/u_t021_010/c1_w1_bl detronyx_12t_write_driver_rc1_9/wen
+ gf180mcu_3v3_12t_2r2w_sram_512x32_array_control_core_0/u_t026_008/c3_w1_bl gf180mcu_3v3_12t_2r2w_sram_512x32_array_control_core_0/u_t030_003/r3_w1_wl
+ detronyx_12t_write_driver_rc1_9/wen gf180mcu_3v3_12t_2r2w_sram_512x32_array_control_core_0/u_t017_016/c1_w1_bl
+ gf180mcu_3v3_12t_2r2w_sram_512x32_array_control_core_0/gf180mcu_as_sc_mcu7t3v3__inv_2_77/Y
+ detronyx_12t_write_driver_rc1_9/wen gf180mcu_3v3_12t_2r2w_sram_512x32_array_control_core_0/u_t006_001/r2_w1_wl
+ gf180mcu_3v3_12t_2r2w_sram_512x32_array_control_core_0/u_t009_017/c3_w1_bl gf180mcu_3v3_12t_2r2w_sram_512x32_array_control_core_0/u_t018_010/c1_w1_bl
+ gf180mcu_3v3_12t_2r2w_sram_512x32_array_control_core_0/u_t013_024/c1_w0_bl detronyx_12t_write_driver_rc1_9/wen
+ detronyx_12t_write_driver_rc1_9/wen gf180mcu_3v3_12t_2r2w_sram_512x32_array_control_core_0/u_t002_025/c3_w0_bl
+ detronyx_12t_write_driver_rc1_9/wen detronyx_12t_write_driver_rc1_9/wen gf180mcu_3v3_12t_2r2w_sram_512x32_array_control_core_0/u_t030_015/c1_w1_bl
+ gf180mcu_3v3_12t_2r2w_sram_512x32_array_control_core_0/u_t002_008/c1_w1_bl detronyx_12t_write_driver_rc1_9/wen
+ detronyx_12t_write_driver_rc1_9/wen gf180mcu_3v3_12t_2r2w_sram_512x32_array_control_core_0/gf180mcu_as_sc_mcu7t3v3__inv_2_737/A
+ detronyx_12t_write_driver_rc1_9/wen gf180mcu_3v3_12t_2r2w_sram_512x32_array_control_core_0/u_t004_002/c1_w1_bl
+ gf180mcu_3v3_12t_2r2w_sram_512x32_array_control_core_0/u_t015_018/c1_w1_bl detronyx_12t_write_driver_rc1_9/wen
+ detronyx_12t_write_driver_rc1_9/wen detronyx_12t_write_driver_rc1_9/wen detronyx_12t_write_driver_rc1_9/wen
+ gf180mcu_3v3_12t_2r2w_sram_512x32_array_control_core_0/a_200_11400# detronyx_12t_write_driver_rc1_9/wen
+ gf180mcu_3v3_12t_2r2w_sram_512x32_array_control_core_0/u_t010_026/c1_w0_bl gf180mcu_3v3_12t_2r2w_sram_512x32_array_control_core_0/u_t017_030/r3_w0_wl
+ gf180mcu_3v3_12t_2r2w_sram_512x32_array_control_core_0/gf180mcu_as_sc_mcu7t3v3__inv_2_9/A
+ gf180mcu_3v3_12t_2r2w_sram_512x32_array_control_core_0/u_t021_023/c3_w1_bl gf180mcu_3v3_12t_2r2w_sram_512x32_array_control_core_0/u_t004_018/VDD
+ detronyx_12t_write_driver_rc1_9/wen detronyx_12t_write_driver_rc1_9/wen detronyx_12t_write_driver_rc1_9/wen
+ detronyx_12t_write_driver_rc1_9/wen gf180mcu_3v3_12t_2r2w_sram_512x32_array_control_core_0/u_t027_017/c1_w1_bl
+ detronyx_12t_write_driver_rc1_9/wen detronyx_12t_write_driver_rc1_9/wen detronyx_12t_write_driver_rc1_9/wen
+ detronyx_12t_write_driver_rc1_9/wen detronyx_12t_write_driver_rc1_9/wen gf180mcu_3v3_12t_2r2w_sram_512x32_array_control_core_0/u_t005_030/r3_w0_wl
+ detronyx_12t_write_driver_rc1_9/wen detronyx_12t_write_driver_rc1_9/wen detronyx_12t_write_driver_rc1_9/wen
+ gf180mcu_3v3_12t_2r2w_sram_512x32_array_control_core_0/u_t009_026/c1_w0_bl detronyx_12t_write_driver_rc1_9/wen
+ detronyx_12t_write_driver_rc1_9/wen gf180mcu_3v3_12t_2r2w_sram_512x32_array_control_core_0/u_t019_023/c3_w1_bl
+ detronyx_12t_write_driver_rc1_9/wen detronyx_12t_write_driver_rc1_9/wen gf180mcu_3v3_12t_2r2w_sram_512x32_array_control_core_0/u_t024_030/r1_w0_wl
+ detronyx_12t_write_driver_rc1_9/wen detronyx_12t_write_driver_rc1_9/wen detronyx_12t_write_driver_rc1_9/wen
+ detronyx_12t_write_driver_rc1_9/wen detronyx_12t_write_driver_rc1_9/wen gf180mcu_3v3_12t_2r2w_sram_512x32_array_control_core_0/u_t014_031/r2_w0_wl
+ detronyx_12t_write_driver_rc1_9/wen detronyx_12t_write_driver_rc1_9/wen detronyx_12t_write_driver_rc1_9/wen
+ detronyx_12t_write_driver_rc1_9/wen detronyx_12t_write_driver_rc1_9/wen detronyx_12t_write_driver_rc1_9/wen
+ gf180mcu_3v3_12t_2r2w_sram_512x32_array_control_core_0/u_t004_015/c3_w1_bl detronyx_12t_write_driver_rc1_9/wen
+ detronyx_12t_write_driver_rc1_9/wen gf180mcu_3v3_12t_2r2w_sram_512x32_array_control_core_0/u_t013_031/r3_w0_wl
+ detronyx_12t_write_driver_rc1_9/wen detronyx_12t_write_driver_rc1_9/wen detronyx_12t_write_driver_rc1_9/wen
+ gf180mcu_3v3_12t_2r2w_sram_512x32_array_control_core_0/u_t025_001/r3_w1_wl detronyx_12t_write_driver_rc1_9/wen
+ detronyx_12t_write_driver_rc1_9/wen detronyx_12t_write_driver_rc1_9/wen detronyx_12t_write_driver_rc1_9/wen
+ detronyx_12t_write_driver_rc1_9/wen gf180mcu_3v3_12t_2r2w_sram_512x32_array_control_core_0/u_t013_001/r3_w1_wl
+ gf180mcu_3v3_12t_2r2w_sram_512x32_array_control_core_0/u_t009_022/c1_w0_bl detronyx_12t_write_driver_rc1_9/wen
+ detronyx_12t_write_driver_rc1_9/wen gf180mcu_3v3_12t_2r2w_sram_512x32_array_control_core_0/u_t021_008/c3_w1_bl
+ gf180mcu_3v3_12t_2r2w_sram_512x32_array_control_core_0/a_14200_101000# gf180mcu_3v3_12t_2r2w_sram_512x32_array_control_core_0/u_t013_016/c1_w1_bl
+ gf180mcu_3v3_12t_2r2w_sram_512x32_array_control_core_0/u_t030_024/c3_w0_bl gf180mcu_3v3_12t_2r2w_sram_512x32_array_control_core_0/u_t002_017/c3_w1_bl
+ gf180mcu_3v3_12t_2r2w_sram_512x32_array_control_core_0/gf180mcu_as_sc_mcu7t3v3__inv_2_1384/Y
+ gf180mcu_3v3_12t_2r2w_sram_512x32_array_control_core_0/u_t013_010/c1_w1_bl gf180mcu_3v3_12t_2r2w_sram_512x32_array_control_core_0/gf180mcu_as_sc_mcu7t3v3__inv_2_9/A
+ detronyx_12t_write_driver_rc1_9/wen detronyx_12t_write_driver_rc1_9/wen detronyx_12t_write_driver_rc1_9/wen
+ detronyx_12t_write_driver_rc1_9/wen detronyx_12t_write_driver_rc1_9/wen gf180mcu_3v3_12t_2r2w_sram_512x32_array_control_core_0/u_t019_008/c3_w1_bl
+ detronyx_12t_write_driver_rc1_9/wen gf180mcu_3v3_12t_2r2w_sram_512x32_array_control_core_0/u_t025_015/c1_w1_bl
+ detronyx_12t_write_driver_rc1_9/wen gf180mcu_3v3_12t_2r2w_sram_512x32_array_control_core_0/u_t021_002/r0_w1_wl
+ detronyx_12t_write_driver_rc1_9/wen detronyx_12t_write_driver_rc1_9/wen detronyx_12t_write_driver_rc1_9/wen
+ gf180mcu_3v3_12t_2r2w_sram_512x32_array_control_core_0/u_t005_024/c1_w0_bl detronyx_12t_write_driver_rc1_9/wen
+ detronyx_12t_write_driver_rc1_9/wen detronyx_12t_write_driver_rc1_9/wen gf180mcu_3v3_12t_2r2w_sram_512x32_array_control_core_0/gf180mcu_as_sc_mcu7t3v3__inv_2_358/Y
+ gf180mcu_3v3_12t_2r2w_sram_512x32_array_control_core_0/u_t030_003/c1_w1_bl gf180mcu_3v3_12t_2r2w_sram_512x32_array_control_core_0/u_t010_018/c1_w1_bl
+ detronyx_12t_write_driver_rc1_9/wen detronyx_12t_write_driver_rc1_9/wen detronyx_12t_write_driver_rc1_9/wen
+ gf180mcu_3v3_12t_2r2w_sram_512x32_array_control_core_0/u_t009_003/r3_w1_wl gf180mcu_3v3_12t_2r2w_sram_512x32_array_control_core_0/u_t027_009/c1_w1_bl
+ detronyx_12t_write_driver_rc1_9/wen detronyx_12t_write_driver_rc1_9/wen detronyx_12t_write_driver_rc1_9/wen
+ detronyx_12t_write_driver_rc1_9/wen detronyx_12t_write_driver_rc1_9/wen detronyx_12t_write_driver_rc1_9/wen
+ gf180mcu_3v3_12t_2r2w_sram_512x32_array_control_core_0/u_t013_030/r3_w0_wl detronyx_12t_write_driver_rc1_9/wen
+ detronyx_12t_write_driver_rc1_9/wen detronyx_12t_write_driver_rc1_9/wen gf180mcu_3v3_12t_2r2w_sram_512x32_array_control_core_0/u_t009_018/c1_w1_bl
+ gf180mcu_3v3_12t_2r2w_sram_512x32_array_control_core_0/u_t030_003/c1_w1_bl gf180mcu_3v3_12t_2r2w_sram_512x32_array_control_core_0/u_t022_017/c1_w1_bl
+ detronyx_12t_write_driver_rc1_9/wen detronyx_12t_write_driver_rc1_9/wen detronyx_12t_write_driver_rc1_9/wen
+ detronyx_12t_write_driver_rc1_9/wen gf180mcu_3v3_12t_2r2w_sram_512x32_array_control_core_0/u_t014_023/c3_w1_bl
+ gf180mcu_3v3_12t_2r2w_sram_512x32_array_control_core_0/u_t005_026/c1_w0_bl detronyx_12t_write_driver_rc1_9/wen
+ gf180mcu_3v3_12t_2r2w_sram_512x32_array_control_core_0/gf180mcu_as_sc_mcu7t3v3__inv_2_66/Y
+ detronyx_12t_write_driver_rc1_9/wen detronyx_12t_write_driver_rc1_9/wen detronyx_12t_write_driver_rc1_9/wen
+ detronyx_12t_write_driver_rc1_9/wen detronyx_12t_write_driver_rc1_9/wen detronyx_12t_write_driver_rc1_9/wen
+ gf180mcu_3v3_12t_2r2w_sram_512x32_array_control_core_0/u_t021_031/r3_w0_wl detronyx_12t_write_driver_rc1_9/wen
+ gf180mcu_3v3_12t_2r2w_sram_512x32_array_control_core_0/a_14200_56200# detronyx_12t_write_driver_rc1_9/wen
+ detronyx_12t_write_driver_rc1_9/wen gf180mcu_3v3_12t_2r2w_sram_512x32_array_control_core_0/a_200_115000#
+ gf180mcu_3v3_12t_2r2w_sram_512x32_array_control_core_0/u_t026_022/c3_w1_bl detronyx_12t_write_driver_rc1_9/wen
+ gf180mcu_3v3_12t_2r2w_sram_512x32_array_control_core_0/u_t017_030/r3_w0_wl detronyx_12t_write_driver_rc1_9/wen
+ detronyx_12t_write_driver_rc1_9/wen gf180mcu_3v3_12t_2r2w_sram_512x32_array_control_core_0/u_t009_031/r3_w0_wl
+ detronyx_12t_write_driver_rc1_9/wen detronyx_12t_write_driver_rc1_9/wen detronyx_12t_write_driver_rc1_9/wen
+ gf180mcu_3v3_12t_2r2w_sram_512x32_array_control_core_0/u_t021_001/r0_w1_wl detronyx_12t_write_driver_rc1_9/wen
+ detronyx_12t_write_driver_rc1_9/wen detronyx_12t_write_driver_rc1_9/wen detronyx_12t_write_driver_rc1_9/wen
+ gf180mcu_3v3_12t_2r2w_sram_512x32_array_control_core_0/u_t028_000/r1_w1_wl gf180mcu_3v3_12t_2r2w_sram_512x32_array_control_core_0/u_t030_016/c3_w1_bl
+ detronyx_12t_write_driver_rc1_9/wen detronyx_12t_write_driver_rc1_9/wen gf180mcu_3v3_12t_2r2w_sram_512x32_array_control_core_0/u_t002_022/c1_w0_bl
+ detronyx_12t_write_driver_rc1_9/wen detronyx_12t_write_driver_rc1_9/wen detronyx_12t_write_driver_rc1_9/wen
+ gf180mcu_3v3_12t_2r2w_sram_512x32_array_control_core_0/u_t016_000/r0_w1_wl gf180mcu_3v3_12t_2r2w_sram_512x32_array_control_core_0/u_t026_024/c3_w0_bl
+ detronyx_12t_write_driver_rc1_9/wen detronyx_12t_write_driver_rc1_9/wen gf180mcu_3v3_12t_2r2w_sram_512x32_array_control_core_0/u_t006_001/r2_w1_wl
+ detronyx_12t_write_driver_rc1_9/wen gf180mcu_3v3_12t_2r2w_sram_512x32_array_control_core_0/gf180mcu_as_sc_mcu7t3v3__inv_2_732/Y
+ detronyx_12t_write_driver_rc1_9/wen gf180mcu_3v3_12t_2r2w_sram_512x32_array_control_core_0/gf180mcu_as_sc_mcu7t3v3__inv_2_631/A
+ gf180mcu_3v3_12t_2r2w_sram_512x32_array_control_core_0/u_t014_008/c3_w1_bl gf180mcu_3v3_12t_2r2w_sram_512x32_array_control_core_0/u_t005_016/c1_w1_bl
+ gf180mcu_3v3_12t_2r2w_sram_512x32_array_control_core_0/u_t025_001/c1_w1_bl detronyx_12t_write_driver_rc1_9/wen
+ detronyx_12t_write_driver_rc1_9/wen gf180mcu_3v3_12t_2r2w_sram_512x32_array_control_core_0/u_t006_010/c1_w1_bl
+ detronyx_12t_write_driver_rc1_9/wen gf180mcu_3v3_12t_2r2w_sram_512x32_array_control_core_0/u_t027_018/c3_w1_bl
+ detronyx_12t_write_driver_rc1_9/wen detronyx_12t_write_driver_rc1_9/wen detronyx_12t_write_driver_rc1_9/wen
+ gf180mcu_3v3_12t_2r2w_sram_512x32_array_control_core_0/u_t017_003/r0_w1_wl detronyx_12t_write_driver_rc1_9/wen
+ detronyx_12t_write_driver_rc1_9/wen detronyx_12t_write_driver_rc1_9/wen gf180mcu_3v3_12t_2r2w_sram_512x32_array_control_core_0/u_t017_015/c1_w1_bl
+ detronyx_12t_write_driver_rc1_9/wen detronyx_12t_write_driver_rc1_9/wen detronyx_12t_write_driver_rc1_9/wen
+ gf180mcu_3v3_12t_2r2w_sram_512x32_array_control_core_0/u_t002_025/VSS gf180mcu_3v3_12t_2r2w_sram_512x32_array_control_core_0/u_t022_009/c1_w1_bl
+ detronyx_12t_write_driver_rc1_9/wen detronyx_12t_write_driver_rc1_9/wen gf180mcu_3v3_12t_2r2w_sram_512x32_array_control_core_0/gf180mcu_as_sc_mcu7t3v3__inv_2_1144/A
+ detronyx_12t_write_driver_rc1_9/wen detronyx_12t_write_driver_rc1_9/wen detronyx_12t_write_driver_rc1_9/wen
+ gf180mcu_3v3_12t_2r2w_sram_512x32_array_control_core_0/u_t023_003/c1_w1_bl gf180mcu_3v3_12t_2r2w_sram_512x32_array_control_core_0/u_t005_018/c1_w1_bl
+ detronyx_12t_write_driver_rc1_9/wen detronyx_12t_write_driver_rc1_9/wen detronyx_12t_write_driver_rc1_9/wen
+ detronyx_12t_write_driver_rc1_9/wen detronyx_12t_write_driver_rc1_9/wen gf180mcu_3v3_12t_2r2w_sram_512x32_array_control_core_0/u_t005_030/r3_w0_wl
+ detronyx_12t_write_driver_rc1_9/wen detronyx_12t_write_driver_rc1_9/wen gf180mcu_3v3_12t_2r2w_sram_512x32_array_control_core_0/u_t015_017/c1_w1_bl
+ detronyx_12t_write_driver_rc1_9/wen gf180mcu_3v3_12t_2r2w_sram_512x32_array_control_core_0/gf180mcu_as_sc_mcu7t3v3__inv_2_1682/Y
+ detronyx_12t_write_driver_rc1_9/wen gf180mcu_3v3_12t_2r2w_sram_512x32_array_control_core_0/gf180mcu_as_sc_mcu7t3v3__inv_2_338/Y
+ detronyx_12t_write_driver_rc1_9/wen detronyx_12t_write_driver_rc1_9/wen detronyx_12t_write_driver_rc1_9/wen
+ detronyx_12t_write_driver_rc1_9/wen detronyx_12t_write_driver_rc1_9/wen detronyx_12t_write_driver_rc1_9/wen
+ gf180mcu_3v3_12t_2r2w_sram_512x32_array_control_core_0/gf180mcu_as_sc_mcu7t3v3__inv_2_66/Y
+ detronyx_12t_write_driver_rc1_9/wen gf180mcu_3v3_12t_2r2w_sram_512x32_array_control_core_0/u_t009_023/c3_w1_bl
+ gf180mcu_3v3_12t_2r2w_sram_512x32_array_control_core_0/u_t021_022/c3_w1_bl detronyx_12t_write_driver_rc1_9/wen
+ detronyx_12t_write_driver_rc1_9/wen detronyx_12t_write_driver_rc1_9/wen detronyx_12t_write_driver_rc1_9/wen
+ gf180mcu_3v3_12t_2r2w_sram_512x32_array_control_core_0/u_t012_030/r1_w0_wl detronyx_12t_write_driver_rc1_9/wen
+ detronyx_12t_write_driver_rc1_9/wen gf180mcu_3v3_12t_2r2w_sram_512x32_array_control_core_0/u_t002_031/r2_w0_wl
+ detronyx_12t_write_driver_rc1_9/wen detronyx_12t_write_driver_rc1_9/wen detronyx_12t_write_driver_rc1_9/wen
+ detronyx_12t_write_driver_rc1_9/wen detronyx_12t_write_driver_rc1_9/wen detronyx_12t_write_driver_rc1_9/wen
+ gf180mcu_3v3_12t_2r2w_sram_512x32_array_control_core_0/u_t019_022/c3_w1_bl detronyx_12t_write_driver_rc1_9/wen
+ detronyx_12t_write_driver_rc1_9/wen gf180mcu_3v3_12t_2r2w_sram_512x32_array_control_core_0/gf180mcu_as_sc_mcu7t3v3__inv_2_1379/Y
+ VSUBS detronyx_12t_write_driver_rc1_9/wen gf180mcu_3v3_12t_2r2w_sram_512x32_array_control_core_0/u_t023_000/r2_w1_wl
+ detronyx_12t_write_driver_rc1_9/wen detronyx_12t_write_driver_rc1_9/wen detronyx_12t_write_driver_rc1_9/wen
+ gf180mcu_3v3_12t_2r2w_sram_512x32_array_control_core_0/u_t025_016/c3_w1_bl detronyx_12t_write_driver_rc1_9/wen
+ gf180mcu_3v3_12t_2r2w_sram_512x32_array_control_core_0/u_t013_001/r3_w1_wl detronyx_12t_write_driver_rc1_9/wen
+ detronyx_12t_write_driver_rc1_9/wen gf180mcu_3v3_12t_2r2w_sram_512x32_array_control_core_0/u_t025_010/c3_w1_bl
+ detronyx_12t_write_driver_rc1_9/wen detronyx_12t_write_driver_rc1_9/wen gf180mcu_3v3_12t_2r2w_sram_512x32_array_control_core_0/u_t011_000/r1_w1_wl
+ detronyx_12t_write_driver_rc1_9/wen gf180mcu_3v3_12t_2r2w_sram_512x32_array_control_core_0/gf180mcu_as_sc_mcu7t3v3__inv_2_358/Y
+ detronyx_12t_write_driver_rc1_9/wen gf180mcu_3v3_12t_2r2w_sram_512x32_array_control_core_0/a_200_59000#
+ gf180mcu_3v3_12t_2r2w_sram_512x32_array_control_core_0/u_t001_001/r2_w1_wl detronyx_12t_write_driver_rc1_9/wen
+ gf180mcu_3v3_12t_2r2w_sram_512x32_array_control_core_0/a_14200_36600# gf180mcu_3v3_12t_2r2w_sram_512x32_array_control_core_0/u_t027_023/c1_w0_bl
+ gf180mcu_3v3_12t_2r2w_sram_512x32_array_control_core_0/u_t020_001/c1_w1_bl detronyx_12t_write_driver_rc1_9/wen
+ gf180mcu_3v3_12t_2r2w_sram_512x32_array_control_core_0/u_t017_024/c3_w0_bl gf180mcu_3v3_12t_2r2w_sram_512x32_array_control_core_0/gf180mcu_as_sc_mcu7t3v3__inv_2_992/A
+ gf180mcu_3v3_12t_2r2w_sram_512x32_array_control_core_0/u_t001_010/c1_w1_bl detronyx_12t_write_driver_rc1_9/wen
+ detronyx_12t_write_driver_rc1_9/wen gf180mcu_3v3_12t_2r2w_sram_512x32_array_control_core_0/u_t022_018/c3_w1_bl
+ gf180mcu_3v3_12t_2r2w_sram_512x32_array_control_core_0/u_t009_008/c3_w1_bl detronyx_12t_write_driver_rc1_9/wen
+ gf180mcu_3v3_12t_2r2w_sram_512x32_array_control_core_0/u_t018_001/c1_w1_bl gf180mcu_3v3_12t_2r2w_sram_512x32_array_control_core_0/u_t013_015/c1_w1_bl
+ detronyx_12t_write_driver_rc1_9/wen detronyx_12t_write_driver_rc1_9/wen detronyx_12t_write_driver_rc1_9/wen
+ gf180mcu_3v3_12t_2r2w_sram_512x32_array_control_core_0/u_t019_002/r1_w1_wl detronyx_12t_write_driver_rc1_9/wen
+ gf180mcu_3v3_12t_2r2w_sram_512x32_array_control_core_0/gf180mcu_as_sc_mcu7t3v3__inv_2_997/Y
+ detronyx_12t_write_driver_rc1_9/wen gf180mcu_3v3_12t_2r2w_sram_512x32_array_control_core_0/u_t009_003/r3_w1_wl
+ gf180mcu_3v3_12t_2r2w_sram_512x32_array_control_core_0/gf180mcu_as_sc_mcu7t3v3__inv_2_1398/Y
+ detronyx_12t_write_driver_rc1_9/wen gf180mcu_3v3_12t_2r2w_sram_512x32_array_control_core_0/gf180mcu_as_sc_mcu7t3v3__inv_2_848/Y
+ gf180mcu_3v3_12t_2r2w_sram_512x32_array_control_core_0/u_t026_025/c1_w0_bl detronyx_12t_write_driver_rc1_9/wen
+ gf180mcu_3v3_12t_2r2w_sram_512x32_array_control_core_0/u_t007_002/r1_w1_wl gf180mcu_3v3_12t_2r2w_sram_512x32_array_control_core_0/gf180mcu_as_sc_mcu7t3v3__inv_2_77/Y
+ detronyx_12t_write_driver_rc1_9/wen detronyx_12t_write_driver_rc1_9/wen gf180mcu_3v3_12t_2r2w_sram_512x32_array_control_core_0/gf180mcu_as_sc_mcu7t3v3__inv_2_848/Y
+ gf180mcu_3v3_12t_2r2w_sram_512x32_array_control_core_0/u_t015_009/c1_w1_bl detronyx_12t_write_driver_rc1_9/wen
+ detronyx_12t_write_driver_rc1_9/wen gf180mcu_3v3_12t_2r2w_sram_512x32_array_control_core
Xdetronyx_12t_write_driver_rc1_60 detronyx_12t_write_driver_rc1_60/VDD VSUBS detronyx_12t_write_driver_rc1_60/din
+ detronyx_12t_write_driver_rc1_9/wen detronyx_12t_write_driver_rc1_60/wbl0 detronyx_12t_write_driver_rc1_9/wen
+ detronyx_12t_write_driver_rc1
Xdetronyx_12t_write_driver_rc1_50 detronyx_12t_write_driver_rc1_50/VDD VSUBS detronyx_12t_write_driver_rc1_50/din
+ detronyx_12t_write_driver_rc1_9/wen detronyx_12t_write_driver_rc1_50/wbl0 detronyx_12t_write_driver_rc1_9/wen
+ detronyx_12t_write_driver_rc1
Xdetronyx_12t_write_driver_rc1_61 detronyx_12t_write_driver_rc1_61/VDD VSUBS detronyx_12t_write_driver_rc1_61/din
+ detronyx_12t_write_driver_rc1_9/wen detronyx_12t_write_driver_rc1_61/wbl0 detronyx_12t_write_driver_rc1_9/wen
+ detronyx_12t_write_driver_rc1
Xdetronyx_12t_write_driver_rc1_51 detronyx_12t_write_driver_rc1_51/VDD VSUBS detronyx_12t_write_driver_rc1_51/din
+ detronyx_12t_write_driver_rc1_9/wen detronyx_12t_write_driver_rc1_51/wbl0 detronyx_12t_write_driver_rc1_9/wen
+ detronyx_12t_write_driver_rc1
Xdetronyx_12t_write_driver_rc1_62 detronyx_12t_write_driver_rc1_62/VDD VSUBS detronyx_12t_write_driver_rc1_9/wen
+ detronyx_12t_write_driver_rc1_9/wen detronyx_12t_write_driver_rc1_9/wen detronyx_12t_write_driver_rc1_9/wen
+ detronyx_12t_write_driver_rc1
Xdetronyx_12t_write_driver_rc1_40 detronyx_12t_write_driver_rc1_40/VDD VSUBS detronyx_12t_write_driver_rc1_9/wen
+ detronyx_12t_write_driver_rc1_9/wen detronyx_12t_write_driver_rc1_9/wen detronyx_12t_write_driver_rc1_9/wen
+ detronyx_12t_write_driver_rc1
Xdetronyx_12t_write_driver_rc1_41 detronyx_12t_write_driver_rc1_41/VDD VSUBS detronyx_12t_write_driver_rc1_41/din
+ detronyx_12t_write_driver_rc1_9/wen detronyx_12t_write_driver_rc1_41/wbl0 detronyx_12t_write_driver_rc1_41/wbr0
+ detronyx_12t_write_driver_rc1
Xdetronyx_12t_write_driver_rc1_30 detronyx_12t_write_driver_rc1_30/VDD VSUBS detronyx_12t_write_driver_rc1_9/wen
+ detronyx_12t_write_driver_rc1_9/wen detronyx_12t_write_driver_rc1_9/wen detronyx_12t_write_driver_rc1_9/wen
+ detronyx_12t_write_driver_rc1
Xdetronyx_12t_write_driver_rc1_52 detronyx_12t_write_driver_rc1_52/VDD VSUBS detronyx_12t_write_driver_rc1_52/din
+ detronyx_12t_write_driver_rc1_9/wen detronyx_12t_write_driver_rc1_52/wbl0 detronyx_12t_write_driver_rc1_9/wen
+ detronyx_12t_write_driver_rc1
Xdetronyx_12t_write_driver_rc1_63 detronyx_12t_write_driver_rc1_63/VDD VSUBS detronyx_12t_write_driver_rc1_63/din
+ detronyx_12t_write_driver_rc1_9/wen detronyx_12t_write_driver_rc1_63/wbl0 detronyx_12t_write_driver_rc1_9/wen
+ detronyx_12t_write_driver_rc1
Xdetronyx_12t_write_driver_rc1_42 detronyx_12t_write_driver_rc1_42/VDD VSUBS detronyx_12t_write_driver_rc1_42/din
+ detronyx_12t_write_driver_rc1_9/wen detronyx_12t_write_driver_rc1_42/wbl0 detronyx_12t_write_driver_rc1_9/wen
+ detronyx_12t_write_driver_rc1
Xdetronyx_12t_write_driver_rc1_31 detronyx_12t_write_driver_rc1_31/VDD VSUBS detronyx_12t_write_driver_rc1_9/wen
+ detronyx_12t_write_driver_rc1_9/wen detronyx_12t_write_driver_rc1_9/wen detronyx_12t_write_driver_rc1_9/wen
+ detronyx_12t_write_driver_rc1
Xdetronyx_12t_write_driver_rc1_53 detronyx_12t_write_driver_rc1_53/VDD VSUBS detronyx_12t_write_driver_rc1_53/din
+ detronyx_12t_write_driver_rc1_9/wen detronyx_12t_write_driver_rc1_53/wbl0 detronyx_12t_write_driver_rc1_9/wen
+ detronyx_12t_write_driver_rc1
Xdetronyx_12t_write_driver_rc1_20 detronyx_12t_write_driver_rc1_20/VDD VSUBS detronyx_12t_write_driver_rc1_9/wen
+ detronyx_12t_write_driver_rc1_9/wen detronyx_12t_write_driver_rc1_9/wen detronyx_12t_write_driver_rc1_9/wen
+ detronyx_12t_write_driver_rc1
Xdetronyx_12t_precharge_sense_rc1_60 detronyx_12t_precharge_sense_rc1_60/VDD VSUBS
+ detronyx_12t_write_driver_rc1_9/wen detronyx_12t_precharge_sense_rc1_60/ren detronyx_12t_precharge_sense_rc1_60/ren
+ detronyx_12t_write_driver_rc1_9/wen detronyx_12t_precharge_sense_rc1
Xdetronyx_12t_write_driver_rc1_43 detronyx_12t_write_driver_rc1_43/VDD VSUBS detronyx_12t_write_driver_rc1_43/din
+ detronyx_12t_write_driver_rc1_9/wen detronyx_12t_write_driver_rc1_43/wbl0 detronyx_12t_write_driver_rc1_9/wen
+ detronyx_12t_write_driver_rc1
Xdetronyx_12t_write_driver_rc1_32 detronyx_12t_write_driver_rc1_32/VDD VSUBS detronyx_12t_write_driver_rc1_9/wen
+ detronyx_12t_write_driver_rc1_9/wen detronyx_12t_write_driver_rc1_9/wen detronyx_12t_write_driver_rc1_9/wen
+ detronyx_12t_write_driver_rc1
Xdetronyx_12t_write_driver_rc1_54 detronyx_12t_write_driver_rc1_54/VDD VSUBS detronyx_12t_write_driver_rc1_54/din
+ detronyx_12t_write_driver_rc1_9/wen detronyx_12t_write_driver_rc1_54/wbl0 detronyx_12t_write_driver_rc1_9/wen
+ detronyx_12t_write_driver_rc1
Xdetronyx_12t_write_driver_rc1_21 detronyx_12t_write_driver_rc1_21/VDD VSUBS detronyx_12t_write_driver_rc1_9/wen
+ detronyx_12t_write_driver_rc1_9/wen detronyx_12t_write_driver_rc1_9/wen detronyx_12t_write_driver_rc1_9/wen
+ detronyx_12t_write_driver_rc1
Xdetronyx_12t_write_driver_rc1_10 detronyx_12t_write_driver_rc1_10/VDD VSUBS detronyx_12t_write_driver_rc1_10/din
+ detronyx_12t_write_driver_rc1_9/wen detronyx_12t_write_driver_rc1_10/wbl0 detronyx_12t_write_driver_rc1_9/wen
+ detronyx_12t_write_driver_rc1
Xdetronyx_12t_precharge_sense_rc1_61 detronyx_12t_precharge_sense_rc1_61/VDD VSUBS
+ detronyx_12t_write_driver_rc1_9/wen detronyx_12t_precharge_sense_rc1_61/ren detronyx_12t_precharge_sense_rc1_61/ren
+ detronyx_12t_write_driver_rc1_9/wen detronyx_12t_precharge_sense_rc1
Xdetronyx_12t_precharge_sense_rc1_50 detronyx_12t_precharge_sense_rc1_50/VDD VSUBS
+ detronyx_12t_write_driver_rc1_9/wen detronyx_12t_write_driver_rc1_9/wen detronyx_12t_write_driver_rc1_9/wen
+ detronyx_12t_write_driver_rc1_9/wen detronyx_12t_precharge_sense_rc1
.ends
