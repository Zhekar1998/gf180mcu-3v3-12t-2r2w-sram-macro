* Independent 12T 2R2W 4x4 tile reference for detronyx_12t_2w2r_rc4_4x4_routed_5layer_direct
* Generated from intended MOS topology, not extracted layout.

.subckt detronyx_12t_2w2r_rc4_4x4_routed_5layer_direct c0_w0_bl c0_w0_br c0_w1_bl c0_w1_br c0_r0_rbl c0_r1_rbl c1_w0_bl c1_w0_br c1_w1_bl c1_w1_br c1_r0_rbl c1_r1_rbl c2_w0_bl c2_w0_br c2_w1_bl c2_w1_br c2_r0_rbl c2_r1_rbl c3_w0_bl c3_w0_br c3_w1_bl c3_w1_br c3_r0_rbl c3_r1_rbl r0_w0_wl r0_w1_wl r0_r0_rwl r0_r1_rwl r1_w0_wl r1_w1_wl r1_r0_rwl r1_r1_rwl r2_w0_wl r2_w1_wl r2_r0_rwl r2_r1_rwl r3_w0_wl r3_w1_wl r3_r0_rwl r3_r1_rwl VDD VSS
Xr0c0_XP_Q gf180mcu_3v3_12t_2r2w_bitcellr0c0/q gf180mcu_3v3_12t_2r2w_bitcellr0c0/qb VDD gf180mcu_3v3_12t_2r2w_bitcellr0c0/NWELL pfet_03v3 w=0.28u l=0.28u
Xr0c0_XN_Q gf180mcu_3v3_12t_2r2w_bitcellr0c0/q gf180mcu_3v3_12t_2r2w_bitcellr0c0/qb VSS VSUBS nfet_03v3 w=0.45u l=0.28u
Xr0c0_XP_QB gf180mcu_3v3_12t_2r2w_bitcellr0c0/qb gf180mcu_3v3_12t_2r2w_bitcellr0c0/q VDD gf180mcu_3v3_12t_2r2w_bitcellr0c0/NWELL pfet_03v3 w=0.28u l=0.28u
Xr0c0_XN_QB gf180mcu_3v3_12t_2r2w_bitcellr0c0/qb gf180mcu_3v3_12t_2r2w_bitcellr0c0/q VSS VSUBS nfet_03v3 w=0.45u l=0.28u
Xr0c0_XW0_Q gf180mcu_3v3_12t_2r2w_bitcellr0c0/q r0_w0_wl c0_w0_bl VSUBS nfet_03v3 w=0.28u l=0.36u
Xr0c0_XW0_QB gf180mcu_3v3_12t_2r2w_bitcellr0c0/qb r0_w0_wl c0_w0_br VSUBS nfet_03v3 w=0.28u l=0.36u
Xr0c0_XW1_Q gf180mcu_3v3_12t_2r2w_bitcellr0c0/q r0_w1_wl c0_w1_bl VSUBS nfet_03v3 w=0.28u l=0.36u
Xr0c0_XW1_QB gf180mcu_3v3_12t_2r2w_bitcellr0c0/qb r0_w1_wl c0_w1_br VSUBS nfet_03v3 w=0.28u l=0.36u
Xr0c0_XR0_Q gf180mcu_3v3_12t_2r2w_bitcellr0c0/r0_mid gf180mcu_3v3_12t_2r2w_bitcellr0c0/q VSS VSUBS nfet_03v3 w=0.53u l=0.28u
Xr0c0_XR0_SEL gf180mcu_3v3_12t_2r2w_bitcellr0c0/r0_mid r0_r0_rwl c0_r0_rbl VSUBS nfet_03v3 w=0.53u l=0.28u
Xr0c0_XR1_Q gf180mcu_3v3_12t_2r2w_bitcellr0c0/r1_mid gf180mcu_3v3_12t_2r2w_bitcellr0c0/q VSS VSUBS nfet_03v3 w=0.53u l=0.28u
Xr0c0_XR1_SEL gf180mcu_3v3_12t_2r2w_bitcellr0c0/r1_mid r0_r1_rwl c0_r1_rbl VSUBS nfet_03v3 w=0.53u l=0.28u
Xr0c1_XP_Q gf180mcu_3v3_12t_2r2w_bitcellr0c1/q gf180mcu_3v3_12t_2r2w_bitcellr0c1/qb VDD gf180mcu_3v3_12t_2r2w_bitcellr0c1/NWELL pfet_03v3 w=0.28u l=0.28u
Xr0c1_XN_Q gf180mcu_3v3_12t_2r2w_bitcellr0c1/q gf180mcu_3v3_12t_2r2w_bitcellr0c1/qb VSS VSUBS nfet_03v3 w=0.45u l=0.28u
Xr0c1_XP_QB gf180mcu_3v3_12t_2r2w_bitcellr0c1/qb gf180mcu_3v3_12t_2r2w_bitcellr0c1/q VDD gf180mcu_3v3_12t_2r2w_bitcellr0c1/NWELL pfet_03v3 w=0.28u l=0.28u
Xr0c1_XN_QB gf180mcu_3v3_12t_2r2w_bitcellr0c1/qb gf180mcu_3v3_12t_2r2w_bitcellr0c1/q VSS VSUBS nfet_03v3 w=0.45u l=0.28u
Xr0c1_XW0_Q gf180mcu_3v3_12t_2r2w_bitcellr0c1/q r0_w0_wl c1_w0_bl VSUBS nfet_03v3 w=0.28u l=0.36u
Xr0c1_XW0_QB gf180mcu_3v3_12t_2r2w_bitcellr0c1/qb r0_w0_wl c1_w0_br VSUBS nfet_03v3 w=0.28u l=0.36u
Xr0c1_XW1_Q gf180mcu_3v3_12t_2r2w_bitcellr0c1/q r0_w1_wl c1_w1_bl VSUBS nfet_03v3 w=0.28u l=0.36u
Xr0c1_XW1_QB gf180mcu_3v3_12t_2r2w_bitcellr0c1/qb r0_w1_wl c1_w1_br VSUBS nfet_03v3 w=0.28u l=0.36u
Xr0c1_XR0_Q gf180mcu_3v3_12t_2r2w_bitcellr0c1/r0_mid gf180mcu_3v3_12t_2r2w_bitcellr0c1/q VSS VSUBS nfet_03v3 w=0.53u l=0.28u
Xr0c1_XR0_SEL gf180mcu_3v3_12t_2r2w_bitcellr0c1/r0_mid r0_r0_rwl c1_r0_rbl VSUBS nfet_03v3 w=0.53u l=0.28u
Xr0c1_XR1_Q gf180mcu_3v3_12t_2r2w_bitcellr0c1/r1_mid gf180mcu_3v3_12t_2r2w_bitcellr0c1/q VSS VSUBS nfet_03v3 w=0.53u l=0.28u
Xr0c1_XR1_SEL gf180mcu_3v3_12t_2r2w_bitcellr0c1/r1_mid r0_r1_rwl c1_r1_rbl VSUBS nfet_03v3 w=0.53u l=0.28u
Xr0c2_XP_Q gf180mcu_3v3_12t_2r2w_bitcellr0c2/q gf180mcu_3v3_12t_2r2w_bitcellr0c2/qb VDD gf180mcu_3v3_12t_2r2w_bitcellr0c2/NWELL pfet_03v3 w=0.28u l=0.28u
Xr0c2_XN_Q gf180mcu_3v3_12t_2r2w_bitcellr0c2/q gf180mcu_3v3_12t_2r2w_bitcellr0c2/qb VSS VSUBS nfet_03v3 w=0.45u l=0.28u
Xr0c2_XP_QB gf180mcu_3v3_12t_2r2w_bitcellr0c2/qb gf180mcu_3v3_12t_2r2w_bitcellr0c2/q VDD gf180mcu_3v3_12t_2r2w_bitcellr0c2/NWELL pfet_03v3 w=0.28u l=0.28u
Xr0c2_XN_QB gf180mcu_3v3_12t_2r2w_bitcellr0c2/qb gf180mcu_3v3_12t_2r2w_bitcellr0c2/q VSS VSUBS nfet_03v3 w=0.45u l=0.28u
Xr0c2_XW0_Q gf180mcu_3v3_12t_2r2w_bitcellr0c2/q r0_w0_wl c2_w0_bl VSUBS nfet_03v3 w=0.28u l=0.36u
Xr0c2_XW0_QB gf180mcu_3v3_12t_2r2w_bitcellr0c2/qb r0_w0_wl c2_w0_br VSUBS nfet_03v3 w=0.28u l=0.36u
Xr0c2_XW1_Q gf180mcu_3v3_12t_2r2w_bitcellr0c2/q r0_w1_wl c2_w1_bl VSUBS nfet_03v3 w=0.28u l=0.36u
Xr0c2_XW1_QB gf180mcu_3v3_12t_2r2w_bitcellr0c2/qb r0_w1_wl c2_w1_br VSUBS nfet_03v3 w=0.28u l=0.36u
Xr0c2_XR0_Q gf180mcu_3v3_12t_2r2w_bitcellr0c2/r0_mid gf180mcu_3v3_12t_2r2w_bitcellr0c2/q VSS VSUBS nfet_03v3 w=0.53u l=0.28u
Xr0c2_XR0_SEL gf180mcu_3v3_12t_2r2w_bitcellr0c2/r0_mid r0_r0_rwl c2_r0_rbl VSUBS nfet_03v3 w=0.53u l=0.28u
Xr0c2_XR1_Q gf180mcu_3v3_12t_2r2w_bitcellr0c2/r1_mid gf180mcu_3v3_12t_2r2w_bitcellr0c2/q VSS VSUBS nfet_03v3 w=0.53u l=0.28u
Xr0c2_XR1_SEL gf180mcu_3v3_12t_2r2w_bitcellr0c2/r1_mid r0_r1_rwl c2_r1_rbl VSUBS nfet_03v3 w=0.53u l=0.28u
Xr0c3_XP_Q gf180mcu_3v3_12t_2r2w_bitcellr0c3/q gf180mcu_3v3_12t_2r2w_bitcellr0c3/qb VDD gf180mcu_3v3_12t_2r2w_bitcellr0c3/NWELL pfet_03v3 w=0.28u l=0.28u
Xr0c3_XN_Q gf180mcu_3v3_12t_2r2w_bitcellr0c3/q gf180mcu_3v3_12t_2r2w_bitcellr0c3/qb VSS VSUBS nfet_03v3 w=0.45u l=0.28u
Xr0c3_XP_QB gf180mcu_3v3_12t_2r2w_bitcellr0c3/qb gf180mcu_3v3_12t_2r2w_bitcellr0c3/q VDD gf180mcu_3v3_12t_2r2w_bitcellr0c3/NWELL pfet_03v3 w=0.28u l=0.28u
Xr0c3_XN_QB gf180mcu_3v3_12t_2r2w_bitcellr0c3/qb gf180mcu_3v3_12t_2r2w_bitcellr0c3/q VSS VSUBS nfet_03v3 w=0.45u l=0.28u
Xr0c3_XW0_Q gf180mcu_3v3_12t_2r2w_bitcellr0c3/q r0_w0_wl c3_w0_bl VSUBS nfet_03v3 w=0.28u l=0.36u
Xr0c3_XW0_QB gf180mcu_3v3_12t_2r2w_bitcellr0c3/qb r0_w0_wl c3_w0_br VSUBS nfet_03v3 w=0.28u l=0.36u
Xr0c3_XW1_Q gf180mcu_3v3_12t_2r2w_bitcellr0c3/q r0_w1_wl c3_w1_bl VSUBS nfet_03v3 w=0.28u l=0.36u
Xr0c3_XW1_QB gf180mcu_3v3_12t_2r2w_bitcellr0c3/qb r0_w1_wl c3_w1_br VSUBS nfet_03v3 w=0.28u l=0.36u
Xr0c3_XR0_Q gf180mcu_3v3_12t_2r2w_bitcellr0c3/r0_mid gf180mcu_3v3_12t_2r2w_bitcellr0c3/q VSS VSUBS nfet_03v3 w=0.53u l=0.28u
Xr0c3_XR0_SEL gf180mcu_3v3_12t_2r2w_bitcellr0c3/r0_mid r0_r0_rwl c3_r0_rbl VSUBS nfet_03v3 w=0.53u l=0.28u
Xr0c3_XR1_Q gf180mcu_3v3_12t_2r2w_bitcellr0c3/r1_mid gf180mcu_3v3_12t_2r2w_bitcellr0c3/q VSS VSUBS nfet_03v3 w=0.53u l=0.28u
Xr0c3_XR1_SEL gf180mcu_3v3_12t_2r2w_bitcellr0c3/r1_mid r0_r1_rwl c3_r1_rbl VSUBS nfet_03v3 w=0.53u l=0.28u
Xr1c0_XP_Q gf180mcu_3v3_12t_2r2w_bitcellr1c0/q gf180mcu_3v3_12t_2r2w_bitcellr1c0/qb VDD gf180mcu_3v3_12t_2r2w_bitcellr1c0/NWELL pfet_03v3 w=0.28u l=0.28u
Xr1c0_XN_Q gf180mcu_3v3_12t_2r2w_bitcellr1c0/q gf180mcu_3v3_12t_2r2w_bitcellr1c0/qb VSS VSUBS nfet_03v3 w=0.45u l=0.28u
Xr1c0_XP_QB gf180mcu_3v3_12t_2r2w_bitcellr1c0/qb gf180mcu_3v3_12t_2r2w_bitcellr1c0/q VDD gf180mcu_3v3_12t_2r2w_bitcellr1c0/NWELL pfet_03v3 w=0.28u l=0.28u
Xr1c0_XN_QB gf180mcu_3v3_12t_2r2w_bitcellr1c0/qb gf180mcu_3v3_12t_2r2w_bitcellr1c0/q VSS VSUBS nfet_03v3 w=0.45u l=0.28u
Xr1c0_XW0_Q gf180mcu_3v3_12t_2r2w_bitcellr1c0/q r1_w0_wl c0_w0_bl VSUBS nfet_03v3 w=0.28u l=0.36u
Xr1c0_XW0_QB gf180mcu_3v3_12t_2r2w_bitcellr1c0/qb r1_w0_wl c0_w0_br VSUBS nfet_03v3 w=0.28u l=0.36u
Xr1c0_XW1_Q gf180mcu_3v3_12t_2r2w_bitcellr1c0/q r1_w1_wl c0_w1_bl VSUBS nfet_03v3 w=0.28u l=0.36u
Xr1c0_XW1_QB gf180mcu_3v3_12t_2r2w_bitcellr1c0/qb r1_w1_wl c0_w1_br VSUBS nfet_03v3 w=0.28u l=0.36u
Xr1c0_XR0_Q gf180mcu_3v3_12t_2r2w_bitcellr1c0/r0_mid gf180mcu_3v3_12t_2r2w_bitcellr1c0/q VSS VSUBS nfet_03v3 w=0.53u l=0.28u
Xr1c0_XR0_SEL gf180mcu_3v3_12t_2r2w_bitcellr1c0/r0_mid r1_r0_rwl c0_r0_rbl VSUBS nfet_03v3 w=0.53u l=0.28u
Xr1c0_XR1_Q gf180mcu_3v3_12t_2r2w_bitcellr1c0/r1_mid gf180mcu_3v3_12t_2r2w_bitcellr1c0/q VSS VSUBS nfet_03v3 w=0.53u l=0.28u
Xr1c0_XR1_SEL gf180mcu_3v3_12t_2r2w_bitcellr1c0/r1_mid r1_r1_rwl c0_r1_rbl VSUBS nfet_03v3 w=0.53u l=0.28u
Xr1c1_XP_Q gf180mcu_3v3_12t_2r2w_bitcellr1c1/q gf180mcu_3v3_12t_2r2w_bitcellr1c1/qb VDD gf180mcu_3v3_12t_2r2w_bitcellr1c1/NWELL pfet_03v3 w=0.28u l=0.28u
Xr1c1_XN_Q gf180mcu_3v3_12t_2r2w_bitcellr1c1/q gf180mcu_3v3_12t_2r2w_bitcellr1c1/qb VSS VSUBS nfet_03v3 w=0.45u l=0.28u
Xr1c1_XP_QB gf180mcu_3v3_12t_2r2w_bitcellr1c1/qb gf180mcu_3v3_12t_2r2w_bitcellr1c1/q VDD gf180mcu_3v3_12t_2r2w_bitcellr1c1/NWELL pfet_03v3 w=0.28u l=0.28u
Xr1c1_XN_QB gf180mcu_3v3_12t_2r2w_bitcellr1c1/qb gf180mcu_3v3_12t_2r2w_bitcellr1c1/q VSS VSUBS nfet_03v3 w=0.45u l=0.28u
Xr1c1_XW0_Q gf180mcu_3v3_12t_2r2w_bitcellr1c1/q r1_w0_wl c1_w0_bl VSUBS nfet_03v3 w=0.28u l=0.36u
Xr1c1_XW0_QB gf180mcu_3v3_12t_2r2w_bitcellr1c1/qb r1_w0_wl c1_w0_br VSUBS nfet_03v3 w=0.28u l=0.36u
Xr1c1_XW1_Q gf180mcu_3v3_12t_2r2w_bitcellr1c1/q r1_w1_wl c1_w1_bl VSUBS nfet_03v3 w=0.28u l=0.36u
Xr1c1_XW1_QB gf180mcu_3v3_12t_2r2w_bitcellr1c1/qb r1_w1_wl c1_w1_br VSUBS nfet_03v3 w=0.28u l=0.36u
Xr1c1_XR0_Q gf180mcu_3v3_12t_2r2w_bitcellr1c1/r0_mid gf180mcu_3v3_12t_2r2w_bitcellr1c1/q VSS VSUBS nfet_03v3 w=0.53u l=0.28u
Xr1c1_XR0_SEL gf180mcu_3v3_12t_2r2w_bitcellr1c1/r0_mid r1_r0_rwl c1_r0_rbl VSUBS nfet_03v3 w=0.53u l=0.28u
Xr1c1_XR1_Q gf180mcu_3v3_12t_2r2w_bitcellr1c1/r1_mid gf180mcu_3v3_12t_2r2w_bitcellr1c1/q VSS VSUBS nfet_03v3 w=0.53u l=0.28u
Xr1c1_XR1_SEL gf180mcu_3v3_12t_2r2w_bitcellr1c1/r1_mid r1_r1_rwl c1_r1_rbl VSUBS nfet_03v3 w=0.53u l=0.28u
Xr1c2_XP_Q gf180mcu_3v3_12t_2r2w_bitcellr1c2/q gf180mcu_3v3_12t_2r2w_bitcellr1c2/qb VDD gf180mcu_3v3_12t_2r2w_bitcellr1c2/NWELL pfet_03v3 w=0.28u l=0.28u
Xr1c2_XN_Q gf180mcu_3v3_12t_2r2w_bitcellr1c2/q gf180mcu_3v3_12t_2r2w_bitcellr1c2/qb VSS VSUBS nfet_03v3 w=0.45u l=0.28u
Xr1c2_XP_QB gf180mcu_3v3_12t_2r2w_bitcellr1c2/qb gf180mcu_3v3_12t_2r2w_bitcellr1c2/q VDD gf180mcu_3v3_12t_2r2w_bitcellr1c2/NWELL pfet_03v3 w=0.28u l=0.28u
Xr1c2_XN_QB gf180mcu_3v3_12t_2r2w_bitcellr1c2/qb gf180mcu_3v3_12t_2r2w_bitcellr1c2/q VSS VSUBS nfet_03v3 w=0.45u l=0.28u
Xr1c2_XW0_Q gf180mcu_3v3_12t_2r2w_bitcellr1c2/q r1_w0_wl c2_w0_bl VSUBS nfet_03v3 w=0.28u l=0.36u
Xr1c2_XW0_QB gf180mcu_3v3_12t_2r2w_bitcellr1c2/qb r1_w0_wl c2_w0_br VSUBS nfet_03v3 w=0.28u l=0.36u
Xr1c2_XW1_Q gf180mcu_3v3_12t_2r2w_bitcellr1c2/q r1_w1_wl c2_w1_bl VSUBS nfet_03v3 w=0.28u l=0.36u
Xr1c2_XW1_QB gf180mcu_3v3_12t_2r2w_bitcellr1c2/qb r1_w1_wl c2_w1_br VSUBS nfet_03v3 w=0.28u l=0.36u
Xr1c2_XR0_Q gf180mcu_3v3_12t_2r2w_bitcellr1c2/r0_mid gf180mcu_3v3_12t_2r2w_bitcellr1c2/q VSS VSUBS nfet_03v3 w=0.53u l=0.28u
Xr1c2_XR0_SEL gf180mcu_3v3_12t_2r2w_bitcellr1c2/r0_mid r1_r0_rwl c2_r0_rbl VSUBS nfet_03v3 w=0.53u l=0.28u
Xr1c2_XR1_Q gf180mcu_3v3_12t_2r2w_bitcellr1c2/r1_mid gf180mcu_3v3_12t_2r2w_bitcellr1c2/q VSS VSUBS nfet_03v3 w=0.53u l=0.28u
Xr1c2_XR1_SEL gf180mcu_3v3_12t_2r2w_bitcellr1c2/r1_mid r1_r1_rwl c2_r1_rbl VSUBS nfet_03v3 w=0.53u l=0.28u
Xr1c3_XP_Q gf180mcu_3v3_12t_2r2w_bitcellr1c3/q gf180mcu_3v3_12t_2r2w_bitcellr1c3/qb VDD gf180mcu_3v3_12t_2r2w_bitcellr1c3/NWELL pfet_03v3 w=0.28u l=0.28u
Xr1c3_XN_Q gf180mcu_3v3_12t_2r2w_bitcellr1c3/q gf180mcu_3v3_12t_2r2w_bitcellr1c3/qb VSS VSUBS nfet_03v3 w=0.45u l=0.28u
Xr1c3_XP_QB gf180mcu_3v3_12t_2r2w_bitcellr1c3/qb gf180mcu_3v3_12t_2r2w_bitcellr1c3/q VDD gf180mcu_3v3_12t_2r2w_bitcellr1c3/NWELL pfet_03v3 w=0.28u l=0.28u
Xr1c3_XN_QB gf180mcu_3v3_12t_2r2w_bitcellr1c3/qb gf180mcu_3v3_12t_2r2w_bitcellr1c3/q VSS VSUBS nfet_03v3 w=0.45u l=0.28u
Xr1c3_XW0_Q gf180mcu_3v3_12t_2r2w_bitcellr1c3/q r1_w0_wl c3_w0_bl VSUBS nfet_03v3 w=0.28u l=0.36u
Xr1c3_XW0_QB gf180mcu_3v3_12t_2r2w_bitcellr1c3/qb r1_w0_wl c3_w0_br VSUBS nfet_03v3 w=0.28u l=0.36u
Xr1c3_XW1_Q gf180mcu_3v3_12t_2r2w_bitcellr1c3/q r1_w1_wl c3_w1_bl VSUBS nfet_03v3 w=0.28u l=0.36u
Xr1c3_XW1_QB gf180mcu_3v3_12t_2r2w_bitcellr1c3/qb r1_w1_wl c3_w1_br VSUBS nfet_03v3 w=0.28u l=0.36u
Xr1c3_XR0_Q gf180mcu_3v3_12t_2r2w_bitcellr1c3/r0_mid gf180mcu_3v3_12t_2r2w_bitcellr1c3/q VSS VSUBS nfet_03v3 w=0.53u l=0.28u
Xr1c3_XR0_SEL gf180mcu_3v3_12t_2r2w_bitcellr1c3/r0_mid r1_r0_rwl c3_r0_rbl VSUBS nfet_03v3 w=0.53u l=0.28u
Xr1c3_XR1_Q gf180mcu_3v3_12t_2r2w_bitcellr1c3/r1_mid gf180mcu_3v3_12t_2r2w_bitcellr1c3/q VSS VSUBS nfet_03v3 w=0.53u l=0.28u
Xr1c3_XR1_SEL gf180mcu_3v3_12t_2r2w_bitcellr1c3/r1_mid r1_r1_rwl c3_r1_rbl VSUBS nfet_03v3 w=0.53u l=0.28u
Xr2c0_XP_Q gf180mcu_3v3_12t_2r2w_bitcellr2c0/q gf180mcu_3v3_12t_2r2w_bitcellr2c0/qb VDD gf180mcu_3v3_12t_2r2w_bitcellr2c0/NWELL pfet_03v3 w=0.28u l=0.28u
Xr2c0_XN_Q gf180mcu_3v3_12t_2r2w_bitcellr2c0/q gf180mcu_3v3_12t_2r2w_bitcellr2c0/qb VSS VSUBS nfet_03v3 w=0.45u l=0.28u
Xr2c0_XP_QB gf180mcu_3v3_12t_2r2w_bitcellr2c0/qb gf180mcu_3v3_12t_2r2w_bitcellr2c0/q VDD gf180mcu_3v3_12t_2r2w_bitcellr2c0/NWELL pfet_03v3 w=0.28u l=0.28u
Xr2c0_XN_QB gf180mcu_3v3_12t_2r2w_bitcellr2c0/qb gf180mcu_3v3_12t_2r2w_bitcellr2c0/q VSS VSUBS nfet_03v3 w=0.45u l=0.28u
Xr2c0_XW0_Q gf180mcu_3v3_12t_2r2w_bitcellr2c0/q r2_w0_wl c0_w0_bl VSUBS nfet_03v3 w=0.28u l=0.36u
Xr2c0_XW0_QB gf180mcu_3v3_12t_2r2w_bitcellr2c0/qb r2_w0_wl c0_w0_br VSUBS nfet_03v3 w=0.28u l=0.36u
Xr2c0_XW1_Q gf180mcu_3v3_12t_2r2w_bitcellr2c0/q r2_w1_wl c0_w1_bl VSUBS nfet_03v3 w=0.28u l=0.36u
Xr2c0_XW1_QB gf180mcu_3v3_12t_2r2w_bitcellr2c0/qb r2_w1_wl c0_w1_br VSUBS nfet_03v3 w=0.28u l=0.36u
Xr2c0_XR0_Q gf180mcu_3v3_12t_2r2w_bitcellr2c0/r0_mid gf180mcu_3v3_12t_2r2w_bitcellr2c0/q VSS VSUBS nfet_03v3 w=0.53u l=0.28u
Xr2c0_XR0_SEL gf180mcu_3v3_12t_2r2w_bitcellr2c0/r0_mid r2_r0_rwl c0_r0_rbl VSUBS nfet_03v3 w=0.53u l=0.28u
Xr2c0_XR1_Q gf180mcu_3v3_12t_2r2w_bitcellr2c0/r1_mid gf180mcu_3v3_12t_2r2w_bitcellr2c0/q VSS VSUBS nfet_03v3 w=0.53u l=0.28u
Xr2c0_XR1_SEL gf180mcu_3v3_12t_2r2w_bitcellr2c0/r1_mid r2_r1_rwl c0_r1_rbl VSUBS nfet_03v3 w=0.53u l=0.28u
Xr2c1_XP_Q gf180mcu_3v3_12t_2r2w_bitcellr2c1/q gf180mcu_3v3_12t_2r2w_bitcellr2c1/qb VDD gf180mcu_3v3_12t_2r2w_bitcellr2c1/NWELL pfet_03v3 w=0.28u l=0.28u
Xr2c1_XN_Q gf180mcu_3v3_12t_2r2w_bitcellr2c1/q gf180mcu_3v3_12t_2r2w_bitcellr2c1/qb VSS VSUBS nfet_03v3 w=0.45u l=0.28u
Xr2c1_XP_QB gf180mcu_3v3_12t_2r2w_bitcellr2c1/qb gf180mcu_3v3_12t_2r2w_bitcellr2c1/q VDD gf180mcu_3v3_12t_2r2w_bitcellr2c1/NWELL pfet_03v3 w=0.28u l=0.28u
Xr2c1_XN_QB gf180mcu_3v3_12t_2r2w_bitcellr2c1/qb gf180mcu_3v3_12t_2r2w_bitcellr2c1/q VSS VSUBS nfet_03v3 w=0.45u l=0.28u
Xr2c1_XW0_Q gf180mcu_3v3_12t_2r2w_bitcellr2c1/q r2_w0_wl c1_w0_bl VSUBS nfet_03v3 w=0.28u l=0.36u
Xr2c1_XW0_QB gf180mcu_3v3_12t_2r2w_bitcellr2c1/qb r2_w0_wl c1_w0_br VSUBS nfet_03v3 w=0.28u l=0.36u
Xr2c1_XW1_Q gf180mcu_3v3_12t_2r2w_bitcellr2c1/q r2_w1_wl c1_w1_bl VSUBS nfet_03v3 w=0.28u l=0.36u
Xr2c1_XW1_QB gf180mcu_3v3_12t_2r2w_bitcellr2c1/qb r2_w1_wl c1_w1_br VSUBS nfet_03v3 w=0.28u l=0.36u
Xr2c1_XR0_Q gf180mcu_3v3_12t_2r2w_bitcellr2c1/r0_mid gf180mcu_3v3_12t_2r2w_bitcellr2c1/q VSS VSUBS nfet_03v3 w=0.53u l=0.28u
Xr2c1_XR0_SEL gf180mcu_3v3_12t_2r2w_bitcellr2c1/r0_mid r2_r0_rwl c1_r0_rbl VSUBS nfet_03v3 w=0.53u l=0.28u
Xr2c1_XR1_Q gf180mcu_3v3_12t_2r2w_bitcellr2c1/r1_mid gf180mcu_3v3_12t_2r2w_bitcellr2c1/q VSS VSUBS nfet_03v3 w=0.53u l=0.28u
Xr2c1_XR1_SEL gf180mcu_3v3_12t_2r2w_bitcellr2c1/r1_mid r2_r1_rwl c1_r1_rbl VSUBS nfet_03v3 w=0.53u l=0.28u
Xr2c2_XP_Q gf180mcu_3v3_12t_2r2w_bitcellr2c2/q gf180mcu_3v3_12t_2r2w_bitcellr2c2/qb VDD gf180mcu_3v3_12t_2r2w_bitcellr2c2/NWELL pfet_03v3 w=0.28u l=0.28u
Xr2c2_XN_Q gf180mcu_3v3_12t_2r2w_bitcellr2c2/q gf180mcu_3v3_12t_2r2w_bitcellr2c2/qb VSS VSUBS nfet_03v3 w=0.45u l=0.28u
Xr2c2_XP_QB gf180mcu_3v3_12t_2r2w_bitcellr2c2/qb gf180mcu_3v3_12t_2r2w_bitcellr2c2/q VDD gf180mcu_3v3_12t_2r2w_bitcellr2c2/NWELL pfet_03v3 w=0.28u l=0.28u
Xr2c2_XN_QB gf180mcu_3v3_12t_2r2w_bitcellr2c2/qb gf180mcu_3v3_12t_2r2w_bitcellr2c2/q VSS VSUBS nfet_03v3 w=0.45u l=0.28u
Xr2c2_XW0_Q gf180mcu_3v3_12t_2r2w_bitcellr2c2/q r2_w0_wl c2_w0_bl VSUBS nfet_03v3 w=0.28u l=0.36u
Xr2c2_XW0_QB gf180mcu_3v3_12t_2r2w_bitcellr2c2/qb r2_w0_wl c2_w0_br VSUBS nfet_03v3 w=0.28u l=0.36u
Xr2c2_XW1_Q gf180mcu_3v3_12t_2r2w_bitcellr2c2/q r2_w1_wl c2_w1_bl VSUBS nfet_03v3 w=0.28u l=0.36u
Xr2c2_XW1_QB gf180mcu_3v3_12t_2r2w_bitcellr2c2/qb r2_w1_wl c2_w1_br VSUBS nfet_03v3 w=0.28u l=0.36u
Xr2c2_XR0_Q gf180mcu_3v3_12t_2r2w_bitcellr2c2/r0_mid gf180mcu_3v3_12t_2r2w_bitcellr2c2/q VSS VSUBS nfet_03v3 w=0.53u l=0.28u
Xr2c2_XR0_SEL gf180mcu_3v3_12t_2r2w_bitcellr2c2/r0_mid r2_r0_rwl c2_r0_rbl VSUBS nfet_03v3 w=0.53u l=0.28u
Xr2c2_XR1_Q gf180mcu_3v3_12t_2r2w_bitcellr2c2/r1_mid gf180mcu_3v3_12t_2r2w_bitcellr2c2/q VSS VSUBS nfet_03v3 w=0.53u l=0.28u
Xr2c2_XR1_SEL gf180mcu_3v3_12t_2r2w_bitcellr2c2/r1_mid r2_r1_rwl c2_r1_rbl VSUBS nfet_03v3 w=0.53u l=0.28u
Xr2c3_XP_Q gf180mcu_3v3_12t_2r2w_bitcellr2c3/q gf180mcu_3v3_12t_2r2w_bitcellr2c3/qb VDD gf180mcu_3v3_12t_2r2w_bitcellr2c3/NWELL pfet_03v3 w=0.28u l=0.28u
Xr2c3_XN_Q gf180mcu_3v3_12t_2r2w_bitcellr2c3/q gf180mcu_3v3_12t_2r2w_bitcellr2c3/qb VSS VSUBS nfet_03v3 w=0.45u l=0.28u
Xr2c3_XP_QB gf180mcu_3v3_12t_2r2w_bitcellr2c3/qb gf180mcu_3v3_12t_2r2w_bitcellr2c3/q VDD gf180mcu_3v3_12t_2r2w_bitcellr2c3/NWELL pfet_03v3 w=0.28u l=0.28u
Xr2c3_XN_QB gf180mcu_3v3_12t_2r2w_bitcellr2c3/qb gf180mcu_3v3_12t_2r2w_bitcellr2c3/q VSS VSUBS nfet_03v3 w=0.45u l=0.28u
Xr2c3_XW0_Q gf180mcu_3v3_12t_2r2w_bitcellr2c3/q r2_w0_wl c3_w0_bl VSUBS nfet_03v3 w=0.28u l=0.36u
Xr2c3_XW0_QB gf180mcu_3v3_12t_2r2w_bitcellr2c3/qb r2_w0_wl c3_w0_br VSUBS nfet_03v3 w=0.28u l=0.36u
Xr2c3_XW1_Q gf180mcu_3v3_12t_2r2w_bitcellr2c3/q r2_w1_wl c3_w1_bl VSUBS nfet_03v3 w=0.28u l=0.36u
Xr2c3_XW1_QB gf180mcu_3v3_12t_2r2w_bitcellr2c3/qb r2_w1_wl c3_w1_br VSUBS nfet_03v3 w=0.28u l=0.36u
Xr2c3_XR0_Q gf180mcu_3v3_12t_2r2w_bitcellr2c3/r0_mid gf180mcu_3v3_12t_2r2w_bitcellr2c3/q VSS VSUBS nfet_03v3 w=0.53u l=0.28u
Xr2c3_XR0_SEL gf180mcu_3v3_12t_2r2w_bitcellr2c3/r0_mid r2_r0_rwl c3_r0_rbl VSUBS nfet_03v3 w=0.53u l=0.28u
Xr2c3_XR1_Q gf180mcu_3v3_12t_2r2w_bitcellr2c3/r1_mid gf180mcu_3v3_12t_2r2w_bitcellr2c3/q VSS VSUBS nfet_03v3 w=0.53u l=0.28u
Xr2c3_XR1_SEL gf180mcu_3v3_12t_2r2w_bitcellr2c3/r1_mid r2_r1_rwl c3_r1_rbl VSUBS nfet_03v3 w=0.53u l=0.28u
Xr3c0_XP_Q gf180mcu_3v3_12t_2r2w_bitcellr3c0/q gf180mcu_3v3_12t_2r2w_bitcellr3c0/qb VDD gf180mcu_3v3_12t_2r2w_bitcellr3c0/NWELL pfet_03v3 w=0.28u l=0.28u
Xr3c0_XN_Q gf180mcu_3v3_12t_2r2w_bitcellr3c0/q gf180mcu_3v3_12t_2r2w_bitcellr3c0/qb VSS VSUBS nfet_03v3 w=0.45u l=0.28u
Xr3c0_XP_QB gf180mcu_3v3_12t_2r2w_bitcellr3c0/qb gf180mcu_3v3_12t_2r2w_bitcellr3c0/q VDD gf180mcu_3v3_12t_2r2w_bitcellr3c0/NWELL pfet_03v3 w=0.28u l=0.28u
Xr3c0_XN_QB gf180mcu_3v3_12t_2r2w_bitcellr3c0/qb gf180mcu_3v3_12t_2r2w_bitcellr3c0/q VSS VSUBS nfet_03v3 w=0.45u l=0.28u
Xr3c0_XW0_Q gf180mcu_3v3_12t_2r2w_bitcellr3c0/q r3_w0_wl c0_w0_bl VSUBS nfet_03v3 w=0.28u l=0.36u
Xr3c0_XW0_QB gf180mcu_3v3_12t_2r2w_bitcellr3c0/qb r3_w0_wl c0_w0_br VSUBS nfet_03v3 w=0.28u l=0.36u
Xr3c0_XW1_Q gf180mcu_3v3_12t_2r2w_bitcellr3c0/q r3_w1_wl c0_w1_bl VSUBS nfet_03v3 w=0.28u l=0.36u
Xr3c0_XW1_QB gf180mcu_3v3_12t_2r2w_bitcellr3c0/qb r3_w1_wl c0_w1_br VSUBS nfet_03v3 w=0.28u l=0.36u
Xr3c0_XR0_Q gf180mcu_3v3_12t_2r2w_bitcellr3c0/r0_mid gf180mcu_3v3_12t_2r2w_bitcellr3c0/q VSS VSUBS nfet_03v3 w=0.53u l=0.28u
Xr3c0_XR0_SEL gf180mcu_3v3_12t_2r2w_bitcellr3c0/r0_mid r3_r0_rwl c0_r0_rbl VSUBS nfet_03v3 w=0.53u l=0.28u
Xr3c0_XR1_Q gf180mcu_3v3_12t_2r2w_bitcellr3c0/r1_mid gf180mcu_3v3_12t_2r2w_bitcellr3c0/q VSS VSUBS nfet_03v3 w=0.53u l=0.28u
Xr3c0_XR1_SEL gf180mcu_3v3_12t_2r2w_bitcellr3c0/r1_mid r3_r1_rwl c0_r1_rbl VSUBS nfet_03v3 w=0.53u l=0.28u
Xr3c1_XP_Q gf180mcu_3v3_12t_2r2w_bitcellr3c1/q gf180mcu_3v3_12t_2r2w_bitcellr3c1/qb VDD gf180mcu_3v3_12t_2r2w_bitcellr3c1/NWELL pfet_03v3 w=0.28u l=0.28u
Xr3c1_XN_Q gf180mcu_3v3_12t_2r2w_bitcellr3c1/q gf180mcu_3v3_12t_2r2w_bitcellr3c1/qb VSS VSUBS nfet_03v3 w=0.45u l=0.28u
Xr3c1_XP_QB gf180mcu_3v3_12t_2r2w_bitcellr3c1/qb gf180mcu_3v3_12t_2r2w_bitcellr3c1/q VDD gf180mcu_3v3_12t_2r2w_bitcellr3c1/NWELL pfet_03v3 w=0.28u l=0.28u
Xr3c1_XN_QB gf180mcu_3v3_12t_2r2w_bitcellr3c1/qb gf180mcu_3v3_12t_2r2w_bitcellr3c1/q VSS VSUBS nfet_03v3 w=0.45u l=0.28u
Xr3c1_XW0_Q gf180mcu_3v3_12t_2r2w_bitcellr3c1/q r3_w0_wl c1_w0_bl VSUBS nfet_03v3 w=0.28u l=0.36u
Xr3c1_XW0_QB gf180mcu_3v3_12t_2r2w_bitcellr3c1/qb r3_w0_wl c1_w0_br VSUBS nfet_03v3 w=0.28u l=0.36u
Xr3c1_XW1_Q gf180mcu_3v3_12t_2r2w_bitcellr3c1/q r3_w1_wl c1_w1_bl VSUBS nfet_03v3 w=0.28u l=0.36u
Xr3c1_XW1_QB gf180mcu_3v3_12t_2r2w_bitcellr3c1/qb r3_w1_wl c1_w1_br VSUBS nfet_03v3 w=0.28u l=0.36u
Xr3c1_XR0_Q gf180mcu_3v3_12t_2r2w_bitcellr3c1/r0_mid gf180mcu_3v3_12t_2r2w_bitcellr3c1/q VSS VSUBS nfet_03v3 w=0.53u l=0.28u
Xr3c1_XR0_SEL gf180mcu_3v3_12t_2r2w_bitcellr3c1/r0_mid r3_r0_rwl c1_r0_rbl VSUBS nfet_03v3 w=0.53u l=0.28u
Xr3c1_XR1_Q gf180mcu_3v3_12t_2r2w_bitcellr3c1/r1_mid gf180mcu_3v3_12t_2r2w_bitcellr3c1/q VSS VSUBS nfet_03v3 w=0.53u l=0.28u
Xr3c1_XR1_SEL gf180mcu_3v3_12t_2r2w_bitcellr3c1/r1_mid r3_r1_rwl c1_r1_rbl VSUBS nfet_03v3 w=0.53u l=0.28u
Xr3c2_XP_Q gf180mcu_3v3_12t_2r2w_bitcellr3c2/q gf180mcu_3v3_12t_2r2w_bitcellr3c2/qb VDD gf180mcu_3v3_12t_2r2w_bitcellr3c2/NWELL pfet_03v3 w=0.28u l=0.28u
Xr3c2_XN_Q gf180mcu_3v3_12t_2r2w_bitcellr3c2/q gf180mcu_3v3_12t_2r2w_bitcellr3c2/qb VSS VSUBS nfet_03v3 w=0.45u l=0.28u
Xr3c2_XP_QB gf180mcu_3v3_12t_2r2w_bitcellr3c2/qb gf180mcu_3v3_12t_2r2w_bitcellr3c2/q VDD gf180mcu_3v3_12t_2r2w_bitcellr3c2/NWELL pfet_03v3 w=0.28u l=0.28u
Xr3c2_XN_QB gf180mcu_3v3_12t_2r2w_bitcellr3c2/qb gf180mcu_3v3_12t_2r2w_bitcellr3c2/q VSS VSUBS nfet_03v3 w=0.45u l=0.28u
Xr3c2_XW0_Q gf180mcu_3v3_12t_2r2w_bitcellr3c2/q r3_w0_wl c2_w0_bl VSUBS nfet_03v3 w=0.28u l=0.36u
Xr3c2_XW0_QB gf180mcu_3v3_12t_2r2w_bitcellr3c2/qb r3_w0_wl c2_w0_br VSUBS nfet_03v3 w=0.28u l=0.36u
Xr3c2_XW1_Q gf180mcu_3v3_12t_2r2w_bitcellr3c2/q r3_w1_wl c2_w1_bl VSUBS nfet_03v3 w=0.28u l=0.36u
Xr3c2_XW1_QB gf180mcu_3v3_12t_2r2w_bitcellr3c2/qb r3_w1_wl c2_w1_br VSUBS nfet_03v3 w=0.28u l=0.36u
Xr3c2_XR0_Q gf180mcu_3v3_12t_2r2w_bitcellr3c2/r0_mid gf180mcu_3v3_12t_2r2w_bitcellr3c2/q VSS VSUBS nfet_03v3 w=0.53u l=0.28u
Xr3c2_XR0_SEL gf180mcu_3v3_12t_2r2w_bitcellr3c2/r0_mid r3_r0_rwl c2_r0_rbl VSUBS nfet_03v3 w=0.53u l=0.28u
Xr3c2_XR1_Q gf180mcu_3v3_12t_2r2w_bitcellr3c2/r1_mid gf180mcu_3v3_12t_2r2w_bitcellr3c2/q VSS VSUBS nfet_03v3 w=0.53u l=0.28u
Xr3c2_XR1_SEL gf180mcu_3v3_12t_2r2w_bitcellr3c2/r1_mid r3_r1_rwl c2_r1_rbl VSUBS nfet_03v3 w=0.53u l=0.28u
Xr3c3_XP_Q gf180mcu_3v3_12t_2r2w_bitcellr3c3/q gf180mcu_3v3_12t_2r2w_bitcellr3c3/qb VDD gf180mcu_3v3_12t_2r2w_bitcellr3c3/NWELL pfet_03v3 w=0.28u l=0.28u
Xr3c3_XN_Q gf180mcu_3v3_12t_2r2w_bitcellr3c3/q gf180mcu_3v3_12t_2r2w_bitcellr3c3/qb VSS VSUBS nfet_03v3 w=0.45u l=0.28u
Xr3c3_XP_QB gf180mcu_3v3_12t_2r2w_bitcellr3c3/qb gf180mcu_3v3_12t_2r2w_bitcellr3c3/q VDD gf180mcu_3v3_12t_2r2w_bitcellr3c3/NWELL pfet_03v3 w=0.28u l=0.28u
Xr3c3_XN_QB gf180mcu_3v3_12t_2r2w_bitcellr3c3/qb gf180mcu_3v3_12t_2r2w_bitcellr3c3/q VSS VSUBS nfet_03v3 w=0.45u l=0.28u
Xr3c3_XW0_Q gf180mcu_3v3_12t_2r2w_bitcellr3c3/q r3_w0_wl c3_w0_bl VSUBS nfet_03v3 w=0.28u l=0.36u
Xr3c3_XW0_QB gf180mcu_3v3_12t_2r2w_bitcellr3c3/qb r3_w0_wl c3_w0_br VSUBS nfet_03v3 w=0.28u l=0.36u
Xr3c3_XW1_Q gf180mcu_3v3_12t_2r2w_bitcellr3c3/q r3_w1_wl c3_w1_bl VSUBS nfet_03v3 w=0.28u l=0.36u
Xr3c3_XW1_QB gf180mcu_3v3_12t_2r2w_bitcellr3c3/qb r3_w1_wl c3_w1_br VSUBS nfet_03v3 w=0.28u l=0.36u
Xr3c3_XR0_Q gf180mcu_3v3_12t_2r2w_bitcellr3c3/r0_mid gf180mcu_3v3_12t_2r2w_bitcellr3c3/q VSS VSUBS nfet_03v3 w=0.53u l=0.28u
Xr3c3_XR0_SEL gf180mcu_3v3_12t_2r2w_bitcellr3c3/r0_mid r3_r0_rwl c3_r0_rbl VSUBS nfet_03v3 w=0.53u l=0.28u
Xr3c3_XR1_Q gf180mcu_3v3_12t_2r2w_bitcellr3c3/r1_mid gf180mcu_3v3_12t_2r2w_bitcellr3c3/q VSS VSUBS nfet_03v3 w=0.53u l=0.28u
Xr3c3_XR1_SEL gf180mcu_3v3_12t_2r2w_bitcellr3c3/r1_mid r3_r1_rwl c3_r1_rbl VSUBS nfet_03v3 w=0.53u l=0.28u
.ends detronyx_12t_2w2r_rc4_4x4_routed_5layer_direct
