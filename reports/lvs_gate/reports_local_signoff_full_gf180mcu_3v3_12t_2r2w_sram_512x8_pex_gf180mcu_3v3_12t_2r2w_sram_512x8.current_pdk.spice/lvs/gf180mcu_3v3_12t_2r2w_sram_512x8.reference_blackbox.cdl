* Independent macro-top blackbox reference for reports/local_signoff_full/gf180mcu_3v3_12t_2r2w_sram_512x8/pex/gf180mcu_3v3_12t_2r2w_sram_512x8.current_pdk.spice

.subckt detronyx_12t_2w2r_rc4_4x4_routed_5layer_direct c0_w0_bl c0_w0_br c0_w1_bl c0_w1_br c0_r0_rbl c0_r1_rbl
+ c1_w0_bl c1_w0_br c1_w1_bl c1_w1_br c1_r0_rbl c1_r1_rbl c2_w0_bl c2_w0_br c2_w1_bl c2_w1_br c2_r0_rbl c2_r1_rbl
+ c3_w0_bl c3_w0_br c3_w1_bl c3_w1_br c3_r0_rbl c3_r1_rbl r0_w0_wl r0_w1_wl r0_r0_rwl r0_r1_rwl r1_w0_wl r1_w1_wl
+ r1_r0_rwl r1_r1_rwl r2_w0_wl r2_w1_wl r2_r0_rwl r2_r1_rwl r3_w0_wl r3_w1_wl r3_r0_rwl r3_r1_rwl VDD VSS VSUBS
.ends detronyx_12t_2w2r_rc4_4x4_routed_5layer_direct

.subckt gf180mcu_3v3_12t_2r2w_sram_512x8 clk w0_en w1_en r0_en r1_en w0_addr[0] w0_addr[1] w0_addr[2] w0_addr[3]
+ w0_addr[4] w0_addr[5] w0_addr[6] w0_addr[7] w0_addr[8] w1_addr[0] w1_addr[1] w1_addr[2] w1_addr[3] w1_addr[4]
+ w1_addr[5] w1_addr[6] w1_addr[7] w1_addr[8] r0_addr[0] r0_addr[1] r0_addr[2] r0_addr[3] r0_addr[4] r0_addr[5]
+ r0_addr[6] r0_addr[7] r0_addr[8] r1_addr[0] r1_addr[1] r1_addr[2] r1_addr[3] r1_addr[4] r1_addr[5] r1_addr[6]
+ r1_addr[7] r1_addr[8] w0_data[0] w0_data[1] w0_data[2] w0_data[3] w0_data[4] w0_data[5] w0_data[6] w0_data[7]
+ w1_data[0] w1_data[1] w1_data[2] w1_data[3] w1_data[4] w1_data[5] w1_data[6] w1_data[7] r0_data[0] r0_data[1]
+ r0_data[2] r0_data[3] r0_data[4] r0_data[5] r0_data[6] r0_data[7] r1_data[0] r1_data[1] r1_data[2] r1_data[3]
+ r1_data[4] r1_data[5] r1_data[6] r1_data[7] VDD VSS
Xu_t013_010 u_t013_010/c0_w0_bl u_t013_010/c0_w0_br u_t013_010/c0_w1_bl u_t013_010/c0_w1_br u_t013_010/c0_r0_rbl
+ u_t013_010/c0_r1_rbl u_t013_010/c1_w0_bl u_t013_010/c1_w0_br u_t013_010/c1_w1_bl u_t013_010/c1_w1_br
+ u_t013_010/c1_r0_rbl u_t013_010/c1_r1_rbl u_t013_010/c2_w0_bl u_t013_010/c2_w0_br u_t013_010/c2_w1_bl
+ u_t013_010/c2_w1_br u_t013_010/c2_r0_rbl u_t013_010/c2_r1_rbl u_t013_010/c3_w0_bl u_t013_010/c3_w0_br
+ u_t013_010/c3_w1_bl u_t013_010/c3_w1_br u_t013_010/c3_r0_rbl u_t013_010/c3_r1_rbl u_t013_010/r0_w0_wl
+ u_t013_010/r0_w1_wl u_t013_010/r0_r0_rwl u_t013_010/r0_r1_rwl u_t013_010/r1_w0_wl u_t013_010/r1_w1_wl
+ u_t013_010/r1_r0_rwl u_t013_010/r1_r1_rwl u_t013_010/r2_w0_wl u_t013_010/r2_w1_wl u_t013_010/r2_r0_rwl
+ u_t013_010/r2_r1_rwl u_t013_010/r3_w0_wl u_t013_010/r3_w1_wl u_t013_010/r3_r0_rwl u_t013_010/r3_r1_rwl VDD VSS VSUBS
+ detronyx_12t_2w2r_rc4_4x4_routed_5layer_direct
Xu_t008_007 u_t008_007/c0_w0_bl u_t008_007/c0_w0_br u_t008_007/c0_w1_bl u_t008_007/c0_w1_br u_t008_007/c0_r0_rbl
+ u_t008_007/c0_r1_rbl u_t008_007/c1_w0_bl u_t008_007/c1_w0_br u_t008_007/c1_w1_bl u_t008_007/c1_w1_br
+ u_t008_007/c1_r0_rbl u_t008_007/c1_r1_rbl u_t008_007/c2_w0_bl u_t008_007/c2_w0_br u_t008_007/c2_w1_bl
+ u_t008_007/c2_w1_br u_t008_007/c2_r0_rbl u_t008_007/c2_r1_rbl u_t008_007/c3_w0_bl u_t008_007/c3_w0_br
+ u_t008_007/c3_w1_bl u_t008_007/c3_w1_br u_t008_007/c3_r0_rbl u_t008_007/c3_r1_rbl u_t008_007/r0_w0_wl
+ u_t008_007/r0_w1_wl u_t008_007/r0_r0_rwl u_t008_007/r0_r1_rwl u_t008_007/r1_w0_wl u_t008_007/r1_w1_wl
+ u_t008_007/r1_r0_rwl u_t008_007/r1_r1_rwl u_t008_007/r2_w0_wl u_t008_007/r2_w1_wl u_t008_007/r2_r0_rwl
+ u_t008_007/r2_r1_rwl u_t008_007/r3_w0_wl u_t008_007/r3_w1_wl u_t008_007/r3_r0_rwl u_t008_007/r3_r1_rwl VDD VSS VSUBS
+ detronyx_12t_2w2r_rc4_4x4_routed_5layer_direct
Xu_t010_013 u_t010_013/c0_w0_bl u_t010_013/c0_w0_br u_t010_013/c0_w1_bl u_t010_013/c0_w1_br u_t010_013/c0_r0_rbl
+ u_t010_013/c0_r1_rbl u_t010_013/c1_w0_bl u_t010_013/c1_w0_br u_t010_013/c1_w1_bl u_t010_013/c1_w1_br
+ u_t010_013/c1_r0_rbl u_t010_013/c1_r1_rbl u_t010_013/c2_w0_bl u_t010_013/c2_w0_br u_t010_013/c2_w1_bl
+ u_t010_013/c2_w1_br u_t010_013/c2_r0_rbl u_t010_013/c2_r1_rbl u_t010_013/c3_w0_bl u_t010_013/c3_w0_br
+ u_t010_013/c3_w1_bl u_t010_013/c3_w1_br u_t010_013/c3_r0_rbl u_t010_013/c3_r1_rbl u_t010_013/r0_w0_wl
+ u_t010_013/r0_w1_wl u_t010_013/r0_r0_rwl u_t010_013/r0_r1_rwl u_t010_013/r1_w0_wl u_t010_013/r1_w1_wl
+ u_t010_013/r1_r0_rwl u_t010_013/r1_r1_rwl u_t010_013/r2_w0_wl u_t010_013/r2_w1_wl u_t010_013/r2_r0_rwl
+ u_t010_013/r2_r1_rwl u_t010_013/r3_w0_wl u_t010_013/r3_w1_wl u_t010_013/r3_r0_rwl u_t010_013/r3_r1_rwl VDD VSS VSUBS
+ detronyx_12t_2w2r_rc4_4x4_routed_5layer_direct
Xu_t010_002 u_t010_002/c0_w0_bl u_t010_002/c0_w0_br u_t010_002/c0_w1_bl u_t010_002/c0_w1_br u_t010_002/c0_r0_rbl
+ u_t010_002/c0_r1_rbl u_t010_002/c1_w0_bl u_t010_002/c1_w0_br u_t010_002/c1_w1_bl u_t010_002/c1_w1_br
+ u_t010_002/c1_r0_rbl u_t010_002/c1_r1_rbl u_t010_002/c2_w0_bl u_t010_002/c2_w0_br u_t010_002/c2_w1_bl
+ u_t010_002/c2_w1_br u_t010_002/c2_r0_rbl u_t010_002/c2_r1_rbl u_t010_002/c3_w0_bl u_t010_002/c3_w0_br
+ u_t010_002/c3_w1_bl u_t010_002/c3_w1_br u_t010_002/c3_r0_rbl u_t010_002/c3_r1_rbl u_t010_002/r0_w0_wl
+ u_t010_002/r0_w1_wl u_t010_002/r0_r0_rwl u_t010_002/r0_r1_rwl u_t010_002/r1_w0_wl u_t010_002/r1_w1_wl
+ u_t010_002/r1_r0_rwl u_t010_002/r1_r1_rwl u_t010_002/r2_w0_wl u_t010_002/r2_w1_wl u_t010_002/r2_r0_rwl
+ u_t010_002/r2_r1_rwl u_t010_002/r3_w0_wl u_t010_002/r3_w1_wl u_t010_002/r3_r0_rwl u_t010_002/r3_r1_rwl VDD VSS VSUBS
+ detronyx_12t_2w2r_rc4_4x4_routed_5layer_direct
Xu_t001_002 u_t001_002/c0_w0_bl u_t001_002/c0_w0_br u_t001_002/c0_w1_bl u_t001_002/c0_w1_br u_t001_002/c0_r0_rbl
+ u_t001_002/c0_r1_rbl u_t001_002/c1_w0_bl u_t001_002/c1_w0_br u_t001_002/c1_w1_bl u_t001_002/c1_w1_br
+ u_t001_002/c1_r0_rbl u_t001_002/c1_r1_rbl u_t001_002/c2_w0_bl u_t001_002/c2_w0_br u_t001_002/c2_w1_bl
+ u_t001_002/c2_w1_br u_t001_002/c2_r0_rbl u_t001_002/c2_r1_rbl u_t001_002/c3_w0_bl u_t001_002/c3_w0_br
+ u_t001_002/c3_w1_bl u_t001_002/c3_w1_br u_t001_002/c3_r0_rbl u_t001_002/c3_r1_rbl u_t001_002/r0_w0_wl
+ u_t001_002/r0_w1_wl u_t001_002/r0_r0_rwl u_t001_002/r0_r1_rwl u_t001_002/r1_w0_wl u_t001_002/r1_w1_wl
+ u_t001_002/r1_r0_rwl u_t001_002/r1_r1_rwl u_t001_002/r2_w0_wl u_t001_002/r2_w1_wl u_t001_002/r2_r0_rwl
+ u_t001_002/r2_r1_rwl u_t001_002/r3_w0_wl u_t001_002/r3_w1_wl u_t001_002/r3_r0_rwl u_t001_002/r3_r1_rwl VDD VSS VSUBS
+ detronyx_12t_2w2r_rc4_4x4_routed_5layer_direct
Xu_t001_013 u_t001_013/c0_w0_bl u_t001_013/c0_w0_br u_t001_013/c0_w1_bl u_t001_013/c0_w1_br u_t001_013/c0_r0_rbl
+ u_t001_013/c0_r1_rbl u_t001_013/c1_w0_bl u_t001_013/c1_w0_br u_t001_013/c1_w1_bl u_t001_013/c1_w1_br
+ u_t001_013/c1_r0_rbl u_t001_013/c1_r1_rbl u_t001_013/c2_w0_bl u_t001_013/c2_w0_br u_t001_013/c2_w1_bl
+ u_t001_013/c2_w1_br u_t001_013/c2_r0_rbl u_t001_013/c2_r1_rbl u_t001_013/c3_w0_bl u_t001_013/c3_w0_br
+ u_t001_013/c3_w1_bl u_t001_013/c3_w1_br u_t001_013/c3_r0_rbl u_t001_013/c3_r1_rbl u_t001_013/r0_w0_wl
+ u_t001_013/r0_w1_wl u_t001_013/r0_r0_rwl u_t001_013/r0_r1_rwl u_t001_013/r1_w0_wl u_t001_013/r1_w1_wl
+ u_t001_013/r1_r0_rwl u_t001_013/r1_r1_rwl u_t001_013/r2_w0_wl u_t001_013/r2_w1_wl u_t001_013/r2_r0_rwl
+ u_t001_013/r2_r1_rwl u_t001_013/r3_w0_wl u_t001_013/r3_w1_wl u_t001_013/r3_r0_rwl u_t001_013/r3_r1_rwl VDD VSS VSUBS
+ detronyx_12t_2w2r_rc4_4x4_routed_5layer_direct
Xu_t004_010 u_t004_010/c0_w0_bl u_t004_010/c0_w0_br u_t004_010/c0_w1_bl u_t004_010/c0_w1_br u_t004_010/c0_r0_rbl
+ u_t004_010/c0_r1_rbl u_t004_010/c1_w0_bl u_t004_010/c1_w0_br u_t004_010/c1_w1_bl u_t004_010/c1_w1_br
+ u_t004_010/c1_r0_rbl u_t004_010/c1_r1_rbl u_t004_010/c2_w0_bl u_t004_010/c2_w0_br u_t004_010/c2_w1_bl
+ u_t004_010/c2_w1_br u_t004_010/c2_r0_rbl u_t004_010/c2_r1_rbl u_t004_010/c3_w0_bl u_t004_010/c3_w0_br
+ u_t004_010/c3_w1_bl u_t004_010/c3_w1_br u_t004_010/c3_r0_rbl u_t004_010/c3_r1_rbl u_t004_010/r0_w0_wl
+ u_t004_010/r0_w1_wl u_t004_010/r0_r0_rwl u_t004_010/r0_r1_rwl u_t004_010/r1_w0_wl u_t004_010/r1_w1_wl
+ u_t004_010/r1_r0_rwl u_t004_010/r1_r1_rwl u_t004_010/r2_w0_wl u_t004_010/r2_w1_wl u_t004_010/r2_r0_rwl
+ u_t004_010/r2_r1_rwl u_t004_010/r3_w0_wl u_t004_010/r3_w1_wl u_t004_010/r3_r0_rwl u_t004_010/r3_r1_rwl VDD VSS VSUBS
+ detronyx_12t_2w2r_rc4_4x4_routed_5layer_direct
Xu_t008_008 u_t008_008/c0_w0_bl u_t008_008/c0_w0_br u_t008_008/c0_w1_bl u_t008_008/c0_w1_br u_t008_008/c0_r0_rbl
+ u_t008_008/c0_r1_rbl u_t008_008/c1_w0_bl u_t008_008/c1_w0_br u_t008_008/c1_w1_bl u_t008_008/c1_w1_br
+ u_t008_008/c1_r0_rbl u_t008_008/c1_r1_rbl u_t008_008/c2_w0_bl u_t008_008/c2_w0_br u_t008_008/c2_w1_bl
+ u_t008_008/c2_w1_br u_t008_008/c2_r0_rbl u_t008_008/c2_r1_rbl u_t008_008/c3_w0_bl u_t008_008/c3_w0_br
+ u_t008_008/c3_w1_bl u_t008_008/c3_w1_br u_t008_008/c3_r0_rbl u_t008_008/c3_r1_rbl u_t008_008/r0_w0_wl
+ u_t008_008/r0_w1_wl u_t008_008/r0_r0_rwl u_t008_008/r0_r1_rwl u_t008_008/r1_w0_wl u_t008_008/r1_w1_wl
+ u_t008_008/r1_r0_rwl u_t008_008/r1_r1_rwl u_t008_008/r2_w0_wl u_t008_008/r2_w1_wl u_t008_008/r2_r0_rwl
+ u_t008_008/r2_r1_rwl u_t008_008/r3_w0_wl u_t008_008/r3_w1_wl u_t008_008/r3_r0_rwl u_t008_008/r3_r1_rwl VDD VSS VSUBS
+ detronyx_12t_2w2r_rc4_4x4_routed_5layer_direct
Xu_t013_011 u_t013_011/c0_w0_bl u_t013_011/c0_w0_br u_t013_011/c0_w1_bl u_t013_011/c0_w1_br u_t013_011/c0_r0_rbl
+ u_t013_011/c0_r1_rbl u_t013_011/c1_w0_bl u_t013_011/c1_w0_br u_t013_011/c1_w1_bl u_t013_011/c1_w1_br
+ u_t013_011/c1_r0_rbl u_t013_011/c1_r1_rbl u_t013_011/c2_w0_bl u_t013_011/c2_w0_br u_t013_011/c2_w1_bl
+ u_t013_011/c2_w1_br u_t013_011/c2_r0_rbl u_t013_011/c2_r1_rbl u_t013_011/c3_w0_bl u_t013_011/c3_w0_br
+ u_t013_011/c3_w1_bl u_t013_011/c3_w1_br u_t013_011/c3_r0_rbl u_t013_011/c3_r1_rbl u_t013_011/r0_w0_wl
+ u_t013_011/r0_w1_wl u_t013_011/r0_r0_rwl u_t013_011/r0_r1_rwl u_t013_011/r1_w0_wl u_t013_011/r1_w1_wl
+ u_t013_011/r1_r0_rwl u_t013_011/r1_r1_rwl u_t013_011/r2_w0_wl u_t013_011/r2_w1_wl u_t013_011/r2_r0_rwl
+ u_t013_011/r2_r1_rwl u_t013_011/r3_w0_wl u_t013_011/r3_w1_wl u_t013_011/r3_r0_rwl u_t013_011/r3_r1_rwl VDD VSS VSUBS
+ detronyx_12t_2w2r_rc4_4x4_routed_5layer_direct
Xu_t013_000 u_t013_000/c0_w0_bl u_t013_000/c0_w0_br u_t013_000/c0_w1_bl u_t013_000/c0_w1_br u_t013_000/c0_r0_rbl
+ u_t013_000/c0_r1_rbl u_t013_000/c1_w0_bl u_t013_000/c1_w0_br u_t013_000/c1_w1_bl u_t013_000/c1_w1_br
+ u_t013_000/c1_r0_rbl u_t013_000/c1_r1_rbl u_t013_000/c2_w0_bl u_t013_000/c2_w0_br u_t013_000/c2_w1_bl
+ u_t013_000/c2_w1_br u_t013_000/c2_r0_rbl u_t013_000/c2_r1_rbl u_t013_000/c3_w0_bl u_t013_000/c3_w0_br
+ u_t013_000/c3_w1_bl u_t013_000/c3_w1_br u_t013_000/c3_r0_rbl u_t013_000/c3_r1_rbl u_t013_000/r0_w0_wl
+ u_t013_000/r0_w1_wl u_t013_000/r0_r0_rwl u_t013_000/r0_r1_rwl u_t013_000/r1_w0_wl u_t013_000/r1_w1_wl
+ u_t013_000/r1_r0_rwl u_t013_000/r1_r1_rwl u_t013_000/r2_w0_wl u_t013_000/r2_w1_wl u_t013_000/r2_r0_rwl
+ u_t013_000/r2_r1_rwl u_t013_000/r3_w0_wl u_t013_000/r3_w1_wl u_t013_000/r3_r0_rwl u_t013_000/r3_r1_rwl VDD VSS VSUBS
+ detronyx_12t_2w2r_rc4_4x4_routed_5layer_direct
Xu_t010_014 u_t010_014/c0_w0_bl u_t010_014/c0_w0_br u_t010_014/c0_w1_bl u_t010_014/c0_w1_br u_t010_014/c0_r0_rbl
+ u_t010_014/c0_r1_rbl u_t010_014/c1_w0_bl u_t010_014/c1_w0_br u_t010_014/c1_w1_bl u_t010_014/c1_w1_br
+ u_t010_014/c1_r0_rbl u_t010_014/c1_r1_rbl u_t010_014/c2_w0_bl u_t010_014/c2_w0_br u_t010_014/c2_w1_bl
+ u_t010_014/c2_w1_br u_t010_014/c2_r0_rbl u_t010_014/c2_r1_rbl u_t010_014/c3_w0_bl u_t010_014/c3_w0_br
+ u_t010_014/c3_w1_bl u_t010_014/c3_w1_br u_t010_014/c3_r0_rbl u_t010_014/c3_r1_rbl u_t010_014/r0_w0_wl
+ u_t010_014/r0_w1_wl u_t010_014/r0_r0_rwl u_t010_014/r0_r1_rwl u_t010_014/r1_w0_wl u_t010_014/r1_w1_wl
+ u_t010_014/r1_r0_rwl u_t010_014/r1_r1_rwl u_t010_014/r2_w0_wl u_t010_014/r2_w1_wl u_t010_014/r2_r0_rwl
+ u_t010_014/r2_r1_rwl u_t010_014/r3_w0_wl u_t010_014/r3_w1_wl u_t010_014/r3_r0_rwl u_t010_014/r3_r1_rwl VDD VSS VSUBS
+ detronyx_12t_2w2r_rc4_4x4_routed_5layer_direct
Xu_t010_003 u_t010_003/c0_w0_bl u_t010_003/c0_w0_br u_t010_003/c0_w1_bl u_t010_003/c0_w1_br u_t010_003/c0_r0_rbl
+ u_t010_003/c0_r1_rbl u_t010_003/c1_w0_bl u_t010_003/c1_w0_br u_t010_003/c1_w1_bl u_t010_003/c1_w1_br
+ u_t010_003/c1_r0_rbl u_t010_003/c1_r1_rbl u_t010_003/c2_w0_bl u_t010_003/c2_w0_br u_t010_003/c2_w1_bl
+ u_t010_003/c2_w1_br u_t010_003/c2_r0_rbl u_t010_003/c2_r1_rbl u_t010_003/c3_w0_bl u_t010_003/c3_w0_br
+ u_t010_003/c3_w1_bl u_t010_003/c3_w1_br u_t010_003/c3_r0_rbl u_t010_003/c3_r1_rbl u_t010_003/r0_w0_wl
+ u_t010_003/r0_w1_wl u_t010_003/r0_r0_rwl u_t010_003/r0_r1_rwl u_t010_003/r1_w0_wl u_t010_003/r1_w1_wl
+ u_t010_003/r1_r0_rwl u_t010_003/r1_r1_rwl u_t010_003/r2_w0_wl u_t010_003/r2_w1_wl u_t010_003/r2_r0_rwl
+ u_t010_003/r2_r1_rwl u_t010_003/r3_w0_wl u_t010_003/r3_w1_wl u_t010_003/r3_r0_rwl u_t010_003/r3_r1_rwl VDD VSS VSUBS
+ detronyx_12t_2w2r_rc4_4x4_routed_5layer_direct
Xu_t004_000 u_t004_000/c0_w0_bl u_t004_000/c0_w0_br u_t004_000/c0_w1_bl u_t004_000/c0_w1_br u_t004_000/c0_r0_rbl
+ u_t004_000/c0_r1_rbl u_t004_000/c1_w0_bl u_t004_000/c1_w0_br u_t004_000/c1_w1_bl u_t004_000/c1_w1_br
+ u_t004_000/c1_r0_rbl u_t004_000/c1_r1_rbl u_t004_000/c2_w0_bl u_t004_000/c2_w0_br u_t004_000/c2_w1_bl
+ u_t004_000/c2_w1_br u_t004_000/c2_r0_rbl u_t004_000/c2_r1_rbl u_t004_000/c3_w0_bl u_t004_000/c3_w0_br
+ u_t004_000/c3_w1_bl u_t004_000/c3_w1_br u_t004_000/c3_r0_rbl u_t004_000/c3_r1_rbl u_t004_000/r0_w0_wl
+ u_t004_000/r0_w1_wl u_t004_000/r0_r0_rwl u_t004_000/r0_r1_rwl u_t004_000/r1_w0_wl u_t004_000/r1_w1_wl
+ u_t004_000/r1_r0_rwl u_t004_000/r1_r1_rwl u_t004_000/r2_w0_wl u_t004_000/r2_w1_wl u_t004_000/r2_r0_rwl
+ u_t004_000/r2_r1_rwl u_t004_000/r3_w0_wl u_t004_000/r3_w1_wl u_t004_000/r3_r0_rwl u_t004_000/r3_r1_rwl VDD VSS VSUBS
+ detronyx_12t_2w2r_rc4_4x4_routed_5layer_direct
Xu_t004_011 u_t004_011/c0_w0_bl u_t004_011/c0_w0_br u_t004_011/c0_w1_bl u_t004_011/c0_w1_br u_t004_011/c0_r0_rbl
+ u_t004_011/c0_r1_rbl u_t004_011/c1_w0_bl u_t004_011/c1_w0_br u_t004_011/c1_w1_bl u_t004_011/c1_w1_br
+ u_t004_011/c1_r0_rbl u_t004_011/c1_r1_rbl u_t004_011/c2_w0_bl u_t004_011/c2_w0_br u_t004_011/c2_w1_bl
+ u_t004_011/c2_w1_br u_t004_011/c2_r0_rbl u_t004_011/c2_r1_rbl u_t004_011/c3_w0_bl u_t004_011/c3_w0_br
+ u_t004_011/c3_w1_bl u_t004_011/c3_w1_br u_t004_011/c3_r0_rbl u_t004_011/c3_r1_rbl u_t004_011/r0_w0_wl
+ u_t004_011/r0_w1_wl u_t004_011/r0_r0_rwl u_t004_011/r0_r1_rwl u_t004_011/r1_w0_wl u_t004_011/r1_w1_wl
+ u_t004_011/r1_r0_rwl u_t004_011/r1_r1_rwl u_t004_011/r2_w0_wl u_t004_011/r2_w1_wl u_t004_011/r2_r0_rwl
+ u_t004_011/r2_r1_rwl u_t004_011/r3_w0_wl u_t004_011/r3_w1_wl u_t004_011/r3_r0_rwl u_t004_011/r3_r1_rwl VDD VSS VSUBS
+ detronyx_12t_2w2r_rc4_4x4_routed_5layer_direct
Xu_t001_003 u_t001_003/c0_w0_bl u_t001_003/c0_w0_br u_t001_003/c0_w1_bl u_t001_003/c0_w1_br u_t001_003/c0_r0_rbl
+ u_t001_003/c0_r1_rbl u_t001_003/c1_w0_bl u_t001_003/c1_w0_br u_t001_003/c1_w1_bl u_t001_003/c1_w1_br
+ u_t001_003/c1_r0_rbl u_t001_003/c1_r1_rbl u_t001_003/c2_w0_bl u_t001_003/c2_w0_br u_t001_003/c2_w1_bl
+ u_t001_003/c2_w1_br u_t001_003/c2_r0_rbl u_t001_003/c2_r1_rbl u_t001_003/c3_w0_bl u_t001_003/c3_w0_br
+ u_t001_003/c3_w1_bl u_t001_003/c3_w1_br u_t001_003/c3_r0_rbl u_t001_003/c3_r1_rbl u_t001_003/r0_w0_wl
+ u_t001_003/r0_w1_wl u_t001_003/r0_r0_rwl u_t001_003/r0_r1_rwl u_t001_003/r1_w0_wl u_t001_003/r1_w1_wl
+ u_t001_003/r1_r0_rwl u_t001_003/r1_r1_rwl u_t001_003/r2_w0_wl u_t001_003/r2_w1_wl u_t001_003/r2_r0_rwl
+ u_t001_003/r2_r1_rwl u_t001_003/r3_w0_wl u_t001_003/r3_w1_wl u_t001_003/r3_r0_rwl u_t001_003/r3_r1_rwl VDD VSS VSUBS
+ detronyx_12t_2w2r_rc4_4x4_routed_5layer_direct
Xu_t001_014 u_t001_014/c0_w0_bl u_t001_014/c0_w0_br u_t001_014/c0_w1_bl u_t001_014/c0_w1_br u_t001_014/c0_r0_rbl
+ u_t001_014/c0_r1_rbl u_t001_014/c1_w0_bl u_t001_014/c1_w0_br u_t001_014/c1_w1_bl u_t001_014/c1_w1_br
+ u_t001_014/c1_r0_rbl u_t001_014/c1_r1_rbl u_t001_014/c2_w0_bl u_t001_014/c2_w0_br u_t001_014/c2_w1_bl
+ u_t001_014/c2_w1_br u_t001_014/c2_r0_rbl u_t001_014/c2_r1_rbl u_t001_014/c3_w0_bl u_t001_014/c3_w0_br
+ u_t001_014/c3_w1_bl u_t001_014/c3_w1_br u_t001_014/c3_r0_rbl u_t001_014/c3_r1_rbl u_t001_014/r0_w0_wl
+ u_t001_014/r0_w1_wl u_t001_014/r0_r0_rwl u_t001_014/r0_r1_rwl u_t001_014/r1_w0_wl u_t001_014/r1_w1_wl
+ u_t001_014/r1_r0_rwl u_t001_014/r1_r1_rwl u_t001_014/r2_w0_wl u_t001_014/r2_w1_wl u_t001_014/r2_r0_rwl
+ u_t001_014/r2_r1_rwl u_t001_014/r3_w0_wl u_t001_014/r3_w1_wl u_t001_014/r3_r0_rwl u_t001_014/r3_r1_rwl VDD VSS VSUBS
+ detronyx_12t_2w2r_rc4_4x4_routed_5layer_direct
Xu_t008_009 u_t008_009/c0_w0_bl u_t008_009/c0_w0_br u_t008_009/c0_w1_bl u_t008_009/c0_w1_br u_t008_009/c0_r0_rbl
+ u_t008_009/c0_r1_rbl u_t008_009/c1_w0_bl u_t008_009/c1_w0_br u_t008_009/c1_w1_bl u_t008_009/c1_w1_br
+ u_t008_009/c1_r0_rbl u_t008_009/c1_r1_rbl u_t008_009/c2_w0_bl u_t008_009/c2_w0_br u_t008_009/c2_w1_bl
+ u_t008_009/c2_w1_br u_t008_009/c2_r0_rbl u_t008_009/c2_r1_rbl u_t008_009/c3_w0_bl u_t008_009/c3_w0_br
+ u_t008_009/c3_w1_bl u_t008_009/c3_w1_br u_t008_009/c3_r0_rbl u_t008_009/c3_r1_rbl u_t008_009/r0_w0_wl
+ u_t008_009/r0_w1_wl u_t008_009/r0_r0_rwl u_t008_009/r0_r1_rwl u_t008_009/r1_w0_wl u_t008_009/r1_w1_wl
+ u_t008_009/r1_r0_rwl u_t008_009/r1_r1_rwl u_t008_009/r2_w0_wl u_t008_009/r2_w1_wl u_t008_009/r2_r0_rwl
+ u_t008_009/r2_r1_rwl u_t008_009/r3_w0_wl u_t008_009/r3_w1_wl u_t008_009/r3_r0_rwl u_t008_009/r3_r1_rwl VDD VSS VSUBS
+ detronyx_12t_2w2r_rc4_4x4_routed_5layer_direct
Xu_t013_012 u_t013_012/c0_w0_bl u_t013_012/c0_w0_br u_t013_012/c0_w1_bl u_t013_012/c0_w1_br u_t013_012/c0_r0_rbl
+ u_t013_012/c0_r1_rbl u_t013_012/c1_w0_bl u_t013_012/c1_w0_br u_t013_012/c1_w1_bl u_t013_012/c1_w1_br
+ u_t013_012/c1_r0_rbl u_t013_012/c1_r1_rbl u_t013_012/c2_w0_bl u_t013_012/c2_w0_br u_t013_012/c2_w1_bl
+ u_t013_012/c2_w1_br u_t013_012/c2_r0_rbl u_t013_012/c2_r1_rbl u_t013_012/c3_w0_bl u_t013_012/c3_w0_br
+ u_t013_012/c3_w1_bl u_t013_012/c3_w1_br u_t013_012/c3_r0_rbl u_t013_012/c3_r1_rbl u_t013_012/r0_w0_wl
+ u_t013_012/r0_w1_wl u_t013_012/r0_r0_rwl u_t013_012/r0_r1_rwl u_t013_012/r1_w0_wl u_t013_012/r1_w1_wl
+ u_t013_012/r1_r0_rwl u_t013_012/r1_r1_rwl u_t013_012/r2_w0_wl u_t013_012/r2_w1_wl u_t013_012/r2_r0_rwl
+ u_t013_012/r2_r1_rwl u_t013_012/r3_w0_wl u_t013_012/r3_w1_wl u_t013_012/r3_r0_rwl u_t013_012/r3_r1_rwl VDD VSS VSUBS
+ detronyx_12t_2w2r_rc4_4x4_routed_5layer_direct
Xu_t013_001 u_t013_001/c0_w0_bl u_t013_001/c0_w0_br u_t013_001/c0_w1_bl u_t013_001/c0_w1_br u_t013_001/c0_r0_rbl
+ u_t013_001/c0_r1_rbl u_t013_001/c1_w0_bl u_t013_001/c1_w0_br u_t013_001/c1_w1_bl u_t013_001/c1_w1_br
+ u_t013_001/c1_r0_rbl u_t013_001/c1_r1_rbl u_t013_001/c2_w0_bl u_t013_001/c2_w0_br u_t013_001/c2_w1_bl
+ u_t013_001/c2_w1_br u_t013_001/c2_r0_rbl u_t013_001/c2_r1_rbl u_t013_001/c3_w0_bl u_t013_001/c3_w0_br
+ u_t013_001/c3_w1_bl u_t013_001/c3_w1_br u_t013_001/c3_r0_rbl u_t013_001/c3_r1_rbl u_t013_001/r0_w0_wl
+ u_t013_001/r0_w1_wl u_t013_001/r0_r0_rwl u_t013_001/r0_r1_rwl u_t013_001/r1_w0_wl u_t013_001/r1_w1_wl
+ u_t013_001/r1_r0_rwl u_t013_001/r1_r1_rwl u_t013_001/r2_w0_wl u_t013_001/r2_w1_wl u_t013_001/r2_r0_rwl
+ u_t013_001/r2_r1_rwl u_t013_001/r3_w0_wl u_t013_001/r3_w1_wl u_t013_001/r3_r0_rwl u_t013_001/r3_r1_rwl VDD VSS VSUBS
+ detronyx_12t_2w2r_rc4_4x4_routed_5layer_direct
Xu_t010_015 u_t010_015/c0_w0_bl u_t010_015/c0_w0_br u_t010_015/c0_w1_bl u_t010_015/c0_w1_br u_t010_015/c0_r0_rbl
+ u_t010_015/c0_r1_rbl u_t010_015/c1_w0_bl u_t010_015/c1_w0_br u_t010_015/c1_w1_bl u_t010_015/c1_w1_br
+ u_t010_015/c1_r0_rbl u_t010_015/c1_r1_rbl u_t010_015/c2_w0_bl u_t010_015/c2_w0_br u_t010_015/c2_w1_bl
+ u_t010_015/c2_w1_br u_t010_015/c2_r0_rbl u_t010_015/c2_r1_rbl u_t010_015/c3_w0_bl u_t010_015/c3_w0_br
+ u_t010_015/c3_w1_bl u_t010_015/c3_w1_br u_t010_015/c3_r0_rbl u_t010_015/c3_r1_rbl u_t010_015/r0_w0_wl
+ u_t010_015/r0_w1_wl u_t010_015/r0_r0_rwl u_t010_015/r0_r1_rwl u_t010_015/r1_w0_wl u_t010_015/r1_w1_wl
+ u_t010_015/r1_r0_rwl u_t010_015/r1_r1_rwl u_t010_015/r2_w0_wl u_t010_015/r2_w1_wl u_t010_015/r2_r0_rwl
+ u_t010_015/r2_r1_rwl u_t010_015/r3_w0_wl u_t010_015/r3_w1_wl u_t010_015/r3_r0_rwl u_t010_015/r3_r1_rwl VDD VSS VSUBS
+ detronyx_12t_2w2r_rc4_4x4_routed_5layer_direct
Xu_t010_004 u_t010_004/c0_w0_bl u_t010_004/c0_w0_br u_t010_004/c0_w1_bl u_t010_004/c0_w1_br u_t010_004/c0_r0_rbl
+ u_t010_004/c0_r1_rbl u_t010_004/c1_w0_bl u_t010_004/c1_w0_br u_t010_004/c1_w1_bl u_t010_004/c1_w1_br
+ u_t010_004/c1_r0_rbl u_t010_004/c1_r1_rbl u_t010_004/c2_w0_bl u_t010_004/c2_w0_br u_t010_004/c2_w1_bl
+ u_t010_004/c2_w1_br u_t010_004/c2_r0_rbl u_t010_004/c2_r1_rbl u_t010_004/c3_w0_bl u_t010_004/c3_w0_br
+ u_t010_004/c3_w1_bl u_t010_004/c3_w1_br u_t010_004/c3_r0_rbl u_t010_004/c3_r1_rbl u_t010_004/r0_w0_wl
+ u_t010_004/r0_w1_wl u_t010_004/r0_r0_rwl u_t010_004/r0_r1_rwl u_t010_004/r1_w0_wl u_t010_004/r1_w1_wl
+ u_t010_004/r1_r0_rwl u_t010_004/r1_r1_rwl u_t010_004/r2_w0_wl u_t010_004/r2_w1_wl u_t010_004/r2_r0_rwl
+ u_t010_004/r2_r1_rwl u_t010_004/r3_w0_wl u_t010_004/r3_w1_wl u_t010_004/r3_r0_rwl u_t010_004/r3_r1_rwl VDD VSS VSUBS
+ detronyx_12t_2w2r_rc4_4x4_routed_5layer_direct
Xu_t001_004 u_t001_004/c0_w0_bl u_t001_004/c0_w0_br u_t001_004/c0_w1_bl u_t001_004/c0_w1_br u_t001_004/c0_r0_rbl
+ u_t001_004/c0_r1_rbl u_t001_004/c1_w0_bl u_t001_004/c1_w0_br u_t001_004/c1_w1_bl u_t001_004/c1_w1_br
+ u_t001_004/c1_r0_rbl u_t001_004/c1_r1_rbl u_t001_004/c2_w0_bl u_t001_004/c2_w0_br u_t001_004/c2_w1_bl
+ u_t001_004/c2_w1_br u_t001_004/c2_r0_rbl u_t001_004/c2_r1_rbl u_t001_004/c3_w0_bl u_t001_004/c3_w0_br
+ u_t001_004/c3_w1_bl u_t001_004/c3_w1_br u_t001_004/c3_r0_rbl u_t001_004/c3_r1_rbl u_t001_004/r0_w0_wl
+ u_t001_004/r0_w1_wl u_t001_004/r0_r0_rwl u_t001_004/r0_r1_rwl u_t001_004/r1_w0_wl u_t001_004/r1_w1_wl
+ u_t001_004/r1_r0_rwl u_t001_004/r1_r1_rwl u_t001_004/r2_w0_wl u_t001_004/r2_w1_wl u_t001_004/r2_r0_rwl
+ u_t001_004/r2_r1_rwl u_t001_004/r3_w0_wl u_t001_004/r3_w1_wl u_t001_004/r3_r0_rwl u_t001_004/r3_r1_rwl VDD VSS VSUBS
+ detronyx_12t_2w2r_rc4_4x4_routed_5layer_direct
Xu_t001_015 u_t001_015/c0_w0_bl u_t001_015/c0_w0_br u_t001_015/c0_w1_bl u_t001_015/c0_w1_br u_t001_015/c0_r0_rbl
+ u_t001_015/c0_r1_rbl u_t001_015/c1_w0_bl u_t001_015/c1_w0_br u_t001_015/c1_w1_bl u_t001_015/c1_w1_br
+ u_t001_015/c1_r0_rbl u_t001_015/c1_r1_rbl u_t001_015/c2_w0_bl u_t001_015/c2_w0_br u_t001_015/c2_w1_bl
+ u_t001_015/c2_w1_br u_t001_015/c2_r0_rbl u_t001_015/c2_r1_rbl u_t001_015/c3_w0_bl u_t001_015/c3_w0_br
+ u_t001_015/c3_w1_bl u_t001_015/c3_w1_br u_t001_015/c3_r0_rbl u_t001_015/c3_r1_rbl u_t001_015/r0_w0_wl
+ u_t001_015/r0_w1_wl u_t001_015/r0_r0_rwl u_t001_015/r0_r1_rwl u_t001_015/r1_w0_wl u_t001_015/r1_w1_wl
+ u_t001_015/r1_r0_rwl u_t001_015/r1_r1_rwl u_t001_015/r2_w0_wl u_t001_015/r2_w1_wl u_t001_015/r2_r0_rwl
+ u_t001_015/r2_r1_rwl u_t001_015/r3_w0_wl u_t001_015/r3_w1_wl u_t001_015/r3_r0_rwl u_t001_015/r3_r1_rwl VDD VSS VSUBS
+ detronyx_12t_2w2r_rc4_4x4_routed_5layer_direct
Xu_t004_001 u_t004_001/c0_w0_bl u_t004_001/c0_w0_br u_t004_001/c0_w1_bl u_t004_001/c0_w1_br u_t004_001/c0_r0_rbl
+ u_t004_001/c0_r1_rbl u_t004_001/c1_w0_bl u_t004_001/c1_w0_br u_t004_001/c1_w1_bl u_t004_001/c1_w1_br
+ u_t004_001/c1_r0_rbl u_t004_001/c1_r1_rbl u_t004_001/c2_w0_bl u_t004_001/c2_w0_br u_t004_001/c2_w1_bl
+ u_t004_001/c2_w1_br u_t004_001/c2_r0_rbl u_t004_001/c2_r1_rbl u_t004_001/c3_w0_bl u_t004_001/c3_w0_br
+ u_t004_001/c3_w1_bl u_t004_001/c3_w1_br u_t004_001/c3_r0_rbl u_t004_001/c3_r1_rbl u_t004_001/r0_w0_wl
+ u_t004_001/r0_w1_wl u_t004_001/r0_r0_rwl u_t004_001/r0_r1_rwl u_t004_001/r1_w0_wl u_t004_001/r1_w1_wl
+ u_t004_001/r1_r0_rwl u_t004_001/r1_r1_rwl u_t004_001/r2_w0_wl u_t004_001/r2_w1_wl u_t004_001/r2_r0_rwl
+ u_t004_001/r2_r1_rwl u_t004_001/r3_w0_wl u_t004_001/r3_w1_wl u_t004_001/r3_r0_rwl u_t004_001/r3_r1_rwl VDD VSS VSUBS
+ detronyx_12t_2w2r_rc4_4x4_routed_5layer_direct
Xu_t004_012 u_t004_012/c0_w0_bl u_t004_012/c0_w0_br u_t004_012/c0_w1_bl u_t004_012/c0_w1_br u_t004_012/c0_r0_rbl
+ u_t004_012/c0_r1_rbl u_t004_012/c1_w0_bl u_t004_012/c1_w0_br u_t004_012/c1_w1_bl u_t004_012/c1_w1_br
+ u_t004_012/c1_r0_rbl u_t004_012/c1_r1_rbl u_t004_012/c2_w0_bl u_t004_012/c2_w0_br u_t004_012/c2_w1_bl
+ u_t004_012/c2_w1_br u_t004_012/c2_r0_rbl u_t004_012/c2_r1_rbl u_t004_012/c3_w0_bl u_t004_012/c3_w0_br
+ u_t004_012/c3_w1_bl u_t004_012/c3_w1_br u_t004_012/c3_r0_rbl u_t004_012/c3_r1_rbl u_t004_012/r0_w0_wl
+ u_t004_012/r0_w1_wl u_t004_012/r0_r0_rwl u_t004_012/r0_r1_rwl u_t004_012/r1_w0_wl u_t004_012/r1_w1_wl
+ u_t004_012/r1_r0_rwl u_t004_012/r1_r1_rwl u_t004_012/r2_w0_wl u_t004_012/r2_w1_wl u_t004_012/r2_r0_rwl
+ u_t004_012/r2_r1_rwl u_t004_012/r3_w0_wl u_t004_012/r3_w1_wl u_t004_012/r3_r0_rwl u_t004_012/r3_r1_rwl VDD VSS VSUBS
+ detronyx_12t_2w2r_rc4_4x4_routed_5layer_direct
Xu_t013_013 u_t013_013/c0_w0_bl u_t013_013/c0_w0_br u_t013_013/c0_w1_bl u_t013_013/c0_w1_br u_t013_013/c0_r0_rbl
+ u_t013_013/c0_r1_rbl u_t013_013/c1_w0_bl u_t013_013/c1_w0_br u_t013_013/c1_w1_bl u_t013_013/c1_w1_br
+ u_t013_013/c1_r0_rbl u_t013_013/c1_r1_rbl u_t013_013/c2_w0_bl u_t013_013/c2_w0_br u_t013_013/c2_w1_bl
+ u_t013_013/c2_w1_br u_t013_013/c2_r0_rbl u_t013_013/c2_r1_rbl u_t013_013/c3_w0_bl u_t013_013/c3_w0_br
+ u_t013_013/c3_w1_bl u_t013_013/c3_w1_br u_t013_013/c3_r0_rbl u_t013_013/c3_r1_rbl u_t013_013/r0_w0_wl
+ u_t013_013/r0_w1_wl u_t013_013/r0_r0_rwl u_t013_013/r0_r1_rwl u_t013_013/r1_w0_wl u_t013_013/r1_w1_wl
+ u_t013_013/r1_r0_rwl u_t013_013/r1_r1_rwl u_t013_013/r2_w0_wl u_t013_013/r2_w1_wl u_t013_013/r2_r0_rwl
+ u_t013_013/r2_r1_rwl u_t013_013/r3_w0_wl u_t013_013/r3_w1_wl u_t013_013/r3_r0_rwl u_t013_013/r3_r1_rwl VDD VSS VSUBS
+ detronyx_12t_2w2r_rc4_4x4_routed_5layer_direct
Xu_t013_002 u_t013_002/c0_w0_bl u_t013_002/c0_w0_br u_t013_002/c0_w1_bl u_t013_002/c0_w1_br u_t013_002/c0_r0_rbl
+ u_t013_002/c0_r1_rbl u_t013_002/c1_w0_bl u_t013_002/c1_w0_br u_t013_002/c1_w1_bl u_t013_002/c1_w1_br
+ u_t013_002/c1_r0_rbl u_t013_002/c1_r1_rbl u_t013_002/c2_w0_bl u_t013_002/c2_w0_br u_t013_002/c2_w1_bl
+ u_t013_002/c2_w1_br u_t013_002/c2_r0_rbl u_t013_002/c2_r1_rbl u_t013_002/c3_w0_bl u_t013_002/c3_w0_br
+ u_t013_002/c3_w1_bl u_t013_002/c3_w1_br u_t013_002/c3_r0_rbl u_t013_002/c3_r1_rbl u_t013_002/r0_w0_wl
+ u_t013_002/r0_w1_wl u_t013_002/r0_r0_rwl u_t013_002/r0_r1_rwl u_t013_002/r1_w0_wl u_t013_002/r1_w1_wl
+ u_t013_002/r1_r0_rwl u_t013_002/r1_r1_rwl u_t013_002/r2_w0_wl u_t013_002/r2_w1_wl u_t013_002/r2_r0_rwl
+ u_t013_002/r2_r1_rwl u_t013_002/r3_w0_wl u_t013_002/r3_w1_wl u_t013_002/r3_r0_rwl u_t013_002/r3_r1_rwl VDD VSS VSUBS
+ detronyx_12t_2w2r_rc4_4x4_routed_5layer_direct
Xu_t007_010 u_t007_010/c0_w0_bl u_t007_010/c0_w0_br u_t007_010/c0_w1_bl u_t007_010/c0_w1_br u_t007_010/c0_r0_rbl
+ u_t007_010/c0_r1_rbl u_t007_010/c1_w0_bl u_t007_010/c1_w0_br u_t007_010/c1_w1_bl u_t007_010/c1_w1_br
+ u_t007_010/c1_r0_rbl u_t007_010/c1_r1_rbl u_t007_010/c2_w0_bl u_t007_010/c2_w0_br u_t007_010/c2_w1_bl
+ u_t007_010/c2_w1_br u_t007_010/c2_r0_rbl u_t007_010/c2_r1_rbl u_t007_010/c3_w0_bl u_t007_010/c3_w0_br
+ u_t007_010/c3_w1_bl u_t007_010/c3_w1_br u_t007_010/c3_r0_rbl u_t007_010/c3_r1_rbl u_t007_010/r0_w0_wl
+ u_t007_010/r0_w1_wl u_t007_010/r0_r0_rwl u_t007_010/r0_r1_rwl u_t007_010/r1_w0_wl u_t007_010/r1_w1_wl
+ u_t007_010/r1_r0_rwl u_t007_010/r1_r1_rwl u_t007_010/r2_w0_wl u_t007_010/r2_w1_wl u_t007_010/r2_r0_rwl
+ u_t007_010/r2_r1_rwl u_t007_010/r3_w0_wl u_t007_010/r3_w1_wl u_t007_010/r3_r0_rwl u_t007_010/r3_r1_rwl VDD VSS VSUBS
+ detronyx_12t_2w2r_rc4_4x4_routed_5layer_direct
Xu_t004_002 u_t004_002/c0_w0_bl u_t004_002/c0_w0_br u_t004_002/c0_w1_bl u_t004_002/c0_w1_br u_t004_002/c0_r0_rbl
+ u_t004_002/c0_r1_rbl u_t004_002/c1_w0_bl u_t004_002/c1_w0_br u_t004_002/c1_w1_bl u_t004_002/c1_w1_br
+ u_t004_002/c1_r0_rbl u_t004_002/c1_r1_rbl u_t004_002/c2_w0_bl u_t004_002/c2_w0_br u_t004_002/c2_w1_bl
+ u_t004_002/c2_w1_br u_t004_002/c2_r0_rbl u_t004_002/c2_r1_rbl u_t004_002/c3_w0_bl u_t004_002/c3_w0_br
+ u_t004_002/c3_w1_bl u_t004_002/c3_w1_br u_t004_002/c3_r0_rbl u_t004_002/c3_r1_rbl u_t004_002/r0_w0_wl
+ u_t004_002/r0_w1_wl u_t004_002/r0_r0_rwl u_t004_002/r0_r1_rwl u_t004_002/r1_w0_wl u_t004_002/r1_w1_wl
+ u_t004_002/r1_r0_rwl u_t004_002/r1_r1_rwl u_t004_002/r2_w0_wl u_t004_002/r2_w1_wl u_t004_002/r2_r0_rwl
+ u_t004_002/r2_r1_rwl u_t004_002/r3_w0_wl u_t004_002/r3_w1_wl u_t004_002/r3_r0_rwl u_t004_002/r3_r1_rwl VDD VSS VSUBS
+ detronyx_12t_2w2r_rc4_4x4_routed_5layer_direct
Xu_t004_013 u_t004_013/c0_w0_bl u_t004_013/c0_w0_br u_t004_013/c0_w1_bl u_t004_013/c0_w1_br u_t004_013/c0_r0_rbl
+ u_t004_013/c0_r1_rbl u_t004_013/c1_w0_bl u_t004_013/c1_w0_br u_t004_013/c1_w1_bl u_t004_013/c1_w1_br
+ u_t004_013/c1_r0_rbl u_t004_013/c1_r1_rbl u_t004_013/c2_w0_bl u_t004_013/c2_w0_br u_t004_013/c2_w1_bl
+ u_t004_013/c2_w1_br u_t004_013/c2_r0_rbl u_t004_013/c2_r1_rbl u_t004_013/c3_w0_bl u_t004_013/c3_w0_br
+ u_t004_013/c3_w1_bl u_t004_013/c3_w1_br u_t004_013/c3_r0_rbl u_t004_013/c3_r1_rbl u_t004_013/r0_w0_wl
+ u_t004_013/r0_w1_wl u_t004_013/r0_r0_rwl u_t004_013/r0_r1_rwl u_t004_013/r1_w0_wl u_t004_013/r1_w1_wl
+ u_t004_013/r1_r0_rwl u_t004_013/r1_r1_rwl u_t004_013/r2_w0_wl u_t004_013/r2_w1_wl u_t004_013/r2_r0_rwl
+ u_t004_013/r2_r1_rwl u_t004_013/r3_w0_wl u_t004_013/r3_w1_wl u_t004_013/r3_r0_rwl u_t004_013/r3_r1_rwl VDD VSS VSUBS
+ detronyx_12t_2w2r_rc4_4x4_routed_5layer_direct
Xu_t010_005 u_t010_005/c0_w0_bl u_t010_005/c0_w0_br u_t010_005/c0_w1_bl u_t010_005/c0_w1_br u_t010_005/c0_r0_rbl
+ u_t010_005/c0_r1_rbl u_t010_005/c1_w0_bl u_t010_005/c1_w0_br u_t010_005/c1_w1_bl u_t010_005/c1_w1_br
+ u_t010_005/c1_r0_rbl u_t010_005/c1_r1_rbl u_t010_005/c2_w0_bl u_t010_005/c2_w0_br u_t010_005/c2_w1_bl
+ u_t010_005/c2_w1_br u_t010_005/c2_r0_rbl u_t010_005/c2_r1_rbl u_t010_005/c3_w0_bl u_t010_005/c3_w0_br
+ u_t010_005/c3_w1_bl u_t010_005/c3_w1_br u_t010_005/c3_r0_rbl u_t010_005/c3_r1_rbl u_t010_005/r0_w0_wl
+ u_t010_005/r0_w1_wl u_t010_005/r0_r0_rwl u_t010_005/r0_r1_rwl u_t010_005/r1_w0_wl u_t010_005/r1_w1_wl
+ u_t010_005/r1_r0_rwl u_t010_005/r1_r1_rwl u_t010_005/r2_w0_wl u_t010_005/r2_w1_wl u_t010_005/r2_r0_rwl
+ u_t010_005/r2_r1_rwl u_t010_005/r3_w0_wl u_t010_005/r3_w1_wl u_t010_005/r3_r0_rwl u_t010_005/r3_r1_rwl VDD VSS VSUBS
+ detronyx_12t_2w2r_rc4_4x4_routed_5layer_direct
Xu_t001_005 u_t001_005/c0_w0_bl u_t001_005/c0_w0_br u_t001_005/c0_w1_bl u_t001_005/c0_w1_br u_t001_005/c0_r0_rbl
+ u_t001_005/c0_r1_rbl u_t001_005/c1_w0_bl u_t001_005/c1_w0_br u_t001_005/c1_w1_bl u_t001_005/c1_w1_br
+ u_t001_005/c1_r0_rbl u_t001_005/c1_r1_rbl u_t001_005/c2_w0_bl u_t001_005/c2_w0_br u_t001_005/c2_w1_bl
+ u_t001_005/c2_w1_br u_t001_005/c2_r0_rbl u_t001_005/c2_r1_rbl u_t001_005/c3_w0_bl u_t001_005/c3_w0_br
+ u_t001_005/c3_w1_bl u_t001_005/c3_w1_br u_t001_005/c3_r0_rbl u_t001_005/c3_r1_rbl u_t001_005/r0_w0_wl
+ u_t001_005/r0_w1_wl u_t001_005/r0_r0_rwl u_t001_005/r0_r1_rwl u_t001_005/r1_w0_wl u_t001_005/r1_w1_wl
+ u_t001_005/r1_r0_rwl u_t001_005/r1_r1_rwl u_t001_005/r2_w0_wl u_t001_005/r2_w1_wl u_t001_005/r2_r0_rwl
+ u_t001_005/r2_r1_rwl u_t001_005/r3_w0_wl u_t001_005/r3_w1_wl u_t001_005/r3_r0_rwl u_t001_005/r3_r1_rwl VDD VSS VSUBS
+ detronyx_12t_2w2r_rc4_4x4_routed_5layer_direct
Xu_t007_011 u_t007_011/c0_w0_bl u_t007_011/c0_w0_br u_t007_011/c0_w1_bl u_t007_011/c0_w1_br u_t007_011/c0_r0_rbl
+ u_t007_011/c0_r1_rbl u_t007_011/c1_w0_bl u_t007_011/c1_w0_br u_t007_011/c1_w1_bl u_t007_011/c1_w1_br
+ u_t007_011/c1_r0_rbl u_t007_011/c1_r1_rbl u_t007_011/c2_w0_bl u_t007_011/c2_w0_br u_t007_011/c2_w1_bl
+ u_t007_011/c2_w1_br u_t007_011/c2_r0_rbl u_t007_011/c2_r1_rbl u_t007_011/c3_w0_bl u_t007_011/c3_w0_br
+ u_t007_011/c3_w1_bl u_t007_011/c3_w1_br u_t007_011/c3_r0_rbl u_t007_011/c3_r1_rbl u_t007_011/r0_w0_wl
+ u_t007_011/r0_w1_wl u_t007_011/r0_r0_rwl u_t007_011/r0_r1_rwl u_t007_011/r1_w0_wl u_t007_011/r1_w1_wl
+ u_t007_011/r1_r0_rwl u_t007_011/r1_r1_rwl u_t007_011/r2_w0_wl u_t007_011/r2_w1_wl u_t007_011/r2_r0_rwl
+ u_t007_011/r2_r1_rwl u_t007_011/r3_w0_wl u_t007_011/r3_w1_wl u_t007_011/r3_r0_rwl u_t007_011/r3_r1_rwl VDD VSS VSUBS
+ detronyx_12t_2w2r_rc4_4x4_routed_5layer_direct
Xu_t007_000 u_t007_000/c0_w0_bl u_t007_000/c0_w0_br u_t007_000/c0_w1_bl u_t007_000/c0_w1_br u_t007_000/c0_r0_rbl
+ u_t007_000/c0_r1_rbl u_t007_000/c1_w0_bl u_t007_000/c1_w0_br u_t007_000/c1_w1_bl u_t007_000/c1_w1_br
+ u_t007_000/c1_r0_rbl u_t007_000/c1_r1_rbl u_t007_000/c2_w0_bl u_t007_000/c2_w0_br u_t007_000/c2_w1_bl
+ u_t007_000/c2_w1_br u_t007_000/c2_r0_rbl u_t007_000/c2_r1_rbl u_t007_000/c3_w0_bl u_t007_000/c3_w0_br
+ u_t007_000/c3_w1_bl u_t007_000/c3_w1_br u_t007_000/c3_r0_rbl u_t007_000/c3_r1_rbl u_t007_000/r0_w0_wl
+ u_t007_000/r0_w1_wl u_t007_000/r0_r0_rwl u_t007_000/r0_r1_rwl u_t007_000/r1_w0_wl u_t007_000/r1_w1_wl
+ u_t007_000/r1_r0_rwl u_t007_000/r1_r1_rwl u_t007_000/r2_w0_wl u_t007_000/r2_w1_wl u_t007_000/r2_r0_rwl
+ u_t007_000/r2_r1_rwl u_t007_000/r3_w0_wl u_t007_000/r3_w1_wl u_t007_000/r3_r0_rwl u_t007_000/r3_r1_rwl VDD VSS VSUBS
+ detronyx_12t_2w2r_rc4_4x4_routed_5layer_direct
Xu_t013_014 u_t013_014/c0_w0_bl u_t013_014/c0_w0_br u_t013_014/c0_w1_bl u_t013_014/c0_w1_br u_t013_014/c0_r0_rbl
+ u_t013_014/c0_r1_rbl u_t013_014/c1_w0_bl u_t013_014/c1_w0_br u_t013_014/c1_w1_bl u_t013_014/c1_w1_br
+ u_t013_014/c1_r0_rbl u_t013_014/c1_r1_rbl u_t013_014/c2_w0_bl u_t013_014/c2_w0_br u_t013_014/c2_w1_bl
+ u_t013_014/c2_w1_br u_t013_014/c2_r0_rbl u_t013_014/c2_r1_rbl u_t013_014/c3_w0_bl u_t013_014/c3_w0_br
+ u_t013_014/c3_w1_bl u_t013_014/c3_w1_br u_t013_014/c3_r0_rbl u_t013_014/c3_r1_rbl u_t013_014/r0_w0_wl
+ u_t013_014/r0_w1_wl u_t013_014/r0_r0_rwl u_t013_014/r0_r1_rwl u_t013_014/r1_w0_wl u_t013_014/r1_w1_wl
+ u_t013_014/r1_r0_rwl u_t013_014/r1_r1_rwl u_t013_014/r2_w0_wl u_t013_014/r2_w1_wl u_t013_014/r2_r0_rwl
+ u_t013_014/r2_r1_rwl u_t013_014/r3_w0_wl u_t013_014/r3_w1_wl u_t013_014/r3_r0_rwl u_t013_014/r3_r1_rwl VDD VSS VSUBS
+ detronyx_12t_2w2r_rc4_4x4_routed_5layer_direct
Xu_t013_003 u_t013_003/c0_w0_bl u_t013_003/c0_w0_br u_t013_003/c0_w1_bl u_t013_003/c0_w1_br u_t013_003/c0_r0_rbl
+ u_t013_003/c0_r1_rbl u_t013_003/c1_w0_bl u_t013_003/c1_w0_br u_t013_003/c1_w1_bl u_t013_003/c1_w1_br
+ u_t013_003/c1_r0_rbl u_t013_003/c1_r1_rbl u_t013_003/c2_w0_bl u_t013_003/c2_w0_br u_t013_003/c2_w1_bl
+ u_t013_003/c2_w1_br u_t013_003/c2_r0_rbl u_t013_003/c2_r1_rbl u_t013_003/c3_w0_bl u_t013_003/c3_w0_br
+ u_t013_003/c3_w1_bl u_t013_003/c3_w1_br u_t013_003/c3_r0_rbl u_t013_003/c3_r1_rbl u_t013_003/r0_w0_wl
+ u_t013_003/r0_w1_wl u_t013_003/r0_r0_rwl u_t013_003/r0_r1_rwl u_t013_003/r1_w0_wl u_t013_003/r1_w1_wl
+ u_t013_003/r1_r0_rwl u_t013_003/r1_r1_rwl u_t013_003/r2_w0_wl u_t013_003/r2_w1_wl u_t013_003/r2_r0_rwl
+ u_t013_003/r2_r1_rwl u_t013_003/r3_w0_wl u_t013_003/r3_w1_wl u_t013_003/r3_r0_rwl u_t013_003/r3_r1_rwl VDD VSS VSUBS
+ detronyx_12t_2w2r_rc4_4x4_routed_5layer_direct
Xu_t010_006 u_t010_006/c0_w0_bl u_t010_006/c0_w0_br u_t010_006/c0_w1_bl u_t010_006/c0_w1_br u_t010_006/c0_r0_rbl
+ u_t010_006/c0_r1_rbl u_t010_006/c1_w0_bl u_t010_006/c1_w0_br u_t010_006/c1_w1_bl u_t010_006/c1_w1_br
+ u_t010_006/c1_r0_rbl u_t010_006/c1_r1_rbl u_t010_006/c2_w0_bl u_t010_006/c2_w0_br u_t010_006/c2_w1_bl
+ u_t010_006/c2_w1_br u_t010_006/c2_r0_rbl u_t010_006/c2_r1_rbl u_t010_006/c3_w0_bl u_t010_006/c3_w0_br
+ u_t010_006/c3_w1_bl u_t010_006/c3_w1_br u_t010_006/c3_r0_rbl u_t010_006/c3_r1_rbl u_t010_006/r0_w0_wl
+ u_t010_006/r0_w1_wl u_t010_006/r0_r0_rwl u_t010_006/r0_r1_rwl u_t010_006/r1_w0_wl u_t010_006/r1_w1_wl
+ u_t010_006/r1_r0_rwl u_t010_006/r1_r1_rwl u_t010_006/r2_w0_wl u_t010_006/r2_w1_wl u_t010_006/r2_r0_rwl
+ u_t010_006/r2_r1_rwl u_t010_006/r3_w0_wl u_t010_006/r3_w1_wl u_t010_006/r3_r0_rwl u_t010_006/r3_r1_rwl VDD VSS VSUBS
+ detronyx_12t_2w2r_rc4_4x4_routed_5layer_direct
Xu_t001_006 u_t001_006/c0_w0_bl u_t001_006/c0_w0_br u_t001_006/c0_w1_bl u_t001_006/c0_w1_br u_t001_006/c0_r0_rbl
+ u_t001_006/c0_r1_rbl u_t001_006/c1_w0_bl u_t001_006/c1_w0_br u_t001_006/c1_w1_bl u_t001_006/c1_w1_br
+ u_t001_006/c1_r0_rbl u_t001_006/c1_r1_rbl u_t001_006/c2_w0_bl u_t001_006/c2_w0_br u_t001_006/c2_w1_bl
+ u_t001_006/c2_w1_br u_t001_006/c2_r0_rbl u_t001_006/c2_r1_rbl u_t001_006/c3_w0_bl u_t001_006/c3_w0_br
+ u_t001_006/c3_w1_bl u_t001_006/c3_w1_br u_t001_006/c3_r0_rbl u_t001_006/c3_r1_rbl u_t001_006/r0_w0_wl
+ u_t001_006/r0_w1_wl u_t001_006/r0_r0_rwl u_t001_006/r0_r1_rwl u_t001_006/r1_w0_wl u_t001_006/r1_w1_wl
+ u_t001_006/r1_r0_rwl u_t001_006/r1_r1_rwl u_t001_006/r2_w0_wl u_t001_006/r2_w1_wl u_t001_006/r2_r0_rwl
+ u_t001_006/r2_r1_rwl u_t001_006/r3_w0_wl u_t001_006/r3_w1_wl u_t001_006/r3_r0_rwl u_t001_006/r3_r1_rwl VDD VSS VSUBS
+ detronyx_12t_2w2r_rc4_4x4_routed_5layer_direct
Xu_t004_003 u_t004_003/c0_w0_bl u_t004_003/c0_w0_br u_t004_003/c0_w1_bl u_t004_003/c0_w1_br u_t004_003/c0_r0_rbl
+ u_t004_003/c0_r1_rbl u_t004_003/c1_w0_bl u_t004_003/c1_w0_br u_t004_003/c1_w1_bl u_t004_003/c1_w1_br
+ u_t004_003/c1_r0_rbl u_t004_003/c1_r1_rbl u_t004_003/c2_w0_bl u_t004_003/c2_w0_br u_t004_003/c2_w1_bl
+ u_t004_003/c2_w1_br u_t004_003/c2_r0_rbl u_t004_003/c2_r1_rbl u_t004_003/c3_w0_bl u_t004_003/c3_w0_br
+ u_t004_003/c3_w1_bl u_t004_003/c3_w1_br u_t004_003/c3_r0_rbl u_t004_003/c3_r1_rbl u_t004_003/r0_w0_wl
+ u_t004_003/r0_w1_wl u_t004_003/r0_r0_rwl u_t004_003/r0_r1_rwl u_t004_003/r1_w0_wl u_t004_003/r1_w1_wl
+ u_t004_003/r1_r0_rwl u_t004_003/r1_r1_rwl u_t004_003/r2_w0_wl u_t004_003/r2_w1_wl u_t004_003/r2_r0_rwl
+ u_t004_003/r2_r1_rwl u_t004_003/r3_w0_wl u_t004_003/r3_w1_wl u_t004_003/r3_r0_rwl u_t004_003/r3_r1_rwl VDD VSS VSUBS
+ detronyx_12t_2w2r_rc4_4x4_routed_5layer_direct
Xu_t004_014 u_t004_014/c0_w0_bl u_t004_014/c0_w0_br u_t004_014/c0_w1_bl u_t004_014/c0_w1_br u_t004_014/c0_r0_rbl
+ u_t004_014/c0_r1_rbl u_t004_014/c1_w0_bl u_t004_014/c1_w0_br u_t004_014/c1_w1_bl u_t004_014/c1_w1_br
+ u_t004_014/c1_r0_rbl u_t004_014/c1_r1_rbl u_t004_014/c2_w0_bl u_t004_014/c2_w0_br u_t004_014/c2_w1_bl
+ u_t004_014/c2_w1_br u_t004_014/c2_r0_rbl u_t004_014/c2_r1_rbl u_t004_014/c3_w0_bl u_t004_014/c3_w0_br
+ u_t004_014/c3_w1_bl u_t004_014/c3_w1_br u_t004_014/c3_r0_rbl u_t004_014/c3_r1_rbl u_t004_014/r0_w0_wl
+ u_t004_014/r0_w1_wl u_t004_014/r0_r0_rwl u_t004_014/r0_r1_rwl u_t004_014/r1_w0_wl u_t004_014/r1_w1_wl
+ u_t004_014/r1_r0_rwl u_t004_014/r1_r1_rwl u_t004_014/r2_w0_wl u_t004_014/r2_w1_wl u_t004_014/r2_r0_rwl
+ u_t004_014/r2_r1_rwl u_t004_014/r3_w0_wl u_t004_014/r3_w1_wl u_t004_014/r3_r0_rwl u_t004_014/r3_r1_rwl VDD VSS VSUBS
+ detronyx_12t_2w2r_rc4_4x4_routed_5layer_direct
Xu_t013_015 u_t013_015/c0_w0_bl u_t013_015/c0_w0_br u_t013_015/c0_w1_bl u_t013_015/c0_w1_br u_t013_015/c0_r0_rbl
+ u_t013_015/c0_r1_rbl u_t013_015/c1_w0_bl u_t013_015/c1_w0_br u_t013_015/c1_w1_bl u_t013_015/c1_w1_br
+ u_t013_015/c1_r0_rbl u_t013_015/c1_r1_rbl u_t013_015/c2_w0_bl u_t013_015/c2_w0_br u_t013_015/c2_w1_bl
+ u_t013_015/c2_w1_br u_t013_015/c2_r0_rbl u_t013_015/c2_r1_rbl u_t013_015/c3_w0_bl u_t013_015/c3_w0_br
+ u_t013_015/c3_w1_bl u_t013_015/c3_w1_br u_t013_015/c3_r0_rbl u_t013_015/c3_r1_rbl u_t013_015/r0_w0_wl
+ u_t013_015/r0_w1_wl u_t013_015/r0_r0_rwl u_t013_015/r0_r1_rwl u_t013_015/r1_w0_wl u_t013_015/r1_w1_wl
+ u_t013_015/r1_r0_rwl u_t013_015/r1_r1_rwl u_t013_015/r2_w0_wl u_t013_015/r2_w1_wl u_t013_015/r2_r0_rwl
+ u_t013_015/r2_r1_rwl u_t013_015/r3_w0_wl u_t013_015/r3_w1_wl u_t013_015/r3_r0_rwl u_t013_015/r3_r1_rwl VDD VSS VSUBS
+ detronyx_12t_2w2r_rc4_4x4_routed_5layer_direct
Xu_t013_004 u_t013_004/c0_w0_bl u_t013_004/c0_w0_br u_t013_004/c0_w1_bl u_t013_004/c0_w1_br u_t013_004/c0_r0_rbl
+ u_t013_004/c0_r1_rbl u_t013_004/c1_w0_bl u_t013_004/c1_w0_br u_t013_004/c1_w1_bl u_t013_004/c1_w1_br
+ u_t013_004/c1_r0_rbl u_t013_004/c1_r1_rbl u_t013_004/c2_w0_bl u_t013_004/c2_w0_br u_t013_004/c2_w1_bl
+ u_t013_004/c2_w1_br u_t013_004/c2_r0_rbl u_t013_004/c2_r1_rbl u_t013_004/c3_w0_bl u_t013_004/c3_w0_br
+ u_t013_004/c3_w1_bl u_t013_004/c3_w1_br u_t013_004/c3_r0_rbl u_t013_004/c3_r1_rbl u_t013_004/r0_w0_wl
+ u_t013_004/r0_w1_wl u_t013_004/r0_r0_rwl u_t013_004/r0_r1_rwl u_t013_004/r1_w0_wl u_t013_004/r1_w1_wl
+ u_t013_004/r1_r0_rwl u_t013_004/r1_r1_rwl u_t013_004/r2_w0_wl u_t013_004/r2_w1_wl u_t013_004/r2_r0_rwl
+ u_t013_004/r2_r1_rwl u_t013_004/r3_w0_wl u_t013_004/r3_w1_wl u_t013_004/r3_r0_rwl u_t013_004/r3_r1_rwl VDD VSS VSUBS
+ detronyx_12t_2w2r_rc4_4x4_routed_5layer_direct
Xu_t007_012 u_t007_012/c0_w0_bl u_t007_012/c0_w0_br u_t007_012/c0_w1_bl u_t007_012/c0_w1_br u_t007_012/c0_r0_rbl
+ u_t007_012/c0_r1_rbl u_t007_012/c1_w0_bl u_t007_012/c1_w0_br u_t007_012/c1_w1_bl u_t007_012/c1_w1_br
+ u_t007_012/c1_r0_rbl u_t007_012/c1_r1_rbl u_t007_012/c2_w0_bl u_t007_012/c2_w0_br u_t007_012/c2_w1_bl
+ u_t007_012/c2_w1_br u_t007_012/c2_r0_rbl u_t007_012/c2_r1_rbl u_t007_012/c3_w0_bl u_t007_012/c3_w0_br
+ u_t007_012/c3_w1_bl u_t007_012/c3_w1_br u_t007_012/c3_r0_rbl u_t007_012/c3_r1_rbl u_t007_012/r0_w0_wl
+ u_t007_012/r0_w1_wl u_t007_012/r0_r0_rwl u_t007_012/r0_r1_rwl u_t007_012/r1_w0_wl u_t007_012/r1_w1_wl
+ u_t007_012/r1_r0_rwl u_t007_012/r1_r1_rwl u_t007_012/r2_w0_wl u_t007_012/r2_w1_wl u_t007_012/r2_r0_rwl
+ u_t007_012/r2_r1_rwl u_t007_012/r3_w0_wl u_t007_012/r3_w1_wl u_t007_012/r3_r0_rwl u_t007_012/r3_r1_rwl VDD VSS VSUBS
+ detronyx_12t_2w2r_rc4_4x4_routed_5layer_direct
Xu_t007_001 u_t007_001/c0_w0_bl u_t007_001/c0_w0_br u_t007_001/c0_w1_bl u_t007_001/c0_w1_br u_t007_001/c0_r0_rbl
+ u_t007_001/c0_r1_rbl u_t007_001/c1_w0_bl u_t007_001/c1_w0_br u_t007_001/c1_w1_bl u_t007_001/c1_w1_br
+ u_t007_001/c1_r0_rbl u_t007_001/c1_r1_rbl u_t007_001/c2_w0_bl u_t007_001/c2_w0_br u_t007_001/c2_w1_bl
+ u_t007_001/c2_w1_br u_t007_001/c2_r0_rbl u_t007_001/c2_r1_rbl u_t007_001/c3_w0_bl u_t007_001/c3_w0_br
+ u_t007_001/c3_w1_bl u_t007_001/c3_w1_br u_t007_001/c3_r0_rbl u_t007_001/c3_r1_rbl u_t007_001/r0_w0_wl
+ u_t007_001/r0_w1_wl u_t007_001/r0_r0_rwl u_t007_001/r0_r1_rwl u_t007_001/r1_w0_wl u_t007_001/r1_w1_wl
+ u_t007_001/r1_r0_rwl u_t007_001/r1_r1_rwl u_t007_001/r2_w0_wl u_t007_001/r2_w1_wl u_t007_001/r2_r0_rwl
+ u_t007_001/r2_r1_rwl u_t007_001/r3_w0_wl u_t007_001/r3_w1_wl u_t007_001/r3_r0_rwl u_t007_001/r3_r1_rwl VDD VSS VSUBS
+ detronyx_12t_2w2r_rc4_4x4_routed_5layer_direct
Xu_t004_004 u_t004_004/c0_w0_bl u_t004_004/c0_w0_br u_t004_004/c0_w1_bl u_t004_004/c0_w1_br u_t004_004/c0_r0_rbl
+ u_t004_004/c0_r1_rbl u_t004_004/c1_w0_bl u_t004_004/c1_w0_br u_t004_004/c1_w1_bl u_t004_004/c1_w1_br
+ u_t004_004/c1_r0_rbl u_t004_004/c1_r1_rbl u_t004_004/c2_w0_bl u_t004_004/c2_w0_br u_t004_004/c2_w1_bl
+ u_t004_004/c2_w1_br u_t004_004/c2_r0_rbl u_t004_004/c2_r1_rbl u_t004_004/c3_w0_bl u_t004_004/c3_w0_br
+ u_t004_004/c3_w1_bl u_t004_004/c3_w1_br u_t004_004/c3_r0_rbl u_t004_004/c3_r1_rbl u_t004_004/r0_w0_wl
+ u_t004_004/r0_w1_wl u_t004_004/r0_r0_rwl u_t004_004/r0_r1_rwl u_t004_004/r1_w0_wl u_t004_004/r1_w1_wl
+ u_t004_004/r1_r0_rwl u_t004_004/r1_r1_rwl u_t004_004/r2_w0_wl u_t004_004/r2_w1_wl u_t004_004/r2_r0_rwl
+ u_t004_004/r2_r1_rwl u_t004_004/r3_w0_wl u_t004_004/r3_w1_wl u_t004_004/r3_r0_rwl u_t004_004/r3_r1_rwl VDD VSS VSUBS
+ detronyx_12t_2w2r_rc4_4x4_routed_5layer_direct
Xu_t004_015 u_t004_015/c0_w0_bl u_t004_015/c0_w0_br u_t004_015/c0_w1_bl u_t004_015/c0_w1_br u_t004_015/c0_r0_rbl
+ u_t004_015/c0_r1_rbl u_t004_015/c1_w0_bl u_t004_015/c1_w0_br u_t004_015/c1_w1_bl u_t004_015/c1_w1_br
+ u_t004_015/c1_r0_rbl u_t004_015/c1_r1_rbl u_t004_015/c2_w0_bl u_t004_015/c2_w0_br u_t004_015/c2_w1_bl
+ u_t004_015/c2_w1_br u_t004_015/c2_r0_rbl u_t004_015/c2_r1_rbl u_t004_015/c3_w0_bl u_t004_015/c3_w0_br
+ u_t004_015/c3_w1_bl u_t004_015/c3_w1_br u_t004_015/c3_r0_rbl u_t004_015/c3_r1_rbl u_t004_015/r0_w0_wl
+ u_t004_015/r0_w1_wl u_t004_015/r0_r0_rwl u_t004_015/r0_r1_rwl u_t004_015/r1_w0_wl u_t004_015/r1_w1_wl
+ u_t004_015/r1_r0_rwl u_t004_015/r1_r1_rwl u_t004_015/r2_w0_wl u_t004_015/r2_w1_wl u_t004_015/r2_r0_rwl
+ u_t004_015/r2_r1_rwl u_t004_015/r3_w0_wl u_t004_015/r3_w1_wl u_t004_015/r3_r0_rwl u_t004_015/r3_r1_rwl VDD VSS VSUBS
+ detronyx_12t_2w2r_rc4_4x4_routed_5layer_direct
Xu_t010_007 u_t010_007/c0_w0_bl u_t010_007/c0_w0_br u_t010_007/c0_w1_bl u_t010_007/c0_w1_br u_t010_007/c0_r0_rbl
+ u_t010_007/c0_r1_rbl u_t010_007/c1_w0_bl u_t010_007/c1_w0_br u_t010_007/c1_w1_bl u_t010_007/c1_w1_br
+ u_t010_007/c1_r0_rbl u_t010_007/c1_r1_rbl u_t010_007/c2_w0_bl u_t010_007/c2_w0_br u_t010_007/c2_w1_bl
+ u_t010_007/c2_w1_br u_t010_007/c2_r0_rbl u_t010_007/c2_r1_rbl u_t010_007/c3_w0_bl u_t010_007/c3_w0_br
+ u_t010_007/c3_w1_bl u_t010_007/c3_w1_br u_t010_007/c3_r0_rbl u_t010_007/c3_r1_rbl u_t010_007/r0_w0_wl
+ u_t010_007/r0_w1_wl u_t010_007/r0_r0_rwl u_t010_007/r0_r1_rwl u_t010_007/r1_w0_wl u_t010_007/r1_w1_wl
+ u_t010_007/r1_r0_rwl u_t010_007/r1_r1_rwl u_t010_007/r2_w0_wl u_t010_007/r2_w1_wl u_t010_007/r2_r0_rwl
+ u_t010_007/r2_r1_rwl u_t010_007/r3_w0_wl u_t010_007/r3_w1_wl u_t010_007/r3_r0_rwl u_t010_007/r3_r1_rwl VDD VSS VSUBS
+ detronyx_12t_2w2r_rc4_4x4_routed_5layer_direct
Xu_t001_007 u_t001_007/c0_w0_bl u_t001_007/c0_w0_br u_t001_007/c0_w1_bl u_t001_007/c0_w1_br u_t001_007/c0_r0_rbl
+ u_t001_007/c0_r1_rbl u_t001_007/c1_w0_bl u_t001_007/c1_w0_br u_t001_007/c1_w1_bl u_t001_007/c1_w1_br
+ u_t001_007/c1_r0_rbl u_t001_007/c1_r1_rbl u_t001_007/c2_w0_bl u_t001_007/c2_w0_br u_t001_007/c2_w1_bl
+ u_t001_007/c2_w1_br u_t001_007/c2_r0_rbl u_t001_007/c2_r1_rbl u_t001_007/c3_w0_bl u_t001_007/c3_w0_br
+ u_t001_007/c3_w1_bl u_t001_007/c3_w1_br u_t001_007/c3_r0_rbl u_t001_007/c3_r1_rbl u_t001_007/r0_w0_wl
+ u_t001_007/r0_w1_wl u_t001_007/r0_r0_rwl u_t001_007/r0_r1_rwl u_t001_007/r1_w0_wl u_t001_007/r1_w1_wl
+ u_t001_007/r1_r0_rwl u_t001_007/r1_r1_rwl u_t001_007/r2_w0_wl u_t001_007/r2_w1_wl u_t001_007/r2_r0_rwl
+ u_t001_007/r2_r1_rwl u_t001_007/r3_w0_wl u_t001_007/r3_w1_wl u_t001_007/r3_r0_rwl u_t001_007/r3_r1_rwl VDD VSS VSUBS
+ detronyx_12t_2w2r_rc4_4x4_routed_5layer_direct
Xu_t007_013 u_t007_013/c0_w0_bl u_t007_013/c0_w0_br u_t007_013/c0_w1_bl u_t007_013/c0_w1_br u_t007_013/c0_r0_rbl
+ u_t007_013/c0_r1_rbl u_t007_013/c1_w0_bl u_t007_013/c1_w0_br u_t007_013/c1_w1_bl u_t007_013/c1_w1_br
+ u_t007_013/c1_r0_rbl u_t007_013/c1_r1_rbl u_t007_013/c2_w0_bl u_t007_013/c2_w0_br u_t007_013/c2_w1_bl
+ u_t007_013/c2_w1_br u_t007_013/c2_r0_rbl u_t007_013/c2_r1_rbl u_t007_013/c3_w0_bl u_t007_013/c3_w0_br
+ u_t007_013/c3_w1_bl u_t007_013/c3_w1_br u_t007_013/c3_r0_rbl u_t007_013/c3_r1_rbl u_t007_013/r0_w0_wl
+ u_t007_013/r0_w1_wl u_t007_013/r0_r0_rwl u_t007_013/r0_r1_rwl u_t007_013/r1_w0_wl u_t007_013/r1_w1_wl
+ u_t007_013/r1_r0_rwl u_t007_013/r1_r1_rwl u_t007_013/r2_w0_wl u_t007_013/r2_w1_wl u_t007_013/r2_r0_rwl
+ u_t007_013/r2_r1_rwl u_t007_013/r3_w0_wl u_t007_013/r3_w1_wl u_t007_013/r3_r0_rwl u_t007_013/r3_r1_rwl VDD VSS VSUBS
+ detronyx_12t_2w2r_rc4_4x4_routed_5layer_direct
Xu_t007_002 u_t007_002/c0_w0_bl u_t007_002/c0_w0_br u_t007_002/c0_w1_bl u_t007_002/c0_w1_br u_t007_002/c0_r0_rbl
+ u_t007_002/c0_r1_rbl u_t007_002/c1_w0_bl u_t007_002/c1_w0_br u_t007_002/c1_w1_bl u_t007_002/c1_w1_br
+ u_t007_002/c1_r0_rbl u_t007_002/c1_r1_rbl u_t007_002/c2_w0_bl u_t007_002/c2_w0_br u_t007_002/c2_w1_bl
+ u_t007_002/c2_w1_br u_t007_002/c2_r0_rbl u_t007_002/c2_r1_rbl u_t007_002/c3_w0_bl u_t007_002/c3_w0_br
+ u_t007_002/c3_w1_bl u_t007_002/c3_w1_br u_t007_002/c3_r0_rbl u_t007_002/c3_r1_rbl u_t007_002/r0_w0_wl
+ u_t007_002/r0_w1_wl u_t007_002/r0_r0_rwl u_t007_002/r0_r1_rwl u_t007_002/r1_w0_wl u_t007_002/r1_w1_wl
+ u_t007_002/r1_r0_rwl u_t007_002/r1_r1_rwl u_t007_002/r2_w0_wl u_t007_002/r2_w1_wl u_t007_002/r2_r0_rwl
+ u_t007_002/r2_r1_rwl u_t007_002/r3_w0_wl u_t007_002/r3_w1_wl u_t007_002/r3_r0_rwl u_t007_002/r3_r1_rwl VDD VSS VSUBS
+ detronyx_12t_2w2r_rc4_4x4_routed_5layer_direct
Xu_t013_005 u_t013_005/c0_w0_bl u_t013_005/c0_w0_br u_t013_005/c0_w1_bl u_t013_005/c0_w1_br u_t013_005/c0_r0_rbl
+ u_t013_005/c0_r1_rbl u_t013_005/c1_w0_bl u_t013_005/c1_w0_br u_t013_005/c1_w1_bl u_t013_005/c1_w1_br
+ u_t013_005/c1_r0_rbl u_t013_005/c1_r1_rbl u_t013_005/c2_w0_bl u_t013_005/c2_w0_br u_t013_005/c2_w1_bl
+ u_t013_005/c2_w1_br u_t013_005/c2_r0_rbl u_t013_005/c2_r1_rbl u_t013_005/c3_w0_bl u_t013_005/c3_w0_br
+ u_t013_005/c3_w1_bl u_t013_005/c3_w1_br u_t013_005/c3_r0_rbl u_t013_005/c3_r1_rbl u_t013_005/r0_w0_wl
+ u_t013_005/r0_w1_wl u_t013_005/r0_r0_rwl u_t013_005/r0_r1_rwl u_t013_005/r1_w0_wl u_t013_005/r1_w1_wl
+ u_t013_005/r1_r0_rwl u_t013_005/r1_r1_rwl u_t013_005/r2_w0_wl u_t013_005/r2_w1_wl u_t013_005/r2_r0_rwl
+ u_t013_005/r2_r1_rwl u_t013_005/r3_w0_wl u_t013_005/r3_w1_wl u_t013_005/r3_r0_rwl u_t013_005/r3_r1_rwl VDD VSS VSUBS
+ detronyx_12t_2w2r_rc4_4x4_routed_5layer_direct
Xu_t010_008 u_t010_008/c0_w0_bl u_t010_008/c0_w0_br u_t010_008/c0_w1_bl u_t010_008/c0_w1_br u_t010_008/c0_r0_rbl
+ u_t010_008/c0_r1_rbl u_t010_008/c1_w0_bl u_t010_008/c1_w0_br u_t010_008/c1_w1_bl u_t010_008/c1_w1_br
+ u_t010_008/c1_r0_rbl u_t010_008/c1_r1_rbl u_t010_008/c2_w0_bl u_t010_008/c2_w0_br u_t010_008/c2_w1_bl
+ u_t010_008/c2_w1_br u_t010_008/c2_r0_rbl u_t010_008/c2_r1_rbl u_t010_008/c3_w0_bl u_t010_008/c3_w0_br
+ u_t010_008/c3_w1_bl u_t010_008/c3_w1_br u_t010_008/c3_r0_rbl u_t010_008/c3_r1_rbl u_t010_008/r0_w0_wl
+ u_t010_008/r0_w1_wl u_t010_008/r0_r0_rwl u_t010_008/r0_r1_rwl u_t010_008/r1_w0_wl u_t010_008/r1_w1_wl
+ u_t010_008/r1_r0_rwl u_t010_008/r1_r1_rwl u_t010_008/r2_w0_wl u_t010_008/r2_w1_wl u_t010_008/r2_r0_rwl
+ u_t010_008/r2_r1_rwl u_t010_008/r3_w0_wl u_t010_008/r3_w1_wl u_t010_008/r3_r0_rwl u_t010_008/r3_r1_rwl VDD VSS VSUBS
+ detronyx_12t_2w2r_rc4_4x4_routed_5layer_direct
Xu_t001_008 u_t001_008/c0_w0_bl u_t001_008/c0_w0_br u_t001_008/c0_w1_bl u_t001_008/c0_w1_br u_t001_008/c0_r0_rbl
+ u_t001_008/c0_r1_rbl u_t001_008/c1_w0_bl u_t001_008/c1_w0_br u_t001_008/c1_w1_bl u_t001_008/c1_w1_br
+ u_t001_008/c1_r0_rbl u_t001_008/c1_r1_rbl u_t001_008/c2_w0_bl u_t001_008/c2_w0_br u_t001_008/c2_w1_bl
+ u_t001_008/c2_w1_br u_t001_008/c2_r0_rbl u_t001_008/c2_r1_rbl u_t001_008/c3_w0_bl u_t001_008/c3_w0_br
+ u_t001_008/c3_w1_bl u_t001_008/c3_w1_br u_t001_008/c3_r0_rbl u_t001_008/c3_r1_rbl u_t001_008/r0_w0_wl
+ u_t001_008/r0_w1_wl u_t001_008/r0_r0_rwl u_t001_008/r0_r1_rwl u_t001_008/r1_w0_wl u_t001_008/r1_w1_wl
+ u_t001_008/r1_r0_rwl u_t001_008/r1_r1_rwl u_t001_008/r2_w0_wl u_t001_008/r2_w1_wl u_t001_008/r2_r0_rwl
+ u_t001_008/r2_r1_rwl u_t001_008/r3_w0_wl u_t001_008/r3_w1_wl u_t001_008/r3_r0_rwl u_t001_008/r3_r1_rwl VDD VSS VSUBS
+ detronyx_12t_2w2r_rc4_4x4_routed_5layer_direct
Xu_t004_005 u_t004_005/c0_w0_bl u_t004_005/c0_w0_br u_t004_005/c0_w1_bl u_t004_005/c0_w1_br u_t004_005/c0_r0_rbl
+ u_t004_005/c0_r1_rbl u_t004_005/c1_w0_bl u_t004_005/c1_w0_br u_t004_005/c1_w1_bl u_t004_005/c1_w1_br
+ u_t004_005/c1_r0_rbl u_t004_005/c1_r1_rbl u_t004_005/c2_w0_bl u_t004_005/c2_w0_br u_t004_005/c2_w1_bl
+ u_t004_005/c2_w1_br u_t004_005/c2_r0_rbl u_t004_005/c2_r1_rbl u_t004_005/c3_w0_bl u_t004_005/c3_w0_br
+ u_t004_005/c3_w1_bl u_t004_005/c3_w1_br u_t004_005/c3_r0_rbl u_t004_005/c3_r1_rbl u_t004_005/r0_w0_wl
+ u_t004_005/r0_w1_wl u_t004_005/r0_r0_rwl u_t004_005/r0_r1_rwl u_t004_005/r1_w0_wl u_t004_005/r1_w1_wl
+ u_t004_005/r1_r0_rwl u_t004_005/r1_r1_rwl u_t004_005/r2_w0_wl u_t004_005/r2_w1_wl u_t004_005/r2_r0_rwl
+ u_t004_005/r2_r1_rwl u_t004_005/r3_w0_wl u_t004_005/r3_w1_wl u_t004_005/r3_r0_rwl u_t004_005/r3_r1_rwl VDD VSS VSUBS
+ detronyx_12t_2w2r_rc4_4x4_routed_5layer_direct
Xu_t013_006 u_t013_006/c0_w0_bl u_t013_006/c0_w0_br u_t013_006/c0_w1_bl u_t013_006/c0_w1_br u_t013_006/c0_r0_rbl
+ u_t013_006/c0_r1_rbl u_t013_006/c1_w0_bl u_t013_006/c1_w0_br u_t013_006/c1_w1_bl u_t013_006/c1_w1_br
+ u_t013_006/c1_r0_rbl u_t013_006/c1_r1_rbl u_t013_006/c2_w0_bl u_t013_006/c2_w0_br u_t013_006/c2_w1_bl
+ u_t013_006/c2_w1_br u_t013_006/c2_r0_rbl u_t013_006/c2_r1_rbl u_t013_006/c3_w0_bl u_t013_006/c3_w0_br
+ u_t013_006/c3_w1_bl u_t013_006/c3_w1_br u_t013_006/c3_r0_rbl u_t013_006/c3_r1_rbl u_t013_006/r0_w0_wl
+ u_t013_006/r0_w1_wl u_t013_006/r0_r0_rwl u_t013_006/r0_r1_rwl u_t013_006/r1_w0_wl u_t013_006/r1_w1_wl
+ u_t013_006/r1_r0_rwl u_t013_006/r1_r1_rwl u_t013_006/r2_w0_wl u_t013_006/r2_w1_wl u_t013_006/r2_r0_rwl
+ u_t013_006/r2_r1_rwl u_t013_006/r3_w0_wl u_t013_006/r3_w1_wl u_t013_006/r3_r0_rwl u_t013_006/r3_r1_rwl VDD VSS VSUBS
+ detronyx_12t_2w2r_rc4_4x4_routed_5layer_direct
Xu_t007_014 u_t007_014/c0_w0_bl u_t007_014/c0_w0_br u_t007_014/c0_w1_bl u_t007_014/c0_w1_br u_t007_014/c0_r0_rbl
+ u_t007_014/c0_r1_rbl u_t007_014/c1_w0_bl u_t007_014/c1_w0_br u_t007_014/c1_w1_bl u_t007_014/c1_w1_br
+ u_t007_014/c1_r0_rbl u_t007_014/c1_r1_rbl u_t007_014/c2_w0_bl u_t007_014/c2_w0_br u_t007_014/c2_w1_bl
+ u_t007_014/c2_w1_br u_t007_014/c2_r0_rbl u_t007_014/c2_r1_rbl u_t007_014/c3_w0_bl u_t007_014/c3_w0_br
+ u_t007_014/c3_w1_bl u_t007_014/c3_w1_br u_t007_014/c3_r0_rbl u_t007_014/c3_r1_rbl u_t007_014/r0_w0_wl
+ u_t007_014/r0_w1_wl u_t007_014/r0_r0_rwl u_t007_014/r0_r1_rwl u_t007_014/r1_w0_wl u_t007_014/r1_w1_wl
+ u_t007_014/r1_r0_rwl u_t007_014/r1_r1_rwl u_t007_014/r2_w0_wl u_t007_014/r2_w1_wl u_t007_014/r2_r0_rwl
+ u_t007_014/r2_r1_rwl u_t007_014/r3_w0_wl u_t007_014/r3_w1_wl u_t007_014/r3_r0_rwl u_t007_014/r3_r1_rwl VDD VSS VSUBS
+ detronyx_12t_2w2r_rc4_4x4_routed_5layer_direct
Xu_t007_003 u_t007_003/c0_w0_bl u_t007_003/c0_w0_br u_t007_003/c0_w1_bl u_t007_003/c0_w1_br u_t007_003/c0_r0_rbl
+ u_t007_003/c0_r1_rbl u_t007_003/c1_w0_bl u_t007_003/c1_w0_br u_t007_003/c1_w1_bl u_t007_003/c1_w1_br
+ u_t007_003/c1_r0_rbl u_t007_003/c1_r1_rbl u_t007_003/c2_w0_bl u_t007_003/c2_w0_br u_t007_003/c2_w1_bl
+ u_t007_003/c2_w1_br u_t007_003/c2_r0_rbl u_t007_003/c2_r1_rbl u_t007_003/c3_w0_bl u_t007_003/c3_w0_br
+ u_t007_003/c3_w1_bl u_t007_003/c3_w1_br u_t007_003/c3_r0_rbl u_t007_003/c3_r1_rbl u_t007_003/r0_w0_wl
+ u_t007_003/r0_w1_wl u_t007_003/r0_r0_rwl u_t007_003/r0_r1_rwl u_t007_003/r1_w0_wl u_t007_003/r1_w1_wl
+ u_t007_003/r1_r0_rwl u_t007_003/r1_r1_rwl u_t007_003/r2_w0_wl u_t007_003/r2_w1_wl u_t007_003/r2_r0_rwl
+ u_t007_003/r2_r1_rwl u_t007_003/r3_w0_wl u_t007_003/r3_w1_wl u_t007_003/r3_r0_rwl u_t007_003/r3_r1_rwl VDD VSS VSUBS
+ detronyx_12t_2w2r_rc4_4x4_routed_5layer_direct
Xu_t004_006 u_t004_006/c0_w0_bl u_t004_006/c0_w0_br u_t004_006/c0_w1_bl u_t004_006/c0_w1_br u_t004_006/c0_r0_rbl
+ u_t004_006/c0_r1_rbl u_t004_006/c1_w0_bl u_t004_006/c1_w0_br u_t004_006/c1_w1_bl u_t004_006/c1_w1_br
+ u_t004_006/c1_r0_rbl u_t004_006/c1_r1_rbl u_t004_006/c2_w0_bl u_t004_006/c2_w0_br u_t004_006/c2_w1_bl
+ u_t004_006/c2_w1_br u_t004_006/c2_r0_rbl u_t004_006/c2_r1_rbl u_t004_006/c3_w0_bl u_t004_006/c3_w0_br
+ u_t004_006/c3_w1_bl u_t004_006/c3_w1_br u_t004_006/c3_r0_rbl u_t004_006/c3_r1_rbl u_t004_006/r0_w0_wl
+ u_t004_006/r0_w1_wl u_t004_006/r0_r0_rwl u_t004_006/r0_r1_rwl u_t004_006/r1_w0_wl u_t004_006/r1_w1_wl
+ u_t004_006/r1_r0_rwl u_t004_006/r1_r1_rwl u_t004_006/r2_w0_wl u_t004_006/r2_w1_wl u_t004_006/r2_r0_rwl
+ u_t004_006/r2_r1_rwl u_t004_006/r3_w0_wl u_t004_006/r3_w1_wl u_t004_006/r3_r0_rwl u_t004_006/r3_r1_rwl VDD VSS VSUBS
+ detronyx_12t_2w2r_rc4_4x4_routed_5layer_direct
Xu_t010_009 u_t010_009/c0_w0_bl u_t010_009/c0_w0_br u_t010_009/c0_w1_bl u_t010_009/c0_w1_br u_t010_009/c0_r0_rbl
+ u_t010_009/c0_r1_rbl u_t010_009/c1_w0_bl u_t010_009/c1_w0_br u_t010_009/c1_w1_bl u_t010_009/c1_w1_br
+ u_t010_009/c1_r0_rbl u_t010_009/c1_r1_rbl u_t010_009/c2_w0_bl u_t010_009/c2_w0_br u_t010_009/c2_w1_bl
+ u_t010_009/c2_w1_br u_t010_009/c2_r0_rbl u_t010_009/c2_r1_rbl u_t010_009/c3_w0_bl u_t010_009/c3_w0_br
+ u_t010_009/c3_w1_bl u_t010_009/c3_w1_br u_t010_009/c3_r0_rbl u_t010_009/c3_r1_rbl u_t010_009/r0_w0_wl
+ u_t010_009/r0_w1_wl u_t010_009/r0_r0_rwl u_t010_009/r0_r1_rwl u_t010_009/r1_w0_wl u_t010_009/r1_w1_wl
+ u_t010_009/r1_r0_rwl u_t010_009/r1_r1_rwl u_t010_009/r2_w0_wl u_t010_009/r2_w1_wl u_t010_009/r2_r0_rwl
+ u_t010_009/r2_r1_rwl u_t010_009/r3_w0_wl u_t010_009/r3_w1_wl u_t010_009/r3_r0_rwl u_t010_009/r3_r1_rwl VDD VSS VSUBS
+ detronyx_12t_2w2r_rc4_4x4_routed_5layer_direct
Xu_t001_009 u_t001_009/c0_w0_bl u_t001_009/c0_w0_br u_t001_009/c0_w1_bl u_t001_009/c0_w1_br u_t001_009/c0_r0_rbl
+ u_t001_009/c0_r1_rbl u_t001_009/c1_w0_bl u_t001_009/c1_w0_br u_t001_009/c1_w1_bl u_t001_009/c1_w1_br
+ u_t001_009/c1_r0_rbl u_t001_009/c1_r1_rbl u_t001_009/c2_w0_bl u_t001_009/c2_w0_br u_t001_009/c2_w1_bl
+ u_t001_009/c2_w1_br u_t001_009/c2_r0_rbl u_t001_009/c2_r1_rbl u_t001_009/c3_w0_bl u_t001_009/c3_w0_br
+ u_t001_009/c3_w1_bl u_t001_009/c3_w1_br u_t001_009/c3_r0_rbl u_t001_009/c3_r1_rbl u_t001_009/r0_w0_wl
+ u_t001_009/r0_w1_wl u_t001_009/r0_r0_rwl u_t001_009/r0_r1_rwl u_t001_009/r1_w0_wl u_t001_009/r1_w1_wl
+ u_t001_009/r1_r0_rwl u_t001_009/r1_r1_rwl u_t001_009/r2_w0_wl u_t001_009/r2_w1_wl u_t001_009/r2_r0_rwl
+ u_t001_009/r2_r1_rwl u_t001_009/r3_w0_wl u_t001_009/r3_w1_wl u_t001_009/r3_r0_rwl u_t001_009/r3_r1_rwl VDD VSS VSUBS
+ detronyx_12t_2w2r_rc4_4x4_routed_5layer_direct
Xu_t013_007 u_t013_007/c0_w0_bl u_t013_007/c0_w0_br u_t013_007/c0_w1_bl u_t013_007/c0_w1_br u_t013_007/c0_r0_rbl
+ u_t013_007/c0_r1_rbl u_t013_007/c1_w0_bl u_t013_007/c1_w0_br u_t013_007/c1_w1_bl u_t013_007/c1_w1_br
+ u_t013_007/c1_r0_rbl u_t013_007/c1_r1_rbl u_t013_007/c2_w0_bl u_t013_007/c2_w0_br u_t013_007/c2_w1_bl
+ u_t013_007/c2_w1_br u_t013_007/c2_r0_rbl u_t013_007/c2_r1_rbl u_t013_007/c3_w0_bl u_t013_007/c3_w0_br
+ u_t013_007/c3_w1_bl u_t013_007/c3_w1_br u_t013_007/c3_r0_rbl u_t013_007/c3_r1_rbl u_t013_007/r0_w0_wl
+ u_t013_007/r0_w1_wl u_t013_007/r0_r0_rwl u_t013_007/r0_r1_rwl u_t013_007/r1_w0_wl u_t013_007/r1_w1_wl
+ u_t013_007/r1_r0_rwl u_t013_007/r1_r1_rwl u_t013_007/r2_w0_wl u_t013_007/r2_w1_wl u_t013_007/r2_r0_rwl
+ u_t013_007/r2_r1_rwl u_t013_007/r3_w0_wl u_t013_007/r3_w1_wl u_t013_007/r3_r0_rwl u_t013_007/r3_r1_rwl VDD VSS VSUBS
+ detronyx_12t_2w2r_rc4_4x4_routed_5layer_direct
Xu_t007_015 u_t007_015/c0_w0_bl u_t007_015/c0_w0_br u_t007_015/c0_w1_bl u_t007_015/c0_w1_br u_t007_015/c0_r0_rbl
+ u_t007_015/c0_r1_rbl u_t007_015/c1_w0_bl u_t007_015/c1_w0_br u_t007_015/c1_w1_bl u_t007_015/c1_w1_br
+ u_t007_015/c1_r0_rbl u_t007_015/c1_r1_rbl u_t007_015/c2_w0_bl u_t007_015/c2_w0_br u_t007_015/c2_w1_bl
+ u_t007_015/c2_w1_br u_t007_015/c2_r0_rbl u_t007_015/c2_r1_rbl u_t007_015/c3_w0_bl u_t007_015/c3_w0_br
+ u_t007_015/c3_w1_bl u_t007_015/c3_w1_br u_t007_015/c3_r0_rbl u_t007_015/c3_r1_rbl u_t007_015/r0_w0_wl
+ u_t007_015/r0_w1_wl u_t007_015/r0_r0_rwl u_t007_015/r0_r1_rwl u_t007_015/r1_w0_wl u_t007_015/r1_w1_wl
+ u_t007_015/r1_r0_rwl u_t007_015/r1_r1_rwl u_t007_015/r2_w0_wl u_t007_015/r2_w1_wl u_t007_015/r2_r0_rwl
+ u_t007_015/r2_r1_rwl u_t007_015/r3_w0_wl u_t007_015/r3_w1_wl u_t007_015/r3_r0_rwl u_t007_015/r3_r1_rwl VDD VSS VSUBS
+ detronyx_12t_2w2r_rc4_4x4_routed_5layer_direct
Xu_t007_004 u_t007_004/c0_w0_bl u_t007_004/c0_w0_br u_t007_004/c0_w1_bl u_t007_004/c0_w1_br u_t007_004/c0_r0_rbl
+ u_t007_004/c0_r1_rbl u_t007_004/c1_w0_bl u_t007_004/c1_w0_br u_t007_004/c1_w1_bl u_t007_004/c1_w1_br
+ u_t007_004/c1_r0_rbl u_t007_004/c1_r1_rbl u_t007_004/c2_w0_bl u_t007_004/c2_w0_br u_t007_004/c2_w1_bl
+ u_t007_004/c2_w1_br u_t007_004/c2_r0_rbl u_t007_004/c2_r1_rbl u_t007_004/c3_w0_bl u_t007_004/c3_w0_br
+ u_t007_004/c3_w1_bl u_t007_004/c3_w1_br u_t007_004/c3_r0_rbl u_t007_004/c3_r1_rbl u_t007_004/r0_w0_wl
+ u_t007_004/r0_w1_wl u_t007_004/r0_r0_rwl u_t007_004/r0_r1_rwl u_t007_004/r1_w0_wl u_t007_004/r1_w1_wl
+ u_t007_004/r1_r0_rwl u_t007_004/r1_r1_rwl u_t007_004/r2_w0_wl u_t007_004/r2_w1_wl u_t007_004/r2_r0_rwl
+ u_t007_004/r2_r1_rwl u_t007_004/r3_w0_wl u_t007_004/r3_w1_wl u_t007_004/r3_r0_rwl u_t007_004/r3_r1_rwl VDD VSS VSUBS
+ detronyx_12t_2w2r_rc4_4x4_routed_5layer_direct
Xu_t004_007 u_t004_007/c0_w0_bl u_t004_007/c0_w0_br u_t004_007/c0_w1_bl u_t004_007/c0_w1_br u_t004_007/c0_r0_rbl
+ u_t004_007/c0_r1_rbl u_t004_007/c1_w0_bl u_t004_007/c1_w0_br u_t004_007/c1_w1_bl u_t004_007/c1_w1_br
+ u_t004_007/c1_r0_rbl u_t004_007/c1_r1_rbl u_t004_007/c2_w0_bl u_t004_007/c2_w0_br u_t004_007/c2_w1_bl
+ u_t004_007/c2_w1_br u_t004_007/c2_r0_rbl u_t004_007/c2_r1_rbl u_t004_007/c3_w0_bl u_t004_007/c3_w0_br
+ u_t004_007/c3_w1_bl u_t004_007/c3_w1_br u_t004_007/c3_r0_rbl u_t004_007/c3_r1_rbl u_t004_007/r0_w0_wl
+ u_t004_007/r0_w1_wl u_t004_007/r0_r0_rwl u_t004_007/r0_r1_rwl u_t004_007/r1_w0_wl u_t004_007/r1_w1_wl
+ u_t004_007/r1_r0_rwl u_t004_007/r1_r1_rwl u_t004_007/r2_w0_wl u_t004_007/r2_w1_wl u_t004_007/r2_r0_rwl
+ u_t004_007/r2_r1_rwl u_t004_007/r3_w0_wl u_t004_007/r3_w1_wl u_t004_007/r3_r0_rwl u_t004_007/r3_r1_rwl VDD VSS VSUBS
+ detronyx_12t_2w2r_rc4_4x4_routed_5layer_direct
Xu_t000_010 u_t000_010/c0_w0_bl u_t000_010/c0_w0_br u_t000_010/c0_w1_bl u_t000_010/c0_w1_br u_t000_010/c0_r0_rbl
+ u_t000_010/c0_r1_rbl u_t000_010/c1_w0_bl u_t000_010/c1_w0_br u_t000_010/c1_w1_bl u_t000_010/c1_w1_br
+ u_t000_010/c1_r0_rbl u_t000_010/c1_r1_rbl u_t000_010/c2_w0_bl u_t000_010/c2_w0_br u_t000_010/c2_w1_bl
+ u_t000_010/c2_w1_br u_t000_010/c2_r0_rbl u_t000_010/c2_r1_rbl u_t000_010/c3_w0_bl u_t000_010/c3_w0_br
+ u_t000_010/c3_w1_bl u_t000_010/c3_w1_br u_t000_010/c3_r0_rbl u_t000_010/c3_r1_rbl u_t000_010/r0_w0_wl
+ u_t000_010/r0_w1_wl u_t000_010/r0_r0_rwl u_t000_010/r0_r1_rwl u_t000_010/r1_w0_wl u_t000_010/r1_w1_wl
+ u_t000_010/r1_r0_rwl u_t000_010/r1_r1_rwl u_t000_010/r2_w0_wl u_t000_010/r2_w1_wl u_t000_010/r2_r0_rwl
+ u_t000_010/r2_r1_rwl u_t000_010/r3_w0_wl u_t000_010/r3_w1_wl u_t000_010/r3_r0_rwl u_t000_010/r3_r1_rwl VDD VSS VSUBS
+ detronyx_12t_2w2r_rc4_4x4_routed_5layer_direct
Xu_t013_008 u_t013_008/c0_w0_bl u_t013_008/c0_w0_br u_t013_008/c0_w1_bl u_t013_008/c0_w1_br u_t013_008/c0_r0_rbl
+ u_t013_008/c0_r1_rbl u_t013_008/c1_w0_bl u_t013_008/c1_w0_br u_t013_008/c1_w1_bl u_t013_008/c1_w1_br
+ u_t013_008/c1_r0_rbl u_t013_008/c1_r1_rbl u_t013_008/c2_w0_bl u_t013_008/c2_w0_br u_t013_008/c2_w1_bl
+ u_t013_008/c2_w1_br u_t013_008/c2_r0_rbl u_t013_008/c2_r1_rbl u_t013_008/c3_w0_bl u_t013_008/c3_w0_br
+ u_t013_008/c3_w1_bl u_t013_008/c3_w1_br u_t013_008/c3_r0_rbl u_t013_008/c3_r1_rbl u_t013_008/r0_w0_wl
+ u_t013_008/r0_w1_wl u_t013_008/r0_r0_rwl u_t013_008/r0_r1_rwl u_t013_008/r1_w0_wl u_t013_008/r1_w1_wl
+ u_t013_008/r1_r0_rwl u_t013_008/r1_r1_rwl u_t013_008/r2_w0_wl u_t013_008/r2_w1_wl u_t013_008/r2_r0_rwl
+ u_t013_008/r2_r1_rwl u_t013_008/r3_w0_wl u_t013_008/r3_w1_wl u_t013_008/r3_r0_rwl u_t013_008/r3_r1_rwl VDD VSS VSUBS
+ detronyx_12t_2w2r_rc4_4x4_routed_5layer_direct
Xu_t007_005 u_t007_005/c0_w0_bl u_t007_005/c0_w0_br u_t007_005/c0_w1_bl u_t007_005/c0_w1_br u_t007_005/c0_r0_rbl
+ u_t007_005/c0_r1_rbl u_t007_005/c1_w0_bl u_t007_005/c1_w0_br u_t007_005/c1_w1_bl u_t007_005/c1_w1_br
+ u_t007_005/c1_r0_rbl u_t007_005/c1_r1_rbl u_t007_005/c2_w0_bl u_t007_005/c2_w0_br u_t007_005/c2_w1_bl
+ u_t007_005/c2_w1_br u_t007_005/c2_r0_rbl u_t007_005/c2_r1_rbl u_t007_005/c3_w0_bl u_t007_005/c3_w0_br
+ u_t007_005/c3_w1_bl u_t007_005/c3_w1_br u_t007_005/c3_r0_rbl u_t007_005/c3_r1_rbl u_t007_005/r0_w0_wl
+ u_t007_005/r0_w1_wl u_t007_005/r0_r0_rwl u_t007_005/r0_r1_rwl u_t007_005/r1_w0_wl u_t007_005/r1_w1_wl
+ u_t007_005/r1_r0_rwl u_t007_005/r1_r1_rwl u_t007_005/r2_w0_wl u_t007_005/r2_w1_wl u_t007_005/r2_r0_rwl
+ u_t007_005/r2_r1_rwl u_t007_005/r3_w0_wl u_t007_005/r3_w1_wl u_t007_005/r3_r0_rwl u_t007_005/r3_r1_rwl VDD VSS VSUBS
+ detronyx_12t_2w2r_rc4_4x4_routed_5layer_direct
Xu_t000_000 u_t000_000/c0_w0_bl u_t000_000/c0_w0_br u_t000_000/c0_w1_bl u_t000_000/c0_w1_br u_t000_000/c0_r0_rbl
+ u_t000_000/c0_r1_rbl u_t000_000/c1_w0_bl u_t000_000/c1_w0_br u_t000_000/c1_w1_bl u_t000_000/c1_w1_br
+ u_t000_000/c1_r0_rbl u_t000_000/c1_r1_rbl u_t000_000/c2_w0_bl u_t000_000/c2_w0_br u_t000_000/c2_w1_bl
+ u_t000_000/c2_w1_br u_t000_000/c2_r0_rbl u_t000_000/c2_r1_rbl u_t000_000/c3_w0_bl u_t000_000/c3_w0_br
+ u_t000_000/c3_w1_bl u_t000_000/c3_w1_br u_t000_000/c3_r0_rbl u_t000_000/c3_r1_rbl u_t000_000/r0_w0_wl
+ u_t000_000/r0_w1_wl u_t000_000/r0_r0_rwl u_t000_000/r0_r1_rwl u_t000_000/r1_w0_wl u_t000_000/r1_w1_wl
+ u_t000_000/r1_r0_rwl u_t000_000/r1_r1_rwl u_t000_000/r2_w0_wl u_t000_000/r2_w1_wl u_t000_000/r2_r0_rwl
+ u_t000_000/r2_r1_rwl u_t000_000/r3_w0_wl u_t000_000/r3_w1_wl u_t000_000/r3_r0_rwl u_t000_000/r3_r1_rwl VDD VSS VSUBS
+ detronyx_12t_2w2r_rc4_4x4_routed_5layer_direct
Xu_t000_011 u_t000_011/c0_w0_bl u_t000_011/c0_w0_br u_t000_011/c0_w1_bl u_t000_011/c0_w1_br u_t000_011/c0_r0_rbl
+ u_t000_011/c0_r1_rbl u_t000_011/c1_w0_bl u_t000_011/c1_w0_br u_t000_011/c1_w1_bl u_t000_011/c1_w1_br
+ u_t000_011/c1_r0_rbl u_t000_011/c1_r1_rbl u_t000_011/c2_w0_bl u_t000_011/c2_w0_br u_t000_011/c2_w1_bl
+ u_t000_011/c2_w1_br u_t000_011/c2_r0_rbl u_t000_011/c2_r1_rbl u_t000_011/c3_w0_bl u_t000_011/c3_w0_br
+ u_t000_011/c3_w1_bl u_t000_011/c3_w1_br u_t000_011/c3_r0_rbl u_t000_011/c3_r1_rbl u_t000_011/r0_w0_wl
+ u_t000_011/r0_w1_wl u_t000_011/r0_r0_rwl u_t000_011/r0_r1_rwl u_t000_011/r1_w0_wl u_t000_011/r1_w1_wl
+ u_t000_011/r1_r0_rwl u_t000_011/r1_r1_rwl u_t000_011/r2_w0_wl u_t000_011/r2_w1_wl u_t000_011/r2_r0_rwl
+ u_t000_011/r2_r1_rwl u_t000_011/r3_w0_wl u_t000_011/r3_w1_wl u_t000_011/r3_r0_rwl u_t000_011/r3_r1_rwl VDD VSS VSUBS
+ detronyx_12t_2w2r_rc4_4x4_routed_5layer_direct
Xu_t004_008 u_t004_008/c0_w0_bl u_t004_008/c0_w0_br u_t004_008/c0_w1_bl u_t004_008/c0_w1_br u_t004_008/c0_r0_rbl
+ u_t004_008/c0_r1_rbl u_t004_008/c1_w0_bl u_t004_008/c1_w0_br u_t004_008/c1_w1_bl u_t004_008/c1_w1_br
+ u_t004_008/c1_r0_rbl u_t004_008/c1_r1_rbl u_t004_008/c2_w0_bl u_t004_008/c2_w0_br u_t004_008/c2_w1_bl
+ u_t004_008/c2_w1_br u_t004_008/c2_r0_rbl u_t004_008/c2_r1_rbl u_t004_008/c3_w0_bl u_t004_008/c3_w0_br
+ u_t004_008/c3_w1_bl u_t004_008/c3_w1_br u_t004_008/c3_r0_rbl u_t004_008/c3_r1_rbl u_t004_008/r0_w0_wl
+ u_t004_008/r0_w1_wl u_t004_008/r0_r0_rwl u_t004_008/r0_r1_rwl u_t004_008/r1_w0_wl u_t004_008/r1_w1_wl
+ u_t004_008/r1_r0_rwl u_t004_008/r1_r1_rwl u_t004_008/r2_w0_wl u_t004_008/r2_w1_wl u_t004_008/r2_r0_rwl
+ u_t004_008/r2_r1_rwl u_t004_008/r3_w0_wl u_t004_008/r3_w1_wl u_t004_008/r3_r0_rwl u_t004_008/r3_r1_rwl VDD VSS VSUBS
+ detronyx_12t_2w2r_rc4_4x4_routed_5layer_direct
Xu_t013_009 u_t013_009/c0_w0_bl u_t013_009/c0_w0_br u_t013_009/c0_w1_bl u_t013_009/c0_w1_br u_t013_009/c0_r0_rbl
+ u_t013_009/c0_r1_rbl u_t013_009/c1_w0_bl u_t013_009/c1_w0_br u_t013_009/c1_w1_bl u_t013_009/c1_w1_br
+ u_t013_009/c1_r0_rbl u_t013_009/c1_r1_rbl u_t013_009/c2_w0_bl u_t013_009/c2_w0_br u_t013_009/c2_w1_bl
+ u_t013_009/c2_w1_br u_t013_009/c2_r0_rbl u_t013_009/c2_r1_rbl u_t013_009/c3_w0_bl u_t013_009/c3_w0_br
+ u_t013_009/c3_w1_bl u_t013_009/c3_w1_br u_t013_009/c3_r0_rbl u_t013_009/c3_r1_rbl u_t013_009/r0_w0_wl
+ u_t013_009/r0_w1_wl u_t013_009/r0_r0_rwl u_t013_009/r0_r1_rwl u_t013_009/r1_w0_wl u_t013_009/r1_w1_wl
+ u_t013_009/r1_r0_rwl u_t013_009/r1_r1_rwl u_t013_009/r2_w0_wl u_t013_009/r2_w1_wl u_t013_009/r2_r0_rwl
+ u_t013_009/r2_r1_rwl u_t013_009/r3_w0_wl u_t013_009/r3_w1_wl u_t013_009/r3_r0_rwl u_t013_009/r3_r1_rwl VDD VSS VSUBS
+ detronyx_12t_2w2r_rc4_4x4_routed_5layer_direct
Xu_t007_006 u_t007_006/c0_w0_bl u_t007_006/c0_w0_br u_t007_006/c0_w1_bl u_t007_006/c0_w1_br u_t007_006/c0_r0_rbl
+ u_t007_006/c0_r1_rbl u_t007_006/c1_w0_bl u_t007_006/c1_w0_br u_t007_006/c1_w1_bl u_t007_006/c1_w1_br
+ u_t007_006/c1_r0_rbl u_t007_006/c1_r1_rbl u_t007_006/c2_w0_bl u_t007_006/c2_w0_br u_t007_006/c2_w1_bl
+ u_t007_006/c2_w1_br u_t007_006/c2_r0_rbl u_t007_006/c2_r1_rbl u_t007_006/c3_w0_bl u_t007_006/c3_w0_br
+ u_t007_006/c3_w1_bl u_t007_006/c3_w1_br u_t007_006/c3_r0_rbl u_t007_006/c3_r1_rbl u_t007_006/r0_w0_wl
+ u_t007_006/r0_w1_wl u_t007_006/r0_r0_rwl u_t007_006/r0_r1_rwl u_t007_006/r1_w0_wl u_t007_006/r1_w1_wl
+ u_t007_006/r1_r0_rwl u_t007_006/r1_r1_rwl u_t007_006/r2_w0_wl u_t007_006/r2_w1_wl u_t007_006/r2_r0_rwl
+ u_t007_006/r2_r1_rwl u_t007_006/r3_w0_wl u_t007_006/r3_w1_wl u_t007_006/r3_r0_rwl u_t007_006/r3_r1_rwl VDD VSS VSUBS
+ detronyx_12t_2w2r_rc4_4x4_routed_5layer_direct
Xu_t004_009 u_t004_009/c0_w0_bl u_t004_009/c0_w0_br u_t004_009/c0_w1_bl u_t004_009/c0_w1_br u_t004_009/c0_r0_rbl
+ u_t004_009/c0_r1_rbl u_t004_009/c1_w0_bl u_t004_009/c1_w0_br u_t004_009/c1_w1_bl u_t004_009/c1_w1_br
+ u_t004_009/c1_r0_rbl u_t004_009/c1_r1_rbl u_t004_009/c2_w0_bl u_t004_009/c2_w0_br u_t004_009/c2_w1_bl
+ u_t004_009/c2_w1_br u_t004_009/c2_r0_rbl u_t004_009/c2_r1_rbl u_t004_009/c3_w0_bl u_t004_009/c3_w0_br
+ u_t004_009/c3_w1_bl u_t004_009/c3_w1_br u_t004_009/c3_r0_rbl u_t004_009/c3_r1_rbl u_t004_009/r0_w0_wl
+ u_t004_009/r0_w1_wl u_t004_009/r0_r0_rwl u_t004_009/r0_r1_rwl u_t004_009/r1_w0_wl u_t004_009/r1_w1_wl
+ u_t004_009/r1_r0_rwl u_t004_009/r1_r1_rwl u_t004_009/r2_w0_wl u_t004_009/r2_w1_wl u_t004_009/r2_r0_rwl
+ u_t004_009/r2_r1_rwl u_t004_009/r3_w0_wl u_t004_009/r3_w1_wl u_t004_009/r3_r0_rwl u_t004_009/r3_r1_rwl VDD VSS VSUBS
+ detronyx_12t_2w2r_rc4_4x4_routed_5layer_direct
Xu_t000_001 u_t000_001/c0_w0_bl u_t000_001/c0_w0_br u_t000_001/c0_w1_bl u_t000_001/c0_w1_br u_t000_001/c0_r0_rbl
+ u_t000_001/c0_r1_rbl u_t000_001/c1_w0_bl u_t000_001/c1_w0_br u_t000_001/c1_w1_bl u_t000_001/c1_w1_br
+ u_t000_001/c1_r0_rbl u_t000_001/c1_r1_rbl u_t000_001/c2_w0_bl u_t000_001/c2_w0_br u_t000_001/c2_w1_bl
+ u_t000_001/c2_w1_br u_t000_001/c2_r0_rbl u_t000_001/c2_r1_rbl u_t000_001/c3_w0_bl u_t000_001/c3_w0_br
+ u_t000_001/c3_w1_bl u_t000_001/c3_w1_br u_t000_001/c3_r0_rbl u_t000_001/c3_r1_rbl u_t000_001/r0_w0_wl
+ u_t000_001/r0_w1_wl u_t000_001/r0_r0_rwl u_t000_001/r0_r1_rwl u_t000_001/r1_w0_wl u_t000_001/r1_w1_wl
+ u_t000_001/r1_r0_rwl u_t000_001/r1_r1_rwl u_t000_001/r2_w0_wl u_t000_001/r2_w1_wl u_t000_001/r2_r0_rwl
+ u_t000_001/r2_r1_rwl u_t000_001/r3_w0_wl u_t000_001/r3_w1_wl u_t000_001/r3_r0_rwl u_t000_001/r3_r1_rwl VDD VSS VSUBS
+ detronyx_12t_2w2r_rc4_4x4_routed_5layer_direct
Xu_t000_012 u_t000_012/c0_w0_bl u_t000_012/c0_w0_br u_t000_012/c0_w1_bl u_t000_012/c0_w1_br u_t000_012/c0_r0_rbl
+ u_t000_012/c0_r1_rbl u_t000_012/c1_w0_bl u_t000_012/c1_w0_br u_t000_012/c1_w1_bl u_t000_012/c1_w1_br
+ u_t000_012/c1_r0_rbl u_t000_012/c1_r1_rbl u_t000_012/c2_w0_bl u_t000_012/c2_w0_br u_t000_012/c2_w1_bl
+ u_t000_012/c2_w1_br u_t000_012/c2_r0_rbl u_t000_012/c2_r1_rbl u_t000_012/c3_w0_bl u_t000_012/c3_w0_br
+ u_t000_012/c3_w1_bl u_t000_012/c3_w1_br u_t000_012/c3_r0_rbl u_t000_012/c3_r1_rbl u_t000_012/r0_w0_wl
+ u_t000_012/r0_w1_wl u_t000_012/r0_r0_rwl u_t000_012/r0_r1_rwl u_t000_012/r1_w0_wl u_t000_012/r1_w1_wl
+ u_t000_012/r1_r0_rwl u_t000_012/r1_r1_rwl u_t000_012/r2_w0_wl u_t000_012/r2_w1_wl u_t000_012/r2_r0_rwl
+ u_t000_012/r2_r1_rwl u_t000_012/r3_w0_wl u_t000_012/r3_w1_wl u_t000_012/r3_r0_rwl u_t000_012/r3_r1_rwl VDD VSS VSUBS
+ detronyx_12t_2w2r_rc4_4x4_routed_5layer_direct
Xu_t007_007 u_t007_007/c0_w0_bl u_t007_007/c0_w0_br u_t007_007/c0_w1_bl u_t007_007/c0_w1_br u_t007_007/c0_r0_rbl
+ u_t007_007/c0_r1_rbl u_t007_007/c1_w0_bl u_t007_007/c1_w0_br u_t007_007/c1_w1_bl u_t007_007/c1_w1_br
+ u_t007_007/c1_r0_rbl u_t007_007/c1_r1_rbl u_t007_007/c2_w0_bl u_t007_007/c2_w0_br u_t007_007/c2_w1_bl
+ u_t007_007/c2_w1_br u_t007_007/c2_r0_rbl u_t007_007/c2_r1_rbl u_t007_007/c3_w0_bl u_t007_007/c3_w0_br
+ u_t007_007/c3_w1_bl u_t007_007/c3_w1_br u_t007_007/c3_r0_rbl u_t007_007/c3_r1_rbl u_t007_007/r0_w0_wl
+ u_t007_007/r0_w1_wl u_t007_007/r0_r0_rwl u_t007_007/r0_r1_rwl u_t007_007/r1_w0_wl u_t007_007/r1_w1_wl
+ u_t007_007/r1_r0_rwl u_t007_007/r1_r1_rwl u_t007_007/r2_w0_wl u_t007_007/r2_w1_wl u_t007_007/r2_r0_rwl
+ u_t007_007/r2_r1_rwl u_t007_007/r3_w0_wl u_t007_007/r3_w1_wl u_t007_007/r3_r0_rwl u_t007_007/r3_r1_rwl VDD VSS VSUBS
+ detronyx_12t_2w2r_rc4_4x4_routed_5layer_direct
Xu_t012_010 u_t012_010/c0_w0_bl u_t012_010/c0_w0_br u_t012_010/c0_w1_bl u_t012_010/c0_w1_br u_t012_010/c0_r0_rbl
+ u_t012_010/c0_r1_rbl u_t012_010/c1_w0_bl u_t012_010/c1_w0_br u_t012_010/c1_w1_bl u_t012_010/c1_w1_br
+ u_t012_010/c1_r0_rbl u_t012_010/c1_r1_rbl u_t012_010/c2_w0_bl u_t012_010/c2_w0_br u_t012_010/c2_w1_bl
+ u_t012_010/c2_w1_br u_t012_010/c2_r0_rbl u_t012_010/c2_r1_rbl u_t012_010/c3_w0_bl u_t012_010/c3_w0_br
+ u_t012_010/c3_w1_bl u_t012_010/c3_w1_br u_t012_010/c3_r0_rbl u_t012_010/c3_r1_rbl u_t012_010/r0_w0_wl
+ u_t012_010/r0_w1_wl u_t012_010/r0_r0_rwl u_t012_010/r0_r1_rwl u_t012_010/r1_w0_wl u_t012_010/r1_w1_wl
+ u_t012_010/r1_r0_rwl u_t012_010/r1_r1_rwl u_t012_010/r2_w0_wl u_t012_010/r2_w1_wl u_t012_010/r2_r0_rwl
+ u_t012_010/r2_r1_rwl u_t012_010/r3_w0_wl u_t012_010/r3_w1_wl u_t012_010/r3_r0_rwl u_t012_010/r3_r1_rwl VDD VSS VSUBS
+ detronyx_12t_2w2r_rc4_4x4_routed_5layer_direct
Xu_t000_002 u_t000_002/c0_w0_bl u_t000_002/c0_w0_br u_t000_002/c0_w1_bl u_t000_002/c0_w1_br u_t000_002/c0_r0_rbl
+ u_t000_002/c0_r1_rbl u_t000_002/c1_w0_bl u_t000_002/c1_w0_br u_t000_002/c1_w1_bl u_t000_002/c1_w1_br
+ u_t000_002/c1_r0_rbl u_t000_002/c1_r1_rbl u_t000_002/c2_w0_bl u_t000_002/c2_w0_br u_t000_002/c2_w1_bl
+ u_t000_002/c2_w1_br u_t000_002/c2_r0_rbl u_t000_002/c2_r1_rbl u_t000_002/c3_w0_bl u_t000_002/c3_w0_br
+ u_t000_002/c3_w1_bl u_t000_002/c3_w1_br u_t000_002/c3_r0_rbl u_t000_002/c3_r1_rbl u_t000_002/r0_w0_wl
+ u_t000_002/r0_w1_wl u_t000_002/r0_r0_rwl u_t000_002/r0_r1_rwl u_t000_002/r1_w0_wl u_t000_002/r1_w1_wl
+ u_t000_002/r1_r0_rwl u_t000_002/r1_r1_rwl u_t000_002/r2_w0_wl u_t000_002/r2_w1_wl u_t000_002/r2_r0_rwl
+ u_t000_002/r2_r1_rwl u_t000_002/r3_w0_wl u_t000_002/r3_w1_wl u_t000_002/r3_r0_rwl u_t000_002/r3_r1_rwl VDD VSS VSUBS
+ detronyx_12t_2w2r_rc4_4x4_routed_5layer_direct
Xu_t000_013 u_t000_013/c0_w0_bl u_t000_013/c0_w0_br u_t000_013/c0_w1_bl u_t000_013/c0_w1_br u_t000_013/c0_r0_rbl
+ u_t000_013/c0_r1_rbl u_t000_013/c1_w0_bl u_t000_013/c1_w0_br u_t000_013/c1_w1_bl u_t000_013/c1_w1_br
+ u_t000_013/c1_r0_rbl u_t000_013/c1_r1_rbl u_t000_013/c2_w0_bl u_t000_013/c2_w0_br u_t000_013/c2_w1_bl
+ u_t000_013/c2_w1_br u_t000_013/c2_r0_rbl u_t000_013/c2_r1_rbl u_t000_013/c3_w0_bl u_t000_013/c3_w0_br
+ u_t000_013/c3_w1_bl u_t000_013/c3_w1_br u_t000_013/c3_r0_rbl u_t000_013/c3_r1_rbl u_t000_013/r0_w0_wl
+ u_t000_013/r0_w1_wl u_t000_013/r0_r0_rwl u_t000_013/r0_r1_rwl u_t000_013/r1_w0_wl u_t000_013/r1_w1_wl
+ u_t000_013/r1_r0_rwl u_t000_013/r1_r1_rwl u_t000_013/r2_w0_wl u_t000_013/r2_w1_wl u_t000_013/r2_r0_rwl
+ u_t000_013/r2_r1_rwl u_t000_013/r3_w0_wl u_t000_013/r3_w1_wl u_t000_013/r3_r0_rwl u_t000_013/r3_r1_rwl VDD VSS VSUBS
+ detronyx_12t_2w2r_rc4_4x4_routed_5layer_direct
Xu_t003_010 u_t003_010/c0_w0_bl u_t003_010/c0_w0_br u_t003_010/c0_w1_bl u_t003_010/c0_w1_br u_t003_010/c0_r0_rbl
+ u_t003_010/c0_r1_rbl u_t003_010/c1_w0_bl u_t003_010/c1_w0_br u_t003_010/c1_w1_bl u_t003_010/c1_w1_br
+ u_t003_010/c1_r0_rbl u_t003_010/c1_r1_rbl u_t003_010/c2_w0_bl u_t003_010/c2_w0_br u_t003_010/c2_w1_bl
+ u_t003_010/c2_w1_br u_t003_010/c2_r0_rbl u_t003_010/c2_r1_rbl u_t003_010/c3_w0_bl u_t003_010/c3_w0_br
+ u_t003_010/c3_w1_bl u_t003_010/c3_w1_br u_t003_010/c3_r0_rbl u_t003_010/c3_r1_rbl u_t003_010/r0_w0_wl
+ u_t003_010/r0_w1_wl u_t003_010/r0_r0_rwl u_t003_010/r0_r1_rwl u_t003_010/r1_w0_wl u_t003_010/r1_w1_wl
+ u_t003_010/r1_r0_rwl u_t003_010/r1_r1_rwl u_t003_010/r2_w0_wl u_t003_010/r2_w1_wl u_t003_010/r2_r0_rwl
+ u_t003_010/r2_r1_rwl u_t003_010/r3_w0_wl u_t003_010/r3_w1_wl u_t003_010/r3_r0_rwl u_t003_010/r3_r1_rwl VDD VSS VSUBS
+ detronyx_12t_2w2r_rc4_4x4_routed_5layer_direct
Xu_t012_011 u_t012_011/c0_w0_bl u_t012_011/c0_w0_br u_t012_011/c0_w1_bl u_t012_011/c0_w1_br u_t012_011/c0_r0_rbl
+ u_t012_011/c0_r1_rbl u_t012_011/c1_w0_bl u_t012_011/c1_w0_br u_t012_011/c1_w1_bl u_t012_011/c1_w1_br
+ u_t012_011/c1_r0_rbl u_t012_011/c1_r1_rbl u_t012_011/c2_w0_bl u_t012_011/c2_w0_br u_t012_011/c2_w1_bl
+ u_t012_011/c2_w1_br u_t012_011/c2_r0_rbl u_t012_011/c2_r1_rbl u_t012_011/c3_w0_bl u_t012_011/c3_w0_br
+ u_t012_011/c3_w1_bl u_t012_011/c3_w1_br u_t012_011/c3_r0_rbl u_t012_011/c3_r1_rbl u_t012_011/r0_w0_wl
+ u_t012_011/r0_w1_wl u_t012_011/r0_r0_rwl u_t012_011/r0_r1_rwl u_t012_011/r1_w0_wl u_t012_011/r1_w1_wl
+ u_t012_011/r1_r0_rwl u_t012_011/r1_r1_rwl u_t012_011/r2_w0_wl u_t012_011/r2_w1_wl u_t012_011/r2_r0_rwl
+ u_t012_011/r2_r1_rwl u_t012_011/r3_w0_wl u_t012_011/r3_w1_wl u_t012_011/r3_r0_rwl u_t012_011/r3_r1_rwl VDD VSS VSUBS
+ detronyx_12t_2w2r_rc4_4x4_routed_5layer_direct
Xu_t012_000 u_t012_000/c0_w0_bl u_t012_000/c0_w0_br u_t012_000/c0_w1_bl u_t012_000/c0_w1_br u_t012_000/c0_r0_rbl
+ u_t012_000/c0_r1_rbl u_t012_000/c1_w0_bl u_t012_000/c1_w0_br u_t012_000/c1_w1_bl u_t012_000/c1_w1_br
+ u_t012_000/c1_r0_rbl u_t012_000/c1_r1_rbl u_t012_000/c2_w0_bl u_t012_000/c2_w0_br u_t012_000/c2_w1_bl
+ u_t012_000/c2_w1_br u_t012_000/c2_r0_rbl u_t012_000/c2_r1_rbl u_t012_000/c3_w0_bl u_t012_000/c3_w0_br
+ u_t012_000/c3_w1_bl u_t012_000/c3_w1_br u_t012_000/c3_r0_rbl u_t012_000/c3_r1_rbl u_t012_000/r0_w0_wl
+ u_t012_000/r0_w1_wl u_t012_000/r0_r0_rwl u_t012_000/r0_r1_rwl u_t012_000/r1_w0_wl u_t012_000/r1_w1_wl
+ u_t012_000/r1_r0_rwl u_t012_000/r1_r1_rwl u_t012_000/r2_w0_wl u_t012_000/r2_w1_wl u_t012_000/r2_r0_rwl
+ u_t012_000/r2_r1_rwl u_t012_000/r3_w0_wl u_t012_000/r3_w1_wl u_t012_000/r3_r0_rwl u_t012_000/r3_r1_rwl VDD VSS VSUBS
+ detronyx_12t_2w2r_rc4_4x4_routed_5layer_direct
Xu_t007_008 u_t007_008/c0_w0_bl u_t007_008/c0_w0_br u_t007_008/c0_w1_bl u_t007_008/c0_w1_br u_t007_008/c0_r0_rbl
+ u_t007_008/c0_r1_rbl u_t007_008/c1_w0_bl u_t007_008/c1_w0_br u_t007_008/c1_w1_bl u_t007_008/c1_w1_br
+ u_t007_008/c1_r0_rbl u_t007_008/c1_r1_rbl u_t007_008/c2_w0_bl u_t007_008/c2_w0_br u_t007_008/c2_w1_bl
+ u_t007_008/c2_w1_br u_t007_008/c2_r0_rbl u_t007_008/c2_r1_rbl u_t007_008/c3_w0_bl u_t007_008/c3_w0_br
+ u_t007_008/c3_w1_bl u_t007_008/c3_w1_br u_t007_008/c3_r0_rbl u_t007_008/c3_r1_rbl u_t007_008/r0_w0_wl
+ u_t007_008/r0_w1_wl u_t007_008/r0_r0_rwl u_t007_008/r0_r1_rwl u_t007_008/r1_w0_wl u_t007_008/r1_w1_wl
+ u_t007_008/r1_r0_rwl u_t007_008/r1_r1_rwl u_t007_008/r2_w0_wl u_t007_008/r2_w1_wl u_t007_008/r2_r0_rwl
+ u_t007_008/r2_r1_rwl u_t007_008/r3_w0_wl u_t007_008/r3_w1_wl u_t007_008/r3_r0_rwl u_t007_008/r3_r1_rwl VDD VSS VSUBS
+ detronyx_12t_2w2r_rc4_4x4_routed_5layer_direct
Xu_t003_000 u_t003_000/c0_w0_bl u_t003_000/c0_w0_br u_t003_000/c0_w1_bl u_t003_000/c0_w1_br u_t003_000/c0_r0_rbl
+ u_t003_000/c0_r1_rbl u_t003_000/c1_w0_bl u_t003_000/c1_w0_br u_t003_000/c1_w1_bl u_t003_000/c1_w1_br
+ u_t003_000/c1_r0_rbl u_t003_000/c1_r1_rbl u_t003_000/c2_w0_bl u_t003_000/c2_w0_br u_t003_000/c2_w1_bl
+ u_t003_000/c2_w1_br u_t003_000/c2_r0_rbl u_t003_000/c2_r1_rbl u_t003_000/c3_w0_bl u_t003_000/c3_w0_br
+ u_t003_000/c3_w1_bl u_t003_000/c3_w1_br u_t003_000/c3_r0_rbl u_t003_000/c3_r1_rbl u_t003_000/r0_w0_wl
+ u_t003_000/r0_w1_wl u_t003_000/r0_r0_rwl u_t003_000/r0_r1_rwl u_t003_000/r1_w0_wl u_t003_000/r1_w1_wl
+ u_t003_000/r1_r0_rwl u_t003_000/r1_r1_rwl u_t003_000/r2_w0_wl u_t003_000/r2_w1_wl u_t003_000/r2_r0_rwl
+ u_t003_000/r2_r1_rwl u_t003_000/r3_w0_wl u_t003_000/r3_w1_wl u_t003_000/r3_r0_rwl u_t003_000/r3_r1_rwl VDD VSS VSUBS
+ detronyx_12t_2w2r_rc4_4x4_routed_5layer_direct
Xu_t003_011 u_t003_011/c0_w0_bl u_t003_011/c0_w0_br u_t003_011/c0_w1_bl u_t003_011/c0_w1_br u_t003_011/c0_r0_rbl
+ u_t003_011/c0_r1_rbl u_t003_011/c1_w0_bl u_t003_011/c1_w0_br u_t003_011/c1_w1_bl u_t003_011/c1_w1_br
+ u_t003_011/c1_r0_rbl u_t003_011/c1_r1_rbl u_t003_011/c2_w0_bl u_t003_011/c2_w0_br u_t003_011/c2_w1_bl
+ u_t003_011/c2_w1_br u_t003_011/c2_r0_rbl u_t003_011/c2_r1_rbl u_t003_011/c3_w0_bl u_t003_011/c3_w0_br
+ u_t003_011/c3_w1_bl u_t003_011/c3_w1_br u_t003_011/c3_r0_rbl u_t003_011/c3_r1_rbl u_t003_011/r0_w0_wl
+ u_t003_011/r0_w1_wl u_t003_011/r0_r0_rwl u_t003_011/r0_r1_rwl u_t003_011/r1_w0_wl u_t003_011/r1_w1_wl
+ u_t003_011/r1_r0_rwl u_t003_011/r1_r1_rwl u_t003_011/r2_w0_wl u_t003_011/r2_w1_wl u_t003_011/r2_r0_rwl
+ u_t003_011/r2_r1_rwl u_t003_011/r3_w0_wl u_t003_011/r3_w1_wl u_t003_011/r3_r0_rwl u_t003_011/r3_r1_rwl VDD VSS VSUBS
+ detronyx_12t_2w2r_rc4_4x4_routed_5layer_direct
Xu_t000_003 u_t000_003/c0_w0_bl u_t000_003/c0_w0_br u_t000_003/c0_w1_bl u_t000_003/c0_w1_br u_t000_003/c0_r0_rbl
+ u_t000_003/c0_r1_rbl u_t000_003/c1_w0_bl u_t000_003/c1_w0_br u_t000_003/c1_w1_bl u_t000_003/c1_w1_br
+ u_t000_003/c1_r0_rbl u_t000_003/c1_r1_rbl u_t000_003/c2_w0_bl u_t000_003/c2_w0_br u_t000_003/c2_w1_bl
+ u_t000_003/c2_w1_br u_t000_003/c2_r0_rbl u_t000_003/c2_r1_rbl u_t000_003/c3_w0_bl u_t000_003/c3_w0_br
+ u_t000_003/c3_w1_bl u_t000_003/c3_w1_br u_t000_003/c3_r0_rbl u_t000_003/c3_r1_rbl u_t000_003/r0_w0_wl
+ u_t000_003/r0_w1_wl u_t000_003/r0_r0_rwl u_t000_003/r0_r1_rwl u_t000_003/r1_w0_wl u_t000_003/r1_w1_wl
+ u_t000_003/r1_r0_rwl u_t000_003/r1_r1_rwl u_t000_003/r2_w0_wl u_t000_003/r2_w1_wl u_t000_003/r2_r0_rwl
+ u_t000_003/r2_r1_rwl u_t000_003/r3_w0_wl u_t000_003/r3_w1_wl u_t000_003/r3_r0_rwl u_t000_003/r3_r1_rwl VDD VSS VSUBS
+ detronyx_12t_2w2r_rc4_4x4_routed_5layer_direct
Xu_t000_014 u_t000_014/c0_w0_bl u_t000_014/c0_w0_br u_t000_014/c0_w1_bl u_t000_014/c0_w1_br u_t000_014/c0_r0_rbl
+ u_t000_014/c0_r1_rbl u_t000_014/c1_w0_bl u_t000_014/c1_w0_br u_t000_014/c1_w1_bl u_t000_014/c1_w1_br
+ u_t000_014/c1_r0_rbl u_t000_014/c1_r1_rbl u_t000_014/c2_w0_bl u_t000_014/c2_w0_br u_t000_014/c2_w1_bl
+ u_t000_014/c2_w1_br u_t000_014/c2_r0_rbl u_t000_014/c2_r1_rbl u_t000_014/c3_w0_bl u_t000_014/c3_w0_br
+ u_t000_014/c3_w1_bl u_t000_014/c3_w1_br u_t000_014/c3_r0_rbl u_t000_014/c3_r1_rbl u_t000_014/r0_w0_wl
+ u_t000_014/r0_w1_wl u_t000_014/r0_r0_rwl u_t000_014/r0_r1_rwl u_t000_014/r1_w0_wl u_t000_014/r1_w1_wl
+ u_t000_014/r1_r0_rwl u_t000_014/r1_r1_rwl u_t000_014/r2_w0_wl u_t000_014/r2_w1_wl u_t000_014/r2_r0_rwl
+ u_t000_014/r2_r1_rwl u_t000_014/r3_w0_wl u_t000_014/r3_w1_wl u_t000_014/r3_r0_rwl u_t000_014/r3_r1_rwl VDD VSS VSUBS
+ detronyx_12t_2w2r_rc4_4x4_routed_5layer_direct
Xu_t007_009 u_t007_009/c0_w0_bl u_t007_009/c0_w0_br u_t007_009/c0_w1_bl u_t007_009/c0_w1_br u_t007_009/c0_r0_rbl
+ u_t007_009/c0_r1_rbl u_t007_009/c1_w0_bl u_t007_009/c1_w0_br u_t007_009/c1_w1_bl u_t007_009/c1_w1_br
+ u_t007_009/c1_r0_rbl u_t007_009/c1_r1_rbl u_t007_009/c2_w0_bl u_t007_009/c2_w0_br u_t007_009/c2_w1_bl
+ u_t007_009/c2_w1_br u_t007_009/c2_r0_rbl u_t007_009/c2_r1_rbl u_t007_009/c3_w0_bl u_t007_009/c3_w0_br
+ u_t007_009/c3_w1_bl u_t007_009/c3_w1_br u_t007_009/c3_r0_rbl u_t007_009/c3_r1_rbl u_t007_009/r0_w0_wl
+ u_t007_009/r0_w1_wl u_t007_009/r0_r0_rwl u_t007_009/r0_r1_rwl u_t007_009/r1_w0_wl u_t007_009/r1_w1_wl
+ u_t007_009/r1_r0_rwl u_t007_009/r1_r1_rwl u_t007_009/r2_w0_wl u_t007_009/r2_w1_wl u_t007_009/r2_r0_rwl
+ u_t007_009/r2_r1_rwl u_t007_009/r3_w0_wl u_t007_009/r3_w1_wl u_t007_009/r3_r0_rwl u_t007_009/r3_r1_rwl VDD VSS VSUBS
+ detronyx_12t_2w2r_rc4_4x4_routed_5layer_direct
Xu_t012_012 u_t012_012/c0_w0_bl u_t012_012/c0_w0_br u_t012_012/c0_w1_bl u_t012_012/c0_w1_br u_t012_012/c0_r0_rbl
+ u_t012_012/c0_r1_rbl u_t012_012/c1_w0_bl u_t012_012/c1_w0_br u_t012_012/c1_w1_bl u_t012_012/c1_w1_br
+ u_t012_012/c1_r0_rbl u_t012_012/c1_r1_rbl u_t012_012/c2_w0_bl u_t012_012/c2_w0_br u_t012_012/c2_w1_bl
+ u_t012_012/c2_w1_br u_t012_012/c2_r0_rbl u_t012_012/c2_r1_rbl u_t012_012/c3_w0_bl u_t012_012/c3_w0_br
+ u_t012_012/c3_w1_bl u_t012_012/c3_w1_br u_t012_012/c3_r0_rbl u_t012_012/c3_r1_rbl u_t012_012/r0_w0_wl
+ u_t012_012/r0_w1_wl u_t012_012/r0_r0_rwl u_t012_012/r0_r1_rwl u_t012_012/r1_w0_wl u_t012_012/r1_w1_wl
+ u_t012_012/r1_r0_rwl u_t012_012/r1_r1_rwl u_t012_012/r2_w0_wl u_t012_012/r2_w1_wl u_t012_012/r2_r0_rwl
+ u_t012_012/r2_r1_rwl u_t012_012/r3_w0_wl u_t012_012/r3_w1_wl u_t012_012/r3_r0_rwl u_t012_012/r3_r1_rwl VDD VSS VSUBS
+ detronyx_12t_2w2r_rc4_4x4_routed_5layer_direct
Xu_t012_001 u_t012_001/c0_w0_bl u_t012_001/c0_w0_br u_t012_001/c0_w1_bl u_t012_001/c0_w1_br u_t012_001/c0_r0_rbl
+ u_t012_001/c0_r1_rbl u_t012_001/c1_w0_bl u_t012_001/c1_w0_br u_t012_001/c1_w1_bl u_t012_001/c1_w1_br
+ u_t012_001/c1_r0_rbl u_t012_001/c1_r1_rbl u_t012_001/c2_w0_bl u_t012_001/c2_w0_br u_t012_001/c2_w1_bl
+ u_t012_001/c2_w1_br u_t012_001/c2_r0_rbl u_t012_001/c2_r1_rbl u_t012_001/c3_w0_bl u_t012_001/c3_w0_br
+ u_t012_001/c3_w1_bl u_t012_001/c3_w1_br u_t012_001/c3_r0_rbl u_t012_001/c3_r1_rbl u_t012_001/r0_w0_wl
+ u_t012_001/r0_w1_wl u_t012_001/r0_r0_rwl u_t012_001/r0_r1_rwl u_t012_001/r1_w0_wl u_t012_001/r1_w1_wl
+ u_t012_001/r1_r0_rwl u_t012_001/r1_r1_rwl u_t012_001/r2_w0_wl u_t012_001/r2_w1_wl u_t012_001/r2_r0_rwl
+ u_t012_001/r2_r1_rwl u_t012_001/r3_w0_wl u_t012_001/r3_w1_wl u_t012_001/r3_r0_rwl u_t012_001/r3_r1_rwl VDD VSS VSUBS
+ detronyx_12t_2w2r_rc4_4x4_routed_5layer_direct
Xu_t000_004 u_t000_004/c0_w0_bl u_t000_004/c0_w0_br u_t000_004/c0_w1_bl u_t000_004/c0_w1_br u_t000_004/c0_r0_rbl
+ u_t000_004/c0_r1_rbl u_t000_004/c1_w0_bl u_t000_004/c1_w0_br u_t000_004/c1_w1_bl u_t000_004/c1_w1_br
+ u_t000_004/c1_r0_rbl u_t000_004/c1_r1_rbl u_t000_004/c2_w0_bl u_t000_004/c2_w0_br u_t000_004/c2_w1_bl
+ u_t000_004/c2_w1_br u_t000_004/c2_r0_rbl u_t000_004/c2_r1_rbl u_t000_004/c3_w0_bl u_t000_004/c3_w0_br
+ u_t000_004/c3_w1_bl u_t000_004/c3_w1_br u_t000_004/c3_r0_rbl u_t000_004/c3_r1_rbl u_t000_004/r0_w0_wl
+ u_t000_004/r0_w1_wl u_t000_004/r0_r0_rwl u_t000_004/r0_r1_rwl u_t000_004/r1_w0_wl u_t000_004/r1_w1_wl
+ u_t000_004/r1_r0_rwl u_t000_004/r1_r1_rwl u_t000_004/r2_w0_wl u_t000_004/r2_w1_wl u_t000_004/r2_r0_rwl
+ u_t000_004/r2_r1_rwl u_t000_004/r3_w0_wl u_t000_004/r3_w1_wl u_t000_004/r3_r0_rwl u_t000_004/r3_r1_rwl VDD VSS VSUBS
+ detronyx_12t_2w2r_rc4_4x4_routed_5layer_direct
Xu_t003_001 u_t003_001/c0_w0_bl u_t003_001/c0_w0_br u_t003_001/c0_w1_bl u_t003_001/c0_w1_br u_t003_001/c0_r0_rbl
+ u_t003_001/c0_r1_rbl u_t003_001/c1_w0_bl u_t003_001/c1_w0_br u_t003_001/c1_w1_bl u_t003_001/c1_w1_br
+ u_t003_001/c1_r0_rbl u_t003_001/c1_r1_rbl u_t003_001/c2_w0_bl u_t003_001/c2_w0_br u_t003_001/c2_w1_bl
+ u_t003_001/c2_w1_br u_t003_001/c2_r0_rbl u_t003_001/c2_r1_rbl u_t003_001/c3_w0_bl u_t003_001/c3_w0_br
+ u_t003_001/c3_w1_bl u_t003_001/c3_w1_br u_t003_001/c3_r0_rbl u_t003_001/c3_r1_rbl u_t003_001/r0_w0_wl
+ u_t003_001/r0_w1_wl u_t003_001/r0_r0_rwl u_t003_001/r0_r1_rwl u_t003_001/r1_w0_wl u_t003_001/r1_w1_wl
+ u_t003_001/r1_r0_rwl u_t003_001/r1_r1_rwl u_t003_001/r2_w0_wl u_t003_001/r2_w1_wl u_t003_001/r2_r0_rwl
+ u_t003_001/r2_r1_rwl u_t003_001/r3_w0_wl u_t003_001/r3_w1_wl u_t003_001/r3_r0_rwl u_t003_001/r3_r1_rwl VDD VSS VSUBS
+ detronyx_12t_2w2r_rc4_4x4_routed_5layer_direct
Xu_t003_012 u_t003_012/c0_w0_bl u_t003_012/c0_w0_br u_t003_012/c0_w1_bl u_t003_012/c0_w1_br u_t003_012/c0_r0_rbl
+ u_t003_012/c0_r1_rbl u_t003_012/c1_w0_bl u_t003_012/c1_w0_br u_t003_012/c1_w1_bl u_t003_012/c1_w1_br
+ u_t003_012/c1_r0_rbl u_t003_012/c1_r1_rbl u_t003_012/c2_w0_bl u_t003_012/c2_w0_br u_t003_012/c2_w1_bl
+ u_t003_012/c2_w1_br u_t003_012/c2_r0_rbl u_t003_012/c2_r1_rbl u_t003_012/c3_w0_bl u_t003_012/c3_w0_br
+ u_t003_012/c3_w1_bl u_t003_012/c3_w1_br u_t003_012/c3_r0_rbl u_t003_012/c3_r1_rbl u_t003_012/r0_w0_wl
+ u_t003_012/r0_w1_wl u_t003_012/r0_r0_rwl u_t003_012/r0_r1_rwl u_t003_012/r1_w0_wl u_t003_012/r1_w1_wl
+ u_t003_012/r1_r0_rwl u_t003_012/r1_r1_rwl u_t003_012/r2_w0_wl u_t003_012/r2_w1_wl u_t003_012/r2_r0_rwl
+ u_t003_012/r2_r1_rwl u_t003_012/r3_w0_wl u_t003_012/r3_w1_wl u_t003_012/r3_r0_rwl u_t003_012/r3_r1_rwl VDD VSS VSUBS
+ detronyx_12t_2w2r_rc4_4x4_routed_5layer_direct
Xu_t000_015 u_t000_015/c0_w0_bl u_t000_015/c0_w0_br u_t000_015/c0_w1_bl u_t000_015/c0_w1_br u_t000_015/c0_r0_rbl
+ u_t000_015/c0_r1_rbl u_t000_015/c1_w0_bl u_t000_015/c1_w0_br u_t000_015/c1_w1_bl u_t000_015/c1_w1_br
+ u_t000_015/c1_r0_rbl u_t000_015/c1_r1_rbl u_t000_015/c2_w0_bl u_t000_015/c2_w0_br u_t000_015/c2_w1_bl
+ u_t000_015/c2_w1_br u_t000_015/c2_r0_rbl u_t000_015/c2_r1_rbl u_t000_015/c3_w0_bl u_t000_015/c3_w0_br
+ u_t000_015/c3_w1_bl u_t000_015/c3_w1_br u_t000_015/c3_r0_rbl u_t000_015/c3_r1_rbl u_t000_015/r0_w0_wl
+ u_t000_015/r0_w1_wl u_t000_015/r0_r0_rwl u_t000_015/r0_r1_rwl u_t000_015/r1_w0_wl u_t000_015/r1_w1_wl
+ u_t000_015/r1_r0_rwl u_t000_015/r1_r1_rwl u_t000_015/r2_w0_wl u_t000_015/r2_w1_wl u_t000_015/r2_r0_rwl
+ u_t000_015/r2_r1_rwl u_t000_015/r3_w0_wl u_t000_015/r3_w1_wl u_t000_015/r3_r0_rwl u_t000_015/r3_r1_rwl VDD VSS VSUBS
+ detronyx_12t_2w2r_rc4_4x4_routed_5layer_direct
Xu_t015_010 u_t015_010/c0_w0_bl u_t015_010/c0_w0_br u_t015_010/c0_w1_bl u_t015_010/c0_w1_br u_t015_010/c0_r0_rbl
+ u_t015_010/c0_r1_rbl u_t015_010/c1_w0_bl u_t015_010/c1_w0_br u_t015_010/c1_w1_bl u_t015_010/c1_w1_br
+ u_t015_010/c1_r0_rbl u_t015_010/c1_r1_rbl u_t015_010/c2_w0_bl u_t015_010/c2_w0_br u_t015_010/c2_w1_bl
+ u_t015_010/c2_w1_br u_t015_010/c2_r0_rbl u_t015_010/c2_r1_rbl u_t015_010/c3_w0_bl u_t015_010/c3_w0_br
+ u_t015_010/c3_w1_bl u_t015_010/c3_w1_br u_t015_010/c3_r0_rbl u_t015_010/c3_r1_rbl u_t015_010/r0_w0_wl
+ u_t015_010/r0_w1_wl u_t015_010/r0_r0_rwl u_t015_010/r0_r1_rwl u_t015_010/r1_w0_wl u_t015_010/r1_w1_wl
+ u_t015_010/r1_r0_rwl u_t015_010/r1_r1_rwl u_t015_010/r2_w0_wl u_t015_010/r2_w1_wl u_t015_010/r2_r0_rwl
+ u_t015_010/r2_r1_rwl u_t015_010/r3_w0_wl u_t015_010/r3_w1_wl u_t015_010/r3_r0_rwl u_t015_010/r3_r1_rwl VDD VSS VSUBS
+ detronyx_12t_2w2r_rc4_4x4_routed_5layer_direct
Xu_t012_013 u_t012_013/c0_w0_bl u_t012_013/c0_w0_br u_t012_013/c0_w1_bl u_t012_013/c0_w1_br u_t012_013/c0_r0_rbl
+ u_t012_013/c0_r1_rbl u_t012_013/c1_w0_bl u_t012_013/c1_w0_br u_t012_013/c1_w1_bl u_t012_013/c1_w1_br
+ u_t012_013/c1_r0_rbl u_t012_013/c1_r1_rbl u_t012_013/c2_w0_bl u_t012_013/c2_w0_br u_t012_013/c2_w1_bl
+ u_t012_013/c2_w1_br u_t012_013/c2_r0_rbl u_t012_013/c2_r1_rbl u_t012_013/c3_w0_bl u_t012_013/c3_w0_br
+ u_t012_013/c3_w1_bl u_t012_013/c3_w1_br u_t012_013/c3_r0_rbl u_t012_013/c3_r1_rbl u_t012_013/r0_w0_wl
+ u_t012_013/r0_w1_wl u_t012_013/r0_r0_rwl u_t012_013/r0_r1_rwl u_t012_013/r1_w0_wl u_t012_013/r1_w1_wl
+ u_t012_013/r1_r0_rwl u_t012_013/r1_r1_rwl u_t012_013/r2_w0_wl u_t012_013/r2_w1_wl u_t012_013/r2_r0_rwl
+ u_t012_013/r2_r1_rwl u_t012_013/r3_w0_wl u_t012_013/r3_w1_wl u_t012_013/r3_r0_rwl u_t012_013/r3_r1_rwl VDD VSS VSUBS
+ detronyx_12t_2w2r_rc4_4x4_routed_5layer_direct
Xu_t012_002 u_t012_002/c0_w0_bl u_t012_002/c0_w0_br u_t012_002/c0_w1_bl u_t012_002/c0_w1_br u_t012_002/c0_r0_rbl
+ u_t012_002/c0_r1_rbl u_t012_002/c1_w0_bl u_t012_002/c1_w0_br u_t012_002/c1_w1_bl u_t012_002/c1_w1_br
+ u_t012_002/c1_r0_rbl u_t012_002/c1_r1_rbl u_t012_002/c2_w0_bl u_t012_002/c2_w0_br u_t012_002/c2_w1_bl
+ u_t012_002/c2_w1_br u_t012_002/c2_r0_rbl u_t012_002/c2_r1_rbl u_t012_002/c3_w0_bl u_t012_002/c3_w0_br
+ u_t012_002/c3_w1_bl u_t012_002/c3_w1_br u_t012_002/c3_r0_rbl u_t012_002/c3_r1_rbl u_t012_002/r0_w0_wl
+ u_t012_002/r0_w1_wl u_t012_002/r0_r0_rwl u_t012_002/r0_r1_rwl u_t012_002/r1_w0_wl u_t012_002/r1_w1_wl
+ u_t012_002/r1_r0_rwl u_t012_002/r1_r1_rwl u_t012_002/r2_w0_wl u_t012_002/r2_w1_wl u_t012_002/r2_r0_rwl
+ u_t012_002/r2_r1_rwl u_t012_002/r3_w0_wl u_t012_002/r3_w1_wl u_t012_002/r3_r0_rwl u_t012_002/r3_r1_rwl VDD VSS VSUBS
+ detronyx_12t_2w2r_rc4_4x4_routed_5layer_direct
Xu_t006_010 u_t006_010/c0_w0_bl u_t006_010/c0_w0_br u_t006_010/c0_w1_bl u_t006_010/c0_w1_br u_t006_010/c0_r0_rbl
+ u_t006_010/c0_r1_rbl u_t006_010/c1_w0_bl u_t006_010/c1_w0_br u_t006_010/c1_w1_bl u_t006_010/c1_w1_br
+ u_t006_010/c1_r0_rbl u_t006_010/c1_r1_rbl u_t006_010/c2_w0_bl u_t006_010/c2_w0_br u_t006_010/c2_w1_bl
+ u_t006_010/c2_w1_br u_t006_010/c2_r0_rbl u_t006_010/c2_r1_rbl u_t006_010/c3_w0_bl u_t006_010/c3_w0_br
+ u_t006_010/c3_w1_bl u_t006_010/c3_w1_br u_t006_010/c3_r0_rbl u_t006_010/c3_r1_rbl u_t006_010/r0_w0_wl
+ u_t006_010/r0_w1_wl u_t006_010/r0_r0_rwl u_t006_010/r0_r1_rwl u_t006_010/r1_w0_wl u_t006_010/r1_w1_wl
+ u_t006_010/r1_r0_rwl u_t006_010/r1_r1_rwl u_t006_010/r2_w0_wl u_t006_010/r2_w1_wl u_t006_010/r2_r0_rwl
+ u_t006_010/r2_r1_rwl u_t006_010/r3_w0_wl u_t006_010/r3_w1_wl u_t006_010/r3_r0_rwl u_t006_010/r3_r1_rwl VDD VSS VSUBS
+ detronyx_12t_2w2r_rc4_4x4_routed_5layer_direct
Xu_t000_005 u_t000_005/c0_w0_bl u_t000_005/c0_w0_br u_t000_005/c0_w1_bl u_t000_005/c0_w1_br u_t000_005/c0_r0_rbl
+ u_t000_005/c0_r1_rbl u_t000_005/c1_w0_bl u_t000_005/c1_w0_br u_t000_005/c1_w1_bl u_t000_005/c1_w1_br
+ u_t000_005/c1_r0_rbl u_t000_005/c1_r1_rbl u_t000_005/c2_w0_bl u_t000_005/c2_w0_br u_t000_005/c2_w1_bl
+ u_t000_005/c2_w1_br u_t000_005/c2_r0_rbl u_t000_005/c2_r1_rbl u_t000_005/c3_w0_bl u_t000_005/c3_w0_br
+ u_t000_005/c3_w1_bl u_t000_005/c3_w1_br u_t000_005/c3_r0_rbl u_t000_005/c3_r1_rbl u_t000_005/r0_w0_wl
+ u_t000_005/r0_w1_wl u_t000_005/r0_r0_rwl u_t000_005/r0_r1_rwl u_t000_005/r1_w0_wl u_t000_005/r1_w1_wl
+ u_t000_005/r1_r0_rwl u_t000_005/r1_r1_rwl u_t000_005/r2_w0_wl u_t000_005/r2_w1_wl u_t000_005/r2_r0_rwl
+ u_t000_005/r2_r1_rwl u_t000_005/r3_w0_wl u_t000_005/r3_w1_wl u_t000_005/r3_r0_rwl u_t000_005/r3_r1_rwl VDD VSS VSUBS
+ detronyx_12t_2w2r_rc4_4x4_routed_5layer_direct
Xu_t003_002 u_t003_002/c0_w0_bl u_t003_002/c0_w0_br u_t003_002/c0_w1_bl u_t003_002/c0_w1_br u_t003_002/c0_r0_rbl
+ u_t003_002/c0_r1_rbl u_t003_002/c1_w0_bl u_t003_002/c1_w0_br u_t003_002/c1_w1_bl u_t003_002/c1_w1_br
+ u_t003_002/c1_r0_rbl u_t003_002/c1_r1_rbl u_t003_002/c2_w0_bl u_t003_002/c2_w0_br u_t003_002/c2_w1_bl
+ u_t003_002/c2_w1_br u_t003_002/c2_r0_rbl u_t003_002/c2_r1_rbl u_t003_002/c3_w0_bl u_t003_002/c3_w0_br
+ u_t003_002/c3_w1_bl u_t003_002/c3_w1_br u_t003_002/c3_r0_rbl u_t003_002/c3_r1_rbl u_t003_002/r0_w0_wl
+ u_t003_002/r0_w1_wl u_t003_002/r0_r0_rwl u_t003_002/r0_r1_rwl u_t003_002/r1_w0_wl u_t003_002/r1_w1_wl
+ u_t003_002/r1_r0_rwl u_t003_002/r1_r1_rwl u_t003_002/r2_w0_wl u_t003_002/r2_w1_wl u_t003_002/r2_r0_rwl
+ u_t003_002/r2_r1_rwl u_t003_002/r3_w0_wl u_t003_002/r3_w1_wl u_t003_002/r3_r0_rwl u_t003_002/r3_r1_rwl VDD VSS VSUBS
+ detronyx_12t_2w2r_rc4_4x4_routed_5layer_direct
Xu_t003_013 u_t003_013/c0_w0_bl u_t003_013/c0_w0_br u_t003_013/c0_w1_bl u_t003_013/c0_w1_br u_t003_013/c0_r0_rbl
+ u_t003_013/c0_r1_rbl u_t003_013/c1_w0_bl u_t003_013/c1_w0_br u_t003_013/c1_w1_bl u_t003_013/c1_w1_br
+ u_t003_013/c1_r0_rbl u_t003_013/c1_r1_rbl u_t003_013/c2_w0_bl u_t003_013/c2_w0_br u_t003_013/c2_w1_bl
+ u_t003_013/c2_w1_br u_t003_013/c2_r0_rbl u_t003_013/c2_r1_rbl u_t003_013/c3_w0_bl u_t003_013/c3_w0_br
+ u_t003_013/c3_w1_bl u_t003_013/c3_w1_br u_t003_013/c3_r0_rbl u_t003_013/c3_r1_rbl u_t003_013/r0_w0_wl
+ u_t003_013/r0_w1_wl u_t003_013/r0_r0_rwl u_t003_013/r0_r1_rwl u_t003_013/r1_w0_wl u_t003_013/r1_w1_wl
+ u_t003_013/r1_r0_rwl u_t003_013/r1_r1_rwl u_t003_013/r2_w0_wl u_t003_013/r2_w1_wl u_t003_013/r2_r0_rwl
+ u_t003_013/r2_r1_rwl u_t003_013/r3_w0_wl u_t003_013/r3_w1_wl u_t003_013/r3_r0_rwl u_t003_013/r3_r1_rwl VDD VSS VSUBS
+ detronyx_12t_2w2r_rc4_4x4_routed_5layer_direct
Xu_t015_011 u_t015_011/c0_w0_bl u_t015_011/c0_w0_br u_t015_011/c0_w1_bl u_t015_011/c0_w1_br u_t015_011/c0_r0_rbl
+ u_t015_011/c0_r1_rbl u_t015_011/c1_w0_bl u_t015_011/c1_w0_br u_t015_011/c1_w1_bl u_t015_011/c1_w1_br
+ u_t015_011/c1_r0_rbl u_t015_011/c1_r1_rbl u_t015_011/c2_w0_bl u_t015_011/c2_w0_br u_t015_011/c2_w1_bl
+ u_t015_011/c2_w1_br u_t015_011/c2_r0_rbl u_t015_011/c2_r1_rbl u_t015_011/c3_w0_bl u_t015_011/c3_w0_br
+ u_t015_011/c3_w1_bl u_t015_011/c3_w1_br u_t015_011/c3_r0_rbl u_t015_011/c3_r1_rbl u_t015_011/r0_w0_wl
+ u_t015_011/r0_w1_wl u_t015_011/r0_r0_rwl u_t015_011/r0_r1_rwl u_t015_011/r1_w0_wl u_t015_011/r1_w1_wl
+ u_t015_011/r1_r0_rwl u_t015_011/r1_r1_rwl u_t015_011/r2_w0_wl u_t015_011/r2_w1_wl u_t015_011/r2_r0_rwl
+ u_t015_011/r2_r1_rwl u_t015_011/r3_w0_wl u_t015_011/r3_w1_wl u_t015_011/r3_r0_rwl u_t015_011/r3_r1_rwl VDD VSS VSUBS
+ detronyx_12t_2w2r_rc4_4x4_routed_5layer_direct
Xu_t015_000 u_t015_000/c0_w0_bl u_t015_000/c0_w0_br u_t015_000/c0_w1_bl u_t015_000/c0_w1_br u_t015_000/c0_r0_rbl
+ u_t015_000/c0_r1_rbl u_t015_000/c1_w0_bl u_t015_000/c1_w0_br u_t015_000/c1_w1_bl u_t015_000/c1_w1_br
+ u_t015_000/c1_r0_rbl u_t015_000/c1_r1_rbl u_t015_000/c2_w0_bl u_t015_000/c2_w0_br u_t015_000/c2_w1_bl
+ u_t015_000/c2_w1_br u_t015_000/c2_r0_rbl u_t015_000/c2_r1_rbl u_t015_000/c3_w0_bl u_t015_000/c3_w0_br
+ u_t015_000/c3_w1_bl u_t015_000/c3_w1_br u_t015_000/c3_r0_rbl u_t015_000/c3_r1_rbl u_t015_000/r0_w0_wl
+ u_t015_000/r0_w1_wl u_t015_000/r0_r0_rwl u_t015_000/r0_r1_rwl u_t015_000/r1_w0_wl u_t015_000/r1_w1_wl
+ u_t015_000/r1_r0_rwl u_t015_000/r1_r1_rwl u_t015_000/r2_w0_wl u_t015_000/r2_w1_wl u_t015_000/r2_r0_rwl
+ u_t015_000/r2_r1_rwl u_t015_000/r3_w0_wl u_t015_000/r3_w1_wl u_t015_000/r3_r0_rwl u_t015_000/r3_r1_rwl VDD VSS VSUBS
+ detronyx_12t_2w2r_rc4_4x4_routed_5layer_direct
Xu_t012_014 u_t012_014/c0_w0_bl u_t012_014/c0_w0_br u_t012_014/c0_w1_bl u_t012_014/c0_w1_br u_t012_014/c0_r0_rbl
+ u_t012_014/c0_r1_rbl u_t012_014/c1_w0_bl u_t012_014/c1_w0_br u_t012_014/c1_w1_bl u_t012_014/c1_w1_br
+ u_t012_014/c1_r0_rbl u_t012_014/c1_r1_rbl u_t012_014/c2_w0_bl u_t012_014/c2_w0_br u_t012_014/c2_w1_bl
+ u_t012_014/c2_w1_br u_t012_014/c2_r0_rbl u_t012_014/c2_r1_rbl u_t012_014/c3_w0_bl u_t012_014/c3_w0_br
+ u_t012_014/c3_w1_bl u_t012_014/c3_w1_br u_t012_014/c3_r0_rbl u_t012_014/c3_r1_rbl u_t012_014/r0_w0_wl
+ u_t012_014/r0_w1_wl u_t012_014/r0_r0_rwl u_t012_014/r0_r1_rwl u_t012_014/r1_w0_wl u_t012_014/r1_w1_wl
+ u_t012_014/r1_r0_rwl u_t012_014/r1_r1_rwl u_t012_014/r2_w0_wl u_t012_014/r2_w1_wl u_t012_014/r2_r0_rwl
+ u_t012_014/r2_r1_rwl u_t012_014/r3_w0_wl u_t012_014/r3_w1_wl u_t012_014/r3_r0_rwl u_t012_014/r3_r1_rwl VDD VSS VSUBS
+ detronyx_12t_2w2r_rc4_4x4_routed_5layer_direct
Xu_t012_003 u_t012_003/c0_w0_bl u_t012_003/c0_w0_br u_t012_003/c0_w1_bl u_t012_003/c0_w1_br u_t012_003/c0_r0_rbl
+ u_t012_003/c0_r1_rbl u_t012_003/c1_w0_bl u_t012_003/c1_w0_br u_t012_003/c1_w1_bl u_t012_003/c1_w1_br
+ u_t012_003/c1_r0_rbl u_t012_003/c1_r1_rbl u_t012_003/c2_w0_bl u_t012_003/c2_w0_br u_t012_003/c2_w1_bl
+ u_t012_003/c2_w1_br u_t012_003/c2_r0_rbl u_t012_003/c2_r1_rbl u_t012_003/c3_w0_bl u_t012_003/c3_w0_br
+ u_t012_003/c3_w1_bl u_t012_003/c3_w1_br u_t012_003/c3_r0_rbl u_t012_003/c3_r1_rbl u_t012_003/r0_w0_wl
+ u_t012_003/r0_w1_wl u_t012_003/r0_r0_rwl u_t012_003/r0_r1_rwl u_t012_003/r1_w0_wl u_t012_003/r1_w1_wl
+ u_t012_003/r1_r0_rwl u_t012_003/r1_r1_rwl u_t012_003/r2_w0_wl u_t012_003/r2_w1_wl u_t012_003/r2_r0_rwl
+ u_t012_003/r2_r1_rwl u_t012_003/r3_w0_wl u_t012_003/r3_w1_wl u_t012_003/r3_r0_rwl u_t012_003/r3_r1_rwl VDD VSS VSUBS
+ detronyx_12t_2w2r_rc4_4x4_routed_5layer_direct
Xu_t006_011 u_t006_011/c0_w0_bl u_t006_011/c0_w0_br u_t006_011/c0_w1_bl u_t006_011/c0_w1_br u_t006_011/c0_r0_rbl
+ u_t006_011/c0_r1_rbl u_t006_011/c1_w0_bl u_t006_011/c1_w0_br u_t006_011/c1_w1_bl u_t006_011/c1_w1_br
+ u_t006_011/c1_r0_rbl u_t006_011/c1_r1_rbl u_t006_011/c2_w0_bl u_t006_011/c2_w0_br u_t006_011/c2_w1_bl
+ u_t006_011/c2_w1_br u_t006_011/c2_r0_rbl u_t006_011/c2_r1_rbl u_t006_011/c3_w0_bl u_t006_011/c3_w0_br
+ u_t006_011/c3_w1_bl u_t006_011/c3_w1_br u_t006_011/c3_r0_rbl u_t006_011/c3_r1_rbl u_t006_011/r0_w0_wl
+ u_t006_011/r0_w1_wl u_t006_011/r0_r0_rwl u_t006_011/r0_r1_rwl u_t006_011/r1_w0_wl u_t006_011/r1_w1_wl
+ u_t006_011/r1_r0_rwl u_t006_011/r1_r1_rwl u_t006_011/r2_w0_wl u_t006_011/r2_w1_wl u_t006_011/r2_r0_rwl
+ u_t006_011/r2_r1_rwl u_t006_011/r3_w0_wl u_t006_011/r3_w1_wl u_t006_011/r3_r0_rwl u_t006_011/r3_r1_rwl VDD VSS VSUBS
+ detronyx_12t_2w2r_rc4_4x4_routed_5layer_direct
Xu_t003_003 u_t003_003/c0_w0_bl u_t003_003/c0_w0_br u_t003_003/c0_w1_bl u_t003_003/c0_w1_br u_t003_003/c0_r0_rbl
+ u_t003_003/c0_r1_rbl u_t003_003/c1_w0_bl u_t003_003/c1_w0_br u_t003_003/c1_w1_bl u_t003_003/c1_w1_br
+ u_t003_003/c1_r0_rbl u_t003_003/c1_r1_rbl u_t003_003/c2_w0_bl u_t003_003/c2_w0_br u_t003_003/c2_w1_bl
+ u_t003_003/c2_w1_br u_t003_003/c2_r0_rbl u_t003_003/c2_r1_rbl u_t003_003/c3_w0_bl u_t003_003/c3_w0_br
+ u_t003_003/c3_w1_bl u_t003_003/c3_w1_br u_t003_003/c3_r0_rbl u_t003_003/c3_r1_rbl u_t003_003/r0_w0_wl
+ u_t003_003/r0_w1_wl u_t003_003/r0_r0_rwl u_t003_003/r0_r1_rwl u_t003_003/r1_w0_wl u_t003_003/r1_w1_wl
+ u_t003_003/r1_r0_rwl u_t003_003/r1_r1_rwl u_t003_003/r2_w0_wl u_t003_003/r2_w1_wl u_t003_003/r2_r0_rwl
+ u_t003_003/r2_r1_rwl u_t003_003/r3_w0_wl u_t003_003/r3_w1_wl u_t003_003/r3_r0_rwl u_t003_003/r3_r1_rwl VDD VSS VSUBS
+ detronyx_12t_2w2r_rc4_4x4_routed_5layer_direct
Xu_t003_014 u_t003_014/c0_w0_bl u_t003_014/c0_w0_br u_t003_014/c0_w1_bl u_t003_014/c0_w1_br u_t003_014/c0_r0_rbl
+ u_t003_014/c0_r1_rbl u_t003_014/c1_w0_bl u_t003_014/c1_w0_br u_t003_014/c1_w1_bl u_t003_014/c1_w1_br
+ u_t003_014/c1_r0_rbl u_t003_014/c1_r1_rbl u_t003_014/c2_w0_bl u_t003_014/c2_w0_br u_t003_014/c2_w1_bl
+ u_t003_014/c2_w1_br u_t003_014/c2_r0_rbl u_t003_014/c2_r1_rbl u_t003_014/c3_w0_bl u_t003_014/c3_w0_br
+ u_t003_014/c3_w1_bl u_t003_014/c3_w1_br u_t003_014/c3_r0_rbl u_t003_014/c3_r1_rbl u_t003_014/r0_w0_wl
+ u_t003_014/r0_w1_wl u_t003_014/r0_r0_rwl u_t003_014/r0_r1_rwl u_t003_014/r1_w0_wl u_t003_014/r1_w1_wl
+ u_t003_014/r1_r0_rwl u_t003_014/r1_r1_rwl u_t003_014/r2_w0_wl u_t003_014/r2_w1_wl u_t003_014/r2_r0_rwl
+ u_t003_014/r2_r1_rwl u_t003_014/r3_w0_wl u_t003_014/r3_w1_wl u_t003_014/r3_r0_rwl u_t003_014/r3_r1_rwl VDD VSS VSUBS
+ detronyx_12t_2w2r_rc4_4x4_routed_5layer_direct
Xu_t006_000 u_t006_000/c0_w0_bl u_t006_000/c0_w0_br u_t006_000/c0_w1_bl u_t006_000/c0_w1_br u_t006_000/c0_r0_rbl
+ u_t006_000/c0_r1_rbl u_t006_000/c1_w0_bl u_t006_000/c1_w0_br u_t006_000/c1_w1_bl u_t006_000/c1_w1_br
+ u_t006_000/c1_r0_rbl u_t006_000/c1_r1_rbl u_t006_000/c2_w0_bl u_t006_000/c2_w0_br u_t006_000/c2_w1_bl
+ u_t006_000/c2_w1_br u_t006_000/c2_r0_rbl u_t006_000/c2_r1_rbl u_t006_000/c3_w0_bl u_t006_000/c3_w0_br
+ u_t006_000/c3_w1_bl u_t006_000/c3_w1_br u_t006_000/c3_r0_rbl u_t006_000/c3_r1_rbl u_t006_000/r0_w0_wl
+ u_t006_000/r0_w1_wl u_t006_000/r0_r0_rwl u_t006_000/r0_r1_rwl u_t006_000/r1_w0_wl u_t006_000/r1_w1_wl
+ u_t006_000/r1_r0_rwl u_t006_000/r1_r1_rwl u_t006_000/r2_w0_wl u_t006_000/r2_w1_wl u_t006_000/r2_r0_rwl
+ u_t006_000/r2_r1_rwl u_t006_000/r3_w0_wl u_t006_000/r3_w1_wl u_t006_000/r3_r0_rwl u_t006_000/r3_r1_rwl VDD VSS VSUBS
+ detronyx_12t_2w2r_rc4_4x4_routed_5layer_direct
Xu_t000_006 u_t000_006/c0_w0_bl u_t000_006/c0_w0_br u_t000_006/c0_w1_bl u_t000_006/c0_w1_br u_t000_006/c0_r0_rbl
+ u_t000_006/c0_r1_rbl u_t000_006/c1_w0_bl u_t000_006/c1_w0_br u_t000_006/c1_w1_bl u_t000_006/c1_w1_br
+ u_t000_006/c1_r0_rbl u_t000_006/c1_r1_rbl u_t000_006/c2_w0_bl u_t000_006/c2_w0_br u_t000_006/c2_w1_bl
+ u_t000_006/c2_w1_br u_t000_006/c2_r0_rbl u_t000_006/c2_r1_rbl u_t000_006/c3_w0_bl u_t000_006/c3_w0_br
+ u_t000_006/c3_w1_bl u_t000_006/c3_w1_br u_t000_006/c3_r0_rbl u_t000_006/c3_r1_rbl u_t000_006/r0_w0_wl
+ u_t000_006/r0_w1_wl u_t000_006/r0_r0_rwl u_t000_006/r0_r1_rwl u_t000_006/r1_w0_wl u_t000_006/r1_w1_wl
+ u_t000_006/r1_r0_rwl u_t000_006/r1_r1_rwl u_t000_006/r2_w0_wl u_t000_006/r2_w1_wl u_t000_006/r2_r0_rwl
+ u_t000_006/r2_r1_rwl u_t000_006/r3_w0_wl u_t000_006/r3_w1_wl u_t000_006/r3_r0_rwl u_t000_006/r3_r1_rwl VDD VSS VSUBS
+ detronyx_12t_2w2r_rc4_4x4_routed_5layer_direct
Xu_t015_012 u_t015_012/c0_w0_bl u_t015_012/c0_w0_br u_t015_012/c0_w1_bl u_t015_012/c0_w1_br u_t015_012/c0_r0_rbl
+ u_t015_012/c0_r1_rbl u_t015_012/c1_w0_bl u_t015_012/c1_w0_br u_t015_012/c1_w1_bl u_t015_012/c1_w1_br
+ u_t015_012/c1_r0_rbl u_t015_012/c1_r1_rbl u_t015_012/c2_w0_bl u_t015_012/c2_w0_br u_t015_012/c2_w1_bl
+ u_t015_012/c2_w1_br u_t015_012/c2_r0_rbl u_t015_012/c2_r1_rbl u_t015_012/c3_w0_bl u_t015_012/c3_w0_br
+ u_t015_012/c3_w1_bl u_t015_012/c3_w1_br u_t015_012/c3_r0_rbl u_t015_012/c3_r1_rbl u_t015_012/r0_w0_wl
+ u_t015_012/r0_w1_wl u_t015_012/r0_r0_rwl u_t015_012/r0_r1_rwl u_t015_012/r1_w0_wl u_t015_012/r1_w1_wl
+ u_t015_012/r1_r0_rwl u_t015_012/r1_r1_rwl u_t015_012/r2_w0_wl u_t015_012/r2_w1_wl u_t015_012/r2_r0_rwl
+ u_t015_012/r2_r1_rwl u_t015_012/r3_w0_wl u_t015_012/r3_w1_wl u_t015_012/r3_r0_rwl u_t015_012/r3_r1_rwl VDD VSS VSUBS
+ detronyx_12t_2w2r_rc4_4x4_routed_5layer_direct
Xu_t015_001 u_t015_001/c0_w0_bl u_t015_001/c0_w0_br u_t015_001/c0_w1_bl u_t015_001/c0_w1_br u_t015_001/c0_r0_rbl
+ u_t015_001/c0_r1_rbl u_t015_001/c1_w0_bl u_t015_001/c1_w0_br u_t015_001/c1_w1_bl u_t015_001/c1_w1_br
+ u_t015_001/c1_r0_rbl u_t015_001/c1_r1_rbl u_t015_001/c2_w0_bl u_t015_001/c2_w0_br u_t015_001/c2_w1_bl
+ u_t015_001/c2_w1_br u_t015_001/c2_r0_rbl u_t015_001/c2_r1_rbl u_t015_001/c3_w0_bl u_t015_001/c3_w0_br
+ u_t015_001/c3_w1_bl u_t015_001/c3_w1_br u_t015_001/c3_r0_rbl u_t015_001/c3_r1_rbl u_t015_001/r0_w0_wl
+ u_t015_001/r0_w1_wl u_t015_001/r0_r0_rwl u_t015_001/r0_r1_rwl u_t015_001/r1_w0_wl u_t015_001/r1_w1_wl
+ u_t015_001/r1_r0_rwl u_t015_001/r1_r1_rwl u_t015_001/r2_w0_wl u_t015_001/r2_w1_wl u_t015_001/r2_r0_rwl
+ u_t015_001/r2_r1_rwl u_t015_001/r3_w0_wl u_t015_001/r3_w1_wl u_t015_001/r3_r0_rwl u_t015_001/r3_r1_rwl VDD VSS VSUBS
+ detronyx_12t_2w2r_rc4_4x4_routed_5layer_direct
Xu_t012_015 u_t012_015/c0_w0_bl u_t012_015/c0_w0_br u_t012_015/c0_w1_bl u_t012_015/c0_w1_br u_t012_015/c0_r0_rbl
+ u_t012_015/c0_r1_rbl u_t012_015/c1_w0_bl u_t012_015/c1_w0_br u_t012_015/c1_w1_bl u_t012_015/c1_w1_br
+ u_t012_015/c1_r0_rbl u_t012_015/c1_r1_rbl u_t012_015/c2_w0_bl u_t012_015/c2_w0_br u_t012_015/c2_w1_bl
+ u_t012_015/c2_w1_br u_t012_015/c2_r0_rbl u_t012_015/c2_r1_rbl u_t012_015/c3_w0_bl u_t012_015/c3_w0_br
+ u_t012_015/c3_w1_bl u_t012_015/c3_w1_br u_t012_015/c3_r0_rbl u_t012_015/c3_r1_rbl u_t012_015/r0_w0_wl
+ u_t012_015/r0_w1_wl u_t012_015/r0_r0_rwl u_t012_015/r0_r1_rwl u_t012_015/r1_w0_wl u_t012_015/r1_w1_wl
+ u_t012_015/r1_r0_rwl u_t012_015/r1_r1_rwl u_t012_015/r2_w0_wl u_t012_015/r2_w1_wl u_t012_015/r2_r0_rwl
+ u_t012_015/r2_r1_rwl u_t012_015/r3_w0_wl u_t012_015/r3_w1_wl u_t012_015/r3_r0_rwl u_t012_015/r3_r1_rwl VDD VSS VSUBS
+ detronyx_12t_2w2r_rc4_4x4_routed_5layer_direct
Xu_t012_004 u_t012_004/c0_w0_bl u_t012_004/c0_w0_br u_t012_004/c0_w1_bl u_t012_004/c0_w1_br u_t012_004/c0_r0_rbl
+ u_t012_004/c0_r1_rbl u_t012_004/c1_w0_bl u_t012_004/c1_w0_br u_t012_004/c1_w1_bl u_t012_004/c1_w1_br
+ u_t012_004/c1_r0_rbl u_t012_004/c1_r1_rbl u_t012_004/c2_w0_bl u_t012_004/c2_w0_br u_t012_004/c2_w1_bl
+ u_t012_004/c2_w1_br u_t012_004/c2_r0_rbl u_t012_004/c2_r1_rbl u_t012_004/c3_w0_bl u_t012_004/c3_w0_br
+ u_t012_004/c3_w1_bl u_t012_004/c3_w1_br u_t012_004/c3_r0_rbl u_t012_004/c3_r1_rbl u_t012_004/r0_w0_wl
+ u_t012_004/r0_w1_wl u_t012_004/r0_r0_rwl u_t012_004/r0_r1_rwl u_t012_004/r1_w0_wl u_t012_004/r1_w1_wl
+ u_t012_004/r1_r0_rwl u_t012_004/r1_r1_rwl u_t012_004/r2_w0_wl u_t012_004/r2_w1_wl u_t012_004/r2_r0_rwl
+ u_t012_004/r2_r1_rwl u_t012_004/r3_w0_wl u_t012_004/r3_w1_wl u_t012_004/r3_r0_rwl u_t012_004/r3_r1_rwl VDD VSS VSUBS
+ detronyx_12t_2w2r_rc4_4x4_routed_5layer_direct
Xu_t006_012 u_t006_012/c0_w0_bl u_t006_012/c0_w0_br u_t006_012/c0_w1_bl u_t006_012/c0_w1_br u_t006_012/c0_r0_rbl
+ u_t006_012/c0_r1_rbl u_t006_012/c1_w0_bl u_t006_012/c1_w0_br u_t006_012/c1_w1_bl u_t006_012/c1_w1_br
+ u_t006_012/c1_r0_rbl u_t006_012/c1_r1_rbl u_t006_012/c2_w0_bl u_t006_012/c2_w0_br u_t006_012/c2_w1_bl
+ u_t006_012/c2_w1_br u_t006_012/c2_r0_rbl u_t006_012/c2_r1_rbl u_t006_012/c3_w0_bl u_t006_012/c3_w0_br
+ u_t006_012/c3_w1_bl u_t006_012/c3_w1_br u_t006_012/c3_r0_rbl u_t006_012/c3_r1_rbl u_t006_012/r0_w0_wl
+ u_t006_012/r0_w1_wl u_t006_012/r0_r0_rwl u_t006_012/r0_r1_rwl u_t006_012/r1_w0_wl u_t006_012/r1_w1_wl
+ u_t006_012/r1_r0_rwl u_t006_012/r1_r1_rwl u_t006_012/r2_w0_wl u_t006_012/r2_w1_wl u_t006_012/r2_r0_rwl
+ u_t006_012/r2_r1_rwl u_t006_012/r3_w0_wl u_t006_012/r3_w1_wl u_t006_012/r3_r0_rwl u_t006_012/r3_r1_rwl VDD VSS VSUBS
+ detronyx_12t_2w2r_rc4_4x4_routed_5layer_direct
Xu_t006_001 u_t006_001/c0_w0_bl u_t006_001/c0_w0_br u_t006_001/c0_w1_bl u_t006_001/c0_w1_br u_t006_001/c0_r0_rbl
+ u_t006_001/c0_r1_rbl u_t006_001/c1_w0_bl u_t006_001/c1_w0_br u_t006_001/c1_w1_bl u_t006_001/c1_w1_br
+ u_t006_001/c1_r0_rbl u_t006_001/c1_r1_rbl u_t006_001/c2_w0_bl u_t006_001/c2_w0_br u_t006_001/c2_w1_bl
+ u_t006_001/c2_w1_br u_t006_001/c2_r0_rbl u_t006_001/c2_r1_rbl u_t006_001/c3_w0_bl u_t006_001/c3_w0_br
+ u_t006_001/c3_w1_bl u_t006_001/c3_w1_br u_t006_001/c3_r0_rbl u_t006_001/c3_r1_rbl u_t006_001/r0_w0_wl
+ u_t006_001/r0_w1_wl u_t006_001/r0_r0_rwl u_t006_001/r0_r1_rwl u_t006_001/r1_w0_wl u_t006_001/r1_w1_wl
+ u_t006_001/r1_r0_rwl u_t006_001/r1_r1_rwl u_t006_001/r2_w0_wl u_t006_001/r2_w1_wl u_t006_001/r2_r0_rwl
+ u_t006_001/r2_r1_rwl u_t006_001/r3_w0_wl u_t006_001/r3_w1_wl u_t006_001/r3_r0_rwl u_t006_001/r3_r1_rwl VDD VSS VSUBS
+ detronyx_12t_2w2r_rc4_4x4_routed_5layer_direct
Xu_t000_007 u_t000_007/c0_w0_bl u_t000_007/c0_w0_br u_t000_007/c0_w1_bl u_t000_007/c0_w1_br u_t000_007/c0_r0_rbl
+ u_t000_007/c0_r1_rbl u_t000_007/c1_w0_bl u_t000_007/c1_w0_br u_t000_007/c1_w1_bl u_t000_007/c1_w1_br
+ u_t000_007/c1_r0_rbl u_t000_007/c1_r1_rbl u_t000_007/c2_w0_bl u_t000_007/c2_w0_br u_t000_007/c2_w1_bl
+ u_t000_007/c2_w1_br u_t000_007/c2_r0_rbl u_t000_007/c2_r1_rbl u_t000_007/c3_w0_bl u_t000_007/c3_w0_br
+ u_t000_007/c3_w1_bl u_t000_007/c3_w1_br u_t000_007/c3_r0_rbl u_t000_007/c3_r1_rbl u_t000_007/r0_w0_wl
+ u_t000_007/r0_w1_wl u_t000_007/r0_r0_rwl u_t000_007/r0_r1_rwl u_t000_007/r1_w0_wl u_t000_007/r1_w1_wl
+ u_t000_007/r1_r0_rwl u_t000_007/r1_r1_rwl u_t000_007/r2_w0_wl u_t000_007/r2_w1_wl u_t000_007/r2_r0_rwl
+ u_t000_007/r2_r1_rwl u_t000_007/r3_w0_wl u_t000_007/r3_w1_wl u_t000_007/r3_r0_rwl u_t000_007/r3_r1_rwl VDD VSS VSUBS
+ detronyx_12t_2w2r_rc4_4x4_routed_5layer_direct
Xu_t003_004 u_t003_004/c0_w0_bl u_t003_004/c0_w0_br u_t003_004/c0_w1_bl u_t003_004/c0_w1_br u_t003_004/c0_r0_rbl
+ u_t003_004/c0_r1_rbl u_t003_004/c1_w0_bl u_t003_004/c1_w0_br u_t003_004/c1_w1_bl u_t003_004/c1_w1_br
+ u_t003_004/c1_r0_rbl u_t003_004/c1_r1_rbl u_t003_004/c2_w0_bl u_t003_004/c2_w0_br u_t003_004/c2_w1_bl
+ u_t003_004/c2_w1_br u_t003_004/c2_r0_rbl u_t003_004/c2_r1_rbl u_t003_004/c3_w0_bl u_t003_004/c3_w0_br
+ u_t003_004/c3_w1_bl u_t003_004/c3_w1_br u_t003_004/c3_r0_rbl u_t003_004/c3_r1_rbl u_t003_004/r0_w0_wl
+ u_t003_004/r0_w1_wl u_t003_004/r0_r0_rwl u_t003_004/r0_r1_rwl u_t003_004/r1_w0_wl u_t003_004/r1_w1_wl
+ u_t003_004/r1_r0_rwl u_t003_004/r1_r1_rwl u_t003_004/r2_w0_wl u_t003_004/r2_w1_wl u_t003_004/r2_r0_rwl
+ u_t003_004/r2_r1_rwl u_t003_004/r3_w0_wl u_t003_004/r3_w1_wl u_t003_004/r3_r0_rwl u_t003_004/r3_r1_rwl VDD VSS VSUBS
+ detronyx_12t_2w2r_rc4_4x4_routed_5layer_direct
Xu_t003_015 u_t003_015/c0_w0_bl u_t003_015/c0_w0_br u_t003_015/c0_w1_bl u_t003_015/c0_w1_br u_t003_015/c0_r0_rbl
+ u_t003_015/c0_r1_rbl u_t003_015/c1_w0_bl u_t003_015/c1_w0_br u_t003_015/c1_w1_bl u_t003_015/c1_w1_br
+ u_t003_015/c1_r0_rbl u_t003_015/c1_r1_rbl u_t003_015/c2_w0_bl u_t003_015/c2_w0_br u_t003_015/c2_w1_bl
+ u_t003_015/c2_w1_br u_t003_015/c2_r0_rbl u_t003_015/c2_r1_rbl u_t003_015/c3_w0_bl u_t003_015/c3_w0_br
+ u_t003_015/c3_w1_bl u_t003_015/c3_w1_br u_t003_015/c3_r0_rbl u_t003_015/c3_r1_rbl u_t003_015/r0_w0_wl
+ u_t003_015/r0_w1_wl u_t003_015/r0_r0_rwl u_t003_015/r0_r1_rwl u_t003_015/r1_w0_wl u_t003_015/r1_w1_wl
+ u_t003_015/r1_r0_rwl u_t003_015/r1_r1_rwl u_t003_015/r2_w0_wl u_t003_015/r2_w1_wl u_t003_015/r2_r0_rwl
+ u_t003_015/r2_r1_rwl u_t003_015/r3_w0_wl u_t003_015/r3_w1_wl u_t003_015/r3_r0_rwl u_t003_015/r3_r1_rwl VDD VSS VSUBS
+ detronyx_12t_2w2r_rc4_4x4_routed_5layer_direct
Xu_t009_010 u_t009_010/c0_w0_bl u_t009_010/c0_w0_br u_t009_010/c0_w1_bl u_t009_010/c0_w1_br u_t009_010/c0_r0_rbl
+ u_t009_010/c0_r1_rbl u_t009_010/c1_w0_bl u_t009_010/c1_w0_br u_t009_010/c1_w1_bl u_t009_010/c1_w1_br
+ u_t009_010/c1_r0_rbl u_t009_010/c1_r1_rbl u_t009_010/c2_w0_bl u_t009_010/c2_w0_br u_t009_010/c2_w1_bl
+ u_t009_010/c2_w1_br u_t009_010/c2_r0_rbl u_t009_010/c2_r1_rbl u_t009_010/c3_w0_bl u_t009_010/c3_w0_br
+ u_t009_010/c3_w1_bl u_t009_010/c3_w1_br u_t009_010/c3_r0_rbl u_t009_010/c3_r1_rbl u_t009_010/r0_w0_wl
+ u_t009_010/r0_w1_wl u_t009_010/r0_r0_rwl u_t009_010/r0_r1_rwl u_t009_010/r1_w0_wl u_t009_010/r1_w1_wl
+ u_t009_010/r1_r0_rwl u_t009_010/r1_r1_rwl u_t009_010/r2_w0_wl u_t009_010/r2_w1_wl u_t009_010/r2_r0_rwl
+ u_t009_010/r2_r1_rwl u_t009_010/r3_w0_wl u_t009_010/r3_w1_wl u_t009_010/r3_r0_rwl u_t009_010/r3_r1_rwl VDD VSS VSUBS
+ detronyx_12t_2w2r_rc4_4x4_routed_5layer_direct
Xu_t015_013 u_t015_013/c0_w0_bl u_t015_013/c0_w0_br u_t015_013/c0_w1_bl u_t015_013/c0_w1_br u_t015_013/c0_r0_rbl
+ u_t015_013/c0_r1_rbl u_t015_013/c1_w0_bl u_t015_013/c1_w0_br u_t015_013/c1_w1_bl u_t015_013/c1_w1_br
+ u_t015_013/c1_r0_rbl u_t015_013/c1_r1_rbl u_t015_013/c2_w0_bl u_t015_013/c2_w0_br u_t015_013/c2_w1_bl
+ u_t015_013/c2_w1_br u_t015_013/c2_r0_rbl u_t015_013/c2_r1_rbl u_t015_013/c3_w0_bl u_t015_013/c3_w0_br
+ u_t015_013/c3_w1_bl u_t015_013/c3_w1_br u_t015_013/c3_r0_rbl u_t015_013/c3_r1_rbl u_t015_013/r0_w0_wl
+ u_t015_013/r0_w1_wl u_t015_013/r0_r0_rwl u_t015_013/r0_r1_rwl u_t015_013/r1_w0_wl u_t015_013/r1_w1_wl
+ u_t015_013/r1_r0_rwl u_t015_013/r1_r1_rwl u_t015_013/r2_w0_wl u_t015_013/r2_w1_wl u_t015_013/r2_r0_rwl
+ u_t015_013/r2_r1_rwl u_t015_013/r3_w0_wl u_t015_013/r3_w1_wl u_t015_013/r3_r0_rwl u_t015_013/r3_r1_rwl VDD VSS VSUBS
+ detronyx_12t_2w2r_rc4_4x4_routed_5layer_direct
Xu_t015_002 u_t015_002/c0_w0_bl u_t015_002/c0_w0_br u_t015_002/c0_w1_bl u_t015_002/c0_w1_br u_t015_002/c0_r0_rbl
+ u_t015_002/c0_r1_rbl u_t015_002/c1_w0_bl u_t015_002/c1_w0_br u_t015_002/c1_w1_bl u_t015_002/c1_w1_br
+ u_t015_002/c1_r0_rbl u_t015_002/c1_r1_rbl u_t015_002/c2_w0_bl u_t015_002/c2_w0_br u_t015_002/c2_w1_bl
+ u_t015_002/c2_w1_br u_t015_002/c2_r0_rbl u_t015_002/c2_r1_rbl u_t015_002/c3_w0_bl u_t015_002/c3_w0_br
+ u_t015_002/c3_w1_bl u_t015_002/c3_w1_br u_t015_002/c3_r0_rbl u_t015_002/c3_r1_rbl u_t015_002/r0_w0_wl
+ u_t015_002/r0_w1_wl u_t015_002/r0_r0_rwl u_t015_002/r0_r1_rwl u_t015_002/r1_w0_wl u_t015_002/r1_w1_wl
+ u_t015_002/r1_r0_rwl u_t015_002/r1_r1_rwl u_t015_002/r2_w0_wl u_t015_002/r2_w1_wl u_t015_002/r2_r0_rwl
+ u_t015_002/r2_r1_rwl u_t015_002/r3_w0_wl u_t015_002/r3_w1_wl u_t015_002/r3_r0_rwl u_t015_002/r3_r1_rwl VDD VSS VSUBS
+ detronyx_12t_2w2r_rc4_4x4_routed_5layer_direct
Xu_t012_005 u_t012_005/c0_w0_bl u_t012_005/c0_w0_br u_t012_005/c0_w1_bl u_t012_005/c0_w1_br u_t012_005/c0_r0_rbl
+ u_t012_005/c0_r1_rbl u_t012_005/c1_w0_bl u_t012_005/c1_w0_br u_t012_005/c1_w1_bl u_t012_005/c1_w1_br
+ u_t012_005/c1_r0_rbl u_t012_005/c1_r1_rbl u_t012_005/c2_w0_bl u_t012_005/c2_w0_br u_t012_005/c2_w1_bl
+ u_t012_005/c2_w1_br u_t012_005/c2_r0_rbl u_t012_005/c2_r1_rbl u_t012_005/c3_w0_bl u_t012_005/c3_w0_br
+ u_t012_005/c3_w1_bl u_t012_005/c3_w1_br u_t012_005/c3_r0_rbl u_t012_005/c3_r1_rbl u_t012_005/r0_w0_wl
+ u_t012_005/r0_w1_wl u_t012_005/r0_r0_rwl u_t012_005/r0_r1_rwl u_t012_005/r1_w0_wl u_t012_005/r1_w1_wl
+ u_t012_005/r1_r0_rwl u_t012_005/r1_r1_rwl u_t012_005/r2_w0_wl u_t012_005/r2_w1_wl u_t012_005/r2_r0_rwl
+ u_t012_005/r2_r1_rwl u_t012_005/r3_w0_wl u_t012_005/r3_w1_wl u_t012_005/r3_r0_rwl u_t012_005/r3_r1_rwl VDD VSS VSUBS
+ detronyx_12t_2w2r_rc4_4x4_routed_5layer_direct
Xu_t006_013 u_t006_013/c0_w0_bl u_t006_013/c0_w0_br u_t006_013/c0_w1_bl u_t006_013/c0_w1_br u_t006_013/c0_r0_rbl
+ u_t006_013/c0_r1_rbl u_t006_013/c1_w0_bl u_t006_013/c1_w0_br u_t006_013/c1_w1_bl u_t006_013/c1_w1_br
+ u_t006_013/c1_r0_rbl u_t006_013/c1_r1_rbl u_t006_013/c2_w0_bl u_t006_013/c2_w0_br u_t006_013/c2_w1_bl
+ u_t006_013/c2_w1_br u_t006_013/c2_r0_rbl u_t006_013/c2_r1_rbl u_t006_013/c3_w0_bl u_t006_013/c3_w0_br
+ u_t006_013/c3_w1_bl u_t006_013/c3_w1_br u_t006_013/c3_r0_rbl u_t006_013/c3_r1_rbl u_t006_013/r0_w0_wl
+ u_t006_013/r0_w1_wl u_t006_013/r0_r0_rwl u_t006_013/r0_r1_rwl u_t006_013/r1_w0_wl u_t006_013/r1_w1_wl
+ u_t006_013/r1_r0_rwl u_t006_013/r1_r1_rwl u_t006_013/r2_w0_wl u_t006_013/r2_w1_wl u_t006_013/r2_r0_rwl
+ u_t006_013/r2_r1_rwl u_t006_013/r3_w0_wl u_t006_013/r3_w1_wl u_t006_013/r3_r0_rwl u_t006_013/r3_r1_rwl VDD VSS VSUBS
+ detronyx_12t_2w2r_rc4_4x4_routed_5layer_direct
Xu_t003_005 u_t003_005/c0_w0_bl u_t003_005/c0_w0_br u_t003_005/c0_w1_bl u_t003_005/c0_w1_br u_t003_005/c0_r0_rbl
+ u_t003_005/c0_r1_rbl u_t003_005/c1_w0_bl u_t003_005/c1_w0_br u_t003_005/c1_w1_bl u_t003_005/c1_w1_br
+ u_t003_005/c1_r0_rbl u_t003_005/c1_r1_rbl u_t003_005/c2_w0_bl u_t003_005/c2_w0_br u_t003_005/c2_w1_bl
+ u_t003_005/c2_w1_br u_t003_005/c2_r0_rbl u_t003_005/c2_r1_rbl u_t003_005/c3_w0_bl u_t003_005/c3_w0_br
+ u_t003_005/c3_w1_bl u_t003_005/c3_w1_br u_t003_005/c3_r0_rbl u_t003_005/c3_r1_rbl u_t003_005/r0_w0_wl
+ u_t003_005/r0_w1_wl u_t003_005/r0_r0_rwl u_t003_005/r0_r1_rwl u_t003_005/r1_w0_wl u_t003_005/r1_w1_wl
+ u_t003_005/r1_r0_rwl u_t003_005/r1_r1_rwl u_t003_005/r2_w0_wl u_t003_005/r2_w1_wl u_t003_005/r2_r0_rwl
+ u_t003_005/r2_r1_rwl u_t003_005/r3_w0_wl u_t003_005/r3_w1_wl u_t003_005/r3_r0_rwl u_t003_005/r3_r1_rwl VDD VSS VSUBS
+ detronyx_12t_2w2r_rc4_4x4_routed_5layer_direct
Xu_t006_002 u_t006_002/c0_w0_bl u_t006_002/c0_w0_br u_t006_002/c0_w1_bl u_t006_002/c0_w1_br u_t006_002/c0_r0_rbl
+ u_t006_002/c0_r1_rbl u_t006_002/c1_w0_bl u_t006_002/c1_w0_br u_t006_002/c1_w1_bl u_t006_002/c1_w1_br
+ u_t006_002/c1_r0_rbl u_t006_002/c1_r1_rbl u_t006_002/c2_w0_bl u_t006_002/c2_w0_br u_t006_002/c2_w1_bl
+ u_t006_002/c2_w1_br u_t006_002/c2_r0_rbl u_t006_002/c2_r1_rbl u_t006_002/c3_w0_bl u_t006_002/c3_w0_br
+ u_t006_002/c3_w1_bl u_t006_002/c3_w1_br u_t006_002/c3_r0_rbl u_t006_002/c3_r1_rbl u_t006_002/r0_w0_wl
+ u_t006_002/r0_w1_wl u_t006_002/r0_r0_rwl u_t006_002/r0_r1_rwl u_t006_002/r1_w0_wl u_t006_002/r1_w1_wl
+ u_t006_002/r1_r0_rwl u_t006_002/r1_r1_rwl u_t006_002/r2_w0_wl u_t006_002/r2_w1_wl u_t006_002/r2_r0_rwl
+ u_t006_002/r2_r1_rwl u_t006_002/r3_w0_wl u_t006_002/r3_w1_wl u_t006_002/r3_r0_rwl u_t006_002/r3_r1_rwl VDD VSS VSUBS
+ detronyx_12t_2w2r_rc4_4x4_routed_5layer_direct
Xu_t000_008 u_t000_008/c0_w0_bl u_t000_008/c0_w0_br u_t000_008/c0_w1_bl u_t000_008/c0_w1_br u_t000_008/c0_r0_rbl
+ u_t000_008/c0_r1_rbl u_t000_008/c1_w0_bl u_t000_008/c1_w0_br u_t000_008/c1_w1_bl u_t000_008/c1_w1_br
+ u_t000_008/c1_r0_rbl u_t000_008/c1_r1_rbl u_t000_008/c2_w0_bl u_t000_008/c2_w0_br u_t000_008/c2_w1_bl
+ u_t000_008/c2_w1_br u_t000_008/c2_r0_rbl u_t000_008/c2_r1_rbl u_t000_008/c3_w0_bl u_t000_008/c3_w0_br
+ u_t000_008/c3_w1_bl u_t000_008/c3_w1_br u_t000_008/c3_r0_rbl u_t000_008/c3_r1_rbl u_t000_008/r0_w0_wl
+ u_t000_008/r0_w1_wl u_t000_008/r0_r0_rwl u_t000_008/r0_r1_rwl u_t000_008/r1_w0_wl u_t000_008/r1_w1_wl
+ u_t000_008/r1_r0_rwl u_t000_008/r1_r1_rwl u_t000_008/r2_w0_wl u_t000_008/r2_w1_wl u_t000_008/r2_r0_rwl
+ u_t000_008/r2_r1_rwl u_t000_008/r3_w0_wl u_t000_008/r3_w1_wl u_t000_008/r3_r0_rwl u_t000_008/r3_r1_rwl VDD VSS VSUBS
+ detronyx_12t_2w2r_rc4_4x4_routed_5layer_direct
Xu_t015_014 u_t015_014/c0_w0_bl u_t015_014/c0_w0_br u_t015_014/c0_w1_bl u_t015_014/c0_w1_br u_t015_014/c0_r0_rbl
+ u_t015_014/c0_r1_rbl u_t015_014/c1_w0_bl u_t015_014/c1_w0_br u_t015_014/c1_w1_bl u_t015_014/c1_w1_br
+ u_t015_014/c1_r0_rbl u_t015_014/c1_r1_rbl u_t015_014/c2_w0_bl u_t015_014/c2_w0_br u_t015_014/c2_w1_bl
+ u_t015_014/c2_w1_br u_t015_014/c2_r0_rbl u_t015_014/c2_r1_rbl u_t015_014/c3_w0_bl u_t015_014/c3_w0_br
+ u_t015_014/c3_w1_bl u_t015_014/c3_w1_br u_t015_014/c3_r0_rbl u_t015_014/c3_r1_rbl u_t015_014/r0_w0_wl
+ u_t015_014/r0_w1_wl u_t015_014/r0_r0_rwl u_t015_014/r0_r1_rwl u_t015_014/r1_w0_wl u_t015_014/r1_w1_wl
+ u_t015_014/r1_r0_rwl u_t015_014/r1_r1_rwl u_t015_014/r2_w0_wl u_t015_014/r2_w1_wl u_t015_014/r2_r0_rwl
+ u_t015_014/r2_r1_rwl u_t015_014/r3_w0_wl u_t015_014/r3_w1_wl u_t015_014/r3_r0_rwl u_t015_014/r3_r1_rwl VDD VSS VSUBS
+ detronyx_12t_2w2r_rc4_4x4_routed_5layer_direct
Xu_t015_003 u_t015_003/c0_w0_bl u_t015_003/c0_w0_br u_t015_003/c0_w1_bl u_t015_003/c0_w1_br u_t015_003/c0_r0_rbl
+ u_t015_003/c0_r1_rbl u_t015_003/c1_w0_bl u_t015_003/c1_w0_br u_t015_003/c1_w1_bl u_t015_003/c1_w1_br
+ u_t015_003/c1_r0_rbl u_t015_003/c1_r1_rbl u_t015_003/c2_w0_bl u_t015_003/c2_w0_br u_t015_003/c2_w1_bl
+ u_t015_003/c2_w1_br u_t015_003/c2_r0_rbl u_t015_003/c2_r1_rbl u_t015_003/c3_w0_bl u_t015_003/c3_w0_br
+ u_t015_003/c3_w1_bl u_t015_003/c3_w1_br u_t015_003/c3_r0_rbl u_t015_003/c3_r1_rbl u_t015_003/r0_w0_wl
+ u_t015_003/r0_w1_wl u_t015_003/r0_r0_rwl u_t015_003/r0_r1_rwl u_t015_003/r1_w0_wl u_t015_003/r1_w1_wl
+ u_t015_003/r1_r0_rwl u_t015_003/r1_r1_rwl u_t015_003/r2_w0_wl u_t015_003/r2_w1_wl u_t015_003/r2_r0_rwl
+ u_t015_003/r2_r1_rwl u_t015_003/r3_w0_wl u_t015_003/r3_w1_wl u_t015_003/r3_r0_rwl u_t015_003/r3_r1_rwl VDD VSS VSUBS
+ detronyx_12t_2w2r_rc4_4x4_routed_5layer_direct
Xu_t009_011 u_t009_011/c0_w0_bl u_t009_011/c0_w0_br u_t009_011/c0_w1_bl u_t009_011/c0_w1_br u_t009_011/c0_r0_rbl
+ u_t009_011/c0_r1_rbl u_t009_011/c1_w0_bl u_t009_011/c1_w0_br u_t009_011/c1_w1_bl u_t009_011/c1_w1_br
+ u_t009_011/c1_r0_rbl u_t009_011/c1_r1_rbl u_t009_011/c2_w0_bl u_t009_011/c2_w0_br u_t009_011/c2_w1_bl
+ u_t009_011/c2_w1_br u_t009_011/c2_r0_rbl u_t009_011/c2_r1_rbl u_t009_011/c3_w0_bl u_t009_011/c3_w0_br
+ u_t009_011/c3_w1_bl u_t009_011/c3_w1_br u_t009_011/c3_r0_rbl u_t009_011/c3_r1_rbl u_t009_011/r0_w0_wl
+ u_t009_011/r0_w1_wl u_t009_011/r0_r0_rwl u_t009_011/r0_r1_rwl u_t009_011/r1_w0_wl u_t009_011/r1_w1_wl
+ u_t009_011/r1_r0_rwl u_t009_011/r1_r1_rwl u_t009_011/r2_w0_wl u_t009_011/r2_w1_wl u_t009_011/r2_r0_rwl
+ u_t009_011/r2_r1_rwl u_t009_011/r3_w0_wl u_t009_011/r3_w1_wl u_t009_011/r3_r0_rwl u_t009_011/r3_r1_rwl VDD VSS VSUBS
+ detronyx_12t_2w2r_rc4_4x4_routed_5layer_direct
Xu_t009_000 u_t009_000/c0_w0_bl u_t009_000/c0_w0_br u_t009_000/c0_w1_bl u_t009_000/c0_w1_br u_t009_000/c0_r0_rbl
+ u_t009_000/c0_r1_rbl u_t009_000/c1_w0_bl u_t009_000/c1_w0_br u_t009_000/c1_w1_bl u_t009_000/c1_w1_br
+ u_t009_000/c1_r0_rbl u_t009_000/c1_r1_rbl u_t009_000/c2_w0_bl u_t009_000/c2_w0_br u_t009_000/c2_w1_bl
+ u_t009_000/c2_w1_br u_t009_000/c2_r0_rbl u_t009_000/c2_r1_rbl u_t009_000/c3_w0_bl u_t009_000/c3_w0_br
+ u_t009_000/c3_w1_bl u_t009_000/c3_w1_br u_t009_000/c3_r0_rbl u_t009_000/c3_r1_rbl u_t009_000/r0_w0_wl
+ u_t009_000/r0_w1_wl u_t009_000/r0_r0_rwl u_t009_000/r0_r1_rwl u_t009_000/r1_w0_wl u_t009_000/r1_w1_wl
+ u_t009_000/r1_r0_rwl u_t009_000/r1_r1_rwl u_t009_000/r2_w0_wl u_t009_000/r2_w1_wl u_t009_000/r2_r0_rwl
+ u_t009_000/r2_r1_rwl u_t009_000/r3_w0_wl u_t009_000/r3_w1_wl u_t009_000/r3_r0_rwl u_t009_000/r3_r1_rwl VDD VSS VSUBS
+ detronyx_12t_2w2r_rc4_4x4_routed_5layer_direct
Xu_t006_014 u_t006_014/c0_w0_bl u_t006_014/c0_w0_br u_t006_014/c0_w1_bl u_t006_014/c0_w1_br u_t006_014/c0_r0_rbl
+ u_t006_014/c0_r1_rbl u_t006_014/c1_w0_bl u_t006_014/c1_w0_br u_t006_014/c1_w1_bl u_t006_014/c1_w1_br
+ u_t006_014/c1_r0_rbl u_t006_014/c1_r1_rbl u_t006_014/c2_w0_bl u_t006_014/c2_w0_br u_t006_014/c2_w1_bl
+ u_t006_014/c2_w1_br u_t006_014/c2_r0_rbl u_t006_014/c2_r1_rbl u_t006_014/c3_w0_bl u_t006_014/c3_w0_br
+ u_t006_014/c3_w1_bl u_t006_014/c3_w1_br u_t006_014/c3_r0_rbl u_t006_014/c3_r1_rbl u_t006_014/r0_w0_wl
+ u_t006_014/r0_w1_wl u_t006_014/r0_r0_rwl u_t006_014/r0_r1_rwl u_t006_014/r1_w0_wl u_t006_014/r1_w1_wl
+ u_t006_014/r1_r0_rwl u_t006_014/r1_r1_rwl u_t006_014/r2_w0_wl u_t006_014/r2_w1_wl u_t006_014/r2_r0_rwl
+ u_t006_014/r2_r1_rwl u_t006_014/r3_w0_wl u_t006_014/r3_w1_wl u_t006_014/r3_r0_rwl u_t006_014/r3_r1_rwl VDD VSS VSUBS
+ detronyx_12t_2w2r_rc4_4x4_routed_5layer_direct
Xu_t006_003 u_t006_003/c0_w0_bl u_t006_003/c0_w0_br u_t006_003/c0_w1_bl u_t006_003/c0_w1_br u_t006_003/c0_r0_rbl
+ u_t006_003/c0_r1_rbl u_t006_003/c1_w0_bl u_t006_003/c1_w0_br u_t006_003/c1_w1_bl u_t006_003/c1_w1_br
+ u_t006_003/c1_r0_rbl u_t006_003/c1_r1_rbl u_t006_003/c2_w0_bl u_t006_003/c2_w0_br u_t006_003/c2_w1_bl
+ u_t006_003/c2_w1_br u_t006_003/c2_r0_rbl u_t006_003/c2_r1_rbl u_t006_003/c3_w0_bl u_t006_003/c3_w0_br
+ u_t006_003/c3_w1_bl u_t006_003/c3_w1_br u_t006_003/c3_r0_rbl u_t006_003/c3_r1_rbl u_t006_003/r0_w0_wl
+ u_t006_003/r0_w1_wl u_t006_003/r0_r0_rwl u_t006_003/r0_r1_rwl u_t006_003/r1_w0_wl u_t006_003/r1_w1_wl
+ u_t006_003/r1_r0_rwl u_t006_003/r1_r1_rwl u_t006_003/r2_w0_wl u_t006_003/r2_w1_wl u_t006_003/r2_r0_rwl
+ u_t006_003/r2_r1_rwl u_t006_003/r3_w0_wl u_t006_003/r3_w1_wl u_t006_003/r3_r0_rwl u_t006_003/r3_r1_rwl VDD VSS VSUBS
+ detronyx_12t_2w2r_rc4_4x4_routed_5layer_direct
Xu_t012_006 u_t012_006/c0_w0_bl u_t012_006/c0_w0_br u_t012_006/c0_w1_bl u_t012_006/c0_w1_br u_t012_006/c0_r0_rbl
+ u_t012_006/c0_r1_rbl u_t012_006/c1_w0_bl u_t012_006/c1_w0_br u_t012_006/c1_w1_bl u_t012_006/c1_w1_br
+ u_t012_006/c1_r0_rbl u_t012_006/c1_r1_rbl u_t012_006/c2_w0_bl u_t012_006/c2_w0_br u_t012_006/c2_w1_bl
+ u_t012_006/c2_w1_br u_t012_006/c2_r0_rbl u_t012_006/c2_r1_rbl u_t012_006/c3_w0_bl u_t012_006/c3_w0_br
+ u_t012_006/c3_w1_bl u_t012_006/c3_w1_br u_t012_006/c3_r0_rbl u_t012_006/c3_r1_rbl u_t012_006/r0_w0_wl
+ u_t012_006/r0_w1_wl u_t012_006/r0_r0_rwl u_t012_006/r0_r1_rwl u_t012_006/r1_w0_wl u_t012_006/r1_w1_wl
+ u_t012_006/r1_r0_rwl u_t012_006/r1_r1_rwl u_t012_006/r2_w0_wl u_t012_006/r2_w1_wl u_t012_006/r2_r0_rwl
+ u_t012_006/r2_r1_rwl u_t012_006/r3_w0_wl u_t012_006/r3_w1_wl u_t012_006/r3_r0_rwl u_t012_006/r3_r1_rwl VDD VSS VSUBS
+ detronyx_12t_2w2r_rc4_4x4_routed_5layer_direct
Xu_t000_009 u_t000_009/c0_w0_bl u_t000_009/c0_w0_br u_t000_009/c0_w1_bl u_t000_009/c0_w1_br u_t000_009/c0_r0_rbl
+ u_t000_009/c0_r1_rbl u_t000_009/c1_w0_bl u_t000_009/c1_w0_br u_t000_009/c1_w1_bl u_t000_009/c1_w1_br
+ u_t000_009/c1_r0_rbl u_t000_009/c1_r1_rbl u_t000_009/c2_w0_bl u_t000_009/c2_w0_br u_t000_009/c2_w1_bl
+ u_t000_009/c2_w1_br u_t000_009/c2_r0_rbl u_t000_009/c2_r1_rbl u_t000_009/c3_w0_bl u_t000_009/c3_w0_br
+ u_t000_009/c3_w1_bl u_t000_009/c3_w1_br u_t000_009/c3_r0_rbl u_t000_009/c3_r1_rbl u_t000_009/r0_w0_wl
+ u_t000_009/r0_w1_wl u_t000_009/r0_r0_rwl u_t000_009/r0_r1_rwl u_t000_009/r1_w0_wl u_t000_009/r1_w1_wl
+ u_t000_009/r1_r0_rwl u_t000_009/r1_r1_rwl u_t000_009/r2_w0_wl u_t000_009/r2_w1_wl u_t000_009/r2_r0_rwl
+ u_t000_009/r2_r1_rwl u_t000_009/r3_w0_wl u_t000_009/r3_w1_wl u_t000_009/r3_r0_rwl u_t000_009/r3_r1_rwl VDD VSS VSUBS
+ detronyx_12t_2w2r_rc4_4x4_routed_5layer_direct
Xu_t003_006 u_t003_006/c0_w0_bl u_t003_006/c0_w0_br u_t003_006/c0_w1_bl u_t003_006/c0_w1_br u_t003_006/c0_r0_rbl
+ u_t003_006/c0_r1_rbl u_t003_006/c1_w0_bl u_t003_006/c1_w0_br u_t003_006/c1_w1_bl u_t003_006/c1_w1_br
+ u_t003_006/c1_r0_rbl u_t003_006/c1_r1_rbl u_t003_006/c2_w0_bl u_t003_006/c2_w0_br u_t003_006/c2_w1_bl
+ u_t003_006/c2_w1_br u_t003_006/c2_r0_rbl u_t003_006/c2_r1_rbl u_t003_006/c3_w0_bl u_t003_006/c3_w0_br
+ u_t003_006/c3_w1_bl u_t003_006/c3_w1_br u_t003_006/c3_r0_rbl u_t003_006/c3_r1_rbl u_t003_006/r0_w0_wl
+ u_t003_006/r0_w1_wl u_t003_006/r0_r0_rwl u_t003_006/r0_r1_rwl u_t003_006/r1_w0_wl u_t003_006/r1_w1_wl
+ u_t003_006/r1_r0_rwl u_t003_006/r1_r1_rwl u_t003_006/r2_w0_wl u_t003_006/r2_w1_wl u_t003_006/r2_r0_rwl
+ u_t003_006/r2_r1_rwl u_t003_006/r3_w0_wl u_t003_006/r3_w1_wl u_t003_006/r3_r0_rwl u_t003_006/r3_r1_rwl VDD VSS VSUBS
+ detronyx_12t_2w2r_rc4_4x4_routed_5layer_direct
Xu_t009_012 u_t009_012/c0_w0_bl u_t009_012/c0_w0_br u_t009_012/c0_w1_bl u_t009_012/c0_w1_br u_t009_012/c0_r0_rbl
+ u_t009_012/c0_r1_rbl u_t009_012/c1_w0_bl u_t009_012/c1_w0_br u_t009_012/c1_w1_bl u_t009_012/c1_w1_br
+ u_t009_012/c1_r0_rbl u_t009_012/c1_r1_rbl u_t009_012/c2_w0_bl u_t009_012/c2_w0_br u_t009_012/c2_w1_bl
+ u_t009_012/c2_w1_br u_t009_012/c2_r0_rbl u_t009_012/c2_r1_rbl u_t009_012/c3_w0_bl u_t009_012/c3_w0_br
+ u_t009_012/c3_w1_bl u_t009_012/c3_w1_br u_t009_012/c3_r0_rbl u_t009_012/c3_r1_rbl u_t009_012/r0_w0_wl
+ u_t009_012/r0_w1_wl u_t009_012/r0_r0_rwl u_t009_012/r0_r1_rwl u_t009_012/r1_w0_wl u_t009_012/r1_w1_wl
+ u_t009_012/r1_r0_rwl u_t009_012/r1_r1_rwl u_t009_012/r2_w0_wl u_t009_012/r2_w1_wl u_t009_012/r2_r0_rwl
+ u_t009_012/r2_r1_rwl u_t009_012/r3_w0_wl u_t009_012/r3_w1_wl u_t009_012/r3_r0_rwl u_t009_012/r3_r1_rwl VDD VSS VSUBS
+ detronyx_12t_2w2r_rc4_4x4_routed_5layer_direct
Xu_t009_001 u_t009_001/c0_w0_bl u_t009_001/c0_w0_br u_t009_001/c0_w1_bl u_t009_001/c0_w1_br u_t009_001/c0_r0_rbl
+ u_t009_001/c0_r1_rbl u_t009_001/c1_w0_bl u_t009_001/c1_w0_br u_t009_001/c1_w1_bl u_t009_001/c1_w1_br
+ u_t009_001/c1_r0_rbl u_t009_001/c1_r1_rbl u_t009_001/c2_w0_bl u_t009_001/c2_w0_br u_t009_001/c2_w1_bl
+ u_t009_001/c2_w1_br u_t009_001/c2_r0_rbl u_t009_001/c2_r1_rbl u_t009_001/c3_w0_bl u_t009_001/c3_w0_br
+ u_t009_001/c3_w1_bl u_t009_001/c3_w1_br u_t009_001/c3_r0_rbl u_t009_001/c3_r1_rbl u_t009_001/r0_w0_wl
+ u_t009_001/r0_w1_wl u_t009_001/r0_r0_rwl u_t009_001/r0_r1_rwl u_t009_001/r1_w0_wl u_t009_001/r1_w1_wl
+ u_t009_001/r1_r0_rwl u_t009_001/r1_r1_rwl u_t009_001/r2_w0_wl u_t009_001/r2_w1_wl u_t009_001/r2_r0_rwl
+ u_t009_001/r2_r1_rwl u_t009_001/r3_w0_wl u_t009_001/r3_w1_wl u_t009_001/r3_r0_rwl u_t009_001/r3_r1_rwl VDD VSS VSUBS
+ detronyx_12t_2w2r_rc4_4x4_routed_5layer_direct
Xu_t015_015 u_t015_015/c0_w0_bl u_t015_015/c0_w0_br u_t015_015/c0_w1_bl u_t015_015/c0_w1_br u_t015_015/c0_r0_rbl
+ u_t015_015/c0_r1_rbl u_t015_015/c1_w0_bl u_t015_015/c1_w0_br u_t015_015/c1_w1_bl u_t015_015/c1_w1_br
+ u_t015_015/c1_r0_rbl u_t015_015/c1_r1_rbl u_t015_015/c2_w0_bl u_t015_015/c2_w0_br u_t015_015/c2_w1_bl
+ u_t015_015/c2_w1_br u_t015_015/c2_r0_rbl u_t015_015/c2_r1_rbl u_t015_015/c3_w0_bl u_t015_015/c3_w0_br
+ u_t015_015/c3_w1_bl u_t015_015/c3_w1_br u_t015_015/c3_r0_rbl u_t015_015/c3_r1_rbl u_t015_015/r0_w0_wl
+ u_t015_015/r0_w1_wl u_t015_015/r0_r0_rwl u_t015_015/r0_r1_rwl u_t015_015/r1_w0_wl u_t015_015/r1_w1_wl
+ u_t015_015/r1_r0_rwl u_t015_015/r1_r1_rwl u_t015_015/r2_w0_wl u_t015_015/r2_w1_wl u_t015_015/r2_r0_rwl
+ u_t015_015/r2_r1_rwl u_t015_015/r3_w0_wl u_t015_015/r3_w1_wl u_t015_015/r3_r0_rwl u_t015_015/r3_r1_rwl VDD VSS VSUBS
+ detronyx_12t_2w2r_rc4_4x4_routed_5layer_direct
Xu_t015_004 u_t015_004/c0_w0_bl u_t015_004/c0_w0_br u_t015_004/c0_w1_bl u_t015_004/c0_w1_br u_t015_004/c0_r0_rbl
+ u_t015_004/c0_r1_rbl u_t015_004/c1_w0_bl u_t015_004/c1_w0_br u_t015_004/c1_w1_bl u_t015_004/c1_w1_br
+ u_t015_004/c1_r0_rbl u_t015_004/c1_r1_rbl u_t015_004/c2_w0_bl u_t015_004/c2_w0_br u_t015_004/c2_w1_bl
+ u_t015_004/c2_w1_br u_t015_004/c2_r0_rbl u_t015_004/c2_r1_rbl u_t015_004/c3_w0_bl u_t015_004/c3_w0_br
+ u_t015_004/c3_w1_bl u_t015_004/c3_w1_br u_t015_004/c3_r0_rbl u_t015_004/c3_r1_rbl u_t015_004/r0_w0_wl
+ u_t015_004/r0_w1_wl u_t015_004/r0_r0_rwl u_t015_004/r0_r1_rwl u_t015_004/r1_w0_wl u_t015_004/r1_w1_wl
+ u_t015_004/r1_r0_rwl u_t015_004/r1_r1_rwl u_t015_004/r2_w0_wl u_t015_004/r2_w1_wl u_t015_004/r2_r0_rwl
+ u_t015_004/r2_r1_rwl u_t015_004/r3_w0_wl u_t015_004/r3_w1_wl u_t015_004/r3_r0_rwl u_t015_004/r3_r1_rwl VDD VSS VSUBS
+ detronyx_12t_2w2r_rc4_4x4_routed_5layer_direct
Xu_t012_007 u_t012_007/c0_w0_bl u_t012_007/c0_w0_br u_t012_007/c0_w1_bl u_t012_007/c0_w1_br u_t012_007/c0_r0_rbl
+ u_t012_007/c0_r1_rbl u_t012_007/c1_w0_bl u_t012_007/c1_w0_br u_t012_007/c1_w1_bl u_t012_007/c1_w1_br
+ u_t012_007/c1_r0_rbl u_t012_007/c1_r1_rbl u_t012_007/c2_w0_bl u_t012_007/c2_w0_br u_t012_007/c2_w1_bl
+ u_t012_007/c2_w1_br u_t012_007/c2_r0_rbl u_t012_007/c2_r1_rbl u_t012_007/c3_w0_bl u_t012_007/c3_w0_br
+ u_t012_007/c3_w1_bl u_t012_007/c3_w1_br u_t012_007/c3_r0_rbl u_t012_007/c3_r1_rbl u_t012_007/r0_w0_wl
+ u_t012_007/r0_w1_wl u_t012_007/r0_r0_rwl u_t012_007/r0_r1_rwl u_t012_007/r1_w0_wl u_t012_007/r1_w1_wl
+ u_t012_007/r1_r0_rwl u_t012_007/r1_r1_rwl u_t012_007/r2_w0_wl u_t012_007/r2_w1_wl u_t012_007/r2_r0_rwl
+ u_t012_007/r2_r1_rwl u_t012_007/r3_w0_wl u_t012_007/r3_w1_wl u_t012_007/r3_r0_rwl u_t012_007/r3_r1_rwl VDD VSS VSUBS
+ detronyx_12t_2w2r_rc4_4x4_routed_5layer_direct
Xu_t006_015 u_t006_015/c0_w0_bl u_t006_015/c0_w0_br u_t006_015/c0_w1_bl u_t006_015/c0_w1_br u_t006_015/c0_r0_rbl
+ u_t006_015/c0_r1_rbl u_t006_015/c1_w0_bl u_t006_015/c1_w0_br u_t006_015/c1_w1_bl u_t006_015/c1_w1_br
+ u_t006_015/c1_r0_rbl u_t006_015/c1_r1_rbl u_t006_015/c2_w0_bl u_t006_015/c2_w0_br u_t006_015/c2_w1_bl
+ u_t006_015/c2_w1_br u_t006_015/c2_r0_rbl u_t006_015/c2_r1_rbl u_t006_015/c3_w0_bl u_t006_015/c3_w0_br
+ u_t006_015/c3_w1_bl u_t006_015/c3_w1_br u_t006_015/c3_r0_rbl u_t006_015/c3_r1_rbl u_t006_015/r0_w0_wl
+ u_t006_015/r0_w1_wl u_t006_015/r0_r0_rwl u_t006_015/r0_r1_rwl u_t006_015/r1_w0_wl u_t006_015/r1_w1_wl
+ u_t006_015/r1_r0_rwl u_t006_015/r1_r1_rwl u_t006_015/r2_w0_wl u_t006_015/r2_w1_wl u_t006_015/r2_r0_rwl
+ u_t006_015/r2_r1_rwl u_t006_015/r3_w0_wl u_t006_015/r3_w1_wl u_t006_015/r3_r0_rwl u_t006_015/r3_r1_rwl VDD VSS VSUBS
+ detronyx_12t_2w2r_rc4_4x4_routed_5layer_direct
Xu_t003_007 u_t003_007/c0_w0_bl u_t003_007/c0_w0_br u_t003_007/c0_w1_bl u_t003_007/c0_w1_br u_t003_007/c0_r0_rbl
+ u_t003_007/c0_r1_rbl u_t003_007/c1_w0_bl u_t003_007/c1_w0_br u_t003_007/c1_w1_bl u_t003_007/c1_w1_br
+ u_t003_007/c1_r0_rbl u_t003_007/c1_r1_rbl u_t003_007/c2_w0_bl u_t003_007/c2_w0_br u_t003_007/c2_w1_bl
+ u_t003_007/c2_w1_br u_t003_007/c2_r0_rbl u_t003_007/c2_r1_rbl u_t003_007/c3_w0_bl u_t003_007/c3_w0_br
+ u_t003_007/c3_w1_bl u_t003_007/c3_w1_br u_t003_007/c3_r0_rbl u_t003_007/c3_r1_rbl u_t003_007/r0_w0_wl
+ u_t003_007/r0_w1_wl u_t003_007/r0_r0_rwl u_t003_007/r0_r1_rwl u_t003_007/r1_w0_wl u_t003_007/r1_w1_wl
+ u_t003_007/r1_r0_rwl u_t003_007/r1_r1_rwl u_t003_007/r2_w0_wl u_t003_007/r2_w1_wl u_t003_007/r2_r0_rwl
+ u_t003_007/r2_r1_rwl u_t003_007/r3_w0_wl u_t003_007/r3_w1_wl u_t003_007/r3_r0_rwl u_t003_007/r3_r1_rwl VDD VSS VSUBS
+ detronyx_12t_2w2r_rc4_4x4_routed_5layer_direct
Xu_t006_004 u_t006_004/c0_w0_bl u_t006_004/c0_w0_br u_t006_004/c0_w1_bl u_t006_004/c0_w1_br u_t006_004/c0_r0_rbl
+ u_t006_004/c0_r1_rbl u_t006_004/c1_w0_bl u_t006_004/c1_w0_br u_t006_004/c1_w1_bl u_t006_004/c1_w1_br
+ u_t006_004/c1_r0_rbl u_t006_004/c1_r1_rbl u_t006_004/c2_w0_bl u_t006_004/c2_w0_br u_t006_004/c2_w1_bl
+ u_t006_004/c2_w1_br u_t006_004/c2_r0_rbl u_t006_004/c2_r1_rbl u_t006_004/c3_w0_bl u_t006_004/c3_w0_br
+ u_t006_004/c3_w1_bl u_t006_004/c3_w1_br u_t006_004/c3_r0_rbl u_t006_004/c3_r1_rbl u_t006_004/r0_w0_wl
+ u_t006_004/r0_w1_wl u_t006_004/r0_r0_rwl u_t006_004/r0_r1_rwl u_t006_004/r1_w0_wl u_t006_004/r1_w1_wl
+ u_t006_004/r1_r0_rwl u_t006_004/r1_r1_rwl u_t006_004/r2_w0_wl u_t006_004/r2_w1_wl u_t006_004/r2_r0_rwl
+ u_t006_004/r2_r1_rwl u_t006_004/r3_w0_wl u_t006_004/r3_w1_wl u_t006_004/r3_r0_rwl u_t006_004/r3_r1_rwl VDD VSS VSUBS
+ detronyx_12t_2w2r_rc4_4x4_routed_5layer_direct
Xu_t015_005 u_t015_005/c0_w0_bl u_t015_005/c0_w0_br u_t015_005/c0_w1_bl u_t015_005/c0_w1_br u_t015_005/c0_r0_rbl
+ u_t015_005/c0_r1_rbl u_t015_005/c1_w0_bl u_t015_005/c1_w0_br u_t015_005/c1_w1_bl u_t015_005/c1_w1_br
+ u_t015_005/c1_r0_rbl u_t015_005/c1_r1_rbl u_t015_005/c2_w0_bl u_t015_005/c2_w0_br u_t015_005/c2_w1_bl
+ u_t015_005/c2_w1_br u_t015_005/c2_r0_rbl u_t015_005/c2_r1_rbl u_t015_005/c3_w0_bl u_t015_005/c3_w0_br
+ u_t015_005/c3_w1_bl u_t015_005/c3_w1_br u_t015_005/c3_r0_rbl u_t015_005/c3_r1_rbl u_t015_005/r0_w0_wl
+ u_t015_005/r0_w1_wl u_t015_005/r0_r0_rwl u_t015_005/r0_r1_rwl u_t015_005/r1_w0_wl u_t015_005/r1_w1_wl
+ u_t015_005/r1_r0_rwl u_t015_005/r1_r1_rwl u_t015_005/r2_w0_wl u_t015_005/r2_w1_wl u_t015_005/r2_r0_rwl
+ u_t015_005/r2_r1_rwl u_t015_005/r3_w0_wl u_t015_005/r3_w1_wl u_t015_005/r3_r0_rwl u_t015_005/r3_r1_rwl VDD VSS VSUBS
+ detronyx_12t_2w2r_rc4_4x4_routed_5layer_direct
Xu_t009_013 u_t009_013/c0_w0_bl u_t009_013/c0_w0_br u_t009_013/c0_w1_bl u_t009_013/c0_w1_br u_t009_013/c0_r0_rbl
+ u_t009_013/c0_r1_rbl u_t009_013/c1_w0_bl u_t009_013/c1_w0_br u_t009_013/c1_w1_bl u_t009_013/c1_w1_br
+ u_t009_013/c1_r0_rbl u_t009_013/c1_r1_rbl u_t009_013/c2_w0_bl u_t009_013/c2_w0_br u_t009_013/c2_w1_bl
+ u_t009_013/c2_w1_br u_t009_013/c2_r0_rbl u_t009_013/c2_r1_rbl u_t009_013/c3_w0_bl u_t009_013/c3_w0_br
+ u_t009_013/c3_w1_bl u_t009_013/c3_w1_br u_t009_013/c3_r0_rbl u_t009_013/c3_r1_rbl u_t009_013/r0_w0_wl
+ u_t009_013/r0_w1_wl u_t009_013/r0_r0_rwl u_t009_013/r0_r1_rwl u_t009_013/r1_w0_wl u_t009_013/r1_w1_wl
+ u_t009_013/r1_r0_rwl u_t009_013/r1_r1_rwl u_t009_013/r2_w0_wl u_t009_013/r2_w1_wl u_t009_013/r2_r0_rwl
+ u_t009_013/r2_r1_rwl u_t009_013/r3_w0_wl u_t009_013/r3_w1_wl u_t009_013/r3_r0_rwl u_t009_013/r3_r1_rwl VDD VSS VSUBS
+ detronyx_12t_2w2r_rc4_4x4_routed_5layer_direct
Xu_t009_002 u_t009_002/c0_w0_bl u_t009_002/c0_w0_br u_t009_002/c0_w1_bl u_t009_002/c0_w1_br u_t009_002/c0_r0_rbl
+ u_t009_002/c0_r1_rbl u_t009_002/c1_w0_bl u_t009_002/c1_w0_br u_t009_002/c1_w1_bl u_t009_002/c1_w1_br
+ u_t009_002/c1_r0_rbl u_t009_002/c1_r1_rbl u_t009_002/c2_w0_bl u_t009_002/c2_w0_br u_t009_002/c2_w1_bl
+ u_t009_002/c2_w1_br u_t009_002/c2_r0_rbl u_t009_002/c2_r1_rbl u_t009_002/c3_w0_bl u_t009_002/c3_w0_br
+ u_t009_002/c3_w1_bl u_t009_002/c3_w1_br u_t009_002/c3_r0_rbl u_t009_002/c3_r1_rbl u_t009_002/r0_w0_wl
+ u_t009_002/r0_w1_wl u_t009_002/r0_r0_rwl u_t009_002/r0_r1_rwl u_t009_002/r1_w0_wl u_t009_002/r1_w1_wl
+ u_t009_002/r1_r0_rwl u_t009_002/r1_r1_rwl u_t009_002/r2_w0_wl u_t009_002/r2_w1_wl u_t009_002/r2_r0_rwl
+ u_t009_002/r2_r1_rwl u_t009_002/r3_w0_wl u_t009_002/r3_w1_wl u_t009_002/r3_r0_rwl u_t009_002/r3_r1_rwl VDD VSS VSUBS
+ detronyx_12t_2w2r_rc4_4x4_routed_5layer_direct
Xu_t006_005 u_t006_005/c0_w0_bl u_t006_005/c0_w0_br u_t006_005/c0_w1_bl u_t006_005/c0_w1_br u_t006_005/c0_r0_rbl
+ u_t006_005/c0_r1_rbl u_t006_005/c1_w0_bl u_t006_005/c1_w0_br u_t006_005/c1_w1_bl u_t006_005/c1_w1_br
+ u_t006_005/c1_r0_rbl u_t006_005/c1_r1_rbl u_t006_005/c2_w0_bl u_t006_005/c2_w0_br u_t006_005/c2_w1_bl
+ u_t006_005/c2_w1_br u_t006_005/c2_r0_rbl u_t006_005/c2_r1_rbl u_t006_005/c3_w0_bl u_t006_005/c3_w0_br
+ u_t006_005/c3_w1_bl u_t006_005/c3_w1_br u_t006_005/c3_r0_rbl u_t006_005/c3_r1_rbl u_t006_005/r0_w0_wl
+ u_t006_005/r0_w1_wl u_t006_005/r0_r0_rwl u_t006_005/r0_r1_rwl u_t006_005/r1_w0_wl u_t006_005/r1_w1_wl
+ u_t006_005/r1_r0_rwl u_t006_005/r1_r1_rwl u_t006_005/r2_w0_wl u_t006_005/r2_w1_wl u_t006_005/r2_r0_rwl
+ u_t006_005/r2_r1_rwl u_t006_005/r3_w0_wl u_t006_005/r3_w1_wl u_t006_005/r3_r0_rwl u_t006_005/r3_r1_rwl VDD VSS VSUBS
+ detronyx_12t_2w2r_rc4_4x4_routed_5layer_direct
Xu_t012_008 u_t012_008/c0_w0_bl u_t012_008/c0_w0_br u_t012_008/c0_w1_bl u_t012_008/c0_w1_br u_t012_008/c0_r0_rbl
+ u_t012_008/c0_r1_rbl u_t012_008/c1_w0_bl u_t012_008/c1_w0_br u_t012_008/c1_w1_bl u_t012_008/c1_w1_br
+ u_t012_008/c1_r0_rbl u_t012_008/c1_r1_rbl u_t012_008/c2_w0_bl u_t012_008/c2_w0_br u_t012_008/c2_w1_bl
+ u_t012_008/c2_w1_br u_t012_008/c2_r0_rbl u_t012_008/c2_r1_rbl u_t012_008/c3_w0_bl u_t012_008/c3_w0_br
+ u_t012_008/c3_w1_bl u_t012_008/c3_w1_br u_t012_008/c3_r0_rbl u_t012_008/c3_r1_rbl u_t012_008/r0_w0_wl
+ u_t012_008/r0_w1_wl u_t012_008/r0_r0_rwl u_t012_008/r0_r1_rwl u_t012_008/r1_w0_wl u_t012_008/r1_w1_wl
+ u_t012_008/r1_r0_rwl u_t012_008/r1_r1_rwl u_t012_008/r2_w0_wl u_t012_008/r2_w1_wl u_t012_008/r2_r0_rwl
+ u_t012_008/r2_r1_rwl u_t012_008/r3_w0_wl u_t012_008/r3_w1_wl u_t012_008/r3_r0_rwl u_t012_008/r3_r1_rwl VDD VSS VSUBS
+ detronyx_12t_2w2r_rc4_4x4_routed_5layer_direct
Xu_t003_008 u_t003_008/c0_w0_bl u_t003_008/c0_w0_br u_t003_008/c0_w1_bl u_t003_008/c0_w1_br u_t003_008/c0_r0_rbl
+ u_t003_008/c0_r1_rbl u_t003_008/c1_w0_bl u_t003_008/c1_w0_br u_t003_008/c1_w1_bl u_t003_008/c1_w1_br
+ u_t003_008/c1_r0_rbl u_t003_008/c1_r1_rbl u_t003_008/c2_w0_bl u_t003_008/c2_w0_br u_t003_008/c2_w1_bl
+ u_t003_008/c2_w1_br u_t003_008/c2_r0_rbl u_t003_008/c2_r1_rbl u_t003_008/c3_w0_bl u_t003_008/c3_w0_br
+ u_t003_008/c3_w1_bl u_t003_008/c3_w1_br u_t003_008/c3_r0_rbl u_t003_008/c3_r1_rbl u_t003_008/r0_w0_wl
+ u_t003_008/r0_w1_wl u_t003_008/r0_r0_rwl u_t003_008/r0_r1_rwl u_t003_008/r1_w0_wl u_t003_008/r1_w1_wl
+ u_t003_008/r1_r0_rwl u_t003_008/r1_r1_rwl u_t003_008/r2_w0_wl u_t003_008/r2_w1_wl u_t003_008/r2_r0_rwl
+ u_t003_008/r2_r1_rwl u_t003_008/r3_w0_wl u_t003_008/r3_w1_wl u_t003_008/r3_r0_rwl u_t003_008/r3_r1_rwl VDD VSS VSUBS
+ detronyx_12t_2w2r_rc4_4x4_routed_5layer_direct
Xu_t009_014 u_t009_014/c0_w0_bl u_t009_014/c0_w0_br u_t009_014/c0_w1_bl u_t009_014/c0_w1_br u_t009_014/c0_r0_rbl
+ u_t009_014/c0_r1_rbl u_t009_014/c1_w0_bl u_t009_014/c1_w0_br u_t009_014/c1_w1_bl u_t009_014/c1_w1_br
+ u_t009_014/c1_r0_rbl u_t009_014/c1_r1_rbl u_t009_014/c2_w0_bl u_t009_014/c2_w0_br u_t009_014/c2_w1_bl
+ u_t009_014/c2_w1_br u_t009_014/c2_r0_rbl u_t009_014/c2_r1_rbl u_t009_014/c3_w0_bl u_t009_014/c3_w0_br
+ u_t009_014/c3_w1_bl u_t009_014/c3_w1_br u_t009_014/c3_r0_rbl u_t009_014/c3_r1_rbl u_t009_014/r0_w0_wl
+ u_t009_014/r0_w1_wl u_t009_014/r0_r0_rwl u_t009_014/r0_r1_rwl u_t009_014/r1_w0_wl u_t009_014/r1_w1_wl
+ u_t009_014/r1_r0_rwl u_t009_014/r1_r1_rwl u_t009_014/r2_w0_wl u_t009_014/r2_w1_wl u_t009_014/r2_r0_rwl
+ u_t009_014/r2_r1_rwl u_t009_014/r3_w0_wl u_t009_014/r3_w1_wl u_t009_014/r3_r0_rwl u_t009_014/r3_r1_rwl VDD VSS VSUBS
+ detronyx_12t_2w2r_rc4_4x4_routed_5layer_direct
Xu_t009_003 u_t009_003/c0_w0_bl u_t009_003/c0_w0_br u_t009_003/c0_w1_bl u_t009_003/c0_w1_br u_t009_003/c0_r0_rbl
+ u_t009_003/c0_r1_rbl u_t009_003/c1_w0_bl u_t009_003/c1_w0_br u_t009_003/c1_w1_bl u_t009_003/c1_w1_br
+ u_t009_003/c1_r0_rbl u_t009_003/c1_r1_rbl u_t009_003/c2_w0_bl u_t009_003/c2_w0_br u_t009_003/c2_w1_bl
+ u_t009_003/c2_w1_br u_t009_003/c2_r0_rbl u_t009_003/c2_r1_rbl u_t009_003/c3_w0_bl u_t009_003/c3_w0_br
+ u_t009_003/c3_w1_bl u_t009_003/c3_w1_br u_t009_003/c3_r0_rbl u_t009_003/c3_r1_rbl u_t009_003/r0_w0_wl
+ u_t009_003/r0_w1_wl u_t009_003/r0_r0_rwl u_t009_003/r0_r1_rwl u_t009_003/r1_w0_wl u_t009_003/r1_w1_wl
+ u_t009_003/r1_r0_rwl u_t009_003/r1_r1_rwl u_t009_003/r2_w0_wl u_t009_003/r2_w1_wl u_t009_003/r2_r0_rwl
+ u_t009_003/r2_r1_rwl u_t009_003/r3_w0_wl u_t009_003/r3_w1_wl u_t009_003/r3_r0_rwl u_t009_003/r3_r1_rwl VDD VSS VSUBS
+ detronyx_12t_2w2r_rc4_4x4_routed_5layer_direct
Xu_t015_006 u_t015_006/c0_w0_bl u_t015_006/c0_w0_br u_t015_006/c0_w1_bl u_t015_006/c0_w1_br u_t015_006/c0_r0_rbl
+ u_t015_006/c0_r1_rbl u_t015_006/c1_w0_bl u_t015_006/c1_w0_br u_t015_006/c1_w1_bl u_t015_006/c1_w1_br
+ u_t015_006/c1_r0_rbl u_t015_006/c1_r1_rbl u_t015_006/c2_w0_bl u_t015_006/c2_w0_br u_t015_006/c2_w1_bl
+ u_t015_006/c2_w1_br u_t015_006/c2_r0_rbl u_t015_006/c2_r1_rbl u_t015_006/c3_w0_bl u_t015_006/c3_w0_br
+ u_t015_006/c3_w1_bl u_t015_006/c3_w1_br u_t015_006/c3_r0_rbl u_t015_006/c3_r1_rbl u_t015_006/r0_w0_wl
+ u_t015_006/r0_w1_wl u_t015_006/r0_r0_rwl u_t015_006/r0_r1_rwl u_t015_006/r1_w0_wl u_t015_006/r1_w1_wl
+ u_t015_006/r1_r0_rwl u_t015_006/r1_r1_rwl u_t015_006/r2_w0_wl u_t015_006/r2_w1_wl u_t015_006/r2_r0_rwl
+ u_t015_006/r2_r1_rwl u_t015_006/r3_w0_wl u_t015_006/r3_w1_wl u_t015_006/r3_r0_rwl u_t015_006/r3_r1_rwl VDD VSS VSUBS
+ detronyx_12t_2w2r_rc4_4x4_routed_5layer_direct
Xu_t012_009 u_t012_009/c0_w0_bl u_t012_009/c0_w0_br u_t012_009/c0_w1_bl u_t012_009/c0_w1_br u_t012_009/c0_r0_rbl
+ u_t012_009/c0_r1_rbl u_t012_009/c1_w0_bl u_t012_009/c1_w0_br u_t012_009/c1_w1_bl u_t012_009/c1_w1_br
+ u_t012_009/c1_r0_rbl u_t012_009/c1_r1_rbl u_t012_009/c2_w0_bl u_t012_009/c2_w0_br u_t012_009/c2_w1_bl
+ u_t012_009/c2_w1_br u_t012_009/c2_r0_rbl u_t012_009/c2_r1_rbl u_t012_009/c3_w0_bl u_t012_009/c3_w0_br
+ u_t012_009/c3_w1_bl u_t012_009/c3_w1_br u_t012_009/c3_r0_rbl u_t012_009/c3_r1_rbl u_t012_009/r0_w0_wl
+ u_t012_009/r0_w1_wl u_t012_009/r0_r0_rwl u_t012_009/r0_r1_rwl u_t012_009/r1_w0_wl u_t012_009/r1_w1_wl
+ u_t012_009/r1_r0_rwl u_t012_009/r1_r1_rwl u_t012_009/r2_w0_wl u_t012_009/r2_w1_wl u_t012_009/r2_r0_rwl
+ u_t012_009/r2_r1_rwl u_t012_009/r3_w0_wl u_t012_009/r3_w1_wl u_t012_009/r3_r0_rwl u_t012_009/r3_r1_rwl VDD VSS VSUBS
+ detronyx_12t_2w2r_rc4_4x4_routed_5layer_direct
Xu_t003_009 u_t003_009/c0_w0_bl u_t003_009/c0_w0_br u_t003_009/c0_w1_bl u_t003_009/c0_w1_br u_t003_009/c0_r0_rbl
+ u_t003_009/c0_r1_rbl u_t003_009/c1_w0_bl u_t003_009/c1_w0_br u_t003_009/c1_w1_bl u_t003_009/c1_w1_br
+ u_t003_009/c1_r0_rbl u_t003_009/c1_r1_rbl u_t003_009/c2_w0_bl u_t003_009/c2_w0_br u_t003_009/c2_w1_bl
+ u_t003_009/c2_w1_br u_t003_009/c2_r0_rbl u_t003_009/c2_r1_rbl u_t003_009/c3_w0_bl u_t003_009/c3_w0_br
+ u_t003_009/c3_w1_bl u_t003_009/c3_w1_br u_t003_009/c3_r0_rbl u_t003_009/c3_r1_rbl u_t003_009/r0_w0_wl
+ u_t003_009/r0_w1_wl u_t003_009/r0_r0_rwl u_t003_009/r0_r1_rwl u_t003_009/r1_w0_wl u_t003_009/r1_w1_wl
+ u_t003_009/r1_r0_rwl u_t003_009/r1_r1_rwl u_t003_009/r2_w0_wl u_t003_009/r2_w1_wl u_t003_009/r2_r0_rwl
+ u_t003_009/r2_r1_rwl u_t003_009/r3_w0_wl u_t003_009/r3_w1_wl u_t003_009/r3_r0_rwl u_t003_009/r3_r1_rwl VDD VSS VSUBS
+ detronyx_12t_2w2r_rc4_4x4_routed_5layer_direct
Xu_t006_006 u_t006_006/c0_w0_bl u_t006_006/c0_w0_br u_t006_006/c0_w1_bl u_t006_006/c0_w1_br u_t006_006/c0_r0_rbl
+ u_t006_006/c0_r1_rbl u_t006_006/c1_w0_bl u_t006_006/c1_w0_br u_t006_006/c1_w1_bl u_t006_006/c1_w1_br
+ u_t006_006/c1_r0_rbl u_t006_006/c1_r1_rbl u_t006_006/c2_w0_bl u_t006_006/c2_w0_br u_t006_006/c2_w1_bl
+ u_t006_006/c2_w1_br u_t006_006/c2_r0_rbl u_t006_006/c2_r1_rbl u_t006_006/c3_w0_bl u_t006_006/c3_w0_br
+ u_t006_006/c3_w1_bl u_t006_006/c3_w1_br u_t006_006/c3_r0_rbl u_t006_006/c3_r1_rbl u_t006_006/r0_w0_wl
+ u_t006_006/r0_w1_wl u_t006_006/r0_r0_rwl u_t006_006/r0_r1_rwl u_t006_006/r1_w0_wl u_t006_006/r1_w1_wl
+ u_t006_006/r1_r0_rwl u_t006_006/r1_r1_rwl u_t006_006/r2_w0_wl u_t006_006/r2_w1_wl u_t006_006/r2_r0_rwl
+ u_t006_006/r2_r1_rwl u_t006_006/r3_w0_wl u_t006_006/r3_w1_wl u_t006_006/r3_r0_rwl u_t006_006/r3_r1_rwl VDD VSS VSUBS
+ detronyx_12t_2w2r_rc4_4x4_routed_5layer_direct
Xu_t015_007 u_t015_007/c0_w0_bl u_t015_007/c0_w0_br u_t015_007/c0_w1_bl u_t015_007/c0_w1_br u_t015_007/c0_r0_rbl
+ u_t015_007/c0_r1_rbl u_t015_007/c1_w0_bl u_t015_007/c1_w0_br u_t015_007/c1_w1_bl u_t015_007/c1_w1_br
+ u_t015_007/c1_r0_rbl u_t015_007/c1_r1_rbl u_t015_007/c2_w0_bl u_t015_007/c2_w0_br u_t015_007/c2_w1_bl
+ u_t015_007/c2_w1_br u_t015_007/c2_r0_rbl u_t015_007/c2_r1_rbl u_t015_007/c3_w0_bl u_t015_007/c3_w0_br
+ u_t015_007/c3_w1_bl u_t015_007/c3_w1_br u_t015_007/c3_r0_rbl u_t015_007/c3_r1_rbl u_t015_007/r0_w0_wl
+ u_t015_007/r0_w1_wl u_t015_007/r0_r0_rwl u_t015_007/r0_r1_rwl u_t015_007/r1_w0_wl u_t015_007/r1_w1_wl
+ u_t015_007/r1_r0_rwl u_t015_007/r1_r1_rwl u_t015_007/r2_w0_wl u_t015_007/r2_w1_wl u_t015_007/r2_r0_rwl
+ u_t015_007/r2_r1_rwl u_t015_007/r3_w0_wl u_t015_007/r3_w1_wl u_t015_007/r3_r0_rwl u_t015_007/r3_r1_rwl VDD VSS VSUBS
+ detronyx_12t_2w2r_rc4_4x4_routed_5layer_direct
Xu_t009_015 u_t009_015/c0_w0_bl u_t009_015/c0_w0_br u_t009_015/c0_w1_bl u_t009_015/c0_w1_br u_t009_015/c0_r0_rbl
+ u_t009_015/c0_r1_rbl u_t009_015/c1_w0_bl u_t009_015/c1_w0_br u_t009_015/c1_w1_bl u_t009_015/c1_w1_br
+ u_t009_015/c1_r0_rbl u_t009_015/c1_r1_rbl u_t009_015/c2_w0_bl u_t009_015/c2_w0_br u_t009_015/c2_w1_bl
+ u_t009_015/c2_w1_br u_t009_015/c2_r0_rbl u_t009_015/c2_r1_rbl u_t009_015/c3_w0_bl u_t009_015/c3_w0_br
+ u_t009_015/c3_w1_bl u_t009_015/c3_w1_br u_t009_015/c3_r0_rbl u_t009_015/c3_r1_rbl u_t009_015/r0_w0_wl
+ u_t009_015/r0_w1_wl u_t009_015/r0_r0_rwl u_t009_015/r0_r1_rwl u_t009_015/r1_w0_wl u_t009_015/r1_w1_wl
+ u_t009_015/r1_r0_rwl u_t009_015/r1_r1_rwl u_t009_015/r2_w0_wl u_t009_015/r2_w1_wl u_t009_015/r2_r0_rwl
+ u_t009_015/r2_r1_rwl u_t009_015/r3_w0_wl u_t009_015/r3_w1_wl u_t009_015/r3_r0_rwl u_t009_015/r3_r1_rwl VDD VSS VSUBS
+ detronyx_12t_2w2r_rc4_4x4_routed_5layer_direct
Xu_t009_004 u_t009_004/c0_w0_bl u_t009_004/c0_w0_br u_t009_004/c0_w1_bl u_t009_004/c0_w1_br u_t009_004/c0_r0_rbl
+ u_t009_004/c0_r1_rbl u_t009_004/c1_w0_bl u_t009_004/c1_w0_br u_t009_004/c1_w1_bl u_t009_004/c1_w1_br
+ u_t009_004/c1_r0_rbl u_t009_004/c1_r1_rbl u_t009_004/c2_w0_bl u_t009_004/c2_w0_br u_t009_004/c2_w1_bl
+ u_t009_004/c2_w1_br u_t009_004/c2_r0_rbl u_t009_004/c2_r1_rbl u_t009_004/c3_w0_bl u_t009_004/c3_w0_br
+ u_t009_004/c3_w1_bl u_t009_004/c3_w1_br u_t009_004/c3_r0_rbl u_t009_004/c3_r1_rbl u_t009_004/r0_w0_wl
+ u_t009_004/r0_w1_wl u_t009_004/r0_r0_rwl u_t009_004/r0_r1_rwl u_t009_004/r1_w0_wl u_t009_004/r1_w1_wl
+ u_t009_004/r1_r0_rwl u_t009_004/r1_r1_rwl u_t009_004/r2_w0_wl u_t009_004/r2_w1_wl u_t009_004/r2_r0_rwl
+ u_t009_004/r2_r1_rwl u_t009_004/r3_w0_wl u_t009_004/r3_w1_wl u_t009_004/r3_r0_rwl u_t009_004/r3_r1_rwl VDD VSS VSUBS
+ detronyx_12t_2w2r_rc4_4x4_routed_5layer_direct
Xu_t006_007 u_t006_007/c0_w0_bl u_t006_007/c0_w0_br u_t006_007/c0_w1_bl u_t006_007/c0_w1_br u_t006_007/c0_r0_rbl
+ u_t006_007/c0_r1_rbl u_t006_007/c1_w0_bl u_t006_007/c1_w0_br u_t006_007/c1_w1_bl u_t006_007/c1_w1_br
+ u_t006_007/c1_r0_rbl u_t006_007/c1_r1_rbl u_t006_007/c2_w0_bl u_t006_007/c2_w0_br u_t006_007/c2_w1_bl
+ u_t006_007/c2_w1_br u_t006_007/c2_r0_rbl u_t006_007/c2_r1_rbl u_t006_007/c3_w0_bl u_t006_007/c3_w0_br
+ u_t006_007/c3_w1_bl u_t006_007/c3_w1_br u_t006_007/c3_r0_rbl u_t006_007/c3_r1_rbl u_t006_007/r0_w0_wl
+ u_t006_007/r0_w1_wl u_t006_007/r0_r0_rwl u_t006_007/r0_r1_rwl u_t006_007/r1_w0_wl u_t006_007/r1_w1_wl
+ u_t006_007/r1_r0_rwl u_t006_007/r1_r1_rwl u_t006_007/r2_w0_wl u_t006_007/r2_w1_wl u_t006_007/r2_r0_rwl
+ u_t006_007/r2_r1_rwl u_t006_007/r3_w0_wl u_t006_007/r3_w1_wl u_t006_007/r3_r0_rwl u_t006_007/r3_r1_rwl VDD VSS VSUBS
+ detronyx_12t_2w2r_rc4_4x4_routed_5layer_direct
Xu_t011_010 u_t011_010/c0_w0_bl u_t011_010/c0_w0_br u_t011_010/c0_w1_bl u_t011_010/c0_w1_br u_t011_010/c0_r0_rbl
+ u_t011_010/c0_r1_rbl u_t011_010/c1_w0_bl u_t011_010/c1_w0_br u_t011_010/c1_w1_bl u_t011_010/c1_w1_br
+ u_t011_010/c1_r0_rbl u_t011_010/c1_r1_rbl u_t011_010/c2_w0_bl u_t011_010/c2_w0_br u_t011_010/c2_w1_bl
+ u_t011_010/c2_w1_br u_t011_010/c2_r0_rbl u_t011_010/c2_r1_rbl u_t011_010/c3_w0_bl u_t011_010/c3_w0_br
+ u_t011_010/c3_w1_bl u_t011_010/c3_w1_br u_t011_010/c3_r0_rbl u_t011_010/c3_r1_rbl u_t011_010/r0_w0_wl
+ u_t011_010/r0_w1_wl u_t011_010/r0_r0_rwl u_t011_010/r0_r1_rwl u_t011_010/r1_w0_wl u_t011_010/r1_w1_wl
+ u_t011_010/r1_r0_rwl u_t011_010/r1_r1_rwl u_t011_010/r2_w0_wl u_t011_010/r2_w1_wl u_t011_010/r2_r0_rwl
+ u_t011_010/r2_r1_rwl u_t011_010/r3_w0_wl u_t011_010/r3_w1_wl u_t011_010/r3_r0_rwl u_t011_010/r3_r1_rwl VDD VSS VSUBS
+ detronyx_12t_2w2r_rc4_4x4_routed_5layer_direct
Xu_t002_010 u_t002_010/c0_w0_bl u_t002_010/c0_w0_br u_t002_010/c0_w1_bl u_t002_010/c0_w1_br u_t002_010/c0_r0_rbl
+ u_t002_010/c0_r1_rbl u_t002_010/c1_w0_bl u_t002_010/c1_w0_br u_t002_010/c1_w1_bl u_t002_010/c1_w1_br
+ u_t002_010/c1_r0_rbl u_t002_010/c1_r1_rbl u_t002_010/c2_w0_bl u_t002_010/c2_w0_br u_t002_010/c2_w1_bl
+ u_t002_010/c2_w1_br u_t002_010/c2_r0_rbl u_t002_010/c2_r1_rbl u_t002_010/c3_w0_bl u_t002_010/c3_w0_br
+ u_t002_010/c3_w1_bl u_t002_010/c3_w1_br u_t002_010/c3_r0_rbl u_t002_010/c3_r1_rbl u_t002_010/r0_w0_wl
+ u_t002_010/r0_w1_wl u_t002_010/r0_r0_rwl u_t002_010/r0_r1_rwl u_t002_010/r1_w0_wl u_t002_010/r1_w1_wl
+ u_t002_010/r1_r0_rwl u_t002_010/r1_r1_rwl u_t002_010/r2_w0_wl u_t002_010/r2_w1_wl u_t002_010/r2_r0_rwl
+ u_t002_010/r2_r1_rwl u_t002_010/r3_w0_wl u_t002_010/r3_w1_wl u_t002_010/r3_r0_rwl u_t002_010/r3_r1_rwl VDD VSS VSUBS
+ detronyx_12t_2w2r_rc4_4x4_routed_5layer_direct
Xu_t015_008 u_t015_008/c0_w0_bl u_t015_008/c0_w0_br u_t015_008/c0_w1_bl u_t015_008/c0_w1_br u_t015_008/c0_r0_rbl
+ u_t015_008/c0_r1_rbl u_t015_008/c1_w0_bl u_t015_008/c1_w0_br u_t015_008/c1_w1_bl u_t015_008/c1_w1_br
+ u_t015_008/c1_r0_rbl u_t015_008/c1_r1_rbl u_t015_008/c2_w0_bl u_t015_008/c2_w0_br u_t015_008/c2_w1_bl
+ u_t015_008/c2_w1_br u_t015_008/c2_r0_rbl u_t015_008/c2_r1_rbl u_t015_008/c3_w0_bl u_t015_008/c3_w0_br
+ u_t015_008/c3_w1_bl u_t015_008/c3_w1_br u_t015_008/c3_r0_rbl u_t015_008/c3_r1_rbl u_t015_008/r0_w0_wl
+ u_t015_008/r0_w1_wl u_t015_008/r0_r0_rwl u_t015_008/r0_r1_rwl u_t015_008/r1_w0_wl u_t015_008/r1_w1_wl
+ u_t015_008/r1_r0_rwl u_t015_008/r1_r1_rwl u_t015_008/r2_w0_wl u_t015_008/r2_w1_wl u_t015_008/r2_r0_rwl
+ u_t015_008/r2_r1_rwl u_t015_008/r3_w0_wl u_t015_008/r3_w1_wl u_t015_008/r3_r0_rwl u_t015_008/r3_r1_rwl VDD VSS VSUBS
+ detronyx_12t_2w2r_rc4_4x4_routed_5layer_direct
Xu_t009_005 u_t009_005/c0_w0_bl u_t009_005/c0_w0_br u_t009_005/c0_w1_bl u_t009_005/c0_w1_br u_t009_005/c0_r0_rbl
+ u_t009_005/c0_r1_rbl u_t009_005/c1_w0_bl u_t009_005/c1_w0_br u_t009_005/c1_w1_bl u_t009_005/c1_w1_br
+ u_t009_005/c1_r0_rbl u_t009_005/c1_r1_rbl u_t009_005/c2_w0_bl u_t009_005/c2_w0_br u_t009_005/c2_w1_bl
+ u_t009_005/c2_w1_br u_t009_005/c2_r0_rbl u_t009_005/c2_r1_rbl u_t009_005/c3_w0_bl u_t009_005/c3_w0_br
+ u_t009_005/c3_w1_bl u_t009_005/c3_w1_br u_t009_005/c3_r0_rbl u_t009_005/c3_r1_rbl u_t009_005/r0_w0_wl
+ u_t009_005/r0_w1_wl u_t009_005/r0_r0_rwl u_t009_005/r0_r1_rwl u_t009_005/r1_w0_wl u_t009_005/r1_w1_wl
+ u_t009_005/r1_r0_rwl u_t009_005/r1_r1_rwl u_t009_005/r2_w0_wl u_t009_005/r2_w1_wl u_t009_005/r2_r0_rwl
+ u_t009_005/r2_r1_rwl u_t009_005/r3_w0_wl u_t009_005/r3_w1_wl u_t009_005/r3_r0_rwl u_t009_005/r3_r1_rwl VDD VSS VSUBS
+ detronyx_12t_2w2r_rc4_4x4_routed_5layer_direct
Xu_t006_008 u_t006_008/c0_w0_bl u_t006_008/c0_w0_br u_t006_008/c0_w1_bl u_t006_008/c0_w1_br u_t006_008/c0_r0_rbl
+ u_t006_008/c0_r1_rbl u_t006_008/c1_w0_bl u_t006_008/c1_w0_br u_t006_008/c1_w1_bl u_t006_008/c1_w1_br
+ u_t006_008/c1_r0_rbl u_t006_008/c1_r1_rbl u_t006_008/c2_w0_bl u_t006_008/c2_w0_br u_t006_008/c2_w1_bl
+ u_t006_008/c2_w1_br u_t006_008/c2_r0_rbl u_t006_008/c2_r1_rbl u_t006_008/c3_w0_bl u_t006_008/c3_w0_br
+ u_t006_008/c3_w1_bl u_t006_008/c3_w1_br u_t006_008/c3_r0_rbl u_t006_008/c3_r1_rbl u_t006_008/r0_w0_wl
+ u_t006_008/r0_w1_wl u_t006_008/r0_r0_rwl u_t006_008/r0_r1_rwl u_t006_008/r1_w0_wl u_t006_008/r1_w1_wl
+ u_t006_008/r1_r0_rwl u_t006_008/r1_r1_rwl u_t006_008/r2_w0_wl u_t006_008/r2_w1_wl u_t006_008/r2_r0_rwl
+ u_t006_008/r2_r1_rwl u_t006_008/r3_w0_wl u_t006_008/r3_w1_wl u_t006_008/r3_r0_rwl u_t006_008/r3_r1_rwl VDD VSS VSUBS
+ detronyx_12t_2w2r_rc4_4x4_routed_5layer_direct
Xu_t011_011 u_t011_011/c0_w0_bl u_t011_011/c0_w0_br u_t011_011/c0_w1_bl u_t011_011/c0_w1_br u_t011_011/c0_r0_rbl
+ u_t011_011/c0_r1_rbl u_t011_011/c1_w0_bl u_t011_011/c1_w0_br u_t011_011/c1_w1_bl u_t011_011/c1_w1_br
+ u_t011_011/c1_r0_rbl u_t011_011/c1_r1_rbl u_t011_011/c2_w0_bl u_t011_011/c2_w0_br u_t011_011/c2_w1_bl
+ u_t011_011/c2_w1_br u_t011_011/c2_r0_rbl u_t011_011/c2_r1_rbl u_t011_011/c3_w0_bl u_t011_011/c3_w0_br
+ u_t011_011/c3_w1_bl u_t011_011/c3_w1_br u_t011_011/c3_r0_rbl u_t011_011/c3_r1_rbl u_t011_011/r0_w0_wl
+ u_t011_011/r0_w1_wl u_t011_011/r0_r0_rwl u_t011_011/r0_r1_rwl u_t011_011/r1_w0_wl u_t011_011/r1_w1_wl
+ u_t011_011/r1_r0_rwl u_t011_011/r1_r1_rwl u_t011_011/r2_w0_wl u_t011_011/r2_w1_wl u_t011_011/r2_r0_rwl
+ u_t011_011/r2_r1_rwl u_t011_011/r3_w0_wl u_t011_011/r3_w1_wl u_t011_011/r3_r0_rwl u_t011_011/r3_r1_rwl VDD VSS VSUBS
+ detronyx_12t_2w2r_rc4_4x4_routed_5layer_direct
Xu_t011_000 u_t011_000/c0_w0_bl u_t011_000/c0_w0_br u_t011_000/c0_w1_bl u_t011_000/c0_w1_br u_t011_000/c0_r0_rbl
+ u_t011_000/c0_r1_rbl u_t011_000/c1_w0_bl u_t011_000/c1_w0_br u_t011_000/c1_w1_bl u_t011_000/c1_w1_br
+ u_t011_000/c1_r0_rbl u_t011_000/c1_r1_rbl u_t011_000/c2_w0_bl u_t011_000/c2_w0_br u_t011_000/c2_w1_bl
+ u_t011_000/c2_w1_br u_t011_000/c2_r0_rbl u_t011_000/c2_r1_rbl u_t011_000/c3_w0_bl u_t011_000/c3_w0_br
+ u_t011_000/c3_w1_bl u_t011_000/c3_w1_br u_t011_000/c3_r0_rbl u_t011_000/c3_r1_rbl u_t011_000/r0_w0_wl
+ u_t011_000/r0_w1_wl u_t011_000/r0_r0_rwl u_t011_000/r0_r1_rwl u_t011_000/r1_w0_wl u_t011_000/r1_w1_wl
+ u_t011_000/r1_r0_rwl u_t011_000/r1_r1_rwl u_t011_000/r2_w0_wl u_t011_000/r2_w1_wl u_t011_000/r2_r0_rwl
+ u_t011_000/r2_r1_rwl u_t011_000/r3_w0_wl u_t011_000/r3_w1_wl u_t011_000/r3_r0_rwl u_t011_000/r3_r1_rwl VDD VSS VSUBS
+ detronyx_12t_2w2r_rc4_4x4_routed_5layer_direct
Xu_t002_000 u_t002_000/c0_w0_bl u_t002_000/c0_w0_br u_t002_000/c0_w1_bl u_t002_000/c0_w1_br u_t002_000/c0_r0_rbl
+ u_t002_000/c0_r1_rbl u_t002_000/c1_w0_bl u_t002_000/c1_w0_br u_t002_000/c1_w1_bl u_t002_000/c1_w1_br
+ u_t002_000/c1_r0_rbl u_t002_000/c1_r1_rbl u_t002_000/c2_w0_bl u_t002_000/c2_w0_br u_t002_000/c2_w1_bl
+ u_t002_000/c2_w1_br u_t002_000/c2_r0_rbl u_t002_000/c2_r1_rbl u_t002_000/c3_w0_bl u_t002_000/c3_w0_br
+ u_t002_000/c3_w1_bl u_t002_000/c3_w1_br u_t002_000/c3_r0_rbl u_t002_000/c3_r1_rbl u_t002_000/r0_w0_wl
+ u_t002_000/r0_w1_wl u_t002_000/r0_r0_rwl u_t002_000/r0_r1_rwl u_t002_000/r1_w0_wl u_t002_000/r1_w1_wl
+ u_t002_000/r1_r0_rwl u_t002_000/r1_r1_rwl u_t002_000/r2_w0_wl u_t002_000/r2_w1_wl u_t002_000/r2_r0_rwl
+ u_t002_000/r2_r1_rwl u_t002_000/r3_w0_wl u_t002_000/r3_w1_wl u_t002_000/r3_r0_rwl u_t002_000/r3_r1_rwl VDD VSS VSUBS
+ detronyx_12t_2w2r_rc4_4x4_routed_5layer_direct
Xu_t002_011 u_t002_011/c0_w0_bl u_t002_011/c0_w0_br u_t002_011/c0_w1_bl u_t002_011/c0_w1_br u_t002_011/c0_r0_rbl
+ u_t002_011/c0_r1_rbl u_t002_011/c1_w0_bl u_t002_011/c1_w0_br u_t002_011/c1_w1_bl u_t002_011/c1_w1_br
+ u_t002_011/c1_r0_rbl u_t002_011/c1_r1_rbl u_t002_011/c2_w0_bl u_t002_011/c2_w0_br u_t002_011/c2_w1_bl
+ u_t002_011/c2_w1_br u_t002_011/c2_r0_rbl u_t002_011/c2_r1_rbl u_t002_011/c3_w0_bl u_t002_011/c3_w0_br
+ u_t002_011/c3_w1_bl u_t002_011/c3_w1_br u_t002_011/c3_r0_rbl u_t002_011/c3_r1_rbl u_t002_011/r0_w0_wl
+ u_t002_011/r0_w1_wl u_t002_011/r0_r0_rwl u_t002_011/r0_r1_rwl u_t002_011/r1_w0_wl u_t002_011/r1_w1_wl
+ u_t002_011/r1_r0_rwl u_t002_011/r1_r1_rwl u_t002_011/r2_w0_wl u_t002_011/r2_w1_wl u_t002_011/r2_r0_rwl
+ u_t002_011/r2_r1_rwl u_t002_011/r3_w0_wl u_t002_011/r3_w1_wl u_t002_011/r3_r0_rwl u_t002_011/r3_r1_rwl VDD VSS VSUBS
+ detronyx_12t_2w2r_rc4_4x4_routed_5layer_direct
Xu_t015_009 u_t015_009/c0_w0_bl u_t015_009/c0_w0_br u_t015_009/c0_w1_bl u_t015_009/c0_w1_br u_t015_009/c0_r0_rbl
+ u_t015_009/c0_r1_rbl u_t015_009/c1_w0_bl u_t015_009/c1_w0_br u_t015_009/c1_w1_bl u_t015_009/c1_w1_br
+ u_t015_009/c1_r0_rbl u_t015_009/c1_r1_rbl u_t015_009/c2_w0_bl u_t015_009/c2_w0_br u_t015_009/c2_w1_bl
+ u_t015_009/c2_w1_br u_t015_009/c2_r0_rbl u_t015_009/c2_r1_rbl u_t015_009/c3_w0_bl u_t015_009/c3_w0_br
+ u_t015_009/c3_w1_bl u_t015_009/c3_w1_br u_t015_009/c3_r0_rbl u_t015_009/c3_r1_rbl u_t015_009/r0_w0_wl
+ u_t015_009/r0_w1_wl u_t015_009/r0_r0_rwl u_t015_009/r0_r1_rwl u_t015_009/r1_w0_wl u_t015_009/r1_w1_wl
+ u_t015_009/r1_r0_rwl u_t015_009/r1_r1_rwl u_t015_009/r2_w0_wl u_t015_009/r2_w1_wl u_t015_009/r2_r0_rwl
+ u_t015_009/r2_r1_rwl u_t015_009/r3_w0_wl u_t015_009/r3_w1_wl u_t015_009/r3_r0_rwl u_t015_009/r3_r1_rwl VDD VSS VSUBS
+ detronyx_12t_2w2r_rc4_4x4_routed_5layer_direct
Xu_t009_006 u_t009_006/c0_w0_bl u_t009_006/c0_w0_br u_t009_006/c0_w1_bl u_t009_006/c0_w1_br u_t009_006/c0_r0_rbl
+ u_t009_006/c0_r1_rbl u_t009_006/c1_w0_bl u_t009_006/c1_w0_br u_t009_006/c1_w1_bl u_t009_006/c1_w1_br
+ u_t009_006/c1_r0_rbl u_t009_006/c1_r1_rbl u_t009_006/c2_w0_bl u_t009_006/c2_w0_br u_t009_006/c2_w1_bl
+ u_t009_006/c2_w1_br u_t009_006/c2_r0_rbl u_t009_006/c2_r1_rbl u_t009_006/c3_w0_bl u_t009_006/c3_w0_br
+ u_t009_006/c3_w1_bl u_t009_006/c3_w1_br u_t009_006/c3_r0_rbl u_t009_006/c3_r1_rbl u_t009_006/r0_w0_wl
+ u_t009_006/r0_w1_wl u_t009_006/r0_r0_rwl u_t009_006/r0_r1_rwl u_t009_006/r1_w0_wl u_t009_006/r1_w1_wl
+ u_t009_006/r1_r0_rwl u_t009_006/r1_r1_rwl u_t009_006/r2_w0_wl u_t009_006/r2_w1_wl u_t009_006/r2_r0_rwl
+ u_t009_006/r2_r1_rwl u_t009_006/r3_w0_wl u_t009_006/r3_w1_wl u_t009_006/r3_r0_rwl u_t009_006/r3_r1_rwl VDD VSS VSUBS
+ detronyx_12t_2w2r_rc4_4x4_routed_5layer_direct
Xu_t011_012 u_t011_012/c0_w0_bl u_t011_012/c0_w0_br u_t011_012/c0_w1_bl u_t011_012/c0_w1_br u_t011_012/c0_r0_rbl
+ u_t011_012/c0_r1_rbl u_t011_012/c1_w0_bl u_t011_012/c1_w0_br u_t011_012/c1_w1_bl u_t011_012/c1_w1_br
+ u_t011_012/c1_r0_rbl u_t011_012/c1_r1_rbl u_t011_012/c2_w0_bl u_t011_012/c2_w0_br u_t011_012/c2_w1_bl
+ u_t011_012/c2_w1_br u_t011_012/c2_r0_rbl u_t011_012/c2_r1_rbl u_t011_012/c3_w0_bl u_t011_012/c3_w0_br
+ u_t011_012/c3_w1_bl u_t011_012/c3_w1_br u_t011_012/c3_r0_rbl u_t011_012/c3_r1_rbl u_t011_012/r0_w0_wl
+ u_t011_012/r0_w1_wl u_t011_012/r0_r0_rwl u_t011_012/r0_r1_rwl u_t011_012/r1_w0_wl u_t011_012/r1_w1_wl
+ u_t011_012/r1_r0_rwl u_t011_012/r1_r1_rwl u_t011_012/r2_w0_wl u_t011_012/r2_w1_wl u_t011_012/r2_r0_rwl
+ u_t011_012/r2_r1_rwl u_t011_012/r3_w0_wl u_t011_012/r3_w1_wl u_t011_012/r3_r0_rwl u_t011_012/r3_r1_rwl VDD VSS VSUBS
+ detronyx_12t_2w2r_rc4_4x4_routed_5layer_direct
Xu_t011_001 u_t011_001/c0_w0_bl u_t011_001/c0_w0_br u_t011_001/c0_w1_bl u_t011_001/c0_w1_br u_t011_001/c0_r0_rbl
+ u_t011_001/c0_r1_rbl u_t011_001/c1_w0_bl u_t011_001/c1_w0_br u_t011_001/c1_w1_bl u_t011_001/c1_w1_br
+ u_t011_001/c1_r0_rbl u_t011_001/c1_r1_rbl u_t011_001/c2_w0_bl u_t011_001/c2_w0_br u_t011_001/c2_w1_bl
+ u_t011_001/c2_w1_br u_t011_001/c2_r0_rbl u_t011_001/c2_r1_rbl u_t011_001/c3_w0_bl u_t011_001/c3_w0_br
+ u_t011_001/c3_w1_bl u_t011_001/c3_w1_br u_t011_001/c3_r0_rbl u_t011_001/c3_r1_rbl u_t011_001/r0_w0_wl
+ u_t011_001/r0_w1_wl u_t011_001/r0_r0_rwl u_t011_001/r0_r1_rwl u_t011_001/r1_w0_wl u_t011_001/r1_w1_wl
+ u_t011_001/r1_r0_rwl u_t011_001/r1_r1_rwl u_t011_001/r2_w0_wl u_t011_001/r2_w1_wl u_t011_001/r2_r0_rwl
+ u_t011_001/r2_r1_rwl u_t011_001/r3_w0_wl u_t011_001/r3_w1_wl u_t011_001/r3_r0_rwl u_t011_001/r3_r1_rwl VDD VSS VSUBS
+ detronyx_12t_2w2r_rc4_4x4_routed_5layer_direct
Xu_t006_009 u_t006_009/c0_w0_bl u_t006_009/c0_w0_br u_t006_009/c0_w1_bl u_t006_009/c0_w1_br u_t006_009/c0_r0_rbl
+ u_t006_009/c0_r1_rbl u_t006_009/c1_w0_bl u_t006_009/c1_w0_br u_t006_009/c1_w1_bl u_t006_009/c1_w1_br
+ u_t006_009/c1_r0_rbl u_t006_009/c1_r1_rbl u_t006_009/c2_w0_bl u_t006_009/c2_w0_br u_t006_009/c2_w1_bl
+ u_t006_009/c2_w1_br u_t006_009/c2_r0_rbl u_t006_009/c2_r1_rbl u_t006_009/c3_w0_bl u_t006_009/c3_w0_br
+ u_t006_009/c3_w1_bl u_t006_009/c3_w1_br u_t006_009/c3_r0_rbl u_t006_009/c3_r1_rbl u_t006_009/r0_w0_wl
+ u_t006_009/r0_w1_wl u_t006_009/r0_r0_rwl u_t006_009/r0_r1_rwl u_t006_009/r1_w0_wl u_t006_009/r1_w1_wl
+ u_t006_009/r1_r0_rwl u_t006_009/r1_r1_rwl u_t006_009/r2_w0_wl u_t006_009/r2_w1_wl u_t006_009/r2_r0_rwl
+ u_t006_009/r2_r1_rwl u_t006_009/r3_w0_wl u_t006_009/r3_w1_wl u_t006_009/r3_r0_rwl u_t006_009/r3_r1_rwl VDD VSS VSUBS
+ detronyx_12t_2w2r_rc4_4x4_routed_5layer_direct
Xu_t002_001 u_t002_001/c0_w0_bl u_t002_001/c0_w0_br u_t002_001/c0_w1_bl u_t002_001/c0_w1_br u_t002_001/c0_r0_rbl
+ u_t002_001/c0_r1_rbl u_t002_001/c1_w0_bl u_t002_001/c1_w0_br u_t002_001/c1_w1_bl u_t002_001/c1_w1_br
+ u_t002_001/c1_r0_rbl u_t002_001/c1_r1_rbl u_t002_001/c2_w0_bl u_t002_001/c2_w0_br u_t002_001/c2_w1_bl
+ u_t002_001/c2_w1_br u_t002_001/c2_r0_rbl u_t002_001/c2_r1_rbl u_t002_001/c3_w0_bl u_t002_001/c3_w0_br
+ u_t002_001/c3_w1_bl u_t002_001/c3_w1_br u_t002_001/c3_r0_rbl u_t002_001/c3_r1_rbl u_t002_001/r0_w0_wl
+ u_t002_001/r0_w1_wl u_t002_001/r0_r0_rwl u_t002_001/r0_r1_rwl u_t002_001/r1_w0_wl u_t002_001/r1_w1_wl
+ u_t002_001/r1_r0_rwl u_t002_001/r1_r1_rwl u_t002_001/r2_w0_wl u_t002_001/r2_w1_wl u_t002_001/r2_r0_rwl
+ u_t002_001/r2_r1_rwl u_t002_001/r3_w0_wl u_t002_001/r3_w1_wl u_t002_001/r3_r0_rwl u_t002_001/r3_r1_rwl VDD VSS VSUBS
+ detronyx_12t_2w2r_rc4_4x4_routed_5layer_direct
Xu_t002_012 u_t002_012/c0_w0_bl u_t002_012/c0_w0_br u_t002_012/c0_w1_bl u_t002_012/c0_w1_br u_t002_012/c0_r0_rbl
+ u_t002_012/c0_r1_rbl u_t002_012/c1_w0_bl u_t002_012/c1_w0_br u_t002_012/c1_w1_bl u_t002_012/c1_w1_br
+ u_t002_012/c1_r0_rbl u_t002_012/c1_r1_rbl u_t002_012/c2_w0_bl u_t002_012/c2_w0_br u_t002_012/c2_w1_bl
+ u_t002_012/c2_w1_br u_t002_012/c2_r0_rbl u_t002_012/c2_r1_rbl u_t002_012/c3_w0_bl u_t002_012/c3_w0_br
+ u_t002_012/c3_w1_bl u_t002_012/c3_w1_br u_t002_012/c3_r0_rbl u_t002_012/c3_r1_rbl u_t002_012/r0_w0_wl
+ u_t002_012/r0_w1_wl u_t002_012/r0_r0_rwl u_t002_012/r0_r1_rwl u_t002_012/r1_w0_wl u_t002_012/r1_w1_wl
+ u_t002_012/r1_r0_rwl u_t002_012/r1_r1_rwl u_t002_012/r2_w0_wl u_t002_012/r2_w1_wl u_t002_012/r2_r0_rwl
+ u_t002_012/r2_r1_rwl u_t002_012/r3_w0_wl u_t002_012/r3_w1_wl u_t002_012/r3_r0_rwl u_t002_012/r3_r1_rwl VDD VSS VSUBS
+ detronyx_12t_2w2r_rc4_4x4_routed_5layer_direct
Xu_t014_010 u_t014_010/c0_w0_bl u_t014_010/c0_w0_br u_t014_010/c0_w1_bl u_t014_010/c0_w1_br u_t014_010/c0_r0_rbl
+ u_t014_010/c0_r1_rbl u_t014_010/c1_w0_bl u_t014_010/c1_w0_br u_t014_010/c1_w1_bl u_t014_010/c1_w1_br
+ u_t014_010/c1_r0_rbl u_t014_010/c1_r1_rbl u_t014_010/c2_w0_bl u_t014_010/c2_w0_br u_t014_010/c2_w1_bl
+ u_t014_010/c2_w1_br u_t014_010/c2_r0_rbl u_t014_010/c2_r1_rbl u_t014_010/c3_w0_bl u_t014_010/c3_w0_br
+ u_t014_010/c3_w1_bl u_t014_010/c3_w1_br u_t014_010/c3_r0_rbl u_t014_010/c3_r1_rbl u_t014_010/r0_w0_wl
+ u_t014_010/r0_w1_wl u_t014_010/r0_r0_rwl u_t014_010/r0_r1_rwl u_t014_010/r1_w0_wl u_t014_010/r1_w1_wl
+ u_t014_010/r1_r0_rwl u_t014_010/r1_r1_rwl u_t014_010/r2_w0_wl u_t014_010/r2_w1_wl u_t014_010/r2_r0_rwl
+ u_t014_010/r2_r1_rwl u_t014_010/r3_w0_wl u_t014_010/r3_w1_wl u_t014_010/r3_r0_rwl u_t014_010/r3_r1_rwl VDD VSS VSUBS
+ detronyx_12t_2w2r_rc4_4x4_routed_5layer_direct
Xu_t009_007 u_t009_007/c0_w0_bl u_t009_007/c0_w0_br u_t009_007/c0_w1_bl u_t009_007/c0_w1_br u_t009_007/c0_r0_rbl
+ u_t009_007/c0_r1_rbl u_t009_007/c1_w0_bl u_t009_007/c1_w0_br u_t009_007/c1_w1_bl u_t009_007/c1_w1_br
+ u_t009_007/c1_r0_rbl u_t009_007/c1_r1_rbl u_t009_007/c2_w0_bl u_t009_007/c2_w0_br u_t009_007/c2_w1_bl
+ u_t009_007/c2_w1_br u_t009_007/c2_r0_rbl u_t009_007/c2_r1_rbl u_t009_007/c3_w0_bl u_t009_007/c3_w0_br
+ u_t009_007/c3_w1_bl u_t009_007/c3_w1_br u_t009_007/c3_r0_rbl u_t009_007/c3_r1_rbl u_t009_007/r0_w0_wl
+ u_t009_007/r0_w1_wl u_t009_007/r0_r0_rwl u_t009_007/r0_r1_rwl u_t009_007/r1_w0_wl u_t009_007/r1_w1_wl
+ u_t009_007/r1_r0_rwl u_t009_007/r1_r1_rwl u_t009_007/r2_w0_wl u_t009_007/r2_w1_wl u_t009_007/r2_r0_rwl
+ u_t009_007/r2_r1_rwl u_t009_007/r3_w0_wl u_t009_007/r3_w1_wl u_t009_007/r3_r0_rwl u_t009_007/r3_r1_rwl VDD VSS VSUBS
+ detronyx_12t_2w2r_rc4_4x4_routed_5layer_direct
Xu_t005_010 u_t005_010/c0_w0_bl u_t005_010/c0_w0_br u_t005_010/c0_w1_bl u_t005_010/c0_w1_br u_t005_010/c0_r0_rbl
+ u_t005_010/c0_r1_rbl u_t005_010/c1_w0_bl u_t005_010/c1_w0_br u_t005_010/c1_w1_bl u_t005_010/c1_w1_br
+ u_t005_010/c1_r0_rbl u_t005_010/c1_r1_rbl u_t005_010/c2_w0_bl u_t005_010/c2_w0_br u_t005_010/c2_w1_bl
+ u_t005_010/c2_w1_br u_t005_010/c2_r0_rbl u_t005_010/c2_r1_rbl u_t005_010/c3_w0_bl u_t005_010/c3_w0_br
+ u_t005_010/c3_w1_bl u_t005_010/c3_w1_br u_t005_010/c3_r0_rbl u_t005_010/c3_r1_rbl u_t005_010/r0_w0_wl
+ u_t005_010/r0_w1_wl u_t005_010/r0_r0_rwl u_t005_010/r0_r1_rwl u_t005_010/r1_w0_wl u_t005_010/r1_w1_wl
+ u_t005_010/r1_r0_rwl u_t005_010/r1_r1_rwl u_t005_010/r2_w0_wl u_t005_010/r2_w1_wl u_t005_010/r2_r0_rwl
+ u_t005_010/r2_r1_rwl u_t005_010/r3_w0_wl u_t005_010/r3_w1_wl u_t005_010/r3_r0_rwl u_t005_010/r3_r1_rwl VDD VSS VSUBS
+ detronyx_12t_2w2r_rc4_4x4_routed_5layer_direct
Xu_t011_013 u_t011_013/c0_w0_bl u_t011_013/c0_w0_br u_t011_013/c0_w1_bl u_t011_013/c0_w1_br u_t011_013/c0_r0_rbl
+ u_t011_013/c0_r1_rbl u_t011_013/c1_w0_bl u_t011_013/c1_w0_br u_t011_013/c1_w1_bl u_t011_013/c1_w1_br
+ u_t011_013/c1_r0_rbl u_t011_013/c1_r1_rbl u_t011_013/c2_w0_bl u_t011_013/c2_w0_br u_t011_013/c2_w1_bl
+ u_t011_013/c2_w1_br u_t011_013/c2_r0_rbl u_t011_013/c2_r1_rbl u_t011_013/c3_w0_bl u_t011_013/c3_w0_br
+ u_t011_013/c3_w1_bl u_t011_013/c3_w1_br u_t011_013/c3_r0_rbl u_t011_013/c3_r1_rbl u_t011_013/r0_w0_wl
+ u_t011_013/r0_w1_wl u_t011_013/r0_r0_rwl u_t011_013/r0_r1_rwl u_t011_013/r1_w0_wl u_t011_013/r1_w1_wl
+ u_t011_013/r1_r0_rwl u_t011_013/r1_r1_rwl u_t011_013/r2_w0_wl u_t011_013/r2_w1_wl u_t011_013/r2_r0_rwl
+ u_t011_013/r2_r1_rwl u_t011_013/r3_w0_wl u_t011_013/r3_w1_wl u_t011_013/r3_r0_rwl u_t011_013/r3_r1_rwl VDD VSS VSUBS
+ detronyx_12t_2w2r_rc4_4x4_routed_5layer_direct
Xu_t011_002 u_t011_002/c0_w0_bl u_t011_002/c0_w0_br u_t011_002/c0_w1_bl u_t011_002/c0_w1_br u_t011_002/c0_r0_rbl
+ u_t011_002/c0_r1_rbl u_t011_002/c1_w0_bl u_t011_002/c1_w0_br u_t011_002/c1_w1_bl u_t011_002/c1_w1_br
+ u_t011_002/c1_r0_rbl u_t011_002/c1_r1_rbl u_t011_002/c2_w0_bl u_t011_002/c2_w0_br u_t011_002/c2_w1_bl
+ u_t011_002/c2_w1_br u_t011_002/c2_r0_rbl u_t011_002/c2_r1_rbl u_t011_002/c3_w0_bl u_t011_002/c3_w0_br
+ u_t011_002/c3_w1_bl u_t011_002/c3_w1_br u_t011_002/c3_r0_rbl u_t011_002/c3_r1_rbl u_t011_002/r0_w0_wl
+ u_t011_002/r0_w1_wl u_t011_002/r0_r0_rwl u_t011_002/r0_r1_rwl u_t011_002/r1_w0_wl u_t011_002/r1_w1_wl
+ u_t011_002/r1_r0_rwl u_t011_002/r1_r1_rwl u_t011_002/r2_w0_wl u_t011_002/r2_w1_wl u_t011_002/r2_r0_rwl
+ u_t011_002/r2_r1_rwl u_t011_002/r3_w0_wl u_t011_002/r3_w1_wl u_t011_002/r3_r0_rwl u_t011_002/r3_r1_rwl VDD VSS VSUBS
+ detronyx_12t_2w2r_rc4_4x4_routed_5layer_direct
Xu_t002_002 u_t002_002/c0_w0_bl u_t002_002/c0_w0_br u_t002_002/c0_w1_bl u_t002_002/c0_w1_br u_t002_002/c0_r0_rbl
+ u_t002_002/c0_r1_rbl u_t002_002/c1_w0_bl u_t002_002/c1_w0_br u_t002_002/c1_w1_bl u_t002_002/c1_w1_br
+ u_t002_002/c1_r0_rbl u_t002_002/c1_r1_rbl u_t002_002/c2_w0_bl u_t002_002/c2_w0_br u_t002_002/c2_w1_bl
+ u_t002_002/c2_w1_br u_t002_002/c2_r0_rbl u_t002_002/c2_r1_rbl u_t002_002/c3_w0_bl u_t002_002/c3_w0_br
+ u_t002_002/c3_w1_bl u_t002_002/c3_w1_br u_t002_002/c3_r0_rbl u_t002_002/c3_r1_rbl u_t002_002/r0_w0_wl
+ u_t002_002/r0_w1_wl u_t002_002/r0_r0_rwl u_t002_002/r0_r1_rwl u_t002_002/r1_w0_wl u_t002_002/r1_w1_wl
+ u_t002_002/r1_r0_rwl u_t002_002/r1_r1_rwl u_t002_002/r2_w0_wl u_t002_002/r2_w1_wl u_t002_002/r2_r0_rwl
+ u_t002_002/r2_r1_rwl u_t002_002/r3_w0_wl u_t002_002/r3_w1_wl u_t002_002/r3_r0_rwl u_t002_002/r3_r1_rwl VDD VSS VSUBS
+ detronyx_12t_2w2r_rc4_4x4_routed_5layer_direct
Xu_t002_013 u_t002_013/c0_w0_bl u_t002_013/c0_w0_br u_t002_013/c0_w1_bl u_t002_013/c0_w1_br u_t002_013/c0_r0_rbl
+ u_t002_013/c0_r1_rbl u_t002_013/c1_w0_bl u_t002_013/c1_w0_br u_t002_013/c1_w1_bl u_t002_013/c1_w1_br
+ u_t002_013/c1_r0_rbl u_t002_013/c1_r1_rbl u_t002_013/c2_w0_bl u_t002_013/c2_w0_br u_t002_013/c2_w1_bl
+ u_t002_013/c2_w1_br u_t002_013/c2_r0_rbl u_t002_013/c2_r1_rbl u_t002_013/c3_w0_bl u_t002_013/c3_w0_br
+ u_t002_013/c3_w1_bl u_t002_013/c3_w1_br u_t002_013/c3_r0_rbl u_t002_013/c3_r1_rbl u_t002_013/r0_w0_wl
+ u_t002_013/r0_w1_wl u_t002_013/r0_r0_rwl u_t002_013/r0_r1_rwl u_t002_013/r1_w0_wl u_t002_013/r1_w1_wl
+ u_t002_013/r1_r0_rwl u_t002_013/r1_r1_rwl u_t002_013/r2_w0_wl u_t002_013/r2_w1_wl u_t002_013/r2_r0_rwl
+ u_t002_013/r2_r1_rwl u_t002_013/r3_w0_wl u_t002_013/r3_w1_wl u_t002_013/r3_r0_rwl u_t002_013/r3_r1_rwl VDD VSS VSUBS
+ detronyx_12t_2w2r_rc4_4x4_routed_5layer_direct
Xu_t009_008 u_t009_008/c0_w0_bl u_t009_008/c0_w0_br u_t009_008/c0_w1_bl u_t009_008/c0_w1_br u_t009_008/c0_r0_rbl
+ u_t009_008/c0_r1_rbl u_t009_008/c1_w0_bl u_t009_008/c1_w0_br u_t009_008/c1_w1_bl u_t009_008/c1_w1_br
+ u_t009_008/c1_r0_rbl u_t009_008/c1_r1_rbl u_t009_008/c2_w0_bl u_t009_008/c2_w0_br u_t009_008/c2_w1_bl
+ u_t009_008/c2_w1_br u_t009_008/c2_r0_rbl u_t009_008/c2_r1_rbl u_t009_008/c3_w0_bl u_t009_008/c3_w0_br
+ u_t009_008/c3_w1_bl u_t009_008/c3_w1_br u_t009_008/c3_r0_rbl u_t009_008/c3_r1_rbl u_t009_008/r0_w0_wl
+ u_t009_008/r0_w1_wl u_t009_008/r0_r0_rwl u_t009_008/r0_r1_rwl u_t009_008/r1_w0_wl u_t009_008/r1_w1_wl
+ u_t009_008/r1_r0_rwl u_t009_008/r1_r1_rwl u_t009_008/r2_w0_wl u_t009_008/r2_w1_wl u_t009_008/r2_r0_rwl
+ u_t009_008/r2_r1_rwl u_t009_008/r3_w0_wl u_t009_008/r3_w1_wl u_t009_008/r3_r0_rwl u_t009_008/r3_r1_rwl VDD VSS VSUBS
+ detronyx_12t_2w2r_rc4_4x4_routed_5layer_direct
Xu_t014_011 u_t014_011/c0_w0_bl u_t014_011/c0_w0_br u_t014_011/c0_w1_bl u_t014_011/c0_w1_br u_t014_011/c0_r0_rbl
+ u_t014_011/c0_r1_rbl u_t014_011/c1_w0_bl u_t014_011/c1_w0_br u_t014_011/c1_w1_bl u_t014_011/c1_w1_br
+ u_t014_011/c1_r0_rbl u_t014_011/c1_r1_rbl u_t014_011/c2_w0_bl u_t014_011/c2_w0_br u_t014_011/c2_w1_bl
+ u_t014_011/c2_w1_br u_t014_011/c2_r0_rbl u_t014_011/c2_r1_rbl u_t014_011/c3_w0_bl u_t014_011/c3_w0_br
+ u_t014_011/c3_w1_bl u_t014_011/c3_w1_br u_t014_011/c3_r0_rbl u_t014_011/c3_r1_rbl u_t014_011/r0_w0_wl
+ u_t014_011/r0_w1_wl u_t014_011/r0_r0_rwl u_t014_011/r0_r1_rwl u_t014_011/r1_w0_wl u_t014_011/r1_w1_wl
+ u_t014_011/r1_r0_rwl u_t014_011/r1_r1_rwl u_t014_011/r2_w0_wl u_t014_011/r2_w1_wl u_t014_011/r2_r0_rwl
+ u_t014_011/r2_r1_rwl u_t014_011/r3_w0_wl u_t014_011/r3_w1_wl u_t014_011/r3_r0_rwl u_t014_011/r3_r1_rwl VDD VSS VSUBS
+ detronyx_12t_2w2r_rc4_4x4_routed_5layer_direct
Xu_t014_000 u_t014_000/c0_w0_bl u_t014_000/c0_w0_br u_t014_000/c0_w1_bl u_t014_000/c0_w1_br u_t014_000/c0_r0_rbl
+ u_t014_000/c0_r1_rbl u_t014_000/c1_w0_bl u_t014_000/c1_w0_br u_t014_000/c1_w1_bl u_t014_000/c1_w1_br
+ u_t014_000/c1_r0_rbl u_t014_000/c1_r1_rbl u_t014_000/c2_w0_bl u_t014_000/c2_w0_br u_t014_000/c2_w1_bl
+ u_t014_000/c2_w1_br u_t014_000/c2_r0_rbl u_t014_000/c2_r1_rbl u_t014_000/c3_w0_bl u_t014_000/c3_w0_br
+ u_t014_000/c3_w1_bl u_t014_000/c3_w1_br u_t014_000/c3_r0_rbl u_t014_000/c3_r1_rbl u_t014_000/r0_w0_wl
+ u_t014_000/r0_w1_wl u_t014_000/r0_r0_rwl u_t014_000/r0_r1_rwl u_t014_000/r1_w0_wl u_t014_000/r1_w1_wl
+ u_t014_000/r1_r0_rwl u_t014_000/r1_r1_rwl u_t014_000/r2_w0_wl u_t014_000/r2_w1_wl u_t014_000/r2_r0_rwl
+ u_t014_000/r2_r1_rwl u_t014_000/r3_w0_wl u_t014_000/r3_w1_wl u_t014_000/r3_r0_rwl u_t014_000/r3_r1_rwl VDD VSS VSUBS
+ detronyx_12t_2w2r_rc4_4x4_routed_5layer_direct
Xu_t011_014 u_t011_014/c0_w0_bl u_t011_014/c0_w0_br u_t011_014/c0_w1_bl u_t011_014/c0_w1_br u_t011_014/c0_r0_rbl
+ u_t011_014/c0_r1_rbl u_t011_014/c1_w0_bl u_t011_014/c1_w0_br u_t011_014/c1_w1_bl u_t011_014/c1_w1_br
+ u_t011_014/c1_r0_rbl u_t011_014/c1_r1_rbl u_t011_014/c2_w0_bl u_t011_014/c2_w0_br u_t011_014/c2_w1_bl
+ u_t011_014/c2_w1_br u_t011_014/c2_r0_rbl u_t011_014/c2_r1_rbl u_t011_014/c3_w0_bl u_t011_014/c3_w0_br
+ u_t011_014/c3_w1_bl u_t011_014/c3_w1_br u_t011_014/c3_r0_rbl u_t011_014/c3_r1_rbl u_t011_014/r0_w0_wl
+ u_t011_014/r0_w1_wl u_t011_014/r0_r0_rwl u_t011_014/r0_r1_rwl u_t011_014/r1_w0_wl u_t011_014/r1_w1_wl
+ u_t011_014/r1_r0_rwl u_t011_014/r1_r1_rwl u_t011_014/r2_w0_wl u_t011_014/r2_w1_wl u_t011_014/r2_r0_rwl
+ u_t011_014/r2_r1_rwl u_t011_014/r3_w0_wl u_t011_014/r3_w1_wl u_t011_014/r3_r0_rwl u_t011_014/r3_r1_rwl VDD VSS VSUBS
+ detronyx_12t_2w2r_rc4_4x4_routed_5layer_direct
Xu_t011_003 u_t011_003/c0_w0_bl u_t011_003/c0_w0_br u_t011_003/c0_w1_bl u_t011_003/c0_w1_br u_t011_003/c0_r0_rbl
+ u_t011_003/c0_r1_rbl u_t011_003/c1_w0_bl u_t011_003/c1_w0_br u_t011_003/c1_w1_bl u_t011_003/c1_w1_br
+ u_t011_003/c1_r0_rbl u_t011_003/c1_r1_rbl u_t011_003/c2_w0_bl u_t011_003/c2_w0_br u_t011_003/c2_w1_bl
+ u_t011_003/c2_w1_br u_t011_003/c2_r0_rbl u_t011_003/c2_r1_rbl u_t011_003/c3_w0_bl u_t011_003/c3_w0_br
+ u_t011_003/c3_w1_bl u_t011_003/c3_w1_br u_t011_003/c3_r0_rbl u_t011_003/c3_r1_rbl u_t011_003/r0_w0_wl
+ u_t011_003/r0_w1_wl u_t011_003/r0_r0_rwl u_t011_003/r0_r1_rwl u_t011_003/r1_w0_wl u_t011_003/r1_w1_wl
+ u_t011_003/r1_r0_rwl u_t011_003/r1_r1_rwl u_t011_003/r2_w0_wl u_t011_003/r2_w1_wl u_t011_003/r2_r0_rwl
+ u_t011_003/r2_r1_rwl u_t011_003/r3_w0_wl u_t011_003/r3_w1_wl u_t011_003/r3_r0_rwl u_t011_003/r3_r1_rwl VDD VSS VSUBS
+ detronyx_12t_2w2r_rc4_4x4_routed_5layer_direct
Xu_t005_011 u_t005_011/c0_w0_bl u_t005_011/c0_w0_br u_t005_011/c0_w1_bl u_t005_011/c0_w1_br u_t005_011/c0_r0_rbl
+ u_t005_011/c0_r1_rbl u_t005_011/c1_w0_bl u_t005_011/c1_w0_br u_t005_011/c1_w1_bl u_t005_011/c1_w1_br
+ u_t005_011/c1_r0_rbl u_t005_011/c1_r1_rbl u_t005_011/c2_w0_bl u_t005_011/c2_w0_br u_t005_011/c2_w1_bl
+ u_t005_011/c2_w1_br u_t005_011/c2_r0_rbl u_t005_011/c2_r1_rbl u_t005_011/c3_w0_bl u_t005_011/c3_w0_br
+ u_t005_011/c3_w1_bl u_t005_011/c3_w1_br u_t005_011/c3_r0_rbl u_t005_011/c3_r1_rbl u_t005_011/r0_w0_wl
+ u_t005_011/r0_w1_wl u_t005_011/r0_r0_rwl u_t005_011/r0_r1_rwl u_t005_011/r1_w0_wl u_t005_011/r1_w1_wl
+ u_t005_011/r1_r0_rwl u_t005_011/r1_r1_rwl u_t005_011/r2_w0_wl u_t005_011/r2_w1_wl u_t005_011/r2_r0_rwl
+ u_t005_011/r2_r1_rwl u_t005_011/r3_w0_wl u_t005_011/r3_w1_wl u_t005_011/r3_r0_rwl u_t005_011/r3_r1_rwl VDD VSS VSUBS
+ detronyx_12t_2w2r_rc4_4x4_routed_5layer_direct
Xu_t002_003 u_t002_003/c0_w0_bl u_t002_003/c0_w0_br u_t002_003/c0_w1_bl u_t002_003/c0_w1_br u_t002_003/c0_r0_rbl
+ u_t002_003/c0_r1_rbl u_t002_003/c1_w0_bl u_t002_003/c1_w0_br u_t002_003/c1_w1_bl u_t002_003/c1_w1_br
+ u_t002_003/c1_r0_rbl u_t002_003/c1_r1_rbl u_t002_003/c2_w0_bl u_t002_003/c2_w0_br u_t002_003/c2_w1_bl
+ u_t002_003/c2_w1_br u_t002_003/c2_r0_rbl u_t002_003/c2_r1_rbl u_t002_003/c3_w0_bl u_t002_003/c3_w0_br
+ u_t002_003/c3_w1_bl u_t002_003/c3_w1_br u_t002_003/c3_r0_rbl u_t002_003/c3_r1_rbl u_t002_003/r0_w0_wl
+ u_t002_003/r0_w1_wl u_t002_003/r0_r0_rwl u_t002_003/r0_r1_rwl u_t002_003/r1_w0_wl u_t002_003/r1_w1_wl
+ u_t002_003/r1_r0_rwl u_t002_003/r1_r1_rwl u_t002_003/r2_w0_wl u_t002_003/r2_w1_wl u_t002_003/r2_r0_rwl
+ u_t002_003/r2_r1_rwl u_t002_003/r3_w0_wl u_t002_003/r3_w1_wl u_t002_003/r3_r0_rwl u_t002_003/r3_r1_rwl VDD VSS VSUBS
+ detronyx_12t_2w2r_rc4_4x4_routed_5layer_direct
Xu_t002_014 u_t002_014/c0_w0_bl u_t002_014/c0_w0_br u_t002_014/c0_w1_bl u_t002_014/c0_w1_br u_t002_014/c0_r0_rbl
+ u_t002_014/c0_r1_rbl u_t002_014/c1_w0_bl u_t002_014/c1_w0_br u_t002_014/c1_w1_bl u_t002_014/c1_w1_br
+ u_t002_014/c1_r0_rbl u_t002_014/c1_r1_rbl u_t002_014/c2_w0_bl u_t002_014/c2_w0_br u_t002_014/c2_w1_bl
+ u_t002_014/c2_w1_br u_t002_014/c2_r0_rbl u_t002_014/c2_r1_rbl u_t002_014/c3_w0_bl u_t002_014/c3_w0_br
+ u_t002_014/c3_w1_bl u_t002_014/c3_w1_br u_t002_014/c3_r0_rbl u_t002_014/c3_r1_rbl u_t002_014/r0_w0_wl
+ u_t002_014/r0_w1_wl u_t002_014/r0_r0_rwl u_t002_014/r0_r1_rwl u_t002_014/r1_w0_wl u_t002_014/r1_w1_wl
+ u_t002_014/r1_r0_rwl u_t002_014/r1_r1_rwl u_t002_014/r2_w0_wl u_t002_014/r2_w1_wl u_t002_014/r2_r0_rwl
+ u_t002_014/r2_r1_rwl u_t002_014/r3_w0_wl u_t002_014/r3_w1_wl u_t002_014/r3_r0_rwl u_t002_014/r3_r1_rwl VDD VSS VSUBS
+ detronyx_12t_2w2r_rc4_4x4_routed_5layer_direct
Xu_t005_000 u_t005_000/c0_w0_bl u_t005_000/c0_w0_br u_t005_000/c0_w1_bl u_t005_000/c0_w1_br u_t005_000/c0_r0_rbl
+ u_t005_000/c0_r1_rbl u_t005_000/c1_w0_bl u_t005_000/c1_w0_br u_t005_000/c1_w1_bl u_t005_000/c1_w1_br
+ u_t005_000/c1_r0_rbl u_t005_000/c1_r1_rbl u_t005_000/c2_w0_bl u_t005_000/c2_w0_br u_t005_000/c2_w1_bl
+ u_t005_000/c2_w1_br u_t005_000/c2_r0_rbl u_t005_000/c2_r1_rbl u_t005_000/c3_w0_bl u_t005_000/c3_w0_br
+ u_t005_000/c3_w1_bl u_t005_000/c3_w1_br u_t005_000/c3_r0_rbl u_t005_000/c3_r1_rbl u_t005_000/r0_w0_wl
+ u_t005_000/r0_w1_wl u_t005_000/r0_r0_rwl u_t005_000/r0_r1_rwl u_t005_000/r1_w0_wl u_t005_000/r1_w1_wl
+ u_t005_000/r1_r0_rwl u_t005_000/r1_r1_rwl u_t005_000/r2_w0_wl u_t005_000/r2_w1_wl u_t005_000/r2_r0_rwl
+ u_t005_000/r2_r1_rwl u_t005_000/r3_w0_wl u_t005_000/r3_w1_wl u_t005_000/r3_r0_rwl u_t005_000/r3_r1_rwl VDD VSS VSUBS
+ detronyx_12t_2w2r_rc4_4x4_routed_5layer_direct
Xu_t014_012 u_t014_012/c0_w0_bl u_t014_012/c0_w0_br u_t014_012/c0_w1_bl u_t014_012/c0_w1_br u_t014_012/c0_r0_rbl
+ u_t014_012/c0_r1_rbl u_t014_012/c1_w0_bl u_t014_012/c1_w0_br u_t014_012/c1_w1_bl u_t014_012/c1_w1_br
+ u_t014_012/c1_r0_rbl u_t014_012/c1_r1_rbl u_t014_012/c2_w0_bl u_t014_012/c2_w0_br u_t014_012/c2_w1_bl
+ u_t014_012/c2_w1_br u_t014_012/c2_r0_rbl u_t014_012/c2_r1_rbl u_t014_012/c3_w0_bl u_t014_012/c3_w0_br
+ u_t014_012/c3_w1_bl u_t014_012/c3_w1_br u_t014_012/c3_r0_rbl u_t014_012/c3_r1_rbl u_t014_012/r0_w0_wl
+ u_t014_012/r0_w1_wl u_t014_012/r0_r0_rwl u_t014_012/r0_r1_rwl u_t014_012/r1_w0_wl u_t014_012/r1_w1_wl
+ u_t014_012/r1_r0_rwl u_t014_012/r1_r1_rwl u_t014_012/r2_w0_wl u_t014_012/r2_w1_wl u_t014_012/r2_r0_rwl
+ u_t014_012/r2_r1_rwl u_t014_012/r3_w0_wl u_t014_012/r3_w1_wl u_t014_012/r3_r0_rwl u_t014_012/r3_r1_rwl VDD VSS VSUBS
+ detronyx_12t_2w2r_rc4_4x4_routed_5layer_direct
Xu_t014_001 u_t014_001/c0_w0_bl u_t014_001/c0_w0_br u_t014_001/c0_w1_bl u_t014_001/c0_w1_br u_t014_001/c0_r0_rbl
+ u_t014_001/c0_r1_rbl u_t014_001/c1_w0_bl u_t014_001/c1_w0_br u_t014_001/c1_w1_bl u_t014_001/c1_w1_br
+ u_t014_001/c1_r0_rbl u_t014_001/c1_r1_rbl u_t014_001/c2_w0_bl u_t014_001/c2_w0_br u_t014_001/c2_w1_bl
+ u_t014_001/c2_w1_br u_t014_001/c2_r0_rbl u_t014_001/c2_r1_rbl u_t014_001/c3_w0_bl u_t014_001/c3_w0_br
+ u_t014_001/c3_w1_bl u_t014_001/c3_w1_br u_t014_001/c3_r0_rbl u_t014_001/c3_r1_rbl u_t014_001/r0_w0_wl
+ u_t014_001/r0_w1_wl u_t014_001/r0_r0_rwl u_t014_001/r0_r1_rwl u_t014_001/r1_w0_wl u_t014_001/r1_w1_wl
+ u_t014_001/r1_r0_rwl u_t014_001/r1_r1_rwl u_t014_001/r2_w0_wl u_t014_001/r2_w1_wl u_t014_001/r2_r0_rwl
+ u_t014_001/r2_r1_rwl u_t014_001/r3_w0_wl u_t014_001/r3_w1_wl u_t014_001/r3_r0_rwl u_t014_001/r3_r1_rwl VDD VSS VSUBS
+ detronyx_12t_2w2r_rc4_4x4_routed_5layer_direct
Xu_t009_009 u_t009_009/c0_w0_bl u_t009_009/c0_w0_br u_t009_009/c0_w1_bl u_t009_009/c0_w1_br u_t009_009/c0_r0_rbl
+ u_t009_009/c0_r1_rbl u_t009_009/c1_w0_bl u_t009_009/c1_w0_br u_t009_009/c1_w1_bl u_t009_009/c1_w1_br
+ u_t009_009/c1_r0_rbl u_t009_009/c1_r1_rbl u_t009_009/c2_w0_bl u_t009_009/c2_w0_br u_t009_009/c2_w1_bl
+ u_t009_009/c2_w1_br u_t009_009/c2_r0_rbl u_t009_009/c2_r1_rbl u_t009_009/c3_w0_bl u_t009_009/c3_w0_br
+ u_t009_009/c3_w1_bl u_t009_009/c3_w1_br u_t009_009/c3_r0_rbl u_t009_009/c3_r1_rbl u_t009_009/r0_w0_wl
+ u_t009_009/r0_w1_wl u_t009_009/r0_r0_rwl u_t009_009/r0_r1_rwl u_t009_009/r1_w0_wl u_t009_009/r1_w1_wl
+ u_t009_009/r1_r0_rwl u_t009_009/r1_r1_rwl u_t009_009/r2_w0_wl u_t009_009/r2_w1_wl u_t009_009/r2_r0_rwl
+ u_t009_009/r2_r1_rwl u_t009_009/r3_w0_wl u_t009_009/r3_w1_wl u_t009_009/r3_r0_rwl u_t009_009/r3_r1_rwl VDD VSS VSUBS
+ detronyx_12t_2w2r_rc4_4x4_routed_5layer_direct
Xu_t005_012 u_t005_012/c0_w0_bl u_t005_012/c0_w0_br u_t005_012/c0_w1_bl u_t005_012/c0_w1_br u_t005_012/c0_r0_rbl
+ u_t005_012/c0_r1_rbl u_t005_012/c1_w0_bl u_t005_012/c1_w0_br u_t005_012/c1_w1_bl u_t005_012/c1_w1_br
+ u_t005_012/c1_r0_rbl u_t005_012/c1_r1_rbl u_t005_012/c2_w0_bl u_t005_012/c2_w0_br u_t005_012/c2_w1_bl
+ u_t005_012/c2_w1_br u_t005_012/c2_r0_rbl u_t005_012/c2_r1_rbl u_t005_012/c3_w0_bl u_t005_012/c3_w0_br
+ u_t005_012/c3_w1_bl u_t005_012/c3_w1_br u_t005_012/c3_r0_rbl u_t005_012/c3_r1_rbl u_t005_012/r0_w0_wl
+ u_t005_012/r0_w1_wl u_t005_012/r0_r0_rwl u_t005_012/r0_r1_rwl u_t005_012/r1_w0_wl u_t005_012/r1_w1_wl
+ u_t005_012/r1_r0_rwl u_t005_012/r1_r1_rwl u_t005_012/r2_w0_wl u_t005_012/r2_w1_wl u_t005_012/r2_r0_rwl
+ u_t005_012/r2_r1_rwl u_t005_012/r3_w0_wl u_t005_012/r3_w1_wl u_t005_012/r3_r0_rwl u_t005_012/r3_r1_rwl VDD VSS VSUBS
+ detronyx_12t_2w2r_rc4_4x4_routed_5layer_direct
Xu_t005_001 u_t005_001/c0_w0_bl u_t005_001/c0_w0_br u_t005_001/c0_w1_bl u_t005_001/c0_w1_br u_t005_001/c0_r0_rbl
+ u_t005_001/c0_r1_rbl u_t005_001/c1_w0_bl u_t005_001/c1_w0_br u_t005_001/c1_w1_bl u_t005_001/c1_w1_br
+ u_t005_001/c1_r0_rbl u_t005_001/c1_r1_rbl u_t005_001/c2_w0_bl u_t005_001/c2_w0_br u_t005_001/c2_w1_bl
+ u_t005_001/c2_w1_br u_t005_001/c2_r0_rbl u_t005_001/c2_r1_rbl u_t005_001/c3_w0_bl u_t005_001/c3_w0_br
+ u_t005_001/c3_w1_bl u_t005_001/c3_w1_br u_t005_001/c3_r0_rbl u_t005_001/c3_r1_rbl u_t005_001/r0_w0_wl
+ u_t005_001/r0_w1_wl u_t005_001/r0_r0_rwl u_t005_001/r0_r1_rwl u_t005_001/r1_w0_wl u_t005_001/r1_w1_wl
+ u_t005_001/r1_r0_rwl u_t005_001/r1_r1_rwl u_t005_001/r2_w0_wl u_t005_001/r2_w1_wl u_t005_001/r2_r0_rwl
+ u_t005_001/r2_r1_rwl u_t005_001/r3_w0_wl u_t005_001/r3_w1_wl u_t005_001/r3_r0_rwl u_t005_001/r3_r1_rwl VDD VSS VSUBS
+ detronyx_12t_2w2r_rc4_4x4_routed_5layer_direct
Xu_t011_015 u_t011_015/c0_w0_bl u_t011_015/c0_w0_br u_t011_015/c0_w1_bl u_t011_015/c0_w1_br u_t011_015/c0_r0_rbl
+ u_t011_015/c0_r1_rbl u_t011_015/c1_w0_bl u_t011_015/c1_w0_br u_t011_015/c1_w1_bl u_t011_015/c1_w1_br
+ u_t011_015/c1_r0_rbl u_t011_015/c1_r1_rbl u_t011_015/c2_w0_bl u_t011_015/c2_w0_br u_t011_015/c2_w1_bl
+ u_t011_015/c2_w1_br u_t011_015/c2_r0_rbl u_t011_015/c2_r1_rbl u_t011_015/c3_w0_bl u_t011_015/c3_w0_br
+ u_t011_015/c3_w1_bl u_t011_015/c3_w1_br u_t011_015/c3_r0_rbl u_t011_015/c3_r1_rbl u_t011_015/r0_w0_wl
+ u_t011_015/r0_w1_wl u_t011_015/r0_r0_rwl u_t011_015/r0_r1_rwl u_t011_015/r1_w0_wl u_t011_015/r1_w1_wl
+ u_t011_015/r1_r0_rwl u_t011_015/r1_r1_rwl u_t011_015/r2_w0_wl u_t011_015/r2_w1_wl u_t011_015/r2_r0_rwl
+ u_t011_015/r2_r1_rwl u_t011_015/r3_w0_wl u_t011_015/r3_w1_wl u_t011_015/r3_r0_rwl u_t011_015/r3_r1_rwl VDD VSS VSUBS
+ detronyx_12t_2w2r_rc4_4x4_routed_5layer_direct
Xu_t011_004 u_t011_004/c0_w0_bl u_t011_004/c0_w0_br u_t011_004/c0_w1_bl u_t011_004/c0_w1_br u_t011_004/c0_r0_rbl
+ u_t011_004/c0_r1_rbl u_t011_004/c1_w0_bl u_t011_004/c1_w0_br u_t011_004/c1_w1_bl u_t011_004/c1_w1_br
+ u_t011_004/c1_r0_rbl u_t011_004/c1_r1_rbl u_t011_004/c2_w0_bl u_t011_004/c2_w0_br u_t011_004/c2_w1_bl
+ u_t011_004/c2_w1_br u_t011_004/c2_r0_rbl u_t011_004/c2_r1_rbl u_t011_004/c3_w0_bl u_t011_004/c3_w0_br
+ u_t011_004/c3_w1_bl u_t011_004/c3_w1_br u_t011_004/c3_r0_rbl u_t011_004/c3_r1_rbl u_t011_004/r0_w0_wl
+ u_t011_004/r0_w1_wl u_t011_004/r0_r0_rwl u_t011_004/r0_r1_rwl u_t011_004/r1_w0_wl u_t011_004/r1_w1_wl
+ u_t011_004/r1_r0_rwl u_t011_004/r1_r1_rwl u_t011_004/r2_w0_wl u_t011_004/r2_w1_wl u_t011_004/r2_r0_rwl
+ u_t011_004/r2_r1_rwl u_t011_004/r3_w0_wl u_t011_004/r3_w1_wl u_t011_004/r3_r0_rwl u_t011_004/r3_r1_rwl VDD VSS VSUBS
+ detronyx_12t_2w2r_rc4_4x4_routed_5layer_direct
Xu_t002_004 u_t002_004/c0_w0_bl u_t002_004/c0_w0_br u_t002_004/c0_w1_bl u_t002_004/c0_w1_br u_t002_004/c0_r0_rbl
+ u_t002_004/c0_r1_rbl u_t002_004/c1_w0_bl u_t002_004/c1_w0_br u_t002_004/c1_w1_bl u_t002_004/c1_w1_br
+ u_t002_004/c1_r0_rbl u_t002_004/c1_r1_rbl u_t002_004/c2_w0_bl u_t002_004/c2_w0_br u_t002_004/c2_w1_bl
+ u_t002_004/c2_w1_br u_t002_004/c2_r0_rbl u_t002_004/c2_r1_rbl u_t002_004/c3_w0_bl u_t002_004/c3_w0_br
+ u_t002_004/c3_w1_bl u_t002_004/c3_w1_br u_t002_004/c3_r0_rbl u_t002_004/c3_r1_rbl u_t002_004/r0_w0_wl
+ u_t002_004/r0_w1_wl u_t002_004/r0_r0_rwl u_t002_004/r0_r1_rwl u_t002_004/r1_w0_wl u_t002_004/r1_w1_wl
+ u_t002_004/r1_r0_rwl u_t002_004/r1_r1_rwl u_t002_004/r2_w0_wl u_t002_004/r2_w1_wl u_t002_004/r2_r0_rwl
+ u_t002_004/r2_r1_rwl u_t002_004/r3_w0_wl u_t002_004/r3_w1_wl u_t002_004/r3_r0_rwl u_t002_004/r3_r1_rwl VDD VSS VSUBS
+ detronyx_12t_2w2r_rc4_4x4_routed_5layer_direct
Xu_t002_015 u_t002_015/c0_w0_bl u_t002_015/c0_w0_br u_t002_015/c0_w1_bl u_t002_015/c0_w1_br u_t002_015/c0_r0_rbl
+ u_t002_015/c0_r1_rbl u_t002_015/c1_w0_bl u_t002_015/c1_w0_br u_t002_015/c1_w1_bl u_t002_015/c1_w1_br
+ u_t002_015/c1_r0_rbl u_t002_015/c1_r1_rbl u_t002_015/c2_w0_bl u_t002_015/c2_w0_br u_t002_015/c2_w1_bl
+ u_t002_015/c2_w1_br u_t002_015/c2_r0_rbl u_t002_015/c2_r1_rbl u_t002_015/c3_w0_bl u_t002_015/c3_w0_br
+ u_t002_015/c3_w1_bl u_t002_015/c3_w1_br u_t002_015/c3_r0_rbl u_t002_015/c3_r1_rbl u_t002_015/r0_w0_wl
+ u_t002_015/r0_w1_wl u_t002_015/r0_r0_rwl u_t002_015/r0_r1_rwl u_t002_015/r1_w0_wl u_t002_015/r1_w1_wl
+ u_t002_015/r1_r0_rwl u_t002_015/r1_r1_rwl u_t002_015/r2_w0_wl u_t002_015/r2_w1_wl u_t002_015/r2_r0_rwl
+ u_t002_015/r2_r1_rwl u_t002_015/r3_w0_wl u_t002_015/r3_w1_wl u_t002_015/r3_r0_rwl u_t002_015/r3_r1_rwl VDD VSS VSUBS
+ detronyx_12t_2w2r_rc4_4x4_routed_5layer_direct
Xu_t014_013 u_t014_013/c0_w0_bl u_t014_013/c0_w0_br u_t014_013/c0_w1_bl u_t014_013/c0_w1_br u_t014_013/c0_r0_rbl
+ u_t014_013/c0_r1_rbl u_t014_013/c1_w0_bl u_t014_013/c1_w0_br u_t014_013/c1_w1_bl u_t014_013/c1_w1_br
+ u_t014_013/c1_r0_rbl u_t014_013/c1_r1_rbl u_t014_013/c2_w0_bl u_t014_013/c2_w0_br u_t014_013/c2_w1_bl
+ u_t014_013/c2_w1_br u_t014_013/c2_r0_rbl u_t014_013/c2_r1_rbl u_t014_013/c3_w0_bl u_t014_013/c3_w0_br
+ u_t014_013/c3_w1_bl u_t014_013/c3_w1_br u_t014_013/c3_r0_rbl u_t014_013/c3_r1_rbl u_t014_013/r0_w0_wl
+ u_t014_013/r0_w1_wl u_t014_013/r0_r0_rwl u_t014_013/r0_r1_rwl u_t014_013/r1_w0_wl u_t014_013/r1_w1_wl
+ u_t014_013/r1_r0_rwl u_t014_013/r1_r1_rwl u_t014_013/r2_w0_wl u_t014_013/r2_w1_wl u_t014_013/r2_r0_rwl
+ u_t014_013/r2_r1_rwl u_t014_013/r3_w0_wl u_t014_013/r3_w1_wl u_t014_013/r3_r0_rwl u_t014_013/r3_r1_rwl VDD VSS VSUBS
+ detronyx_12t_2w2r_rc4_4x4_routed_5layer_direct
Xu_t014_002 u_t014_002/c0_w0_bl u_t014_002/c0_w0_br u_t014_002/c0_w1_bl u_t014_002/c0_w1_br u_t014_002/c0_r0_rbl
+ u_t014_002/c0_r1_rbl u_t014_002/c1_w0_bl u_t014_002/c1_w0_br u_t014_002/c1_w1_bl u_t014_002/c1_w1_br
+ u_t014_002/c1_r0_rbl u_t014_002/c1_r1_rbl u_t014_002/c2_w0_bl u_t014_002/c2_w0_br u_t014_002/c2_w1_bl
+ u_t014_002/c2_w1_br u_t014_002/c2_r0_rbl u_t014_002/c2_r1_rbl u_t014_002/c3_w0_bl u_t014_002/c3_w0_br
+ u_t014_002/c3_w1_bl u_t014_002/c3_w1_br u_t014_002/c3_r0_rbl u_t014_002/c3_r1_rbl u_t014_002/r0_w0_wl
+ u_t014_002/r0_w1_wl u_t014_002/r0_r0_rwl u_t014_002/r0_r1_rwl u_t014_002/r1_w0_wl u_t014_002/r1_w1_wl
+ u_t014_002/r1_r0_rwl u_t014_002/r1_r1_rwl u_t014_002/r2_w0_wl u_t014_002/r2_w1_wl u_t014_002/r2_r0_rwl
+ u_t014_002/r2_r1_rwl u_t014_002/r3_w0_wl u_t014_002/r3_w1_wl u_t014_002/r3_r0_rwl u_t014_002/r3_r1_rwl VDD VSS VSUBS
+ detronyx_12t_2w2r_rc4_4x4_routed_5layer_direct
Xu_t011_005 u_t011_005/c0_w0_bl u_t011_005/c0_w0_br u_t011_005/c0_w1_bl u_t011_005/c0_w1_br u_t011_005/c0_r0_rbl
+ u_t011_005/c0_r1_rbl u_t011_005/c1_w0_bl u_t011_005/c1_w0_br u_t011_005/c1_w1_bl u_t011_005/c1_w1_br
+ u_t011_005/c1_r0_rbl u_t011_005/c1_r1_rbl u_t011_005/c2_w0_bl u_t011_005/c2_w0_br u_t011_005/c2_w1_bl
+ u_t011_005/c2_w1_br u_t011_005/c2_r0_rbl u_t011_005/c2_r1_rbl u_t011_005/c3_w0_bl u_t011_005/c3_w0_br
+ u_t011_005/c3_w1_bl u_t011_005/c3_w1_br u_t011_005/c3_r0_rbl u_t011_005/c3_r1_rbl u_t011_005/r0_w0_wl
+ u_t011_005/r0_w1_wl u_t011_005/r0_r0_rwl u_t011_005/r0_r1_rwl u_t011_005/r1_w0_wl u_t011_005/r1_w1_wl
+ u_t011_005/r1_r0_rwl u_t011_005/r1_r1_rwl u_t011_005/r2_w0_wl u_t011_005/r2_w1_wl u_t011_005/r2_r0_rwl
+ u_t011_005/r2_r1_rwl u_t011_005/r3_w0_wl u_t011_005/r3_w1_wl u_t011_005/r3_r0_rwl u_t011_005/r3_r1_rwl VDD VSS VSUBS
+ detronyx_12t_2w2r_rc4_4x4_routed_5layer_direct
Xu_t008_010 u_t008_010/c0_w0_bl u_t008_010/c0_w0_br u_t008_010/c0_w1_bl u_t008_010/c0_w1_br u_t008_010/c0_r0_rbl
+ u_t008_010/c0_r1_rbl u_t008_010/c1_w0_bl u_t008_010/c1_w0_br u_t008_010/c1_w1_bl u_t008_010/c1_w1_br
+ u_t008_010/c1_r0_rbl u_t008_010/c1_r1_rbl u_t008_010/c2_w0_bl u_t008_010/c2_w0_br u_t008_010/c2_w1_bl
+ u_t008_010/c2_w1_br u_t008_010/c2_r0_rbl u_t008_010/c2_r1_rbl u_t008_010/c3_w0_bl u_t008_010/c3_w0_br
+ u_t008_010/c3_w1_bl u_t008_010/c3_w1_br u_t008_010/c3_r0_rbl u_t008_010/c3_r1_rbl u_t008_010/r0_w0_wl
+ u_t008_010/r0_w1_wl u_t008_010/r0_r0_rwl u_t008_010/r0_r1_rwl u_t008_010/r1_w0_wl u_t008_010/r1_w1_wl
+ u_t008_010/r1_r0_rwl u_t008_010/r1_r1_rwl u_t008_010/r2_w0_wl u_t008_010/r2_w1_wl u_t008_010/r2_r0_rwl
+ u_t008_010/r2_r1_rwl u_t008_010/r3_w0_wl u_t008_010/r3_w1_wl u_t008_010/r3_r0_rwl u_t008_010/r3_r1_rwl VDD VSS VSUBS
+ detronyx_12t_2w2r_rc4_4x4_routed_5layer_direct
Xu_t005_013 u_t005_013/c0_w0_bl u_t005_013/c0_w0_br u_t005_013/c0_w1_bl u_t005_013/c0_w1_br u_t005_013/c0_r0_rbl
+ u_t005_013/c0_r1_rbl u_t005_013/c1_w0_bl u_t005_013/c1_w0_br u_t005_013/c1_w1_bl u_t005_013/c1_w1_br
+ u_t005_013/c1_r0_rbl u_t005_013/c1_r1_rbl u_t005_013/c2_w0_bl u_t005_013/c2_w0_br u_t005_013/c2_w1_bl
+ u_t005_013/c2_w1_br u_t005_013/c2_r0_rbl u_t005_013/c2_r1_rbl u_t005_013/c3_w0_bl u_t005_013/c3_w0_br
+ u_t005_013/c3_w1_bl u_t005_013/c3_w1_br u_t005_013/c3_r0_rbl u_t005_013/c3_r1_rbl u_t005_013/r0_w0_wl
+ u_t005_013/r0_w1_wl u_t005_013/r0_r0_rwl u_t005_013/r0_r1_rwl u_t005_013/r1_w0_wl u_t005_013/r1_w1_wl
+ u_t005_013/r1_r0_rwl u_t005_013/r1_r1_rwl u_t005_013/r2_w0_wl u_t005_013/r2_w1_wl u_t005_013/r2_r0_rwl
+ u_t005_013/r2_r1_rwl u_t005_013/r3_w0_wl u_t005_013/r3_w1_wl u_t005_013/r3_r0_rwl u_t005_013/r3_r1_rwl VDD VSS VSUBS
+ detronyx_12t_2w2r_rc4_4x4_routed_5layer_direct
Xu_t002_005 u_t002_005/c0_w0_bl u_t002_005/c0_w0_br u_t002_005/c0_w1_bl u_t002_005/c0_w1_br u_t002_005/c0_r0_rbl
+ u_t002_005/c0_r1_rbl u_t002_005/c1_w0_bl u_t002_005/c1_w0_br u_t002_005/c1_w1_bl u_t002_005/c1_w1_br
+ u_t002_005/c1_r0_rbl u_t002_005/c1_r1_rbl u_t002_005/c2_w0_bl u_t002_005/c2_w0_br u_t002_005/c2_w1_bl
+ u_t002_005/c2_w1_br u_t002_005/c2_r0_rbl u_t002_005/c2_r1_rbl u_t002_005/c3_w0_bl u_t002_005/c3_w0_br
+ u_t002_005/c3_w1_bl u_t002_005/c3_w1_br u_t002_005/c3_r0_rbl u_t002_005/c3_r1_rbl u_t002_005/r0_w0_wl
+ u_t002_005/r0_w1_wl u_t002_005/r0_r0_rwl u_t002_005/r0_r1_rwl u_t002_005/r1_w0_wl u_t002_005/r1_w1_wl
+ u_t002_005/r1_r0_rwl u_t002_005/r1_r1_rwl u_t002_005/r2_w0_wl u_t002_005/r2_w1_wl u_t002_005/r2_r0_rwl
+ u_t002_005/r2_r1_rwl u_t002_005/r3_w0_wl u_t002_005/r3_w1_wl u_t002_005/r3_r0_rwl u_t002_005/r3_r1_rwl VDD VSS VSUBS
+ detronyx_12t_2w2r_rc4_4x4_routed_5layer_direct
Xu_t005_002 u_t005_002/c0_w0_bl u_t005_002/c0_w0_br u_t005_002/c0_w1_bl u_t005_002/c0_w1_br u_t005_002/c0_r0_rbl
+ u_t005_002/c0_r1_rbl u_t005_002/c1_w0_bl u_t005_002/c1_w0_br u_t005_002/c1_w1_bl u_t005_002/c1_w1_br
+ u_t005_002/c1_r0_rbl u_t005_002/c1_r1_rbl u_t005_002/c2_w0_bl u_t005_002/c2_w0_br u_t005_002/c2_w1_bl
+ u_t005_002/c2_w1_br u_t005_002/c2_r0_rbl u_t005_002/c2_r1_rbl u_t005_002/c3_w0_bl u_t005_002/c3_w0_br
+ u_t005_002/c3_w1_bl u_t005_002/c3_w1_br u_t005_002/c3_r0_rbl u_t005_002/c3_r1_rbl u_t005_002/r0_w0_wl
+ u_t005_002/r0_w1_wl u_t005_002/r0_r0_rwl u_t005_002/r0_r1_rwl u_t005_002/r1_w0_wl u_t005_002/r1_w1_wl
+ u_t005_002/r1_r0_rwl u_t005_002/r1_r1_rwl u_t005_002/r2_w0_wl u_t005_002/r2_w1_wl u_t005_002/r2_r0_rwl
+ u_t005_002/r2_r1_rwl u_t005_002/r3_w0_wl u_t005_002/r3_w1_wl u_t005_002/r3_r0_rwl u_t005_002/r3_r1_rwl VDD VSS VSUBS
+ detronyx_12t_2w2r_rc4_4x4_routed_5layer_direct
Xu_t014_014 u_t014_014/c0_w0_bl u_t014_014/c0_w0_br u_t014_014/c0_w1_bl u_t014_014/c0_w1_br u_t014_014/c0_r0_rbl
+ u_t014_014/c0_r1_rbl u_t014_014/c1_w0_bl u_t014_014/c1_w0_br u_t014_014/c1_w1_bl u_t014_014/c1_w1_br
+ u_t014_014/c1_r0_rbl u_t014_014/c1_r1_rbl u_t014_014/c2_w0_bl u_t014_014/c2_w0_br u_t014_014/c2_w1_bl
+ u_t014_014/c2_w1_br u_t014_014/c2_r0_rbl u_t014_014/c2_r1_rbl u_t014_014/c3_w0_bl u_t014_014/c3_w0_br
+ u_t014_014/c3_w1_bl u_t014_014/c3_w1_br u_t014_014/c3_r0_rbl u_t014_014/c3_r1_rbl u_t014_014/r0_w0_wl
+ u_t014_014/r0_w1_wl u_t014_014/r0_r0_rwl u_t014_014/r0_r1_rwl u_t014_014/r1_w0_wl u_t014_014/r1_w1_wl
+ u_t014_014/r1_r0_rwl u_t014_014/r1_r1_rwl u_t014_014/r2_w0_wl u_t014_014/r2_w1_wl u_t014_014/r2_r0_rwl
+ u_t014_014/r2_r1_rwl u_t014_014/r3_w0_wl u_t014_014/r3_w1_wl u_t014_014/r3_r0_rwl u_t014_014/r3_r1_rwl VDD VSS VSUBS
+ detronyx_12t_2w2r_rc4_4x4_routed_5layer_direct
Xu_t014_003 u_t014_003/c0_w0_bl u_t014_003/c0_w0_br u_t014_003/c0_w1_bl u_t014_003/c0_w1_br u_t014_003/c0_r0_rbl
+ u_t014_003/c0_r1_rbl u_t014_003/c1_w0_bl u_t014_003/c1_w0_br u_t014_003/c1_w1_bl u_t014_003/c1_w1_br
+ u_t014_003/c1_r0_rbl u_t014_003/c1_r1_rbl u_t014_003/c2_w0_bl u_t014_003/c2_w0_br u_t014_003/c2_w1_bl
+ u_t014_003/c2_w1_br u_t014_003/c2_r0_rbl u_t014_003/c2_r1_rbl u_t014_003/c3_w0_bl u_t014_003/c3_w0_br
+ u_t014_003/c3_w1_bl u_t014_003/c3_w1_br u_t014_003/c3_r0_rbl u_t014_003/c3_r1_rbl u_t014_003/r0_w0_wl
+ u_t014_003/r0_w1_wl u_t014_003/r0_r0_rwl u_t014_003/r0_r1_rwl u_t014_003/r1_w0_wl u_t014_003/r1_w1_wl
+ u_t014_003/r1_r0_rwl u_t014_003/r1_r1_rwl u_t014_003/r2_w0_wl u_t014_003/r2_w1_wl u_t014_003/r2_r0_rwl
+ u_t014_003/r2_r1_rwl u_t014_003/r3_w0_wl u_t014_003/r3_w1_wl u_t014_003/r3_r0_rwl u_t014_003/r3_r1_rwl VDD VSS VSUBS
+ detronyx_12t_2w2r_rc4_4x4_routed_5layer_direct
Xu_t008_011 u_t008_011/c0_w0_bl u_t008_011/c0_w0_br u_t008_011/c0_w1_bl u_t008_011/c0_w1_br u_t008_011/c0_r0_rbl
+ u_t008_011/c0_r1_rbl u_t008_011/c1_w0_bl u_t008_011/c1_w0_br u_t008_011/c1_w1_bl u_t008_011/c1_w1_br
+ u_t008_011/c1_r0_rbl u_t008_011/c1_r1_rbl u_t008_011/c2_w0_bl u_t008_011/c2_w0_br u_t008_011/c2_w1_bl
+ u_t008_011/c2_w1_br u_t008_011/c2_r0_rbl u_t008_011/c2_r1_rbl u_t008_011/c3_w0_bl u_t008_011/c3_w0_br
+ u_t008_011/c3_w1_bl u_t008_011/c3_w1_br u_t008_011/c3_r0_rbl u_t008_011/c3_r1_rbl u_t008_011/r0_w0_wl
+ u_t008_011/r0_w1_wl u_t008_011/r0_r0_rwl u_t008_011/r0_r1_rwl u_t008_011/r1_w0_wl u_t008_011/r1_w1_wl
+ u_t008_011/r1_r0_rwl u_t008_011/r1_r1_rwl u_t008_011/r2_w0_wl u_t008_011/r2_w1_wl u_t008_011/r2_r0_rwl
+ u_t008_011/r2_r1_rwl u_t008_011/r3_w0_wl u_t008_011/r3_w1_wl u_t008_011/r3_r0_rwl u_t008_011/r3_r1_rwl VDD VSS VSUBS
+ detronyx_12t_2w2r_rc4_4x4_routed_5layer_direct
Xu_t008_000 u_t008_000/c0_w0_bl u_t008_000/c0_w0_br u_t008_000/c0_w1_bl u_t008_000/c0_w1_br u_t008_000/c0_r0_rbl
+ u_t008_000/c0_r1_rbl u_t008_000/c1_w0_bl u_t008_000/c1_w0_br u_t008_000/c1_w1_bl u_t008_000/c1_w1_br
+ u_t008_000/c1_r0_rbl u_t008_000/c1_r1_rbl u_t008_000/c2_w0_bl u_t008_000/c2_w0_br u_t008_000/c2_w1_bl
+ u_t008_000/c2_w1_br u_t008_000/c2_r0_rbl u_t008_000/c2_r1_rbl u_t008_000/c3_w0_bl u_t008_000/c3_w0_br
+ u_t008_000/c3_w1_bl u_t008_000/c3_w1_br u_t008_000/c3_r0_rbl u_t008_000/c3_r1_rbl u_t008_000/r0_w0_wl
+ u_t008_000/r0_w1_wl u_t008_000/r0_r0_rwl u_t008_000/r0_r1_rwl u_t008_000/r1_w0_wl u_t008_000/r1_w1_wl
+ u_t008_000/r1_r0_rwl u_t008_000/r1_r1_rwl u_t008_000/r2_w0_wl u_t008_000/r2_w1_wl u_t008_000/r2_r0_rwl
+ u_t008_000/r2_r1_rwl u_t008_000/r3_w0_wl u_t008_000/r3_w1_wl u_t008_000/r3_r0_rwl u_t008_000/r3_r1_rwl VDD VSS VSUBS
+ detronyx_12t_2w2r_rc4_4x4_routed_5layer_direct
Xu_t011_006 u_t011_006/c0_w0_bl u_t011_006/c0_w0_br u_t011_006/c0_w1_bl u_t011_006/c0_w1_br u_t011_006/c0_r0_rbl
+ u_t011_006/c0_r1_rbl u_t011_006/c1_w0_bl u_t011_006/c1_w0_br u_t011_006/c1_w1_bl u_t011_006/c1_w1_br
+ u_t011_006/c1_r0_rbl u_t011_006/c1_r1_rbl u_t011_006/c2_w0_bl u_t011_006/c2_w0_br u_t011_006/c2_w1_bl
+ u_t011_006/c2_w1_br u_t011_006/c2_r0_rbl u_t011_006/c2_r1_rbl u_t011_006/c3_w0_bl u_t011_006/c3_w0_br
+ u_t011_006/c3_w1_bl u_t011_006/c3_w1_br u_t011_006/c3_r0_rbl u_t011_006/c3_r1_rbl u_t011_006/r0_w0_wl
+ u_t011_006/r0_w1_wl u_t011_006/r0_r0_rwl u_t011_006/r0_r1_rwl u_t011_006/r1_w0_wl u_t011_006/r1_w1_wl
+ u_t011_006/r1_r0_rwl u_t011_006/r1_r1_rwl u_t011_006/r2_w0_wl u_t011_006/r2_w1_wl u_t011_006/r2_r0_rwl
+ u_t011_006/r2_r1_rwl u_t011_006/r3_w0_wl u_t011_006/r3_w1_wl u_t011_006/r3_r0_rwl u_t011_006/r3_r1_rwl VDD VSS VSUBS
+ detronyx_12t_2w2r_rc4_4x4_routed_5layer_direct
Xu_t005_014 u_t005_014/c0_w0_bl u_t005_014/c0_w0_br u_t005_014/c0_w1_bl u_t005_014/c0_w1_br u_t005_014/c0_r0_rbl
+ u_t005_014/c0_r1_rbl u_t005_014/c1_w0_bl u_t005_014/c1_w0_br u_t005_014/c1_w1_bl u_t005_014/c1_w1_br
+ u_t005_014/c1_r0_rbl u_t005_014/c1_r1_rbl u_t005_014/c2_w0_bl u_t005_014/c2_w0_br u_t005_014/c2_w1_bl
+ u_t005_014/c2_w1_br u_t005_014/c2_r0_rbl u_t005_014/c2_r1_rbl u_t005_014/c3_w0_bl u_t005_014/c3_w0_br
+ u_t005_014/c3_w1_bl u_t005_014/c3_w1_br u_t005_014/c3_r0_rbl u_t005_014/c3_r1_rbl u_t005_014/r0_w0_wl
+ u_t005_014/r0_w1_wl u_t005_014/r0_r0_rwl u_t005_014/r0_r1_rwl u_t005_014/r1_w0_wl u_t005_014/r1_w1_wl
+ u_t005_014/r1_r0_rwl u_t005_014/r1_r1_rwl u_t005_014/r2_w0_wl u_t005_014/r2_w1_wl u_t005_014/r2_r0_rwl
+ u_t005_014/r2_r1_rwl u_t005_014/r3_w0_wl u_t005_014/r3_w1_wl u_t005_014/r3_r0_rwl u_t005_014/r3_r1_rwl VDD VSS VSUBS
+ detronyx_12t_2w2r_rc4_4x4_routed_5layer_direct
Xu_t002_006 u_t002_006/c0_w0_bl u_t002_006/c0_w0_br u_t002_006/c0_w1_bl u_t002_006/c0_w1_br u_t002_006/c0_r0_rbl
+ u_t002_006/c0_r1_rbl u_t002_006/c1_w0_bl u_t002_006/c1_w0_br u_t002_006/c1_w1_bl u_t002_006/c1_w1_br
+ u_t002_006/c1_r0_rbl u_t002_006/c1_r1_rbl u_t002_006/c2_w0_bl u_t002_006/c2_w0_br u_t002_006/c2_w1_bl
+ u_t002_006/c2_w1_br u_t002_006/c2_r0_rbl u_t002_006/c2_r1_rbl u_t002_006/c3_w0_bl u_t002_006/c3_w0_br
+ u_t002_006/c3_w1_bl u_t002_006/c3_w1_br u_t002_006/c3_r0_rbl u_t002_006/c3_r1_rbl u_t002_006/r0_w0_wl
+ u_t002_006/r0_w1_wl u_t002_006/r0_r0_rwl u_t002_006/r0_r1_rwl u_t002_006/r1_w0_wl u_t002_006/r1_w1_wl
+ u_t002_006/r1_r0_rwl u_t002_006/r1_r1_rwl u_t002_006/r2_w0_wl u_t002_006/r2_w1_wl u_t002_006/r2_r0_rwl
+ u_t002_006/r2_r1_rwl u_t002_006/r3_w0_wl u_t002_006/r3_w1_wl u_t002_006/r3_r0_rwl u_t002_006/r3_r1_rwl VDD VSS VSUBS
+ detronyx_12t_2w2r_rc4_4x4_routed_5layer_direct
Xu_t005_003 u_t005_003/c0_w0_bl u_t005_003/c0_w0_br u_t005_003/c0_w1_bl u_t005_003/c0_w1_br u_t005_003/c0_r0_rbl
+ u_t005_003/c0_r1_rbl u_t005_003/c1_w0_bl u_t005_003/c1_w0_br u_t005_003/c1_w1_bl u_t005_003/c1_w1_br
+ u_t005_003/c1_r0_rbl u_t005_003/c1_r1_rbl u_t005_003/c2_w0_bl u_t005_003/c2_w0_br u_t005_003/c2_w1_bl
+ u_t005_003/c2_w1_br u_t005_003/c2_r0_rbl u_t005_003/c2_r1_rbl u_t005_003/c3_w0_bl u_t005_003/c3_w0_br
+ u_t005_003/c3_w1_bl u_t005_003/c3_w1_br u_t005_003/c3_r0_rbl u_t005_003/c3_r1_rbl u_t005_003/r0_w0_wl
+ u_t005_003/r0_w1_wl u_t005_003/r0_r0_rwl u_t005_003/r0_r1_rwl u_t005_003/r1_w0_wl u_t005_003/r1_w1_wl
+ u_t005_003/r1_r0_rwl u_t005_003/r1_r1_rwl u_t005_003/r2_w0_wl u_t005_003/r2_w1_wl u_t005_003/r2_r0_rwl
+ u_t005_003/r2_r1_rwl u_t005_003/r3_w0_wl u_t005_003/r3_w1_wl u_t005_003/r3_r0_rwl u_t005_003/r3_r1_rwl VDD VSS VSUBS
+ detronyx_12t_2w2r_rc4_4x4_routed_5layer_direct
Xu_t014_015 u_t014_015/c0_w0_bl u_t014_015/c0_w0_br u_t014_015/c0_w1_bl u_t014_015/c0_w1_br u_t014_015/c0_r0_rbl
+ u_t014_015/c0_r1_rbl u_t014_015/c1_w0_bl u_t014_015/c1_w0_br u_t014_015/c1_w1_bl u_t014_015/c1_w1_br
+ u_t014_015/c1_r0_rbl u_t014_015/c1_r1_rbl u_t014_015/c2_w0_bl u_t014_015/c2_w0_br u_t014_015/c2_w1_bl
+ u_t014_015/c2_w1_br u_t014_015/c2_r0_rbl u_t014_015/c2_r1_rbl u_t014_015/c3_w0_bl u_t014_015/c3_w0_br
+ u_t014_015/c3_w1_bl u_t014_015/c3_w1_br u_t014_015/c3_r0_rbl u_t014_015/c3_r1_rbl u_t014_015/r0_w0_wl
+ u_t014_015/r0_w1_wl u_t014_015/r0_r0_rwl u_t014_015/r0_r1_rwl u_t014_015/r1_w0_wl u_t014_015/r1_w1_wl
+ u_t014_015/r1_r0_rwl u_t014_015/r1_r1_rwl u_t014_015/r2_w0_wl u_t014_015/r2_w1_wl u_t014_015/r2_r0_rwl
+ u_t014_015/r2_r1_rwl u_t014_015/r3_w0_wl u_t014_015/r3_w1_wl u_t014_015/r3_r0_rwl u_t014_015/r3_r1_rwl VDD VSS VSUBS
+ detronyx_12t_2w2r_rc4_4x4_routed_5layer_direct
Xu_t014_004 u_t014_004/c0_w0_bl u_t014_004/c0_w0_br u_t014_004/c0_w1_bl u_t014_004/c0_w1_br u_t014_004/c0_r0_rbl
+ u_t014_004/c0_r1_rbl u_t014_004/c1_w0_bl u_t014_004/c1_w0_br u_t014_004/c1_w1_bl u_t014_004/c1_w1_br
+ u_t014_004/c1_r0_rbl u_t014_004/c1_r1_rbl u_t014_004/c2_w0_bl u_t014_004/c2_w0_br u_t014_004/c2_w1_bl
+ u_t014_004/c2_w1_br u_t014_004/c2_r0_rbl u_t014_004/c2_r1_rbl u_t014_004/c3_w0_bl u_t014_004/c3_w0_br
+ u_t014_004/c3_w1_bl u_t014_004/c3_w1_br u_t014_004/c3_r0_rbl u_t014_004/c3_r1_rbl u_t014_004/r0_w0_wl
+ u_t014_004/r0_w1_wl u_t014_004/r0_r0_rwl u_t014_004/r0_r1_rwl u_t014_004/r1_w0_wl u_t014_004/r1_w1_wl
+ u_t014_004/r1_r0_rwl u_t014_004/r1_r1_rwl u_t014_004/r2_w0_wl u_t014_004/r2_w1_wl u_t014_004/r2_r0_rwl
+ u_t014_004/r2_r1_rwl u_t014_004/r3_w0_wl u_t014_004/r3_w1_wl u_t014_004/r3_r0_rwl u_t014_004/r3_r1_rwl VDD VSS VSUBS
+ detronyx_12t_2w2r_rc4_4x4_routed_5layer_direct
Xu_t011_007 u_t011_007/c0_w0_bl u_t011_007/c0_w0_br u_t011_007/c0_w1_bl u_t011_007/c0_w1_br u_t011_007/c0_r0_rbl
+ u_t011_007/c0_r1_rbl u_t011_007/c1_w0_bl u_t011_007/c1_w0_br u_t011_007/c1_w1_bl u_t011_007/c1_w1_br
+ u_t011_007/c1_r0_rbl u_t011_007/c1_r1_rbl u_t011_007/c2_w0_bl u_t011_007/c2_w0_br u_t011_007/c2_w1_bl
+ u_t011_007/c2_w1_br u_t011_007/c2_r0_rbl u_t011_007/c2_r1_rbl u_t011_007/c3_w0_bl u_t011_007/c3_w0_br
+ u_t011_007/c3_w1_bl u_t011_007/c3_w1_br u_t011_007/c3_r0_rbl u_t011_007/c3_r1_rbl u_t011_007/r0_w0_wl
+ u_t011_007/r0_w1_wl u_t011_007/r0_r0_rwl u_t011_007/r0_r1_rwl u_t011_007/r1_w0_wl u_t011_007/r1_w1_wl
+ u_t011_007/r1_r0_rwl u_t011_007/r1_r1_rwl u_t011_007/r2_w0_wl u_t011_007/r2_w1_wl u_t011_007/r2_r0_rwl
+ u_t011_007/r2_r1_rwl u_t011_007/r3_w0_wl u_t011_007/r3_w1_wl u_t011_007/r3_r0_rwl u_t011_007/r3_r1_rwl VDD VSS VSUBS
+ detronyx_12t_2w2r_rc4_4x4_routed_5layer_direct
Xu_t008_012 u_t008_012/c0_w0_bl u_t008_012/c0_w0_br u_t008_012/c0_w1_bl u_t008_012/c0_w1_br u_t008_012/c0_r0_rbl
+ u_t008_012/c0_r1_rbl u_t008_012/c1_w0_bl u_t008_012/c1_w0_br u_t008_012/c1_w1_bl u_t008_012/c1_w1_br
+ u_t008_012/c1_r0_rbl u_t008_012/c1_r1_rbl u_t008_012/c2_w0_bl u_t008_012/c2_w0_br u_t008_012/c2_w1_bl
+ u_t008_012/c2_w1_br u_t008_012/c2_r0_rbl u_t008_012/c2_r1_rbl u_t008_012/c3_w0_bl u_t008_012/c3_w0_br
+ u_t008_012/c3_w1_bl u_t008_012/c3_w1_br u_t008_012/c3_r0_rbl u_t008_012/c3_r1_rbl u_t008_012/r0_w0_wl
+ u_t008_012/r0_w1_wl u_t008_012/r0_r0_rwl u_t008_012/r0_r1_rwl u_t008_012/r1_w0_wl u_t008_012/r1_w1_wl
+ u_t008_012/r1_r0_rwl u_t008_012/r1_r1_rwl u_t008_012/r2_w0_wl u_t008_012/r2_w1_wl u_t008_012/r2_r0_rwl
+ u_t008_012/r2_r1_rwl u_t008_012/r3_w0_wl u_t008_012/r3_w1_wl u_t008_012/r3_r0_rwl u_t008_012/r3_r1_rwl VDD VSS VSUBS
+ detronyx_12t_2w2r_rc4_4x4_routed_5layer_direct
Xu_t008_001 u_t008_001/c0_w0_bl u_t008_001/c0_w0_br u_t008_001/c0_w1_bl u_t008_001/c0_w1_br u_t008_001/c0_r0_rbl
+ u_t008_001/c0_r1_rbl u_t008_001/c1_w0_bl u_t008_001/c1_w0_br u_t008_001/c1_w1_bl u_t008_001/c1_w1_br
+ u_t008_001/c1_r0_rbl u_t008_001/c1_r1_rbl u_t008_001/c2_w0_bl u_t008_001/c2_w0_br u_t008_001/c2_w1_bl
+ u_t008_001/c2_w1_br u_t008_001/c2_r0_rbl u_t008_001/c2_r1_rbl u_t008_001/c3_w0_bl u_t008_001/c3_w0_br
+ u_t008_001/c3_w1_bl u_t008_001/c3_w1_br u_t008_001/c3_r0_rbl u_t008_001/c3_r1_rbl u_t008_001/r0_w0_wl
+ u_t008_001/r0_w1_wl u_t008_001/r0_r0_rwl u_t008_001/r0_r1_rwl u_t008_001/r1_w0_wl u_t008_001/r1_w1_wl
+ u_t008_001/r1_r0_rwl u_t008_001/r1_r1_rwl u_t008_001/r2_w0_wl u_t008_001/r2_w1_wl u_t008_001/r2_r0_rwl
+ u_t008_001/r2_r1_rwl u_t008_001/r3_w0_wl u_t008_001/r3_w1_wl u_t008_001/r3_r0_rwl u_t008_001/r3_r1_rwl VDD VSS VSUBS
+ detronyx_12t_2w2r_rc4_4x4_routed_5layer_direct
Xu_t005_015 u_t005_015/c0_w0_bl u_t005_015/c0_w0_br u_t005_015/c0_w1_bl u_t005_015/c0_w1_br u_t005_015/c0_r0_rbl
+ u_t005_015/c0_r1_rbl u_t005_015/c1_w0_bl u_t005_015/c1_w0_br u_t005_015/c1_w1_bl u_t005_015/c1_w1_br
+ u_t005_015/c1_r0_rbl u_t005_015/c1_r1_rbl u_t005_015/c2_w0_bl u_t005_015/c2_w0_br u_t005_015/c2_w1_bl
+ u_t005_015/c2_w1_br u_t005_015/c2_r0_rbl u_t005_015/c2_r1_rbl u_t005_015/c3_w0_bl u_t005_015/c3_w0_br
+ u_t005_015/c3_w1_bl u_t005_015/c3_w1_br u_t005_015/c3_r0_rbl u_t005_015/c3_r1_rbl u_t005_015/r0_w0_wl
+ u_t005_015/r0_w1_wl u_t005_015/r0_r0_rwl u_t005_015/r0_r1_rwl u_t005_015/r1_w0_wl u_t005_015/r1_w1_wl
+ u_t005_015/r1_r0_rwl u_t005_015/r1_r1_rwl u_t005_015/r2_w0_wl u_t005_015/r2_w1_wl u_t005_015/r2_r0_rwl
+ u_t005_015/r2_r1_rwl u_t005_015/r3_w0_wl u_t005_015/r3_w1_wl u_t005_015/r3_r0_rwl u_t005_015/r3_r1_rwl VDD VSS VSUBS
+ detronyx_12t_2w2r_rc4_4x4_routed_5layer_direct
Xu_t005_004 u_t005_004/c0_w0_bl u_t005_004/c0_w0_br u_t005_004/c0_w1_bl u_t005_004/c0_w1_br u_t005_004/c0_r0_rbl
+ u_t005_004/c0_r1_rbl u_t005_004/c1_w0_bl u_t005_004/c1_w0_br u_t005_004/c1_w1_bl u_t005_004/c1_w1_br
+ u_t005_004/c1_r0_rbl u_t005_004/c1_r1_rbl u_t005_004/c2_w0_bl u_t005_004/c2_w0_br u_t005_004/c2_w1_bl
+ u_t005_004/c2_w1_br u_t005_004/c2_r0_rbl u_t005_004/c2_r1_rbl u_t005_004/c3_w0_bl u_t005_004/c3_w0_br
+ u_t005_004/c3_w1_bl u_t005_004/c3_w1_br u_t005_004/c3_r0_rbl u_t005_004/c3_r1_rbl u_t005_004/r0_w0_wl
+ u_t005_004/r0_w1_wl u_t005_004/r0_r0_rwl u_t005_004/r0_r1_rwl u_t005_004/r1_w0_wl u_t005_004/r1_w1_wl
+ u_t005_004/r1_r0_rwl u_t005_004/r1_r1_rwl u_t005_004/r2_w0_wl u_t005_004/r2_w1_wl u_t005_004/r2_r0_rwl
+ u_t005_004/r2_r1_rwl u_t005_004/r3_w0_wl u_t005_004/r3_w1_wl u_t005_004/r3_r0_rwl u_t005_004/r3_r1_rwl VDD VSS VSUBS
+ detronyx_12t_2w2r_rc4_4x4_routed_5layer_direct
Xu_t002_007 u_t002_007/c0_w0_bl u_t002_007/c0_w0_br u_t002_007/c0_w1_bl u_t002_007/c0_w1_br u_t002_007/c0_r0_rbl
+ u_t002_007/c0_r1_rbl u_t002_007/c1_w0_bl u_t002_007/c1_w0_br u_t002_007/c1_w1_bl u_t002_007/c1_w1_br
+ u_t002_007/c1_r0_rbl u_t002_007/c1_r1_rbl u_t002_007/c2_w0_bl u_t002_007/c2_w0_br u_t002_007/c2_w1_bl
+ u_t002_007/c2_w1_br u_t002_007/c2_r0_rbl u_t002_007/c2_r1_rbl u_t002_007/c3_w0_bl u_t002_007/c3_w0_br
+ u_t002_007/c3_w1_bl u_t002_007/c3_w1_br u_t002_007/c3_r0_rbl u_t002_007/c3_r1_rbl u_t002_007/r0_w0_wl
+ u_t002_007/r0_w1_wl u_t002_007/r0_r0_rwl u_t002_007/r0_r1_rwl u_t002_007/r1_w0_wl u_t002_007/r1_w1_wl
+ u_t002_007/r1_r0_rwl u_t002_007/r1_r1_rwl u_t002_007/r2_w0_wl u_t002_007/r2_w1_wl u_t002_007/r2_r0_rwl
+ u_t002_007/r2_r1_rwl u_t002_007/r3_w0_wl u_t002_007/r3_w1_wl u_t002_007/r3_r0_rwl u_t002_007/r3_r1_rwl VDD VSS VSUBS
+ detronyx_12t_2w2r_rc4_4x4_routed_5layer_direct
Xu_t014_005 u_t014_005/c0_w0_bl u_t014_005/c0_w0_br u_t014_005/c0_w1_bl u_t014_005/c0_w1_br u_t014_005/c0_r0_rbl
+ u_t014_005/c0_r1_rbl u_t014_005/c1_w0_bl u_t014_005/c1_w0_br u_t014_005/c1_w1_bl u_t014_005/c1_w1_br
+ u_t014_005/c1_r0_rbl u_t014_005/c1_r1_rbl u_t014_005/c2_w0_bl u_t014_005/c2_w0_br u_t014_005/c2_w1_bl
+ u_t014_005/c2_w1_br u_t014_005/c2_r0_rbl u_t014_005/c2_r1_rbl u_t014_005/c3_w0_bl u_t014_005/c3_w0_br
+ u_t014_005/c3_w1_bl u_t014_005/c3_w1_br u_t014_005/c3_r0_rbl u_t014_005/c3_r1_rbl u_t014_005/r0_w0_wl
+ u_t014_005/r0_w1_wl u_t014_005/r0_r0_rwl u_t014_005/r0_r1_rwl u_t014_005/r1_w0_wl u_t014_005/r1_w1_wl
+ u_t014_005/r1_r0_rwl u_t014_005/r1_r1_rwl u_t014_005/r2_w0_wl u_t014_005/r2_w1_wl u_t014_005/r2_r0_rwl
+ u_t014_005/r2_r1_rwl u_t014_005/r3_w0_wl u_t014_005/r3_w1_wl u_t014_005/r3_r0_rwl u_t014_005/r3_r1_rwl VDD VSS VSUBS
+ detronyx_12t_2w2r_rc4_4x4_routed_5layer_direct
Xu_t008_013 u_t008_013/c0_w0_bl u_t008_013/c0_w0_br u_t008_013/c0_w1_bl u_t008_013/c0_w1_br u_t008_013/c0_r0_rbl
+ u_t008_013/c0_r1_rbl u_t008_013/c1_w0_bl u_t008_013/c1_w0_br u_t008_013/c1_w1_bl u_t008_013/c1_w1_br
+ u_t008_013/c1_r0_rbl u_t008_013/c1_r1_rbl u_t008_013/c2_w0_bl u_t008_013/c2_w0_br u_t008_013/c2_w1_bl
+ u_t008_013/c2_w1_br u_t008_013/c2_r0_rbl u_t008_013/c2_r1_rbl u_t008_013/c3_w0_bl u_t008_013/c3_w0_br
+ u_t008_013/c3_w1_bl u_t008_013/c3_w1_br u_t008_013/c3_r0_rbl u_t008_013/c3_r1_rbl u_t008_013/r0_w0_wl
+ u_t008_013/r0_w1_wl u_t008_013/r0_r0_rwl u_t008_013/r0_r1_rwl u_t008_013/r1_w0_wl u_t008_013/r1_w1_wl
+ u_t008_013/r1_r0_rwl u_t008_013/r1_r1_rwl u_t008_013/r2_w0_wl u_t008_013/r2_w1_wl u_t008_013/r2_r0_rwl
+ u_t008_013/r2_r1_rwl u_t008_013/r3_w0_wl u_t008_013/r3_w1_wl u_t008_013/r3_r0_rwl u_t008_013/r3_r1_rwl VDD VSS VSUBS
+ detronyx_12t_2w2r_rc4_4x4_routed_5layer_direct
Xu_t008_002 u_t008_002/c0_w0_bl u_t008_002/c0_w0_br u_t008_002/c0_w1_bl u_t008_002/c0_w1_br u_t008_002/c0_r0_rbl
+ u_t008_002/c0_r1_rbl u_t008_002/c1_w0_bl u_t008_002/c1_w0_br u_t008_002/c1_w1_bl u_t008_002/c1_w1_br
+ u_t008_002/c1_r0_rbl u_t008_002/c1_r1_rbl u_t008_002/c2_w0_bl u_t008_002/c2_w0_br u_t008_002/c2_w1_bl
+ u_t008_002/c2_w1_br u_t008_002/c2_r0_rbl u_t008_002/c2_r1_rbl u_t008_002/c3_w0_bl u_t008_002/c3_w0_br
+ u_t008_002/c3_w1_bl u_t008_002/c3_w1_br u_t008_002/c3_r0_rbl u_t008_002/c3_r1_rbl u_t008_002/r0_w0_wl
+ u_t008_002/r0_w1_wl u_t008_002/r0_r0_rwl u_t008_002/r0_r1_rwl u_t008_002/r1_w0_wl u_t008_002/r1_w1_wl
+ u_t008_002/r1_r0_rwl u_t008_002/r1_r1_rwl u_t008_002/r2_w0_wl u_t008_002/r2_w1_wl u_t008_002/r2_r0_rwl
+ u_t008_002/r2_r1_rwl u_t008_002/r3_w0_wl u_t008_002/r3_w1_wl u_t008_002/r3_r0_rwl u_t008_002/r3_r1_rwl VDD VSS VSUBS
+ detronyx_12t_2w2r_rc4_4x4_routed_5layer_direct
Xu_t011_008 u_t011_008/c0_w0_bl u_t011_008/c0_w0_br u_t011_008/c0_w1_bl u_t011_008/c0_w1_br u_t011_008/c0_r0_rbl
+ u_t011_008/c0_r1_rbl u_t011_008/c1_w0_bl u_t011_008/c1_w0_br u_t011_008/c1_w1_bl u_t011_008/c1_w1_br
+ u_t011_008/c1_r0_rbl u_t011_008/c1_r1_rbl u_t011_008/c2_w0_bl u_t011_008/c2_w0_br u_t011_008/c2_w1_bl
+ u_t011_008/c2_w1_br u_t011_008/c2_r0_rbl u_t011_008/c2_r1_rbl u_t011_008/c3_w0_bl u_t011_008/c3_w0_br
+ u_t011_008/c3_w1_bl u_t011_008/c3_w1_br u_t011_008/c3_r0_rbl u_t011_008/c3_r1_rbl u_t011_008/r0_w0_wl
+ u_t011_008/r0_w1_wl u_t011_008/r0_r0_rwl u_t011_008/r0_r1_rwl u_t011_008/r1_w0_wl u_t011_008/r1_w1_wl
+ u_t011_008/r1_r0_rwl u_t011_008/r1_r1_rwl u_t011_008/r2_w0_wl u_t011_008/r2_w1_wl u_t011_008/r2_r0_rwl
+ u_t011_008/r2_r1_rwl u_t011_008/r3_w0_wl u_t011_008/r3_w1_wl u_t011_008/r3_r0_rwl u_t011_008/r3_r1_rwl VDD VSS VSUBS
+ detronyx_12t_2w2r_rc4_4x4_routed_5layer_direct
Xu_t002_008 u_t002_008/c0_w0_bl u_t002_008/c0_w0_br u_t002_008/c0_w1_bl u_t002_008/c0_w1_br u_t002_008/c0_r0_rbl
+ u_t002_008/c0_r1_rbl u_t002_008/c1_w0_bl u_t002_008/c1_w0_br u_t002_008/c1_w1_bl u_t002_008/c1_w1_br
+ u_t002_008/c1_r0_rbl u_t002_008/c1_r1_rbl u_t002_008/c2_w0_bl u_t002_008/c2_w0_br u_t002_008/c2_w1_bl
+ u_t002_008/c2_w1_br u_t002_008/c2_r0_rbl u_t002_008/c2_r1_rbl u_t002_008/c3_w0_bl u_t002_008/c3_w0_br
+ u_t002_008/c3_w1_bl u_t002_008/c3_w1_br u_t002_008/c3_r0_rbl u_t002_008/c3_r1_rbl u_t002_008/r0_w0_wl
+ u_t002_008/r0_w1_wl u_t002_008/r0_r0_rwl u_t002_008/r0_r1_rwl u_t002_008/r1_w0_wl u_t002_008/r1_w1_wl
+ u_t002_008/r1_r0_rwl u_t002_008/r1_r1_rwl u_t002_008/r2_w0_wl u_t002_008/r2_w1_wl u_t002_008/r2_r0_rwl
+ u_t002_008/r2_r1_rwl u_t002_008/r3_w0_wl u_t002_008/r3_w1_wl u_t002_008/r3_r0_rwl u_t002_008/r3_r1_rwl VDD VSS VSUBS
+ detronyx_12t_2w2r_rc4_4x4_routed_5layer_direct
Xu_t005_005 u_t005_005/c0_w0_bl u_t005_005/c0_w0_br u_t005_005/c0_w1_bl u_t005_005/c0_w1_br u_t005_005/c0_r0_rbl
+ u_t005_005/c0_r1_rbl u_t005_005/c1_w0_bl u_t005_005/c1_w0_br u_t005_005/c1_w1_bl u_t005_005/c1_w1_br
+ u_t005_005/c1_r0_rbl u_t005_005/c1_r1_rbl u_t005_005/c2_w0_bl u_t005_005/c2_w0_br u_t005_005/c2_w1_bl
+ u_t005_005/c2_w1_br u_t005_005/c2_r0_rbl u_t005_005/c2_r1_rbl u_t005_005/c3_w0_bl u_t005_005/c3_w0_br
+ u_t005_005/c3_w1_bl u_t005_005/c3_w1_br u_t005_005/c3_r0_rbl u_t005_005/c3_r1_rbl u_t005_005/r0_w0_wl
+ u_t005_005/r0_w1_wl u_t005_005/r0_r0_rwl u_t005_005/r0_r1_rwl u_t005_005/r1_w0_wl u_t005_005/r1_w1_wl
+ u_t005_005/r1_r0_rwl u_t005_005/r1_r1_rwl u_t005_005/r2_w0_wl u_t005_005/r2_w1_wl u_t005_005/r2_r0_rwl
+ u_t005_005/r2_r1_rwl u_t005_005/r3_w0_wl u_t005_005/r3_w1_wl u_t005_005/r3_r0_rwl u_t005_005/r3_r1_rwl VDD VSS VSUBS
+ detronyx_12t_2w2r_rc4_4x4_routed_5layer_direct
Xu_t014_006 u_t014_006/c0_w0_bl u_t014_006/c0_w0_br u_t014_006/c0_w1_bl u_t014_006/c0_w1_br u_t014_006/c0_r0_rbl
+ u_t014_006/c0_r1_rbl u_t014_006/c1_w0_bl u_t014_006/c1_w0_br u_t014_006/c1_w1_bl u_t014_006/c1_w1_br
+ u_t014_006/c1_r0_rbl u_t014_006/c1_r1_rbl u_t014_006/c2_w0_bl u_t014_006/c2_w0_br u_t014_006/c2_w1_bl
+ u_t014_006/c2_w1_br u_t014_006/c2_r0_rbl u_t014_006/c2_r1_rbl u_t014_006/c3_w0_bl u_t014_006/c3_w0_br
+ u_t014_006/c3_w1_bl u_t014_006/c3_w1_br u_t014_006/c3_r0_rbl u_t014_006/c3_r1_rbl u_t014_006/r0_w0_wl
+ u_t014_006/r0_w1_wl u_t014_006/r0_r0_rwl u_t014_006/r0_r1_rwl u_t014_006/r1_w0_wl u_t014_006/r1_w1_wl
+ u_t014_006/r1_r0_rwl u_t014_006/r1_r1_rwl u_t014_006/r2_w0_wl u_t014_006/r2_w1_wl u_t014_006/r2_r0_rwl
+ u_t014_006/r2_r1_rwl u_t014_006/r3_w0_wl u_t014_006/r3_w1_wl u_t014_006/r3_r0_rwl u_t014_006/r3_r1_rwl VDD VSS VSUBS
+ detronyx_12t_2w2r_rc4_4x4_routed_5layer_direct
Xu_t011_009 u_t011_009/c0_w0_bl u_t011_009/c0_w0_br u_t011_009/c0_w1_bl u_t011_009/c0_w1_br u_t011_009/c0_r0_rbl
+ u_t011_009/c0_r1_rbl u_t011_009/c1_w0_bl u_t011_009/c1_w0_br u_t011_009/c1_w1_bl u_t011_009/c1_w1_br
+ u_t011_009/c1_r0_rbl u_t011_009/c1_r1_rbl u_t011_009/c2_w0_bl u_t011_009/c2_w0_br u_t011_009/c2_w1_bl
+ u_t011_009/c2_w1_br u_t011_009/c2_r0_rbl u_t011_009/c2_r1_rbl u_t011_009/c3_w0_bl u_t011_009/c3_w0_br
+ u_t011_009/c3_w1_bl u_t011_009/c3_w1_br u_t011_009/c3_r0_rbl u_t011_009/c3_r1_rbl u_t011_009/r0_w0_wl
+ u_t011_009/r0_w1_wl u_t011_009/r0_r0_rwl u_t011_009/r0_r1_rwl u_t011_009/r1_w0_wl u_t011_009/r1_w1_wl
+ u_t011_009/r1_r0_rwl u_t011_009/r1_r1_rwl u_t011_009/r2_w0_wl u_t011_009/r2_w1_wl u_t011_009/r2_r0_rwl
+ u_t011_009/r2_r1_rwl u_t011_009/r3_w0_wl u_t011_009/r3_w1_wl u_t011_009/r3_r0_rwl u_t011_009/r3_r1_rwl VDD VSS VSUBS
+ detronyx_12t_2w2r_rc4_4x4_routed_5layer_direct
Xu_t008_014 u_t008_014/c0_w0_bl u_t008_014/c0_w0_br u_t008_014/c0_w1_bl u_t008_014/c0_w1_br u_t008_014/c0_r0_rbl
+ u_t008_014/c0_r1_rbl u_t008_014/c1_w0_bl u_t008_014/c1_w0_br u_t008_014/c1_w1_bl u_t008_014/c1_w1_br
+ u_t008_014/c1_r0_rbl u_t008_014/c1_r1_rbl u_t008_014/c2_w0_bl u_t008_014/c2_w0_br u_t008_014/c2_w1_bl
+ u_t008_014/c2_w1_br u_t008_014/c2_r0_rbl u_t008_014/c2_r1_rbl u_t008_014/c3_w0_bl u_t008_014/c3_w0_br
+ u_t008_014/c3_w1_bl u_t008_014/c3_w1_br u_t008_014/c3_r0_rbl u_t008_014/c3_r1_rbl u_t008_014/r0_w0_wl
+ u_t008_014/r0_w1_wl u_t008_014/r0_r0_rwl u_t008_014/r0_r1_rwl u_t008_014/r1_w0_wl u_t008_014/r1_w1_wl
+ u_t008_014/r1_r0_rwl u_t008_014/r1_r1_rwl u_t008_014/r2_w0_wl u_t008_014/r2_w1_wl u_t008_014/r2_r0_rwl
+ u_t008_014/r2_r1_rwl u_t008_014/r3_w0_wl u_t008_014/r3_w1_wl u_t008_014/r3_r0_rwl u_t008_014/r3_r1_rwl VDD VSS VSUBS
+ detronyx_12t_2w2r_rc4_4x4_routed_5layer_direct
Xu_t008_003 u_t008_003/c0_w0_bl u_t008_003/c0_w0_br u_t008_003/c0_w1_bl u_t008_003/c0_w1_br u_t008_003/c0_r0_rbl
+ u_t008_003/c0_r1_rbl u_t008_003/c1_w0_bl u_t008_003/c1_w0_br u_t008_003/c1_w1_bl u_t008_003/c1_w1_br
+ u_t008_003/c1_r0_rbl u_t008_003/c1_r1_rbl u_t008_003/c2_w0_bl u_t008_003/c2_w0_br u_t008_003/c2_w1_bl
+ u_t008_003/c2_w1_br u_t008_003/c2_r0_rbl u_t008_003/c2_r1_rbl u_t008_003/c3_w0_bl u_t008_003/c3_w0_br
+ u_t008_003/c3_w1_bl u_t008_003/c3_w1_br u_t008_003/c3_r0_rbl u_t008_003/c3_r1_rbl u_t008_003/r0_w0_wl
+ u_t008_003/r0_w1_wl u_t008_003/r0_r0_rwl u_t008_003/r0_r1_rwl u_t008_003/r1_w0_wl u_t008_003/r1_w1_wl
+ u_t008_003/r1_r0_rwl u_t008_003/r1_r1_rwl u_t008_003/r2_w0_wl u_t008_003/r2_w1_wl u_t008_003/r2_r0_rwl
+ u_t008_003/r2_r1_rwl u_t008_003/r3_w0_wl u_t008_003/r3_w1_wl u_t008_003/r3_r0_rwl u_t008_003/r3_r1_rwl VDD VSS VSUBS
+ detronyx_12t_2w2r_rc4_4x4_routed_5layer_direct
Xu_t005_006 u_t005_006/c0_w0_bl u_t005_006/c0_w0_br u_t005_006/c0_w1_bl u_t005_006/c0_w1_br u_t005_006/c0_r0_rbl
+ u_t005_006/c0_r1_rbl u_t005_006/c1_w0_bl u_t005_006/c1_w0_br u_t005_006/c1_w1_bl u_t005_006/c1_w1_br
+ u_t005_006/c1_r0_rbl u_t005_006/c1_r1_rbl u_t005_006/c2_w0_bl u_t005_006/c2_w0_br u_t005_006/c2_w1_bl
+ u_t005_006/c2_w1_br u_t005_006/c2_r0_rbl u_t005_006/c2_r1_rbl u_t005_006/c3_w0_bl u_t005_006/c3_w0_br
+ u_t005_006/c3_w1_bl u_t005_006/c3_w1_br u_t005_006/c3_r0_rbl u_t005_006/c3_r1_rbl u_t005_006/r0_w0_wl
+ u_t005_006/r0_w1_wl u_t005_006/r0_r0_rwl u_t005_006/r0_r1_rwl u_t005_006/r1_w0_wl u_t005_006/r1_w1_wl
+ u_t005_006/r1_r0_rwl u_t005_006/r1_r1_rwl u_t005_006/r2_w0_wl u_t005_006/r2_w1_wl u_t005_006/r2_r0_rwl
+ u_t005_006/r2_r1_rwl u_t005_006/r3_w0_wl u_t005_006/r3_w1_wl u_t005_006/r3_r0_rwl u_t005_006/r3_r1_rwl VDD VSS VSUBS
+ detronyx_12t_2w2r_rc4_4x4_routed_5layer_direct
Xu_t002_009 u_t002_009/c0_w0_bl u_t002_009/c0_w0_br u_t002_009/c0_w1_bl u_t002_009/c0_w1_br u_t002_009/c0_r0_rbl
+ u_t002_009/c0_r1_rbl u_t002_009/c1_w0_bl u_t002_009/c1_w0_br u_t002_009/c1_w1_bl u_t002_009/c1_w1_br
+ u_t002_009/c1_r0_rbl u_t002_009/c1_r1_rbl u_t002_009/c2_w0_bl u_t002_009/c2_w0_br u_t002_009/c2_w1_bl
+ u_t002_009/c2_w1_br u_t002_009/c2_r0_rbl u_t002_009/c2_r1_rbl u_t002_009/c3_w0_bl u_t002_009/c3_w0_br
+ u_t002_009/c3_w1_bl u_t002_009/c3_w1_br u_t002_009/c3_r0_rbl u_t002_009/c3_r1_rbl u_t002_009/r0_w0_wl
+ u_t002_009/r0_w1_wl u_t002_009/r0_r0_rwl u_t002_009/r0_r1_rwl u_t002_009/r1_w0_wl u_t002_009/r1_w1_wl
+ u_t002_009/r1_r0_rwl u_t002_009/r1_r1_rwl u_t002_009/r2_w0_wl u_t002_009/r2_w1_wl u_t002_009/r2_r0_rwl
+ u_t002_009/r2_r1_rwl u_t002_009/r3_w0_wl u_t002_009/r3_w1_wl u_t002_009/r3_r0_rwl u_t002_009/r3_r1_rwl VDD VSS VSUBS
+ detronyx_12t_2w2r_rc4_4x4_routed_5layer_direct
Xu_t008_015 u_t008_015/c0_w0_bl u_t008_015/c0_w0_br u_t008_015/c0_w1_bl u_t008_015/c0_w1_br u_t008_015/c0_r0_rbl
+ u_t008_015/c0_r1_rbl u_t008_015/c1_w0_bl u_t008_015/c1_w0_br u_t008_015/c1_w1_bl u_t008_015/c1_w1_br
+ u_t008_015/c1_r0_rbl u_t008_015/c1_r1_rbl u_t008_015/c2_w0_bl u_t008_015/c2_w0_br u_t008_015/c2_w1_bl
+ u_t008_015/c2_w1_br u_t008_015/c2_r0_rbl u_t008_015/c2_r1_rbl u_t008_015/c3_w0_bl u_t008_015/c3_w0_br
+ u_t008_015/c3_w1_bl u_t008_015/c3_w1_br u_t008_015/c3_r0_rbl u_t008_015/c3_r1_rbl u_t008_015/r0_w0_wl
+ u_t008_015/r0_w1_wl u_t008_015/r0_r0_rwl u_t008_015/r0_r1_rwl u_t008_015/r1_w0_wl u_t008_015/r1_w1_wl
+ u_t008_015/r1_r0_rwl u_t008_015/r1_r1_rwl u_t008_015/r2_w0_wl u_t008_015/r2_w1_wl u_t008_015/r2_r0_rwl
+ u_t008_015/r2_r1_rwl u_t008_015/r3_w0_wl u_t008_015/r3_w1_wl u_t008_015/r3_r0_rwl u_t008_015/r3_r1_rwl VDD VSS VSUBS
+ detronyx_12t_2w2r_rc4_4x4_routed_5layer_direct
Xu_t008_004 u_t008_004/c0_w0_bl u_t008_004/c0_w0_br u_t008_004/c0_w1_bl u_t008_004/c0_w1_br u_t008_004/c0_r0_rbl
+ u_t008_004/c0_r1_rbl u_t008_004/c1_w0_bl u_t008_004/c1_w0_br u_t008_004/c1_w1_bl u_t008_004/c1_w1_br
+ u_t008_004/c1_r0_rbl u_t008_004/c1_r1_rbl u_t008_004/c2_w0_bl u_t008_004/c2_w0_br u_t008_004/c2_w1_bl
+ u_t008_004/c2_w1_br u_t008_004/c2_r0_rbl u_t008_004/c2_r1_rbl u_t008_004/c3_w0_bl u_t008_004/c3_w0_br
+ u_t008_004/c3_w1_bl u_t008_004/c3_w1_br u_t008_004/c3_r0_rbl u_t008_004/c3_r1_rbl u_t008_004/r0_w0_wl
+ u_t008_004/r0_w1_wl u_t008_004/r0_r0_rwl u_t008_004/r0_r1_rwl u_t008_004/r1_w0_wl u_t008_004/r1_w1_wl
+ u_t008_004/r1_r0_rwl u_t008_004/r1_r1_rwl u_t008_004/r2_w0_wl u_t008_004/r2_w1_wl u_t008_004/r2_r0_rwl
+ u_t008_004/r2_r1_rwl u_t008_004/r3_w0_wl u_t008_004/r3_w1_wl u_t008_004/r3_r0_rwl u_t008_004/r3_r1_rwl VDD VSS VSUBS
+ detronyx_12t_2w2r_rc4_4x4_routed_5layer_direct
Xu_t014_007 u_t014_007/c0_w0_bl u_t014_007/c0_w0_br u_t014_007/c0_w1_bl u_t014_007/c0_w1_br u_t014_007/c0_r0_rbl
+ u_t014_007/c0_r1_rbl u_t014_007/c1_w0_bl u_t014_007/c1_w0_br u_t014_007/c1_w1_bl u_t014_007/c1_w1_br
+ u_t014_007/c1_r0_rbl u_t014_007/c1_r1_rbl u_t014_007/c2_w0_bl u_t014_007/c2_w0_br u_t014_007/c2_w1_bl
+ u_t014_007/c2_w1_br u_t014_007/c2_r0_rbl u_t014_007/c2_r1_rbl u_t014_007/c3_w0_bl u_t014_007/c3_w0_br
+ u_t014_007/c3_w1_bl u_t014_007/c3_w1_br u_t014_007/c3_r0_rbl u_t014_007/c3_r1_rbl u_t014_007/r0_w0_wl
+ u_t014_007/r0_w1_wl u_t014_007/r0_r0_rwl u_t014_007/r0_r1_rwl u_t014_007/r1_w0_wl u_t014_007/r1_w1_wl
+ u_t014_007/r1_r0_rwl u_t014_007/r1_r1_rwl u_t014_007/r2_w0_wl u_t014_007/r2_w1_wl u_t014_007/r2_r0_rwl
+ u_t014_007/r2_r1_rwl u_t014_007/r3_w0_wl u_t014_007/r3_w1_wl u_t014_007/r3_r0_rwl u_t014_007/r3_r1_rwl VDD VSS VSUBS
+ detronyx_12t_2w2r_rc4_4x4_routed_5layer_direct
Xu_t010_010 u_t010_010/c0_w0_bl u_t010_010/c0_w0_br u_t010_010/c0_w1_bl u_t010_010/c0_w1_br u_t010_010/c0_r0_rbl
+ u_t010_010/c0_r1_rbl u_t010_010/c1_w0_bl u_t010_010/c1_w0_br u_t010_010/c1_w1_bl u_t010_010/c1_w1_br
+ u_t010_010/c1_r0_rbl u_t010_010/c1_r1_rbl u_t010_010/c2_w0_bl u_t010_010/c2_w0_br u_t010_010/c2_w1_bl
+ u_t010_010/c2_w1_br u_t010_010/c2_r0_rbl u_t010_010/c2_r1_rbl u_t010_010/c3_w0_bl u_t010_010/c3_w0_br
+ u_t010_010/c3_w1_bl u_t010_010/c3_w1_br u_t010_010/c3_r0_rbl u_t010_010/c3_r1_rbl u_t010_010/r0_w0_wl
+ u_t010_010/r0_w1_wl u_t010_010/r0_r0_rwl u_t010_010/r0_r1_rwl u_t010_010/r1_w0_wl u_t010_010/r1_w1_wl
+ u_t010_010/r1_r0_rwl u_t010_010/r1_r1_rwl u_t010_010/r2_w0_wl u_t010_010/r2_w1_wl u_t010_010/r2_r0_rwl
+ u_t010_010/r2_r1_rwl u_t010_010/r3_w0_wl u_t010_010/r3_w1_wl u_t010_010/r3_r0_rwl u_t010_010/r3_r1_rwl VDD VSS VSUBS
+ detronyx_12t_2w2r_rc4_4x4_routed_5layer_direct
Xu_t001_010 u_t001_010/c0_w0_bl u_t001_010/c0_w0_br u_t001_010/c0_w1_bl u_t001_010/c0_w1_br u_t001_010/c0_r0_rbl
+ u_t001_010/c0_r1_rbl u_t001_010/c1_w0_bl u_t001_010/c1_w0_br u_t001_010/c1_w1_bl u_t001_010/c1_w1_br
+ u_t001_010/c1_r0_rbl u_t001_010/c1_r1_rbl u_t001_010/c2_w0_bl u_t001_010/c2_w0_br u_t001_010/c2_w1_bl
+ u_t001_010/c2_w1_br u_t001_010/c2_r0_rbl u_t001_010/c2_r1_rbl u_t001_010/c3_w0_bl u_t001_010/c3_w0_br
+ u_t001_010/c3_w1_bl u_t001_010/c3_w1_br u_t001_010/c3_r0_rbl u_t001_010/c3_r1_rbl u_t001_010/r0_w0_wl
+ u_t001_010/r0_w1_wl u_t001_010/r0_r0_rwl u_t001_010/r0_r1_rwl u_t001_010/r1_w0_wl u_t001_010/r1_w1_wl
+ u_t001_010/r1_r0_rwl u_t001_010/r1_r1_rwl u_t001_010/r2_w0_wl u_t001_010/r2_w1_wl u_t001_010/r2_r0_rwl
+ u_t001_010/r2_r1_rwl u_t001_010/r3_w0_wl u_t001_010/r3_w1_wl u_t001_010/r3_r0_rwl u_t001_010/r3_r1_rwl VDD VSS VSUBS
+ detronyx_12t_2w2r_rc4_4x4_routed_5layer_direct
Xu_t005_007 u_t005_007/c0_w0_bl u_t005_007/c0_w0_br u_t005_007/c0_w1_bl u_t005_007/c0_w1_br u_t005_007/c0_r0_rbl
+ u_t005_007/c0_r1_rbl u_t005_007/c1_w0_bl u_t005_007/c1_w0_br u_t005_007/c1_w1_bl u_t005_007/c1_w1_br
+ u_t005_007/c1_r0_rbl u_t005_007/c1_r1_rbl u_t005_007/c2_w0_bl u_t005_007/c2_w0_br u_t005_007/c2_w1_bl
+ u_t005_007/c2_w1_br u_t005_007/c2_r0_rbl u_t005_007/c2_r1_rbl u_t005_007/c3_w0_bl u_t005_007/c3_w0_br
+ u_t005_007/c3_w1_bl u_t005_007/c3_w1_br u_t005_007/c3_r0_rbl u_t005_007/c3_r1_rbl u_t005_007/r0_w0_wl
+ u_t005_007/r0_w1_wl u_t005_007/r0_r0_rwl u_t005_007/r0_r1_rwl u_t005_007/r1_w0_wl u_t005_007/r1_w1_wl
+ u_t005_007/r1_r0_rwl u_t005_007/r1_r1_rwl u_t005_007/r2_w0_wl u_t005_007/r2_w1_wl u_t005_007/r2_r0_rwl
+ u_t005_007/r2_r1_rwl u_t005_007/r3_w0_wl u_t005_007/r3_w1_wl u_t005_007/r3_r0_rwl u_t005_007/r3_r1_rwl VDD VSS VSUBS
+ detronyx_12t_2w2r_rc4_4x4_routed_5layer_direct
Xu_t014_008 u_t014_008/c0_w0_bl u_t014_008/c0_w0_br u_t014_008/c0_w1_bl u_t014_008/c0_w1_br u_t014_008/c0_r0_rbl
+ u_t014_008/c0_r1_rbl u_t014_008/c1_w0_bl u_t014_008/c1_w0_br u_t014_008/c1_w1_bl u_t014_008/c1_w1_br
+ u_t014_008/c1_r0_rbl u_t014_008/c1_r1_rbl u_t014_008/c2_w0_bl u_t014_008/c2_w0_br u_t014_008/c2_w1_bl
+ u_t014_008/c2_w1_br u_t014_008/c2_r0_rbl u_t014_008/c2_r1_rbl u_t014_008/c3_w0_bl u_t014_008/c3_w0_br
+ u_t014_008/c3_w1_bl u_t014_008/c3_w1_br u_t014_008/c3_r0_rbl u_t014_008/c3_r1_rbl u_t014_008/r0_w0_wl
+ u_t014_008/r0_w1_wl u_t014_008/r0_r0_rwl u_t014_008/r0_r1_rwl u_t014_008/r1_w0_wl u_t014_008/r1_w1_wl
+ u_t014_008/r1_r0_rwl u_t014_008/r1_r1_rwl u_t014_008/r2_w0_wl u_t014_008/r2_w1_wl u_t014_008/r2_r0_rwl
+ u_t014_008/r2_r1_rwl u_t014_008/r3_w0_wl u_t014_008/r3_w1_wl u_t014_008/r3_r0_rwl u_t014_008/r3_r1_rwl VDD VSS VSUBS
+ detronyx_12t_2w2r_rc4_4x4_routed_5layer_direct
Xu_t008_005 u_t008_005/c0_w0_bl u_t008_005/c0_w0_br u_t008_005/c0_w1_bl u_t008_005/c0_w1_br u_t008_005/c0_r0_rbl
+ u_t008_005/c0_r1_rbl u_t008_005/c1_w0_bl u_t008_005/c1_w0_br u_t008_005/c1_w1_bl u_t008_005/c1_w1_br
+ u_t008_005/c1_r0_rbl u_t008_005/c1_r1_rbl u_t008_005/c2_w0_bl u_t008_005/c2_w0_br u_t008_005/c2_w1_bl
+ u_t008_005/c2_w1_br u_t008_005/c2_r0_rbl u_t008_005/c2_r1_rbl u_t008_005/c3_w0_bl u_t008_005/c3_w0_br
+ u_t008_005/c3_w1_bl u_t008_005/c3_w1_br u_t008_005/c3_r0_rbl u_t008_005/c3_r1_rbl u_t008_005/r0_w0_wl
+ u_t008_005/r0_w1_wl u_t008_005/r0_r0_rwl u_t008_005/r0_r1_rwl u_t008_005/r1_w0_wl u_t008_005/r1_w1_wl
+ u_t008_005/r1_r0_rwl u_t008_005/r1_r1_rwl u_t008_005/r2_w0_wl u_t008_005/r2_w1_wl u_t008_005/r2_r0_rwl
+ u_t008_005/r2_r1_rwl u_t008_005/r3_w0_wl u_t008_005/r3_w1_wl u_t008_005/r3_r0_rwl u_t008_005/r3_r1_rwl VDD VSS VSUBS
+ detronyx_12t_2w2r_rc4_4x4_routed_5layer_direct
Xu_t005_008 u_t005_008/c0_w0_bl u_t005_008/c0_w0_br u_t005_008/c0_w1_bl u_t005_008/c0_w1_br u_t005_008/c0_r0_rbl
+ u_t005_008/c0_r1_rbl u_t005_008/c1_w0_bl u_t005_008/c1_w0_br u_t005_008/c1_w1_bl u_t005_008/c1_w1_br
+ u_t005_008/c1_r0_rbl u_t005_008/c1_r1_rbl u_t005_008/c2_w0_bl u_t005_008/c2_w0_br u_t005_008/c2_w1_bl
+ u_t005_008/c2_w1_br u_t005_008/c2_r0_rbl u_t005_008/c2_r1_rbl u_t005_008/c3_w0_bl u_t005_008/c3_w0_br
+ u_t005_008/c3_w1_bl u_t005_008/c3_w1_br u_t005_008/c3_r0_rbl u_t005_008/c3_r1_rbl u_t005_008/r0_w0_wl
+ u_t005_008/r0_w1_wl u_t005_008/r0_r0_rwl u_t005_008/r0_r1_rwl u_t005_008/r1_w0_wl u_t005_008/r1_w1_wl
+ u_t005_008/r1_r0_rwl u_t005_008/r1_r1_rwl u_t005_008/r2_w0_wl u_t005_008/r2_w1_wl u_t005_008/r2_r0_rwl
+ u_t005_008/r2_r1_rwl u_t005_008/r3_w0_wl u_t005_008/r3_w1_wl u_t005_008/r3_r0_rwl u_t005_008/r3_r1_rwl VDD VSS VSUBS
+ detronyx_12t_2w2r_rc4_4x4_routed_5layer_direct
Xu_t010_011 u_t010_011/c0_w0_bl u_t010_011/c0_w0_br u_t010_011/c0_w1_bl u_t010_011/c0_w1_br u_t010_011/c0_r0_rbl
+ u_t010_011/c0_r1_rbl u_t010_011/c1_w0_bl u_t010_011/c1_w0_br u_t010_011/c1_w1_bl u_t010_011/c1_w1_br
+ u_t010_011/c1_r0_rbl u_t010_011/c1_r1_rbl u_t010_011/c2_w0_bl u_t010_011/c2_w0_br u_t010_011/c2_w1_bl
+ u_t010_011/c2_w1_br u_t010_011/c2_r0_rbl u_t010_011/c2_r1_rbl u_t010_011/c3_w0_bl u_t010_011/c3_w0_br
+ u_t010_011/c3_w1_bl u_t010_011/c3_w1_br u_t010_011/c3_r0_rbl u_t010_011/c3_r1_rbl u_t010_011/r0_w0_wl
+ u_t010_011/r0_w1_wl u_t010_011/r0_r0_rwl u_t010_011/r0_r1_rwl u_t010_011/r1_w0_wl u_t010_011/r1_w1_wl
+ u_t010_011/r1_r0_rwl u_t010_011/r1_r1_rwl u_t010_011/r2_w0_wl u_t010_011/r2_w1_wl u_t010_011/r2_r0_rwl
+ u_t010_011/r2_r1_rwl u_t010_011/r3_w0_wl u_t010_011/r3_w1_wl u_t010_011/r3_r0_rwl u_t010_011/r3_r1_rwl VDD VSS VSUBS
+ detronyx_12t_2w2r_rc4_4x4_routed_5layer_direct
Xu_t010_000 u_t010_000/c0_w0_bl u_t010_000/c0_w0_br u_t010_000/c0_w1_bl u_t010_000/c0_w1_br u_t010_000/c0_r0_rbl
+ u_t010_000/c0_r1_rbl u_t010_000/c1_w0_bl u_t010_000/c1_w0_br u_t010_000/c1_w1_bl u_t010_000/c1_w1_br
+ u_t010_000/c1_r0_rbl u_t010_000/c1_r1_rbl u_t010_000/c2_w0_bl u_t010_000/c2_w0_br u_t010_000/c2_w1_bl
+ u_t010_000/c2_w1_br u_t010_000/c2_r0_rbl u_t010_000/c2_r1_rbl u_t010_000/c3_w0_bl u_t010_000/c3_w0_br
+ u_t010_000/c3_w1_bl u_t010_000/c3_w1_br u_t010_000/c3_r0_rbl u_t010_000/c3_r1_rbl u_t010_000/r0_w0_wl
+ u_t010_000/r0_w1_wl u_t010_000/r0_r0_rwl u_t010_000/r0_r1_rwl u_t010_000/r1_w0_wl u_t010_000/r1_w1_wl
+ u_t010_000/r1_r0_rwl u_t010_000/r1_r1_rwl u_t010_000/r2_w0_wl u_t010_000/r2_w1_wl u_t010_000/r2_r0_rwl
+ u_t010_000/r2_r1_rwl u_t010_000/r3_w0_wl u_t010_000/r3_w1_wl u_t010_000/r3_r0_rwl u_t010_000/r3_r1_rwl VDD VSS VSUBS
+ detronyx_12t_2w2r_rc4_4x4_routed_5layer_direct
Xu_t001_000 u_t001_000/c0_w0_bl u_t001_000/c0_w0_br u_t001_000/c0_w1_bl u_t001_000/c0_w1_br u_t001_000/c0_r0_rbl
+ u_t001_000/c0_r1_rbl u_t001_000/c1_w0_bl u_t001_000/c1_w0_br u_t001_000/c1_w1_bl u_t001_000/c1_w1_br
+ u_t001_000/c1_r0_rbl u_t001_000/c1_r1_rbl u_t001_000/c2_w0_bl u_t001_000/c2_w0_br u_t001_000/c2_w1_bl
+ u_t001_000/c2_w1_br u_t001_000/c2_r0_rbl u_t001_000/c2_r1_rbl u_t001_000/c3_w0_bl u_t001_000/c3_w0_br
+ u_t001_000/c3_w1_bl u_t001_000/c3_w1_br u_t001_000/c3_r0_rbl u_t001_000/c3_r1_rbl u_t001_000/r0_w0_wl
+ u_t001_000/r0_w1_wl u_t001_000/r0_r0_rwl u_t001_000/r0_r1_rwl u_t001_000/r1_w0_wl u_t001_000/r1_w1_wl
+ u_t001_000/r1_r0_rwl u_t001_000/r1_r1_rwl u_t001_000/r2_w0_wl u_t001_000/r2_w1_wl u_t001_000/r2_r0_rwl
+ u_t001_000/r2_r1_rwl u_t001_000/r3_w0_wl u_t001_000/r3_w1_wl u_t001_000/r3_r0_rwl u_t001_000/r3_r1_rwl VDD VSS VSUBS
+ detronyx_12t_2w2r_rc4_4x4_routed_5layer_direct
Xu_t001_011 u_t001_011/c0_w0_bl u_t001_011/c0_w0_br u_t001_011/c0_w1_bl u_t001_011/c0_w1_br u_t001_011/c0_r0_rbl
+ u_t001_011/c0_r1_rbl u_t001_011/c1_w0_bl u_t001_011/c1_w0_br u_t001_011/c1_w1_bl u_t001_011/c1_w1_br
+ u_t001_011/c1_r0_rbl u_t001_011/c1_r1_rbl u_t001_011/c2_w0_bl u_t001_011/c2_w0_br u_t001_011/c2_w1_bl
+ u_t001_011/c2_w1_br u_t001_011/c2_r0_rbl u_t001_011/c2_r1_rbl u_t001_011/c3_w0_bl u_t001_011/c3_w0_br
+ u_t001_011/c3_w1_bl u_t001_011/c3_w1_br u_t001_011/c3_r0_rbl u_t001_011/c3_r1_rbl u_t001_011/r0_w0_wl
+ u_t001_011/r0_w1_wl u_t001_011/r0_r0_rwl u_t001_011/r0_r1_rwl u_t001_011/r1_w0_wl u_t001_011/r1_w1_wl
+ u_t001_011/r1_r0_rwl u_t001_011/r1_r1_rwl u_t001_011/r2_w0_wl u_t001_011/r2_w1_wl u_t001_011/r2_r0_rwl
+ u_t001_011/r2_r1_rwl u_t001_011/r3_w0_wl u_t001_011/r3_w1_wl u_t001_011/r3_r0_rwl u_t001_011/r3_r1_rwl VDD VSS VSUBS
+ detronyx_12t_2w2r_rc4_4x4_routed_5layer_direct
Xu_t008_006 u_t008_006/c0_w0_bl u_t008_006/c0_w0_br u_t008_006/c0_w1_bl u_t008_006/c0_w1_br u_t008_006/c0_r0_rbl
+ u_t008_006/c0_r1_rbl u_t008_006/c1_w0_bl u_t008_006/c1_w0_br u_t008_006/c1_w1_bl u_t008_006/c1_w1_br
+ u_t008_006/c1_r0_rbl u_t008_006/c1_r1_rbl u_t008_006/c2_w0_bl u_t008_006/c2_w0_br u_t008_006/c2_w1_bl
+ u_t008_006/c2_w1_br u_t008_006/c2_r0_rbl u_t008_006/c2_r1_rbl u_t008_006/c3_w0_bl u_t008_006/c3_w0_br
+ u_t008_006/c3_w1_bl u_t008_006/c3_w1_br u_t008_006/c3_r0_rbl u_t008_006/c3_r1_rbl u_t008_006/r0_w0_wl
+ u_t008_006/r0_w1_wl u_t008_006/r0_r0_rwl u_t008_006/r0_r1_rwl u_t008_006/r1_w0_wl u_t008_006/r1_w1_wl
+ u_t008_006/r1_r0_rwl u_t008_006/r1_r1_rwl u_t008_006/r2_w0_wl u_t008_006/r2_w1_wl u_t008_006/r2_r0_rwl
+ u_t008_006/r2_r1_rwl u_t008_006/r3_w0_wl u_t008_006/r3_w1_wl u_t008_006/r3_r0_rwl u_t008_006/r3_r1_rwl VDD VSS VSUBS
+ detronyx_12t_2w2r_rc4_4x4_routed_5layer_direct
Xu_t014_009 u_t014_009/c0_w0_bl u_t014_009/c0_w0_br u_t014_009/c0_w1_bl u_t014_009/c0_w1_br u_t014_009/c0_r0_rbl
+ u_t014_009/c0_r1_rbl u_t014_009/c1_w0_bl u_t014_009/c1_w0_br u_t014_009/c1_w1_bl u_t014_009/c1_w1_br
+ u_t014_009/c1_r0_rbl u_t014_009/c1_r1_rbl u_t014_009/c2_w0_bl u_t014_009/c2_w0_br u_t014_009/c2_w1_bl
+ u_t014_009/c2_w1_br u_t014_009/c2_r0_rbl u_t014_009/c2_r1_rbl u_t014_009/c3_w0_bl u_t014_009/c3_w0_br
+ u_t014_009/c3_w1_bl u_t014_009/c3_w1_br u_t014_009/c3_r0_rbl u_t014_009/c3_r1_rbl u_t014_009/r0_w0_wl
+ u_t014_009/r0_w1_wl u_t014_009/r0_r0_rwl u_t014_009/r0_r1_rwl u_t014_009/r1_w0_wl u_t014_009/r1_w1_wl
+ u_t014_009/r1_r0_rwl u_t014_009/r1_r1_rwl u_t014_009/r2_w0_wl u_t014_009/r2_w1_wl u_t014_009/r2_r0_rwl
+ u_t014_009/r2_r1_rwl u_t014_009/r3_w0_wl u_t014_009/r3_w1_wl u_t014_009/r3_r0_rwl u_t014_009/r3_r1_rwl VDD VSS VSUBS
+ detronyx_12t_2w2r_rc4_4x4_routed_5layer_direct
Xu_t010_012 u_t010_012/c0_w0_bl u_t010_012/c0_w0_br u_t010_012/c0_w1_bl u_t010_012/c0_w1_br u_t010_012/c0_r0_rbl
+ u_t010_012/c0_r1_rbl u_t010_012/c1_w0_bl u_t010_012/c1_w0_br u_t010_012/c1_w1_bl u_t010_012/c1_w1_br
+ u_t010_012/c1_r0_rbl u_t010_012/c1_r1_rbl u_t010_012/c2_w0_bl u_t010_012/c2_w0_br u_t010_012/c2_w1_bl
+ u_t010_012/c2_w1_br u_t010_012/c2_r0_rbl u_t010_012/c2_r1_rbl u_t010_012/c3_w0_bl u_t010_012/c3_w0_br
+ u_t010_012/c3_w1_bl u_t010_012/c3_w1_br u_t010_012/c3_r0_rbl u_t010_012/c3_r1_rbl u_t010_012/r0_w0_wl
+ u_t010_012/r0_w1_wl u_t010_012/r0_r0_rwl u_t010_012/r0_r1_rwl u_t010_012/r1_w0_wl u_t010_012/r1_w1_wl
+ u_t010_012/r1_r0_rwl u_t010_012/r1_r1_rwl u_t010_012/r2_w0_wl u_t010_012/r2_w1_wl u_t010_012/r2_r0_rwl
+ u_t010_012/r2_r1_rwl u_t010_012/r3_w0_wl u_t010_012/r3_w1_wl u_t010_012/r3_r0_rwl u_t010_012/r3_r1_rwl VDD VSS VSUBS
+ detronyx_12t_2w2r_rc4_4x4_routed_5layer_direct
Xu_t010_001 u_t010_001/c0_w0_bl u_t010_001/c0_w0_br u_t010_001/c0_w1_bl u_t010_001/c0_w1_br u_t010_001/c0_r0_rbl
+ u_t010_001/c0_r1_rbl u_t010_001/c1_w0_bl u_t010_001/c1_w0_br u_t010_001/c1_w1_bl u_t010_001/c1_w1_br
+ u_t010_001/c1_r0_rbl u_t010_001/c1_r1_rbl u_t010_001/c2_w0_bl u_t010_001/c2_w0_br u_t010_001/c2_w1_bl
+ u_t010_001/c2_w1_br u_t010_001/c2_r0_rbl u_t010_001/c2_r1_rbl u_t010_001/c3_w0_bl u_t010_001/c3_w0_br
+ u_t010_001/c3_w1_bl u_t010_001/c3_w1_br u_t010_001/c3_r0_rbl u_t010_001/c3_r1_rbl u_t010_001/r0_w0_wl
+ u_t010_001/r0_w1_wl u_t010_001/r0_r0_rwl u_t010_001/r0_r1_rwl u_t010_001/r1_w0_wl u_t010_001/r1_w1_wl
+ u_t010_001/r1_r0_rwl u_t010_001/r1_r1_rwl u_t010_001/r2_w0_wl u_t010_001/r2_w1_wl u_t010_001/r2_r0_rwl
+ u_t010_001/r2_r1_rwl u_t010_001/r3_w0_wl u_t010_001/r3_w1_wl u_t010_001/r3_r0_rwl u_t010_001/r3_r1_rwl VDD VSS VSUBS
+ detronyx_12t_2w2r_rc4_4x4_routed_5layer_direct
Xu_t005_009 u_t005_009/c0_w0_bl u_t005_009/c0_w0_br u_t005_009/c0_w1_bl u_t005_009/c0_w1_br u_t005_009/c0_r0_rbl
+ u_t005_009/c0_r1_rbl u_t005_009/c1_w0_bl u_t005_009/c1_w0_br u_t005_009/c1_w1_bl u_t005_009/c1_w1_br
+ u_t005_009/c1_r0_rbl u_t005_009/c1_r1_rbl u_t005_009/c2_w0_bl u_t005_009/c2_w0_br u_t005_009/c2_w1_bl
+ u_t005_009/c2_w1_br u_t005_009/c2_r0_rbl u_t005_009/c2_r1_rbl u_t005_009/c3_w0_bl u_t005_009/c3_w0_br
+ u_t005_009/c3_w1_bl u_t005_009/c3_w1_br u_t005_009/c3_r0_rbl u_t005_009/c3_r1_rbl u_t005_009/r0_w0_wl
+ u_t005_009/r0_w1_wl u_t005_009/r0_r0_rwl u_t005_009/r0_r1_rwl u_t005_009/r1_w0_wl u_t005_009/r1_w1_wl
+ u_t005_009/r1_r0_rwl u_t005_009/r1_r1_rwl u_t005_009/r2_w0_wl u_t005_009/r2_w1_wl u_t005_009/r2_r0_rwl
+ u_t005_009/r2_r1_rwl u_t005_009/r3_w0_wl u_t005_009/r3_w1_wl u_t005_009/r3_r0_rwl u_t005_009/r3_r1_rwl VDD VSS VSUBS
+ detronyx_12t_2w2r_rc4_4x4_routed_5layer_direct
Xu_t001_001 u_t001_001/c0_w0_bl u_t001_001/c0_w0_br u_t001_001/c0_w1_bl u_t001_001/c0_w1_br u_t001_001/c0_r0_rbl
+ u_t001_001/c0_r1_rbl u_t001_001/c1_w0_bl u_t001_001/c1_w0_br u_t001_001/c1_w1_bl u_t001_001/c1_w1_br
+ u_t001_001/c1_r0_rbl u_t001_001/c1_r1_rbl u_t001_001/c2_w0_bl u_t001_001/c2_w0_br u_t001_001/c2_w1_bl
+ u_t001_001/c2_w1_br u_t001_001/c2_r0_rbl u_t001_001/c2_r1_rbl u_t001_001/c3_w0_bl u_t001_001/c3_w0_br
+ u_t001_001/c3_w1_bl u_t001_001/c3_w1_br u_t001_001/c3_r0_rbl u_t001_001/c3_r1_rbl u_t001_001/r0_w0_wl
+ u_t001_001/r0_w1_wl u_t001_001/r0_r0_rwl u_t001_001/r0_r1_rwl u_t001_001/r1_w0_wl u_t001_001/r1_w1_wl
+ u_t001_001/r1_r0_rwl u_t001_001/r1_r1_rwl u_t001_001/r2_w0_wl u_t001_001/r2_w1_wl u_t001_001/r2_r0_rwl
+ u_t001_001/r2_r1_rwl u_t001_001/r3_w0_wl u_t001_001/r3_w1_wl u_t001_001/r3_r0_rwl u_t001_001/r3_r1_rwl VDD VSS VSUBS
+ detronyx_12t_2w2r_rc4_4x4_routed_5layer_direct
Xu_t001_012 u_t001_012/c0_w0_bl u_t001_012/c0_w0_br u_t001_012/c0_w1_bl u_t001_012/c0_w1_br u_t001_012/c0_r0_rbl
+ u_t001_012/c0_r1_rbl u_t001_012/c1_w0_bl u_t001_012/c1_w0_br u_t001_012/c1_w1_bl u_t001_012/c1_w1_br
+ u_t001_012/c1_r0_rbl u_t001_012/c1_r1_rbl u_t001_012/c2_w0_bl u_t001_012/c2_w0_br u_t001_012/c2_w1_bl
+ u_t001_012/c2_w1_br u_t001_012/c2_r0_rbl u_t001_012/c2_r1_rbl u_t001_012/c3_w0_bl u_t001_012/c3_w0_br
+ u_t001_012/c3_w1_bl u_t001_012/c3_w1_br u_t001_012/c3_r0_rbl u_t001_012/c3_r1_rbl u_t001_012/r0_w0_wl
+ u_t001_012/r0_w1_wl u_t001_012/r0_r0_rwl u_t001_012/r0_r1_rwl u_t001_012/r1_w0_wl u_t001_012/r1_w1_wl
+ u_t001_012/r1_r0_rwl u_t001_012/r1_r1_rwl u_t001_012/r2_w0_wl u_t001_012/r2_w1_wl u_t001_012/r2_r0_rwl
+ u_t001_012/r2_r1_rwl u_t001_012/r3_w0_wl u_t001_012/r3_w1_wl u_t001_012/r3_r0_rwl u_t001_012/r3_r1_rwl VDD VSS VSUBS
+ detronyx_12t_2w2r_rc4_4x4_routed_5layer_direct
.ends gf180mcu_3v3_12t_2r2w_sram_512x8
