* Independent macro-top blackbox reference for reports/local_signoff_full/gf180mcu_3v3_12t_2r2w_sram_1024x8/pex/gf180mcu_3v3_12t_2r2w_sram_1024x8.current_pdk.spice

.subckt detronyx_12t_2w2r_rc4_4x4_routed_5layer_direct c0_w0_bl c0_w0_br c0_w1_bl c0_w1_br c0_r0_rbl c0_r1_rbl
+ c1_w0_bl c1_w0_br c1_w1_bl c1_w1_br c1_r0_rbl c1_r1_rbl c2_w0_bl c2_w0_br c2_w1_bl c2_w1_br c2_r0_rbl c2_r1_rbl
+ c3_w0_bl c3_w0_br c3_w1_bl c3_w1_br c3_r0_rbl c3_r1_rbl r0_w0_wl r0_w1_wl r0_r0_rwl r0_r1_rwl r1_w0_wl r1_w1_wl
+ r1_r0_rwl r1_r1_rwl r2_w0_wl r2_w1_wl r2_r0_rwl r2_r1_rwl r3_w0_wl r3_w1_wl r3_r0_rwl r3_r1_rwl VDD VSS VSUBS
.ends detronyx_12t_2w2r_rc4_4x4_routed_5layer_direct

.subckt gf180mcu_3v3_12t_2r2w_sram_1024x8 clk w0_en w1_en r0_en r1_en w0_addr[0] w0_addr[1] w0_addr[2] w0_addr[3]
+ w0_addr[4] w0_addr[5] w0_addr[6] w0_addr[7] w0_addr[8] w0_addr[9] w1_addr[0] w1_addr[1] w1_addr[2] w1_addr[3]
+ w1_addr[4] w1_addr[5] w1_addr[6] w1_addr[7] w1_addr[8] w1_addr[9] r0_addr[0] r0_addr[1] r0_addr[2] r0_addr[3]
+ r0_addr[4] r0_addr[5] r0_addr[6] r0_addr[7] r0_addr[8] r0_addr[9] r1_addr[0] r1_addr[1] r1_addr[2] r1_addr[3]
+ r1_addr[4] r1_addr[5] r1_addr[6] r1_addr[7] r1_addr[8] r1_addr[9] w0_data[0] w0_data[1] w0_data[2] w0_data[3]
+ w0_data[4] w0_data[5] w0_data[6] w0_data[7] w1_data[0] w1_data[1] w1_data[2] w1_data[3] w1_data[4] w1_data[5]
+ w1_data[6] w1_data[7] r0_data[0] r0_data[1] r0_data[2] r0_data[3] r0_data[4] r0_data[5] r0_data[6] r0_data[7]
+ r1_data[0] r1_data[1] r1_data[2] r1_data[3] r1_data[4] r1_data[5] r1_data[6] r1_data[7] VDD VSS
Xu_t029_015 u_t029_015/c0_w0_bl u_t029_015/c0_w0_br u_t029_015/c0_w1_bl u_t029_015/c0_w1_br u_t029_015/c0_r0_rbl
+ u_t029_015/c0_r1_rbl u_t029_015/c1_w0_bl u_t029_015/c1_w0_br u_t029_015/c1_w1_bl u_t029_015/c1_w1_br
+ u_t029_015/c1_r0_rbl u_t029_015/c1_r1_rbl u_t029_015/c2_w0_bl u_t029_015/c2_w0_br u_t029_015/c2_w1_bl
+ u_t029_015/c2_w1_br u_t029_015/c2_r0_rbl u_t029_015/c2_r1_rbl u_t029_015/c3_w0_bl u_t029_015/c3_w0_br
+ u_t029_015/c3_w1_bl u_t029_015/c3_w1_br u_t029_015/c3_r0_rbl u_t029_015/c3_r1_rbl u_t029_015/r0_w0_wl
+ u_t029_015/r0_w1_wl u_t029_015/r0_r0_rwl u_t029_015/r0_r1_rwl u_t029_015/r1_w0_wl u_t029_015/r1_w1_wl
+ u_t029_015/r1_r0_rwl u_t029_015/r1_r1_rwl u_t029_015/r2_w0_wl u_t029_015/r2_w1_wl u_t029_015/r2_r0_rwl
+ u_t029_015/r2_r1_rwl u_t029_015/r3_w0_wl u_t029_015/r3_w1_wl u_t029_015/r3_r0_rwl u_t029_015/r3_r1_rwl VDD VSS VSUBS
+ detronyx_12t_2w2r_rc4_4x4_routed_5layer_direct
Xu_t029_004 u_t029_004/c0_w0_bl u_t029_004/c0_w0_br u_t029_004/c0_w1_bl u_t029_004/c0_w1_br u_t029_004/c0_r0_rbl
+ u_t029_004/c0_r1_rbl u_t029_004/c1_w0_bl u_t029_004/c1_w0_br u_t029_004/c1_w1_bl u_t029_004/c1_w1_br
+ u_t029_004/c1_r0_rbl u_t029_004/c1_r1_rbl u_t029_004/c2_w0_bl u_t029_004/c2_w0_br u_t029_004/c2_w1_bl
+ u_t029_004/c2_w1_br u_t029_004/c2_r0_rbl u_t029_004/c2_r1_rbl u_t029_004/c3_w0_bl u_t029_004/c3_w0_br
+ u_t029_004/c3_w1_bl u_t029_004/c3_w1_br u_t029_004/c3_r0_rbl u_t029_004/c3_r1_rbl u_t029_004/r0_w0_wl
+ u_t029_004/r0_w1_wl u_t029_004/r0_r0_rwl u_t029_004/r0_r1_rwl u_t029_004/r1_w0_wl u_t029_004/r1_w1_wl
+ u_t029_004/r1_r0_rwl u_t029_004/r1_r1_rwl u_t029_004/r2_w0_wl u_t029_004/r2_w1_wl u_t029_004/r2_r0_rwl
+ u_t029_004/r2_r1_rwl u_t029_004/r3_w0_wl u_t029_004/r3_w1_wl u_t029_004/r3_r0_rwl u_t029_004/r3_r1_rwl VDD VSS VSUBS
+ detronyx_12t_2w2r_rc4_4x4_routed_5layer_direct
Xu_t026_007 u_t026_007/c0_w0_bl u_t026_007/c0_w0_br u_t026_007/c0_w1_bl u_t026_007/c0_w1_br u_t026_007/c0_r0_rbl
+ u_t026_007/c0_r1_rbl u_t026_007/c1_w0_bl u_t026_007/c1_w0_br u_t026_007/c1_w1_bl u_t026_007/c1_w1_br
+ u_t026_007/c1_r0_rbl u_t026_007/c1_r1_rbl u_t026_007/c2_w0_bl u_t026_007/c2_w0_br u_t026_007/c2_w1_bl
+ u_t026_007/c2_w1_br u_t026_007/c2_r0_rbl u_t026_007/c2_r1_rbl u_t026_007/c3_w0_bl u_t026_007/c3_w0_br
+ u_t026_007/c3_w1_bl u_t026_007/c3_w1_br u_t026_007/c3_r0_rbl u_t026_007/c3_r1_rbl u_t026_007/r0_w0_wl
+ u_t026_007/r0_w1_wl u_t026_007/r0_r0_rwl u_t026_007/r0_r1_rwl u_t026_007/r1_w0_wl u_t026_007/r1_w1_wl
+ u_t026_007/r1_r0_rwl u_t026_007/r1_r1_rwl u_t026_007/r2_w0_wl u_t026_007/r2_w1_wl u_t026_007/r2_r0_rwl
+ u_t026_007/r2_r1_rwl u_t026_007/r3_w0_wl u_t026_007/r3_w1_wl u_t026_007/r3_r0_rwl u_t026_007/r3_r1_rwl VDD VSS VSUBS
+ detronyx_12t_2w2r_rc4_4x4_routed_5layer_direct
Xu_t017_007 u_t017_007/c0_w0_bl u_t017_007/c0_w0_br u_t017_007/c0_w1_bl u_t017_007/c0_w1_br u_t017_007/c0_r0_rbl
+ u_t017_007/c0_r1_rbl u_t017_007/c1_w0_bl u_t017_007/c1_w0_br u_t017_007/c1_w1_bl u_t017_007/c1_w1_br
+ u_t017_007/c1_r0_rbl u_t017_007/c1_r1_rbl u_t017_007/c2_w0_bl u_t017_007/c2_w0_br u_t017_007/c2_w1_bl
+ u_t017_007/c2_w1_br u_t017_007/c2_r0_rbl u_t017_007/c2_r1_rbl u_t017_007/c3_w0_bl u_t017_007/c3_w0_br
+ u_t017_007/c3_w1_bl u_t017_007/c3_w1_br u_t017_007/c3_r0_rbl u_t017_007/c3_r1_rbl u_t017_007/r0_w0_wl
+ u_t017_007/r0_w1_wl u_t017_007/r0_r0_rwl u_t017_007/r0_r1_rwl u_t017_007/r1_w0_wl u_t017_007/r1_w1_wl
+ u_t017_007/r1_r0_rwl u_t017_007/r1_r1_rwl u_t017_007/r2_w0_wl u_t017_007/r2_w1_wl u_t017_007/r2_r0_rwl
+ u_t017_007/r2_r1_rwl u_t017_007/r3_w0_wl u_t017_007/r3_w1_wl u_t017_007/r3_r0_rwl u_t017_007/r3_r1_rwl VDD VSS VSUBS
+ detronyx_12t_2w2r_rc4_4x4_routed_5layer_direct
Xu_t031_010 u_t031_010/c0_w0_bl u_t031_010/c0_w0_br u_t031_010/c0_w1_bl u_t031_010/c0_w1_br u_t031_010/c0_r0_rbl
+ u_t031_010/c0_r1_rbl u_t031_010/c1_w0_bl u_t031_010/c1_w0_br u_t031_010/c1_w1_bl u_t031_010/c1_w1_br
+ u_t031_010/c1_r0_rbl u_t031_010/c1_r1_rbl u_t031_010/c2_w0_bl u_t031_010/c2_w0_br u_t031_010/c2_w1_bl
+ u_t031_010/c2_w1_br u_t031_010/c2_r0_rbl u_t031_010/c2_r1_rbl u_t031_010/c3_w0_bl u_t031_010/c3_w0_br
+ u_t031_010/c3_w1_bl u_t031_010/c3_w1_br u_t031_010/c3_r0_rbl u_t031_010/c3_r1_rbl u_t031_010/r0_w0_wl
+ u_t031_010/r0_w1_wl u_t031_010/r0_r0_rwl u_t031_010/r0_r1_rwl u_t031_010/r1_w0_wl u_t031_010/r1_w1_wl
+ u_t031_010/r1_r0_rwl u_t031_010/r1_r1_rwl u_t031_010/r2_w0_wl u_t031_010/r2_w1_wl u_t031_010/r2_r0_rwl
+ u_t031_010/r2_r1_rwl u_t031_010/r3_w0_wl u_t031_010/r3_w1_wl u_t031_010/r3_r0_rwl u_t031_010/r3_r1_rwl VDD VSS VSUBS
+ detronyx_12t_2w2r_rc4_4x4_routed_5layer_direct
Xu_t008_007 u_t008_007/c0_w0_bl u_t008_007/c0_w0_br u_t008_007/c0_w1_bl u_t008_007/c0_w1_br u_t008_007/c0_r0_rbl
+ u_t008_007/c0_r1_rbl u_t008_007/c1_w0_bl u_t008_007/c1_w0_br u_t008_007/c1_w1_bl u_t008_007/c1_w1_br
+ u_t008_007/c1_r0_rbl u_t008_007/c1_r1_rbl u_t008_007/c2_w0_bl u_t008_007/c2_w0_br u_t008_007/c2_w1_bl
+ u_t008_007/c2_w1_br u_t008_007/c2_r0_rbl u_t008_007/c2_r1_rbl u_t008_007/c3_w0_bl u_t008_007/c3_w0_br
+ u_t008_007/c3_w1_bl u_t008_007/c3_w1_br u_t008_007/c3_r0_rbl u_t008_007/c3_r1_rbl u_t008_007/r0_w0_wl
+ u_t008_007/r0_w1_wl u_t008_007/r0_r0_rwl u_t008_007/r0_r1_rwl u_t008_007/r1_w0_wl u_t008_007/r1_w1_wl
+ u_t008_007/r1_r0_rwl u_t008_007/r1_r1_rwl u_t008_007/r2_w0_wl u_t008_007/r2_w1_wl u_t008_007/r2_r0_rwl
+ u_t008_007/r2_r1_rwl u_t008_007/r3_w0_wl u_t008_007/r3_w1_wl u_t008_007/r3_r0_rwl u_t008_007/r3_r1_rwl VDD VSS VSUBS
+ detronyx_12t_2w2r_rc4_4x4_routed_5layer_direct
Xu_t022_010 u_t022_010/c0_w0_bl u_t022_010/c0_w0_br u_t022_010/c0_w1_bl u_t022_010/c0_w1_br u_t022_010/c0_r0_rbl
+ u_t022_010/c0_r1_rbl u_t022_010/c1_w0_bl u_t022_010/c1_w0_br u_t022_010/c1_w1_bl u_t022_010/c1_w1_br
+ u_t022_010/c1_r0_rbl u_t022_010/c1_r1_rbl u_t022_010/c2_w0_bl u_t022_010/c2_w0_br u_t022_010/c2_w1_bl
+ u_t022_010/c2_w1_br u_t022_010/c2_r0_rbl u_t022_010/c2_r1_rbl u_t022_010/c3_w0_bl u_t022_010/c3_w0_br
+ u_t022_010/c3_w1_bl u_t022_010/c3_w1_br u_t022_010/c3_r0_rbl u_t022_010/c3_r1_rbl u_t022_010/r0_w0_wl
+ u_t022_010/r0_w1_wl u_t022_010/r0_r0_rwl u_t022_010/r0_r1_rwl u_t022_010/r1_w0_wl u_t022_010/r1_w1_wl
+ u_t022_010/r1_r0_rwl u_t022_010/r1_r1_rwl u_t022_010/r2_w0_wl u_t022_010/r2_w1_wl u_t022_010/r2_r0_rwl
+ u_t022_010/r2_r1_rwl u_t022_010/r3_w0_wl u_t022_010/r3_w1_wl u_t022_010/r3_r0_rwl u_t022_010/r3_r1_rwl VDD VSS VSUBS
+ detronyx_12t_2w2r_rc4_4x4_routed_5layer_direct
Xu_t013_010 u_t013_010/c0_w0_bl u_t013_010/c0_w0_br u_t013_010/c0_w1_bl u_t013_010/c0_w1_br u_t013_010/c0_r0_rbl
+ u_t013_010/c0_r1_rbl u_t013_010/c1_w0_bl u_t013_010/c1_w0_br u_t013_010/c1_w1_bl u_t013_010/c1_w1_br
+ u_t013_010/c1_r0_rbl u_t013_010/c1_r1_rbl u_t013_010/c2_w0_bl u_t013_010/c2_w0_br u_t013_010/c2_w1_bl
+ u_t013_010/c2_w1_br u_t013_010/c2_r0_rbl u_t013_010/c2_r1_rbl u_t013_010/c3_w0_bl u_t013_010/c3_w0_br
+ u_t013_010/c3_w1_bl u_t013_010/c3_w1_br u_t013_010/c3_r0_rbl u_t013_010/c3_r1_rbl u_t013_010/r0_w0_wl
+ u_t013_010/r0_w1_wl u_t013_010/r0_r0_rwl u_t013_010/r0_r1_rwl u_t013_010/r1_w0_wl u_t013_010/r1_w1_wl
+ u_t013_010/r1_r0_rwl u_t013_010/r1_r1_rwl u_t013_010/r2_w0_wl u_t013_010/r2_w1_wl u_t013_010/r2_r0_rwl
+ u_t013_010/r2_r1_rwl u_t013_010/r3_w0_wl u_t013_010/r3_w1_wl u_t013_010/r3_r0_rwl u_t013_010/r3_r1_rwl VDD VSS VSUBS
+ detronyx_12t_2w2r_rc4_4x4_routed_5layer_direct
Xu_t004_010 u_t004_010/c0_w0_bl u_t004_010/c0_w0_br u_t004_010/c0_w1_bl u_t004_010/c0_w1_br u_t004_010/c0_r0_rbl
+ u_t004_010/c0_r1_rbl u_t004_010/c1_w0_bl u_t004_010/c1_w0_br u_t004_010/c1_w1_bl u_t004_010/c1_w1_br
+ u_t004_010/c1_r0_rbl u_t004_010/c1_r1_rbl u_t004_010/c2_w0_bl u_t004_010/c2_w0_br u_t004_010/c2_w1_bl
+ u_t004_010/c2_w1_br u_t004_010/c2_r0_rbl u_t004_010/c2_r1_rbl u_t004_010/c3_w0_bl u_t004_010/c3_w0_br
+ u_t004_010/c3_w1_bl u_t004_010/c3_w1_br u_t004_010/c3_r0_rbl u_t004_010/c3_r1_rbl u_t004_010/r0_w0_wl
+ u_t004_010/r0_w1_wl u_t004_010/r0_r0_rwl u_t004_010/r0_r1_rwl u_t004_010/r1_w0_wl u_t004_010/r1_w1_wl
+ u_t004_010/r1_r0_rwl u_t004_010/r1_r1_rwl u_t004_010/r2_w0_wl u_t004_010/r2_w1_wl u_t004_010/r2_r0_rwl
+ u_t004_010/r2_r1_rwl u_t004_010/r3_w0_wl u_t004_010/r3_w1_wl u_t004_010/r3_r0_rwl u_t004_010/r3_r1_rwl VDD VSS VSUBS
+ detronyx_12t_2w2r_rc4_4x4_routed_5layer_direct
Xu_t010_002 u_t010_002/c0_w0_bl u_t010_002/c0_w0_br u_t010_002/c0_w1_bl u_t010_002/c0_w1_br u_t010_002/c0_r0_rbl
+ u_t010_002/c0_r1_rbl u_t010_002/c1_w0_bl u_t010_002/c1_w0_br u_t010_002/c1_w1_bl u_t010_002/c1_w1_br
+ u_t010_002/c1_r0_rbl u_t010_002/c1_r1_rbl u_t010_002/c2_w0_bl u_t010_002/c2_w0_br u_t010_002/c2_w1_bl
+ u_t010_002/c2_w1_br u_t010_002/c2_r0_rbl u_t010_002/c2_r1_rbl u_t010_002/c3_w0_bl u_t010_002/c3_w0_br
+ u_t010_002/c3_w1_bl u_t010_002/c3_w1_br u_t010_002/c3_r0_rbl u_t010_002/c3_r1_rbl u_t010_002/r0_w0_wl
+ u_t010_002/r0_w1_wl u_t010_002/r0_r0_rwl u_t010_002/r0_r1_rwl u_t010_002/r1_w0_wl u_t010_002/r1_w1_wl
+ u_t010_002/r1_r0_rwl u_t010_002/r1_r1_rwl u_t010_002/r2_w0_wl u_t010_002/r2_w1_wl u_t010_002/r2_r0_rwl
+ u_t010_002/r2_r1_rwl u_t010_002/r3_w0_wl u_t010_002/r3_w1_wl u_t010_002/r3_r0_rwl u_t010_002/r3_r1_rwl VDD VSS VSUBS
+ detronyx_12t_2w2r_rc4_4x4_routed_5layer_direct
Xu_t010_013 u_t010_013/c0_w0_bl u_t010_013/c0_w0_br u_t010_013/c0_w1_bl u_t010_013/c0_w1_br u_t010_013/c0_r0_rbl
+ u_t010_013/c0_r1_rbl u_t010_013/c1_w0_bl u_t010_013/c1_w0_br u_t010_013/c1_w1_bl u_t010_013/c1_w1_br
+ u_t010_013/c1_r0_rbl u_t010_013/c1_r1_rbl u_t010_013/c2_w0_bl u_t010_013/c2_w0_br u_t010_013/c2_w1_bl
+ u_t010_013/c2_w1_br u_t010_013/c2_r0_rbl u_t010_013/c2_r1_rbl u_t010_013/c3_w0_bl u_t010_013/c3_w0_br
+ u_t010_013/c3_w1_bl u_t010_013/c3_w1_br u_t010_013/c3_r0_rbl u_t010_013/c3_r1_rbl u_t010_013/r0_w0_wl
+ u_t010_013/r0_w1_wl u_t010_013/r0_r0_rwl u_t010_013/r0_r1_rwl u_t010_013/r1_w0_wl u_t010_013/r1_w1_wl
+ u_t010_013/r1_r0_rwl u_t010_013/r1_r1_rwl u_t010_013/r2_w0_wl u_t010_013/r2_w1_wl u_t010_013/r2_r0_rwl
+ u_t010_013/r2_r1_rwl u_t010_013/r3_w0_wl u_t010_013/r3_w1_wl u_t010_013/r3_r0_rwl u_t010_013/r3_r1_rwl VDD VSS VSUBS
+ detronyx_12t_2w2r_rc4_4x4_routed_5layer_direct
Xu_t001_013 u_t001_013/c0_w0_bl u_t001_013/c0_w0_br u_t001_013/c0_w1_bl u_t001_013/c0_w1_br u_t001_013/c0_r0_rbl
+ u_t001_013/c0_r1_rbl u_t001_013/c1_w0_bl u_t001_013/c1_w0_br u_t001_013/c1_w1_bl u_t001_013/c1_w1_br
+ u_t001_013/c1_r0_rbl u_t001_013/c1_r1_rbl u_t001_013/c2_w0_bl u_t001_013/c2_w0_br u_t001_013/c2_w1_bl
+ u_t001_013/c2_w1_br u_t001_013/c2_r0_rbl u_t001_013/c2_r1_rbl u_t001_013/c3_w0_bl u_t001_013/c3_w0_br
+ u_t001_013/c3_w1_bl u_t001_013/c3_w1_br u_t001_013/c3_r0_rbl u_t001_013/c3_r1_rbl u_t001_013/r0_w0_wl
+ u_t001_013/r0_w1_wl u_t001_013/r0_r0_rwl u_t001_013/r0_r1_rwl u_t001_013/r1_w0_wl u_t001_013/r1_w1_wl
+ u_t001_013/r1_r0_rwl u_t001_013/r1_r1_rwl u_t001_013/r2_w0_wl u_t001_013/r2_w1_wl u_t001_013/r2_r0_rwl
+ u_t001_013/r2_r1_rwl u_t001_013/r3_w0_wl u_t001_013/r3_w1_wl u_t001_013/r3_r0_rwl u_t001_013/r3_r1_rwl VDD VSS VSUBS
+ detronyx_12t_2w2r_rc4_4x4_routed_5layer_direct
Xu_t001_002 u_t001_002/c0_w0_bl u_t001_002/c0_w0_br u_t001_002/c0_w1_bl u_t001_002/c0_w1_br u_t001_002/c0_r0_rbl
+ u_t001_002/c0_r1_rbl u_t001_002/c1_w0_bl u_t001_002/c1_w0_br u_t001_002/c1_w1_bl u_t001_002/c1_w1_br
+ u_t001_002/c1_r0_rbl u_t001_002/c1_r1_rbl u_t001_002/c2_w0_bl u_t001_002/c2_w0_br u_t001_002/c2_w1_bl
+ u_t001_002/c2_w1_br u_t001_002/c2_r0_rbl u_t001_002/c2_r1_rbl u_t001_002/c3_w0_bl u_t001_002/c3_w0_br
+ u_t001_002/c3_w1_bl u_t001_002/c3_w1_br u_t001_002/c3_r0_rbl u_t001_002/c3_r1_rbl u_t001_002/r0_w0_wl
+ u_t001_002/r0_w1_wl u_t001_002/r0_r0_rwl u_t001_002/r0_r1_rwl u_t001_002/r1_w0_wl u_t001_002/r1_w1_wl
+ u_t001_002/r1_r0_rwl u_t001_002/r1_r1_rwl u_t001_002/r2_w0_wl u_t001_002/r2_w1_wl u_t001_002/r2_r0_rwl
+ u_t001_002/r2_r1_rwl u_t001_002/r3_w0_wl u_t001_002/r3_w1_wl u_t001_002/r3_r0_rwl u_t001_002/r3_r1_rwl VDD VSS VSUBS
+ detronyx_12t_2w2r_rc4_4x4_routed_5layer_direct
Xu_t029_005 u_t029_005/c0_w0_bl u_t029_005/c0_w0_br u_t029_005/c0_w1_bl u_t029_005/c0_w1_br u_t029_005/c0_r0_rbl
+ u_t029_005/c0_r1_rbl u_t029_005/c1_w0_bl u_t029_005/c1_w0_br u_t029_005/c1_w1_bl u_t029_005/c1_w1_br
+ u_t029_005/c1_r0_rbl u_t029_005/c1_r1_rbl u_t029_005/c2_w0_bl u_t029_005/c2_w0_br u_t029_005/c2_w1_bl
+ u_t029_005/c2_w1_br u_t029_005/c2_r0_rbl u_t029_005/c2_r1_rbl u_t029_005/c3_w0_bl u_t029_005/c3_w0_br
+ u_t029_005/c3_w1_bl u_t029_005/c3_w1_br u_t029_005/c3_r0_rbl u_t029_005/c3_r1_rbl u_t029_005/r0_w0_wl
+ u_t029_005/r0_w1_wl u_t029_005/r0_r0_rwl u_t029_005/r0_r1_rwl u_t029_005/r1_w0_wl u_t029_005/r1_w1_wl
+ u_t029_005/r1_r0_rwl u_t029_005/r1_r1_rwl u_t029_005/r2_w0_wl u_t029_005/r2_w1_wl u_t029_005/r2_r0_rwl
+ u_t029_005/r2_r1_rwl u_t029_005/r3_w0_wl u_t029_005/r3_w1_wl u_t029_005/r3_r0_rwl u_t029_005/r3_r1_rwl VDD VSS VSUBS
+ detronyx_12t_2w2r_rc4_4x4_routed_5layer_direct
Xu_t026_008 u_t026_008/c0_w0_bl u_t026_008/c0_w0_br u_t026_008/c0_w1_bl u_t026_008/c0_w1_br u_t026_008/c0_r0_rbl
+ u_t026_008/c0_r1_rbl u_t026_008/c1_w0_bl u_t026_008/c1_w0_br u_t026_008/c1_w1_bl u_t026_008/c1_w1_br
+ u_t026_008/c1_r0_rbl u_t026_008/c1_r1_rbl u_t026_008/c2_w0_bl u_t026_008/c2_w0_br u_t026_008/c2_w1_bl
+ u_t026_008/c2_w1_br u_t026_008/c2_r0_rbl u_t026_008/c2_r1_rbl u_t026_008/c3_w0_bl u_t026_008/c3_w0_br
+ u_t026_008/c3_w1_bl u_t026_008/c3_w1_br u_t026_008/c3_r0_rbl u_t026_008/c3_r1_rbl u_t026_008/r0_w0_wl
+ u_t026_008/r0_w1_wl u_t026_008/r0_r0_rwl u_t026_008/r0_r1_rwl u_t026_008/r1_w0_wl u_t026_008/r1_w1_wl
+ u_t026_008/r1_r0_rwl u_t026_008/r1_r1_rwl u_t026_008/r2_w0_wl u_t026_008/r2_w1_wl u_t026_008/r2_r0_rwl
+ u_t026_008/r2_r1_rwl u_t026_008/r3_w0_wl u_t026_008/r3_w1_wl u_t026_008/r3_r0_rwl u_t026_008/r3_r1_rwl VDD VSS VSUBS
+ detronyx_12t_2w2r_rc4_4x4_routed_5layer_direct
Xu_t008_008 u_t008_008/c0_w0_bl u_t008_008/c0_w0_br u_t008_008/c0_w1_bl u_t008_008/c0_w1_br u_t008_008/c0_r0_rbl
+ u_t008_008/c0_r1_rbl u_t008_008/c1_w0_bl u_t008_008/c1_w0_br u_t008_008/c1_w1_bl u_t008_008/c1_w1_br
+ u_t008_008/c1_r0_rbl u_t008_008/c1_r1_rbl u_t008_008/c2_w0_bl u_t008_008/c2_w0_br u_t008_008/c2_w1_bl
+ u_t008_008/c2_w1_br u_t008_008/c2_r0_rbl u_t008_008/c2_r1_rbl u_t008_008/c3_w0_bl u_t008_008/c3_w0_br
+ u_t008_008/c3_w1_bl u_t008_008/c3_w1_br u_t008_008/c3_r0_rbl u_t008_008/c3_r1_rbl u_t008_008/r0_w0_wl
+ u_t008_008/r0_w1_wl u_t008_008/r0_r0_rwl u_t008_008/r0_r1_rwl u_t008_008/r1_w0_wl u_t008_008/r1_w1_wl
+ u_t008_008/r1_r0_rwl u_t008_008/r1_r1_rwl u_t008_008/r2_w0_wl u_t008_008/r2_w1_wl u_t008_008/r2_r0_rwl
+ u_t008_008/r2_r1_rwl u_t008_008/r3_w0_wl u_t008_008/r3_w1_wl u_t008_008/r3_r0_rwl u_t008_008/r3_r1_rwl VDD VSS VSUBS
+ detronyx_12t_2w2r_rc4_4x4_routed_5layer_direct
Xu_t017_008 u_t017_008/c0_w0_bl u_t017_008/c0_w0_br u_t017_008/c0_w1_bl u_t017_008/c0_w1_br u_t017_008/c0_r0_rbl
+ u_t017_008/c0_r1_rbl u_t017_008/c1_w0_bl u_t017_008/c1_w0_br u_t017_008/c1_w1_bl u_t017_008/c1_w1_br
+ u_t017_008/c1_r0_rbl u_t017_008/c1_r1_rbl u_t017_008/c2_w0_bl u_t017_008/c2_w0_br u_t017_008/c2_w1_bl
+ u_t017_008/c2_w1_br u_t017_008/c2_r0_rbl u_t017_008/c2_r1_rbl u_t017_008/c3_w0_bl u_t017_008/c3_w0_br
+ u_t017_008/c3_w1_bl u_t017_008/c3_w1_br u_t017_008/c3_r0_rbl u_t017_008/c3_r1_rbl u_t017_008/r0_w0_wl
+ u_t017_008/r0_w1_wl u_t017_008/r0_r0_rwl u_t017_008/r0_r1_rwl u_t017_008/r1_w0_wl u_t017_008/r1_w1_wl
+ u_t017_008/r1_r0_rwl u_t017_008/r1_r1_rwl u_t017_008/r2_w0_wl u_t017_008/r2_w1_wl u_t017_008/r2_r0_rwl
+ u_t017_008/r2_r1_rwl u_t017_008/r3_w0_wl u_t017_008/r3_w1_wl u_t017_008/r3_r0_rwl u_t017_008/r3_r1_rwl VDD VSS VSUBS
+ detronyx_12t_2w2r_rc4_4x4_routed_5layer_direct
Xu_t031_011 u_t031_011/c0_w0_bl u_t031_011/c0_w0_br u_t031_011/c0_w1_bl u_t031_011/c0_w1_br u_t031_011/c0_r0_rbl
+ u_t031_011/c0_r1_rbl u_t031_011/c1_w0_bl u_t031_011/c1_w0_br u_t031_011/c1_w1_bl u_t031_011/c1_w1_br
+ u_t031_011/c1_r0_rbl u_t031_011/c1_r1_rbl u_t031_011/c2_w0_bl u_t031_011/c2_w0_br u_t031_011/c2_w1_bl
+ u_t031_011/c2_w1_br u_t031_011/c2_r0_rbl u_t031_011/c2_r1_rbl u_t031_011/c3_w0_bl u_t031_011/c3_w0_br
+ u_t031_011/c3_w1_bl u_t031_011/c3_w1_br u_t031_011/c3_r0_rbl u_t031_011/c3_r1_rbl u_t031_011/r0_w0_wl
+ u_t031_011/r0_w1_wl u_t031_011/r0_r0_rwl u_t031_011/r0_r1_rwl u_t031_011/r1_w0_wl u_t031_011/r1_w1_wl
+ u_t031_011/r1_r0_rwl u_t031_011/r1_r1_rwl u_t031_011/r2_w0_wl u_t031_011/r2_w1_wl u_t031_011/r2_r0_rwl
+ u_t031_011/r2_r1_rwl u_t031_011/r3_w0_wl u_t031_011/r3_w1_wl u_t031_011/r3_r0_rwl u_t031_011/r3_r1_rwl VDD VSS VSUBS
+ detronyx_12t_2w2r_rc4_4x4_routed_5layer_direct
Xu_t031_000 u_t031_000/c0_w0_bl u_t031_000/c0_w0_br u_t031_000/c0_w1_bl u_t031_000/c0_w1_br u_t031_000/c0_r0_rbl
+ u_t031_000/c0_r1_rbl u_t031_000/c1_w0_bl u_t031_000/c1_w0_br u_t031_000/c1_w1_bl u_t031_000/c1_w1_br
+ u_t031_000/c1_r0_rbl u_t031_000/c1_r1_rbl u_t031_000/c2_w0_bl u_t031_000/c2_w0_br u_t031_000/c2_w1_bl
+ u_t031_000/c2_w1_br u_t031_000/c2_r0_rbl u_t031_000/c2_r1_rbl u_t031_000/c3_w0_bl u_t031_000/c3_w0_br
+ u_t031_000/c3_w1_bl u_t031_000/c3_w1_br u_t031_000/c3_r0_rbl u_t031_000/c3_r1_rbl u_t031_000/r0_w0_wl
+ u_t031_000/r0_w1_wl u_t031_000/r0_r0_rwl u_t031_000/r0_r1_rwl u_t031_000/r1_w0_wl u_t031_000/r1_w1_wl
+ u_t031_000/r1_r0_rwl u_t031_000/r1_r1_rwl u_t031_000/r2_w0_wl u_t031_000/r2_w1_wl u_t031_000/r2_r0_rwl
+ u_t031_000/r2_r1_rwl u_t031_000/r3_w0_wl u_t031_000/r3_w1_wl u_t031_000/r3_r0_rwl u_t031_000/r3_r1_rwl VDD VSS VSUBS
+ detronyx_12t_2w2r_rc4_4x4_routed_5layer_direct
Xu_t013_000 u_t013_000/c0_w0_bl u_t013_000/c0_w0_br u_t013_000/c0_w1_bl u_t013_000/c0_w1_br u_t013_000/c0_r0_rbl
+ u_t013_000/c0_r1_rbl u_t013_000/c1_w0_bl u_t013_000/c1_w0_br u_t013_000/c1_w1_bl u_t013_000/c1_w1_br
+ u_t013_000/c1_r0_rbl u_t013_000/c1_r1_rbl u_t013_000/c2_w0_bl u_t013_000/c2_w0_br u_t013_000/c2_w1_bl
+ u_t013_000/c2_w1_br u_t013_000/c2_r0_rbl u_t013_000/c2_r1_rbl u_t013_000/c3_w0_bl u_t013_000/c3_w0_br
+ u_t013_000/c3_w1_bl u_t013_000/c3_w1_br u_t013_000/c3_r0_rbl u_t013_000/c3_r1_rbl u_t013_000/r0_w0_wl
+ u_t013_000/r0_w1_wl u_t013_000/r0_r0_rwl u_t013_000/r0_r1_rwl u_t013_000/r1_w0_wl u_t013_000/r1_w1_wl
+ u_t013_000/r1_r0_rwl u_t013_000/r1_r1_rwl u_t013_000/r2_w0_wl u_t013_000/r2_w1_wl u_t013_000/r2_r0_rwl
+ u_t013_000/r2_r1_rwl u_t013_000/r3_w0_wl u_t013_000/r3_w1_wl u_t013_000/r3_r0_rwl u_t013_000/r3_r1_rwl VDD VSS VSUBS
+ detronyx_12t_2w2r_rc4_4x4_routed_5layer_direct
Xu_t013_011 u_t013_011/c0_w0_bl u_t013_011/c0_w0_br u_t013_011/c0_w1_bl u_t013_011/c0_w1_br u_t013_011/c0_r0_rbl
+ u_t013_011/c0_r1_rbl u_t013_011/c1_w0_bl u_t013_011/c1_w0_br u_t013_011/c1_w1_bl u_t013_011/c1_w1_br
+ u_t013_011/c1_r0_rbl u_t013_011/c1_r1_rbl u_t013_011/c2_w0_bl u_t013_011/c2_w0_br u_t013_011/c2_w1_bl
+ u_t013_011/c2_w1_br u_t013_011/c2_r0_rbl u_t013_011/c2_r1_rbl u_t013_011/c3_w0_bl u_t013_011/c3_w0_br
+ u_t013_011/c3_w1_bl u_t013_011/c3_w1_br u_t013_011/c3_r0_rbl u_t013_011/c3_r1_rbl u_t013_011/r0_w0_wl
+ u_t013_011/r0_w1_wl u_t013_011/r0_r0_rwl u_t013_011/r0_r1_rwl u_t013_011/r1_w0_wl u_t013_011/r1_w1_wl
+ u_t013_011/r1_r0_rwl u_t013_011/r1_r1_rwl u_t013_011/r2_w0_wl u_t013_011/r2_w1_wl u_t013_011/r2_r0_rwl
+ u_t013_011/r2_r1_rwl u_t013_011/r3_w0_wl u_t013_011/r3_w1_wl u_t013_011/r3_r0_rwl u_t013_011/r3_r1_rwl VDD VSS VSUBS
+ detronyx_12t_2w2r_rc4_4x4_routed_5layer_direct
Xu_t022_000 u_t022_000/c0_w0_bl u_t022_000/c0_w0_br u_t022_000/c0_w1_bl u_t022_000/c0_w1_br u_t022_000/c0_r0_rbl
+ u_t022_000/c0_r1_rbl u_t022_000/c1_w0_bl u_t022_000/c1_w0_br u_t022_000/c1_w1_bl u_t022_000/c1_w1_br
+ u_t022_000/c1_r0_rbl u_t022_000/c1_r1_rbl u_t022_000/c2_w0_bl u_t022_000/c2_w0_br u_t022_000/c2_w1_bl
+ u_t022_000/c2_w1_br u_t022_000/c2_r0_rbl u_t022_000/c2_r1_rbl u_t022_000/c3_w0_bl u_t022_000/c3_w0_br
+ u_t022_000/c3_w1_bl u_t022_000/c3_w1_br u_t022_000/c3_r0_rbl u_t022_000/c3_r1_rbl u_t022_000/r0_w0_wl
+ u_t022_000/r0_w1_wl u_t022_000/r0_r0_rwl u_t022_000/r0_r1_rwl u_t022_000/r1_w0_wl u_t022_000/r1_w1_wl
+ u_t022_000/r1_r0_rwl u_t022_000/r1_r1_rwl u_t022_000/r2_w0_wl u_t022_000/r2_w1_wl u_t022_000/r2_r0_rwl
+ u_t022_000/r2_r1_rwl u_t022_000/r3_w0_wl u_t022_000/r3_w1_wl u_t022_000/r3_r0_rwl u_t022_000/r3_r1_rwl VDD VSS VSUBS
+ detronyx_12t_2w2r_rc4_4x4_routed_5layer_direct
Xu_t022_011 u_t022_011/c0_w0_bl u_t022_011/c0_w0_br u_t022_011/c0_w1_bl u_t022_011/c0_w1_br u_t022_011/c0_r0_rbl
+ u_t022_011/c0_r1_rbl u_t022_011/c1_w0_bl u_t022_011/c1_w0_br u_t022_011/c1_w1_bl u_t022_011/c1_w1_br
+ u_t022_011/c1_r0_rbl u_t022_011/c1_r1_rbl u_t022_011/c2_w0_bl u_t022_011/c2_w0_br u_t022_011/c2_w1_bl
+ u_t022_011/c2_w1_br u_t022_011/c2_r0_rbl u_t022_011/c2_r1_rbl u_t022_011/c3_w0_bl u_t022_011/c3_w0_br
+ u_t022_011/c3_w1_bl u_t022_011/c3_w1_br u_t022_011/c3_r0_rbl u_t022_011/c3_r1_rbl u_t022_011/r0_w0_wl
+ u_t022_011/r0_w1_wl u_t022_011/r0_r0_rwl u_t022_011/r0_r1_rwl u_t022_011/r1_w0_wl u_t022_011/r1_w1_wl
+ u_t022_011/r1_r0_rwl u_t022_011/r1_r1_rwl u_t022_011/r2_w0_wl u_t022_011/r2_w1_wl u_t022_011/r2_r0_rwl
+ u_t022_011/r2_r1_rwl u_t022_011/r3_w0_wl u_t022_011/r3_w1_wl u_t022_011/r3_r0_rwl u_t022_011/r3_r1_rwl VDD VSS VSUBS
+ detronyx_12t_2w2r_rc4_4x4_routed_5layer_direct
Xu_t004_011 u_t004_011/c0_w0_bl u_t004_011/c0_w0_br u_t004_011/c0_w1_bl u_t004_011/c0_w1_br u_t004_011/c0_r0_rbl
+ u_t004_011/c0_r1_rbl u_t004_011/c1_w0_bl u_t004_011/c1_w0_br u_t004_011/c1_w1_bl u_t004_011/c1_w1_br
+ u_t004_011/c1_r0_rbl u_t004_011/c1_r1_rbl u_t004_011/c2_w0_bl u_t004_011/c2_w0_br u_t004_011/c2_w1_bl
+ u_t004_011/c2_w1_br u_t004_011/c2_r0_rbl u_t004_011/c2_r1_rbl u_t004_011/c3_w0_bl u_t004_011/c3_w0_br
+ u_t004_011/c3_w1_bl u_t004_011/c3_w1_br u_t004_011/c3_r0_rbl u_t004_011/c3_r1_rbl u_t004_011/r0_w0_wl
+ u_t004_011/r0_w1_wl u_t004_011/r0_r0_rwl u_t004_011/r0_r1_rwl u_t004_011/r1_w0_wl u_t004_011/r1_w1_wl
+ u_t004_011/r1_r0_rwl u_t004_011/r1_r1_rwl u_t004_011/r2_w0_wl u_t004_011/r2_w1_wl u_t004_011/r2_r0_rwl
+ u_t004_011/r2_r1_rwl u_t004_011/r3_w0_wl u_t004_011/r3_w1_wl u_t004_011/r3_r0_rwl u_t004_011/r3_r1_rwl VDD VSS VSUBS
+ detronyx_12t_2w2r_rc4_4x4_routed_5layer_direct
Xu_t004_000 u_t004_000/c0_w0_bl u_t004_000/c0_w0_br u_t004_000/c0_w1_bl u_t004_000/c0_w1_br u_t004_000/c0_r0_rbl
+ u_t004_000/c0_r1_rbl u_t004_000/c1_w0_bl u_t004_000/c1_w0_br u_t004_000/c1_w1_bl u_t004_000/c1_w1_br
+ u_t004_000/c1_r0_rbl u_t004_000/c1_r1_rbl u_t004_000/c2_w0_bl u_t004_000/c2_w0_br u_t004_000/c2_w1_bl
+ u_t004_000/c2_w1_br u_t004_000/c2_r0_rbl u_t004_000/c2_r1_rbl u_t004_000/c3_w0_bl u_t004_000/c3_w0_br
+ u_t004_000/c3_w1_bl u_t004_000/c3_w1_br u_t004_000/c3_r0_rbl u_t004_000/c3_r1_rbl u_t004_000/r0_w0_wl
+ u_t004_000/r0_w1_wl u_t004_000/r0_r0_rwl u_t004_000/r0_r1_rwl u_t004_000/r1_w0_wl u_t004_000/r1_w1_wl
+ u_t004_000/r1_r0_rwl u_t004_000/r1_r1_rwl u_t004_000/r2_w0_wl u_t004_000/r2_w1_wl u_t004_000/r2_r0_rwl
+ u_t004_000/r2_r1_rwl u_t004_000/r3_w0_wl u_t004_000/r3_w1_wl u_t004_000/r3_r0_rwl u_t004_000/r3_r1_rwl VDD VSS VSUBS
+ detronyx_12t_2w2r_rc4_4x4_routed_5layer_direct
Xu_t010_003 u_t010_003/c0_w0_bl u_t010_003/c0_w0_br u_t010_003/c0_w1_bl u_t010_003/c0_w1_br u_t010_003/c0_r0_rbl
+ u_t010_003/c0_r1_rbl u_t010_003/c1_w0_bl u_t010_003/c1_w0_br u_t010_003/c1_w1_bl u_t010_003/c1_w1_br
+ u_t010_003/c1_r0_rbl u_t010_003/c1_r1_rbl u_t010_003/c2_w0_bl u_t010_003/c2_w0_br u_t010_003/c2_w1_bl
+ u_t010_003/c2_w1_br u_t010_003/c2_r0_rbl u_t010_003/c2_r1_rbl u_t010_003/c3_w0_bl u_t010_003/c3_w0_br
+ u_t010_003/c3_w1_bl u_t010_003/c3_w1_br u_t010_003/c3_r0_rbl u_t010_003/c3_r1_rbl u_t010_003/r0_w0_wl
+ u_t010_003/r0_w1_wl u_t010_003/r0_r0_rwl u_t010_003/r0_r1_rwl u_t010_003/r1_w0_wl u_t010_003/r1_w1_wl
+ u_t010_003/r1_r0_rwl u_t010_003/r1_r1_rwl u_t010_003/r2_w0_wl u_t010_003/r2_w1_wl u_t010_003/r2_r0_rwl
+ u_t010_003/r2_r1_rwl u_t010_003/r3_w0_wl u_t010_003/r3_w1_wl u_t010_003/r3_r0_rwl u_t010_003/r3_r1_rwl VDD VSS VSUBS
+ detronyx_12t_2w2r_rc4_4x4_routed_5layer_direct
Xu_t010_014 u_t010_014/c0_w0_bl u_t010_014/c0_w0_br u_t010_014/c0_w1_bl u_t010_014/c0_w1_br u_t010_014/c0_r0_rbl
+ u_t010_014/c0_r1_rbl u_t010_014/c1_w0_bl u_t010_014/c1_w0_br u_t010_014/c1_w1_bl u_t010_014/c1_w1_br
+ u_t010_014/c1_r0_rbl u_t010_014/c1_r1_rbl u_t010_014/c2_w0_bl u_t010_014/c2_w0_br u_t010_014/c2_w1_bl
+ u_t010_014/c2_w1_br u_t010_014/c2_r0_rbl u_t010_014/c2_r1_rbl u_t010_014/c3_w0_bl u_t010_014/c3_w0_br
+ u_t010_014/c3_w1_bl u_t010_014/c3_w1_br u_t010_014/c3_r0_rbl u_t010_014/c3_r1_rbl u_t010_014/r0_w0_wl
+ u_t010_014/r0_w1_wl u_t010_014/r0_r0_rwl u_t010_014/r0_r1_rwl u_t010_014/r1_w0_wl u_t010_014/r1_w1_wl
+ u_t010_014/r1_r0_rwl u_t010_014/r1_r1_rwl u_t010_014/r2_w0_wl u_t010_014/r2_w1_wl u_t010_014/r2_r0_rwl
+ u_t010_014/r2_r1_rwl u_t010_014/r3_w0_wl u_t010_014/r3_w1_wl u_t010_014/r3_r0_rwl u_t010_014/r3_r1_rwl VDD VSS VSUBS
+ detronyx_12t_2w2r_rc4_4x4_routed_5layer_direct
Xu_t001_014 u_t001_014/c0_w0_bl u_t001_014/c0_w0_br u_t001_014/c0_w1_bl u_t001_014/c0_w1_br u_t001_014/c0_r0_rbl
+ u_t001_014/c0_r1_rbl u_t001_014/c1_w0_bl u_t001_014/c1_w0_br u_t001_014/c1_w1_bl u_t001_014/c1_w1_br
+ u_t001_014/c1_r0_rbl u_t001_014/c1_r1_rbl u_t001_014/c2_w0_bl u_t001_014/c2_w0_br u_t001_014/c2_w1_bl
+ u_t001_014/c2_w1_br u_t001_014/c2_r0_rbl u_t001_014/c2_r1_rbl u_t001_014/c3_w0_bl u_t001_014/c3_w0_br
+ u_t001_014/c3_w1_bl u_t001_014/c3_w1_br u_t001_014/c3_r0_rbl u_t001_014/c3_r1_rbl u_t001_014/r0_w0_wl
+ u_t001_014/r0_w1_wl u_t001_014/r0_r0_rwl u_t001_014/r0_r1_rwl u_t001_014/r1_w0_wl u_t001_014/r1_w1_wl
+ u_t001_014/r1_r0_rwl u_t001_014/r1_r1_rwl u_t001_014/r2_w0_wl u_t001_014/r2_w1_wl u_t001_014/r2_r0_rwl
+ u_t001_014/r2_r1_rwl u_t001_014/r3_w0_wl u_t001_014/r3_w1_wl u_t001_014/r3_r0_rwl u_t001_014/r3_r1_rwl VDD VSS VSUBS
+ detronyx_12t_2w2r_rc4_4x4_routed_5layer_direct
Xu_t001_003 u_t001_003/c0_w0_bl u_t001_003/c0_w0_br u_t001_003/c0_w1_bl u_t001_003/c0_w1_br u_t001_003/c0_r0_rbl
+ u_t001_003/c0_r1_rbl u_t001_003/c1_w0_bl u_t001_003/c1_w0_br u_t001_003/c1_w1_bl u_t001_003/c1_w1_br
+ u_t001_003/c1_r0_rbl u_t001_003/c1_r1_rbl u_t001_003/c2_w0_bl u_t001_003/c2_w0_br u_t001_003/c2_w1_bl
+ u_t001_003/c2_w1_br u_t001_003/c2_r0_rbl u_t001_003/c2_r1_rbl u_t001_003/c3_w0_bl u_t001_003/c3_w0_br
+ u_t001_003/c3_w1_bl u_t001_003/c3_w1_br u_t001_003/c3_r0_rbl u_t001_003/c3_r1_rbl u_t001_003/r0_w0_wl
+ u_t001_003/r0_w1_wl u_t001_003/r0_r0_rwl u_t001_003/r0_r1_rwl u_t001_003/r1_w0_wl u_t001_003/r1_w1_wl
+ u_t001_003/r1_r0_rwl u_t001_003/r1_r1_rwl u_t001_003/r2_w0_wl u_t001_003/r2_w1_wl u_t001_003/r2_r0_rwl
+ u_t001_003/r2_r1_rwl u_t001_003/r3_w0_wl u_t001_003/r3_w1_wl u_t001_003/r3_r0_rwl u_t001_003/r3_r1_rwl VDD VSS VSUBS
+ detronyx_12t_2w2r_rc4_4x4_routed_5layer_direct
Xu_t029_006 u_t029_006/c0_w0_bl u_t029_006/c0_w0_br u_t029_006/c0_w1_bl u_t029_006/c0_w1_br u_t029_006/c0_r0_rbl
+ u_t029_006/c0_r1_rbl u_t029_006/c1_w0_bl u_t029_006/c1_w0_br u_t029_006/c1_w1_bl u_t029_006/c1_w1_br
+ u_t029_006/c1_r0_rbl u_t029_006/c1_r1_rbl u_t029_006/c2_w0_bl u_t029_006/c2_w0_br u_t029_006/c2_w1_bl
+ u_t029_006/c2_w1_br u_t029_006/c2_r0_rbl u_t029_006/c2_r1_rbl u_t029_006/c3_w0_bl u_t029_006/c3_w0_br
+ u_t029_006/c3_w1_bl u_t029_006/c3_w1_br u_t029_006/c3_r0_rbl u_t029_006/c3_r1_rbl u_t029_006/r0_w0_wl
+ u_t029_006/r0_w1_wl u_t029_006/r0_r0_rwl u_t029_006/r0_r1_rwl u_t029_006/r1_w0_wl u_t029_006/r1_w1_wl
+ u_t029_006/r1_r0_rwl u_t029_006/r1_r1_rwl u_t029_006/r2_w0_wl u_t029_006/r2_w1_wl u_t029_006/r2_r0_rwl
+ u_t029_006/r2_r1_rwl u_t029_006/r3_w0_wl u_t029_006/r3_w1_wl u_t029_006/r3_r0_rwl u_t029_006/r3_r1_rwl VDD VSS VSUBS
+ detronyx_12t_2w2r_rc4_4x4_routed_5layer_direct
Xu_t026_009 u_t026_009/c0_w0_bl u_t026_009/c0_w0_br u_t026_009/c0_w1_bl u_t026_009/c0_w1_br u_t026_009/c0_r0_rbl
+ u_t026_009/c0_r1_rbl u_t026_009/c1_w0_bl u_t026_009/c1_w0_br u_t026_009/c1_w1_bl u_t026_009/c1_w1_br
+ u_t026_009/c1_r0_rbl u_t026_009/c1_r1_rbl u_t026_009/c2_w0_bl u_t026_009/c2_w0_br u_t026_009/c2_w1_bl
+ u_t026_009/c2_w1_br u_t026_009/c2_r0_rbl u_t026_009/c2_r1_rbl u_t026_009/c3_w0_bl u_t026_009/c3_w0_br
+ u_t026_009/c3_w1_bl u_t026_009/c3_w1_br u_t026_009/c3_r0_rbl u_t026_009/c3_r1_rbl u_t026_009/r0_w0_wl
+ u_t026_009/r0_w1_wl u_t026_009/r0_r0_rwl u_t026_009/r0_r1_rwl u_t026_009/r1_w0_wl u_t026_009/r1_w1_wl
+ u_t026_009/r1_r0_rwl u_t026_009/r1_r1_rwl u_t026_009/r2_w0_wl u_t026_009/r2_w1_wl u_t026_009/r2_r0_rwl
+ u_t026_009/r2_r1_rwl u_t026_009/r3_w0_wl u_t026_009/r3_w1_wl u_t026_009/r3_r0_rwl u_t026_009/r3_r1_rwl VDD VSS VSUBS
+ detronyx_12t_2w2r_rc4_4x4_routed_5layer_direct
Xu_t017_009 u_t017_009/c0_w0_bl u_t017_009/c0_w0_br u_t017_009/c0_w1_bl u_t017_009/c0_w1_br u_t017_009/c0_r0_rbl
+ u_t017_009/c0_r1_rbl u_t017_009/c1_w0_bl u_t017_009/c1_w0_br u_t017_009/c1_w1_bl u_t017_009/c1_w1_br
+ u_t017_009/c1_r0_rbl u_t017_009/c1_r1_rbl u_t017_009/c2_w0_bl u_t017_009/c2_w0_br u_t017_009/c2_w1_bl
+ u_t017_009/c2_w1_br u_t017_009/c2_r0_rbl u_t017_009/c2_r1_rbl u_t017_009/c3_w0_bl u_t017_009/c3_w0_br
+ u_t017_009/c3_w1_bl u_t017_009/c3_w1_br u_t017_009/c3_r0_rbl u_t017_009/c3_r1_rbl u_t017_009/r0_w0_wl
+ u_t017_009/r0_w1_wl u_t017_009/r0_r0_rwl u_t017_009/r0_r1_rwl u_t017_009/r1_w0_wl u_t017_009/r1_w1_wl
+ u_t017_009/r1_r0_rwl u_t017_009/r1_r1_rwl u_t017_009/r2_w0_wl u_t017_009/r2_w1_wl u_t017_009/r2_r0_rwl
+ u_t017_009/r2_r1_rwl u_t017_009/r3_w0_wl u_t017_009/r3_w1_wl u_t017_009/r3_r0_rwl u_t017_009/r3_r1_rwl VDD VSS VSUBS
+ detronyx_12t_2w2r_rc4_4x4_routed_5layer_direct
Xu_t031_012 u_t031_012/c0_w0_bl u_t031_012/c0_w0_br u_t031_012/c0_w1_bl u_t031_012/c0_w1_br u_t031_012/c0_r0_rbl
+ u_t031_012/c0_r1_rbl u_t031_012/c1_w0_bl u_t031_012/c1_w0_br u_t031_012/c1_w1_bl u_t031_012/c1_w1_br
+ u_t031_012/c1_r0_rbl u_t031_012/c1_r1_rbl u_t031_012/c2_w0_bl u_t031_012/c2_w0_br u_t031_012/c2_w1_bl
+ u_t031_012/c2_w1_br u_t031_012/c2_r0_rbl u_t031_012/c2_r1_rbl u_t031_012/c3_w0_bl u_t031_012/c3_w0_br
+ u_t031_012/c3_w1_bl u_t031_012/c3_w1_br u_t031_012/c3_r0_rbl u_t031_012/c3_r1_rbl u_t031_012/r0_w0_wl
+ u_t031_012/r0_w1_wl u_t031_012/r0_r0_rwl u_t031_012/r0_r1_rwl u_t031_012/r1_w0_wl u_t031_012/r1_w1_wl
+ u_t031_012/r1_r0_rwl u_t031_012/r1_r1_rwl u_t031_012/r2_w0_wl u_t031_012/r2_w1_wl u_t031_012/r2_r0_rwl
+ u_t031_012/r2_r1_rwl u_t031_012/r3_w0_wl u_t031_012/r3_w1_wl u_t031_012/r3_r0_rwl u_t031_012/r3_r1_rwl VDD VSS VSUBS
+ detronyx_12t_2w2r_rc4_4x4_routed_5layer_direct
Xu_t031_001 u_t031_001/c0_w0_bl u_t031_001/c0_w0_br u_t031_001/c0_w1_bl u_t031_001/c0_w1_br u_t031_001/c0_r0_rbl
+ u_t031_001/c0_r1_rbl u_t031_001/c1_w0_bl u_t031_001/c1_w0_br u_t031_001/c1_w1_bl u_t031_001/c1_w1_br
+ u_t031_001/c1_r0_rbl u_t031_001/c1_r1_rbl u_t031_001/c2_w0_bl u_t031_001/c2_w0_br u_t031_001/c2_w1_bl
+ u_t031_001/c2_w1_br u_t031_001/c2_r0_rbl u_t031_001/c2_r1_rbl u_t031_001/c3_w0_bl u_t031_001/c3_w0_br
+ u_t031_001/c3_w1_bl u_t031_001/c3_w1_br u_t031_001/c3_r0_rbl u_t031_001/c3_r1_rbl u_t031_001/r0_w0_wl
+ u_t031_001/r0_w1_wl u_t031_001/r0_r0_rwl u_t031_001/r0_r1_rwl u_t031_001/r1_w0_wl u_t031_001/r1_w1_wl
+ u_t031_001/r1_r0_rwl u_t031_001/r1_r1_rwl u_t031_001/r2_w0_wl u_t031_001/r2_w1_wl u_t031_001/r2_r0_rwl
+ u_t031_001/r2_r1_rwl u_t031_001/r3_w0_wl u_t031_001/r3_w1_wl u_t031_001/r3_r0_rwl u_t031_001/r3_r1_rwl VDD VSS VSUBS
+ detronyx_12t_2w2r_rc4_4x4_routed_5layer_direct
Xu_t008_009 u_t008_009/c0_w0_bl u_t008_009/c0_w0_br u_t008_009/c0_w1_bl u_t008_009/c0_w1_br u_t008_009/c0_r0_rbl
+ u_t008_009/c0_r1_rbl u_t008_009/c1_w0_bl u_t008_009/c1_w0_br u_t008_009/c1_w1_bl u_t008_009/c1_w1_br
+ u_t008_009/c1_r0_rbl u_t008_009/c1_r1_rbl u_t008_009/c2_w0_bl u_t008_009/c2_w0_br u_t008_009/c2_w1_bl
+ u_t008_009/c2_w1_br u_t008_009/c2_r0_rbl u_t008_009/c2_r1_rbl u_t008_009/c3_w0_bl u_t008_009/c3_w0_br
+ u_t008_009/c3_w1_bl u_t008_009/c3_w1_br u_t008_009/c3_r0_rbl u_t008_009/c3_r1_rbl u_t008_009/r0_w0_wl
+ u_t008_009/r0_w1_wl u_t008_009/r0_r0_rwl u_t008_009/r0_r1_rwl u_t008_009/r1_w0_wl u_t008_009/r1_w1_wl
+ u_t008_009/r1_r0_rwl u_t008_009/r1_r1_rwl u_t008_009/r2_w0_wl u_t008_009/r2_w1_wl u_t008_009/r2_r0_rwl
+ u_t008_009/r2_r1_rwl u_t008_009/r3_w0_wl u_t008_009/r3_w1_wl u_t008_009/r3_r0_rwl u_t008_009/r3_r1_rwl VDD VSS VSUBS
+ detronyx_12t_2w2r_rc4_4x4_routed_5layer_direct
Xu_t022_001 u_t022_001/c0_w0_bl u_t022_001/c0_w0_br u_t022_001/c0_w1_bl u_t022_001/c0_w1_br u_t022_001/c0_r0_rbl
+ u_t022_001/c0_r1_rbl u_t022_001/c1_w0_bl u_t022_001/c1_w0_br u_t022_001/c1_w1_bl u_t022_001/c1_w1_br
+ u_t022_001/c1_r0_rbl u_t022_001/c1_r1_rbl u_t022_001/c2_w0_bl u_t022_001/c2_w0_br u_t022_001/c2_w1_bl
+ u_t022_001/c2_w1_br u_t022_001/c2_r0_rbl u_t022_001/c2_r1_rbl u_t022_001/c3_w0_bl u_t022_001/c3_w0_br
+ u_t022_001/c3_w1_bl u_t022_001/c3_w1_br u_t022_001/c3_r0_rbl u_t022_001/c3_r1_rbl u_t022_001/r0_w0_wl
+ u_t022_001/r0_w1_wl u_t022_001/r0_r0_rwl u_t022_001/r0_r1_rwl u_t022_001/r1_w0_wl u_t022_001/r1_w1_wl
+ u_t022_001/r1_r0_rwl u_t022_001/r1_r1_rwl u_t022_001/r2_w0_wl u_t022_001/r2_w1_wl u_t022_001/r2_r0_rwl
+ u_t022_001/r2_r1_rwl u_t022_001/r3_w0_wl u_t022_001/r3_w1_wl u_t022_001/r3_r0_rwl u_t022_001/r3_r1_rwl VDD VSS VSUBS
+ detronyx_12t_2w2r_rc4_4x4_routed_5layer_direct
Xu_t022_012 u_t022_012/c0_w0_bl u_t022_012/c0_w0_br u_t022_012/c0_w1_bl u_t022_012/c0_w1_br u_t022_012/c0_r0_rbl
+ u_t022_012/c0_r1_rbl u_t022_012/c1_w0_bl u_t022_012/c1_w0_br u_t022_012/c1_w1_bl u_t022_012/c1_w1_br
+ u_t022_012/c1_r0_rbl u_t022_012/c1_r1_rbl u_t022_012/c2_w0_bl u_t022_012/c2_w0_br u_t022_012/c2_w1_bl
+ u_t022_012/c2_w1_br u_t022_012/c2_r0_rbl u_t022_012/c2_r1_rbl u_t022_012/c3_w0_bl u_t022_012/c3_w0_br
+ u_t022_012/c3_w1_bl u_t022_012/c3_w1_br u_t022_012/c3_r0_rbl u_t022_012/c3_r1_rbl u_t022_012/r0_w0_wl
+ u_t022_012/r0_w1_wl u_t022_012/r0_r0_rwl u_t022_012/r0_r1_rwl u_t022_012/r1_w0_wl u_t022_012/r1_w1_wl
+ u_t022_012/r1_r0_rwl u_t022_012/r1_r1_rwl u_t022_012/r2_w0_wl u_t022_012/r2_w1_wl u_t022_012/r2_r0_rwl
+ u_t022_012/r2_r1_rwl u_t022_012/r3_w0_wl u_t022_012/r3_w1_wl u_t022_012/r3_r0_rwl u_t022_012/r3_r1_rwl VDD VSS VSUBS
+ detronyx_12t_2w2r_rc4_4x4_routed_5layer_direct
Xu_t013_001 u_t013_001/c0_w0_bl u_t013_001/c0_w0_br u_t013_001/c0_w1_bl u_t013_001/c0_w1_br u_t013_001/c0_r0_rbl
+ u_t013_001/c0_r1_rbl u_t013_001/c1_w0_bl u_t013_001/c1_w0_br u_t013_001/c1_w1_bl u_t013_001/c1_w1_br
+ u_t013_001/c1_r0_rbl u_t013_001/c1_r1_rbl u_t013_001/c2_w0_bl u_t013_001/c2_w0_br u_t013_001/c2_w1_bl
+ u_t013_001/c2_w1_br u_t013_001/c2_r0_rbl u_t013_001/c2_r1_rbl u_t013_001/c3_w0_bl u_t013_001/c3_w0_br
+ u_t013_001/c3_w1_bl u_t013_001/c3_w1_br u_t013_001/c3_r0_rbl u_t013_001/c3_r1_rbl u_t013_001/r0_w0_wl
+ u_t013_001/r0_w1_wl u_t013_001/r0_r0_rwl u_t013_001/r0_r1_rwl u_t013_001/r1_w0_wl u_t013_001/r1_w1_wl
+ u_t013_001/r1_r0_rwl u_t013_001/r1_r1_rwl u_t013_001/r2_w0_wl u_t013_001/r2_w1_wl u_t013_001/r2_r0_rwl
+ u_t013_001/r2_r1_rwl u_t013_001/r3_w0_wl u_t013_001/r3_w1_wl u_t013_001/r3_r0_rwl u_t013_001/r3_r1_rwl VDD VSS VSUBS
+ detronyx_12t_2w2r_rc4_4x4_routed_5layer_direct
Xu_t013_012 u_t013_012/c0_w0_bl u_t013_012/c0_w0_br u_t013_012/c0_w1_bl u_t013_012/c0_w1_br u_t013_012/c0_r0_rbl
+ u_t013_012/c0_r1_rbl u_t013_012/c1_w0_bl u_t013_012/c1_w0_br u_t013_012/c1_w1_bl u_t013_012/c1_w1_br
+ u_t013_012/c1_r0_rbl u_t013_012/c1_r1_rbl u_t013_012/c2_w0_bl u_t013_012/c2_w0_br u_t013_012/c2_w1_bl
+ u_t013_012/c2_w1_br u_t013_012/c2_r0_rbl u_t013_012/c2_r1_rbl u_t013_012/c3_w0_bl u_t013_012/c3_w0_br
+ u_t013_012/c3_w1_bl u_t013_012/c3_w1_br u_t013_012/c3_r0_rbl u_t013_012/c3_r1_rbl u_t013_012/r0_w0_wl
+ u_t013_012/r0_w1_wl u_t013_012/r0_r0_rwl u_t013_012/r0_r1_rwl u_t013_012/r1_w0_wl u_t013_012/r1_w1_wl
+ u_t013_012/r1_r0_rwl u_t013_012/r1_r1_rwl u_t013_012/r2_w0_wl u_t013_012/r2_w1_wl u_t013_012/r2_r0_rwl
+ u_t013_012/r2_r1_rwl u_t013_012/r3_w0_wl u_t013_012/r3_w1_wl u_t013_012/r3_r0_rwl u_t013_012/r3_r1_rwl VDD VSS VSUBS
+ detronyx_12t_2w2r_rc4_4x4_routed_5layer_direct
Xu_t004_001 u_t004_001/c0_w0_bl u_t004_001/c0_w0_br u_t004_001/c0_w1_bl u_t004_001/c0_w1_br u_t004_001/c0_r0_rbl
+ u_t004_001/c0_r1_rbl u_t004_001/c1_w0_bl u_t004_001/c1_w0_br u_t004_001/c1_w1_bl u_t004_001/c1_w1_br
+ u_t004_001/c1_r0_rbl u_t004_001/c1_r1_rbl u_t004_001/c2_w0_bl u_t004_001/c2_w0_br u_t004_001/c2_w1_bl
+ u_t004_001/c2_w1_br u_t004_001/c2_r0_rbl u_t004_001/c2_r1_rbl u_t004_001/c3_w0_bl u_t004_001/c3_w0_br
+ u_t004_001/c3_w1_bl u_t004_001/c3_w1_br u_t004_001/c3_r0_rbl u_t004_001/c3_r1_rbl u_t004_001/r0_w0_wl
+ u_t004_001/r0_w1_wl u_t004_001/r0_r0_rwl u_t004_001/r0_r1_rwl u_t004_001/r1_w0_wl u_t004_001/r1_w1_wl
+ u_t004_001/r1_r0_rwl u_t004_001/r1_r1_rwl u_t004_001/r2_w0_wl u_t004_001/r2_w1_wl u_t004_001/r2_r0_rwl
+ u_t004_001/r2_r1_rwl u_t004_001/r3_w0_wl u_t004_001/r3_w1_wl u_t004_001/r3_r0_rwl u_t004_001/r3_r1_rwl VDD VSS VSUBS
+ detronyx_12t_2w2r_rc4_4x4_routed_5layer_direct
Xu_t004_012 u_t004_012/c0_w0_bl u_t004_012/c0_w0_br u_t004_012/c0_w1_bl u_t004_012/c0_w1_br u_t004_012/c0_r0_rbl
+ u_t004_012/c0_r1_rbl u_t004_012/c1_w0_bl u_t004_012/c1_w0_br u_t004_012/c1_w1_bl u_t004_012/c1_w1_br
+ u_t004_012/c1_r0_rbl u_t004_012/c1_r1_rbl u_t004_012/c2_w0_bl u_t004_012/c2_w0_br u_t004_012/c2_w1_bl
+ u_t004_012/c2_w1_br u_t004_012/c2_r0_rbl u_t004_012/c2_r1_rbl u_t004_012/c3_w0_bl u_t004_012/c3_w0_br
+ u_t004_012/c3_w1_bl u_t004_012/c3_w1_br u_t004_012/c3_r0_rbl u_t004_012/c3_r1_rbl u_t004_012/r0_w0_wl
+ u_t004_012/r0_w1_wl u_t004_012/r0_r0_rwl u_t004_012/r0_r1_rwl u_t004_012/r1_w0_wl u_t004_012/r1_w1_wl
+ u_t004_012/r1_r0_rwl u_t004_012/r1_r1_rwl u_t004_012/r2_w0_wl u_t004_012/r2_w1_wl u_t004_012/r2_r0_rwl
+ u_t004_012/r2_r1_rwl u_t004_012/r3_w0_wl u_t004_012/r3_w1_wl u_t004_012/r3_r0_rwl u_t004_012/r3_r1_rwl VDD VSS VSUBS
+ detronyx_12t_2w2r_rc4_4x4_routed_5layer_direct
Xu_t001_015 u_t001_015/c0_w0_bl u_t001_015/c0_w0_br u_t001_015/c0_w1_bl u_t001_015/c0_w1_br u_t001_015/c0_r0_rbl
+ u_t001_015/c0_r1_rbl u_t001_015/c1_w0_bl u_t001_015/c1_w0_br u_t001_015/c1_w1_bl u_t001_015/c1_w1_br
+ u_t001_015/c1_r0_rbl u_t001_015/c1_r1_rbl u_t001_015/c2_w0_bl u_t001_015/c2_w0_br u_t001_015/c2_w1_bl
+ u_t001_015/c2_w1_br u_t001_015/c2_r0_rbl u_t001_015/c2_r1_rbl u_t001_015/c3_w0_bl u_t001_015/c3_w0_br
+ u_t001_015/c3_w1_bl u_t001_015/c3_w1_br u_t001_015/c3_r0_rbl u_t001_015/c3_r1_rbl u_t001_015/r0_w0_wl
+ u_t001_015/r0_w1_wl u_t001_015/r0_r0_rwl u_t001_015/r0_r1_rwl u_t001_015/r1_w0_wl u_t001_015/r1_w1_wl
+ u_t001_015/r1_r0_rwl u_t001_015/r1_r1_rwl u_t001_015/r2_w0_wl u_t001_015/r2_w1_wl u_t001_015/r2_r0_rwl
+ u_t001_015/r2_r1_rwl u_t001_015/r3_w0_wl u_t001_015/r3_w1_wl u_t001_015/r3_r0_rwl u_t001_015/r3_r1_rwl VDD VSS VSUBS
+ detronyx_12t_2w2r_rc4_4x4_routed_5layer_direct
Xu_t001_004 u_t001_004/c0_w0_bl u_t001_004/c0_w0_br u_t001_004/c0_w1_bl u_t001_004/c0_w1_br u_t001_004/c0_r0_rbl
+ u_t001_004/c0_r1_rbl u_t001_004/c1_w0_bl u_t001_004/c1_w0_br u_t001_004/c1_w1_bl u_t001_004/c1_w1_br
+ u_t001_004/c1_r0_rbl u_t001_004/c1_r1_rbl u_t001_004/c2_w0_bl u_t001_004/c2_w0_br u_t001_004/c2_w1_bl
+ u_t001_004/c2_w1_br u_t001_004/c2_r0_rbl u_t001_004/c2_r1_rbl u_t001_004/c3_w0_bl u_t001_004/c3_w0_br
+ u_t001_004/c3_w1_bl u_t001_004/c3_w1_br u_t001_004/c3_r0_rbl u_t001_004/c3_r1_rbl u_t001_004/r0_w0_wl
+ u_t001_004/r0_w1_wl u_t001_004/r0_r0_rwl u_t001_004/r0_r1_rwl u_t001_004/r1_w0_wl u_t001_004/r1_w1_wl
+ u_t001_004/r1_r0_rwl u_t001_004/r1_r1_rwl u_t001_004/r2_w0_wl u_t001_004/r2_w1_wl u_t001_004/r2_r0_rwl
+ u_t001_004/r2_r1_rwl u_t001_004/r3_w0_wl u_t001_004/r3_w1_wl u_t001_004/r3_r0_rwl u_t001_004/r3_r1_rwl VDD VSS VSUBS
+ detronyx_12t_2w2r_rc4_4x4_routed_5layer_direct
Xu_t010_004 u_t010_004/c0_w0_bl u_t010_004/c0_w0_br u_t010_004/c0_w1_bl u_t010_004/c0_w1_br u_t010_004/c0_r0_rbl
+ u_t010_004/c0_r1_rbl u_t010_004/c1_w0_bl u_t010_004/c1_w0_br u_t010_004/c1_w1_bl u_t010_004/c1_w1_br
+ u_t010_004/c1_r0_rbl u_t010_004/c1_r1_rbl u_t010_004/c2_w0_bl u_t010_004/c2_w0_br u_t010_004/c2_w1_bl
+ u_t010_004/c2_w1_br u_t010_004/c2_r0_rbl u_t010_004/c2_r1_rbl u_t010_004/c3_w0_bl u_t010_004/c3_w0_br
+ u_t010_004/c3_w1_bl u_t010_004/c3_w1_br u_t010_004/c3_r0_rbl u_t010_004/c3_r1_rbl u_t010_004/r0_w0_wl
+ u_t010_004/r0_w1_wl u_t010_004/r0_r0_rwl u_t010_004/r0_r1_rwl u_t010_004/r1_w0_wl u_t010_004/r1_w1_wl
+ u_t010_004/r1_r0_rwl u_t010_004/r1_r1_rwl u_t010_004/r2_w0_wl u_t010_004/r2_w1_wl u_t010_004/r2_r0_rwl
+ u_t010_004/r2_r1_rwl u_t010_004/r3_w0_wl u_t010_004/r3_w1_wl u_t010_004/r3_r0_rwl u_t010_004/r3_r1_rwl VDD VSS VSUBS
+ detronyx_12t_2w2r_rc4_4x4_routed_5layer_direct
Xu_t010_015 u_t010_015/c0_w0_bl u_t010_015/c0_w0_br u_t010_015/c0_w1_bl u_t010_015/c0_w1_br u_t010_015/c0_r0_rbl
+ u_t010_015/c0_r1_rbl u_t010_015/c1_w0_bl u_t010_015/c1_w0_br u_t010_015/c1_w1_bl u_t010_015/c1_w1_br
+ u_t010_015/c1_r0_rbl u_t010_015/c1_r1_rbl u_t010_015/c2_w0_bl u_t010_015/c2_w0_br u_t010_015/c2_w1_bl
+ u_t010_015/c2_w1_br u_t010_015/c2_r0_rbl u_t010_015/c2_r1_rbl u_t010_015/c3_w0_bl u_t010_015/c3_w0_br
+ u_t010_015/c3_w1_bl u_t010_015/c3_w1_br u_t010_015/c3_r0_rbl u_t010_015/c3_r1_rbl u_t010_015/r0_w0_wl
+ u_t010_015/r0_w1_wl u_t010_015/r0_r0_rwl u_t010_015/r0_r1_rwl u_t010_015/r1_w0_wl u_t010_015/r1_w1_wl
+ u_t010_015/r1_r0_rwl u_t010_015/r1_r1_rwl u_t010_015/r2_w0_wl u_t010_015/r2_w1_wl u_t010_015/r2_r0_rwl
+ u_t010_015/r2_r1_rwl u_t010_015/r3_w0_wl u_t010_015/r3_w1_wl u_t010_015/r3_r0_rwl u_t010_015/r3_r1_rwl VDD VSS VSUBS
+ detronyx_12t_2w2r_rc4_4x4_routed_5layer_direct
Xu_t029_007 u_t029_007/c0_w0_bl u_t029_007/c0_w0_br u_t029_007/c0_w1_bl u_t029_007/c0_w1_br u_t029_007/c0_r0_rbl
+ u_t029_007/c0_r1_rbl u_t029_007/c1_w0_bl u_t029_007/c1_w0_br u_t029_007/c1_w1_bl u_t029_007/c1_w1_br
+ u_t029_007/c1_r0_rbl u_t029_007/c1_r1_rbl u_t029_007/c2_w0_bl u_t029_007/c2_w0_br u_t029_007/c2_w1_bl
+ u_t029_007/c2_w1_br u_t029_007/c2_r0_rbl u_t029_007/c2_r1_rbl u_t029_007/c3_w0_bl u_t029_007/c3_w0_br
+ u_t029_007/c3_w1_bl u_t029_007/c3_w1_br u_t029_007/c3_r0_rbl u_t029_007/c3_r1_rbl u_t029_007/r0_w0_wl
+ u_t029_007/r0_w1_wl u_t029_007/r0_r0_rwl u_t029_007/r0_r1_rwl u_t029_007/r1_w0_wl u_t029_007/r1_w1_wl
+ u_t029_007/r1_r0_rwl u_t029_007/r1_r1_rwl u_t029_007/r2_w0_wl u_t029_007/r2_w1_wl u_t029_007/r2_r0_rwl
+ u_t029_007/r2_r1_rwl u_t029_007/r3_w0_wl u_t029_007/r3_w1_wl u_t029_007/r3_r0_rwl u_t029_007/r3_r1_rwl VDD VSS VSUBS
+ detronyx_12t_2w2r_rc4_4x4_routed_5layer_direct
Xu_t025_010 u_t025_010/c0_w0_bl u_t025_010/c0_w0_br u_t025_010/c0_w1_bl u_t025_010/c0_w1_br u_t025_010/c0_r0_rbl
+ u_t025_010/c0_r1_rbl u_t025_010/c1_w0_bl u_t025_010/c1_w0_br u_t025_010/c1_w1_bl u_t025_010/c1_w1_br
+ u_t025_010/c1_r0_rbl u_t025_010/c1_r1_rbl u_t025_010/c2_w0_bl u_t025_010/c2_w0_br u_t025_010/c2_w1_bl
+ u_t025_010/c2_w1_br u_t025_010/c2_r0_rbl u_t025_010/c2_r1_rbl u_t025_010/c3_w0_bl u_t025_010/c3_w0_br
+ u_t025_010/c3_w1_bl u_t025_010/c3_w1_br u_t025_010/c3_r0_rbl u_t025_010/c3_r1_rbl u_t025_010/r0_w0_wl
+ u_t025_010/r0_w1_wl u_t025_010/r0_r0_rwl u_t025_010/r0_r1_rwl u_t025_010/r1_w0_wl u_t025_010/r1_w1_wl
+ u_t025_010/r1_r0_rwl u_t025_010/r1_r1_rwl u_t025_010/r2_w0_wl u_t025_010/r2_w1_wl u_t025_010/r2_r0_rwl
+ u_t025_010/r2_r1_rwl u_t025_010/r3_w0_wl u_t025_010/r3_w1_wl u_t025_010/r3_r0_rwl u_t025_010/r3_r1_rwl VDD VSS VSUBS
+ detronyx_12t_2w2r_rc4_4x4_routed_5layer_direct
Xu_t031_013 u_t031_013/c0_w0_bl u_t031_013/c0_w0_br u_t031_013/c0_w1_bl u_t031_013/c0_w1_br u_t031_013/c0_r0_rbl
+ u_t031_013/c0_r1_rbl u_t031_013/c1_w0_bl u_t031_013/c1_w0_br u_t031_013/c1_w1_bl u_t031_013/c1_w1_br
+ u_t031_013/c1_r0_rbl u_t031_013/c1_r1_rbl u_t031_013/c2_w0_bl u_t031_013/c2_w0_br u_t031_013/c2_w1_bl
+ u_t031_013/c2_w1_br u_t031_013/c2_r0_rbl u_t031_013/c2_r1_rbl u_t031_013/c3_w0_bl u_t031_013/c3_w0_br
+ u_t031_013/c3_w1_bl u_t031_013/c3_w1_br u_t031_013/c3_r0_rbl u_t031_013/c3_r1_rbl u_t031_013/r0_w0_wl
+ u_t031_013/r0_w1_wl u_t031_013/r0_r0_rwl u_t031_013/r0_r1_rwl u_t031_013/r1_w0_wl u_t031_013/r1_w1_wl
+ u_t031_013/r1_r0_rwl u_t031_013/r1_r1_rwl u_t031_013/r2_w0_wl u_t031_013/r2_w1_wl u_t031_013/r2_r0_rwl
+ u_t031_013/r2_r1_rwl u_t031_013/r3_w0_wl u_t031_013/r3_w1_wl u_t031_013/r3_r0_rwl u_t031_013/r3_r1_rwl VDD VSS VSUBS
+ detronyx_12t_2w2r_rc4_4x4_routed_5layer_direct
Xu_t031_002 u_t031_002/c0_w0_bl u_t031_002/c0_w0_br u_t031_002/c0_w1_bl u_t031_002/c0_w1_br u_t031_002/c0_r0_rbl
+ u_t031_002/c0_r1_rbl u_t031_002/c1_w0_bl u_t031_002/c1_w0_br u_t031_002/c1_w1_bl u_t031_002/c1_w1_br
+ u_t031_002/c1_r0_rbl u_t031_002/c1_r1_rbl u_t031_002/c2_w0_bl u_t031_002/c2_w0_br u_t031_002/c2_w1_bl
+ u_t031_002/c2_w1_br u_t031_002/c2_r0_rbl u_t031_002/c2_r1_rbl u_t031_002/c3_w0_bl u_t031_002/c3_w0_br
+ u_t031_002/c3_w1_bl u_t031_002/c3_w1_br u_t031_002/c3_r0_rbl u_t031_002/c3_r1_rbl u_t031_002/r0_w0_wl
+ u_t031_002/r0_w1_wl u_t031_002/r0_r0_rwl u_t031_002/r0_r1_rwl u_t031_002/r1_w0_wl u_t031_002/r1_w1_wl
+ u_t031_002/r1_r0_rwl u_t031_002/r1_r1_rwl u_t031_002/r2_w0_wl u_t031_002/r2_w1_wl u_t031_002/r2_r0_rwl
+ u_t031_002/r2_r1_rwl u_t031_002/r3_w0_wl u_t031_002/r3_w1_wl u_t031_002/r3_r0_rwl u_t031_002/r3_r1_rwl VDD VSS VSUBS
+ detronyx_12t_2w2r_rc4_4x4_routed_5layer_direct
Xu_t016_010 u_t016_010/c0_w0_bl u_t016_010/c0_w0_br u_t016_010/c0_w1_bl u_t016_010/c0_w1_br u_t016_010/c0_r0_rbl
+ u_t016_010/c0_r1_rbl u_t016_010/c1_w0_bl u_t016_010/c1_w0_br u_t016_010/c1_w1_bl u_t016_010/c1_w1_br
+ u_t016_010/c1_r0_rbl u_t016_010/c1_r1_rbl u_t016_010/c2_w0_bl u_t016_010/c2_w0_br u_t016_010/c2_w1_bl
+ u_t016_010/c2_w1_br u_t016_010/c2_r0_rbl u_t016_010/c2_r1_rbl u_t016_010/c3_w0_bl u_t016_010/c3_w0_br
+ u_t016_010/c3_w1_bl u_t016_010/c3_w1_br u_t016_010/c3_r0_rbl u_t016_010/c3_r1_rbl u_t016_010/r0_w0_wl
+ u_t016_010/r0_w1_wl u_t016_010/r0_r0_rwl u_t016_010/r0_r1_rwl u_t016_010/r1_w0_wl u_t016_010/r1_w1_wl
+ u_t016_010/r1_r0_rwl u_t016_010/r1_r1_rwl u_t016_010/r2_w0_wl u_t016_010/r2_w1_wl u_t016_010/r2_r0_rwl
+ u_t016_010/r2_r1_rwl u_t016_010/r3_w0_wl u_t016_010/r3_w1_wl u_t016_010/r3_r0_rwl u_t016_010/r3_r1_rwl VDD VSS VSUBS
+ detronyx_12t_2w2r_rc4_4x4_routed_5layer_direct
Xu_t007_010 u_t007_010/c0_w0_bl u_t007_010/c0_w0_br u_t007_010/c0_w1_bl u_t007_010/c0_w1_br u_t007_010/c0_r0_rbl
+ u_t007_010/c0_r1_rbl u_t007_010/c1_w0_bl u_t007_010/c1_w0_br u_t007_010/c1_w1_bl u_t007_010/c1_w1_br
+ u_t007_010/c1_r0_rbl u_t007_010/c1_r1_rbl u_t007_010/c2_w0_bl u_t007_010/c2_w0_br u_t007_010/c2_w1_bl
+ u_t007_010/c2_w1_br u_t007_010/c2_r0_rbl u_t007_010/c2_r1_rbl u_t007_010/c3_w0_bl u_t007_010/c3_w0_br
+ u_t007_010/c3_w1_bl u_t007_010/c3_w1_br u_t007_010/c3_r0_rbl u_t007_010/c3_r1_rbl u_t007_010/r0_w0_wl
+ u_t007_010/r0_w1_wl u_t007_010/r0_r0_rwl u_t007_010/r0_r1_rwl u_t007_010/r1_w0_wl u_t007_010/r1_w1_wl
+ u_t007_010/r1_r0_rwl u_t007_010/r1_r1_rwl u_t007_010/r2_w0_wl u_t007_010/r2_w1_wl u_t007_010/r2_r0_rwl
+ u_t007_010/r2_r1_rwl u_t007_010/r3_w0_wl u_t007_010/r3_w1_wl u_t007_010/r3_r0_rwl u_t007_010/r3_r1_rwl VDD VSS VSUBS
+ detronyx_12t_2w2r_rc4_4x4_routed_5layer_direct
Xu_t022_002 u_t022_002/c0_w0_bl u_t022_002/c0_w0_br u_t022_002/c0_w1_bl u_t022_002/c0_w1_br u_t022_002/c0_r0_rbl
+ u_t022_002/c0_r1_rbl u_t022_002/c1_w0_bl u_t022_002/c1_w0_br u_t022_002/c1_w1_bl u_t022_002/c1_w1_br
+ u_t022_002/c1_r0_rbl u_t022_002/c1_r1_rbl u_t022_002/c2_w0_bl u_t022_002/c2_w0_br u_t022_002/c2_w1_bl
+ u_t022_002/c2_w1_br u_t022_002/c2_r0_rbl u_t022_002/c2_r1_rbl u_t022_002/c3_w0_bl u_t022_002/c3_w0_br
+ u_t022_002/c3_w1_bl u_t022_002/c3_w1_br u_t022_002/c3_r0_rbl u_t022_002/c3_r1_rbl u_t022_002/r0_w0_wl
+ u_t022_002/r0_w1_wl u_t022_002/r0_r0_rwl u_t022_002/r0_r1_rwl u_t022_002/r1_w0_wl u_t022_002/r1_w1_wl
+ u_t022_002/r1_r0_rwl u_t022_002/r1_r1_rwl u_t022_002/r2_w0_wl u_t022_002/r2_w1_wl u_t022_002/r2_r0_rwl
+ u_t022_002/r2_r1_rwl u_t022_002/r3_w0_wl u_t022_002/r3_w1_wl u_t022_002/r3_r0_rwl u_t022_002/r3_r1_rwl VDD VSS VSUBS
+ detronyx_12t_2w2r_rc4_4x4_routed_5layer_direct
Xu_t022_013 u_t022_013/c0_w0_bl u_t022_013/c0_w0_br u_t022_013/c0_w1_bl u_t022_013/c0_w1_br u_t022_013/c0_r0_rbl
+ u_t022_013/c0_r1_rbl u_t022_013/c1_w0_bl u_t022_013/c1_w0_br u_t022_013/c1_w1_bl u_t022_013/c1_w1_br
+ u_t022_013/c1_r0_rbl u_t022_013/c1_r1_rbl u_t022_013/c2_w0_bl u_t022_013/c2_w0_br u_t022_013/c2_w1_bl
+ u_t022_013/c2_w1_br u_t022_013/c2_r0_rbl u_t022_013/c2_r1_rbl u_t022_013/c3_w0_bl u_t022_013/c3_w0_br
+ u_t022_013/c3_w1_bl u_t022_013/c3_w1_br u_t022_013/c3_r0_rbl u_t022_013/c3_r1_rbl u_t022_013/r0_w0_wl
+ u_t022_013/r0_w1_wl u_t022_013/r0_r0_rwl u_t022_013/r0_r1_rwl u_t022_013/r1_w0_wl u_t022_013/r1_w1_wl
+ u_t022_013/r1_r0_rwl u_t022_013/r1_r1_rwl u_t022_013/r2_w0_wl u_t022_013/r2_w1_wl u_t022_013/r2_r0_rwl
+ u_t022_013/r2_r1_rwl u_t022_013/r3_w0_wl u_t022_013/r3_w1_wl u_t022_013/r3_r0_rwl u_t022_013/r3_r1_rwl VDD VSS VSUBS
+ detronyx_12t_2w2r_rc4_4x4_routed_5layer_direct
Xu_t013_002 u_t013_002/c0_w0_bl u_t013_002/c0_w0_br u_t013_002/c0_w1_bl u_t013_002/c0_w1_br u_t013_002/c0_r0_rbl
+ u_t013_002/c0_r1_rbl u_t013_002/c1_w0_bl u_t013_002/c1_w0_br u_t013_002/c1_w1_bl u_t013_002/c1_w1_br
+ u_t013_002/c1_r0_rbl u_t013_002/c1_r1_rbl u_t013_002/c2_w0_bl u_t013_002/c2_w0_br u_t013_002/c2_w1_bl
+ u_t013_002/c2_w1_br u_t013_002/c2_r0_rbl u_t013_002/c2_r1_rbl u_t013_002/c3_w0_bl u_t013_002/c3_w0_br
+ u_t013_002/c3_w1_bl u_t013_002/c3_w1_br u_t013_002/c3_r0_rbl u_t013_002/c3_r1_rbl u_t013_002/r0_w0_wl
+ u_t013_002/r0_w1_wl u_t013_002/r0_r0_rwl u_t013_002/r0_r1_rwl u_t013_002/r1_w0_wl u_t013_002/r1_w1_wl
+ u_t013_002/r1_r0_rwl u_t013_002/r1_r1_rwl u_t013_002/r2_w0_wl u_t013_002/r2_w1_wl u_t013_002/r2_r0_rwl
+ u_t013_002/r2_r1_rwl u_t013_002/r3_w0_wl u_t013_002/r3_w1_wl u_t013_002/r3_r0_rwl u_t013_002/r3_r1_rwl VDD VSS VSUBS
+ detronyx_12t_2w2r_rc4_4x4_routed_5layer_direct
Xu_t013_013 u_t013_013/c0_w0_bl u_t013_013/c0_w0_br u_t013_013/c0_w1_bl u_t013_013/c0_w1_br u_t013_013/c0_r0_rbl
+ u_t013_013/c0_r1_rbl u_t013_013/c1_w0_bl u_t013_013/c1_w0_br u_t013_013/c1_w1_bl u_t013_013/c1_w1_br
+ u_t013_013/c1_r0_rbl u_t013_013/c1_r1_rbl u_t013_013/c2_w0_bl u_t013_013/c2_w0_br u_t013_013/c2_w1_bl
+ u_t013_013/c2_w1_br u_t013_013/c2_r0_rbl u_t013_013/c2_r1_rbl u_t013_013/c3_w0_bl u_t013_013/c3_w0_br
+ u_t013_013/c3_w1_bl u_t013_013/c3_w1_br u_t013_013/c3_r0_rbl u_t013_013/c3_r1_rbl u_t013_013/r0_w0_wl
+ u_t013_013/r0_w1_wl u_t013_013/r0_r0_rwl u_t013_013/r0_r1_rwl u_t013_013/r1_w0_wl u_t013_013/r1_w1_wl
+ u_t013_013/r1_r0_rwl u_t013_013/r1_r1_rwl u_t013_013/r2_w0_wl u_t013_013/r2_w1_wl u_t013_013/r2_r0_rwl
+ u_t013_013/r2_r1_rwl u_t013_013/r3_w0_wl u_t013_013/r3_w1_wl u_t013_013/r3_r0_rwl u_t013_013/r3_r1_rwl VDD VSS VSUBS
+ detronyx_12t_2w2r_rc4_4x4_routed_5layer_direct
Xu_t004_002 u_t004_002/c0_w0_bl u_t004_002/c0_w0_br u_t004_002/c0_w1_bl u_t004_002/c0_w1_br u_t004_002/c0_r0_rbl
+ u_t004_002/c0_r1_rbl u_t004_002/c1_w0_bl u_t004_002/c1_w0_br u_t004_002/c1_w1_bl u_t004_002/c1_w1_br
+ u_t004_002/c1_r0_rbl u_t004_002/c1_r1_rbl u_t004_002/c2_w0_bl u_t004_002/c2_w0_br u_t004_002/c2_w1_bl
+ u_t004_002/c2_w1_br u_t004_002/c2_r0_rbl u_t004_002/c2_r1_rbl u_t004_002/c3_w0_bl u_t004_002/c3_w0_br
+ u_t004_002/c3_w1_bl u_t004_002/c3_w1_br u_t004_002/c3_r0_rbl u_t004_002/c3_r1_rbl u_t004_002/r0_w0_wl
+ u_t004_002/r0_w1_wl u_t004_002/r0_r0_rwl u_t004_002/r0_r1_rwl u_t004_002/r1_w0_wl u_t004_002/r1_w1_wl
+ u_t004_002/r1_r0_rwl u_t004_002/r1_r1_rwl u_t004_002/r2_w0_wl u_t004_002/r2_w1_wl u_t004_002/r2_r0_rwl
+ u_t004_002/r2_r1_rwl u_t004_002/r3_w0_wl u_t004_002/r3_w1_wl u_t004_002/r3_r0_rwl u_t004_002/r3_r1_rwl VDD VSS VSUBS
+ detronyx_12t_2w2r_rc4_4x4_routed_5layer_direct
Xu_t004_013 u_t004_013/c0_w0_bl u_t004_013/c0_w0_br u_t004_013/c0_w1_bl u_t004_013/c0_w1_br u_t004_013/c0_r0_rbl
+ u_t004_013/c0_r1_rbl u_t004_013/c1_w0_bl u_t004_013/c1_w0_br u_t004_013/c1_w1_bl u_t004_013/c1_w1_br
+ u_t004_013/c1_r0_rbl u_t004_013/c1_r1_rbl u_t004_013/c2_w0_bl u_t004_013/c2_w0_br u_t004_013/c2_w1_bl
+ u_t004_013/c2_w1_br u_t004_013/c2_r0_rbl u_t004_013/c2_r1_rbl u_t004_013/c3_w0_bl u_t004_013/c3_w0_br
+ u_t004_013/c3_w1_bl u_t004_013/c3_w1_br u_t004_013/c3_r0_rbl u_t004_013/c3_r1_rbl u_t004_013/r0_w0_wl
+ u_t004_013/r0_w1_wl u_t004_013/r0_r0_rwl u_t004_013/r0_r1_rwl u_t004_013/r1_w0_wl u_t004_013/r1_w1_wl
+ u_t004_013/r1_r0_rwl u_t004_013/r1_r1_rwl u_t004_013/r2_w0_wl u_t004_013/r2_w1_wl u_t004_013/r2_r0_rwl
+ u_t004_013/r2_r1_rwl u_t004_013/r3_w0_wl u_t004_013/r3_w1_wl u_t004_013/r3_r0_rwl u_t004_013/r3_r1_rwl VDD VSS VSUBS
+ detronyx_12t_2w2r_rc4_4x4_routed_5layer_direct
Xu_t010_005 u_t010_005/c0_w0_bl u_t010_005/c0_w0_br u_t010_005/c0_w1_bl u_t010_005/c0_w1_br u_t010_005/c0_r0_rbl
+ u_t010_005/c0_r1_rbl u_t010_005/c1_w0_bl u_t010_005/c1_w0_br u_t010_005/c1_w1_bl u_t010_005/c1_w1_br
+ u_t010_005/c1_r0_rbl u_t010_005/c1_r1_rbl u_t010_005/c2_w0_bl u_t010_005/c2_w0_br u_t010_005/c2_w1_bl
+ u_t010_005/c2_w1_br u_t010_005/c2_r0_rbl u_t010_005/c2_r1_rbl u_t010_005/c3_w0_bl u_t010_005/c3_w0_br
+ u_t010_005/c3_w1_bl u_t010_005/c3_w1_br u_t010_005/c3_r0_rbl u_t010_005/c3_r1_rbl u_t010_005/r0_w0_wl
+ u_t010_005/r0_w1_wl u_t010_005/r0_r0_rwl u_t010_005/r0_r1_rwl u_t010_005/r1_w0_wl u_t010_005/r1_w1_wl
+ u_t010_005/r1_r0_rwl u_t010_005/r1_r1_rwl u_t010_005/r2_w0_wl u_t010_005/r2_w1_wl u_t010_005/r2_r0_rwl
+ u_t010_005/r2_r1_rwl u_t010_005/r3_w0_wl u_t010_005/r3_w1_wl u_t010_005/r3_r0_rwl u_t010_005/r3_r1_rwl VDD VSS VSUBS
+ detronyx_12t_2w2r_rc4_4x4_routed_5layer_direct
Xu_t001_005 u_t001_005/c0_w0_bl u_t001_005/c0_w0_br u_t001_005/c0_w1_bl u_t001_005/c0_w1_br u_t001_005/c0_r0_rbl
+ u_t001_005/c0_r1_rbl u_t001_005/c1_w0_bl u_t001_005/c1_w0_br u_t001_005/c1_w1_bl u_t001_005/c1_w1_br
+ u_t001_005/c1_r0_rbl u_t001_005/c1_r1_rbl u_t001_005/c2_w0_bl u_t001_005/c2_w0_br u_t001_005/c2_w1_bl
+ u_t001_005/c2_w1_br u_t001_005/c2_r0_rbl u_t001_005/c2_r1_rbl u_t001_005/c3_w0_bl u_t001_005/c3_w0_br
+ u_t001_005/c3_w1_bl u_t001_005/c3_w1_br u_t001_005/c3_r0_rbl u_t001_005/c3_r1_rbl u_t001_005/r0_w0_wl
+ u_t001_005/r0_w1_wl u_t001_005/r0_r0_rwl u_t001_005/r0_r1_rwl u_t001_005/r1_w0_wl u_t001_005/r1_w1_wl
+ u_t001_005/r1_r0_rwl u_t001_005/r1_r1_rwl u_t001_005/r2_w0_wl u_t001_005/r2_w1_wl u_t001_005/r2_r0_rwl
+ u_t001_005/r2_r1_rwl u_t001_005/r3_w0_wl u_t001_005/r3_w1_wl u_t001_005/r3_r0_rwl u_t001_005/r3_r1_rwl VDD VSS VSUBS
+ detronyx_12t_2w2r_rc4_4x4_routed_5layer_direct
Xu_t029_008 u_t029_008/c0_w0_bl u_t029_008/c0_w0_br u_t029_008/c0_w1_bl u_t029_008/c0_w1_br u_t029_008/c0_r0_rbl
+ u_t029_008/c0_r1_rbl u_t029_008/c1_w0_bl u_t029_008/c1_w0_br u_t029_008/c1_w1_bl u_t029_008/c1_w1_br
+ u_t029_008/c1_r0_rbl u_t029_008/c1_r1_rbl u_t029_008/c2_w0_bl u_t029_008/c2_w0_br u_t029_008/c2_w1_bl
+ u_t029_008/c2_w1_br u_t029_008/c2_r0_rbl u_t029_008/c2_r1_rbl u_t029_008/c3_w0_bl u_t029_008/c3_w0_br
+ u_t029_008/c3_w1_bl u_t029_008/c3_w1_br u_t029_008/c3_r0_rbl u_t029_008/c3_r1_rbl u_t029_008/r0_w0_wl
+ u_t029_008/r0_w1_wl u_t029_008/r0_r0_rwl u_t029_008/r0_r1_rwl u_t029_008/r1_w0_wl u_t029_008/r1_w1_wl
+ u_t029_008/r1_r0_rwl u_t029_008/r1_r1_rwl u_t029_008/r2_w0_wl u_t029_008/r2_w1_wl u_t029_008/r2_r0_rwl
+ u_t029_008/r2_r1_rwl u_t029_008/r3_w0_wl u_t029_008/r3_w1_wl u_t029_008/r3_r0_rwl u_t029_008/r3_r1_rwl VDD VSS VSUBS
+ detronyx_12t_2w2r_rc4_4x4_routed_5layer_direct
Xu_t025_011 u_t025_011/c0_w0_bl u_t025_011/c0_w0_br u_t025_011/c0_w1_bl u_t025_011/c0_w1_br u_t025_011/c0_r0_rbl
+ u_t025_011/c0_r1_rbl u_t025_011/c1_w0_bl u_t025_011/c1_w0_br u_t025_011/c1_w1_bl u_t025_011/c1_w1_br
+ u_t025_011/c1_r0_rbl u_t025_011/c1_r1_rbl u_t025_011/c2_w0_bl u_t025_011/c2_w0_br u_t025_011/c2_w1_bl
+ u_t025_011/c2_w1_br u_t025_011/c2_r0_rbl u_t025_011/c2_r1_rbl u_t025_011/c3_w0_bl u_t025_011/c3_w0_br
+ u_t025_011/c3_w1_bl u_t025_011/c3_w1_br u_t025_011/c3_r0_rbl u_t025_011/c3_r1_rbl u_t025_011/r0_w0_wl
+ u_t025_011/r0_w1_wl u_t025_011/r0_r0_rwl u_t025_011/r0_r1_rwl u_t025_011/r1_w0_wl u_t025_011/r1_w1_wl
+ u_t025_011/r1_r0_rwl u_t025_011/r1_r1_rwl u_t025_011/r2_w0_wl u_t025_011/r2_w1_wl u_t025_011/r2_r0_rwl
+ u_t025_011/r2_r1_rwl u_t025_011/r3_w0_wl u_t025_011/r3_w1_wl u_t025_011/r3_r0_rwl u_t025_011/r3_r1_rwl VDD VSS VSUBS
+ detronyx_12t_2w2r_rc4_4x4_routed_5layer_direct
Xu_t025_000 u_t025_000/c0_w0_bl u_t025_000/c0_w0_br u_t025_000/c0_w1_bl u_t025_000/c0_w1_br u_t025_000/c0_r0_rbl
+ u_t025_000/c0_r1_rbl u_t025_000/c1_w0_bl u_t025_000/c1_w0_br u_t025_000/c1_w1_bl u_t025_000/c1_w1_br
+ u_t025_000/c1_r0_rbl u_t025_000/c1_r1_rbl u_t025_000/c2_w0_bl u_t025_000/c2_w0_br u_t025_000/c2_w1_bl
+ u_t025_000/c2_w1_br u_t025_000/c2_r0_rbl u_t025_000/c2_r1_rbl u_t025_000/c3_w0_bl u_t025_000/c3_w0_br
+ u_t025_000/c3_w1_bl u_t025_000/c3_w1_br u_t025_000/c3_r0_rbl u_t025_000/c3_r1_rbl u_t025_000/r0_w0_wl
+ u_t025_000/r0_w1_wl u_t025_000/r0_r0_rwl u_t025_000/r0_r1_rwl u_t025_000/r1_w0_wl u_t025_000/r1_w1_wl
+ u_t025_000/r1_r0_rwl u_t025_000/r1_r1_rwl u_t025_000/r2_w0_wl u_t025_000/r2_w1_wl u_t025_000/r2_r0_rwl
+ u_t025_000/r2_r1_rwl u_t025_000/r3_w0_wl u_t025_000/r3_w1_wl u_t025_000/r3_r0_rwl u_t025_000/r3_r1_rwl VDD VSS VSUBS
+ detronyx_12t_2w2r_rc4_4x4_routed_5layer_direct
Xu_t031_014 u_t031_014/c0_w0_bl u_t031_014/c0_w0_br u_t031_014/c0_w1_bl u_t031_014/c0_w1_br u_t031_014/c0_r0_rbl
+ u_t031_014/c0_r1_rbl u_t031_014/c1_w0_bl u_t031_014/c1_w0_br u_t031_014/c1_w1_bl u_t031_014/c1_w1_br
+ u_t031_014/c1_r0_rbl u_t031_014/c1_r1_rbl u_t031_014/c2_w0_bl u_t031_014/c2_w0_br u_t031_014/c2_w1_bl
+ u_t031_014/c2_w1_br u_t031_014/c2_r0_rbl u_t031_014/c2_r1_rbl u_t031_014/c3_w0_bl u_t031_014/c3_w0_br
+ u_t031_014/c3_w1_bl u_t031_014/c3_w1_br u_t031_014/c3_r0_rbl u_t031_014/c3_r1_rbl u_t031_014/r0_w0_wl
+ u_t031_014/r0_w1_wl u_t031_014/r0_r0_rwl u_t031_014/r0_r1_rwl u_t031_014/r1_w0_wl u_t031_014/r1_w1_wl
+ u_t031_014/r1_r0_rwl u_t031_014/r1_r1_rwl u_t031_014/r2_w0_wl u_t031_014/r2_w1_wl u_t031_014/r2_r0_rwl
+ u_t031_014/r2_r1_rwl u_t031_014/r3_w0_wl u_t031_014/r3_w1_wl u_t031_014/r3_r0_rwl u_t031_014/r3_r1_rwl VDD VSS VSUBS
+ detronyx_12t_2w2r_rc4_4x4_routed_5layer_direct
Xu_t031_003 u_t031_003/c0_w0_bl u_t031_003/c0_w0_br u_t031_003/c0_w1_bl u_t031_003/c0_w1_br u_t031_003/c0_r0_rbl
+ u_t031_003/c0_r1_rbl u_t031_003/c1_w0_bl u_t031_003/c1_w0_br u_t031_003/c1_w1_bl u_t031_003/c1_w1_br
+ u_t031_003/c1_r0_rbl u_t031_003/c1_r1_rbl u_t031_003/c2_w0_bl u_t031_003/c2_w0_br u_t031_003/c2_w1_bl
+ u_t031_003/c2_w1_br u_t031_003/c2_r0_rbl u_t031_003/c2_r1_rbl u_t031_003/c3_w0_bl u_t031_003/c3_w0_br
+ u_t031_003/c3_w1_bl u_t031_003/c3_w1_br u_t031_003/c3_r0_rbl u_t031_003/c3_r1_rbl u_t031_003/r0_w0_wl
+ u_t031_003/r0_w1_wl u_t031_003/r0_r0_rwl u_t031_003/r0_r1_rwl u_t031_003/r1_w0_wl u_t031_003/r1_w1_wl
+ u_t031_003/r1_r0_rwl u_t031_003/r1_r1_rwl u_t031_003/r2_w0_wl u_t031_003/r2_w1_wl u_t031_003/r2_r0_rwl
+ u_t031_003/r2_r1_rwl u_t031_003/r3_w0_wl u_t031_003/r3_w1_wl u_t031_003/r3_r0_rwl u_t031_003/r3_r1_rwl VDD VSS VSUBS
+ detronyx_12t_2w2r_rc4_4x4_routed_5layer_direct
Xu_t016_000 u_t016_000/c0_w0_bl u_t016_000/c0_w0_br u_t016_000/c0_w1_bl u_t016_000/c0_w1_br u_t016_000/c0_r0_rbl
+ u_t016_000/c0_r1_rbl u_t016_000/c1_w0_bl u_t016_000/c1_w0_br u_t016_000/c1_w1_bl u_t016_000/c1_w1_br
+ u_t016_000/c1_r0_rbl u_t016_000/c1_r1_rbl u_t016_000/c2_w0_bl u_t016_000/c2_w0_br u_t016_000/c2_w1_bl
+ u_t016_000/c2_w1_br u_t016_000/c2_r0_rbl u_t016_000/c2_r1_rbl u_t016_000/c3_w0_bl u_t016_000/c3_w0_br
+ u_t016_000/c3_w1_bl u_t016_000/c3_w1_br u_t016_000/c3_r0_rbl u_t016_000/c3_r1_rbl u_t016_000/r0_w0_wl
+ u_t016_000/r0_w1_wl u_t016_000/r0_r0_rwl u_t016_000/r0_r1_rwl u_t016_000/r1_w0_wl u_t016_000/r1_w1_wl
+ u_t016_000/r1_r0_rwl u_t016_000/r1_r1_rwl u_t016_000/r2_w0_wl u_t016_000/r2_w1_wl u_t016_000/r2_r0_rwl
+ u_t016_000/r2_r1_rwl u_t016_000/r3_w0_wl u_t016_000/r3_w1_wl u_t016_000/r3_r0_rwl u_t016_000/r3_r1_rwl VDD VSS VSUBS
+ detronyx_12t_2w2r_rc4_4x4_routed_5layer_direct
Xu_t016_011 u_t016_011/c0_w0_bl u_t016_011/c0_w0_br u_t016_011/c0_w1_bl u_t016_011/c0_w1_br u_t016_011/c0_r0_rbl
+ u_t016_011/c0_r1_rbl u_t016_011/c1_w0_bl u_t016_011/c1_w0_br u_t016_011/c1_w1_bl u_t016_011/c1_w1_br
+ u_t016_011/c1_r0_rbl u_t016_011/c1_r1_rbl u_t016_011/c2_w0_bl u_t016_011/c2_w0_br u_t016_011/c2_w1_bl
+ u_t016_011/c2_w1_br u_t016_011/c2_r0_rbl u_t016_011/c2_r1_rbl u_t016_011/c3_w0_bl u_t016_011/c3_w0_br
+ u_t016_011/c3_w1_bl u_t016_011/c3_w1_br u_t016_011/c3_r0_rbl u_t016_011/c3_r1_rbl u_t016_011/r0_w0_wl
+ u_t016_011/r0_w1_wl u_t016_011/r0_r0_rwl u_t016_011/r0_r1_rwl u_t016_011/r1_w0_wl u_t016_011/r1_w1_wl
+ u_t016_011/r1_r0_rwl u_t016_011/r1_r1_rwl u_t016_011/r2_w0_wl u_t016_011/r2_w1_wl u_t016_011/r2_r0_rwl
+ u_t016_011/r2_r1_rwl u_t016_011/r3_w0_wl u_t016_011/r3_w1_wl u_t016_011/r3_r0_rwl u_t016_011/r3_r1_rwl VDD VSS VSUBS
+ detronyx_12t_2w2r_rc4_4x4_routed_5layer_direct
Xu_t007_000 u_t007_000/c0_w0_bl u_t007_000/c0_w0_br u_t007_000/c0_w1_bl u_t007_000/c0_w1_br u_t007_000/c0_r0_rbl
+ u_t007_000/c0_r1_rbl u_t007_000/c1_w0_bl u_t007_000/c1_w0_br u_t007_000/c1_w1_bl u_t007_000/c1_w1_br
+ u_t007_000/c1_r0_rbl u_t007_000/c1_r1_rbl u_t007_000/c2_w0_bl u_t007_000/c2_w0_br u_t007_000/c2_w1_bl
+ u_t007_000/c2_w1_br u_t007_000/c2_r0_rbl u_t007_000/c2_r1_rbl u_t007_000/c3_w0_bl u_t007_000/c3_w0_br
+ u_t007_000/c3_w1_bl u_t007_000/c3_w1_br u_t007_000/c3_r0_rbl u_t007_000/c3_r1_rbl u_t007_000/r0_w0_wl
+ u_t007_000/r0_w1_wl u_t007_000/r0_r0_rwl u_t007_000/r0_r1_rwl u_t007_000/r1_w0_wl u_t007_000/r1_w1_wl
+ u_t007_000/r1_r0_rwl u_t007_000/r1_r1_rwl u_t007_000/r2_w0_wl u_t007_000/r2_w1_wl u_t007_000/r2_r0_rwl
+ u_t007_000/r2_r1_rwl u_t007_000/r3_w0_wl u_t007_000/r3_w1_wl u_t007_000/r3_r0_rwl u_t007_000/r3_r1_rwl VDD VSS VSUBS
+ detronyx_12t_2w2r_rc4_4x4_routed_5layer_direct
Xu_t007_011 u_t007_011/c0_w0_bl u_t007_011/c0_w0_br u_t007_011/c0_w1_bl u_t007_011/c0_w1_br u_t007_011/c0_r0_rbl
+ u_t007_011/c0_r1_rbl u_t007_011/c1_w0_bl u_t007_011/c1_w0_br u_t007_011/c1_w1_bl u_t007_011/c1_w1_br
+ u_t007_011/c1_r0_rbl u_t007_011/c1_r1_rbl u_t007_011/c2_w0_bl u_t007_011/c2_w0_br u_t007_011/c2_w1_bl
+ u_t007_011/c2_w1_br u_t007_011/c2_r0_rbl u_t007_011/c2_r1_rbl u_t007_011/c3_w0_bl u_t007_011/c3_w0_br
+ u_t007_011/c3_w1_bl u_t007_011/c3_w1_br u_t007_011/c3_r0_rbl u_t007_011/c3_r1_rbl u_t007_011/r0_w0_wl
+ u_t007_011/r0_w1_wl u_t007_011/r0_r0_rwl u_t007_011/r0_r1_rwl u_t007_011/r1_w0_wl u_t007_011/r1_w1_wl
+ u_t007_011/r1_r0_rwl u_t007_011/r1_r1_rwl u_t007_011/r2_w0_wl u_t007_011/r2_w1_wl u_t007_011/r2_r0_rwl
+ u_t007_011/r2_r1_rwl u_t007_011/r3_w0_wl u_t007_011/r3_w1_wl u_t007_011/r3_r0_rwl u_t007_011/r3_r1_rwl VDD VSS VSUBS
+ detronyx_12t_2w2r_rc4_4x4_routed_5layer_direct
Xu_t022_003 u_t022_003/c0_w0_bl u_t022_003/c0_w0_br u_t022_003/c0_w1_bl u_t022_003/c0_w1_br u_t022_003/c0_r0_rbl
+ u_t022_003/c0_r1_rbl u_t022_003/c1_w0_bl u_t022_003/c1_w0_br u_t022_003/c1_w1_bl u_t022_003/c1_w1_br
+ u_t022_003/c1_r0_rbl u_t022_003/c1_r1_rbl u_t022_003/c2_w0_bl u_t022_003/c2_w0_br u_t022_003/c2_w1_bl
+ u_t022_003/c2_w1_br u_t022_003/c2_r0_rbl u_t022_003/c2_r1_rbl u_t022_003/c3_w0_bl u_t022_003/c3_w0_br
+ u_t022_003/c3_w1_bl u_t022_003/c3_w1_br u_t022_003/c3_r0_rbl u_t022_003/c3_r1_rbl u_t022_003/r0_w0_wl
+ u_t022_003/r0_w1_wl u_t022_003/r0_r0_rwl u_t022_003/r0_r1_rwl u_t022_003/r1_w0_wl u_t022_003/r1_w1_wl
+ u_t022_003/r1_r0_rwl u_t022_003/r1_r1_rwl u_t022_003/r2_w0_wl u_t022_003/r2_w1_wl u_t022_003/r2_r0_rwl
+ u_t022_003/r2_r1_rwl u_t022_003/r3_w0_wl u_t022_003/r3_w1_wl u_t022_003/r3_r0_rwl u_t022_003/r3_r1_rwl VDD VSS VSUBS
+ detronyx_12t_2w2r_rc4_4x4_routed_5layer_direct
Xu_t022_014 u_t022_014/c0_w0_bl u_t022_014/c0_w0_br u_t022_014/c0_w1_bl u_t022_014/c0_w1_br u_t022_014/c0_r0_rbl
+ u_t022_014/c0_r1_rbl u_t022_014/c1_w0_bl u_t022_014/c1_w0_br u_t022_014/c1_w1_bl u_t022_014/c1_w1_br
+ u_t022_014/c1_r0_rbl u_t022_014/c1_r1_rbl u_t022_014/c2_w0_bl u_t022_014/c2_w0_br u_t022_014/c2_w1_bl
+ u_t022_014/c2_w1_br u_t022_014/c2_r0_rbl u_t022_014/c2_r1_rbl u_t022_014/c3_w0_bl u_t022_014/c3_w0_br
+ u_t022_014/c3_w1_bl u_t022_014/c3_w1_br u_t022_014/c3_r0_rbl u_t022_014/c3_r1_rbl u_t022_014/r0_w0_wl
+ u_t022_014/r0_w1_wl u_t022_014/r0_r0_rwl u_t022_014/r0_r1_rwl u_t022_014/r1_w0_wl u_t022_014/r1_w1_wl
+ u_t022_014/r1_r0_rwl u_t022_014/r1_r1_rwl u_t022_014/r2_w0_wl u_t022_014/r2_w1_wl u_t022_014/r2_r0_rwl
+ u_t022_014/r2_r1_rwl u_t022_014/r3_w0_wl u_t022_014/r3_w1_wl u_t022_014/r3_r0_rwl u_t022_014/r3_r1_rwl VDD VSS VSUBS
+ detronyx_12t_2w2r_rc4_4x4_routed_5layer_direct
Xu_t013_003 u_t013_003/c0_w0_bl u_t013_003/c0_w0_br u_t013_003/c0_w1_bl u_t013_003/c0_w1_br u_t013_003/c0_r0_rbl
+ u_t013_003/c0_r1_rbl u_t013_003/c1_w0_bl u_t013_003/c1_w0_br u_t013_003/c1_w1_bl u_t013_003/c1_w1_br
+ u_t013_003/c1_r0_rbl u_t013_003/c1_r1_rbl u_t013_003/c2_w0_bl u_t013_003/c2_w0_br u_t013_003/c2_w1_bl
+ u_t013_003/c2_w1_br u_t013_003/c2_r0_rbl u_t013_003/c2_r1_rbl u_t013_003/c3_w0_bl u_t013_003/c3_w0_br
+ u_t013_003/c3_w1_bl u_t013_003/c3_w1_br u_t013_003/c3_r0_rbl u_t013_003/c3_r1_rbl u_t013_003/r0_w0_wl
+ u_t013_003/r0_w1_wl u_t013_003/r0_r0_rwl u_t013_003/r0_r1_rwl u_t013_003/r1_w0_wl u_t013_003/r1_w1_wl
+ u_t013_003/r1_r0_rwl u_t013_003/r1_r1_rwl u_t013_003/r2_w0_wl u_t013_003/r2_w1_wl u_t013_003/r2_r0_rwl
+ u_t013_003/r2_r1_rwl u_t013_003/r3_w0_wl u_t013_003/r3_w1_wl u_t013_003/r3_r0_rwl u_t013_003/r3_r1_rwl VDD VSS VSUBS
+ detronyx_12t_2w2r_rc4_4x4_routed_5layer_direct
Xu_t013_014 u_t013_014/c0_w0_bl u_t013_014/c0_w0_br u_t013_014/c0_w1_bl u_t013_014/c0_w1_br u_t013_014/c0_r0_rbl
+ u_t013_014/c0_r1_rbl u_t013_014/c1_w0_bl u_t013_014/c1_w0_br u_t013_014/c1_w1_bl u_t013_014/c1_w1_br
+ u_t013_014/c1_r0_rbl u_t013_014/c1_r1_rbl u_t013_014/c2_w0_bl u_t013_014/c2_w0_br u_t013_014/c2_w1_bl
+ u_t013_014/c2_w1_br u_t013_014/c2_r0_rbl u_t013_014/c2_r1_rbl u_t013_014/c3_w0_bl u_t013_014/c3_w0_br
+ u_t013_014/c3_w1_bl u_t013_014/c3_w1_br u_t013_014/c3_r0_rbl u_t013_014/c3_r1_rbl u_t013_014/r0_w0_wl
+ u_t013_014/r0_w1_wl u_t013_014/r0_r0_rwl u_t013_014/r0_r1_rwl u_t013_014/r1_w0_wl u_t013_014/r1_w1_wl
+ u_t013_014/r1_r0_rwl u_t013_014/r1_r1_rwl u_t013_014/r2_w0_wl u_t013_014/r2_w1_wl u_t013_014/r2_r0_rwl
+ u_t013_014/r2_r1_rwl u_t013_014/r3_w0_wl u_t013_014/r3_w1_wl u_t013_014/r3_r0_rwl u_t013_014/r3_r1_rwl VDD VSS VSUBS
+ detronyx_12t_2w2r_rc4_4x4_routed_5layer_direct
Xu_t004_003 u_t004_003/c0_w0_bl u_t004_003/c0_w0_br u_t004_003/c0_w1_bl u_t004_003/c0_w1_br u_t004_003/c0_r0_rbl
+ u_t004_003/c0_r1_rbl u_t004_003/c1_w0_bl u_t004_003/c1_w0_br u_t004_003/c1_w1_bl u_t004_003/c1_w1_br
+ u_t004_003/c1_r0_rbl u_t004_003/c1_r1_rbl u_t004_003/c2_w0_bl u_t004_003/c2_w0_br u_t004_003/c2_w1_bl
+ u_t004_003/c2_w1_br u_t004_003/c2_r0_rbl u_t004_003/c2_r1_rbl u_t004_003/c3_w0_bl u_t004_003/c3_w0_br
+ u_t004_003/c3_w1_bl u_t004_003/c3_w1_br u_t004_003/c3_r0_rbl u_t004_003/c3_r1_rbl u_t004_003/r0_w0_wl
+ u_t004_003/r0_w1_wl u_t004_003/r0_r0_rwl u_t004_003/r0_r1_rwl u_t004_003/r1_w0_wl u_t004_003/r1_w1_wl
+ u_t004_003/r1_r0_rwl u_t004_003/r1_r1_rwl u_t004_003/r2_w0_wl u_t004_003/r2_w1_wl u_t004_003/r2_r0_rwl
+ u_t004_003/r2_r1_rwl u_t004_003/r3_w0_wl u_t004_003/r3_w1_wl u_t004_003/r3_r0_rwl u_t004_003/r3_r1_rwl VDD VSS VSUBS
+ detronyx_12t_2w2r_rc4_4x4_routed_5layer_direct
Xu_t004_014 u_t004_014/c0_w0_bl u_t004_014/c0_w0_br u_t004_014/c0_w1_bl u_t004_014/c0_w1_br u_t004_014/c0_r0_rbl
+ u_t004_014/c0_r1_rbl u_t004_014/c1_w0_bl u_t004_014/c1_w0_br u_t004_014/c1_w1_bl u_t004_014/c1_w1_br
+ u_t004_014/c1_r0_rbl u_t004_014/c1_r1_rbl u_t004_014/c2_w0_bl u_t004_014/c2_w0_br u_t004_014/c2_w1_bl
+ u_t004_014/c2_w1_br u_t004_014/c2_r0_rbl u_t004_014/c2_r1_rbl u_t004_014/c3_w0_bl u_t004_014/c3_w0_br
+ u_t004_014/c3_w1_bl u_t004_014/c3_w1_br u_t004_014/c3_r0_rbl u_t004_014/c3_r1_rbl u_t004_014/r0_w0_wl
+ u_t004_014/r0_w1_wl u_t004_014/r0_r0_rwl u_t004_014/r0_r1_rwl u_t004_014/r1_w0_wl u_t004_014/r1_w1_wl
+ u_t004_014/r1_r0_rwl u_t004_014/r1_r1_rwl u_t004_014/r2_w0_wl u_t004_014/r2_w1_wl u_t004_014/r2_r0_rwl
+ u_t004_014/r2_r1_rwl u_t004_014/r3_w0_wl u_t004_014/r3_w1_wl u_t004_014/r3_r0_rwl u_t004_014/r3_r1_rwl VDD VSS VSUBS
+ detronyx_12t_2w2r_rc4_4x4_routed_5layer_direct
Xu_t010_006 u_t010_006/c0_w0_bl u_t010_006/c0_w0_br u_t010_006/c0_w1_bl u_t010_006/c0_w1_br u_t010_006/c0_r0_rbl
+ u_t010_006/c0_r1_rbl u_t010_006/c1_w0_bl u_t010_006/c1_w0_br u_t010_006/c1_w1_bl u_t010_006/c1_w1_br
+ u_t010_006/c1_r0_rbl u_t010_006/c1_r1_rbl u_t010_006/c2_w0_bl u_t010_006/c2_w0_br u_t010_006/c2_w1_bl
+ u_t010_006/c2_w1_br u_t010_006/c2_r0_rbl u_t010_006/c2_r1_rbl u_t010_006/c3_w0_bl u_t010_006/c3_w0_br
+ u_t010_006/c3_w1_bl u_t010_006/c3_w1_br u_t010_006/c3_r0_rbl u_t010_006/c3_r1_rbl u_t010_006/r0_w0_wl
+ u_t010_006/r0_w1_wl u_t010_006/r0_r0_rwl u_t010_006/r0_r1_rwl u_t010_006/r1_w0_wl u_t010_006/r1_w1_wl
+ u_t010_006/r1_r0_rwl u_t010_006/r1_r1_rwl u_t010_006/r2_w0_wl u_t010_006/r2_w1_wl u_t010_006/r2_r0_rwl
+ u_t010_006/r2_r1_rwl u_t010_006/r3_w0_wl u_t010_006/r3_w1_wl u_t010_006/r3_r0_rwl u_t010_006/r3_r1_rwl VDD VSS VSUBS
+ detronyx_12t_2w2r_rc4_4x4_routed_5layer_direct
Xu_t001_006 u_t001_006/c0_w0_bl u_t001_006/c0_w0_br u_t001_006/c0_w1_bl u_t001_006/c0_w1_br u_t001_006/c0_r0_rbl
+ u_t001_006/c0_r1_rbl u_t001_006/c1_w0_bl u_t001_006/c1_w0_br u_t001_006/c1_w1_bl u_t001_006/c1_w1_br
+ u_t001_006/c1_r0_rbl u_t001_006/c1_r1_rbl u_t001_006/c2_w0_bl u_t001_006/c2_w0_br u_t001_006/c2_w1_bl
+ u_t001_006/c2_w1_br u_t001_006/c2_r0_rbl u_t001_006/c2_r1_rbl u_t001_006/c3_w0_bl u_t001_006/c3_w0_br
+ u_t001_006/c3_w1_bl u_t001_006/c3_w1_br u_t001_006/c3_r0_rbl u_t001_006/c3_r1_rbl u_t001_006/r0_w0_wl
+ u_t001_006/r0_w1_wl u_t001_006/r0_r0_rwl u_t001_006/r0_r1_rwl u_t001_006/r1_w0_wl u_t001_006/r1_w1_wl
+ u_t001_006/r1_r0_rwl u_t001_006/r1_r1_rwl u_t001_006/r2_w0_wl u_t001_006/r2_w1_wl u_t001_006/r2_r0_rwl
+ u_t001_006/r2_r1_rwl u_t001_006/r3_w0_wl u_t001_006/r3_w1_wl u_t001_006/r3_r0_rwl u_t001_006/r3_r1_rwl VDD VSS VSUBS
+ detronyx_12t_2w2r_rc4_4x4_routed_5layer_direct
Xu_t029_009 u_t029_009/c0_w0_bl u_t029_009/c0_w0_br u_t029_009/c0_w1_bl u_t029_009/c0_w1_br u_t029_009/c0_r0_rbl
+ u_t029_009/c0_r1_rbl u_t029_009/c1_w0_bl u_t029_009/c1_w0_br u_t029_009/c1_w1_bl u_t029_009/c1_w1_br
+ u_t029_009/c1_r0_rbl u_t029_009/c1_r1_rbl u_t029_009/c2_w0_bl u_t029_009/c2_w0_br u_t029_009/c2_w1_bl
+ u_t029_009/c2_w1_br u_t029_009/c2_r0_rbl u_t029_009/c2_r1_rbl u_t029_009/c3_w0_bl u_t029_009/c3_w0_br
+ u_t029_009/c3_w1_bl u_t029_009/c3_w1_br u_t029_009/c3_r0_rbl u_t029_009/c3_r1_rbl u_t029_009/r0_w0_wl
+ u_t029_009/r0_w1_wl u_t029_009/r0_r0_rwl u_t029_009/r0_r1_rwl u_t029_009/r1_w0_wl u_t029_009/r1_w1_wl
+ u_t029_009/r1_r0_rwl u_t029_009/r1_r1_rwl u_t029_009/r2_w0_wl u_t029_009/r2_w1_wl u_t029_009/r2_r0_rwl
+ u_t029_009/r2_r1_rwl u_t029_009/r3_w0_wl u_t029_009/r3_w1_wl u_t029_009/r3_r0_rwl u_t029_009/r3_r1_rwl VDD VSS VSUBS
+ detronyx_12t_2w2r_rc4_4x4_routed_5layer_direct
Xu_t025_012 u_t025_012/c0_w0_bl u_t025_012/c0_w0_br u_t025_012/c0_w1_bl u_t025_012/c0_w1_br u_t025_012/c0_r0_rbl
+ u_t025_012/c0_r1_rbl u_t025_012/c1_w0_bl u_t025_012/c1_w0_br u_t025_012/c1_w1_bl u_t025_012/c1_w1_br
+ u_t025_012/c1_r0_rbl u_t025_012/c1_r1_rbl u_t025_012/c2_w0_bl u_t025_012/c2_w0_br u_t025_012/c2_w1_bl
+ u_t025_012/c2_w1_br u_t025_012/c2_r0_rbl u_t025_012/c2_r1_rbl u_t025_012/c3_w0_bl u_t025_012/c3_w0_br
+ u_t025_012/c3_w1_bl u_t025_012/c3_w1_br u_t025_012/c3_r0_rbl u_t025_012/c3_r1_rbl u_t025_012/r0_w0_wl
+ u_t025_012/r0_w1_wl u_t025_012/r0_r0_rwl u_t025_012/r0_r1_rwl u_t025_012/r1_w0_wl u_t025_012/r1_w1_wl
+ u_t025_012/r1_r0_rwl u_t025_012/r1_r1_rwl u_t025_012/r2_w0_wl u_t025_012/r2_w1_wl u_t025_012/r2_r0_rwl
+ u_t025_012/r2_r1_rwl u_t025_012/r3_w0_wl u_t025_012/r3_w1_wl u_t025_012/r3_r0_rwl u_t025_012/r3_r1_rwl VDD VSS VSUBS
+ detronyx_12t_2w2r_rc4_4x4_routed_5layer_direct
Xu_t025_001 u_t025_001/c0_w0_bl u_t025_001/c0_w0_br u_t025_001/c0_w1_bl u_t025_001/c0_w1_br u_t025_001/c0_r0_rbl
+ u_t025_001/c0_r1_rbl u_t025_001/c1_w0_bl u_t025_001/c1_w0_br u_t025_001/c1_w1_bl u_t025_001/c1_w1_br
+ u_t025_001/c1_r0_rbl u_t025_001/c1_r1_rbl u_t025_001/c2_w0_bl u_t025_001/c2_w0_br u_t025_001/c2_w1_bl
+ u_t025_001/c2_w1_br u_t025_001/c2_r0_rbl u_t025_001/c2_r1_rbl u_t025_001/c3_w0_bl u_t025_001/c3_w0_br
+ u_t025_001/c3_w1_bl u_t025_001/c3_w1_br u_t025_001/c3_r0_rbl u_t025_001/c3_r1_rbl u_t025_001/r0_w0_wl
+ u_t025_001/r0_w1_wl u_t025_001/r0_r0_rwl u_t025_001/r0_r1_rwl u_t025_001/r1_w0_wl u_t025_001/r1_w1_wl
+ u_t025_001/r1_r0_rwl u_t025_001/r1_r1_rwl u_t025_001/r2_w0_wl u_t025_001/r2_w1_wl u_t025_001/r2_r0_rwl
+ u_t025_001/r2_r1_rwl u_t025_001/r3_w0_wl u_t025_001/r3_w1_wl u_t025_001/r3_r0_rwl u_t025_001/r3_r1_rwl VDD VSS VSUBS
+ detronyx_12t_2w2r_rc4_4x4_routed_5layer_direct
Xu_t031_015 u_t031_015/c0_w0_bl u_t031_015/c0_w0_br u_t031_015/c0_w1_bl u_t031_015/c0_w1_br u_t031_015/c0_r0_rbl
+ u_t031_015/c0_r1_rbl u_t031_015/c1_w0_bl u_t031_015/c1_w0_br u_t031_015/c1_w1_bl u_t031_015/c1_w1_br
+ u_t031_015/c1_r0_rbl u_t031_015/c1_r1_rbl u_t031_015/c2_w0_bl u_t031_015/c2_w0_br u_t031_015/c2_w1_bl
+ u_t031_015/c2_w1_br u_t031_015/c2_r0_rbl u_t031_015/c2_r1_rbl u_t031_015/c3_w0_bl u_t031_015/c3_w0_br
+ u_t031_015/c3_w1_bl u_t031_015/c3_w1_br u_t031_015/c3_r0_rbl u_t031_015/c3_r1_rbl u_t031_015/r0_w0_wl
+ u_t031_015/r0_w1_wl u_t031_015/r0_r0_rwl u_t031_015/r0_r1_rwl u_t031_015/r1_w0_wl u_t031_015/r1_w1_wl
+ u_t031_015/r1_r0_rwl u_t031_015/r1_r1_rwl u_t031_015/r2_w0_wl u_t031_015/r2_w1_wl u_t031_015/r2_r0_rwl
+ u_t031_015/r2_r1_rwl u_t031_015/r3_w0_wl u_t031_015/r3_w1_wl u_t031_015/r3_r0_rwl u_t031_015/r3_r1_rwl VDD VSS VSUBS
+ detronyx_12t_2w2r_rc4_4x4_routed_5layer_direct
Xu_t031_004 u_t031_004/c0_w0_bl u_t031_004/c0_w0_br u_t031_004/c0_w1_bl u_t031_004/c0_w1_br u_t031_004/c0_r0_rbl
+ u_t031_004/c0_r1_rbl u_t031_004/c1_w0_bl u_t031_004/c1_w0_br u_t031_004/c1_w1_bl u_t031_004/c1_w1_br
+ u_t031_004/c1_r0_rbl u_t031_004/c1_r1_rbl u_t031_004/c2_w0_bl u_t031_004/c2_w0_br u_t031_004/c2_w1_bl
+ u_t031_004/c2_w1_br u_t031_004/c2_r0_rbl u_t031_004/c2_r1_rbl u_t031_004/c3_w0_bl u_t031_004/c3_w0_br
+ u_t031_004/c3_w1_bl u_t031_004/c3_w1_br u_t031_004/c3_r0_rbl u_t031_004/c3_r1_rbl u_t031_004/r0_w0_wl
+ u_t031_004/r0_w1_wl u_t031_004/r0_r0_rwl u_t031_004/r0_r1_rwl u_t031_004/r1_w0_wl u_t031_004/r1_w1_wl
+ u_t031_004/r1_r0_rwl u_t031_004/r1_r1_rwl u_t031_004/r2_w0_wl u_t031_004/r2_w1_wl u_t031_004/r2_r0_rwl
+ u_t031_004/r2_r1_rwl u_t031_004/r3_w0_wl u_t031_004/r3_w1_wl u_t031_004/r3_r0_rwl u_t031_004/r3_r1_rwl VDD VSS VSUBS
+ detronyx_12t_2w2r_rc4_4x4_routed_5layer_direct
Xu_t016_001 u_t016_001/c0_w0_bl u_t016_001/c0_w0_br u_t016_001/c0_w1_bl u_t016_001/c0_w1_br u_t016_001/c0_r0_rbl
+ u_t016_001/c0_r1_rbl u_t016_001/c1_w0_bl u_t016_001/c1_w0_br u_t016_001/c1_w1_bl u_t016_001/c1_w1_br
+ u_t016_001/c1_r0_rbl u_t016_001/c1_r1_rbl u_t016_001/c2_w0_bl u_t016_001/c2_w0_br u_t016_001/c2_w1_bl
+ u_t016_001/c2_w1_br u_t016_001/c2_r0_rbl u_t016_001/c2_r1_rbl u_t016_001/c3_w0_bl u_t016_001/c3_w0_br
+ u_t016_001/c3_w1_bl u_t016_001/c3_w1_br u_t016_001/c3_r0_rbl u_t016_001/c3_r1_rbl u_t016_001/r0_w0_wl
+ u_t016_001/r0_w1_wl u_t016_001/r0_r0_rwl u_t016_001/r0_r1_rwl u_t016_001/r1_w0_wl u_t016_001/r1_w1_wl
+ u_t016_001/r1_r0_rwl u_t016_001/r1_r1_rwl u_t016_001/r2_w0_wl u_t016_001/r2_w1_wl u_t016_001/r2_r0_rwl
+ u_t016_001/r2_r1_rwl u_t016_001/r3_w0_wl u_t016_001/r3_w1_wl u_t016_001/r3_r0_rwl u_t016_001/r3_r1_rwl VDD VSS VSUBS
+ detronyx_12t_2w2r_rc4_4x4_routed_5layer_direct
Xu_t016_012 u_t016_012/c0_w0_bl u_t016_012/c0_w0_br u_t016_012/c0_w1_bl u_t016_012/c0_w1_br u_t016_012/c0_r0_rbl
+ u_t016_012/c0_r1_rbl u_t016_012/c1_w0_bl u_t016_012/c1_w0_br u_t016_012/c1_w1_bl u_t016_012/c1_w1_br
+ u_t016_012/c1_r0_rbl u_t016_012/c1_r1_rbl u_t016_012/c2_w0_bl u_t016_012/c2_w0_br u_t016_012/c2_w1_bl
+ u_t016_012/c2_w1_br u_t016_012/c2_r0_rbl u_t016_012/c2_r1_rbl u_t016_012/c3_w0_bl u_t016_012/c3_w0_br
+ u_t016_012/c3_w1_bl u_t016_012/c3_w1_br u_t016_012/c3_r0_rbl u_t016_012/c3_r1_rbl u_t016_012/r0_w0_wl
+ u_t016_012/r0_w1_wl u_t016_012/r0_r0_rwl u_t016_012/r0_r1_rwl u_t016_012/r1_w0_wl u_t016_012/r1_w1_wl
+ u_t016_012/r1_r0_rwl u_t016_012/r1_r1_rwl u_t016_012/r2_w0_wl u_t016_012/r2_w1_wl u_t016_012/r2_r0_rwl
+ u_t016_012/r2_r1_rwl u_t016_012/r3_w0_wl u_t016_012/r3_w1_wl u_t016_012/r3_r0_rwl u_t016_012/r3_r1_rwl VDD VSS VSUBS
+ detronyx_12t_2w2r_rc4_4x4_routed_5layer_direct
Xu_t007_001 u_t007_001/c0_w0_bl u_t007_001/c0_w0_br u_t007_001/c0_w1_bl u_t007_001/c0_w1_br u_t007_001/c0_r0_rbl
+ u_t007_001/c0_r1_rbl u_t007_001/c1_w0_bl u_t007_001/c1_w0_br u_t007_001/c1_w1_bl u_t007_001/c1_w1_br
+ u_t007_001/c1_r0_rbl u_t007_001/c1_r1_rbl u_t007_001/c2_w0_bl u_t007_001/c2_w0_br u_t007_001/c2_w1_bl
+ u_t007_001/c2_w1_br u_t007_001/c2_r0_rbl u_t007_001/c2_r1_rbl u_t007_001/c3_w0_bl u_t007_001/c3_w0_br
+ u_t007_001/c3_w1_bl u_t007_001/c3_w1_br u_t007_001/c3_r0_rbl u_t007_001/c3_r1_rbl u_t007_001/r0_w0_wl
+ u_t007_001/r0_w1_wl u_t007_001/r0_r0_rwl u_t007_001/r0_r1_rwl u_t007_001/r1_w0_wl u_t007_001/r1_w1_wl
+ u_t007_001/r1_r0_rwl u_t007_001/r1_r1_rwl u_t007_001/r2_w0_wl u_t007_001/r2_w1_wl u_t007_001/r2_r0_rwl
+ u_t007_001/r2_r1_rwl u_t007_001/r3_w0_wl u_t007_001/r3_w1_wl u_t007_001/r3_r0_rwl u_t007_001/r3_r1_rwl VDD VSS VSUBS
+ detronyx_12t_2w2r_rc4_4x4_routed_5layer_direct
Xu_t007_012 u_t007_012/c0_w0_bl u_t007_012/c0_w0_br u_t007_012/c0_w1_bl u_t007_012/c0_w1_br u_t007_012/c0_r0_rbl
+ u_t007_012/c0_r1_rbl u_t007_012/c1_w0_bl u_t007_012/c1_w0_br u_t007_012/c1_w1_bl u_t007_012/c1_w1_br
+ u_t007_012/c1_r0_rbl u_t007_012/c1_r1_rbl u_t007_012/c2_w0_bl u_t007_012/c2_w0_br u_t007_012/c2_w1_bl
+ u_t007_012/c2_w1_br u_t007_012/c2_r0_rbl u_t007_012/c2_r1_rbl u_t007_012/c3_w0_bl u_t007_012/c3_w0_br
+ u_t007_012/c3_w1_bl u_t007_012/c3_w1_br u_t007_012/c3_r0_rbl u_t007_012/c3_r1_rbl u_t007_012/r0_w0_wl
+ u_t007_012/r0_w1_wl u_t007_012/r0_r0_rwl u_t007_012/r0_r1_rwl u_t007_012/r1_w0_wl u_t007_012/r1_w1_wl
+ u_t007_012/r1_r0_rwl u_t007_012/r1_r1_rwl u_t007_012/r2_w0_wl u_t007_012/r2_w1_wl u_t007_012/r2_r0_rwl
+ u_t007_012/r2_r1_rwl u_t007_012/r3_w0_wl u_t007_012/r3_w1_wl u_t007_012/r3_r0_rwl u_t007_012/r3_r1_rwl VDD VSS VSUBS
+ detronyx_12t_2w2r_rc4_4x4_routed_5layer_direct
Xu_t022_004 u_t022_004/c0_w0_bl u_t022_004/c0_w0_br u_t022_004/c0_w1_bl u_t022_004/c0_w1_br u_t022_004/c0_r0_rbl
+ u_t022_004/c0_r1_rbl u_t022_004/c1_w0_bl u_t022_004/c1_w0_br u_t022_004/c1_w1_bl u_t022_004/c1_w1_br
+ u_t022_004/c1_r0_rbl u_t022_004/c1_r1_rbl u_t022_004/c2_w0_bl u_t022_004/c2_w0_br u_t022_004/c2_w1_bl
+ u_t022_004/c2_w1_br u_t022_004/c2_r0_rbl u_t022_004/c2_r1_rbl u_t022_004/c3_w0_bl u_t022_004/c3_w0_br
+ u_t022_004/c3_w1_bl u_t022_004/c3_w1_br u_t022_004/c3_r0_rbl u_t022_004/c3_r1_rbl u_t022_004/r0_w0_wl
+ u_t022_004/r0_w1_wl u_t022_004/r0_r0_rwl u_t022_004/r0_r1_rwl u_t022_004/r1_w0_wl u_t022_004/r1_w1_wl
+ u_t022_004/r1_r0_rwl u_t022_004/r1_r1_rwl u_t022_004/r2_w0_wl u_t022_004/r2_w1_wl u_t022_004/r2_r0_rwl
+ u_t022_004/r2_r1_rwl u_t022_004/r3_w0_wl u_t022_004/r3_w1_wl u_t022_004/r3_r0_rwl u_t022_004/r3_r1_rwl VDD VSS VSUBS
+ detronyx_12t_2w2r_rc4_4x4_routed_5layer_direct
Xu_t022_015 u_t022_015/c0_w0_bl u_t022_015/c0_w0_br u_t022_015/c0_w1_bl u_t022_015/c0_w1_br u_t022_015/c0_r0_rbl
+ u_t022_015/c0_r1_rbl u_t022_015/c1_w0_bl u_t022_015/c1_w0_br u_t022_015/c1_w1_bl u_t022_015/c1_w1_br
+ u_t022_015/c1_r0_rbl u_t022_015/c1_r1_rbl u_t022_015/c2_w0_bl u_t022_015/c2_w0_br u_t022_015/c2_w1_bl
+ u_t022_015/c2_w1_br u_t022_015/c2_r0_rbl u_t022_015/c2_r1_rbl u_t022_015/c3_w0_bl u_t022_015/c3_w0_br
+ u_t022_015/c3_w1_bl u_t022_015/c3_w1_br u_t022_015/c3_r0_rbl u_t022_015/c3_r1_rbl u_t022_015/r0_w0_wl
+ u_t022_015/r0_w1_wl u_t022_015/r0_r0_rwl u_t022_015/r0_r1_rwl u_t022_015/r1_w0_wl u_t022_015/r1_w1_wl
+ u_t022_015/r1_r0_rwl u_t022_015/r1_r1_rwl u_t022_015/r2_w0_wl u_t022_015/r2_w1_wl u_t022_015/r2_r0_rwl
+ u_t022_015/r2_r1_rwl u_t022_015/r3_w0_wl u_t022_015/r3_w1_wl u_t022_015/r3_r0_rwl u_t022_015/r3_r1_rwl VDD VSS VSUBS
+ detronyx_12t_2w2r_rc4_4x4_routed_5layer_direct
Xu_t013_004 u_t013_004/c0_w0_bl u_t013_004/c0_w0_br u_t013_004/c0_w1_bl u_t013_004/c0_w1_br u_t013_004/c0_r0_rbl
+ u_t013_004/c0_r1_rbl u_t013_004/c1_w0_bl u_t013_004/c1_w0_br u_t013_004/c1_w1_bl u_t013_004/c1_w1_br
+ u_t013_004/c1_r0_rbl u_t013_004/c1_r1_rbl u_t013_004/c2_w0_bl u_t013_004/c2_w0_br u_t013_004/c2_w1_bl
+ u_t013_004/c2_w1_br u_t013_004/c2_r0_rbl u_t013_004/c2_r1_rbl u_t013_004/c3_w0_bl u_t013_004/c3_w0_br
+ u_t013_004/c3_w1_bl u_t013_004/c3_w1_br u_t013_004/c3_r0_rbl u_t013_004/c3_r1_rbl u_t013_004/r0_w0_wl
+ u_t013_004/r0_w1_wl u_t013_004/r0_r0_rwl u_t013_004/r0_r1_rwl u_t013_004/r1_w0_wl u_t013_004/r1_w1_wl
+ u_t013_004/r1_r0_rwl u_t013_004/r1_r1_rwl u_t013_004/r2_w0_wl u_t013_004/r2_w1_wl u_t013_004/r2_r0_rwl
+ u_t013_004/r2_r1_rwl u_t013_004/r3_w0_wl u_t013_004/r3_w1_wl u_t013_004/r3_r0_rwl u_t013_004/r3_r1_rwl VDD VSS VSUBS
+ detronyx_12t_2w2r_rc4_4x4_routed_5layer_direct
Xu_t013_015 u_t013_015/c0_w0_bl u_t013_015/c0_w0_br u_t013_015/c0_w1_bl u_t013_015/c0_w1_br u_t013_015/c0_r0_rbl
+ u_t013_015/c0_r1_rbl u_t013_015/c1_w0_bl u_t013_015/c1_w0_br u_t013_015/c1_w1_bl u_t013_015/c1_w1_br
+ u_t013_015/c1_r0_rbl u_t013_015/c1_r1_rbl u_t013_015/c2_w0_bl u_t013_015/c2_w0_br u_t013_015/c2_w1_bl
+ u_t013_015/c2_w1_br u_t013_015/c2_r0_rbl u_t013_015/c2_r1_rbl u_t013_015/c3_w0_bl u_t013_015/c3_w0_br
+ u_t013_015/c3_w1_bl u_t013_015/c3_w1_br u_t013_015/c3_r0_rbl u_t013_015/c3_r1_rbl u_t013_015/r0_w0_wl
+ u_t013_015/r0_w1_wl u_t013_015/r0_r0_rwl u_t013_015/r0_r1_rwl u_t013_015/r1_w0_wl u_t013_015/r1_w1_wl
+ u_t013_015/r1_r0_rwl u_t013_015/r1_r1_rwl u_t013_015/r2_w0_wl u_t013_015/r2_w1_wl u_t013_015/r2_r0_rwl
+ u_t013_015/r2_r1_rwl u_t013_015/r3_w0_wl u_t013_015/r3_w1_wl u_t013_015/r3_r0_rwl u_t013_015/r3_r1_rwl VDD VSS VSUBS
+ detronyx_12t_2w2r_rc4_4x4_routed_5layer_direct
Xu_t004_004 u_t004_004/c0_w0_bl u_t004_004/c0_w0_br u_t004_004/c0_w1_bl u_t004_004/c0_w1_br u_t004_004/c0_r0_rbl
+ u_t004_004/c0_r1_rbl u_t004_004/c1_w0_bl u_t004_004/c1_w0_br u_t004_004/c1_w1_bl u_t004_004/c1_w1_br
+ u_t004_004/c1_r0_rbl u_t004_004/c1_r1_rbl u_t004_004/c2_w0_bl u_t004_004/c2_w0_br u_t004_004/c2_w1_bl
+ u_t004_004/c2_w1_br u_t004_004/c2_r0_rbl u_t004_004/c2_r1_rbl u_t004_004/c3_w0_bl u_t004_004/c3_w0_br
+ u_t004_004/c3_w1_bl u_t004_004/c3_w1_br u_t004_004/c3_r0_rbl u_t004_004/c3_r1_rbl u_t004_004/r0_w0_wl
+ u_t004_004/r0_w1_wl u_t004_004/r0_r0_rwl u_t004_004/r0_r1_rwl u_t004_004/r1_w0_wl u_t004_004/r1_w1_wl
+ u_t004_004/r1_r0_rwl u_t004_004/r1_r1_rwl u_t004_004/r2_w0_wl u_t004_004/r2_w1_wl u_t004_004/r2_r0_rwl
+ u_t004_004/r2_r1_rwl u_t004_004/r3_w0_wl u_t004_004/r3_w1_wl u_t004_004/r3_r0_rwl u_t004_004/r3_r1_rwl VDD VSS VSUBS
+ detronyx_12t_2w2r_rc4_4x4_routed_5layer_direct
Xu_t004_015 u_t004_015/c0_w0_bl u_t004_015/c0_w0_br u_t004_015/c0_w1_bl u_t004_015/c0_w1_br u_t004_015/c0_r0_rbl
+ u_t004_015/c0_r1_rbl u_t004_015/c1_w0_bl u_t004_015/c1_w0_br u_t004_015/c1_w1_bl u_t004_015/c1_w1_br
+ u_t004_015/c1_r0_rbl u_t004_015/c1_r1_rbl u_t004_015/c2_w0_bl u_t004_015/c2_w0_br u_t004_015/c2_w1_bl
+ u_t004_015/c2_w1_br u_t004_015/c2_r0_rbl u_t004_015/c2_r1_rbl u_t004_015/c3_w0_bl u_t004_015/c3_w0_br
+ u_t004_015/c3_w1_bl u_t004_015/c3_w1_br u_t004_015/c3_r0_rbl u_t004_015/c3_r1_rbl u_t004_015/r0_w0_wl
+ u_t004_015/r0_w1_wl u_t004_015/r0_r0_rwl u_t004_015/r0_r1_rwl u_t004_015/r1_w0_wl u_t004_015/r1_w1_wl
+ u_t004_015/r1_r0_rwl u_t004_015/r1_r1_rwl u_t004_015/r2_w0_wl u_t004_015/r2_w1_wl u_t004_015/r2_r0_rwl
+ u_t004_015/r2_r1_rwl u_t004_015/r3_w0_wl u_t004_015/r3_w1_wl u_t004_015/r3_r0_rwl u_t004_015/r3_r1_rwl VDD VSS VSUBS
+ detronyx_12t_2w2r_rc4_4x4_routed_5layer_direct
Xu_t010_007 u_t010_007/c0_w0_bl u_t010_007/c0_w0_br u_t010_007/c0_w1_bl u_t010_007/c0_w1_br u_t010_007/c0_r0_rbl
+ u_t010_007/c0_r1_rbl u_t010_007/c1_w0_bl u_t010_007/c1_w0_br u_t010_007/c1_w1_bl u_t010_007/c1_w1_br
+ u_t010_007/c1_r0_rbl u_t010_007/c1_r1_rbl u_t010_007/c2_w0_bl u_t010_007/c2_w0_br u_t010_007/c2_w1_bl
+ u_t010_007/c2_w1_br u_t010_007/c2_r0_rbl u_t010_007/c2_r1_rbl u_t010_007/c3_w0_bl u_t010_007/c3_w0_br
+ u_t010_007/c3_w1_bl u_t010_007/c3_w1_br u_t010_007/c3_r0_rbl u_t010_007/c3_r1_rbl u_t010_007/r0_w0_wl
+ u_t010_007/r0_w1_wl u_t010_007/r0_r0_rwl u_t010_007/r0_r1_rwl u_t010_007/r1_w0_wl u_t010_007/r1_w1_wl
+ u_t010_007/r1_r0_rwl u_t010_007/r1_r1_rwl u_t010_007/r2_w0_wl u_t010_007/r2_w1_wl u_t010_007/r2_r0_rwl
+ u_t010_007/r2_r1_rwl u_t010_007/r3_w0_wl u_t010_007/r3_w1_wl u_t010_007/r3_r0_rwl u_t010_007/r3_r1_rwl VDD VSS VSUBS
+ detronyx_12t_2w2r_rc4_4x4_routed_5layer_direct
Xu_t001_007 u_t001_007/c0_w0_bl u_t001_007/c0_w0_br u_t001_007/c0_w1_bl u_t001_007/c0_w1_br u_t001_007/c0_r0_rbl
+ u_t001_007/c0_r1_rbl u_t001_007/c1_w0_bl u_t001_007/c1_w0_br u_t001_007/c1_w1_bl u_t001_007/c1_w1_br
+ u_t001_007/c1_r0_rbl u_t001_007/c1_r1_rbl u_t001_007/c2_w0_bl u_t001_007/c2_w0_br u_t001_007/c2_w1_bl
+ u_t001_007/c2_w1_br u_t001_007/c2_r0_rbl u_t001_007/c2_r1_rbl u_t001_007/c3_w0_bl u_t001_007/c3_w0_br
+ u_t001_007/c3_w1_bl u_t001_007/c3_w1_br u_t001_007/c3_r0_rbl u_t001_007/c3_r1_rbl u_t001_007/r0_w0_wl
+ u_t001_007/r0_w1_wl u_t001_007/r0_r0_rwl u_t001_007/r0_r1_rwl u_t001_007/r1_w0_wl u_t001_007/r1_w1_wl
+ u_t001_007/r1_r0_rwl u_t001_007/r1_r1_rwl u_t001_007/r2_w0_wl u_t001_007/r2_w1_wl u_t001_007/r2_r0_rwl
+ u_t001_007/r2_r1_rwl u_t001_007/r3_w0_wl u_t001_007/r3_w1_wl u_t001_007/r3_r0_rwl u_t001_007/r3_r1_rwl VDD VSS VSUBS
+ detronyx_12t_2w2r_rc4_4x4_routed_5layer_direct
Xu_t028_010 u_t028_010/c0_w0_bl u_t028_010/c0_w0_br u_t028_010/c0_w1_bl u_t028_010/c0_w1_br u_t028_010/c0_r0_rbl
+ u_t028_010/c0_r1_rbl u_t028_010/c1_w0_bl u_t028_010/c1_w0_br u_t028_010/c1_w1_bl u_t028_010/c1_w1_br
+ u_t028_010/c1_r0_rbl u_t028_010/c1_r1_rbl u_t028_010/c2_w0_bl u_t028_010/c2_w0_br u_t028_010/c2_w1_bl
+ u_t028_010/c2_w1_br u_t028_010/c2_r0_rbl u_t028_010/c2_r1_rbl u_t028_010/c3_w0_bl u_t028_010/c3_w0_br
+ u_t028_010/c3_w1_bl u_t028_010/c3_w1_br u_t028_010/c3_r0_rbl u_t028_010/c3_r1_rbl u_t028_010/r0_w0_wl
+ u_t028_010/r0_w1_wl u_t028_010/r0_r0_rwl u_t028_010/r0_r1_rwl u_t028_010/r1_w0_wl u_t028_010/r1_w1_wl
+ u_t028_010/r1_r0_rwl u_t028_010/r1_r1_rwl u_t028_010/r2_w0_wl u_t028_010/r2_w1_wl u_t028_010/r2_r0_rwl
+ u_t028_010/r2_r1_rwl u_t028_010/r3_w0_wl u_t028_010/r3_w1_wl u_t028_010/r3_r0_rwl u_t028_010/r3_r1_rwl VDD VSS VSUBS
+ detronyx_12t_2w2r_rc4_4x4_routed_5layer_direct
Xu_t019_010 u_t019_010/c0_w0_bl u_t019_010/c0_w0_br u_t019_010/c0_w1_bl u_t019_010/c0_w1_br u_t019_010/c0_r0_rbl
+ u_t019_010/c0_r1_rbl u_t019_010/c1_w0_bl u_t019_010/c1_w0_br u_t019_010/c1_w1_bl u_t019_010/c1_w1_br
+ u_t019_010/c1_r0_rbl u_t019_010/c1_r1_rbl u_t019_010/c2_w0_bl u_t019_010/c2_w0_br u_t019_010/c2_w1_bl
+ u_t019_010/c2_w1_br u_t019_010/c2_r0_rbl u_t019_010/c2_r1_rbl u_t019_010/c3_w0_bl u_t019_010/c3_w0_br
+ u_t019_010/c3_w1_bl u_t019_010/c3_w1_br u_t019_010/c3_r0_rbl u_t019_010/c3_r1_rbl u_t019_010/r0_w0_wl
+ u_t019_010/r0_w1_wl u_t019_010/r0_r0_rwl u_t019_010/r0_r1_rwl u_t019_010/r1_w0_wl u_t019_010/r1_w1_wl
+ u_t019_010/r1_r0_rwl u_t019_010/r1_r1_rwl u_t019_010/r2_w0_wl u_t019_010/r2_w1_wl u_t019_010/r2_r0_rwl
+ u_t019_010/r2_r1_rwl u_t019_010/r3_w0_wl u_t019_010/r3_w1_wl u_t019_010/r3_r0_rwl u_t019_010/r3_r1_rwl VDD VSS VSUBS
+ detronyx_12t_2w2r_rc4_4x4_routed_5layer_direct
Xu_t025_013 u_t025_013/c0_w0_bl u_t025_013/c0_w0_br u_t025_013/c0_w1_bl u_t025_013/c0_w1_br u_t025_013/c0_r0_rbl
+ u_t025_013/c0_r1_rbl u_t025_013/c1_w0_bl u_t025_013/c1_w0_br u_t025_013/c1_w1_bl u_t025_013/c1_w1_br
+ u_t025_013/c1_r0_rbl u_t025_013/c1_r1_rbl u_t025_013/c2_w0_bl u_t025_013/c2_w0_br u_t025_013/c2_w1_bl
+ u_t025_013/c2_w1_br u_t025_013/c2_r0_rbl u_t025_013/c2_r1_rbl u_t025_013/c3_w0_bl u_t025_013/c3_w0_br
+ u_t025_013/c3_w1_bl u_t025_013/c3_w1_br u_t025_013/c3_r0_rbl u_t025_013/c3_r1_rbl u_t025_013/r0_w0_wl
+ u_t025_013/r0_w1_wl u_t025_013/r0_r0_rwl u_t025_013/r0_r1_rwl u_t025_013/r1_w0_wl u_t025_013/r1_w1_wl
+ u_t025_013/r1_r0_rwl u_t025_013/r1_r1_rwl u_t025_013/r2_w0_wl u_t025_013/r2_w1_wl u_t025_013/r2_r0_rwl
+ u_t025_013/r2_r1_rwl u_t025_013/r3_w0_wl u_t025_013/r3_w1_wl u_t025_013/r3_r0_rwl u_t025_013/r3_r1_rwl VDD VSS VSUBS
+ detronyx_12t_2w2r_rc4_4x4_routed_5layer_direct
Xu_t025_002 u_t025_002/c0_w0_bl u_t025_002/c0_w0_br u_t025_002/c0_w1_bl u_t025_002/c0_w1_br u_t025_002/c0_r0_rbl
+ u_t025_002/c0_r1_rbl u_t025_002/c1_w0_bl u_t025_002/c1_w0_br u_t025_002/c1_w1_bl u_t025_002/c1_w1_br
+ u_t025_002/c1_r0_rbl u_t025_002/c1_r1_rbl u_t025_002/c2_w0_bl u_t025_002/c2_w0_br u_t025_002/c2_w1_bl
+ u_t025_002/c2_w1_br u_t025_002/c2_r0_rbl u_t025_002/c2_r1_rbl u_t025_002/c3_w0_bl u_t025_002/c3_w0_br
+ u_t025_002/c3_w1_bl u_t025_002/c3_w1_br u_t025_002/c3_r0_rbl u_t025_002/c3_r1_rbl u_t025_002/r0_w0_wl
+ u_t025_002/r0_w1_wl u_t025_002/r0_r0_rwl u_t025_002/r0_r1_rwl u_t025_002/r1_w0_wl u_t025_002/r1_w1_wl
+ u_t025_002/r1_r0_rwl u_t025_002/r1_r1_rwl u_t025_002/r2_w0_wl u_t025_002/r2_w1_wl u_t025_002/r2_r0_rwl
+ u_t025_002/r2_r1_rwl u_t025_002/r3_w0_wl u_t025_002/r3_w1_wl u_t025_002/r3_r0_rwl u_t025_002/r3_r1_rwl VDD VSS VSUBS
+ detronyx_12t_2w2r_rc4_4x4_routed_5layer_direct
Xu_t031_005 u_t031_005/c0_w0_bl u_t031_005/c0_w0_br u_t031_005/c0_w1_bl u_t031_005/c0_w1_br u_t031_005/c0_r0_rbl
+ u_t031_005/c0_r1_rbl u_t031_005/c1_w0_bl u_t031_005/c1_w0_br u_t031_005/c1_w1_bl u_t031_005/c1_w1_br
+ u_t031_005/c1_r0_rbl u_t031_005/c1_r1_rbl u_t031_005/c2_w0_bl u_t031_005/c2_w0_br u_t031_005/c2_w1_bl
+ u_t031_005/c2_w1_br u_t031_005/c2_r0_rbl u_t031_005/c2_r1_rbl u_t031_005/c3_w0_bl u_t031_005/c3_w0_br
+ u_t031_005/c3_w1_bl u_t031_005/c3_w1_br u_t031_005/c3_r0_rbl u_t031_005/c3_r1_rbl u_t031_005/r0_w0_wl
+ u_t031_005/r0_w1_wl u_t031_005/r0_r0_rwl u_t031_005/r0_r1_rwl u_t031_005/r1_w0_wl u_t031_005/r1_w1_wl
+ u_t031_005/r1_r0_rwl u_t031_005/r1_r1_rwl u_t031_005/r2_w0_wl u_t031_005/r2_w1_wl u_t031_005/r2_r0_rwl
+ u_t031_005/r2_r1_rwl u_t031_005/r3_w0_wl u_t031_005/r3_w1_wl u_t031_005/r3_r0_rwl u_t031_005/r3_r1_rwl VDD VSS VSUBS
+ detronyx_12t_2w2r_rc4_4x4_routed_5layer_direct
Xu_t007_002 u_t007_002/c0_w0_bl u_t007_002/c0_w0_br u_t007_002/c0_w1_bl u_t007_002/c0_w1_br u_t007_002/c0_r0_rbl
+ u_t007_002/c0_r1_rbl u_t007_002/c1_w0_bl u_t007_002/c1_w0_br u_t007_002/c1_w1_bl u_t007_002/c1_w1_br
+ u_t007_002/c1_r0_rbl u_t007_002/c1_r1_rbl u_t007_002/c2_w0_bl u_t007_002/c2_w0_br u_t007_002/c2_w1_bl
+ u_t007_002/c2_w1_br u_t007_002/c2_r0_rbl u_t007_002/c2_r1_rbl u_t007_002/c3_w0_bl u_t007_002/c3_w0_br
+ u_t007_002/c3_w1_bl u_t007_002/c3_w1_br u_t007_002/c3_r0_rbl u_t007_002/c3_r1_rbl u_t007_002/r0_w0_wl
+ u_t007_002/r0_w1_wl u_t007_002/r0_r0_rwl u_t007_002/r0_r1_rwl u_t007_002/r1_w0_wl u_t007_002/r1_w1_wl
+ u_t007_002/r1_r0_rwl u_t007_002/r1_r1_rwl u_t007_002/r2_w0_wl u_t007_002/r2_w1_wl u_t007_002/r2_r0_rwl
+ u_t007_002/r2_r1_rwl u_t007_002/r3_w0_wl u_t007_002/r3_w1_wl u_t007_002/r3_r0_rwl u_t007_002/r3_r1_rwl VDD VSS VSUBS
+ detronyx_12t_2w2r_rc4_4x4_routed_5layer_direct
Xu_t007_013 u_t007_013/c0_w0_bl u_t007_013/c0_w0_br u_t007_013/c0_w1_bl u_t007_013/c0_w1_br u_t007_013/c0_r0_rbl
+ u_t007_013/c0_r1_rbl u_t007_013/c1_w0_bl u_t007_013/c1_w0_br u_t007_013/c1_w1_bl u_t007_013/c1_w1_br
+ u_t007_013/c1_r0_rbl u_t007_013/c1_r1_rbl u_t007_013/c2_w0_bl u_t007_013/c2_w0_br u_t007_013/c2_w1_bl
+ u_t007_013/c2_w1_br u_t007_013/c2_r0_rbl u_t007_013/c2_r1_rbl u_t007_013/c3_w0_bl u_t007_013/c3_w0_br
+ u_t007_013/c3_w1_bl u_t007_013/c3_w1_br u_t007_013/c3_r0_rbl u_t007_013/c3_r1_rbl u_t007_013/r0_w0_wl
+ u_t007_013/r0_w1_wl u_t007_013/r0_r0_rwl u_t007_013/r0_r1_rwl u_t007_013/r1_w0_wl u_t007_013/r1_w1_wl
+ u_t007_013/r1_r0_rwl u_t007_013/r1_r1_rwl u_t007_013/r2_w0_wl u_t007_013/r2_w1_wl u_t007_013/r2_r0_rwl
+ u_t007_013/r2_r1_rwl u_t007_013/r3_w0_wl u_t007_013/r3_w1_wl u_t007_013/r3_r0_rwl u_t007_013/r3_r1_rwl VDD VSS VSUBS
+ detronyx_12t_2w2r_rc4_4x4_routed_5layer_direct
Xu_t016_002 u_t016_002/c0_w0_bl u_t016_002/c0_w0_br u_t016_002/c0_w1_bl u_t016_002/c0_w1_br u_t016_002/c0_r0_rbl
+ u_t016_002/c0_r1_rbl u_t016_002/c1_w0_bl u_t016_002/c1_w0_br u_t016_002/c1_w1_bl u_t016_002/c1_w1_br
+ u_t016_002/c1_r0_rbl u_t016_002/c1_r1_rbl u_t016_002/c2_w0_bl u_t016_002/c2_w0_br u_t016_002/c2_w1_bl
+ u_t016_002/c2_w1_br u_t016_002/c2_r0_rbl u_t016_002/c2_r1_rbl u_t016_002/c3_w0_bl u_t016_002/c3_w0_br
+ u_t016_002/c3_w1_bl u_t016_002/c3_w1_br u_t016_002/c3_r0_rbl u_t016_002/c3_r1_rbl u_t016_002/r0_w0_wl
+ u_t016_002/r0_w1_wl u_t016_002/r0_r0_rwl u_t016_002/r0_r1_rwl u_t016_002/r1_w0_wl u_t016_002/r1_w1_wl
+ u_t016_002/r1_r0_rwl u_t016_002/r1_r1_rwl u_t016_002/r2_w0_wl u_t016_002/r2_w1_wl u_t016_002/r2_r0_rwl
+ u_t016_002/r2_r1_rwl u_t016_002/r3_w0_wl u_t016_002/r3_w1_wl u_t016_002/r3_r0_rwl u_t016_002/r3_r1_rwl VDD VSS VSUBS
+ detronyx_12t_2w2r_rc4_4x4_routed_5layer_direct
Xu_t016_013 u_t016_013/c0_w0_bl u_t016_013/c0_w0_br u_t016_013/c0_w1_bl u_t016_013/c0_w1_br u_t016_013/c0_r0_rbl
+ u_t016_013/c0_r1_rbl u_t016_013/c1_w0_bl u_t016_013/c1_w0_br u_t016_013/c1_w1_bl u_t016_013/c1_w1_br
+ u_t016_013/c1_r0_rbl u_t016_013/c1_r1_rbl u_t016_013/c2_w0_bl u_t016_013/c2_w0_br u_t016_013/c2_w1_bl
+ u_t016_013/c2_w1_br u_t016_013/c2_r0_rbl u_t016_013/c2_r1_rbl u_t016_013/c3_w0_bl u_t016_013/c3_w0_br
+ u_t016_013/c3_w1_bl u_t016_013/c3_w1_br u_t016_013/c3_r0_rbl u_t016_013/c3_r1_rbl u_t016_013/r0_w0_wl
+ u_t016_013/r0_w1_wl u_t016_013/r0_r0_rwl u_t016_013/r0_r1_rwl u_t016_013/r1_w0_wl u_t016_013/r1_w1_wl
+ u_t016_013/r1_r0_rwl u_t016_013/r1_r1_rwl u_t016_013/r2_w0_wl u_t016_013/r2_w1_wl u_t016_013/r2_r0_rwl
+ u_t016_013/r2_r1_rwl u_t016_013/r3_w0_wl u_t016_013/r3_w1_wl u_t016_013/r3_r0_rwl u_t016_013/r3_r1_rwl VDD VSS VSUBS
+ detronyx_12t_2w2r_rc4_4x4_routed_5layer_direct
Xu_t013_005 u_t013_005/c0_w0_bl u_t013_005/c0_w0_br u_t013_005/c0_w1_bl u_t013_005/c0_w1_br u_t013_005/c0_r0_rbl
+ u_t013_005/c0_r1_rbl u_t013_005/c1_w0_bl u_t013_005/c1_w0_br u_t013_005/c1_w1_bl u_t013_005/c1_w1_br
+ u_t013_005/c1_r0_rbl u_t013_005/c1_r1_rbl u_t013_005/c2_w0_bl u_t013_005/c2_w0_br u_t013_005/c2_w1_bl
+ u_t013_005/c2_w1_br u_t013_005/c2_r0_rbl u_t013_005/c2_r1_rbl u_t013_005/c3_w0_bl u_t013_005/c3_w0_br
+ u_t013_005/c3_w1_bl u_t013_005/c3_w1_br u_t013_005/c3_r0_rbl u_t013_005/c3_r1_rbl u_t013_005/r0_w0_wl
+ u_t013_005/r0_w1_wl u_t013_005/r0_r0_rwl u_t013_005/r0_r1_rwl u_t013_005/r1_w0_wl u_t013_005/r1_w1_wl
+ u_t013_005/r1_r0_rwl u_t013_005/r1_r1_rwl u_t013_005/r2_w0_wl u_t013_005/r2_w1_wl u_t013_005/r2_r0_rwl
+ u_t013_005/r2_r1_rwl u_t013_005/r3_w0_wl u_t013_005/r3_w1_wl u_t013_005/r3_r0_rwl u_t013_005/r3_r1_rwl VDD VSS VSUBS
+ detronyx_12t_2w2r_rc4_4x4_routed_5layer_direct
Xu_t022_005 u_t022_005/c0_w0_bl u_t022_005/c0_w0_br u_t022_005/c0_w1_bl u_t022_005/c0_w1_br u_t022_005/c0_r0_rbl
+ u_t022_005/c0_r1_rbl u_t022_005/c1_w0_bl u_t022_005/c1_w0_br u_t022_005/c1_w1_bl u_t022_005/c1_w1_br
+ u_t022_005/c1_r0_rbl u_t022_005/c1_r1_rbl u_t022_005/c2_w0_bl u_t022_005/c2_w0_br u_t022_005/c2_w1_bl
+ u_t022_005/c2_w1_br u_t022_005/c2_r0_rbl u_t022_005/c2_r1_rbl u_t022_005/c3_w0_bl u_t022_005/c3_w0_br
+ u_t022_005/c3_w1_bl u_t022_005/c3_w1_br u_t022_005/c3_r0_rbl u_t022_005/c3_r1_rbl u_t022_005/r0_w0_wl
+ u_t022_005/r0_w1_wl u_t022_005/r0_r0_rwl u_t022_005/r0_r1_rwl u_t022_005/r1_w0_wl u_t022_005/r1_w1_wl
+ u_t022_005/r1_r0_rwl u_t022_005/r1_r1_rwl u_t022_005/r2_w0_wl u_t022_005/r2_w1_wl u_t022_005/r2_r0_rwl
+ u_t022_005/r2_r1_rwl u_t022_005/r3_w0_wl u_t022_005/r3_w1_wl u_t022_005/r3_r0_rwl u_t022_005/r3_r1_rwl VDD VSS VSUBS
+ detronyx_12t_2w2r_rc4_4x4_routed_5layer_direct
Xu_t004_005 u_t004_005/c0_w0_bl u_t004_005/c0_w0_br u_t004_005/c0_w1_bl u_t004_005/c0_w1_br u_t004_005/c0_r0_rbl
+ u_t004_005/c0_r1_rbl u_t004_005/c1_w0_bl u_t004_005/c1_w0_br u_t004_005/c1_w1_bl u_t004_005/c1_w1_br
+ u_t004_005/c1_r0_rbl u_t004_005/c1_r1_rbl u_t004_005/c2_w0_bl u_t004_005/c2_w0_br u_t004_005/c2_w1_bl
+ u_t004_005/c2_w1_br u_t004_005/c2_r0_rbl u_t004_005/c2_r1_rbl u_t004_005/c3_w0_bl u_t004_005/c3_w0_br
+ u_t004_005/c3_w1_bl u_t004_005/c3_w1_br u_t004_005/c3_r0_rbl u_t004_005/c3_r1_rbl u_t004_005/r0_w0_wl
+ u_t004_005/r0_w1_wl u_t004_005/r0_r0_rwl u_t004_005/r0_r1_rwl u_t004_005/r1_w0_wl u_t004_005/r1_w1_wl
+ u_t004_005/r1_r0_rwl u_t004_005/r1_r1_rwl u_t004_005/r2_w0_wl u_t004_005/r2_w1_wl u_t004_005/r2_r0_rwl
+ u_t004_005/r2_r1_rwl u_t004_005/r3_w0_wl u_t004_005/r3_w1_wl u_t004_005/r3_r0_rwl u_t004_005/r3_r1_rwl VDD VSS VSUBS
+ detronyx_12t_2w2r_rc4_4x4_routed_5layer_direct
Xu_t010_008 u_t010_008/c0_w0_bl u_t010_008/c0_w0_br u_t010_008/c0_w1_bl u_t010_008/c0_w1_br u_t010_008/c0_r0_rbl
+ u_t010_008/c0_r1_rbl u_t010_008/c1_w0_bl u_t010_008/c1_w0_br u_t010_008/c1_w1_bl u_t010_008/c1_w1_br
+ u_t010_008/c1_r0_rbl u_t010_008/c1_r1_rbl u_t010_008/c2_w0_bl u_t010_008/c2_w0_br u_t010_008/c2_w1_bl
+ u_t010_008/c2_w1_br u_t010_008/c2_r0_rbl u_t010_008/c2_r1_rbl u_t010_008/c3_w0_bl u_t010_008/c3_w0_br
+ u_t010_008/c3_w1_bl u_t010_008/c3_w1_br u_t010_008/c3_r0_rbl u_t010_008/c3_r1_rbl u_t010_008/r0_w0_wl
+ u_t010_008/r0_w1_wl u_t010_008/r0_r0_rwl u_t010_008/r0_r1_rwl u_t010_008/r1_w0_wl u_t010_008/r1_w1_wl
+ u_t010_008/r1_r0_rwl u_t010_008/r1_r1_rwl u_t010_008/r2_w0_wl u_t010_008/r2_w1_wl u_t010_008/r2_r0_rwl
+ u_t010_008/r2_r1_rwl u_t010_008/r3_w0_wl u_t010_008/r3_w1_wl u_t010_008/r3_r0_rwl u_t010_008/r3_r1_rwl VDD VSS VSUBS
+ detronyx_12t_2w2r_rc4_4x4_routed_5layer_direct
Xu_t001_008 u_t001_008/c0_w0_bl u_t001_008/c0_w0_br u_t001_008/c0_w1_bl u_t001_008/c0_w1_br u_t001_008/c0_r0_rbl
+ u_t001_008/c0_r1_rbl u_t001_008/c1_w0_bl u_t001_008/c1_w0_br u_t001_008/c1_w1_bl u_t001_008/c1_w1_br
+ u_t001_008/c1_r0_rbl u_t001_008/c1_r1_rbl u_t001_008/c2_w0_bl u_t001_008/c2_w0_br u_t001_008/c2_w1_bl
+ u_t001_008/c2_w1_br u_t001_008/c2_r0_rbl u_t001_008/c2_r1_rbl u_t001_008/c3_w0_bl u_t001_008/c3_w0_br
+ u_t001_008/c3_w1_bl u_t001_008/c3_w1_br u_t001_008/c3_r0_rbl u_t001_008/c3_r1_rbl u_t001_008/r0_w0_wl
+ u_t001_008/r0_w1_wl u_t001_008/r0_r0_rwl u_t001_008/r0_r1_rwl u_t001_008/r1_w0_wl u_t001_008/r1_w1_wl
+ u_t001_008/r1_r0_rwl u_t001_008/r1_r1_rwl u_t001_008/r2_w0_wl u_t001_008/r2_w1_wl u_t001_008/r2_r0_rwl
+ u_t001_008/r2_r1_rwl u_t001_008/r3_w0_wl u_t001_008/r3_w1_wl u_t001_008/r3_r0_rwl u_t001_008/r3_r1_rwl VDD VSS VSUBS
+ detronyx_12t_2w2r_rc4_4x4_routed_5layer_direct
Xu_t028_011 u_t028_011/c0_w0_bl u_t028_011/c0_w0_br u_t028_011/c0_w1_bl u_t028_011/c0_w1_br u_t028_011/c0_r0_rbl
+ u_t028_011/c0_r1_rbl u_t028_011/c1_w0_bl u_t028_011/c1_w0_br u_t028_011/c1_w1_bl u_t028_011/c1_w1_br
+ u_t028_011/c1_r0_rbl u_t028_011/c1_r1_rbl u_t028_011/c2_w0_bl u_t028_011/c2_w0_br u_t028_011/c2_w1_bl
+ u_t028_011/c2_w1_br u_t028_011/c2_r0_rbl u_t028_011/c2_r1_rbl u_t028_011/c3_w0_bl u_t028_011/c3_w0_br
+ u_t028_011/c3_w1_bl u_t028_011/c3_w1_br u_t028_011/c3_r0_rbl u_t028_011/c3_r1_rbl u_t028_011/r0_w0_wl
+ u_t028_011/r0_w1_wl u_t028_011/r0_r0_rwl u_t028_011/r0_r1_rwl u_t028_011/r1_w0_wl u_t028_011/r1_w1_wl
+ u_t028_011/r1_r0_rwl u_t028_011/r1_r1_rwl u_t028_011/r2_w0_wl u_t028_011/r2_w1_wl u_t028_011/r2_r0_rwl
+ u_t028_011/r2_r1_rwl u_t028_011/r3_w0_wl u_t028_011/r3_w1_wl u_t028_011/r3_r0_rwl u_t028_011/r3_r1_rwl VDD VSS VSUBS
+ detronyx_12t_2w2r_rc4_4x4_routed_5layer_direct
Xu_t028_000 u_t028_000/c0_w0_bl u_t028_000/c0_w0_br u_t028_000/c0_w1_bl u_t028_000/c0_w1_br u_t028_000/c0_r0_rbl
+ u_t028_000/c0_r1_rbl u_t028_000/c1_w0_bl u_t028_000/c1_w0_br u_t028_000/c1_w1_bl u_t028_000/c1_w1_br
+ u_t028_000/c1_r0_rbl u_t028_000/c1_r1_rbl u_t028_000/c2_w0_bl u_t028_000/c2_w0_br u_t028_000/c2_w1_bl
+ u_t028_000/c2_w1_br u_t028_000/c2_r0_rbl u_t028_000/c2_r1_rbl u_t028_000/c3_w0_bl u_t028_000/c3_w0_br
+ u_t028_000/c3_w1_bl u_t028_000/c3_w1_br u_t028_000/c3_r0_rbl u_t028_000/c3_r1_rbl u_t028_000/r0_w0_wl
+ u_t028_000/r0_w1_wl u_t028_000/r0_r0_rwl u_t028_000/r0_r1_rwl u_t028_000/r1_w0_wl u_t028_000/r1_w1_wl
+ u_t028_000/r1_r0_rwl u_t028_000/r1_r1_rwl u_t028_000/r2_w0_wl u_t028_000/r2_w1_wl u_t028_000/r2_r0_rwl
+ u_t028_000/r2_r1_rwl u_t028_000/r3_w0_wl u_t028_000/r3_w1_wl u_t028_000/r3_r0_rwl u_t028_000/r3_r1_rwl VDD VSS VSUBS
+ detronyx_12t_2w2r_rc4_4x4_routed_5layer_direct
Xu_t019_000 u_t019_000/c0_w0_bl u_t019_000/c0_w0_br u_t019_000/c0_w1_bl u_t019_000/c0_w1_br u_t019_000/c0_r0_rbl
+ u_t019_000/c0_r1_rbl u_t019_000/c1_w0_bl u_t019_000/c1_w0_br u_t019_000/c1_w1_bl u_t019_000/c1_w1_br
+ u_t019_000/c1_r0_rbl u_t019_000/c1_r1_rbl u_t019_000/c2_w0_bl u_t019_000/c2_w0_br u_t019_000/c2_w1_bl
+ u_t019_000/c2_w1_br u_t019_000/c2_r0_rbl u_t019_000/c2_r1_rbl u_t019_000/c3_w0_bl u_t019_000/c3_w0_br
+ u_t019_000/c3_w1_bl u_t019_000/c3_w1_br u_t019_000/c3_r0_rbl u_t019_000/c3_r1_rbl u_t019_000/r0_w0_wl
+ u_t019_000/r0_w1_wl u_t019_000/r0_r0_rwl u_t019_000/r0_r1_rwl u_t019_000/r1_w0_wl u_t019_000/r1_w1_wl
+ u_t019_000/r1_r0_rwl u_t019_000/r1_r1_rwl u_t019_000/r2_w0_wl u_t019_000/r2_w1_wl u_t019_000/r2_r0_rwl
+ u_t019_000/r2_r1_rwl u_t019_000/r3_w0_wl u_t019_000/r3_w1_wl u_t019_000/r3_r0_rwl u_t019_000/r3_r1_rwl VDD VSS VSUBS
+ detronyx_12t_2w2r_rc4_4x4_routed_5layer_direct
Xu_t019_011 u_t019_011/c0_w0_bl u_t019_011/c0_w0_br u_t019_011/c0_w1_bl u_t019_011/c0_w1_br u_t019_011/c0_r0_rbl
+ u_t019_011/c0_r1_rbl u_t019_011/c1_w0_bl u_t019_011/c1_w0_br u_t019_011/c1_w1_bl u_t019_011/c1_w1_br
+ u_t019_011/c1_r0_rbl u_t019_011/c1_r1_rbl u_t019_011/c2_w0_bl u_t019_011/c2_w0_br u_t019_011/c2_w1_bl
+ u_t019_011/c2_w1_br u_t019_011/c2_r0_rbl u_t019_011/c2_r1_rbl u_t019_011/c3_w0_bl u_t019_011/c3_w0_br
+ u_t019_011/c3_w1_bl u_t019_011/c3_w1_br u_t019_011/c3_r0_rbl u_t019_011/c3_r1_rbl u_t019_011/r0_w0_wl
+ u_t019_011/r0_w1_wl u_t019_011/r0_r0_rwl u_t019_011/r0_r1_rwl u_t019_011/r1_w0_wl u_t019_011/r1_w1_wl
+ u_t019_011/r1_r0_rwl u_t019_011/r1_r1_rwl u_t019_011/r2_w0_wl u_t019_011/r2_w1_wl u_t019_011/r2_r0_rwl
+ u_t019_011/r2_r1_rwl u_t019_011/r3_w0_wl u_t019_011/r3_w1_wl u_t019_011/r3_r0_rwl u_t019_011/r3_r1_rwl VDD VSS VSUBS
+ detronyx_12t_2w2r_rc4_4x4_routed_5layer_direct
Xu_t025_014 u_t025_014/c0_w0_bl u_t025_014/c0_w0_br u_t025_014/c0_w1_bl u_t025_014/c0_w1_br u_t025_014/c0_r0_rbl
+ u_t025_014/c0_r1_rbl u_t025_014/c1_w0_bl u_t025_014/c1_w0_br u_t025_014/c1_w1_bl u_t025_014/c1_w1_br
+ u_t025_014/c1_r0_rbl u_t025_014/c1_r1_rbl u_t025_014/c2_w0_bl u_t025_014/c2_w0_br u_t025_014/c2_w1_bl
+ u_t025_014/c2_w1_br u_t025_014/c2_r0_rbl u_t025_014/c2_r1_rbl u_t025_014/c3_w0_bl u_t025_014/c3_w0_br
+ u_t025_014/c3_w1_bl u_t025_014/c3_w1_br u_t025_014/c3_r0_rbl u_t025_014/c3_r1_rbl u_t025_014/r0_w0_wl
+ u_t025_014/r0_w1_wl u_t025_014/r0_r0_rwl u_t025_014/r0_r1_rwl u_t025_014/r1_w0_wl u_t025_014/r1_w1_wl
+ u_t025_014/r1_r0_rwl u_t025_014/r1_r1_rwl u_t025_014/r2_w0_wl u_t025_014/r2_w1_wl u_t025_014/r2_r0_rwl
+ u_t025_014/r2_r1_rwl u_t025_014/r3_w0_wl u_t025_014/r3_w1_wl u_t025_014/r3_r0_rwl u_t025_014/r3_r1_rwl VDD VSS VSUBS
+ detronyx_12t_2w2r_rc4_4x4_routed_5layer_direct
Xu_t025_003 u_t025_003/c0_w0_bl u_t025_003/c0_w0_br u_t025_003/c0_w1_bl u_t025_003/c0_w1_br u_t025_003/c0_r0_rbl
+ u_t025_003/c0_r1_rbl u_t025_003/c1_w0_bl u_t025_003/c1_w0_br u_t025_003/c1_w1_bl u_t025_003/c1_w1_br
+ u_t025_003/c1_r0_rbl u_t025_003/c1_r1_rbl u_t025_003/c2_w0_bl u_t025_003/c2_w0_br u_t025_003/c2_w1_bl
+ u_t025_003/c2_w1_br u_t025_003/c2_r0_rbl u_t025_003/c2_r1_rbl u_t025_003/c3_w0_bl u_t025_003/c3_w0_br
+ u_t025_003/c3_w1_bl u_t025_003/c3_w1_br u_t025_003/c3_r0_rbl u_t025_003/c3_r1_rbl u_t025_003/r0_w0_wl
+ u_t025_003/r0_w1_wl u_t025_003/r0_r0_rwl u_t025_003/r0_r1_rwl u_t025_003/r1_w0_wl u_t025_003/r1_w1_wl
+ u_t025_003/r1_r0_rwl u_t025_003/r1_r1_rwl u_t025_003/r2_w0_wl u_t025_003/r2_w1_wl u_t025_003/r2_r0_rwl
+ u_t025_003/r2_r1_rwl u_t025_003/r3_w0_wl u_t025_003/r3_w1_wl u_t025_003/r3_r0_rwl u_t025_003/r3_r1_rwl VDD VSS VSUBS
+ detronyx_12t_2w2r_rc4_4x4_routed_5layer_direct
Xu_t031_006 u_t031_006/c0_w0_bl u_t031_006/c0_w0_br u_t031_006/c0_w1_bl u_t031_006/c0_w1_br u_t031_006/c0_r0_rbl
+ u_t031_006/c0_r1_rbl u_t031_006/c1_w0_bl u_t031_006/c1_w0_br u_t031_006/c1_w1_bl u_t031_006/c1_w1_br
+ u_t031_006/c1_r0_rbl u_t031_006/c1_r1_rbl u_t031_006/c2_w0_bl u_t031_006/c2_w0_br u_t031_006/c2_w1_bl
+ u_t031_006/c2_w1_br u_t031_006/c2_r0_rbl u_t031_006/c2_r1_rbl u_t031_006/c3_w0_bl u_t031_006/c3_w0_br
+ u_t031_006/c3_w1_bl u_t031_006/c3_w1_br u_t031_006/c3_r0_rbl u_t031_006/c3_r1_rbl u_t031_006/r0_w0_wl
+ u_t031_006/r0_w1_wl u_t031_006/r0_r0_rwl u_t031_006/r0_r1_rwl u_t031_006/r1_w0_wl u_t031_006/r1_w1_wl
+ u_t031_006/r1_r0_rwl u_t031_006/r1_r1_rwl u_t031_006/r2_w0_wl u_t031_006/r2_w1_wl u_t031_006/r2_r0_rwl
+ u_t031_006/r2_r1_rwl u_t031_006/r3_w0_wl u_t031_006/r3_w1_wl u_t031_006/r3_r0_rwl u_t031_006/r3_r1_rwl VDD VSS VSUBS
+ detronyx_12t_2w2r_rc4_4x4_routed_5layer_direct
Xu_t016_003 u_t016_003/c0_w0_bl u_t016_003/c0_w0_br u_t016_003/c0_w1_bl u_t016_003/c0_w1_br u_t016_003/c0_r0_rbl
+ u_t016_003/c0_r1_rbl u_t016_003/c1_w0_bl u_t016_003/c1_w0_br u_t016_003/c1_w1_bl u_t016_003/c1_w1_br
+ u_t016_003/c1_r0_rbl u_t016_003/c1_r1_rbl u_t016_003/c2_w0_bl u_t016_003/c2_w0_br u_t016_003/c2_w1_bl
+ u_t016_003/c2_w1_br u_t016_003/c2_r0_rbl u_t016_003/c2_r1_rbl u_t016_003/c3_w0_bl u_t016_003/c3_w0_br
+ u_t016_003/c3_w1_bl u_t016_003/c3_w1_br u_t016_003/c3_r0_rbl u_t016_003/c3_r1_rbl u_t016_003/r0_w0_wl
+ u_t016_003/r0_w1_wl u_t016_003/r0_r0_rwl u_t016_003/r0_r1_rwl u_t016_003/r1_w0_wl u_t016_003/r1_w1_wl
+ u_t016_003/r1_r0_rwl u_t016_003/r1_r1_rwl u_t016_003/r2_w0_wl u_t016_003/r2_w1_wl u_t016_003/r2_r0_rwl
+ u_t016_003/r2_r1_rwl u_t016_003/r3_w0_wl u_t016_003/r3_w1_wl u_t016_003/r3_r0_rwl u_t016_003/r3_r1_rwl VDD VSS VSUBS
+ detronyx_12t_2w2r_rc4_4x4_routed_5layer_direct
Xu_t016_014 u_t016_014/c0_w0_bl u_t016_014/c0_w0_br u_t016_014/c0_w1_bl u_t016_014/c0_w1_br u_t016_014/c0_r0_rbl
+ u_t016_014/c0_r1_rbl u_t016_014/c1_w0_bl u_t016_014/c1_w0_br u_t016_014/c1_w1_bl u_t016_014/c1_w1_br
+ u_t016_014/c1_r0_rbl u_t016_014/c1_r1_rbl u_t016_014/c2_w0_bl u_t016_014/c2_w0_br u_t016_014/c2_w1_bl
+ u_t016_014/c2_w1_br u_t016_014/c2_r0_rbl u_t016_014/c2_r1_rbl u_t016_014/c3_w0_bl u_t016_014/c3_w0_br
+ u_t016_014/c3_w1_bl u_t016_014/c3_w1_br u_t016_014/c3_r0_rbl u_t016_014/c3_r1_rbl u_t016_014/r0_w0_wl
+ u_t016_014/r0_w1_wl u_t016_014/r0_r0_rwl u_t016_014/r0_r1_rwl u_t016_014/r1_w0_wl u_t016_014/r1_w1_wl
+ u_t016_014/r1_r0_rwl u_t016_014/r1_r1_rwl u_t016_014/r2_w0_wl u_t016_014/r2_w1_wl u_t016_014/r2_r0_rwl
+ u_t016_014/r2_r1_rwl u_t016_014/r3_w0_wl u_t016_014/r3_w1_wl u_t016_014/r3_r0_rwl u_t016_014/r3_r1_rwl VDD VSS VSUBS
+ detronyx_12t_2w2r_rc4_4x4_routed_5layer_direct
Xu_t007_003 u_t007_003/c0_w0_bl u_t007_003/c0_w0_br u_t007_003/c0_w1_bl u_t007_003/c0_w1_br u_t007_003/c0_r0_rbl
+ u_t007_003/c0_r1_rbl u_t007_003/c1_w0_bl u_t007_003/c1_w0_br u_t007_003/c1_w1_bl u_t007_003/c1_w1_br
+ u_t007_003/c1_r0_rbl u_t007_003/c1_r1_rbl u_t007_003/c2_w0_bl u_t007_003/c2_w0_br u_t007_003/c2_w1_bl
+ u_t007_003/c2_w1_br u_t007_003/c2_r0_rbl u_t007_003/c2_r1_rbl u_t007_003/c3_w0_bl u_t007_003/c3_w0_br
+ u_t007_003/c3_w1_bl u_t007_003/c3_w1_br u_t007_003/c3_r0_rbl u_t007_003/c3_r1_rbl u_t007_003/r0_w0_wl
+ u_t007_003/r0_w1_wl u_t007_003/r0_r0_rwl u_t007_003/r0_r1_rwl u_t007_003/r1_w0_wl u_t007_003/r1_w1_wl
+ u_t007_003/r1_r0_rwl u_t007_003/r1_r1_rwl u_t007_003/r2_w0_wl u_t007_003/r2_w1_wl u_t007_003/r2_r0_rwl
+ u_t007_003/r2_r1_rwl u_t007_003/r3_w0_wl u_t007_003/r3_w1_wl u_t007_003/r3_r0_rwl u_t007_003/r3_r1_rwl VDD VSS VSUBS
+ detronyx_12t_2w2r_rc4_4x4_routed_5layer_direct
Xu_t007_014 u_t007_014/c0_w0_bl u_t007_014/c0_w0_br u_t007_014/c0_w1_bl u_t007_014/c0_w1_br u_t007_014/c0_r0_rbl
+ u_t007_014/c0_r1_rbl u_t007_014/c1_w0_bl u_t007_014/c1_w0_br u_t007_014/c1_w1_bl u_t007_014/c1_w1_br
+ u_t007_014/c1_r0_rbl u_t007_014/c1_r1_rbl u_t007_014/c2_w0_bl u_t007_014/c2_w0_br u_t007_014/c2_w1_bl
+ u_t007_014/c2_w1_br u_t007_014/c2_r0_rbl u_t007_014/c2_r1_rbl u_t007_014/c3_w0_bl u_t007_014/c3_w0_br
+ u_t007_014/c3_w1_bl u_t007_014/c3_w1_br u_t007_014/c3_r0_rbl u_t007_014/c3_r1_rbl u_t007_014/r0_w0_wl
+ u_t007_014/r0_w1_wl u_t007_014/r0_r0_rwl u_t007_014/r0_r1_rwl u_t007_014/r1_w0_wl u_t007_014/r1_w1_wl
+ u_t007_014/r1_r0_rwl u_t007_014/r1_r1_rwl u_t007_014/r2_w0_wl u_t007_014/r2_w1_wl u_t007_014/r2_r0_rwl
+ u_t007_014/r2_r1_rwl u_t007_014/r3_w0_wl u_t007_014/r3_w1_wl u_t007_014/r3_r0_rwl u_t007_014/r3_r1_rwl VDD VSS VSUBS
+ detronyx_12t_2w2r_rc4_4x4_routed_5layer_direct
Xu_t022_006 u_t022_006/c0_w0_bl u_t022_006/c0_w0_br u_t022_006/c0_w1_bl u_t022_006/c0_w1_br u_t022_006/c0_r0_rbl
+ u_t022_006/c0_r1_rbl u_t022_006/c1_w0_bl u_t022_006/c1_w0_br u_t022_006/c1_w1_bl u_t022_006/c1_w1_br
+ u_t022_006/c1_r0_rbl u_t022_006/c1_r1_rbl u_t022_006/c2_w0_bl u_t022_006/c2_w0_br u_t022_006/c2_w1_bl
+ u_t022_006/c2_w1_br u_t022_006/c2_r0_rbl u_t022_006/c2_r1_rbl u_t022_006/c3_w0_bl u_t022_006/c3_w0_br
+ u_t022_006/c3_w1_bl u_t022_006/c3_w1_br u_t022_006/c3_r0_rbl u_t022_006/c3_r1_rbl u_t022_006/r0_w0_wl
+ u_t022_006/r0_w1_wl u_t022_006/r0_r0_rwl u_t022_006/r0_r1_rwl u_t022_006/r1_w0_wl u_t022_006/r1_w1_wl
+ u_t022_006/r1_r0_rwl u_t022_006/r1_r1_rwl u_t022_006/r2_w0_wl u_t022_006/r2_w1_wl u_t022_006/r2_r0_rwl
+ u_t022_006/r2_r1_rwl u_t022_006/r3_w0_wl u_t022_006/r3_w1_wl u_t022_006/r3_r0_rwl u_t022_006/r3_r1_rwl VDD VSS VSUBS
+ detronyx_12t_2w2r_rc4_4x4_routed_5layer_direct
Xu_t004_006 u_t004_006/c0_w0_bl u_t004_006/c0_w0_br u_t004_006/c0_w1_bl u_t004_006/c0_w1_br u_t004_006/c0_r0_rbl
+ u_t004_006/c0_r1_rbl u_t004_006/c1_w0_bl u_t004_006/c1_w0_br u_t004_006/c1_w1_bl u_t004_006/c1_w1_br
+ u_t004_006/c1_r0_rbl u_t004_006/c1_r1_rbl u_t004_006/c2_w0_bl u_t004_006/c2_w0_br u_t004_006/c2_w1_bl
+ u_t004_006/c2_w1_br u_t004_006/c2_r0_rbl u_t004_006/c2_r1_rbl u_t004_006/c3_w0_bl u_t004_006/c3_w0_br
+ u_t004_006/c3_w1_bl u_t004_006/c3_w1_br u_t004_006/c3_r0_rbl u_t004_006/c3_r1_rbl u_t004_006/r0_w0_wl
+ u_t004_006/r0_w1_wl u_t004_006/r0_r0_rwl u_t004_006/r0_r1_rwl u_t004_006/r1_w0_wl u_t004_006/r1_w1_wl
+ u_t004_006/r1_r0_rwl u_t004_006/r1_r1_rwl u_t004_006/r2_w0_wl u_t004_006/r2_w1_wl u_t004_006/r2_r0_rwl
+ u_t004_006/r2_r1_rwl u_t004_006/r3_w0_wl u_t004_006/r3_w1_wl u_t004_006/r3_r0_rwl u_t004_006/r3_r1_rwl VDD VSS VSUBS
+ detronyx_12t_2w2r_rc4_4x4_routed_5layer_direct
Xu_t013_006 u_t013_006/c0_w0_bl u_t013_006/c0_w0_br u_t013_006/c0_w1_bl u_t013_006/c0_w1_br u_t013_006/c0_r0_rbl
+ u_t013_006/c0_r1_rbl u_t013_006/c1_w0_bl u_t013_006/c1_w0_br u_t013_006/c1_w1_bl u_t013_006/c1_w1_br
+ u_t013_006/c1_r0_rbl u_t013_006/c1_r1_rbl u_t013_006/c2_w0_bl u_t013_006/c2_w0_br u_t013_006/c2_w1_bl
+ u_t013_006/c2_w1_br u_t013_006/c2_r0_rbl u_t013_006/c2_r1_rbl u_t013_006/c3_w0_bl u_t013_006/c3_w0_br
+ u_t013_006/c3_w1_bl u_t013_006/c3_w1_br u_t013_006/c3_r0_rbl u_t013_006/c3_r1_rbl u_t013_006/r0_w0_wl
+ u_t013_006/r0_w1_wl u_t013_006/r0_r0_rwl u_t013_006/r0_r1_rwl u_t013_006/r1_w0_wl u_t013_006/r1_w1_wl
+ u_t013_006/r1_r0_rwl u_t013_006/r1_r1_rwl u_t013_006/r2_w0_wl u_t013_006/r2_w1_wl u_t013_006/r2_r0_rwl
+ u_t013_006/r2_r1_rwl u_t013_006/r3_w0_wl u_t013_006/r3_w1_wl u_t013_006/r3_r0_rwl u_t013_006/r3_r1_rwl VDD VSS VSUBS
+ detronyx_12t_2w2r_rc4_4x4_routed_5layer_direct
Xu_t001_009 u_t001_009/c0_w0_bl u_t001_009/c0_w0_br u_t001_009/c0_w1_bl u_t001_009/c0_w1_br u_t001_009/c0_r0_rbl
+ u_t001_009/c0_r1_rbl u_t001_009/c1_w0_bl u_t001_009/c1_w0_br u_t001_009/c1_w1_bl u_t001_009/c1_w1_br
+ u_t001_009/c1_r0_rbl u_t001_009/c1_r1_rbl u_t001_009/c2_w0_bl u_t001_009/c2_w0_br u_t001_009/c2_w1_bl
+ u_t001_009/c2_w1_br u_t001_009/c2_r0_rbl u_t001_009/c2_r1_rbl u_t001_009/c3_w0_bl u_t001_009/c3_w0_br
+ u_t001_009/c3_w1_bl u_t001_009/c3_w1_br u_t001_009/c3_r0_rbl u_t001_009/c3_r1_rbl u_t001_009/r0_w0_wl
+ u_t001_009/r0_w1_wl u_t001_009/r0_r0_rwl u_t001_009/r0_r1_rwl u_t001_009/r1_w0_wl u_t001_009/r1_w1_wl
+ u_t001_009/r1_r0_rwl u_t001_009/r1_r1_rwl u_t001_009/r2_w0_wl u_t001_009/r2_w1_wl u_t001_009/r2_r0_rwl
+ u_t001_009/r2_r1_rwl u_t001_009/r3_w0_wl u_t001_009/r3_w1_wl u_t001_009/r3_r0_rwl u_t001_009/r3_r1_rwl VDD VSS VSUBS
+ detronyx_12t_2w2r_rc4_4x4_routed_5layer_direct
Xu_t010_009 u_t010_009/c0_w0_bl u_t010_009/c0_w0_br u_t010_009/c0_w1_bl u_t010_009/c0_w1_br u_t010_009/c0_r0_rbl
+ u_t010_009/c0_r1_rbl u_t010_009/c1_w0_bl u_t010_009/c1_w0_br u_t010_009/c1_w1_bl u_t010_009/c1_w1_br
+ u_t010_009/c1_r0_rbl u_t010_009/c1_r1_rbl u_t010_009/c2_w0_bl u_t010_009/c2_w0_br u_t010_009/c2_w1_bl
+ u_t010_009/c2_w1_br u_t010_009/c2_r0_rbl u_t010_009/c2_r1_rbl u_t010_009/c3_w0_bl u_t010_009/c3_w0_br
+ u_t010_009/c3_w1_bl u_t010_009/c3_w1_br u_t010_009/c3_r0_rbl u_t010_009/c3_r1_rbl u_t010_009/r0_w0_wl
+ u_t010_009/r0_w1_wl u_t010_009/r0_r0_rwl u_t010_009/r0_r1_rwl u_t010_009/r1_w0_wl u_t010_009/r1_w1_wl
+ u_t010_009/r1_r0_rwl u_t010_009/r1_r1_rwl u_t010_009/r2_w0_wl u_t010_009/r2_w1_wl u_t010_009/r2_r0_rwl
+ u_t010_009/r2_r1_rwl u_t010_009/r3_w0_wl u_t010_009/r3_w1_wl u_t010_009/r3_r0_rwl u_t010_009/r3_r1_rwl VDD VSS VSUBS
+ detronyx_12t_2w2r_rc4_4x4_routed_5layer_direct
Xu_t028_012 u_t028_012/c0_w0_bl u_t028_012/c0_w0_br u_t028_012/c0_w1_bl u_t028_012/c0_w1_br u_t028_012/c0_r0_rbl
+ u_t028_012/c0_r1_rbl u_t028_012/c1_w0_bl u_t028_012/c1_w0_br u_t028_012/c1_w1_bl u_t028_012/c1_w1_br
+ u_t028_012/c1_r0_rbl u_t028_012/c1_r1_rbl u_t028_012/c2_w0_bl u_t028_012/c2_w0_br u_t028_012/c2_w1_bl
+ u_t028_012/c2_w1_br u_t028_012/c2_r0_rbl u_t028_012/c2_r1_rbl u_t028_012/c3_w0_bl u_t028_012/c3_w0_br
+ u_t028_012/c3_w1_bl u_t028_012/c3_w1_br u_t028_012/c3_r0_rbl u_t028_012/c3_r1_rbl u_t028_012/r0_w0_wl
+ u_t028_012/r0_w1_wl u_t028_012/r0_r0_rwl u_t028_012/r0_r1_rwl u_t028_012/r1_w0_wl u_t028_012/r1_w1_wl
+ u_t028_012/r1_r0_rwl u_t028_012/r1_r1_rwl u_t028_012/r2_w0_wl u_t028_012/r2_w1_wl u_t028_012/r2_r0_rwl
+ u_t028_012/r2_r1_rwl u_t028_012/r3_w0_wl u_t028_012/r3_w1_wl u_t028_012/r3_r0_rwl u_t028_012/r3_r1_rwl VDD VSS VSUBS
+ detronyx_12t_2w2r_rc4_4x4_routed_5layer_direct
Xu_t028_001 u_t028_001/c0_w0_bl u_t028_001/c0_w0_br u_t028_001/c0_w1_bl u_t028_001/c0_w1_br u_t028_001/c0_r0_rbl
+ u_t028_001/c0_r1_rbl u_t028_001/c1_w0_bl u_t028_001/c1_w0_br u_t028_001/c1_w1_bl u_t028_001/c1_w1_br
+ u_t028_001/c1_r0_rbl u_t028_001/c1_r1_rbl u_t028_001/c2_w0_bl u_t028_001/c2_w0_br u_t028_001/c2_w1_bl
+ u_t028_001/c2_w1_br u_t028_001/c2_r0_rbl u_t028_001/c2_r1_rbl u_t028_001/c3_w0_bl u_t028_001/c3_w0_br
+ u_t028_001/c3_w1_bl u_t028_001/c3_w1_br u_t028_001/c3_r0_rbl u_t028_001/c3_r1_rbl u_t028_001/r0_w0_wl
+ u_t028_001/r0_w1_wl u_t028_001/r0_r0_rwl u_t028_001/r0_r1_rwl u_t028_001/r1_w0_wl u_t028_001/r1_w1_wl
+ u_t028_001/r1_r0_rwl u_t028_001/r1_r1_rwl u_t028_001/r2_w0_wl u_t028_001/r2_w1_wl u_t028_001/r2_r0_rwl
+ u_t028_001/r2_r1_rwl u_t028_001/r3_w0_wl u_t028_001/r3_w1_wl u_t028_001/r3_r0_rwl u_t028_001/r3_r1_rwl VDD VSS VSUBS
+ detronyx_12t_2w2r_rc4_4x4_routed_5layer_direct
Xu_t019_001 u_t019_001/c0_w0_bl u_t019_001/c0_w0_br u_t019_001/c0_w1_bl u_t019_001/c0_w1_br u_t019_001/c0_r0_rbl
+ u_t019_001/c0_r1_rbl u_t019_001/c1_w0_bl u_t019_001/c1_w0_br u_t019_001/c1_w1_bl u_t019_001/c1_w1_br
+ u_t019_001/c1_r0_rbl u_t019_001/c1_r1_rbl u_t019_001/c2_w0_bl u_t019_001/c2_w0_br u_t019_001/c2_w1_bl
+ u_t019_001/c2_w1_br u_t019_001/c2_r0_rbl u_t019_001/c2_r1_rbl u_t019_001/c3_w0_bl u_t019_001/c3_w0_br
+ u_t019_001/c3_w1_bl u_t019_001/c3_w1_br u_t019_001/c3_r0_rbl u_t019_001/c3_r1_rbl u_t019_001/r0_w0_wl
+ u_t019_001/r0_w1_wl u_t019_001/r0_r0_rwl u_t019_001/r0_r1_rwl u_t019_001/r1_w0_wl u_t019_001/r1_w1_wl
+ u_t019_001/r1_r0_rwl u_t019_001/r1_r1_rwl u_t019_001/r2_w0_wl u_t019_001/r2_w1_wl u_t019_001/r2_r0_rwl
+ u_t019_001/r2_r1_rwl u_t019_001/r3_w0_wl u_t019_001/r3_w1_wl u_t019_001/r3_r0_rwl u_t019_001/r3_r1_rwl VDD VSS VSUBS
+ detronyx_12t_2w2r_rc4_4x4_routed_5layer_direct
Xu_t019_012 u_t019_012/c0_w0_bl u_t019_012/c0_w0_br u_t019_012/c0_w1_bl u_t019_012/c0_w1_br u_t019_012/c0_r0_rbl
+ u_t019_012/c0_r1_rbl u_t019_012/c1_w0_bl u_t019_012/c1_w0_br u_t019_012/c1_w1_bl u_t019_012/c1_w1_br
+ u_t019_012/c1_r0_rbl u_t019_012/c1_r1_rbl u_t019_012/c2_w0_bl u_t019_012/c2_w0_br u_t019_012/c2_w1_bl
+ u_t019_012/c2_w1_br u_t019_012/c2_r0_rbl u_t019_012/c2_r1_rbl u_t019_012/c3_w0_bl u_t019_012/c3_w0_br
+ u_t019_012/c3_w1_bl u_t019_012/c3_w1_br u_t019_012/c3_r0_rbl u_t019_012/c3_r1_rbl u_t019_012/r0_w0_wl
+ u_t019_012/r0_w1_wl u_t019_012/r0_r0_rwl u_t019_012/r0_r1_rwl u_t019_012/r1_w0_wl u_t019_012/r1_w1_wl
+ u_t019_012/r1_r0_rwl u_t019_012/r1_r1_rwl u_t019_012/r2_w0_wl u_t019_012/r2_w1_wl u_t019_012/r2_r0_rwl
+ u_t019_012/r2_r1_rwl u_t019_012/r3_w0_wl u_t019_012/r3_w1_wl u_t019_012/r3_r0_rwl u_t019_012/r3_r1_rwl VDD VSS VSUBS
+ detronyx_12t_2w2r_rc4_4x4_routed_5layer_direct
Xu_t025_015 u_t025_015/c0_w0_bl u_t025_015/c0_w0_br u_t025_015/c0_w1_bl u_t025_015/c0_w1_br u_t025_015/c0_r0_rbl
+ u_t025_015/c0_r1_rbl u_t025_015/c1_w0_bl u_t025_015/c1_w0_br u_t025_015/c1_w1_bl u_t025_015/c1_w1_br
+ u_t025_015/c1_r0_rbl u_t025_015/c1_r1_rbl u_t025_015/c2_w0_bl u_t025_015/c2_w0_br u_t025_015/c2_w1_bl
+ u_t025_015/c2_w1_br u_t025_015/c2_r0_rbl u_t025_015/c2_r1_rbl u_t025_015/c3_w0_bl u_t025_015/c3_w0_br
+ u_t025_015/c3_w1_bl u_t025_015/c3_w1_br u_t025_015/c3_r0_rbl u_t025_015/c3_r1_rbl u_t025_015/r0_w0_wl
+ u_t025_015/r0_w1_wl u_t025_015/r0_r0_rwl u_t025_015/r0_r1_rwl u_t025_015/r1_w0_wl u_t025_015/r1_w1_wl
+ u_t025_015/r1_r0_rwl u_t025_015/r1_r1_rwl u_t025_015/r2_w0_wl u_t025_015/r2_w1_wl u_t025_015/r2_r0_rwl
+ u_t025_015/r2_r1_rwl u_t025_015/r3_w0_wl u_t025_015/r3_w1_wl u_t025_015/r3_r0_rwl u_t025_015/r3_r1_rwl VDD VSS VSUBS
+ detronyx_12t_2w2r_rc4_4x4_routed_5layer_direct
Xu_t025_004 u_t025_004/c0_w0_bl u_t025_004/c0_w0_br u_t025_004/c0_w1_bl u_t025_004/c0_w1_br u_t025_004/c0_r0_rbl
+ u_t025_004/c0_r1_rbl u_t025_004/c1_w0_bl u_t025_004/c1_w0_br u_t025_004/c1_w1_bl u_t025_004/c1_w1_br
+ u_t025_004/c1_r0_rbl u_t025_004/c1_r1_rbl u_t025_004/c2_w0_bl u_t025_004/c2_w0_br u_t025_004/c2_w1_bl
+ u_t025_004/c2_w1_br u_t025_004/c2_r0_rbl u_t025_004/c2_r1_rbl u_t025_004/c3_w0_bl u_t025_004/c3_w0_br
+ u_t025_004/c3_w1_bl u_t025_004/c3_w1_br u_t025_004/c3_r0_rbl u_t025_004/c3_r1_rbl u_t025_004/r0_w0_wl
+ u_t025_004/r0_w1_wl u_t025_004/r0_r0_rwl u_t025_004/r0_r1_rwl u_t025_004/r1_w0_wl u_t025_004/r1_w1_wl
+ u_t025_004/r1_r0_rwl u_t025_004/r1_r1_rwl u_t025_004/r2_w0_wl u_t025_004/r2_w1_wl u_t025_004/r2_r0_rwl
+ u_t025_004/r2_r1_rwl u_t025_004/r3_w0_wl u_t025_004/r3_w1_wl u_t025_004/r3_r0_rwl u_t025_004/r3_r1_rwl VDD VSS VSUBS
+ detronyx_12t_2w2r_rc4_4x4_routed_5layer_direct
Xu_t031_007 u_t031_007/c0_w0_bl u_t031_007/c0_w0_br u_t031_007/c0_w1_bl u_t031_007/c0_w1_br u_t031_007/c0_r0_rbl
+ u_t031_007/c0_r1_rbl u_t031_007/c1_w0_bl u_t031_007/c1_w0_br u_t031_007/c1_w1_bl u_t031_007/c1_w1_br
+ u_t031_007/c1_r0_rbl u_t031_007/c1_r1_rbl u_t031_007/c2_w0_bl u_t031_007/c2_w0_br u_t031_007/c2_w1_bl
+ u_t031_007/c2_w1_br u_t031_007/c2_r0_rbl u_t031_007/c2_r1_rbl u_t031_007/c3_w0_bl u_t031_007/c3_w0_br
+ u_t031_007/c3_w1_bl u_t031_007/c3_w1_br u_t031_007/c3_r0_rbl u_t031_007/c3_r1_rbl u_t031_007/r0_w0_wl
+ u_t031_007/r0_w1_wl u_t031_007/r0_r0_rwl u_t031_007/r0_r1_rwl u_t031_007/r1_w0_wl u_t031_007/r1_w1_wl
+ u_t031_007/r1_r0_rwl u_t031_007/r1_r1_rwl u_t031_007/r2_w0_wl u_t031_007/r2_w1_wl u_t031_007/r2_r0_rwl
+ u_t031_007/r2_r1_rwl u_t031_007/r3_w0_wl u_t031_007/r3_w1_wl u_t031_007/r3_r0_rwl u_t031_007/r3_r1_rwl VDD VSS VSUBS
+ detronyx_12t_2w2r_rc4_4x4_routed_5layer_direct
Xu_t016_004 u_t016_004/c0_w0_bl u_t016_004/c0_w0_br u_t016_004/c0_w1_bl u_t016_004/c0_w1_br u_t016_004/c0_r0_rbl
+ u_t016_004/c0_r1_rbl u_t016_004/c1_w0_bl u_t016_004/c1_w0_br u_t016_004/c1_w1_bl u_t016_004/c1_w1_br
+ u_t016_004/c1_r0_rbl u_t016_004/c1_r1_rbl u_t016_004/c2_w0_bl u_t016_004/c2_w0_br u_t016_004/c2_w1_bl
+ u_t016_004/c2_w1_br u_t016_004/c2_r0_rbl u_t016_004/c2_r1_rbl u_t016_004/c3_w0_bl u_t016_004/c3_w0_br
+ u_t016_004/c3_w1_bl u_t016_004/c3_w1_br u_t016_004/c3_r0_rbl u_t016_004/c3_r1_rbl u_t016_004/r0_w0_wl
+ u_t016_004/r0_w1_wl u_t016_004/r0_r0_rwl u_t016_004/r0_r1_rwl u_t016_004/r1_w0_wl u_t016_004/r1_w1_wl
+ u_t016_004/r1_r0_rwl u_t016_004/r1_r1_rwl u_t016_004/r2_w0_wl u_t016_004/r2_w1_wl u_t016_004/r2_r0_rwl
+ u_t016_004/r2_r1_rwl u_t016_004/r3_w0_wl u_t016_004/r3_w1_wl u_t016_004/r3_r0_rwl u_t016_004/r3_r1_rwl VDD VSS VSUBS
+ detronyx_12t_2w2r_rc4_4x4_routed_5layer_direct
Xu_t016_015 u_t016_015/c0_w0_bl u_t016_015/c0_w0_br u_t016_015/c0_w1_bl u_t016_015/c0_w1_br u_t016_015/c0_r0_rbl
+ u_t016_015/c0_r1_rbl u_t016_015/c1_w0_bl u_t016_015/c1_w0_br u_t016_015/c1_w1_bl u_t016_015/c1_w1_br
+ u_t016_015/c1_r0_rbl u_t016_015/c1_r1_rbl u_t016_015/c2_w0_bl u_t016_015/c2_w0_br u_t016_015/c2_w1_bl
+ u_t016_015/c2_w1_br u_t016_015/c2_r0_rbl u_t016_015/c2_r1_rbl u_t016_015/c3_w0_bl u_t016_015/c3_w0_br
+ u_t016_015/c3_w1_bl u_t016_015/c3_w1_br u_t016_015/c3_r0_rbl u_t016_015/c3_r1_rbl u_t016_015/r0_w0_wl
+ u_t016_015/r0_w1_wl u_t016_015/r0_r0_rwl u_t016_015/r0_r1_rwl u_t016_015/r1_w0_wl u_t016_015/r1_w1_wl
+ u_t016_015/r1_r0_rwl u_t016_015/r1_r1_rwl u_t016_015/r2_w0_wl u_t016_015/r2_w1_wl u_t016_015/r2_r0_rwl
+ u_t016_015/r2_r1_rwl u_t016_015/r3_w0_wl u_t016_015/r3_w1_wl u_t016_015/r3_r0_rwl u_t016_015/r3_r1_rwl VDD VSS VSUBS
+ detronyx_12t_2w2r_rc4_4x4_routed_5layer_direct
Xu_t007_004 u_t007_004/c0_w0_bl u_t007_004/c0_w0_br u_t007_004/c0_w1_bl u_t007_004/c0_w1_br u_t007_004/c0_r0_rbl
+ u_t007_004/c0_r1_rbl u_t007_004/c1_w0_bl u_t007_004/c1_w0_br u_t007_004/c1_w1_bl u_t007_004/c1_w1_br
+ u_t007_004/c1_r0_rbl u_t007_004/c1_r1_rbl u_t007_004/c2_w0_bl u_t007_004/c2_w0_br u_t007_004/c2_w1_bl
+ u_t007_004/c2_w1_br u_t007_004/c2_r0_rbl u_t007_004/c2_r1_rbl u_t007_004/c3_w0_bl u_t007_004/c3_w0_br
+ u_t007_004/c3_w1_bl u_t007_004/c3_w1_br u_t007_004/c3_r0_rbl u_t007_004/c3_r1_rbl u_t007_004/r0_w0_wl
+ u_t007_004/r0_w1_wl u_t007_004/r0_r0_rwl u_t007_004/r0_r1_rwl u_t007_004/r1_w0_wl u_t007_004/r1_w1_wl
+ u_t007_004/r1_r0_rwl u_t007_004/r1_r1_rwl u_t007_004/r2_w0_wl u_t007_004/r2_w1_wl u_t007_004/r2_r0_rwl
+ u_t007_004/r2_r1_rwl u_t007_004/r3_w0_wl u_t007_004/r3_w1_wl u_t007_004/r3_r0_rwl u_t007_004/r3_r1_rwl VDD VSS VSUBS
+ detronyx_12t_2w2r_rc4_4x4_routed_5layer_direct
Xu_t007_015 u_t007_015/c0_w0_bl u_t007_015/c0_w0_br u_t007_015/c0_w1_bl u_t007_015/c0_w1_br u_t007_015/c0_r0_rbl
+ u_t007_015/c0_r1_rbl u_t007_015/c1_w0_bl u_t007_015/c1_w0_br u_t007_015/c1_w1_bl u_t007_015/c1_w1_br
+ u_t007_015/c1_r0_rbl u_t007_015/c1_r1_rbl u_t007_015/c2_w0_bl u_t007_015/c2_w0_br u_t007_015/c2_w1_bl
+ u_t007_015/c2_w1_br u_t007_015/c2_r0_rbl u_t007_015/c2_r1_rbl u_t007_015/c3_w0_bl u_t007_015/c3_w0_br
+ u_t007_015/c3_w1_bl u_t007_015/c3_w1_br u_t007_015/c3_r0_rbl u_t007_015/c3_r1_rbl u_t007_015/r0_w0_wl
+ u_t007_015/r0_w1_wl u_t007_015/r0_r0_rwl u_t007_015/r0_r1_rwl u_t007_015/r1_w0_wl u_t007_015/r1_w1_wl
+ u_t007_015/r1_r0_rwl u_t007_015/r1_r1_rwl u_t007_015/r2_w0_wl u_t007_015/r2_w1_wl u_t007_015/r2_r0_rwl
+ u_t007_015/r2_r1_rwl u_t007_015/r3_w0_wl u_t007_015/r3_w1_wl u_t007_015/r3_r0_rwl u_t007_015/r3_r1_rwl VDD VSS VSUBS
+ detronyx_12t_2w2r_rc4_4x4_routed_5layer_direct
Xu_t022_007 u_t022_007/c0_w0_bl u_t022_007/c0_w0_br u_t022_007/c0_w1_bl u_t022_007/c0_w1_br u_t022_007/c0_r0_rbl
+ u_t022_007/c0_r1_rbl u_t022_007/c1_w0_bl u_t022_007/c1_w0_br u_t022_007/c1_w1_bl u_t022_007/c1_w1_br
+ u_t022_007/c1_r0_rbl u_t022_007/c1_r1_rbl u_t022_007/c2_w0_bl u_t022_007/c2_w0_br u_t022_007/c2_w1_bl
+ u_t022_007/c2_w1_br u_t022_007/c2_r0_rbl u_t022_007/c2_r1_rbl u_t022_007/c3_w0_bl u_t022_007/c3_w0_br
+ u_t022_007/c3_w1_bl u_t022_007/c3_w1_br u_t022_007/c3_r0_rbl u_t022_007/c3_r1_rbl u_t022_007/r0_w0_wl
+ u_t022_007/r0_w1_wl u_t022_007/r0_r0_rwl u_t022_007/r0_r1_rwl u_t022_007/r1_w0_wl u_t022_007/r1_w1_wl
+ u_t022_007/r1_r0_rwl u_t022_007/r1_r1_rwl u_t022_007/r2_w0_wl u_t022_007/r2_w1_wl u_t022_007/r2_r0_rwl
+ u_t022_007/r2_r1_rwl u_t022_007/r3_w0_wl u_t022_007/r3_w1_wl u_t022_007/r3_r0_rwl u_t022_007/r3_r1_rwl VDD VSS VSUBS
+ detronyx_12t_2w2r_rc4_4x4_routed_5layer_direct
Xu_t013_007 u_t013_007/c0_w0_bl u_t013_007/c0_w0_br u_t013_007/c0_w1_bl u_t013_007/c0_w1_br u_t013_007/c0_r0_rbl
+ u_t013_007/c0_r1_rbl u_t013_007/c1_w0_bl u_t013_007/c1_w0_br u_t013_007/c1_w1_bl u_t013_007/c1_w1_br
+ u_t013_007/c1_r0_rbl u_t013_007/c1_r1_rbl u_t013_007/c2_w0_bl u_t013_007/c2_w0_br u_t013_007/c2_w1_bl
+ u_t013_007/c2_w1_br u_t013_007/c2_r0_rbl u_t013_007/c2_r1_rbl u_t013_007/c3_w0_bl u_t013_007/c3_w0_br
+ u_t013_007/c3_w1_bl u_t013_007/c3_w1_br u_t013_007/c3_r0_rbl u_t013_007/c3_r1_rbl u_t013_007/r0_w0_wl
+ u_t013_007/r0_w1_wl u_t013_007/r0_r0_rwl u_t013_007/r0_r1_rwl u_t013_007/r1_w0_wl u_t013_007/r1_w1_wl
+ u_t013_007/r1_r0_rwl u_t013_007/r1_r1_rwl u_t013_007/r2_w0_wl u_t013_007/r2_w1_wl u_t013_007/r2_r0_rwl
+ u_t013_007/r2_r1_rwl u_t013_007/r3_w0_wl u_t013_007/r3_w1_wl u_t013_007/r3_r0_rwl u_t013_007/r3_r1_rwl VDD VSS VSUBS
+ detronyx_12t_2w2r_rc4_4x4_routed_5layer_direct
Xu_t004_007 u_t004_007/c0_w0_bl u_t004_007/c0_w0_br u_t004_007/c0_w1_bl u_t004_007/c0_w1_br u_t004_007/c0_r0_rbl
+ u_t004_007/c0_r1_rbl u_t004_007/c1_w0_bl u_t004_007/c1_w0_br u_t004_007/c1_w1_bl u_t004_007/c1_w1_br
+ u_t004_007/c1_r0_rbl u_t004_007/c1_r1_rbl u_t004_007/c2_w0_bl u_t004_007/c2_w0_br u_t004_007/c2_w1_bl
+ u_t004_007/c2_w1_br u_t004_007/c2_r0_rbl u_t004_007/c2_r1_rbl u_t004_007/c3_w0_bl u_t004_007/c3_w0_br
+ u_t004_007/c3_w1_bl u_t004_007/c3_w1_br u_t004_007/c3_r0_rbl u_t004_007/c3_r1_rbl u_t004_007/r0_w0_wl
+ u_t004_007/r0_w1_wl u_t004_007/r0_r0_rwl u_t004_007/r0_r1_rwl u_t004_007/r1_w0_wl u_t004_007/r1_w1_wl
+ u_t004_007/r1_r0_rwl u_t004_007/r1_r1_rwl u_t004_007/r2_w0_wl u_t004_007/r2_w1_wl u_t004_007/r2_r0_rwl
+ u_t004_007/r2_r1_rwl u_t004_007/r3_w0_wl u_t004_007/r3_w1_wl u_t004_007/r3_r0_rwl u_t004_007/r3_r1_rwl VDD VSS VSUBS
+ detronyx_12t_2w2r_rc4_4x4_routed_5layer_direct
Xu_t000_010 u_t000_010/c0_w0_bl u_t000_010/c0_w0_br u_t000_010/c0_w1_bl u_t000_010/c0_w1_br u_t000_010/c0_r0_rbl
+ u_t000_010/c0_r1_rbl u_t000_010/c1_w0_bl u_t000_010/c1_w0_br u_t000_010/c1_w1_bl u_t000_010/c1_w1_br
+ u_t000_010/c1_r0_rbl u_t000_010/c1_r1_rbl u_t000_010/c2_w0_bl u_t000_010/c2_w0_br u_t000_010/c2_w1_bl
+ u_t000_010/c2_w1_br u_t000_010/c2_r0_rbl u_t000_010/c2_r1_rbl u_t000_010/c3_w0_bl u_t000_010/c3_w0_br
+ u_t000_010/c3_w1_bl u_t000_010/c3_w1_br u_t000_010/c3_r0_rbl u_t000_010/c3_r1_rbl u_t000_010/r0_w0_wl
+ u_t000_010/r0_w1_wl u_t000_010/r0_r0_rwl u_t000_010/r0_r1_rwl u_t000_010/r1_w0_wl u_t000_010/r1_w1_wl
+ u_t000_010/r1_r0_rwl u_t000_010/r1_r1_rwl u_t000_010/r2_w0_wl u_t000_010/r2_w1_wl u_t000_010/r2_r0_rwl
+ u_t000_010/r2_r1_rwl u_t000_010/r3_w0_wl u_t000_010/r3_w1_wl u_t000_010/r3_r0_rwl u_t000_010/r3_r1_rwl VDD VSS VSUBS
+ detronyx_12t_2w2r_rc4_4x4_routed_5layer_direct
Xu_t028_013 u_t028_013/c0_w0_bl u_t028_013/c0_w0_br u_t028_013/c0_w1_bl u_t028_013/c0_w1_br u_t028_013/c0_r0_rbl
+ u_t028_013/c0_r1_rbl u_t028_013/c1_w0_bl u_t028_013/c1_w0_br u_t028_013/c1_w1_bl u_t028_013/c1_w1_br
+ u_t028_013/c1_r0_rbl u_t028_013/c1_r1_rbl u_t028_013/c2_w0_bl u_t028_013/c2_w0_br u_t028_013/c2_w1_bl
+ u_t028_013/c2_w1_br u_t028_013/c2_r0_rbl u_t028_013/c2_r1_rbl u_t028_013/c3_w0_bl u_t028_013/c3_w0_br
+ u_t028_013/c3_w1_bl u_t028_013/c3_w1_br u_t028_013/c3_r0_rbl u_t028_013/c3_r1_rbl u_t028_013/r0_w0_wl
+ u_t028_013/r0_w1_wl u_t028_013/r0_r0_rwl u_t028_013/r0_r1_rwl u_t028_013/r1_w0_wl u_t028_013/r1_w1_wl
+ u_t028_013/r1_r0_rwl u_t028_013/r1_r1_rwl u_t028_013/r2_w0_wl u_t028_013/r2_w1_wl u_t028_013/r2_r0_rwl
+ u_t028_013/r2_r1_rwl u_t028_013/r3_w0_wl u_t028_013/r3_w1_wl u_t028_013/r3_r0_rwl u_t028_013/r3_r1_rwl VDD VSS VSUBS
+ detronyx_12t_2w2r_rc4_4x4_routed_5layer_direct
Xu_t028_002 u_t028_002/c0_w0_bl u_t028_002/c0_w0_br u_t028_002/c0_w1_bl u_t028_002/c0_w1_br u_t028_002/c0_r0_rbl
+ u_t028_002/c0_r1_rbl u_t028_002/c1_w0_bl u_t028_002/c1_w0_br u_t028_002/c1_w1_bl u_t028_002/c1_w1_br
+ u_t028_002/c1_r0_rbl u_t028_002/c1_r1_rbl u_t028_002/c2_w0_bl u_t028_002/c2_w0_br u_t028_002/c2_w1_bl
+ u_t028_002/c2_w1_br u_t028_002/c2_r0_rbl u_t028_002/c2_r1_rbl u_t028_002/c3_w0_bl u_t028_002/c3_w0_br
+ u_t028_002/c3_w1_bl u_t028_002/c3_w1_br u_t028_002/c3_r0_rbl u_t028_002/c3_r1_rbl u_t028_002/r0_w0_wl
+ u_t028_002/r0_w1_wl u_t028_002/r0_r0_rwl u_t028_002/r0_r1_rwl u_t028_002/r1_w0_wl u_t028_002/r1_w1_wl
+ u_t028_002/r1_r0_rwl u_t028_002/r1_r1_rwl u_t028_002/r2_w0_wl u_t028_002/r2_w1_wl u_t028_002/r2_r0_rwl
+ u_t028_002/r2_r1_rwl u_t028_002/r3_w0_wl u_t028_002/r3_w1_wl u_t028_002/r3_r0_rwl u_t028_002/r3_r1_rwl VDD VSS VSUBS
+ detronyx_12t_2w2r_rc4_4x4_routed_5layer_direct
Xu_t019_002 u_t019_002/c0_w0_bl u_t019_002/c0_w0_br u_t019_002/c0_w1_bl u_t019_002/c0_w1_br u_t019_002/c0_r0_rbl
+ u_t019_002/c0_r1_rbl u_t019_002/c1_w0_bl u_t019_002/c1_w0_br u_t019_002/c1_w1_bl u_t019_002/c1_w1_br
+ u_t019_002/c1_r0_rbl u_t019_002/c1_r1_rbl u_t019_002/c2_w0_bl u_t019_002/c2_w0_br u_t019_002/c2_w1_bl
+ u_t019_002/c2_w1_br u_t019_002/c2_r0_rbl u_t019_002/c2_r1_rbl u_t019_002/c3_w0_bl u_t019_002/c3_w0_br
+ u_t019_002/c3_w1_bl u_t019_002/c3_w1_br u_t019_002/c3_r0_rbl u_t019_002/c3_r1_rbl u_t019_002/r0_w0_wl
+ u_t019_002/r0_w1_wl u_t019_002/r0_r0_rwl u_t019_002/r0_r1_rwl u_t019_002/r1_w0_wl u_t019_002/r1_w1_wl
+ u_t019_002/r1_r0_rwl u_t019_002/r1_r1_rwl u_t019_002/r2_w0_wl u_t019_002/r2_w1_wl u_t019_002/r2_r0_rwl
+ u_t019_002/r2_r1_rwl u_t019_002/r3_w0_wl u_t019_002/r3_w1_wl u_t019_002/r3_r0_rwl u_t019_002/r3_r1_rwl VDD VSS VSUBS
+ detronyx_12t_2w2r_rc4_4x4_routed_5layer_direct
Xu_t019_013 u_t019_013/c0_w0_bl u_t019_013/c0_w0_br u_t019_013/c0_w1_bl u_t019_013/c0_w1_br u_t019_013/c0_r0_rbl
+ u_t019_013/c0_r1_rbl u_t019_013/c1_w0_bl u_t019_013/c1_w0_br u_t019_013/c1_w1_bl u_t019_013/c1_w1_br
+ u_t019_013/c1_r0_rbl u_t019_013/c1_r1_rbl u_t019_013/c2_w0_bl u_t019_013/c2_w0_br u_t019_013/c2_w1_bl
+ u_t019_013/c2_w1_br u_t019_013/c2_r0_rbl u_t019_013/c2_r1_rbl u_t019_013/c3_w0_bl u_t019_013/c3_w0_br
+ u_t019_013/c3_w1_bl u_t019_013/c3_w1_br u_t019_013/c3_r0_rbl u_t019_013/c3_r1_rbl u_t019_013/r0_w0_wl
+ u_t019_013/r0_w1_wl u_t019_013/r0_r0_rwl u_t019_013/r0_r1_rwl u_t019_013/r1_w0_wl u_t019_013/r1_w1_wl
+ u_t019_013/r1_r0_rwl u_t019_013/r1_r1_rwl u_t019_013/r2_w0_wl u_t019_013/r2_w1_wl u_t019_013/r2_r0_rwl
+ u_t019_013/r2_r1_rwl u_t019_013/r3_w0_wl u_t019_013/r3_w1_wl u_t019_013/r3_r0_rwl u_t019_013/r3_r1_rwl VDD VSS VSUBS
+ detronyx_12t_2w2r_rc4_4x4_routed_5layer_direct
Xu_t025_005 u_t025_005/c0_w0_bl u_t025_005/c0_w0_br u_t025_005/c0_w1_bl u_t025_005/c0_w1_br u_t025_005/c0_r0_rbl
+ u_t025_005/c0_r1_rbl u_t025_005/c1_w0_bl u_t025_005/c1_w0_br u_t025_005/c1_w1_bl u_t025_005/c1_w1_br
+ u_t025_005/c1_r0_rbl u_t025_005/c1_r1_rbl u_t025_005/c2_w0_bl u_t025_005/c2_w0_br u_t025_005/c2_w1_bl
+ u_t025_005/c2_w1_br u_t025_005/c2_r0_rbl u_t025_005/c2_r1_rbl u_t025_005/c3_w0_bl u_t025_005/c3_w0_br
+ u_t025_005/c3_w1_bl u_t025_005/c3_w1_br u_t025_005/c3_r0_rbl u_t025_005/c3_r1_rbl u_t025_005/r0_w0_wl
+ u_t025_005/r0_w1_wl u_t025_005/r0_r0_rwl u_t025_005/r0_r1_rwl u_t025_005/r1_w0_wl u_t025_005/r1_w1_wl
+ u_t025_005/r1_r0_rwl u_t025_005/r1_r1_rwl u_t025_005/r2_w0_wl u_t025_005/r2_w1_wl u_t025_005/r2_r0_rwl
+ u_t025_005/r2_r1_rwl u_t025_005/r3_w0_wl u_t025_005/r3_w1_wl u_t025_005/r3_r0_rwl u_t025_005/r3_r1_rwl VDD VSS VSUBS
+ detronyx_12t_2w2r_rc4_4x4_routed_5layer_direct
Xu_t031_008 u_t031_008/c0_w0_bl u_t031_008/c0_w0_br u_t031_008/c0_w1_bl u_t031_008/c0_w1_br u_t031_008/c0_r0_rbl
+ u_t031_008/c0_r1_rbl u_t031_008/c1_w0_bl u_t031_008/c1_w0_br u_t031_008/c1_w1_bl u_t031_008/c1_w1_br
+ u_t031_008/c1_r0_rbl u_t031_008/c1_r1_rbl u_t031_008/c2_w0_bl u_t031_008/c2_w0_br u_t031_008/c2_w1_bl
+ u_t031_008/c2_w1_br u_t031_008/c2_r0_rbl u_t031_008/c2_r1_rbl u_t031_008/c3_w0_bl u_t031_008/c3_w0_br
+ u_t031_008/c3_w1_bl u_t031_008/c3_w1_br u_t031_008/c3_r0_rbl u_t031_008/c3_r1_rbl u_t031_008/r0_w0_wl
+ u_t031_008/r0_w1_wl u_t031_008/r0_r0_rwl u_t031_008/r0_r1_rwl u_t031_008/r1_w0_wl u_t031_008/r1_w1_wl
+ u_t031_008/r1_r0_rwl u_t031_008/r1_r1_rwl u_t031_008/r2_w0_wl u_t031_008/r2_w1_wl u_t031_008/r2_r0_rwl
+ u_t031_008/r2_r1_rwl u_t031_008/r3_w0_wl u_t031_008/r3_w1_wl u_t031_008/r3_r0_rwl u_t031_008/r3_r1_rwl VDD VSS VSUBS
+ detronyx_12t_2w2r_rc4_4x4_routed_5layer_direct
Xu_t016_005 u_t016_005/c0_w0_bl u_t016_005/c0_w0_br u_t016_005/c0_w1_bl u_t016_005/c0_w1_br u_t016_005/c0_r0_rbl
+ u_t016_005/c0_r1_rbl u_t016_005/c1_w0_bl u_t016_005/c1_w0_br u_t016_005/c1_w1_bl u_t016_005/c1_w1_br
+ u_t016_005/c1_r0_rbl u_t016_005/c1_r1_rbl u_t016_005/c2_w0_bl u_t016_005/c2_w0_br u_t016_005/c2_w1_bl
+ u_t016_005/c2_w1_br u_t016_005/c2_r0_rbl u_t016_005/c2_r1_rbl u_t016_005/c3_w0_bl u_t016_005/c3_w0_br
+ u_t016_005/c3_w1_bl u_t016_005/c3_w1_br u_t016_005/c3_r0_rbl u_t016_005/c3_r1_rbl u_t016_005/r0_w0_wl
+ u_t016_005/r0_w1_wl u_t016_005/r0_r0_rwl u_t016_005/r0_r1_rwl u_t016_005/r1_w0_wl u_t016_005/r1_w1_wl
+ u_t016_005/r1_r0_rwl u_t016_005/r1_r1_rwl u_t016_005/r2_w0_wl u_t016_005/r2_w1_wl u_t016_005/r2_r0_rwl
+ u_t016_005/r2_r1_rwl u_t016_005/r3_w0_wl u_t016_005/r3_w1_wl u_t016_005/r3_r0_rwl u_t016_005/r3_r1_rwl VDD VSS VSUBS
+ detronyx_12t_2w2r_rc4_4x4_routed_5layer_direct
Xu_t007_005 u_t007_005/c0_w0_bl u_t007_005/c0_w0_br u_t007_005/c0_w1_bl u_t007_005/c0_w1_br u_t007_005/c0_r0_rbl
+ u_t007_005/c0_r1_rbl u_t007_005/c1_w0_bl u_t007_005/c1_w0_br u_t007_005/c1_w1_bl u_t007_005/c1_w1_br
+ u_t007_005/c1_r0_rbl u_t007_005/c1_r1_rbl u_t007_005/c2_w0_bl u_t007_005/c2_w0_br u_t007_005/c2_w1_bl
+ u_t007_005/c2_w1_br u_t007_005/c2_r0_rbl u_t007_005/c2_r1_rbl u_t007_005/c3_w0_bl u_t007_005/c3_w0_br
+ u_t007_005/c3_w1_bl u_t007_005/c3_w1_br u_t007_005/c3_r0_rbl u_t007_005/c3_r1_rbl u_t007_005/r0_w0_wl
+ u_t007_005/r0_w1_wl u_t007_005/r0_r0_rwl u_t007_005/r0_r1_rwl u_t007_005/r1_w0_wl u_t007_005/r1_w1_wl
+ u_t007_005/r1_r0_rwl u_t007_005/r1_r1_rwl u_t007_005/r2_w0_wl u_t007_005/r2_w1_wl u_t007_005/r2_r0_rwl
+ u_t007_005/r2_r1_rwl u_t007_005/r3_w0_wl u_t007_005/r3_w1_wl u_t007_005/r3_r0_rwl u_t007_005/r3_r1_rwl VDD VSS VSUBS
+ detronyx_12t_2w2r_rc4_4x4_routed_5layer_direct
Xu_t022_008 u_t022_008/c0_w0_bl u_t022_008/c0_w0_br u_t022_008/c0_w1_bl u_t022_008/c0_w1_br u_t022_008/c0_r0_rbl
+ u_t022_008/c0_r1_rbl u_t022_008/c1_w0_bl u_t022_008/c1_w0_br u_t022_008/c1_w1_bl u_t022_008/c1_w1_br
+ u_t022_008/c1_r0_rbl u_t022_008/c1_r1_rbl u_t022_008/c2_w0_bl u_t022_008/c2_w0_br u_t022_008/c2_w1_bl
+ u_t022_008/c2_w1_br u_t022_008/c2_r0_rbl u_t022_008/c2_r1_rbl u_t022_008/c3_w0_bl u_t022_008/c3_w0_br
+ u_t022_008/c3_w1_bl u_t022_008/c3_w1_br u_t022_008/c3_r0_rbl u_t022_008/c3_r1_rbl u_t022_008/r0_w0_wl
+ u_t022_008/r0_w1_wl u_t022_008/r0_r0_rwl u_t022_008/r0_r1_rwl u_t022_008/r1_w0_wl u_t022_008/r1_w1_wl
+ u_t022_008/r1_r0_rwl u_t022_008/r1_r1_rwl u_t022_008/r2_w0_wl u_t022_008/r2_w1_wl u_t022_008/r2_r0_rwl
+ u_t022_008/r2_r1_rwl u_t022_008/r3_w0_wl u_t022_008/r3_w1_wl u_t022_008/r3_r0_rwl u_t022_008/r3_r1_rwl VDD VSS VSUBS
+ detronyx_12t_2w2r_rc4_4x4_routed_5layer_direct
Xu_t013_008 u_t013_008/c0_w0_bl u_t013_008/c0_w0_br u_t013_008/c0_w1_bl u_t013_008/c0_w1_br u_t013_008/c0_r0_rbl
+ u_t013_008/c0_r1_rbl u_t013_008/c1_w0_bl u_t013_008/c1_w0_br u_t013_008/c1_w1_bl u_t013_008/c1_w1_br
+ u_t013_008/c1_r0_rbl u_t013_008/c1_r1_rbl u_t013_008/c2_w0_bl u_t013_008/c2_w0_br u_t013_008/c2_w1_bl
+ u_t013_008/c2_w1_br u_t013_008/c2_r0_rbl u_t013_008/c2_r1_rbl u_t013_008/c3_w0_bl u_t013_008/c3_w0_br
+ u_t013_008/c3_w1_bl u_t013_008/c3_w1_br u_t013_008/c3_r0_rbl u_t013_008/c3_r1_rbl u_t013_008/r0_w0_wl
+ u_t013_008/r0_w1_wl u_t013_008/r0_r0_rwl u_t013_008/r0_r1_rwl u_t013_008/r1_w0_wl u_t013_008/r1_w1_wl
+ u_t013_008/r1_r0_rwl u_t013_008/r1_r1_rwl u_t013_008/r2_w0_wl u_t013_008/r2_w1_wl u_t013_008/r2_r0_rwl
+ u_t013_008/r2_r1_rwl u_t013_008/r3_w0_wl u_t013_008/r3_w1_wl u_t013_008/r3_r0_rwl u_t013_008/r3_r1_rwl VDD VSS VSUBS
+ detronyx_12t_2w2r_rc4_4x4_routed_5layer_direct
Xu_t004_008 u_t004_008/c0_w0_bl u_t004_008/c0_w0_br u_t004_008/c0_w1_bl u_t004_008/c0_w1_br u_t004_008/c0_r0_rbl
+ u_t004_008/c0_r1_rbl u_t004_008/c1_w0_bl u_t004_008/c1_w0_br u_t004_008/c1_w1_bl u_t004_008/c1_w1_br
+ u_t004_008/c1_r0_rbl u_t004_008/c1_r1_rbl u_t004_008/c2_w0_bl u_t004_008/c2_w0_br u_t004_008/c2_w1_bl
+ u_t004_008/c2_w1_br u_t004_008/c2_r0_rbl u_t004_008/c2_r1_rbl u_t004_008/c3_w0_bl u_t004_008/c3_w0_br
+ u_t004_008/c3_w1_bl u_t004_008/c3_w1_br u_t004_008/c3_r0_rbl u_t004_008/c3_r1_rbl u_t004_008/r0_w0_wl
+ u_t004_008/r0_w1_wl u_t004_008/r0_r0_rwl u_t004_008/r0_r1_rwl u_t004_008/r1_w0_wl u_t004_008/r1_w1_wl
+ u_t004_008/r1_r0_rwl u_t004_008/r1_r1_rwl u_t004_008/r2_w0_wl u_t004_008/r2_w1_wl u_t004_008/r2_r0_rwl
+ u_t004_008/r2_r1_rwl u_t004_008/r3_w0_wl u_t004_008/r3_w1_wl u_t004_008/r3_r0_rwl u_t004_008/r3_r1_rwl VDD VSS VSUBS
+ detronyx_12t_2w2r_rc4_4x4_routed_5layer_direct
Xu_t000_011 u_t000_011/c0_w0_bl u_t000_011/c0_w0_br u_t000_011/c0_w1_bl u_t000_011/c0_w1_br u_t000_011/c0_r0_rbl
+ u_t000_011/c0_r1_rbl u_t000_011/c1_w0_bl u_t000_011/c1_w0_br u_t000_011/c1_w1_bl u_t000_011/c1_w1_br
+ u_t000_011/c1_r0_rbl u_t000_011/c1_r1_rbl u_t000_011/c2_w0_bl u_t000_011/c2_w0_br u_t000_011/c2_w1_bl
+ u_t000_011/c2_w1_br u_t000_011/c2_r0_rbl u_t000_011/c2_r1_rbl u_t000_011/c3_w0_bl u_t000_011/c3_w0_br
+ u_t000_011/c3_w1_bl u_t000_011/c3_w1_br u_t000_011/c3_r0_rbl u_t000_011/c3_r1_rbl u_t000_011/r0_w0_wl
+ u_t000_011/r0_w1_wl u_t000_011/r0_r0_rwl u_t000_011/r0_r1_rwl u_t000_011/r1_w0_wl u_t000_011/r1_w1_wl
+ u_t000_011/r1_r0_rwl u_t000_011/r1_r1_rwl u_t000_011/r2_w0_wl u_t000_011/r2_w1_wl u_t000_011/r2_r0_rwl
+ u_t000_011/r2_r1_rwl u_t000_011/r3_w0_wl u_t000_011/r3_w1_wl u_t000_011/r3_r0_rwl u_t000_011/r3_r1_rwl VDD VSS VSUBS
+ detronyx_12t_2w2r_rc4_4x4_routed_5layer_direct
Xu_t000_000 u_t000_000/c0_w0_bl u_t000_000/c0_w0_br u_t000_000/c0_w1_bl u_t000_000/c0_w1_br u_t000_000/c0_r0_rbl
+ u_t000_000/c0_r1_rbl u_t000_000/c1_w0_bl u_t000_000/c1_w0_br u_t000_000/c1_w1_bl u_t000_000/c1_w1_br
+ u_t000_000/c1_r0_rbl u_t000_000/c1_r1_rbl u_t000_000/c2_w0_bl u_t000_000/c2_w0_br u_t000_000/c2_w1_bl
+ u_t000_000/c2_w1_br u_t000_000/c2_r0_rbl u_t000_000/c2_r1_rbl u_t000_000/c3_w0_bl u_t000_000/c3_w0_br
+ u_t000_000/c3_w1_bl u_t000_000/c3_w1_br u_t000_000/c3_r0_rbl u_t000_000/c3_r1_rbl u_t000_000/r0_w0_wl
+ u_t000_000/r0_w1_wl u_t000_000/r0_r0_rwl u_t000_000/r0_r1_rwl u_t000_000/r1_w0_wl u_t000_000/r1_w1_wl
+ u_t000_000/r1_r0_rwl u_t000_000/r1_r1_rwl u_t000_000/r2_w0_wl u_t000_000/r2_w1_wl u_t000_000/r2_r0_rwl
+ u_t000_000/r2_r1_rwl u_t000_000/r3_w0_wl u_t000_000/r3_w1_wl u_t000_000/r3_r0_rwl u_t000_000/r3_r1_rwl VDD VSS VSUBS
+ detronyx_12t_2w2r_rc4_4x4_routed_5layer_direct
Xu_t028_014 u_t028_014/c0_w0_bl u_t028_014/c0_w0_br u_t028_014/c0_w1_bl u_t028_014/c0_w1_br u_t028_014/c0_r0_rbl
+ u_t028_014/c0_r1_rbl u_t028_014/c1_w0_bl u_t028_014/c1_w0_br u_t028_014/c1_w1_bl u_t028_014/c1_w1_br
+ u_t028_014/c1_r0_rbl u_t028_014/c1_r1_rbl u_t028_014/c2_w0_bl u_t028_014/c2_w0_br u_t028_014/c2_w1_bl
+ u_t028_014/c2_w1_br u_t028_014/c2_r0_rbl u_t028_014/c2_r1_rbl u_t028_014/c3_w0_bl u_t028_014/c3_w0_br
+ u_t028_014/c3_w1_bl u_t028_014/c3_w1_br u_t028_014/c3_r0_rbl u_t028_014/c3_r1_rbl u_t028_014/r0_w0_wl
+ u_t028_014/r0_w1_wl u_t028_014/r0_r0_rwl u_t028_014/r0_r1_rwl u_t028_014/r1_w0_wl u_t028_014/r1_w1_wl
+ u_t028_014/r1_r0_rwl u_t028_014/r1_r1_rwl u_t028_014/r2_w0_wl u_t028_014/r2_w1_wl u_t028_014/r2_r0_rwl
+ u_t028_014/r2_r1_rwl u_t028_014/r3_w0_wl u_t028_014/r3_w1_wl u_t028_014/r3_r0_rwl u_t028_014/r3_r1_rwl VDD VSS VSUBS
+ detronyx_12t_2w2r_rc4_4x4_routed_5layer_direct
Xu_t028_003 u_t028_003/c0_w0_bl u_t028_003/c0_w0_br u_t028_003/c0_w1_bl u_t028_003/c0_w1_br u_t028_003/c0_r0_rbl
+ u_t028_003/c0_r1_rbl u_t028_003/c1_w0_bl u_t028_003/c1_w0_br u_t028_003/c1_w1_bl u_t028_003/c1_w1_br
+ u_t028_003/c1_r0_rbl u_t028_003/c1_r1_rbl u_t028_003/c2_w0_bl u_t028_003/c2_w0_br u_t028_003/c2_w1_bl
+ u_t028_003/c2_w1_br u_t028_003/c2_r0_rbl u_t028_003/c2_r1_rbl u_t028_003/c3_w0_bl u_t028_003/c3_w0_br
+ u_t028_003/c3_w1_bl u_t028_003/c3_w1_br u_t028_003/c3_r0_rbl u_t028_003/c3_r1_rbl u_t028_003/r0_w0_wl
+ u_t028_003/r0_w1_wl u_t028_003/r0_r0_rwl u_t028_003/r0_r1_rwl u_t028_003/r1_w0_wl u_t028_003/r1_w1_wl
+ u_t028_003/r1_r0_rwl u_t028_003/r1_r1_rwl u_t028_003/r2_w0_wl u_t028_003/r2_w1_wl u_t028_003/r2_r0_rwl
+ u_t028_003/r2_r1_rwl u_t028_003/r3_w0_wl u_t028_003/r3_w1_wl u_t028_003/r3_r0_rwl u_t028_003/r3_r1_rwl VDD VSS VSUBS
+ detronyx_12t_2w2r_rc4_4x4_routed_5layer_direct
Xu_t019_003 u_t019_003/c0_w0_bl u_t019_003/c0_w0_br u_t019_003/c0_w1_bl u_t019_003/c0_w1_br u_t019_003/c0_r0_rbl
+ u_t019_003/c0_r1_rbl u_t019_003/c1_w0_bl u_t019_003/c1_w0_br u_t019_003/c1_w1_bl u_t019_003/c1_w1_br
+ u_t019_003/c1_r0_rbl u_t019_003/c1_r1_rbl u_t019_003/c2_w0_bl u_t019_003/c2_w0_br u_t019_003/c2_w1_bl
+ u_t019_003/c2_w1_br u_t019_003/c2_r0_rbl u_t019_003/c2_r1_rbl u_t019_003/c3_w0_bl u_t019_003/c3_w0_br
+ u_t019_003/c3_w1_bl u_t019_003/c3_w1_br u_t019_003/c3_r0_rbl u_t019_003/c3_r1_rbl u_t019_003/r0_w0_wl
+ u_t019_003/r0_w1_wl u_t019_003/r0_r0_rwl u_t019_003/r0_r1_rwl u_t019_003/r1_w0_wl u_t019_003/r1_w1_wl
+ u_t019_003/r1_r0_rwl u_t019_003/r1_r1_rwl u_t019_003/r2_w0_wl u_t019_003/r2_w1_wl u_t019_003/r2_r0_rwl
+ u_t019_003/r2_r1_rwl u_t019_003/r3_w0_wl u_t019_003/r3_w1_wl u_t019_003/r3_r0_rwl u_t019_003/r3_r1_rwl VDD VSS VSUBS
+ detronyx_12t_2w2r_rc4_4x4_routed_5layer_direct
Xu_t019_014 u_t019_014/c0_w0_bl u_t019_014/c0_w0_br u_t019_014/c0_w1_bl u_t019_014/c0_w1_br u_t019_014/c0_r0_rbl
+ u_t019_014/c0_r1_rbl u_t019_014/c1_w0_bl u_t019_014/c1_w0_br u_t019_014/c1_w1_bl u_t019_014/c1_w1_br
+ u_t019_014/c1_r0_rbl u_t019_014/c1_r1_rbl u_t019_014/c2_w0_bl u_t019_014/c2_w0_br u_t019_014/c2_w1_bl
+ u_t019_014/c2_w1_br u_t019_014/c2_r0_rbl u_t019_014/c2_r1_rbl u_t019_014/c3_w0_bl u_t019_014/c3_w0_br
+ u_t019_014/c3_w1_bl u_t019_014/c3_w1_br u_t019_014/c3_r0_rbl u_t019_014/c3_r1_rbl u_t019_014/r0_w0_wl
+ u_t019_014/r0_w1_wl u_t019_014/r0_r0_rwl u_t019_014/r0_r1_rwl u_t019_014/r1_w0_wl u_t019_014/r1_w1_wl
+ u_t019_014/r1_r0_rwl u_t019_014/r1_r1_rwl u_t019_014/r2_w0_wl u_t019_014/r2_w1_wl u_t019_014/r2_r0_rwl
+ u_t019_014/r2_r1_rwl u_t019_014/r3_w0_wl u_t019_014/r3_w1_wl u_t019_014/r3_r0_rwl u_t019_014/r3_r1_rwl VDD VSS VSUBS
+ detronyx_12t_2w2r_rc4_4x4_routed_5layer_direct
Xu_t025_006 u_t025_006/c0_w0_bl u_t025_006/c0_w0_br u_t025_006/c0_w1_bl u_t025_006/c0_w1_br u_t025_006/c0_r0_rbl
+ u_t025_006/c0_r1_rbl u_t025_006/c1_w0_bl u_t025_006/c1_w0_br u_t025_006/c1_w1_bl u_t025_006/c1_w1_br
+ u_t025_006/c1_r0_rbl u_t025_006/c1_r1_rbl u_t025_006/c2_w0_bl u_t025_006/c2_w0_br u_t025_006/c2_w1_bl
+ u_t025_006/c2_w1_br u_t025_006/c2_r0_rbl u_t025_006/c2_r1_rbl u_t025_006/c3_w0_bl u_t025_006/c3_w0_br
+ u_t025_006/c3_w1_bl u_t025_006/c3_w1_br u_t025_006/c3_r0_rbl u_t025_006/c3_r1_rbl u_t025_006/r0_w0_wl
+ u_t025_006/r0_w1_wl u_t025_006/r0_r0_rwl u_t025_006/r0_r1_rwl u_t025_006/r1_w0_wl u_t025_006/r1_w1_wl
+ u_t025_006/r1_r0_rwl u_t025_006/r1_r1_rwl u_t025_006/r2_w0_wl u_t025_006/r2_w1_wl u_t025_006/r2_r0_rwl
+ u_t025_006/r2_r1_rwl u_t025_006/r3_w0_wl u_t025_006/r3_w1_wl u_t025_006/r3_r0_rwl u_t025_006/r3_r1_rwl VDD VSS VSUBS
+ detronyx_12t_2w2r_rc4_4x4_routed_5layer_direct
Xu_t031_009 u_t031_009/c0_w0_bl u_t031_009/c0_w0_br u_t031_009/c0_w1_bl u_t031_009/c0_w1_br u_t031_009/c0_r0_rbl
+ u_t031_009/c0_r1_rbl u_t031_009/c1_w0_bl u_t031_009/c1_w0_br u_t031_009/c1_w1_bl u_t031_009/c1_w1_br
+ u_t031_009/c1_r0_rbl u_t031_009/c1_r1_rbl u_t031_009/c2_w0_bl u_t031_009/c2_w0_br u_t031_009/c2_w1_bl
+ u_t031_009/c2_w1_br u_t031_009/c2_r0_rbl u_t031_009/c2_r1_rbl u_t031_009/c3_w0_bl u_t031_009/c3_w0_br
+ u_t031_009/c3_w1_bl u_t031_009/c3_w1_br u_t031_009/c3_r0_rbl u_t031_009/c3_r1_rbl u_t031_009/r0_w0_wl
+ u_t031_009/r0_w1_wl u_t031_009/r0_r0_rwl u_t031_009/r0_r1_rwl u_t031_009/r1_w0_wl u_t031_009/r1_w1_wl
+ u_t031_009/r1_r0_rwl u_t031_009/r1_r1_rwl u_t031_009/r2_w0_wl u_t031_009/r2_w1_wl u_t031_009/r2_r0_rwl
+ u_t031_009/r2_r1_rwl u_t031_009/r3_w0_wl u_t031_009/r3_w1_wl u_t031_009/r3_r0_rwl u_t031_009/r3_r1_rwl VDD VSS VSUBS
+ detronyx_12t_2w2r_rc4_4x4_routed_5layer_direct
Xu_t016_006 u_t016_006/c0_w0_bl u_t016_006/c0_w0_br u_t016_006/c0_w1_bl u_t016_006/c0_w1_br u_t016_006/c0_r0_rbl
+ u_t016_006/c0_r1_rbl u_t016_006/c1_w0_bl u_t016_006/c1_w0_br u_t016_006/c1_w1_bl u_t016_006/c1_w1_br
+ u_t016_006/c1_r0_rbl u_t016_006/c1_r1_rbl u_t016_006/c2_w0_bl u_t016_006/c2_w0_br u_t016_006/c2_w1_bl
+ u_t016_006/c2_w1_br u_t016_006/c2_r0_rbl u_t016_006/c2_r1_rbl u_t016_006/c3_w0_bl u_t016_006/c3_w0_br
+ u_t016_006/c3_w1_bl u_t016_006/c3_w1_br u_t016_006/c3_r0_rbl u_t016_006/c3_r1_rbl u_t016_006/r0_w0_wl
+ u_t016_006/r0_w1_wl u_t016_006/r0_r0_rwl u_t016_006/r0_r1_rwl u_t016_006/r1_w0_wl u_t016_006/r1_w1_wl
+ u_t016_006/r1_r0_rwl u_t016_006/r1_r1_rwl u_t016_006/r2_w0_wl u_t016_006/r2_w1_wl u_t016_006/r2_r0_rwl
+ u_t016_006/r2_r1_rwl u_t016_006/r3_w0_wl u_t016_006/r3_w1_wl u_t016_006/r3_r0_rwl u_t016_006/r3_r1_rwl VDD VSS VSUBS
+ detronyx_12t_2w2r_rc4_4x4_routed_5layer_direct
Xu_t007_006 u_t007_006/c0_w0_bl u_t007_006/c0_w0_br u_t007_006/c0_w1_bl u_t007_006/c0_w1_br u_t007_006/c0_r0_rbl
+ u_t007_006/c0_r1_rbl u_t007_006/c1_w0_bl u_t007_006/c1_w0_br u_t007_006/c1_w1_bl u_t007_006/c1_w1_br
+ u_t007_006/c1_r0_rbl u_t007_006/c1_r1_rbl u_t007_006/c2_w0_bl u_t007_006/c2_w0_br u_t007_006/c2_w1_bl
+ u_t007_006/c2_w1_br u_t007_006/c2_r0_rbl u_t007_006/c2_r1_rbl u_t007_006/c3_w0_bl u_t007_006/c3_w0_br
+ u_t007_006/c3_w1_bl u_t007_006/c3_w1_br u_t007_006/c3_r0_rbl u_t007_006/c3_r1_rbl u_t007_006/r0_w0_wl
+ u_t007_006/r0_w1_wl u_t007_006/r0_r0_rwl u_t007_006/r0_r1_rwl u_t007_006/r1_w0_wl u_t007_006/r1_w1_wl
+ u_t007_006/r1_r0_rwl u_t007_006/r1_r1_rwl u_t007_006/r2_w0_wl u_t007_006/r2_w1_wl u_t007_006/r2_r0_rwl
+ u_t007_006/r2_r1_rwl u_t007_006/r3_w0_wl u_t007_006/r3_w1_wl u_t007_006/r3_r0_rwl u_t007_006/r3_r1_rwl VDD VSS VSUBS
+ detronyx_12t_2w2r_rc4_4x4_routed_5layer_direct
Xu_t022_009 u_t022_009/c0_w0_bl u_t022_009/c0_w0_br u_t022_009/c0_w1_bl u_t022_009/c0_w1_br u_t022_009/c0_r0_rbl
+ u_t022_009/c0_r1_rbl u_t022_009/c1_w0_bl u_t022_009/c1_w0_br u_t022_009/c1_w1_bl u_t022_009/c1_w1_br
+ u_t022_009/c1_r0_rbl u_t022_009/c1_r1_rbl u_t022_009/c2_w0_bl u_t022_009/c2_w0_br u_t022_009/c2_w1_bl
+ u_t022_009/c2_w1_br u_t022_009/c2_r0_rbl u_t022_009/c2_r1_rbl u_t022_009/c3_w0_bl u_t022_009/c3_w0_br
+ u_t022_009/c3_w1_bl u_t022_009/c3_w1_br u_t022_009/c3_r0_rbl u_t022_009/c3_r1_rbl u_t022_009/r0_w0_wl
+ u_t022_009/r0_w1_wl u_t022_009/r0_r0_rwl u_t022_009/r0_r1_rwl u_t022_009/r1_w0_wl u_t022_009/r1_w1_wl
+ u_t022_009/r1_r0_rwl u_t022_009/r1_r1_rwl u_t022_009/r2_w0_wl u_t022_009/r2_w1_wl u_t022_009/r2_r0_rwl
+ u_t022_009/r2_r1_rwl u_t022_009/r3_w0_wl u_t022_009/r3_w1_wl u_t022_009/r3_r0_rwl u_t022_009/r3_r1_rwl VDD VSS VSUBS
+ detronyx_12t_2w2r_rc4_4x4_routed_5layer_direct
Xu_t013_009 u_t013_009/c0_w0_bl u_t013_009/c0_w0_br u_t013_009/c0_w1_bl u_t013_009/c0_w1_br u_t013_009/c0_r0_rbl
+ u_t013_009/c0_r1_rbl u_t013_009/c1_w0_bl u_t013_009/c1_w0_br u_t013_009/c1_w1_bl u_t013_009/c1_w1_br
+ u_t013_009/c1_r0_rbl u_t013_009/c1_r1_rbl u_t013_009/c2_w0_bl u_t013_009/c2_w0_br u_t013_009/c2_w1_bl
+ u_t013_009/c2_w1_br u_t013_009/c2_r0_rbl u_t013_009/c2_r1_rbl u_t013_009/c3_w0_bl u_t013_009/c3_w0_br
+ u_t013_009/c3_w1_bl u_t013_009/c3_w1_br u_t013_009/c3_r0_rbl u_t013_009/c3_r1_rbl u_t013_009/r0_w0_wl
+ u_t013_009/r0_w1_wl u_t013_009/r0_r0_rwl u_t013_009/r0_r1_rwl u_t013_009/r1_w0_wl u_t013_009/r1_w1_wl
+ u_t013_009/r1_r0_rwl u_t013_009/r1_r1_rwl u_t013_009/r2_w0_wl u_t013_009/r2_w1_wl u_t013_009/r2_r0_rwl
+ u_t013_009/r2_r1_rwl u_t013_009/r3_w0_wl u_t013_009/r3_w1_wl u_t013_009/r3_r0_rwl u_t013_009/r3_r1_rwl VDD VSS VSUBS
+ detronyx_12t_2w2r_rc4_4x4_routed_5layer_direct
Xu_t004_009 u_t004_009/c0_w0_bl u_t004_009/c0_w0_br u_t004_009/c0_w1_bl u_t004_009/c0_w1_br u_t004_009/c0_r0_rbl
+ u_t004_009/c0_r1_rbl u_t004_009/c1_w0_bl u_t004_009/c1_w0_br u_t004_009/c1_w1_bl u_t004_009/c1_w1_br
+ u_t004_009/c1_r0_rbl u_t004_009/c1_r1_rbl u_t004_009/c2_w0_bl u_t004_009/c2_w0_br u_t004_009/c2_w1_bl
+ u_t004_009/c2_w1_br u_t004_009/c2_r0_rbl u_t004_009/c2_r1_rbl u_t004_009/c3_w0_bl u_t004_009/c3_w0_br
+ u_t004_009/c3_w1_bl u_t004_009/c3_w1_br u_t004_009/c3_r0_rbl u_t004_009/c3_r1_rbl u_t004_009/r0_w0_wl
+ u_t004_009/r0_w1_wl u_t004_009/r0_r0_rwl u_t004_009/r0_r1_rwl u_t004_009/r1_w0_wl u_t004_009/r1_w1_wl
+ u_t004_009/r1_r0_rwl u_t004_009/r1_r1_rwl u_t004_009/r2_w0_wl u_t004_009/r2_w1_wl u_t004_009/r2_r0_rwl
+ u_t004_009/r2_r1_rwl u_t004_009/r3_w0_wl u_t004_009/r3_w1_wl u_t004_009/r3_r0_rwl u_t004_009/r3_r1_rwl VDD VSS VSUBS
+ detronyx_12t_2w2r_rc4_4x4_routed_5layer_direct
Xu_t000_012 u_t000_012/c0_w0_bl u_t000_012/c0_w0_br u_t000_012/c0_w1_bl u_t000_012/c0_w1_br u_t000_012/c0_r0_rbl
+ u_t000_012/c0_r1_rbl u_t000_012/c1_w0_bl u_t000_012/c1_w0_br u_t000_012/c1_w1_bl u_t000_012/c1_w1_br
+ u_t000_012/c1_r0_rbl u_t000_012/c1_r1_rbl u_t000_012/c2_w0_bl u_t000_012/c2_w0_br u_t000_012/c2_w1_bl
+ u_t000_012/c2_w1_br u_t000_012/c2_r0_rbl u_t000_012/c2_r1_rbl u_t000_012/c3_w0_bl u_t000_012/c3_w0_br
+ u_t000_012/c3_w1_bl u_t000_012/c3_w1_br u_t000_012/c3_r0_rbl u_t000_012/c3_r1_rbl u_t000_012/r0_w0_wl
+ u_t000_012/r0_w1_wl u_t000_012/r0_r0_rwl u_t000_012/r0_r1_rwl u_t000_012/r1_w0_wl u_t000_012/r1_w1_wl
+ u_t000_012/r1_r0_rwl u_t000_012/r1_r1_rwl u_t000_012/r2_w0_wl u_t000_012/r2_w1_wl u_t000_012/r2_r0_rwl
+ u_t000_012/r2_r1_rwl u_t000_012/r3_w0_wl u_t000_012/r3_w1_wl u_t000_012/r3_r0_rwl u_t000_012/r3_r1_rwl VDD VSS VSUBS
+ detronyx_12t_2w2r_rc4_4x4_routed_5layer_direct
Xu_t000_001 u_t000_001/c0_w0_bl u_t000_001/c0_w0_br u_t000_001/c0_w1_bl u_t000_001/c0_w1_br u_t000_001/c0_r0_rbl
+ u_t000_001/c0_r1_rbl u_t000_001/c1_w0_bl u_t000_001/c1_w0_br u_t000_001/c1_w1_bl u_t000_001/c1_w1_br
+ u_t000_001/c1_r0_rbl u_t000_001/c1_r1_rbl u_t000_001/c2_w0_bl u_t000_001/c2_w0_br u_t000_001/c2_w1_bl
+ u_t000_001/c2_w1_br u_t000_001/c2_r0_rbl u_t000_001/c2_r1_rbl u_t000_001/c3_w0_bl u_t000_001/c3_w0_br
+ u_t000_001/c3_w1_bl u_t000_001/c3_w1_br u_t000_001/c3_r0_rbl u_t000_001/c3_r1_rbl u_t000_001/r0_w0_wl
+ u_t000_001/r0_w1_wl u_t000_001/r0_r0_rwl u_t000_001/r0_r1_rwl u_t000_001/r1_w0_wl u_t000_001/r1_w1_wl
+ u_t000_001/r1_r0_rwl u_t000_001/r1_r1_rwl u_t000_001/r2_w0_wl u_t000_001/r2_w1_wl u_t000_001/r2_r0_rwl
+ u_t000_001/r2_r1_rwl u_t000_001/r3_w0_wl u_t000_001/r3_w1_wl u_t000_001/r3_r0_rwl u_t000_001/r3_r1_rwl VDD VSS VSUBS
+ detronyx_12t_2w2r_rc4_4x4_routed_5layer_direct
Xu_t028_015 u_t028_015/c0_w0_bl u_t028_015/c0_w0_br u_t028_015/c0_w1_bl u_t028_015/c0_w1_br u_t028_015/c0_r0_rbl
+ u_t028_015/c0_r1_rbl u_t028_015/c1_w0_bl u_t028_015/c1_w0_br u_t028_015/c1_w1_bl u_t028_015/c1_w1_br
+ u_t028_015/c1_r0_rbl u_t028_015/c1_r1_rbl u_t028_015/c2_w0_bl u_t028_015/c2_w0_br u_t028_015/c2_w1_bl
+ u_t028_015/c2_w1_br u_t028_015/c2_r0_rbl u_t028_015/c2_r1_rbl u_t028_015/c3_w0_bl u_t028_015/c3_w0_br
+ u_t028_015/c3_w1_bl u_t028_015/c3_w1_br u_t028_015/c3_r0_rbl u_t028_015/c3_r1_rbl u_t028_015/r0_w0_wl
+ u_t028_015/r0_w1_wl u_t028_015/r0_r0_rwl u_t028_015/r0_r1_rwl u_t028_015/r1_w0_wl u_t028_015/r1_w1_wl
+ u_t028_015/r1_r0_rwl u_t028_015/r1_r1_rwl u_t028_015/r2_w0_wl u_t028_015/r2_w1_wl u_t028_015/r2_r0_rwl
+ u_t028_015/r2_r1_rwl u_t028_015/r3_w0_wl u_t028_015/r3_w1_wl u_t028_015/r3_r0_rwl u_t028_015/r3_r1_rwl VDD VSS VSUBS
+ detronyx_12t_2w2r_rc4_4x4_routed_5layer_direct
Xu_t028_004 u_t028_004/c0_w0_bl u_t028_004/c0_w0_br u_t028_004/c0_w1_bl u_t028_004/c0_w1_br u_t028_004/c0_r0_rbl
+ u_t028_004/c0_r1_rbl u_t028_004/c1_w0_bl u_t028_004/c1_w0_br u_t028_004/c1_w1_bl u_t028_004/c1_w1_br
+ u_t028_004/c1_r0_rbl u_t028_004/c1_r1_rbl u_t028_004/c2_w0_bl u_t028_004/c2_w0_br u_t028_004/c2_w1_bl
+ u_t028_004/c2_w1_br u_t028_004/c2_r0_rbl u_t028_004/c2_r1_rbl u_t028_004/c3_w0_bl u_t028_004/c3_w0_br
+ u_t028_004/c3_w1_bl u_t028_004/c3_w1_br u_t028_004/c3_r0_rbl u_t028_004/c3_r1_rbl u_t028_004/r0_w0_wl
+ u_t028_004/r0_w1_wl u_t028_004/r0_r0_rwl u_t028_004/r0_r1_rwl u_t028_004/r1_w0_wl u_t028_004/r1_w1_wl
+ u_t028_004/r1_r0_rwl u_t028_004/r1_r1_rwl u_t028_004/r2_w0_wl u_t028_004/r2_w1_wl u_t028_004/r2_r0_rwl
+ u_t028_004/r2_r1_rwl u_t028_004/r3_w0_wl u_t028_004/r3_w1_wl u_t028_004/r3_r0_rwl u_t028_004/r3_r1_rwl VDD VSS VSUBS
+ detronyx_12t_2w2r_rc4_4x4_routed_5layer_direct
Xu_t019_004 u_t019_004/c0_w0_bl u_t019_004/c0_w0_br u_t019_004/c0_w1_bl u_t019_004/c0_w1_br u_t019_004/c0_r0_rbl
+ u_t019_004/c0_r1_rbl u_t019_004/c1_w0_bl u_t019_004/c1_w0_br u_t019_004/c1_w1_bl u_t019_004/c1_w1_br
+ u_t019_004/c1_r0_rbl u_t019_004/c1_r1_rbl u_t019_004/c2_w0_bl u_t019_004/c2_w0_br u_t019_004/c2_w1_bl
+ u_t019_004/c2_w1_br u_t019_004/c2_r0_rbl u_t019_004/c2_r1_rbl u_t019_004/c3_w0_bl u_t019_004/c3_w0_br
+ u_t019_004/c3_w1_bl u_t019_004/c3_w1_br u_t019_004/c3_r0_rbl u_t019_004/c3_r1_rbl u_t019_004/r0_w0_wl
+ u_t019_004/r0_w1_wl u_t019_004/r0_r0_rwl u_t019_004/r0_r1_rwl u_t019_004/r1_w0_wl u_t019_004/r1_w1_wl
+ u_t019_004/r1_r0_rwl u_t019_004/r1_r1_rwl u_t019_004/r2_w0_wl u_t019_004/r2_w1_wl u_t019_004/r2_r0_rwl
+ u_t019_004/r2_r1_rwl u_t019_004/r3_w0_wl u_t019_004/r3_w1_wl u_t019_004/r3_r0_rwl u_t019_004/r3_r1_rwl VDD VSS VSUBS
+ detronyx_12t_2w2r_rc4_4x4_routed_5layer_direct
Xu_t019_015 u_t019_015/c0_w0_bl u_t019_015/c0_w0_br u_t019_015/c0_w1_bl u_t019_015/c0_w1_br u_t019_015/c0_r0_rbl
+ u_t019_015/c0_r1_rbl u_t019_015/c1_w0_bl u_t019_015/c1_w0_br u_t019_015/c1_w1_bl u_t019_015/c1_w1_br
+ u_t019_015/c1_r0_rbl u_t019_015/c1_r1_rbl u_t019_015/c2_w0_bl u_t019_015/c2_w0_br u_t019_015/c2_w1_bl
+ u_t019_015/c2_w1_br u_t019_015/c2_r0_rbl u_t019_015/c2_r1_rbl u_t019_015/c3_w0_bl u_t019_015/c3_w0_br
+ u_t019_015/c3_w1_bl u_t019_015/c3_w1_br u_t019_015/c3_r0_rbl u_t019_015/c3_r1_rbl u_t019_015/r0_w0_wl
+ u_t019_015/r0_w1_wl u_t019_015/r0_r0_rwl u_t019_015/r0_r1_rwl u_t019_015/r1_w0_wl u_t019_015/r1_w1_wl
+ u_t019_015/r1_r0_rwl u_t019_015/r1_r1_rwl u_t019_015/r2_w0_wl u_t019_015/r2_w1_wl u_t019_015/r2_r0_rwl
+ u_t019_015/r2_r1_rwl u_t019_015/r3_w0_wl u_t019_015/r3_w1_wl u_t019_015/r3_r0_rwl u_t019_015/r3_r1_rwl VDD VSS VSUBS
+ detronyx_12t_2w2r_rc4_4x4_routed_5layer_direct
Xu_t025_007 u_t025_007/c0_w0_bl u_t025_007/c0_w0_br u_t025_007/c0_w1_bl u_t025_007/c0_w1_br u_t025_007/c0_r0_rbl
+ u_t025_007/c0_r1_rbl u_t025_007/c1_w0_bl u_t025_007/c1_w0_br u_t025_007/c1_w1_bl u_t025_007/c1_w1_br
+ u_t025_007/c1_r0_rbl u_t025_007/c1_r1_rbl u_t025_007/c2_w0_bl u_t025_007/c2_w0_br u_t025_007/c2_w1_bl
+ u_t025_007/c2_w1_br u_t025_007/c2_r0_rbl u_t025_007/c2_r1_rbl u_t025_007/c3_w0_bl u_t025_007/c3_w0_br
+ u_t025_007/c3_w1_bl u_t025_007/c3_w1_br u_t025_007/c3_r0_rbl u_t025_007/c3_r1_rbl u_t025_007/r0_w0_wl
+ u_t025_007/r0_w1_wl u_t025_007/r0_r0_rwl u_t025_007/r0_r1_rwl u_t025_007/r1_w0_wl u_t025_007/r1_w1_wl
+ u_t025_007/r1_r0_rwl u_t025_007/r1_r1_rwl u_t025_007/r2_w0_wl u_t025_007/r2_w1_wl u_t025_007/r2_r0_rwl
+ u_t025_007/r2_r1_rwl u_t025_007/r3_w0_wl u_t025_007/r3_w1_wl u_t025_007/r3_r0_rwl u_t025_007/r3_r1_rwl VDD VSS VSUBS
+ detronyx_12t_2w2r_rc4_4x4_routed_5layer_direct
Xu_t016_007 u_t016_007/c0_w0_bl u_t016_007/c0_w0_br u_t016_007/c0_w1_bl u_t016_007/c0_w1_br u_t016_007/c0_r0_rbl
+ u_t016_007/c0_r1_rbl u_t016_007/c1_w0_bl u_t016_007/c1_w0_br u_t016_007/c1_w1_bl u_t016_007/c1_w1_br
+ u_t016_007/c1_r0_rbl u_t016_007/c1_r1_rbl u_t016_007/c2_w0_bl u_t016_007/c2_w0_br u_t016_007/c2_w1_bl
+ u_t016_007/c2_w1_br u_t016_007/c2_r0_rbl u_t016_007/c2_r1_rbl u_t016_007/c3_w0_bl u_t016_007/c3_w0_br
+ u_t016_007/c3_w1_bl u_t016_007/c3_w1_br u_t016_007/c3_r0_rbl u_t016_007/c3_r1_rbl u_t016_007/r0_w0_wl
+ u_t016_007/r0_w1_wl u_t016_007/r0_r0_rwl u_t016_007/r0_r1_rwl u_t016_007/r1_w0_wl u_t016_007/r1_w1_wl
+ u_t016_007/r1_r0_rwl u_t016_007/r1_r1_rwl u_t016_007/r2_w0_wl u_t016_007/r2_w1_wl u_t016_007/r2_r0_rwl
+ u_t016_007/r2_r1_rwl u_t016_007/r3_w0_wl u_t016_007/r3_w1_wl u_t016_007/r3_r0_rwl u_t016_007/r3_r1_rwl VDD VSS VSUBS
+ detronyx_12t_2w2r_rc4_4x4_routed_5layer_direct
Xu_t007_007 u_t007_007/c0_w0_bl u_t007_007/c0_w0_br u_t007_007/c0_w1_bl u_t007_007/c0_w1_br u_t007_007/c0_r0_rbl
+ u_t007_007/c0_r1_rbl u_t007_007/c1_w0_bl u_t007_007/c1_w0_br u_t007_007/c1_w1_bl u_t007_007/c1_w1_br
+ u_t007_007/c1_r0_rbl u_t007_007/c1_r1_rbl u_t007_007/c2_w0_bl u_t007_007/c2_w0_br u_t007_007/c2_w1_bl
+ u_t007_007/c2_w1_br u_t007_007/c2_r0_rbl u_t007_007/c2_r1_rbl u_t007_007/c3_w0_bl u_t007_007/c3_w0_br
+ u_t007_007/c3_w1_bl u_t007_007/c3_w1_br u_t007_007/c3_r0_rbl u_t007_007/c3_r1_rbl u_t007_007/r0_w0_wl
+ u_t007_007/r0_w1_wl u_t007_007/r0_r0_rwl u_t007_007/r0_r1_rwl u_t007_007/r1_w0_wl u_t007_007/r1_w1_wl
+ u_t007_007/r1_r0_rwl u_t007_007/r1_r1_rwl u_t007_007/r2_w0_wl u_t007_007/r2_w1_wl u_t007_007/r2_r0_rwl
+ u_t007_007/r2_r1_rwl u_t007_007/r3_w0_wl u_t007_007/r3_w1_wl u_t007_007/r3_r0_rwl u_t007_007/r3_r1_rwl VDD VSS VSUBS
+ detronyx_12t_2w2r_rc4_4x4_routed_5layer_direct
Xu_t030_010 u_t030_010/c0_w0_bl u_t030_010/c0_w0_br u_t030_010/c0_w1_bl u_t030_010/c0_w1_br u_t030_010/c0_r0_rbl
+ u_t030_010/c0_r1_rbl u_t030_010/c1_w0_bl u_t030_010/c1_w0_br u_t030_010/c1_w1_bl u_t030_010/c1_w1_br
+ u_t030_010/c1_r0_rbl u_t030_010/c1_r1_rbl u_t030_010/c2_w0_bl u_t030_010/c2_w0_br u_t030_010/c2_w1_bl
+ u_t030_010/c2_w1_br u_t030_010/c2_r0_rbl u_t030_010/c2_r1_rbl u_t030_010/c3_w0_bl u_t030_010/c3_w0_br
+ u_t030_010/c3_w1_bl u_t030_010/c3_w1_br u_t030_010/c3_r0_rbl u_t030_010/c3_r1_rbl u_t030_010/r0_w0_wl
+ u_t030_010/r0_w1_wl u_t030_010/r0_r0_rwl u_t030_010/r0_r1_rwl u_t030_010/r1_w0_wl u_t030_010/r1_w1_wl
+ u_t030_010/r1_r0_rwl u_t030_010/r1_r1_rwl u_t030_010/r2_w0_wl u_t030_010/r2_w1_wl u_t030_010/r2_r0_rwl
+ u_t030_010/r2_r1_rwl u_t030_010/r3_w0_wl u_t030_010/r3_w1_wl u_t030_010/r3_r0_rwl u_t030_010/r3_r1_rwl VDD VSS VSUBS
+ detronyx_12t_2w2r_rc4_4x4_routed_5layer_direct
Xu_t021_010 u_t021_010/c0_w0_bl u_t021_010/c0_w0_br u_t021_010/c0_w1_bl u_t021_010/c0_w1_br u_t021_010/c0_r0_rbl
+ u_t021_010/c0_r1_rbl u_t021_010/c1_w0_bl u_t021_010/c1_w0_br u_t021_010/c1_w1_bl u_t021_010/c1_w1_br
+ u_t021_010/c1_r0_rbl u_t021_010/c1_r1_rbl u_t021_010/c2_w0_bl u_t021_010/c2_w0_br u_t021_010/c2_w1_bl
+ u_t021_010/c2_w1_br u_t021_010/c2_r0_rbl u_t021_010/c2_r1_rbl u_t021_010/c3_w0_bl u_t021_010/c3_w0_br
+ u_t021_010/c3_w1_bl u_t021_010/c3_w1_br u_t021_010/c3_r0_rbl u_t021_010/c3_r1_rbl u_t021_010/r0_w0_wl
+ u_t021_010/r0_w1_wl u_t021_010/r0_r0_rwl u_t021_010/r0_r1_rwl u_t021_010/r1_w0_wl u_t021_010/r1_w1_wl
+ u_t021_010/r1_r0_rwl u_t021_010/r1_r1_rwl u_t021_010/r2_w0_wl u_t021_010/r2_w1_wl u_t021_010/r2_r0_rwl
+ u_t021_010/r2_r1_rwl u_t021_010/r3_w0_wl u_t021_010/r3_w1_wl u_t021_010/r3_r0_rwl u_t021_010/r3_r1_rwl VDD VSS VSUBS
+ detronyx_12t_2w2r_rc4_4x4_routed_5layer_direct
Xu_t012_010 u_t012_010/c0_w0_bl u_t012_010/c0_w0_br u_t012_010/c0_w1_bl u_t012_010/c0_w1_br u_t012_010/c0_r0_rbl
+ u_t012_010/c0_r1_rbl u_t012_010/c1_w0_bl u_t012_010/c1_w0_br u_t012_010/c1_w1_bl u_t012_010/c1_w1_br
+ u_t012_010/c1_r0_rbl u_t012_010/c1_r1_rbl u_t012_010/c2_w0_bl u_t012_010/c2_w0_br u_t012_010/c2_w1_bl
+ u_t012_010/c2_w1_br u_t012_010/c2_r0_rbl u_t012_010/c2_r1_rbl u_t012_010/c3_w0_bl u_t012_010/c3_w0_br
+ u_t012_010/c3_w1_bl u_t012_010/c3_w1_br u_t012_010/c3_r0_rbl u_t012_010/c3_r1_rbl u_t012_010/r0_w0_wl
+ u_t012_010/r0_w1_wl u_t012_010/r0_r0_rwl u_t012_010/r0_r1_rwl u_t012_010/r1_w0_wl u_t012_010/r1_w1_wl
+ u_t012_010/r1_r0_rwl u_t012_010/r1_r1_rwl u_t012_010/r2_w0_wl u_t012_010/r2_w1_wl u_t012_010/r2_r0_rwl
+ u_t012_010/r2_r1_rwl u_t012_010/r3_w0_wl u_t012_010/r3_w1_wl u_t012_010/r3_r0_rwl u_t012_010/r3_r1_rwl VDD VSS VSUBS
+ detronyx_12t_2w2r_rc4_4x4_routed_5layer_direct
Xu_t003_010 u_t003_010/c0_w0_bl u_t003_010/c0_w0_br u_t003_010/c0_w1_bl u_t003_010/c0_w1_br u_t003_010/c0_r0_rbl
+ u_t003_010/c0_r1_rbl u_t003_010/c1_w0_bl u_t003_010/c1_w0_br u_t003_010/c1_w1_bl u_t003_010/c1_w1_br
+ u_t003_010/c1_r0_rbl u_t003_010/c1_r1_rbl u_t003_010/c2_w0_bl u_t003_010/c2_w0_br u_t003_010/c2_w1_bl
+ u_t003_010/c2_w1_br u_t003_010/c2_r0_rbl u_t003_010/c2_r1_rbl u_t003_010/c3_w0_bl u_t003_010/c3_w0_br
+ u_t003_010/c3_w1_bl u_t003_010/c3_w1_br u_t003_010/c3_r0_rbl u_t003_010/c3_r1_rbl u_t003_010/r0_w0_wl
+ u_t003_010/r0_w1_wl u_t003_010/r0_r0_rwl u_t003_010/r0_r1_rwl u_t003_010/r1_w0_wl u_t003_010/r1_w1_wl
+ u_t003_010/r1_r0_rwl u_t003_010/r1_r1_rwl u_t003_010/r2_w0_wl u_t003_010/r2_w1_wl u_t003_010/r2_r0_rwl
+ u_t003_010/r2_r1_rwl u_t003_010/r3_w0_wl u_t003_010/r3_w1_wl u_t003_010/r3_r0_rwl u_t003_010/r3_r1_rwl VDD VSS VSUBS
+ detronyx_12t_2w2r_rc4_4x4_routed_5layer_direct
Xu_t000_013 u_t000_013/c0_w0_bl u_t000_013/c0_w0_br u_t000_013/c0_w1_bl u_t000_013/c0_w1_br u_t000_013/c0_r0_rbl
+ u_t000_013/c0_r1_rbl u_t000_013/c1_w0_bl u_t000_013/c1_w0_br u_t000_013/c1_w1_bl u_t000_013/c1_w1_br
+ u_t000_013/c1_r0_rbl u_t000_013/c1_r1_rbl u_t000_013/c2_w0_bl u_t000_013/c2_w0_br u_t000_013/c2_w1_bl
+ u_t000_013/c2_w1_br u_t000_013/c2_r0_rbl u_t000_013/c2_r1_rbl u_t000_013/c3_w0_bl u_t000_013/c3_w0_br
+ u_t000_013/c3_w1_bl u_t000_013/c3_w1_br u_t000_013/c3_r0_rbl u_t000_013/c3_r1_rbl u_t000_013/r0_w0_wl
+ u_t000_013/r0_w1_wl u_t000_013/r0_r0_rwl u_t000_013/r0_r1_rwl u_t000_013/r1_w0_wl u_t000_013/r1_w1_wl
+ u_t000_013/r1_r0_rwl u_t000_013/r1_r1_rwl u_t000_013/r2_w0_wl u_t000_013/r2_w1_wl u_t000_013/r2_r0_rwl
+ u_t000_013/r2_r1_rwl u_t000_013/r3_w0_wl u_t000_013/r3_w1_wl u_t000_013/r3_r0_rwl u_t000_013/r3_r1_rwl VDD VSS VSUBS
+ detronyx_12t_2w2r_rc4_4x4_routed_5layer_direct
Xu_t000_002 u_t000_002/c0_w0_bl u_t000_002/c0_w0_br u_t000_002/c0_w1_bl u_t000_002/c0_w1_br u_t000_002/c0_r0_rbl
+ u_t000_002/c0_r1_rbl u_t000_002/c1_w0_bl u_t000_002/c1_w0_br u_t000_002/c1_w1_bl u_t000_002/c1_w1_br
+ u_t000_002/c1_r0_rbl u_t000_002/c1_r1_rbl u_t000_002/c2_w0_bl u_t000_002/c2_w0_br u_t000_002/c2_w1_bl
+ u_t000_002/c2_w1_br u_t000_002/c2_r0_rbl u_t000_002/c2_r1_rbl u_t000_002/c3_w0_bl u_t000_002/c3_w0_br
+ u_t000_002/c3_w1_bl u_t000_002/c3_w1_br u_t000_002/c3_r0_rbl u_t000_002/c3_r1_rbl u_t000_002/r0_w0_wl
+ u_t000_002/r0_w1_wl u_t000_002/r0_r0_rwl u_t000_002/r0_r1_rwl u_t000_002/r1_w0_wl u_t000_002/r1_w1_wl
+ u_t000_002/r1_r0_rwl u_t000_002/r1_r1_rwl u_t000_002/r2_w0_wl u_t000_002/r2_w1_wl u_t000_002/r2_r0_rwl
+ u_t000_002/r2_r1_rwl u_t000_002/r3_w0_wl u_t000_002/r3_w1_wl u_t000_002/r3_r0_rwl u_t000_002/r3_r1_rwl VDD VSS VSUBS
+ detronyx_12t_2w2r_rc4_4x4_routed_5layer_direct
Xu_t028_005 u_t028_005/c0_w0_bl u_t028_005/c0_w0_br u_t028_005/c0_w1_bl u_t028_005/c0_w1_br u_t028_005/c0_r0_rbl
+ u_t028_005/c0_r1_rbl u_t028_005/c1_w0_bl u_t028_005/c1_w0_br u_t028_005/c1_w1_bl u_t028_005/c1_w1_br
+ u_t028_005/c1_r0_rbl u_t028_005/c1_r1_rbl u_t028_005/c2_w0_bl u_t028_005/c2_w0_br u_t028_005/c2_w1_bl
+ u_t028_005/c2_w1_br u_t028_005/c2_r0_rbl u_t028_005/c2_r1_rbl u_t028_005/c3_w0_bl u_t028_005/c3_w0_br
+ u_t028_005/c3_w1_bl u_t028_005/c3_w1_br u_t028_005/c3_r0_rbl u_t028_005/c3_r1_rbl u_t028_005/r0_w0_wl
+ u_t028_005/r0_w1_wl u_t028_005/r0_r0_rwl u_t028_005/r0_r1_rwl u_t028_005/r1_w0_wl u_t028_005/r1_w1_wl
+ u_t028_005/r1_r0_rwl u_t028_005/r1_r1_rwl u_t028_005/r2_w0_wl u_t028_005/r2_w1_wl u_t028_005/r2_r0_rwl
+ u_t028_005/r2_r1_rwl u_t028_005/r3_w0_wl u_t028_005/r3_w1_wl u_t028_005/r3_r0_rwl u_t028_005/r3_r1_rwl VDD VSS VSUBS
+ detronyx_12t_2w2r_rc4_4x4_routed_5layer_direct
Xu_t019_005 u_t019_005/c0_w0_bl u_t019_005/c0_w0_br u_t019_005/c0_w1_bl u_t019_005/c0_w1_br u_t019_005/c0_r0_rbl
+ u_t019_005/c0_r1_rbl u_t019_005/c1_w0_bl u_t019_005/c1_w0_br u_t019_005/c1_w1_bl u_t019_005/c1_w1_br
+ u_t019_005/c1_r0_rbl u_t019_005/c1_r1_rbl u_t019_005/c2_w0_bl u_t019_005/c2_w0_br u_t019_005/c2_w1_bl
+ u_t019_005/c2_w1_br u_t019_005/c2_r0_rbl u_t019_005/c2_r1_rbl u_t019_005/c3_w0_bl u_t019_005/c3_w0_br
+ u_t019_005/c3_w1_bl u_t019_005/c3_w1_br u_t019_005/c3_r0_rbl u_t019_005/c3_r1_rbl u_t019_005/r0_w0_wl
+ u_t019_005/r0_w1_wl u_t019_005/r0_r0_rwl u_t019_005/r0_r1_rwl u_t019_005/r1_w0_wl u_t019_005/r1_w1_wl
+ u_t019_005/r1_r0_rwl u_t019_005/r1_r1_rwl u_t019_005/r2_w0_wl u_t019_005/r2_w1_wl u_t019_005/r2_r0_rwl
+ u_t019_005/r2_r1_rwl u_t019_005/r3_w0_wl u_t019_005/r3_w1_wl u_t019_005/r3_r0_rwl u_t019_005/r3_r1_rwl VDD VSS VSUBS
+ detronyx_12t_2w2r_rc4_4x4_routed_5layer_direct
Xu_t025_008 u_t025_008/c0_w0_bl u_t025_008/c0_w0_br u_t025_008/c0_w1_bl u_t025_008/c0_w1_br u_t025_008/c0_r0_rbl
+ u_t025_008/c0_r1_rbl u_t025_008/c1_w0_bl u_t025_008/c1_w0_br u_t025_008/c1_w1_bl u_t025_008/c1_w1_br
+ u_t025_008/c1_r0_rbl u_t025_008/c1_r1_rbl u_t025_008/c2_w0_bl u_t025_008/c2_w0_br u_t025_008/c2_w1_bl
+ u_t025_008/c2_w1_br u_t025_008/c2_r0_rbl u_t025_008/c2_r1_rbl u_t025_008/c3_w0_bl u_t025_008/c3_w0_br
+ u_t025_008/c3_w1_bl u_t025_008/c3_w1_br u_t025_008/c3_r0_rbl u_t025_008/c3_r1_rbl u_t025_008/r0_w0_wl
+ u_t025_008/r0_w1_wl u_t025_008/r0_r0_rwl u_t025_008/r0_r1_rwl u_t025_008/r1_w0_wl u_t025_008/r1_w1_wl
+ u_t025_008/r1_r0_rwl u_t025_008/r1_r1_rwl u_t025_008/r2_w0_wl u_t025_008/r2_w1_wl u_t025_008/r2_r0_rwl
+ u_t025_008/r2_r1_rwl u_t025_008/r3_w0_wl u_t025_008/r3_w1_wl u_t025_008/r3_r0_rwl u_t025_008/r3_r1_rwl VDD VSS VSUBS
+ detronyx_12t_2w2r_rc4_4x4_routed_5layer_direct
Xu_t016_008 u_t016_008/c0_w0_bl u_t016_008/c0_w0_br u_t016_008/c0_w1_bl u_t016_008/c0_w1_br u_t016_008/c0_r0_rbl
+ u_t016_008/c0_r1_rbl u_t016_008/c1_w0_bl u_t016_008/c1_w0_br u_t016_008/c1_w1_bl u_t016_008/c1_w1_br
+ u_t016_008/c1_r0_rbl u_t016_008/c1_r1_rbl u_t016_008/c2_w0_bl u_t016_008/c2_w0_br u_t016_008/c2_w1_bl
+ u_t016_008/c2_w1_br u_t016_008/c2_r0_rbl u_t016_008/c2_r1_rbl u_t016_008/c3_w0_bl u_t016_008/c3_w0_br
+ u_t016_008/c3_w1_bl u_t016_008/c3_w1_br u_t016_008/c3_r0_rbl u_t016_008/c3_r1_rbl u_t016_008/r0_w0_wl
+ u_t016_008/r0_w1_wl u_t016_008/r0_r0_rwl u_t016_008/r0_r1_rwl u_t016_008/r1_w0_wl u_t016_008/r1_w1_wl
+ u_t016_008/r1_r0_rwl u_t016_008/r1_r1_rwl u_t016_008/r2_w0_wl u_t016_008/r2_w1_wl u_t016_008/r2_r0_rwl
+ u_t016_008/r2_r1_rwl u_t016_008/r3_w0_wl u_t016_008/r3_w1_wl u_t016_008/r3_r0_rwl u_t016_008/r3_r1_rwl VDD VSS VSUBS
+ detronyx_12t_2w2r_rc4_4x4_routed_5layer_direct
Xu_t030_011 u_t030_011/c0_w0_bl u_t030_011/c0_w0_br u_t030_011/c0_w1_bl u_t030_011/c0_w1_br u_t030_011/c0_r0_rbl
+ u_t030_011/c0_r1_rbl u_t030_011/c1_w0_bl u_t030_011/c1_w0_br u_t030_011/c1_w1_bl u_t030_011/c1_w1_br
+ u_t030_011/c1_r0_rbl u_t030_011/c1_r1_rbl u_t030_011/c2_w0_bl u_t030_011/c2_w0_br u_t030_011/c2_w1_bl
+ u_t030_011/c2_w1_br u_t030_011/c2_r0_rbl u_t030_011/c2_r1_rbl u_t030_011/c3_w0_bl u_t030_011/c3_w0_br
+ u_t030_011/c3_w1_bl u_t030_011/c3_w1_br u_t030_011/c3_r0_rbl u_t030_011/c3_r1_rbl u_t030_011/r0_w0_wl
+ u_t030_011/r0_w1_wl u_t030_011/r0_r0_rwl u_t030_011/r0_r1_rwl u_t030_011/r1_w0_wl u_t030_011/r1_w1_wl
+ u_t030_011/r1_r0_rwl u_t030_011/r1_r1_rwl u_t030_011/r2_w0_wl u_t030_011/r2_w1_wl u_t030_011/r2_r0_rwl
+ u_t030_011/r2_r1_rwl u_t030_011/r3_w0_wl u_t030_011/r3_w1_wl u_t030_011/r3_r0_rwl u_t030_011/r3_r1_rwl VDD VSS VSUBS
+ detronyx_12t_2w2r_rc4_4x4_routed_5layer_direct
Xu_t030_000 u_t030_000/c0_w0_bl u_t030_000/c0_w0_br u_t030_000/c0_w1_bl u_t030_000/c0_w1_br u_t030_000/c0_r0_rbl
+ u_t030_000/c0_r1_rbl u_t030_000/c1_w0_bl u_t030_000/c1_w0_br u_t030_000/c1_w1_bl u_t030_000/c1_w1_br
+ u_t030_000/c1_r0_rbl u_t030_000/c1_r1_rbl u_t030_000/c2_w0_bl u_t030_000/c2_w0_br u_t030_000/c2_w1_bl
+ u_t030_000/c2_w1_br u_t030_000/c2_r0_rbl u_t030_000/c2_r1_rbl u_t030_000/c3_w0_bl u_t030_000/c3_w0_br
+ u_t030_000/c3_w1_bl u_t030_000/c3_w1_br u_t030_000/c3_r0_rbl u_t030_000/c3_r1_rbl u_t030_000/r0_w0_wl
+ u_t030_000/r0_w1_wl u_t030_000/r0_r0_rwl u_t030_000/r0_r1_rwl u_t030_000/r1_w0_wl u_t030_000/r1_w1_wl
+ u_t030_000/r1_r0_rwl u_t030_000/r1_r1_rwl u_t030_000/r2_w0_wl u_t030_000/r2_w1_wl u_t030_000/r2_r0_rwl
+ u_t030_000/r2_r1_rwl u_t030_000/r3_w0_wl u_t030_000/r3_w1_wl u_t030_000/r3_r0_rwl u_t030_000/r3_r1_rwl VDD VSS VSUBS
+ detronyx_12t_2w2r_rc4_4x4_routed_5layer_direct
Xu_t007_008 u_t007_008/c0_w0_bl u_t007_008/c0_w0_br u_t007_008/c0_w1_bl u_t007_008/c0_w1_br u_t007_008/c0_r0_rbl
+ u_t007_008/c0_r1_rbl u_t007_008/c1_w0_bl u_t007_008/c1_w0_br u_t007_008/c1_w1_bl u_t007_008/c1_w1_br
+ u_t007_008/c1_r0_rbl u_t007_008/c1_r1_rbl u_t007_008/c2_w0_bl u_t007_008/c2_w0_br u_t007_008/c2_w1_bl
+ u_t007_008/c2_w1_br u_t007_008/c2_r0_rbl u_t007_008/c2_r1_rbl u_t007_008/c3_w0_bl u_t007_008/c3_w0_br
+ u_t007_008/c3_w1_bl u_t007_008/c3_w1_br u_t007_008/c3_r0_rbl u_t007_008/c3_r1_rbl u_t007_008/r0_w0_wl
+ u_t007_008/r0_w1_wl u_t007_008/r0_r0_rwl u_t007_008/r0_r1_rwl u_t007_008/r1_w0_wl u_t007_008/r1_w1_wl
+ u_t007_008/r1_r0_rwl u_t007_008/r1_r1_rwl u_t007_008/r2_w0_wl u_t007_008/r2_w1_wl u_t007_008/r2_r0_rwl
+ u_t007_008/r2_r1_rwl u_t007_008/r3_w0_wl u_t007_008/r3_w1_wl u_t007_008/r3_r0_rwl u_t007_008/r3_r1_rwl VDD VSS VSUBS
+ detronyx_12t_2w2r_rc4_4x4_routed_5layer_direct
Xu_t021_000 u_t021_000/c0_w0_bl u_t021_000/c0_w0_br u_t021_000/c0_w1_bl u_t021_000/c0_w1_br u_t021_000/c0_r0_rbl
+ u_t021_000/c0_r1_rbl u_t021_000/c1_w0_bl u_t021_000/c1_w0_br u_t021_000/c1_w1_bl u_t021_000/c1_w1_br
+ u_t021_000/c1_r0_rbl u_t021_000/c1_r1_rbl u_t021_000/c2_w0_bl u_t021_000/c2_w0_br u_t021_000/c2_w1_bl
+ u_t021_000/c2_w1_br u_t021_000/c2_r0_rbl u_t021_000/c2_r1_rbl u_t021_000/c3_w0_bl u_t021_000/c3_w0_br
+ u_t021_000/c3_w1_bl u_t021_000/c3_w1_br u_t021_000/c3_r0_rbl u_t021_000/c3_r1_rbl u_t021_000/r0_w0_wl
+ u_t021_000/r0_w1_wl u_t021_000/r0_r0_rwl u_t021_000/r0_r1_rwl u_t021_000/r1_w0_wl u_t021_000/r1_w1_wl
+ u_t021_000/r1_r0_rwl u_t021_000/r1_r1_rwl u_t021_000/r2_w0_wl u_t021_000/r2_w1_wl u_t021_000/r2_r0_rwl
+ u_t021_000/r2_r1_rwl u_t021_000/r3_w0_wl u_t021_000/r3_w1_wl u_t021_000/r3_r0_rwl u_t021_000/r3_r1_rwl VDD VSS VSUBS
+ detronyx_12t_2w2r_rc4_4x4_routed_5layer_direct
Xu_t021_011 u_t021_011/c0_w0_bl u_t021_011/c0_w0_br u_t021_011/c0_w1_bl u_t021_011/c0_w1_br u_t021_011/c0_r0_rbl
+ u_t021_011/c0_r1_rbl u_t021_011/c1_w0_bl u_t021_011/c1_w0_br u_t021_011/c1_w1_bl u_t021_011/c1_w1_br
+ u_t021_011/c1_r0_rbl u_t021_011/c1_r1_rbl u_t021_011/c2_w0_bl u_t021_011/c2_w0_br u_t021_011/c2_w1_bl
+ u_t021_011/c2_w1_br u_t021_011/c2_r0_rbl u_t021_011/c2_r1_rbl u_t021_011/c3_w0_bl u_t021_011/c3_w0_br
+ u_t021_011/c3_w1_bl u_t021_011/c3_w1_br u_t021_011/c3_r0_rbl u_t021_011/c3_r1_rbl u_t021_011/r0_w0_wl
+ u_t021_011/r0_w1_wl u_t021_011/r0_r0_rwl u_t021_011/r0_r1_rwl u_t021_011/r1_w0_wl u_t021_011/r1_w1_wl
+ u_t021_011/r1_r0_rwl u_t021_011/r1_r1_rwl u_t021_011/r2_w0_wl u_t021_011/r2_w1_wl u_t021_011/r2_r0_rwl
+ u_t021_011/r2_r1_rwl u_t021_011/r3_w0_wl u_t021_011/r3_w1_wl u_t021_011/r3_r0_rwl u_t021_011/r3_r1_rwl VDD VSS VSUBS
+ detronyx_12t_2w2r_rc4_4x4_routed_5layer_direct
Xu_t003_011 u_t003_011/c0_w0_bl u_t003_011/c0_w0_br u_t003_011/c0_w1_bl u_t003_011/c0_w1_br u_t003_011/c0_r0_rbl
+ u_t003_011/c0_r1_rbl u_t003_011/c1_w0_bl u_t003_011/c1_w0_br u_t003_011/c1_w1_bl u_t003_011/c1_w1_br
+ u_t003_011/c1_r0_rbl u_t003_011/c1_r1_rbl u_t003_011/c2_w0_bl u_t003_011/c2_w0_br u_t003_011/c2_w1_bl
+ u_t003_011/c2_w1_br u_t003_011/c2_r0_rbl u_t003_011/c2_r1_rbl u_t003_011/c3_w0_bl u_t003_011/c3_w0_br
+ u_t003_011/c3_w1_bl u_t003_011/c3_w1_br u_t003_011/c3_r0_rbl u_t003_011/c3_r1_rbl u_t003_011/r0_w0_wl
+ u_t003_011/r0_w1_wl u_t003_011/r0_r0_rwl u_t003_011/r0_r1_rwl u_t003_011/r1_w0_wl u_t003_011/r1_w1_wl
+ u_t003_011/r1_r0_rwl u_t003_011/r1_r1_rwl u_t003_011/r2_w0_wl u_t003_011/r2_w1_wl u_t003_011/r2_r0_rwl
+ u_t003_011/r2_r1_rwl u_t003_011/r3_w0_wl u_t003_011/r3_w1_wl u_t003_011/r3_r0_rwl u_t003_011/r3_r1_rwl VDD VSS VSUBS
+ detronyx_12t_2w2r_rc4_4x4_routed_5layer_direct
Xu_t003_000 u_t003_000/c0_w0_bl u_t003_000/c0_w0_br u_t003_000/c0_w1_bl u_t003_000/c0_w1_br u_t003_000/c0_r0_rbl
+ u_t003_000/c0_r1_rbl u_t003_000/c1_w0_bl u_t003_000/c1_w0_br u_t003_000/c1_w1_bl u_t003_000/c1_w1_br
+ u_t003_000/c1_r0_rbl u_t003_000/c1_r1_rbl u_t003_000/c2_w0_bl u_t003_000/c2_w0_br u_t003_000/c2_w1_bl
+ u_t003_000/c2_w1_br u_t003_000/c2_r0_rbl u_t003_000/c2_r1_rbl u_t003_000/c3_w0_bl u_t003_000/c3_w0_br
+ u_t003_000/c3_w1_bl u_t003_000/c3_w1_br u_t003_000/c3_r0_rbl u_t003_000/c3_r1_rbl u_t003_000/r0_w0_wl
+ u_t003_000/r0_w1_wl u_t003_000/r0_r0_rwl u_t003_000/r0_r1_rwl u_t003_000/r1_w0_wl u_t003_000/r1_w1_wl
+ u_t003_000/r1_r0_rwl u_t003_000/r1_r1_rwl u_t003_000/r2_w0_wl u_t003_000/r2_w1_wl u_t003_000/r2_r0_rwl
+ u_t003_000/r2_r1_rwl u_t003_000/r3_w0_wl u_t003_000/r3_w1_wl u_t003_000/r3_r0_rwl u_t003_000/r3_r1_rwl VDD VSS VSUBS
+ detronyx_12t_2w2r_rc4_4x4_routed_5layer_direct
Xu_t012_000 u_t012_000/c0_w0_bl u_t012_000/c0_w0_br u_t012_000/c0_w1_bl u_t012_000/c0_w1_br u_t012_000/c0_r0_rbl
+ u_t012_000/c0_r1_rbl u_t012_000/c1_w0_bl u_t012_000/c1_w0_br u_t012_000/c1_w1_bl u_t012_000/c1_w1_br
+ u_t012_000/c1_r0_rbl u_t012_000/c1_r1_rbl u_t012_000/c2_w0_bl u_t012_000/c2_w0_br u_t012_000/c2_w1_bl
+ u_t012_000/c2_w1_br u_t012_000/c2_r0_rbl u_t012_000/c2_r1_rbl u_t012_000/c3_w0_bl u_t012_000/c3_w0_br
+ u_t012_000/c3_w1_bl u_t012_000/c3_w1_br u_t012_000/c3_r0_rbl u_t012_000/c3_r1_rbl u_t012_000/r0_w0_wl
+ u_t012_000/r0_w1_wl u_t012_000/r0_r0_rwl u_t012_000/r0_r1_rwl u_t012_000/r1_w0_wl u_t012_000/r1_w1_wl
+ u_t012_000/r1_r0_rwl u_t012_000/r1_r1_rwl u_t012_000/r2_w0_wl u_t012_000/r2_w1_wl u_t012_000/r2_r0_rwl
+ u_t012_000/r2_r1_rwl u_t012_000/r3_w0_wl u_t012_000/r3_w1_wl u_t012_000/r3_r0_rwl u_t012_000/r3_r1_rwl VDD VSS VSUBS
+ detronyx_12t_2w2r_rc4_4x4_routed_5layer_direct
Xu_t012_011 u_t012_011/c0_w0_bl u_t012_011/c0_w0_br u_t012_011/c0_w1_bl u_t012_011/c0_w1_br u_t012_011/c0_r0_rbl
+ u_t012_011/c0_r1_rbl u_t012_011/c1_w0_bl u_t012_011/c1_w0_br u_t012_011/c1_w1_bl u_t012_011/c1_w1_br
+ u_t012_011/c1_r0_rbl u_t012_011/c1_r1_rbl u_t012_011/c2_w0_bl u_t012_011/c2_w0_br u_t012_011/c2_w1_bl
+ u_t012_011/c2_w1_br u_t012_011/c2_r0_rbl u_t012_011/c2_r1_rbl u_t012_011/c3_w0_bl u_t012_011/c3_w0_br
+ u_t012_011/c3_w1_bl u_t012_011/c3_w1_br u_t012_011/c3_r0_rbl u_t012_011/c3_r1_rbl u_t012_011/r0_w0_wl
+ u_t012_011/r0_w1_wl u_t012_011/r0_r0_rwl u_t012_011/r0_r1_rwl u_t012_011/r1_w0_wl u_t012_011/r1_w1_wl
+ u_t012_011/r1_r0_rwl u_t012_011/r1_r1_rwl u_t012_011/r2_w0_wl u_t012_011/r2_w1_wl u_t012_011/r2_r0_rwl
+ u_t012_011/r2_r1_rwl u_t012_011/r3_w0_wl u_t012_011/r3_w1_wl u_t012_011/r3_r0_rwl u_t012_011/r3_r1_rwl VDD VSS VSUBS
+ detronyx_12t_2w2r_rc4_4x4_routed_5layer_direct
Xu_t000_014 u_t000_014/c0_w0_bl u_t000_014/c0_w0_br u_t000_014/c0_w1_bl u_t000_014/c0_w1_br u_t000_014/c0_r0_rbl
+ u_t000_014/c0_r1_rbl u_t000_014/c1_w0_bl u_t000_014/c1_w0_br u_t000_014/c1_w1_bl u_t000_014/c1_w1_br
+ u_t000_014/c1_r0_rbl u_t000_014/c1_r1_rbl u_t000_014/c2_w0_bl u_t000_014/c2_w0_br u_t000_014/c2_w1_bl
+ u_t000_014/c2_w1_br u_t000_014/c2_r0_rbl u_t000_014/c2_r1_rbl u_t000_014/c3_w0_bl u_t000_014/c3_w0_br
+ u_t000_014/c3_w1_bl u_t000_014/c3_w1_br u_t000_014/c3_r0_rbl u_t000_014/c3_r1_rbl u_t000_014/r0_w0_wl
+ u_t000_014/r0_w1_wl u_t000_014/r0_r0_rwl u_t000_014/r0_r1_rwl u_t000_014/r1_w0_wl u_t000_014/r1_w1_wl
+ u_t000_014/r1_r0_rwl u_t000_014/r1_r1_rwl u_t000_014/r2_w0_wl u_t000_014/r2_w1_wl u_t000_014/r2_r0_rwl
+ u_t000_014/r2_r1_rwl u_t000_014/r3_w0_wl u_t000_014/r3_w1_wl u_t000_014/r3_r0_rwl u_t000_014/r3_r1_rwl VDD VSS VSUBS
+ detronyx_12t_2w2r_rc4_4x4_routed_5layer_direct
Xu_t000_003 u_t000_003/c0_w0_bl u_t000_003/c0_w0_br u_t000_003/c0_w1_bl u_t000_003/c0_w1_br u_t000_003/c0_r0_rbl
+ u_t000_003/c0_r1_rbl u_t000_003/c1_w0_bl u_t000_003/c1_w0_br u_t000_003/c1_w1_bl u_t000_003/c1_w1_br
+ u_t000_003/c1_r0_rbl u_t000_003/c1_r1_rbl u_t000_003/c2_w0_bl u_t000_003/c2_w0_br u_t000_003/c2_w1_bl
+ u_t000_003/c2_w1_br u_t000_003/c2_r0_rbl u_t000_003/c2_r1_rbl u_t000_003/c3_w0_bl u_t000_003/c3_w0_br
+ u_t000_003/c3_w1_bl u_t000_003/c3_w1_br u_t000_003/c3_r0_rbl u_t000_003/c3_r1_rbl u_t000_003/r0_w0_wl
+ u_t000_003/r0_w1_wl u_t000_003/r0_r0_rwl u_t000_003/r0_r1_rwl u_t000_003/r1_w0_wl u_t000_003/r1_w1_wl
+ u_t000_003/r1_r0_rwl u_t000_003/r1_r1_rwl u_t000_003/r2_w0_wl u_t000_003/r2_w1_wl u_t000_003/r2_r0_rwl
+ u_t000_003/r2_r1_rwl u_t000_003/r3_w0_wl u_t000_003/r3_w1_wl u_t000_003/r3_r0_rwl u_t000_003/r3_r1_rwl VDD VSS VSUBS
+ detronyx_12t_2w2r_rc4_4x4_routed_5layer_direct
Xu_t028_006 u_t028_006/c0_w0_bl u_t028_006/c0_w0_br u_t028_006/c0_w1_bl u_t028_006/c0_w1_br u_t028_006/c0_r0_rbl
+ u_t028_006/c0_r1_rbl u_t028_006/c1_w0_bl u_t028_006/c1_w0_br u_t028_006/c1_w1_bl u_t028_006/c1_w1_br
+ u_t028_006/c1_r0_rbl u_t028_006/c1_r1_rbl u_t028_006/c2_w0_bl u_t028_006/c2_w0_br u_t028_006/c2_w1_bl
+ u_t028_006/c2_w1_br u_t028_006/c2_r0_rbl u_t028_006/c2_r1_rbl u_t028_006/c3_w0_bl u_t028_006/c3_w0_br
+ u_t028_006/c3_w1_bl u_t028_006/c3_w1_br u_t028_006/c3_r0_rbl u_t028_006/c3_r1_rbl u_t028_006/r0_w0_wl
+ u_t028_006/r0_w1_wl u_t028_006/r0_r0_rwl u_t028_006/r0_r1_rwl u_t028_006/r1_w0_wl u_t028_006/r1_w1_wl
+ u_t028_006/r1_r0_rwl u_t028_006/r1_r1_rwl u_t028_006/r2_w0_wl u_t028_006/r2_w1_wl u_t028_006/r2_r0_rwl
+ u_t028_006/r2_r1_rwl u_t028_006/r3_w0_wl u_t028_006/r3_w1_wl u_t028_006/r3_r0_rwl u_t028_006/r3_r1_rwl VDD VSS VSUBS
+ detronyx_12t_2w2r_rc4_4x4_routed_5layer_direct
Xu_t019_006 u_t019_006/c0_w0_bl u_t019_006/c0_w0_br u_t019_006/c0_w1_bl u_t019_006/c0_w1_br u_t019_006/c0_r0_rbl
+ u_t019_006/c0_r1_rbl u_t019_006/c1_w0_bl u_t019_006/c1_w0_br u_t019_006/c1_w1_bl u_t019_006/c1_w1_br
+ u_t019_006/c1_r0_rbl u_t019_006/c1_r1_rbl u_t019_006/c2_w0_bl u_t019_006/c2_w0_br u_t019_006/c2_w1_bl
+ u_t019_006/c2_w1_br u_t019_006/c2_r0_rbl u_t019_006/c2_r1_rbl u_t019_006/c3_w0_bl u_t019_006/c3_w0_br
+ u_t019_006/c3_w1_bl u_t019_006/c3_w1_br u_t019_006/c3_r0_rbl u_t019_006/c3_r1_rbl u_t019_006/r0_w0_wl
+ u_t019_006/r0_w1_wl u_t019_006/r0_r0_rwl u_t019_006/r0_r1_rwl u_t019_006/r1_w0_wl u_t019_006/r1_w1_wl
+ u_t019_006/r1_r0_rwl u_t019_006/r1_r1_rwl u_t019_006/r2_w0_wl u_t019_006/r2_w1_wl u_t019_006/r2_r0_rwl
+ u_t019_006/r2_r1_rwl u_t019_006/r3_w0_wl u_t019_006/r3_w1_wl u_t019_006/r3_r0_rwl u_t019_006/r3_r1_rwl VDD VSS VSUBS
+ detronyx_12t_2w2r_rc4_4x4_routed_5layer_direct
Xu_t025_009 u_t025_009/c0_w0_bl u_t025_009/c0_w0_br u_t025_009/c0_w1_bl u_t025_009/c0_w1_br u_t025_009/c0_r0_rbl
+ u_t025_009/c0_r1_rbl u_t025_009/c1_w0_bl u_t025_009/c1_w0_br u_t025_009/c1_w1_bl u_t025_009/c1_w1_br
+ u_t025_009/c1_r0_rbl u_t025_009/c1_r1_rbl u_t025_009/c2_w0_bl u_t025_009/c2_w0_br u_t025_009/c2_w1_bl
+ u_t025_009/c2_w1_br u_t025_009/c2_r0_rbl u_t025_009/c2_r1_rbl u_t025_009/c3_w0_bl u_t025_009/c3_w0_br
+ u_t025_009/c3_w1_bl u_t025_009/c3_w1_br u_t025_009/c3_r0_rbl u_t025_009/c3_r1_rbl u_t025_009/r0_w0_wl
+ u_t025_009/r0_w1_wl u_t025_009/r0_r0_rwl u_t025_009/r0_r1_rwl u_t025_009/r1_w0_wl u_t025_009/r1_w1_wl
+ u_t025_009/r1_r0_rwl u_t025_009/r1_r1_rwl u_t025_009/r2_w0_wl u_t025_009/r2_w1_wl u_t025_009/r2_r0_rwl
+ u_t025_009/r2_r1_rwl u_t025_009/r3_w0_wl u_t025_009/r3_w1_wl u_t025_009/r3_r0_rwl u_t025_009/r3_r1_rwl VDD VSS VSUBS
+ detronyx_12t_2w2r_rc4_4x4_routed_5layer_direct
Xu_t016_009 u_t016_009/c0_w0_bl u_t016_009/c0_w0_br u_t016_009/c0_w1_bl u_t016_009/c0_w1_br u_t016_009/c0_r0_rbl
+ u_t016_009/c0_r1_rbl u_t016_009/c1_w0_bl u_t016_009/c1_w0_br u_t016_009/c1_w1_bl u_t016_009/c1_w1_br
+ u_t016_009/c1_r0_rbl u_t016_009/c1_r1_rbl u_t016_009/c2_w0_bl u_t016_009/c2_w0_br u_t016_009/c2_w1_bl
+ u_t016_009/c2_w1_br u_t016_009/c2_r0_rbl u_t016_009/c2_r1_rbl u_t016_009/c3_w0_bl u_t016_009/c3_w0_br
+ u_t016_009/c3_w1_bl u_t016_009/c3_w1_br u_t016_009/c3_r0_rbl u_t016_009/c3_r1_rbl u_t016_009/r0_w0_wl
+ u_t016_009/r0_w1_wl u_t016_009/r0_r0_rwl u_t016_009/r0_r1_rwl u_t016_009/r1_w0_wl u_t016_009/r1_w1_wl
+ u_t016_009/r1_r0_rwl u_t016_009/r1_r1_rwl u_t016_009/r2_w0_wl u_t016_009/r2_w1_wl u_t016_009/r2_r0_rwl
+ u_t016_009/r2_r1_rwl u_t016_009/r3_w0_wl u_t016_009/r3_w1_wl u_t016_009/r3_r0_rwl u_t016_009/r3_r1_rwl VDD VSS VSUBS
+ detronyx_12t_2w2r_rc4_4x4_routed_5layer_direct
Xu_t030_012 u_t030_012/c0_w0_bl u_t030_012/c0_w0_br u_t030_012/c0_w1_bl u_t030_012/c0_w1_br u_t030_012/c0_r0_rbl
+ u_t030_012/c0_r1_rbl u_t030_012/c1_w0_bl u_t030_012/c1_w0_br u_t030_012/c1_w1_bl u_t030_012/c1_w1_br
+ u_t030_012/c1_r0_rbl u_t030_012/c1_r1_rbl u_t030_012/c2_w0_bl u_t030_012/c2_w0_br u_t030_012/c2_w1_bl
+ u_t030_012/c2_w1_br u_t030_012/c2_r0_rbl u_t030_012/c2_r1_rbl u_t030_012/c3_w0_bl u_t030_012/c3_w0_br
+ u_t030_012/c3_w1_bl u_t030_012/c3_w1_br u_t030_012/c3_r0_rbl u_t030_012/c3_r1_rbl u_t030_012/r0_w0_wl
+ u_t030_012/r0_w1_wl u_t030_012/r0_r0_rwl u_t030_012/r0_r1_rwl u_t030_012/r1_w0_wl u_t030_012/r1_w1_wl
+ u_t030_012/r1_r0_rwl u_t030_012/r1_r1_rwl u_t030_012/r2_w0_wl u_t030_012/r2_w1_wl u_t030_012/r2_r0_rwl
+ u_t030_012/r2_r1_rwl u_t030_012/r3_w0_wl u_t030_012/r3_w1_wl u_t030_012/r3_r0_rwl u_t030_012/r3_r1_rwl VDD VSS VSUBS
+ detronyx_12t_2w2r_rc4_4x4_routed_5layer_direct
Xu_t030_001 u_t030_001/c0_w0_bl u_t030_001/c0_w0_br u_t030_001/c0_w1_bl u_t030_001/c0_w1_br u_t030_001/c0_r0_rbl
+ u_t030_001/c0_r1_rbl u_t030_001/c1_w0_bl u_t030_001/c1_w0_br u_t030_001/c1_w1_bl u_t030_001/c1_w1_br
+ u_t030_001/c1_r0_rbl u_t030_001/c1_r1_rbl u_t030_001/c2_w0_bl u_t030_001/c2_w0_br u_t030_001/c2_w1_bl
+ u_t030_001/c2_w1_br u_t030_001/c2_r0_rbl u_t030_001/c2_r1_rbl u_t030_001/c3_w0_bl u_t030_001/c3_w0_br
+ u_t030_001/c3_w1_bl u_t030_001/c3_w1_br u_t030_001/c3_r0_rbl u_t030_001/c3_r1_rbl u_t030_001/r0_w0_wl
+ u_t030_001/r0_w1_wl u_t030_001/r0_r0_rwl u_t030_001/r0_r1_rwl u_t030_001/r1_w0_wl u_t030_001/r1_w1_wl
+ u_t030_001/r1_r0_rwl u_t030_001/r1_r1_rwl u_t030_001/r2_w0_wl u_t030_001/r2_w1_wl u_t030_001/r2_r0_rwl
+ u_t030_001/r2_r1_rwl u_t030_001/r3_w0_wl u_t030_001/r3_w1_wl u_t030_001/r3_r0_rwl u_t030_001/r3_r1_rwl VDD VSS VSUBS
+ detronyx_12t_2w2r_rc4_4x4_routed_5layer_direct
Xu_t007_009 u_t007_009/c0_w0_bl u_t007_009/c0_w0_br u_t007_009/c0_w1_bl u_t007_009/c0_w1_br u_t007_009/c0_r0_rbl
+ u_t007_009/c0_r1_rbl u_t007_009/c1_w0_bl u_t007_009/c1_w0_br u_t007_009/c1_w1_bl u_t007_009/c1_w1_br
+ u_t007_009/c1_r0_rbl u_t007_009/c1_r1_rbl u_t007_009/c2_w0_bl u_t007_009/c2_w0_br u_t007_009/c2_w1_bl
+ u_t007_009/c2_w1_br u_t007_009/c2_r0_rbl u_t007_009/c2_r1_rbl u_t007_009/c3_w0_bl u_t007_009/c3_w0_br
+ u_t007_009/c3_w1_bl u_t007_009/c3_w1_br u_t007_009/c3_r0_rbl u_t007_009/c3_r1_rbl u_t007_009/r0_w0_wl
+ u_t007_009/r0_w1_wl u_t007_009/r0_r0_rwl u_t007_009/r0_r1_rwl u_t007_009/r1_w0_wl u_t007_009/r1_w1_wl
+ u_t007_009/r1_r0_rwl u_t007_009/r1_r1_rwl u_t007_009/r2_w0_wl u_t007_009/r2_w1_wl u_t007_009/r2_r0_rwl
+ u_t007_009/r2_r1_rwl u_t007_009/r3_w0_wl u_t007_009/r3_w1_wl u_t007_009/r3_r0_rwl u_t007_009/r3_r1_rwl VDD VSS VSUBS
+ detronyx_12t_2w2r_rc4_4x4_routed_5layer_direct
Xu_t021_001 u_t021_001/c0_w0_bl u_t021_001/c0_w0_br u_t021_001/c0_w1_bl u_t021_001/c0_w1_br u_t021_001/c0_r0_rbl
+ u_t021_001/c0_r1_rbl u_t021_001/c1_w0_bl u_t021_001/c1_w0_br u_t021_001/c1_w1_bl u_t021_001/c1_w1_br
+ u_t021_001/c1_r0_rbl u_t021_001/c1_r1_rbl u_t021_001/c2_w0_bl u_t021_001/c2_w0_br u_t021_001/c2_w1_bl
+ u_t021_001/c2_w1_br u_t021_001/c2_r0_rbl u_t021_001/c2_r1_rbl u_t021_001/c3_w0_bl u_t021_001/c3_w0_br
+ u_t021_001/c3_w1_bl u_t021_001/c3_w1_br u_t021_001/c3_r0_rbl u_t021_001/c3_r1_rbl u_t021_001/r0_w0_wl
+ u_t021_001/r0_w1_wl u_t021_001/r0_r0_rwl u_t021_001/r0_r1_rwl u_t021_001/r1_w0_wl u_t021_001/r1_w1_wl
+ u_t021_001/r1_r0_rwl u_t021_001/r1_r1_rwl u_t021_001/r2_w0_wl u_t021_001/r2_w1_wl u_t021_001/r2_r0_rwl
+ u_t021_001/r2_r1_rwl u_t021_001/r3_w0_wl u_t021_001/r3_w1_wl u_t021_001/r3_r0_rwl u_t021_001/r3_r1_rwl VDD VSS VSUBS
+ detronyx_12t_2w2r_rc4_4x4_routed_5layer_direct
Xu_t021_012 u_t021_012/c0_w0_bl u_t021_012/c0_w0_br u_t021_012/c0_w1_bl u_t021_012/c0_w1_br u_t021_012/c0_r0_rbl
+ u_t021_012/c0_r1_rbl u_t021_012/c1_w0_bl u_t021_012/c1_w0_br u_t021_012/c1_w1_bl u_t021_012/c1_w1_br
+ u_t021_012/c1_r0_rbl u_t021_012/c1_r1_rbl u_t021_012/c2_w0_bl u_t021_012/c2_w0_br u_t021_012/c2_w1_bl
+ u_t021_012/c2_w1_br u_t021_012/c2_r0_rbl u_t021_012/c2_r1_rbl u_t021_012/c3_w0_bl u_t021_012/c3_w0_br
+ u_t021_012/c3_w1_bl u_t021_012/c3_w1_br u_t021_012/c3_r0_rbl u_t021_012/c3_r1_rbl u_t021_012/r0_w0_wl
+ u_t021_012/r0_w1_wl u_t021_012/r0_r0_rwl u_t021_012/r0_r1_rwl u_t021_012/r1_w0_wl u_t021_012/r1_w1_wl
+ u_t021_012/r1_r0_rwl u_t021_012/r1_r1_rwl u_t021_012/r2_w0_wl u_t021_012/r2_w1_wl u_t021_012/r2_r0_rwl
+ u_t021_012/r2_r1_rwl u_t021_012/r3_w0_wl u_t021_012/r3_w1_wl u_t021_012/r3_r0_rwl u_t021_012/r3_r1_rwl VDD VSS VSUBS
+ detronyx_12t_2w2r_rc4_4x4_routed_5layer_direct
Xu_t012_001 u_t012_001/c0_w0_bl u_t012_001/c0_w0_br u_t012_001/c0_w1_bl u_t012_001/c0_w1_br u_t012_001/c0_r0_rbl
+ u_t012_001/c0_r1_rbl u_t012_001/c1_w0_bl u_t012_001/c1_w0_br u_t012_001/c1_w1_bl u_t012_001/c1_w1_br
+ u_t012_001/c1_r0_rbl u_t012_001/c1_r1_rbl u_t012_001/c2_w0_bl u_t012_001/c2_w0_br u_t012_001/c2_w1_bl
+ u_t012_001/c2_w1_br u_t012_001/c2_r0_rbl u_t012_001/c2_r1_rbl u_t012_001/c3_w0_bl u_t012_001/c3_w0_br
+ u_t012_001/c3_w1_bl u_t012_001/c3_w1_br u_t012_001/c3_r0_rbl u_t012_001/c3_r1_rbl u_t012_001/r0_w0_wl
+ u_t012_001/r0_w1_wl u_t012_001/r0_r0_rwl u_t012_001/r0_r1_rwl u_t012_001/r1_w0_wl u_t012_001/r1_w1_wl
+ u_t012_001/r1_r0_rwl u_t012_001/r1_r1_rwl u_t012_001/r2_w0_wl u_t012_001/r2_w1_wl u_t012_001/r2_r0_rwl
+ u_t012_001/r2_r1_rwl u_t012_001/r3_w0_wl u_t012_001/r3_w1_wl u_t012_001/r3_r0_rwl u_t012_001/r3_r1_rwl VDD VSS VSUBS
+ detronyx_12t_2w2r_rc4_4x4_routed_5layer_direct
Xu_t012_012 u_t012_012/c0_w0_bl u_t012_012/c0_w0_br u_t012_012/c0_w1_bl u_t012_012/c0_w1_br u_t012_012/c0_r0_rbl
+ u_t012_012/c0_r1_rbl u_t012_012/c1_w0_bl u_t012_012/c1_w0_br u_t012_012/c1_w1_bl u_t012_012/c1_w1_br
+ u_t012_012/c1_r0_rbl u_t012_012/c1_r1_rbl u_t012_012/c2_w0_bl u_t012_012/c2_w0_br u_t012_012/c2_w1_bl
+ u_t012_012/c2_w1_br u_t012_012/c2_r0_rbl u_t012_012/c2_r1_rbl u_t012_012/c3_w0_bl u_t012_012/c3_w0_br
+ u_t012_012/c3_w1_bl u_t012_012/c3_w1_br u_t012_012/c3_r0_rbl u_t012_012/c3_r1_rbl u_t012_012/r0_w0_wl
+ u_t012_012/r0_w1_wl u_t012_012/r0_r0_rwl u_t012_012/r0_r1_rwl u_t012_012/r1_w0_wl u_t012_012/r1_w1_wl
+ u_t012_012/r1_r0_rwl u_t012_012/r1_r1_rwl u_t012_012/r2_w0_wl u_t012_012/r2_w1_wl u_t012_012/r2_r0_rwl
+ u_t012_012/r2_r1_rwl u_t012_012/r3_w0_wl u_t012_012/r3_w1_wl u_t012_012/r3_r0_rwl u_t012_012/r3_r1_rwl VDD VSS VSUBS
+ detronyx_12t_2w2r_rc4_4x4_routed_5layer_direct
Xu_t003_012 u_t003_012/c0_w0_bl u_t003_012/c0_w0_br u_t003_012/c0_w1_bl u_t003_012/c0_w1_br u_t003_012/c0_r0_rbl
+ u_t003_012/c0_r1_rbl u_t003_012/c1_w0_bl u_t003_012/c1_w0_br u_t003_012/c1_w1_bl u_t003_012/c1_w1_br
+ u_t003_012/c1_r0_rbl u_t003_012/c1_r1_rbl u_t003_012/c2_w0_bl u_t003_012/c2_w0_br u_t003_012/c2_w1_bl
+ u_t003_012/c2_w1_br u_t003_012/c2_r0_rbl u_t003_012/c2_r1_rbl u_t003_012/c3_w0_bl u_t003_012/c3_w0_br
+ u_t003_012/c3_w1_bl u_t003_012/c3_w1_br u_t003_012/c3_r0_rbl u_t003_012/c3_r1_rbl u_t003_012/r0_w0_wl
+ u_t003_012/r0_w1_wl u_t003_012/r0_r0_rwl u_t003_012/r0_r1_rwl u_t003_012/r1_w0_wl u_t003_012/r1_w1_wl
+ u_t003_012/r1_r0_rwl u_t003_012/r1_r1_rwl u_t003_012/r2_w0_wl u_t003_012/r2_w1_wl u_t003_012/r2_r0_rwl
+ u_t003_012/r2_r1_rwl u_t003_012/r3_w0_wl u_t003_012/r3_w1_wl u_t003_012/r3_r0_rwl u_t003_012/r3_r1_rwl VDD VSS VSUBS
+ detronyx_12t_2w2r_rc4_4x4_routed_5layer_direct
Xu_t003_001 u_t003_001/c0_w0_bl u_t003_001/c0_w0_br u_t003_001/c0_w1_bl u_t003_001/c0_w1_br u_t003_001/c0_r0_rbl
+ u_t003_001/c0_r1_rbl u_t003_001/c1_w0_bl u_t003_001/c1_w0_br u_t003_001/c1_w1_bl u_t003_001/c1_w1_br
+ u_t003_001/c1_r0_rbl u_t003_001/c1_r1_rbl u_t003_001/c2_w0_bl u_t003_001/c2_w0_br u_t003_001/c2_w1_bl
+ u_t003_001/c2_w1_br u_t003_001/c2_r0_rbl u_t003_001/c2_r1_rbl u_t003_001/c3_w0_bl u_t003_001/c3_w0_br
+ u_t003_001/c3_w1_bl u_t003_001/c3_w1_br u_t003_001/c3_r0_rbl u_t003_001/c3_r1_rbl u_t003_001/r0_w0_wl
+ u_t003_001/r0_w1_wl u_t003_001/r0_r0_rwl u_t003_001/r0_r1_rwl u_t003_001/r1_w0_wl u_t003_001/r1_w1_wl
+ u_t003_001/r1_r0_rwl u_t003_001/r1_r1_rwl u_t003_001/r2_w0_wl u_t003_001/r2_w1_wl u_t003_001/r2_r0_rwl
+ u_t003_001/r2_r1_rwl u_t003_001/r3_w0_wl u_t003_001/r3_w1_wl u_t003_001/r3_r0_rwl u_t003_001/r3_r1_rwl VDD VSS VSUBS
+ detronyx_12t_2w2r_rc4_4x4_routed_5layer_direct
Xu_t000_004 u_t000_004/c0_w0_bl u_t000_004/c0_w0_br u_t000_004/c0_w1_bl u_t000_004/c0_w1_br u_t000_004/c0_r0_rbl
+ u_t000_004/c0_r1_rbl u_t000_004/c1_w0_bl u_t000_004/c1_w0_br u_t000_004/c1_w1_bl u_t000_004/c1_w1_br
+ u_t000_004/c1_r0_rbl u_t000_004/c1_r1_rbl u_t000_004/c2_w0_bl u_t000_004/c2_w0_br u_t000_004/c2_w1_bl
+ u_t000_004/c2_w1_br u_t000_004/c2_r0_rbl u_t000_004/c2_r1_rbl u_t000_004/c3_w0_bl u_t000_004/c3_w0_br
+ u_t000_004/c3_w1_bl u_t000_004/c3_w1_br u_t000_004/c3_r0_rbl u_t000_004/c3_r1_rbl u_t000_004/r0_w0_wl
+ u_t000_004/r0_w1_wl u_t000_004/r0_r0_rwl u_t000_004/r0_r1_rwl u_t000_004/r1_w0_wl u_t000_004/r1_w1_wl
+ u_t000_004/r1_r0_rwl u_t000_004/r1_r1_rwl u_t000_004/r2_w0_wl u_t000_004/r2_w1_wl u_t000_004/r2_r0_rwl
+ u_t000_004/r2_r1_rwl u_t000_004/r3_w0_wl u_t000_004/r3_w1_wl u_t000_004/r3_r0_rwl u_t000_004/r3_r1_rwl VDD VSS VSUBS
+ detronyx_12t_2w2r_rc4_4x4_routed_5layer_direct
Xu_t000_015 u_t000_015/c0_w0_bl u_t000_015/c0_w0_br u_t000_015/c0_w1_bl u_t000_015/c0_w1_br u_t000_015/c0_r0_rbl
+ u_t000_015/c0_r1_rbl u_t000_015/c1_w0_bl u_t000_015/c1_w0_br u_t000_015/c1_w1_bl u_t000_015/c1_w1_br
+ u_t000_015/c1_r0_rbl u_t000_015/c1_r1_rbl u_t000_015/c2_w0_bl u_t000_015/c2_w0_br u_t000_015/c2_w1_bl
+ u_t000_015/c2_w1_br u_t000_015/c2_r0_rbl u_t000_015/c2_r1_rbl u_t000_015/c3_w0_bl u_t000_015/c3_w0_br
+ u_t000_015/c3_w1_bl u_t000_015/c3_w1_br u_t000_015/c3_r0_rbl u_t000_015/c3_r1_rbl u_t000_015/r0_w0_wl
+ u_t000_015/r0_w1_wl u_t000_015/r0_r0_rwl u_t000_015/r0_r1_rwl u_t000_015/r1_w0_wl u_t000_015/r1_w1_wl
+ u_t000_015/r1_r0_rwl u_t000_015/r1_r1_rwl u_t000_015/r2_w0_wl u_t000_015/r2_w1_wl u_t000_015/r2_r0_rwl
+ u_t000_015/r2_r1_rwl u_t000_015/r3_w0_wl u_t000_015/r3_w1_wl u_t000_015/r3_r0_rwl u_t000_015/r3_r1_rwl VDD VSS VSUBS
+ detronyx_12t_2w2r_rc4_4x4_routed_5layer_direct
Xu_t028_007 u_t028_007/c0_w0_bl u_t028_007/c0_w0_br u_t028_007/c0_w1_bl u_t028_007/c0_w1_br u_t028_007/c0_r0_rbl
+ u_t028_007/c0_r1_rbl u_t028_007/c1_w0_bl u_t028_007/c1_w0_br u_t028_007/c1_w1_bl u_t028_007/c1_w1_br
+ u_t028_007/c1_r0_rbl u_t028_007/c1_r1_rbl u_t028_007/c2_w0_bl u_t028_007/c2_w0_br u_t028_007/c2_w1_bl
+ u_t028_007/c2_w1_br u_t028_007/c2_r0_rbl u_t028_007/c2_r1_rbl u_t028_007/c3_w0_bl u_t028_007/c3_w0_br
+ u_t028_007/c3_w1_bl u_t028_007/c3_w1_br u_t028_007/c3_r0_rbl u_t028_007/c3_r1_rbl u_t028_007/r0_w0_wl
+ u_t028_007/r0_w1_wl u_t028_007/r0_r0_rwl u_t028_007/r0_r1_rwl u_t028_007/r1_w0_wl u_t028_007/r1_w1_wl
+ u_t028_007/r1_r0_rwl u_t028_007/r1_r1_rwl u_t028_007/r2_w0_wl u_t028_007/r2_w1_wl u_t028_007/r2_r0_rwl
+ u_t028_007/r2_r1_rwl u_t028_007/r3_w0_wl u_t028_007/r3_w1_wl u_t028_007/r3_r0_rwl u_t028_007/r3_r1_rwl VDD VSS VSUBS
+ detronyx_12t_2w2r_rc4_4x4_routed_5layer_direct
Xu_t019_007 u_t019_007/c0_w0_bl u_t019_007/c0_w0_br u_t019_007/c0_w1_bl u_t019_007/c0_w1_br u_t019_007/c0_r0_rbl
+ u_t019_007/c0_r1_rbl u_t019_007/c1_w0_bl u_t019_007/c1_w0_br u_t019_007/c1_w1_bl u_t019_007/c1_w1_br
+ u_t019_007/c1_r0_rbl u_t019_007/c1_r1_rbl u_t019_007/c2_w0_bl u_t019_007/c2_w0_br u_t019_007/c2_w1_bl
+ u_t019_007/c2_w1_br u_t019_007/c2_r0_rbl u_t019_007/c2_r1_rbl u_t019_007/c3_w0_bl u_t019_007/c3_w0_br
+ u_t019_007/c3_w1_bl u_t019_007/c3_w1_br u_t019_007/c3_r0_rbl u_t019_007/c3_r1_rbl u_t019_007/r0_w0_wl
+ u_t019_007/r0_w1_wl u_t019_007/r0_r0_rwl u_t019_007/r0_r1_rwl u_t019_007/r1_w0_wl u_t019_007/r1_w1_wl
+ u_t019_007/r1_r0_rwl u_t019_007/r1_r1_rwl u_t019_007/r2_w0_wl u_t019_007/r2_w1_wl u_t019_007/r2_r0_rwl
+ u_t019_007/r2_r1_rwl u_t019_007/r3_w0_wl u_t019_007/r3_w1_wl u_t019_007/r3_r0_rwl u_t019_007/r3_r1_rwl VDD VSS VSUBS
+ detronyx_12t_2w2r_rc4_4x4_routed_5layer_direct
Xu_t024_010 u_t024_010/c0_w0_bl u_t024_010/c0_w0_br u_t024_010/c0_w1_bl u_t024_010/c0_w1_br u_t024_010/c0_r0_rbl
+ u_t024_010/c0_r1_rbl u_t024_010/c1_w0_bl u_t024_010/c1_w0_br u_t024_010/c1_w1_bl u_t024_010/c1_w1_br
+ u_t024_010/c1_r0_rbl u_t024_010/c1_r1_rbl u_t024_010/c2_w0_bl u_t024_010/c2_w0_br u_t024_010/c2_w1_bl
+ u_t024_010/c2_w1_br u_t024_010/c2_r0_rbl u_t024_010/c2_r1_rbl u_t024_010/c3_w0_bl u_t024_010/c3_w0_br
+ u_t024_010/c3_w1_bl u_t024_010/c3_w1_br u_t024_010/c3_r0_rbl u_t024_010/c3_r1_rbl u_t024_010/r0_w0_wl
+ u_t024_010/r0_w1_wl u_t024_010/r0_r0_rwl u_t024_010/r0_r1_rwl u_t024_010/r1_w0_wl u_t024_010/r1_w1_wl
+ u_t024_010/r1_r0_rwl u_t024_010/r1_r1_rwl u_t024_010/r2_w0_wl u_t024_010/r2_w1_wl u_t024_010/r2_r0_rwl
+ u_t024_010/r2_r1_rwl u_t024_010/r3_w0_wl u_t024_010/r3_w1_wl u_t024_010/r3_r0_rwl u_t024_010/r3_r1_rwl VDD VSS VSUBS
+ detronyx_12t_2w2r_rc4_4x4_routed_5layer_direct
Xu_t030_013 u_t030_013/c0_w0_bl u_t030_013/c0_w0_br u_t030_013/c0_w1_bl u_t030_013/c0_w1_br u_t030_013/c0_r0_rbl
+ u_t030_013/c0_r1_rbl u_t030_013/c1_w0_bl u_t030_013/c1_w0_br u_t030_013/c1_w1_bl u_t030_013/c1_w1_br
+ u_t030_013/c1_r0_rbl u_t030_013/c1_r1_rbl u_t030_013/c2_w0_bl u_t030_013/c2_w0_br u_t030_013/c2_w1_bl
+ u_t030_013/c2_w1_br u_t030_013/c2_r0_rbl u_t030_013/c2_r1_rbl u_t030_013/c3_w0_bl u_t030_013/c3_w0_br
+ u_t030_013/c3_w1_bl u_t030_013/c3_w1_br u_t030_013/c3_r0_rbl u_t030_013/c3_r1_rbl u_t030_013/r0_w0_wl
+ u_t030_013/r0_w1_wl u_t030_013/r0_r0_rwl u_t030_013/r0_r1_rwl u_t030_013/r1_w0_wl u_t030_013/r1_w1_wl
+ u_t030_013/r1_r0_rwl u_t030_013/r1_r1_rwl u_t030_013/r2_w0_wl u_t030_013/r2_w1_wl u_t030_013/r2_r0_rwl
+ u_t030_013/r2_r1_rwl u_t030_013/r3_w0_wl u_t030_013/r3_w1_wl u_t030_013/r3_r0_rwl u_t030_013/r3_r1_rwl VDD VSS VSUBS
+ detronyx_12t_2w2r_rc4_4x4_routed_5layer_direct
Xu_t030_002 u_t030_002/c0_w0_bl u_t030_002/c0_w0_br u_t030_002/c0_w1_bl u_t030_002/c0_w1_br u_t030_002/c0_r0_rbl
+ u_t030_002/c0_r1_rbl u_t030_002/c1_w0_bl u_t030_002/c1_w0_br u_t030_002/c1_w1_bl u_t030_002/c1_w1_br
+ u_t030_002/c1_r0_rbl u_t030_002/c1_r1_rbl u_t030_002/c2_w0_bl u_t030_002/c2_w0_br u_t030_002/c2_w1_bl
+ u_t030_002/c2_w1_br u_t030_002/c2_r0_rbl u_t030_002/c2_r1_rbl u_t030_002/c3_w0_bl u_t030_002/c3_w0_br
+ u_t030_002/c3_w1_bl u_t030_002/c3_w1_br u_t030_002/c3_r0_rbl u_t030_002/c3_r1_rbl u_t030_002/r0_w0_wl
+ u_t030_002/r0_w1_wl u_t030_002/r0_r0_rwl u_t030_002/r0_r1_rwl u_t030_002/r1_w0_wl u_t030_002/r1_w1_wl
+ u_t030_002/r1_r0_rwl u_t030_002/r1_r1_rwl u_t030_002/r2_w0_wl u_t030_002/r2_w1_wl u_t030_002/r2_r0_rwl
+ u_t030_002/r2_r1_rwl u_t030_002/r3_w0_wl u_t030_002/r3_w1_wl u_t030_002/r3_r0_rwl u_t030_002/r3_r1_rwl VDD VSS VSUBS
+ detronyx_12t_2w2r_rc4_4x4_routed_5layer_direct
Xu_t015_010 u_t015_010/c0_w0_bl u_t015_010/c0_w0_br u_t015_010/c0_w1_bl u_t015_010/c0_w1_br u_t015_010/c0_r0_rbl
+ u_t015_010/c0_r1_rbl u_t015_010/c1_w0_bl u_t015_010/c1_w0_br u_t015_010/c1_w1_bl u_t015_010/c1_w1_br
+ u_t015_010/c1_r0_rbl u_t015_010/c1_r1_rbl u_t015_010/c2_w0_bl u_t015_010/c2_w0_br u_t015_010/c2_w1_bl
+ u_t015_010/c2_w1_br u_t015_010/c2_r0_rbl u_t015_010/c2_r1_rbl u_t015_010/c3_w0_bl u_t015_010/c3_w0_br
+ u_t015_010/c3_w1_bl u_t015_010/c3_w1_br u_t015_010/c3_r0_rbl u_t015_010/c3_r1_rbl u_t015_010/r0_w0_wl
+ u_t015_010/r0_w1_wl u_t015_010/r0_r0_rwl u_t015_010/r0_r1_rwl u_t015_010/r1_w0_wl u_t015_010/r1_w1_wl
+ u_t015_010/r1_r0_rwl u_t015_010/r1_r1_rwl u_t015_010/r2_w0_wl u_t015_010/r2_w1_wl u_t015_010/r2_r0_rwl
+ u_t015_010/r2_r1_rwl u_t015_010/r3_w0_wl u_t015_010/r3_w1_wl u_t015_010/r3_r0_rwl u_t015_010/r3_r1_rwl VDD VSS VSUBS
+ detronyx_12t_2w2r_rc4_4x4_routed_5layer_direct
Xu_t006_010 u_t006_010/c0_w0_bl u_t006_010/c0_w0_br u_t006_010/c0_w1_bl u_t006_010/c0_w1_br u_t006_010/c0_r0_rbl
+ u_t006_010/c0_r1_rbl u_t006_010/c1_w0_bl u_t006_010/c1_w0_br u_t006_010/c1_w1_bl u_t006_010/c1_w1_br
+ u_t006_010/c1_r0_rbl u_t006_010/c1_r1_rbl u_t006_010/c2_w0_bl u_t006_010/c2_w0_br u_t006_010/c2_w1_bl
+ u_t006_010/c2_w1_br u_t006_010/c2_r0_rbl u_t006_010/c2_r1_rbl u_t006_010/c3_w0_bl u_t006_010/c3_w0_br
+ u_t006_010/c3_w1_bl u_t006_010/c3_w1_br u_t006_010/c3_r0_rbl u_t006_010/c3_r1_rbl u_t006_010/r0_w0_wl
+ u_t006_010/r0_w1_wl u_t006_010/r0_r0_rwl u_t006_010/r0_r1_rwl u_t006_010/r1_w0_wl u_t006_010/r1_w1_wl
+ u_t006_010/r1_r0_rwl u_t006_010/r1_r1_rwl u_t006_010/r2_w0_wl u_t006_010/r2_w1_wl u_t006_010/r2_r0_rwl
+ u_t006_010/r2_r1_rwl u_t006_010/r3_w0_wl u_t006_010/r3_w1_wl u_t006_010/r3_r0_rwl u_t006_010/r3_r1_rwl VDD VSS VSUBS
+ detronyx_12t_2w2r_rc4_4x4_routed_5layer_direct
Xu_t021_002 u_t021_002/c0_w0_bl u_t021_002/c0_w0_br u_t021_002/c0_w1_bl u_t021_002/c0_w1_br u_t021_002/c0_r0_rbl
+ u_t021_002/c0_r1_rbl u_t021_002/c1_w0_bl u_t021_002/c1_w0_br u_t021_002/c1_w1_bl u_t021_002/c1_w1_br
+ u_t021_002/c1_r0_rbl u_t021_002/c1_r1_rbl u_t021_002/c2_w0_bl u_t021_002/c2_w0_br u_t021_002/c2_w1_bl
+ u_t021_002/c2_w1_br u_t021_002/c2_r0_rbl u_t021_002/c2_r1_rbl u_t021_002/c3_w0_bl u_t021_002/c3_w0_br
+ u_t021_002/c3_w1_bl u_t021_002/c3_w1_br u_t021_002/c3_r0_rbl u_t021_002/c3_r1_rbl u_t021_002/r0_w0_wl
+ u_t021_002/r0_w1_wl u_t021_002/r0_r0_rwl u_t021_002/r0_r1_rwl u_t021_002/r1_w0_wl u_t021_002/r1_w1_wl
+ u_t021_002/r1_r0_rwl u_t021_002/r1_r1_rwl u_t021_002/r2_w0_wl u_t021_002/r2_w1_wl u_t021_002/r2_r0_rwl
+ u_t021_002/r2_r1_rwl u_t021_002/r3_w0_wl u_t021_002/r3_w1_wl u_t021_002/r3_r0_rwl u_t021_002/r3_r1_rwl VDD VSS VSUBS
+ detronyx_12t_2w2r_rc4_4x4_routed_5layer_direct
Xu_t021_013 u_t021_013/c0_w0_bl u_t021_013/c0_w0_br u_t021_013/c0_w1_bl u_t021_013/c0_w1_br u_t021_013/c0_r0_rbl
+ u_t021_013/c0_r1_rbl u_t021_013/c1_w0_bl u_t021_013/c1_w0_br u_t021_013/c1_w1_bl u_t021_013/c1_w1_br
+ u_t021_013/c1_r0_rbl u_t021_013/c1_r1_rbl u_t021_013/c2_w0_bl u_t021_013/c2_w0_br u_t021_013/c2_w1_bl
+ u_t021_013/c2_w1_br u_t021_013/c2_r0_rbl u_t021_013/c2_r1_rbl u_t021_013/c3_w0_bl u_t021_013/c3_w0_br
+ u_t021_013/c3_w1_bl u_t021_013/c3_w1_br u_t021_013/c3_r0_rbl u_t021_013/c3_r1_rbl u_t021_013/r0_w0_wl
+ u_t021_013/r0_w1_wl u_t021_013/r0_r0_rwl u_t021_013/r0_r1_rwl u_t021_013/r1_w0_wl u_t021_013/r1_w1_wl
+ u_t021_013/r1_r0_rwl u_t021_013/r1_r1_rwl u_t021_013/r2_w0_wl u_t021_013/r2_w1_wl u_t021_013/r2_r0_rwl
+ u_t021_013/r2_r1_rwl u_t021_013/r3_w0_wl u_t021_013/r3_w1_wl u_t021_013/r3_r0_rwl u_t021_013/r3_r1_rwl VDD VSS VSUBS
+ detronyx_12t_2w2r_rc4_4x4_routed_5layer_direct
Xu_t012_002 u_t012_002/c0_w0_bl u_t012_002/c0_w0_br u_t012_002/c0_w1_bl u_t012_002/c0_w1_br u_t012_002/c0_r0_rbl
+ u_t012_002/c0_r1_rbl u_t012_002/c1_w0_bl u_t012_002/c1_w0_br u_t012_002/c1_w1_bl u_t012_002/c1_w1_br
+ u_t012_002/c1_r0_rbl u_t012_002/c1_r1_rbl u_t012_002/c2_w0_bl u_t012_002/c2_w0_br u_t012_002/c2_w1_bl
+ u_t012_002/c2_w1_br u_t012_002/c2_r0_rbl u_t012_002/c2_r1_rbl u_t012_002/c3_w0_bl u_t012_002/c3_w0_br
+ u_t012_002/c3_w1_bl u_t012_002/c3_w1_br u_t012_002/c3_r0_rbl u_t012_002/c3_r1_rbl u_t012_002/r0_w0_wl
+ u_t012_002/r0_w1_wl u_t012_002/r0_r0_rwl u_t012_002/r0_r1_rwl u_t012_002/r1_w0_wl u_t012_002/r1_w1_wl
+ u_t012_002/r1_r0_rwl u_t012_002/r1_r1_rwl u_t012_002/r2_w0_wl u_t012_002/r2_w1_wl u_t012_002/r2_r0_rwl
+ u_t012_002/r2_r1_rwl u_t012_002/r3_w0_wl u_t012_002/r3_w1_wl u_t012_002/r3_r0_rwl u_t012_002/r3_r1_rwl VDD VSS VSUBS
+ detronyx_12t_2w2r_rc4_4x4_routed_5layer_direct
Xu_t012_013 u_t012_013/c0_w0_bl u_t012_013/c0_w0_br u_t012_013/c0_w1_bl u_t012_013/c0_w1_br u_t012_013/c0_r0_rbl
+ u_t012_013/c0_r1_rbl u_t012_013/c1_w0_bl u_t012_013/c1_w0_br u_t012_013/c1_w1_bl u_t012_013/c1_w1_br
+ u_t012_013/c1_r0_rbl u_t012_013/c1_r1_rbl u_t012_013/c2_w0_bl u_t012_013/c2_w0_br u_t012_013/c2_w1_bl
+ u_t012_013/c2_w1_br u_t012_013/c2_r0_rbl u_t012_013/c2_r1_rbl u_t012_013/c3_w0_bl u_t012_013/c3_w0_br
+ u_t012_013/c3_w1_bl u_t012_013/c3_w1_br u_t012_013/c3_r0_rbl u_t012_013/c3_r1_rbl u_t012_013/r0_w0_wl
+ u_t012_013/r0_w1_wl u_t012_013/r0_r0_rwl u_t012_013/r0_r1_rwl u_t012_013/r1_w0_wl u_t012_013/r1_w1_wl
+ u_t012_013/r1_r0_rwl u_t012_013/r1_r1_rwl u_t012_013/r2_w0_wl u_t012_013/r2_w1_wl u_t012_013/r2_r0_rwl
+ u_t012_013/r2_r1_rwl u_t012_013/r3_w0_wl u_t012_013/r3_w1_wl u_t012_013/r3_r0_rwl u_t012_013/r3_r1_rwl VDD VSS VSUBS
+ detronyx_12t_2w2r_rc4_4x4_routed_5layer_direct
Xu_t003_013 u_t003_013/c0_w0_bl u_t003_013/c0_w0_br u_t003_013/c0_w1_bl u_t003_013/c0_w1_br u_t003_013/c0_r0_rbl
+ u_t003_013/c0_r1_rbl u_t003_013/c1_w0_bl u_t003_013/c1_w0_br u_t003_013/c1_w1_bl u_t003_013/c1_w1_br
+ u_t003_013/c1_r0_rbl u_t003_013/c1_r1_rbl u_t003_013/c2_w0_bl u_t003_013/c2_w0_br u_t003_013/c2_w1_bl
+ u_t003_013/c2_w1_br u_t003_013/c2_r0_rbl u_t003_013/c2_r1_rbl u_t003_013/c3_w0_bl u_t003_013/c3_w0_br
+ u_t003_013/c3_w1_bl u_t003_013/c3_w1_br u_t003_013/c3_r0_rbl u_t003_013/c3_r1_rbl u_t003_013/r0_w0_wl
+ u_t003_013/r0_w1_wl u_t003_013/r0_r0_rwl u_t003_013/r0_r1_rwl u_t003_013/r1_w0_wl u_t003_013/r1_w1_wl
+ u_t003_013/r1_r0_rwl u_t003_013/r1_r1_rwl u_t003_013/r2_w0_wl u_t003_013/r2_w1_wl u_t003_013/r2_r0_rwl
+ u_t003_013/r2_r1_rwl u_t003_013/r3_w0_wl u_t003_013/r3_w1_wl u_t003_013/r3_r0_rwl u_t003_013/r3_r1_rwl VDD VSS VSUBS
+ detronyx_12t_2w2r_rc4_4x4_routed_5layer_direct
Xu_t003_002 u_t003_002/c0_w0_bl u_t003_002/c0_w0_br u_t003_002/c0_w1_bl u_t003_002/c0_w1_br u_t003_002/c0_r0_rbl
+ u_t003_002/c0_r1_rbl u_t003_002/c1_w0_bl u_t003_002/c1_w0_br u_t003_002/c1_w1_bl u_t003_002/c1_w1_br
+ u_t003_002/c1_r0_rbl u_t003_002/c1_r1_rbl u_t003_002/c2_w0_bl u_t003_002/c2_w0_br u_t003_002/c2_w1_bl
+ u_t003_002/c2_w1_br u_t003_002/c2_r0_rbl u_t003_002/c2_r1_rbl u_t003_002/c3_w0_bl u_t003_002/c3_w0_br
+ u_t003_002/c3_w1_bl u_t003_002/c3_w1_br u_t003_002/c3_r0_rbl u_t003_002/c3_r1_rbl u_t003_002/r0_w0_wl
+ u_t003_002/r0_w1_wl u_t003_002/r0_r0_rwl u_t003_002/r0_r1_rwl u_t003_002/r1_w0_wl u_t003_002/r1_w1_wl
+ u_t003_002/r1_r0_rwl u_t003_002/r1_r1_rwl u_t003_002/r2_w0_wl u_t003_002/r2_w1_wl u_t003_002/r2_r0_rwl
+ u_t003_002/r2_r1_rwl u_t003_002/r3_w0_wl u_t003_002/r3_w1_wl u_t003_002/r3_r0_rwl u_t003_002/r3_r1_rwl VDD VSS VSUBS
+ detronyx_12t_2w2r_rc4_4x4_routed_5layer_direct
Xu_t000_005 u_t000_005/c0_w0_bl u_t000_005/c0_w0_br u_t000_005/c0_w1_bl u_t000_005/c0_w1_br u_t000_005/c0_r0_rbl
+ u_t000_005/c0_r1_rbl u_t000_005/c1_w0_bl u_t000_005/c1_w0_br u_t000_005/c1_w1_bl u_t000_005/c1_w1_br
+ u_t000_005/c1_r0_rbl u_t000_005/c1_r1_rbl u_t000_005/c2_w0_bl u_t000_005/c2_w0_br u_t000_005/c2_w1_bl
+ u_t000_005/c2_w1_br u_t000_005/c2_r0_rbl u_t000_005/c2_r1_rbl u_t000_005/c3_w0_bl u_t000_005/c3_w0_br
+ u_t000_005/c3_w1_bl u_t000_005/c3_w1_br u_t000_005/c3_r0_rbl u_t000_005/c3_r1_rbl u_t000_005/r0_w0_wl
+ u_t000_005/r0_w1_wl u_t000_005/r0_r0_rwl u_t000_005/r0_r1_rwl u_t000_005/r1_w0_wl u_t000_005/r1_w1_wl
+ u_t000_005/r1_r0_rwl u_t000_005/r1_r1_rwl u_t000_005/r2_w0_wl u_t000_005/r2_w1_wl u_t000_005/r2_r0_rwl
+ u_t000_005/r2_r1_rwl u_t000_005/r3_w0_wl u_t000_005/r3_w1_wl u_t000_005/r3_r0_rwl u_t000_005/r3_r1_rwl VDD VSS VSUBS
+ detronyx_12t_2w2r_rc4_4x4_routed_5layer_direct
Xu_t028_008 u_t028_008/c0_w0_bl u_t028_008/c0_w0_br u_t028_008/c0_w1_bl u_t028_008/c0_w1_br u_t028_008/c0_r0_rbl
+ u_t028_008/c0_r1_rbl u_t028_008/c1_w0_bl u_t028_008/c1_w0_br u_t028_008/c1_w1_bl u_t028_008/c1_w1_br
+ u_t028_008/c1_r0_rbl u_t028_008/c1_r1_rbl u_t028_008/c2_w0_bl u_t028_008/c2_w0_br u_t028_008/c2_w1_bl
+ u_t028_008/c2_w1_br u_t028_008/c2_r0_rbl u_t028_008/c2_r1_rbl u_t028_008/c3_w0_bl u_t028_008/c3_w0_br
+ u_t028_008/c3_w1_bl u_t028_008/c3_w1_br u_t028_008/c3_r0_rbl u_t028_008/c3_r1_rbl u_t028_008/r0_w0_wl
+ u_t028_008/r0_w1_wl u_t028_008/r0_r0_rwl u_t028_008/r0_r1_rwl u_t028_008/r1_w0_wl u_t028_008/r1_w1_wl
+ u_t028_008/r1_r0_rwl u_t028_008/r1_r1_rwl u_t028_008/r2_w0_wl u_t028_008/r2_w1_wl u_t028_008/r2_r0_rwl
+ u_t028_008/r2_r1_rwl u_t028_008/r3_w0_wl u_t028_008/r3_w1_wl u_t028_008/r3_r0_rwl u_t028_008/r3_r1_rwl VDD VSS VSUBS
+ detronyx_12t_2w2r_rc4_4x4_routed_5layer_direct
Xu_t019_008 u_t019_008/c0_w0_bl u_t019_008/c0_w0_br u_t019_008/c0_w1_bl u_t019_008/c0_w1_br u_t019_008/c0_r0_rbl
+ u_t019_008/c0_r1_rbl u_t019_008/c1_w0_bl u_t019_008/c1_w0_br u_t019_008/c1_w1_bl u_t019_008/c1_w1_br
+ u_t019_008/c1_r0_rbl u_t019_008/c1_r1_rbl u_t019_008/c2_w0_bl u_t019_008/c2_w0_br u_t019_008/c2_w1_bl
+ u_t019_008/c2_w1_br u_t019_008/c2_r0_rbl u_t019_008/c2_r1_rbl u_t019_008/c3_w0_bl u_t019_008/c3_w0_br
+ u_t019_008/c3_w1_bl u_t019_008/c3_w1_br u_t019_008/c3_r0_rbl u_t019_008/c3_r1_rbl u_t019_008/r0_w0_wl
+ u_t019_008/r0_w1_wl u_t019_008/r0_r0_rwl u_t019_008/r0_r1_rwl u_t019_008/r1_w0_wl u_t019_008/r1_w1_wl
+ u_t019_008/r1_r0_rwl u_t019_008/r1_r1_rwl u_t019_008/r2_w0_wl u_t019_008/r2_w1_wl u_t019_008/r2_r0_rwl
+ u_t019_008/r2_r1_rwl u_t019_008/r3_w0_wl u_t019_008/r3_w1_wl u_t019_008/r3_r0_rwl u_t019_008/r3_r1_rwl VDD VSS VSUBS
+ detronyx_12t_2w2r_rc4_4x4_routed_5layer_direct
Xu_t024_011 u_t024_011/c0_w0_bl u_t024_011/c0_w0_br u_t024_011/c0_w1_bl u_t024_011/c0_w1_br u_t024_011/c0_r0_rbl
+ u_t024_011/c0_r1_rbl u_t024_011/c1_w0_bl u_t024_011/c1_w0_br u_t024_011/c1_w1_bl u_t024_011/c1_w1_br
+ u_t024_011/c1_r0_rbl u_t024_011/c1_r1_rbl u_t024_011/c2_w0_bl u_t024_011/c2_w0_br u_t024_011/c2_w1_bl
+ u_t024_011/c2_w1_br u_t024_011/c2_r0_rbl u_t024_011/c2_r1_rbl u_t024_011/c3_w0_bl u_t024_011/c3_w0_br
+ u_t024_011/c3_w1_bl u_t024_011/c3_w1_br u_t024_011/c3_r0_rbl u_t024_011/c3_r1_rbl u_t024_011/r0_w0_wl
+ u_t024_011/r0_w1_wl u_t024_011/r0_r0_rwl u_t024_011/r0_r1_rwl u_t024_011/r1_w0_wl u_t024_011/r1_w1_wl
+ u_t024_011/r1_r0_rwl u_t024_011/r1_r1_rwl u_t024_011/r2_w0_wl u_t024_011/r2_w1_wl u_t024_011/r2_r0_rwl
+ u_t024_011/r2_r1_rwl u_t024_011/r3_w0_wl u_t024_011/r3_w1_wl u_t024_011/r3_r0_rwl u_t024_011/r3_r1_rwl VDD VSS VSUBS
+ detronyx_12t_2w2r_rc4_4x4_routed_5layer_direct
Xu_t024_000 u_t024_000/c0_w0_bl u_t024_000/c0_w0_br u_t024_000/c0_w1_bl u_t024_000/c0_w1_br u_t024_000/c0_r0_rbl
+ u_t024_000/c0_r1_rbl u_t024_000/c1_w0_bl u_t024_000/c1_w0_br u_t024_000/c1_w1_bl u_t024_000/c1_w1_br
+ u_t024_000/c1_r0_rbl u_t024_000/c1_r1_rbl u_t024_000/c2_w0_bl u_t024_000/c2_w0_br u_t024_000/c2_w1_bl
+ u_t024_000/c2_w1_br u_t024_000/c2_r0_rbl u_t024_000/c2_r1_rbl u_t024_000/c3_w0_bl u_t024_000/c3_w0_br
+ u_t024_000/c3_w1_bl u_t024_000/c3_w1_br u_t024_000/c3_r0_rbl u_t024_000/c3_r1_rbl u_t024_000/r0_w0_wl
+ u_t024_000/r0_w1_wl u_t024_000/r0_r0_rwl u_t024_000/r0_r1_rwl u_t024_000/r1_w0_wl u_t024_000/r1_w1_wl
+ u_t024_000/r1_r0_rwl u_t024_000/r1_r1_rwl u_t024_000/r2_w0_wl u_t024_000/r2_w1_wl u_t024_000/r2_r0_rwl
+ u_t024_000/r2_r1_rwl u_t024_000/r3_w0_wl u_t024_000/r3_w1_wl u_t024_000/r3_r0_rwl u_t024_000/r3_r1_rwl VDD VSS VSUBS
+ detronyx_12t_2w2r_rc4_4x4_routed_5layer_direct
Xu_t030_014 u_t030_014/c0_w0_bl u_t030_014/c0_w0_br u_t030_014/c0_w1_bl u_t030_014/c0_w1_br u_t030_014/c0_r0_rbl
+ u_t030_014/c0_r1_rbl u_t030_014/c1_w0_bl u_t030_014/c1_w0_br u_t030_014/c1_w1_bl u_t030_014/c1_w1_br
+ u_t030_014/c1_r0_rbl u_t030_014/c1_r1_rbl u_t030_014/c2_w0_bl u_t030_014/c2_w0_br u_t030_014/c2_w1_bl
+ u_t030_014/c2_w1_br u_t030_014/c2_r0_rbl u_t030_014/c2_r1_rbl u_t030_014/c3_w0_bl u_t030_014/c3_w0_br
+ u_t030_014/c3_w1_bl u_t030_014/c3_w1_br u_t030_014/c3_r0_rbl u_t030_014/c3_r1_rbl u_t030_014/r0_w0_wl
+ u_t030_014/r0_w1_wl u_t030_014/r0_r0_rwl u_t030_014/r0_r1_rwl u_t030_014/r1_w0_wl u_t030_014/r1_w1_wl
+ u_t030_014/r1_r0_rwl u_t030_014/r1_r1_rwl u_t030_014/r2_w0_wl u_t030_014/r2_w1_wl u_t030_014/r2_r0_rwl
+ u_t030_014/r2_r1_rwl u_t030_014/r3_w0_wl u_t030_014/r3_w1_wl u_t030_014/r3_r0_rwl u_t030_014/r3_r1_rwl VDD VSS VSUBS
+ detronyx_12t_2w2r_rc4_4x4_routed_5layer_direct
Xu_t030_003 u_t030_003/c0_w0_bl u_t030_003/c0_w0_br u_t030_003/c0_w1_bl u_t030_003/c0_w1_br u_t030_003/c0_r0_rbl
+ u_t030_003/c0_r1_rbl u_t030_003/c1_w0_bl u_t030_003/c1_w0_br u_t030_003/c1_w1_bl u_t030_003/c1_w1_br
+ u_t030_003/c1_r0_rbl u_t030_003/c1_r1_rbl u_t030_003/c2_w0_bl u_t030_003/c2_w0_br u_t030_003/c2_w1_bl
+ u_t030_003/c2_w1_br u_t030_003/c2_r0_rbl u_t030_003/c2_r1_rbl u_t030_003/c3_w0_bl u_t030_003/c3_w0_br
+ u_t030_003/c3_w1_bl u_t030_003/c3_w1_br u_t030_003/c3_r0_rbl u_t030_003/c3_r1_rbl u_t030_003/r0_w0_wl
+ u_t030_003/r0_w1_wl u_t030_003/r0_r0_rwl u_t030_003/r0_r1_rwl u_t030_003/r1_w0_wl u_t030_003/r1_w1_wl
+ u_t030_003/r1_r0_rwl u_t030_003/r1_r1_rwl u_t030_003/r2_w0_wl u_t030_003/r2_w1_wl u_t030_003/r2_r0_rwl
+ u_t030_003/r2_r1_rwl u_t030_003/r3_w0_wl u_t030_003/r3_w1_wl u_t030_003/r3_r0_rwl u_t030_003/r3_r1_rwl VDD VSS VSUBS
+ detronyx_12t_2w2r_rc4_4x4_routed_5layer_direct
Xu_t015_000 u_t015_000/c0_w0_bl u_t015_000/c0_w0_br u_t015_000/c0_w1_bl u_t015_000/c0_w1_br u_t015_000/c0_r0_rbl
+ u_t015_000/c0_r1_rbl u_t015_000/c1_w0_bl u_t015_000/c1_w0_br u_t015_000/c1_w1_bl u_t015_000/c1_w1_br
+ u_t015_000/c1_r0_rbl u_t015_000/c1_r1_rbl u_t015_000/c2_w0_bl u_t015_000/c2_w0_br u_t015_000/c2_w1_bl
+ u_t015_000/c2_w1_br u_t015_000/c2_r0_rbl u_t015_000/c2_r1_rbl u_t015_000/c3_w0_bl u_t015_000/c3_w0_br
+ u_t015_000/c3_w1_bl u_t015_000/c3_w1_br u_t015_000/c3_r0_rbl u_t015_000/c3_r1_rbl u_t015_000/r0_w0_wl
+ u_t015_000/r0_w1_wl u_t015_000/r0_r0_rwl u_t015_000/r0_r1_rwl u_t015_000/r1_w0_wl u_t015_000/r1_w1_wl
+ u_t015_000/r1_r0_rwl u_t015_000/r1_r1_rwl u_t015_000/r2_w0_wl u_t015_000/r2_w1_wl u_t015_000/r2_r0_rwl
+ u_t015_000/r2_r1_rwl u_t015_000/r3_w0_wl u_t015_000/r3_w1_wl u_t015_000/r3_r0_rwl u_t015_000/r3_r1_rwl VDD VSS VSUBS
+ detronyx_12t_2w2r_rc4_4x4_routed_5layer_direct
Xu_t015_011 u_t015_011/c0_w0_bl u_t015_011/c0_w0_br u_t015_011/c0_w1_bl u_t015_011/c0_w1_br u_t015_011/c0_r0_rbl
+ u_t015_011/c0_r1_rbl u_t015_011/c1_w0_bl u_t015_011/c1_w0_br u_t015_011/c1_w1_bl u_t015_011/c1_w1_br
+ u_t015_011/c1_r0_rbl u_t015_011/c1_r1_rbl u_t015_011/c2_w0_bl u_t015_011/c2_w0_br u_t015_011/c2_w1_bl
+ u_t015_011/c2_w1_br u_t015_011/c2_r0_rbl u_t015_011/c2_r1_rbl u_t015_011/c3_w0_bl u_t015_011/c3_w0_br
+ u_t015_011/c3_w1_bl u_t015_011/c3_w1_br u_t015_011/c3_r0_rbl u_t015_011/c3_r1_rbl u_t015_011/r0_w0_wl
+ u_t015_011/r0_w1_wl u_t015_011/r0_r0_rwl u_t015_011/r0_r1_rwl u_t015_011/r1_w0_wl u_t015_011/r1_w1_wl
+ u_t015_011/r1_r0_rwl u_t015_011/r1_r1_rwl u_t015_011/r2_w0_wl u_t015_011/r2_w1_wl u_t015_011/r2_r0_rwl
+ u_t015_011/r2_r1_rwl u_t015_011/r3_w0_wl u_t015_011/r3_w1_wl u_t015_011/r3_r0_rwl u_t015_011/r3_r1_rwl VDD VSS VSUBS
+ detronyx_12t_2w2r_rc4_4x4_routed_5layer_direct
Xu_t006_000 u_t006_000/c0_w0_bl u_t006_000/c0_w0_br u_t006_000/c0_w1_bl u_t006_000/c0_w1_br u_t006_000/c0_r0_rbl
+ u_t006_000/c0_r1_rbl u_t006_000/c1_w0_bl u_t006_000/c1_w0_br u_t006_000/c1_w1_bl u_t006_000/c1_w1_br
+ u_t006_000/c1_r0_rbl u_t006_000/c1_r1_rbl u_t006_000/c2_w0_bl u_t006_000/c2_w0_br u_t006_000/c2_w1_bl
+ u_t006_000/c2_w1_br u_t006_000/c2_r0_rbl u_t006_000/c2_r1_rbl u_t006_000/c3_w0_bl u_t006_000/c3_w0_br
+ u_t006_000/c3_w1_bl u_t006_000/c3_w1_br u_t006_000/c3_r0_rbl u_t006_000/c3_r1_rbl u_t006_000/r0_w0_wl
+ u_t006_000/r0_w1_wl u_t006_000/r0_r0_rwl u_t006_000/r0_r1_rwl u_t006_000/r1_w0_wl u_t006_000/r1_w1_wl
+ u_t006_000/r1_r0_rwl u_t006_000/r1_r1_rwl u_t006_000/r2_w0_wl u_t006_000/r2_w1_wl u_t006_000/r2_r0_rwl
+ u_t006_000/r2_r1_rwl u_t006_000/r3_w0_wl u_t006_000/r3_w1_wl u_t006_000/r3_r0_rwl u_t006_000/r3_r1_rwl VDD VSS VSUBS
+ detronyx_12t_2w2r_rc4_4x4_routed_5layer_direct
Xu_t006_011 u_t006_011/c0_w0_bl u_t006_011/c0_w0_br u_t006_011/c0_w1_bl u_t006_011/c0_w1_br u_t006_011/c0_r0_rbl
+ u_t006_011/c0_r1_rbl u_t006_011/c1_w0_bl u_t006_011/c1_w0_br u_t006_011/c1_w1_bl u_t006_011/c1_w1_br
+ u_t006_011/c1_r0_rbl u_t006_011/c1_r1_rbl u_t006_011/c2_w0_bl u_t006_011/c2_w0_br u_t006_011/c2_w1_bl
+ u_t006_011/c2_w1_br u_t006_011/c2_r0_rbl u_t006_011/c2_r1_rbl u_t006_011/c3_w0_bl u_t006_011/c3_w0_br
+ u_t006_011/c3_w1_bl u_t006_011/c3_w1_br u_t006_011/c3_r0_rbl u_t006_011/c3_r1_rbl u_t006_011/r0_w0_wl
+ u_t006_011/r0_w1_wl u_t006_011/r0_r0_rwl u_t006_011/r0_r1_rwl u_t006_011/r1_w0_wl u_t006_011/r1_w1_wl
+ u_t006_011/r1_r0_rwl u_t006_011/r1_r1_rwl u_t006_011/r2_w0_wl u_t006_011/r2_w1_wl u_t006_011/r2_r0_rwl
+ u_t006_011/r2_r1_rwl u_t006_011/r3_w0_wl u_t006_011/r3_w1_wl u_t006_011/r3_r0_rwl u_t006_011/r3_r1_rwl VDD VSS VSUBS
+ detronyx_12t_2w2r_rc4_4x4_routed_5layer_direct
Xu_t021_003 u_t021_003/c0_w0_bl u_t021_003/c0_w0_br u_t021_003/c0_w1_bl u_t021_003/c0_w1_br u_t021_003/c0_r0_rbl
+ u_t021_003/c0_r1_rbl u_t021_003/c1_w0_bl u_t021_003/c1_w0_br u_t021_003/c1_w1_bl u_t021_003/c1_w1_br
+ u_t021_003/c1_r0_rbl u_t021_003/c1_r1_rbl u_t021_003/c2_w0_bl u_t021_003/c2_w0_br u_t021_003/c2_w1_bl
+ u_t021_003/c2_w1_br u_t021_003/c2_r0_rbl u_t021_003/c2_r1_rbl u_t021_003/c3_w0_bl u_t021_003/c3_w0_br
+ u_t021_003/c3_w1_bl u_t021_003/c3_w1_br u_t021_003/c3_r0_rbl u_t021_003/c3_r1_rbl u_t021_003/r0_w0_wl
+ u_t021_003/r0_w1_wl u_t021_003/r0_r0_rwl u_t021_003/r0_r1_rwl u_t021_003/r1_w0_wl u_t021_003/r1_w1_wl
+ u_t021_003/r1_r0_rwl u_t021_003/r1_r1_rwl u_t021_003/r2_w0_wl u_t021_003/r2_w1_wl u_t021_003/r2_r0_rwl
+ u_t021_003/r2_r1_rwl u_t021_003/r3_w0_wl u_t021_003/r3_w1_wl u_t021_003/r3_r0_rwl u_t021_003/r3_r1_rwl VDD VSS VSUBS
+ detronyx_12t_2w2r_rc4_4x4_routed_5layer_direct
Xu_t021_014 u_t021_014/c0_w0_bl u_t021_014/c0_w0_br u_t021_014/c0_w1_bl u_t021_014/c0_w1_br u_t021_014/c0_r0_rbl
+ u_t021_014/c0_r1_rbl u_t021_014/c1_w0_bl u_t021_014/c1_w0_br u_t021_014/c1_w1_bl u_t021_014/c1_w1_br
+ u_t021_014/c1_r0_rbl u_t021_014/c1_r1_rbl u_t021_014/c2_w0_bl u_t021_014/c2_w0_br u_t021_014/c2_w1_bl
+ u_t021_014/c2_w1_br u_t021_014/c2_r0_rbl u_t021_014/c2_r1_rbl u_t021_014/c3_w0_bl u_t021_014/c3_w0_br
+ u_t021_014/c3_w1_bl u_t021_014/c3_w1_br u_t021_014/c3_r0_rbl u_t021_014/c3_r1_rbl u_t021_014/r0_w0_wl
+ u_t021_014/r0_w1_wl u_t021_014/r0_r0_rwl u_t021_014/r0_r1_rwl u_t021_014/r1_w0_wl u_t021_014/r1_w1_wl
+ u_t021_014/r1_r0_rwl u_t021_014/r1_r1_rwl u_t021_014/r2_w0_wl u_t021_014/r2_w1_wl u_t021_014/r2_r0_rwl
+ u_t021_014/r2_r1_rwl u_t021_014/r3_w0_wl u_t021_014/r3_w1_wl u_t021_014/r3_r0_rwl u_t021_014/r3_r1_rwl VDD VSS VSUBS
+ detronyx_12t_2w2r_rc4_4x4_routed_5layer_direct
Xu_t012_003 u_t012_003/c0_w0_bl u_t012_003/c0_w0_br u_t012_003/c0_w1_bl u_t012_003/c0_w1_br u_t012_003/c0_r0_rbl
+ u_t012_003/c0_r1_rbl u_t012_003/c1_w0_bl u_t012_003/c1_w0_br u_t012_003/c1_w1_bl u_t012_003/c1_w1_br
+ u_t012_003/c1_r0_rbl u_t012_003/c1_r1_rbl u_t012_003/c2_w0_bl u_t012_003/c2_w0_br u_t012_003/c2_w1_bl
+ u_t012_003/c2_w1_br u_t012_003/c2_r0_rbl u_t012_003/c2_r1_rbl u_t012_003/c3_w0_bl u_t012_003/c3_w0_br
+ u_t012_003/c3_w1_bl u_t012_003/c3_w1_br u_t012_003/c3_r0_rbl u_t012_003/c3_r1_rbl u_t012_003/r0_w0_wl
+ u_t012_003/r0_w1_wl u_t012_003/r0_r0_rwl u_t012_003/r0_r1_rwl u_t012_003/r1_w0_wl u_t012_003/r1_w1_wl
+ u_t012_003/r1_r0_rwl u_t012_003/r1_r1_rwl u_t012_003/r2_w0_wl u_t012_003/r2_w1_wl u_t012_003/r2_r0_rwl
+ u_t012_003/r2_r1_rwl u_t012_003/r3_w0_wl u_t012_003/r3_w1_wl u_t012_003/r3_r0_rwl u_t012_003/r3_r1_rwl VDD VSS VSUBS
+ detronyx_12t_2w2r_rc4_4x4_routed_5layer_direct
Xu_t012_014 u_t012_014/c0_w0_bl u_t012_014/c0_w0_br u_t012_014/c0_w1_bl u_t012_014/c0_w1_br u_t012_014/c0_r0_rbl
+ u_t012_014/c0_r1_rbl u_t012_014/c1_w0_bl u_t012_014/c1_w0_br u_t012_014/c1_w1_bl u_t012_014/c1_w1_br
+ u_t012_014/c1_r0_rbl u_t012_014/c1_r1_rbl u_t012_014/c2_w0_bl u_t012_014/c2_w0_br u_t012_014/c2_w1_bl
+ u_t012_014/c2_w1_br u_t012_014/c2_r0_rbl u_t012_014/c2_r1_rbl u_t012_014/c3_w0_bl u_t012_014/c3_w0_br
+ u_t012_014/c3_w1_bl u_t012_014/c3_w1_br u_t012_014/c3_r0_rbl u_t012_014/c3_r1_rbl u_t012_014/r0_w0_wl
+ u_t012_014/r0_w1_wl u_t012_014/r0_r0_rwl u_t012_014/r0_r1_rwl u_t012_014/r1_w0_wl u_t012_014/r1_w1_wl
+ u_t012_014/r1_r0_rwl u_t012_014/r1_r1_rwl u_t012_014/r2_w0_wl u_t012_014/r2_w1_wl u_t012_014/r2_r0_rwl
+ u_t012_014/r2_r1_rwl u_t012_014/r3_w0_wl u_t012_014/r3_w1_wl u_t012_014/r3_r0_rwl u_t012_014/r3_r1_rwl VDD VSS VSUBS
+ detronyx_12t_2w2r_rc4_4x4_routed_5layer_direct
Xu_t003_014 u_t003_014/c0_w0_bl u_t003_014/c0_w0_br u_t003_014/c0_w1_bl u_t003_014/c0_w1_br u_t003_014/c0_r0_rbl
+ u_t003_014/c0_r1_rbl u_t003_014/c1_w0_bl u_t003_014/c1_w0_br u_t003_014/c1_w1_bl u_t003_014/c1_w1_br
+ u_t003_014/c1_r0_rbl u_t003_014/c1_r1_rbl u_t003_014/c2_w0_bl u_t003_014/c2_w0_br u_t003_014/c2_w1_bl
+ u_t003_014/c2_w1_br u_t003_014/c2_r0_rbl u_t003_014/c2_r1_rbl u_t003_014/c3_w0_bl u_t003_014/c3_w0_br
+ u_t003_014/c3_w1_bl u_t003_014/c3_w1_br u_t003_014/c3_r0_rbl u_t003_014/c3_r1_rbl u_t003_014/r0_w0_wl
+ u_t003_014/r0_w1_wl u_t003_014/r0_r0_rwl u_t003_014/r0_r1_rwl u_t003_014/r1_w0_wl u_t003_014/r1_w1_wl
+ u_t003_014/r1_r0_rwl u_t003_014/r1_r1_rwl u_t003_014/r2_w0_wl u_t003_014/r2_w1_wl u_t003_014/r2_r0_rwl
+ u_t003_014/r2_r1_rwl u_t003_014/r3_w0_wl u_t003_014/r3_w1_wl u_t003_014/r3_r0_rwl u_t003_014/r3_r1_rwl VDD VSS VSUBS
+ detronyx_12t_2w2r_rc4_4x4_routed_5layer_direct
Xu_t003_003 u_t003_003/c0_w0_bl u_t003_003/c0_w0_br u_t003_003/c0_w1_bl u_t003_003/c0_w1_br u_t003_003/c0_r0_rbl
+ u_t003_003/c0_r1_rbl u_t003_003/c1_w0_bl u_t003_003/c1_w0_br u_t003_003/c1_w1_bl u_t003_003/c1_w1_br
+ u_t003_003/c1_r0_rbl u_t003_003/c1_r1_rbl u_t003_003/c2_w0_bl u_t003_003/c2_w0_br u_t003_003/c2_w1_bl
+ u_t003_003/c2_w1_br u_t003_003/c2_r0_rbl u_t003_003/c2_r1_rbl u_t003_003/c3_w0_bl u_t003_003/c3_w0_br
+ u_t003_003/c3_w1_bl u_t003_003/c3_w1_br u_t003_003/c3_r0_rbl u_t003_003/c3_r1_rbl u_t003_003/r0_w0_wl
+ u_t003_003/r0_w1_wl u_t003_003/r0_r0_rwl u_t003_003/r0_r1_rwl u_t003_003/r1_w0_wl u_t003_003/r1_w1_wl
+ u_t003_003/r1_r0_rwl u_t003_003/r1_r1_rwl u_t003_003/r2_w0_wl u_t003_003/r2_w1_wl u_t003_003/r2_r0_rwl
+ u_t003_003/r2_r1_rwl u_t003_003/r3_w0_wl u_t003_003/r3_w1_wl u_t003_003/r3_r0_rwl u_t003_003/r3_r1_rwl VDD VSS VSUBS
+ detronyx_12t_2w2r_rc4_4x4_routed_5layer_direct
Xu_t000_006 u_t000_006/c0_w0_bl u_t000_006/c0_w0_br u_t000_006/c0_w1_bl u_t000_006/c0_w1_br u_t000_006/c0_r0_rbl
+ u_t000_006/c0_r1_rbl u_t000_006/c1_w0_bl u_t000_006/c1_w0_br u_t000_006/c1_w1_bl u_t000_006/c1_w1_br
+ u_t000_006/c1_r0_rbl u_t000_006/c1_r1_rbl u_t000_006/c2_w0_bl u_t000_006/c2_w0_br u_t000_006/c2_w1_bl
+ u_t000_006/c2_w1_br u_t000_006/c2_r0_rbl u_t000_006/c2_r1_rbl u_t000_006/c3_w0_bl u_t000_006/c3_w0_br
+ u_t000_006/c3_w1_bl u_t000_006/c3_w1_br u_t000_006/c3_r0_rbl u_t000_006/c3_r1_rbl u_t000_006/r0_w0_wl
+ u_t000_006/r0_w1_wl u_t000_006/r0_r0_rwl u_t000_006/r0_r1_rwl u_t000_006/r1_w0_wl u_t000_006/r1_w1_wl
+ u_t000_006/r1_r0_rwl u_t000_006/r1_r1_rwl u_t000_006/r2_w0_wl u_t000_006/r2_w1_wl u_t000_006/r2_r0_rwl
+ u_t000_006/r2_r1_rwl u_t000_006/r3_w0_wl u_t000_006/r3_w1_wl u_t000_006/r3_r0_rwl u_t000_006/r3_r1_rwl VDD VSS VSUBS
+ detronyx_12t_2w2r_rc4_4x4_routed_5layer_direct
Xu_t028_009 u_t028_009/c0_w0_bl u_t028_009/c0_w0_br u_t028_009/c0_w1_bl u_t028_009/c0_w1_br u_t028_009/c0_r0_rbl
+ u_t028_009/c0_r1_rbl u_t028_009/c1_w0_bl u_t028_009/c1_w0_br u_t028_009/c1_w1_bl u_t028_009/c1_w1_br
+ u_t028_009/c1_r0_rbl u_t028_009/c1_r1_rbl u_t028_009/c2_w0_bl u_t028_009/c2_w0_br u_t028_009/c2_w1_bl
+ u_t028_009/c2_w1_br u_t028_009/c2_r0_rbl u_t028_009/c2_r1_rbl u_t028_009/c3_w0_bl u_t028_009/c3_w0_br
+ u_t028_009/c3_w1_bl u_t028_009/c3_w1_br u_t028_009/c3_r0_rbl u_t028_009/c3_r1_rbl u_t028_009/r0_w0_wl
+ u_t028_009/r0_w1_wl u_t028_009/r0_r0_rwl u_t028_009/r0_r1_rwl u_t028_009/r1_w0_wl u_t028_009/r1_w1_wl
+ u_t028_009/r1_r0_rwl u_t028_009/r1_r1_rwl u_t028_009/r2_w0_wl u_t028_009/r2_w1_wl u_t028_009/r2_r0_rwl
+ u_t028_009/r2_r1_rwl u_t028_009/r3_w0_wl u_t028_009/r3_w1_wl u_t028_009/r3_r0_rwl u_t028_009/r3_r1_rwl VDD VSS VSUBS
+ detronyx_12t_2w2r_rc4_4x4_routed_5layer_direct
Xu_t019_009 u_t019_009/c0_w0_bl u_t019_009/c0_w0_br u_t019_009/c0_w1_bl u_t019_009/c0_w1_br u_t019_009/c0_r0_rbl
+ u_t019_009/c0_r1_rbl u_t019_009/c1_w0_bl u_t019_009/c1_w0_br u_t019_009/c1_w1_bl u_t019_009/c1_w1_br
+ u_t019_009/c1_r0_rbl u_t019_009/c1_r1_rbl u_t019_009/c2_w0_bl u_t019_009/c2_w0_br u_t019_009/c2_w1_bl
+ u_t019_009/c2_w1_br u_t019_009/c2_r0_rbl u_t019_009/c2_r1_rbl u_t019_009/c3_w0_bl u_t019_009/c3_w0_br
+ u_t019_009/c3_w1_bl u_t019_009/c3_w1_br u_t019_009/c3_r0_rbl u_t019_009/c3_r1_rbl u_t019_009/r0_w0_wl
+ u_t019_009/r0_w1_wl u_t019_009/r0_r0_rwl u_t019_009/r0_r1_rwl u_t019_009/r1_w0_wl u_t019_009/r1_w1_wl
+ u_t019_009/r1_r0_rwl u_t019_009/r1_r1_rwl u_t019_009/r2_w0_wl u_t019_009/r2_w1_wl u_t019_009/r2_r0_rwl
+ u_t019_009/r2_r1_rwl u_t019_009/r3_w0_wl u_t019_009/r3_w1_wl u_t019_009/r3_r0_rwl u_t019_009/r3_r1_rwl VDD VSS VSUBS
+ detronyx_12t_2w2r_rc4_4x4_routed_5layer_direct
Xu_t024_012 u_t024_012/c0_w0_bl u_t024_012/c0_w0_br u_t024_012/c0_w1_bl u_t024_012/c0_w1_br u_t024_012/c0_r0_rbl
+ u_t024_012/c0_r1_rbl u_t024_012/c1_w0_bl u_t024_012/c1_w0_br u_t024_012/c1_w1_bl u_t024_012/c1_w1_br
+ u_t024_012/c1_r0_rbl u_t024_012/c1_r1_rbl u_t024_012/c2_w0_bl u_t024_012/c2_w0_br u_t024_012/c2_w1_bl
+ u_t024_012/c2_w1_br u_t024_012/c2_r0_rbl u_t024_012/c2_r1_rbl u_t024_012/c3_w0_bl u_t024_012/c3_w0_br
+ u_t024_012/c3_w1_bl u_t024_012/c3_w1_br u_t024_012/c3_r0_rbl u_t024_012/c3_r1_rbl u_t024_012/r0_w0_wl
+ u_t024_012/r0_w1_wl u_t024_012/r0_r0_rwl u_t024_012/r0_r1_rwl u_t024_012/r1_w0_wl u_t024_012/r1_w1_wl
+ u_t024_012/r1_r0_rwl u_t024_012/r1_r1_rwl u_t024_012/r2_w0_wl u_t024_012/r2_w1_wl u_t024_012/r2_r0_rwl
+ u_t024_012/r2_r1_rwl u_t024_012/r3_w0_wl u_t024_012/r3_w1_wl u_t024_012/r3_r0_rwl u_t024_012/r3_r1_rwl VDD VSS VSUBS
+ detronyx_12t_2w2r_rc4_4x4_routed_5layer_direct
Xu_t024_001 u_t024_001/c0_w0_bl u_t024_001/c0_w0_br u_t024_001/c0_w1_bl u_t024_001/c0_w1_br u_t024_001/c0_r0_rbl
+ u_t024_001/c0_r1_rbl u_t024_001/c1_w0_bl u_t024_001/c1_w0_br u_t024_001/c1_w1_bl u_t024_001/c1_w1_br
+ u_t024_001/c1_r0_rbl u_t024_001/c1_r1_rbl u_t024_001/c2_w0_bl u_t024_001/c2_w0_br u_t024_001/c2_w1_bl
+ u_t024_001/c2_w1_br u_t024_001/c2_r0_rbl u_t024_001/c2_r1_rbl u_t024_001/c3_w0_bl u_t024_001/c3_w0_br
+ u_t024_001/c3_w1_bl u_t024_001/c3_w1_br u_t024_001/c3_r0_rbl u_t024_001/c3_r1_rbl u_t024_001/r0_w0_wl
+ u_t024_001/r0_w1_wl u_t024_001/r0_r0_rwl u_t024_001/r0_r1_rwl u_t024_001/r1_w0_wl u_t024_001/r1_w1_wl
+ u_t024_001/r1_r0_rwl u_t024_001/r1_r1_rwl u_t024_001/r2_w0_wl u_t024_001/r2_w1_wl u_t024_001/r2_r0_rwl
+ u_t024_001/r2_r1_rwl u_t024_001/r3_w0_wl u_t024_001/r3_w1_wl u_t024_001/r3_r0_rwl u_t024_001/r3_r1_rwl VDD VSS VSUBS
+ detronyx_12t_2w2r_rc4_4x4_routed_5layer_direct
Xu_t015_001 u_t015_001/c0_w0_bl u_t015_001/c0_w0_br u_t015_001/c0_w1_bl u_t015_001/c0_w1_br u_t015_001/c0_r0_rbl
+ u_t015_001/c0_r1_rbl u_t015_001/c1_w0_bl u_t015_001/c1_w0_br u_t015_001/c1_w1_bl u_t015_001/c1_w1_br
+ u_t015_001/c1_r0_rbl u_t015_001/c1_r1_rbl u_t015_001/c2_w0_bl u_t015_001/c2_w0_br u_t015_001/c2_w1_bl
+ u_t015_001/c2_w1_br u_t015_001/c2_r0_rbl u_t015_001/c2_r1_rbl u_t015_001/c3_w0_bl u_t015_001/c3_w0_br
+ u_t015_001/c3_w1_bl u_t015_001/c3_w1_br u_t015_001/c3_r0_rbl u_t015_001/c3_r1_rbl u_t015_001/r0_w0_wl
+ u_t015_001/r0_w1_wl u_t015_001/r0_r0_rwl u_t015_001/r0_r1_rwl u_t015_001/r1_w0_wl u_t015_001/r1_w1_wl
+ u_t015_001/r1_r0_rwl u_t015_001/r1_r1_rwl u_t015_001/r2_w0_wl u_t015_001/r2_w1_wl u_t015_001/r2_r0_rwl
+ u_t015_001/r2_r1_rwl u_t015_001/r3_w0_wl u_t015_001/r3_w1_wl u_t015_001/r3_r0_rwl u_t015_001/r3_r1_rwl VDD VSS VSUBS
+ detronyx_12t_2w2r_rc4_4x4_routed_5layer_direct
Xu_t015_012 u_t015_012/c0_w0_bl u_t015_012/c0_w0_br u_t015_012/c0_w1_bl u_t015_012/c0_w1_br u_t015_012/c0_r0_rbl
+ u_t015_012/c0_r1_rbl u_t015_012/c1_w0_bl u_t015_012/c1_w0_br u_t015_012/c1_w1_bl u_t015_012/c1_w1_br
+ u_t015_012/c1_r0_rbl u_t015_012/c1_r1_rbl u_t015_012/c2_w0_bl u_t015_012/c2_w0_br u_t015_012/c2_w1_bl
+ u_t015_012/c2_w1_br u_t015_012/c2_r0_rbl u_t015_012/c2_r1_rbl u_t015_012/c3_w0_bl u_t015_012/c3_w0_br
+ u_t015_012/c3_w1_bl u_t015_012/c3_w1_br u_t015_012/c3_r0_rbl u_t015_012/c3_r1_rbl u_t015_012/r0_w0_wl
+ u_t015_012/r0_w1_wl u_t015_012/r0_r0_rwl u_t015_012/r0_r1_rwl u_t015_012/r1_w0_wl u_t015_012/r1_w1_wl
+ u_t015_012/r1_r0_rwl u_t015_012/r1_r1_rwl u_t015_012/r2_w0_wl u_t015_012/r2_w1_wl u_t015_012/r2_r0_rwl
+ u_t015_012/r2_r1_rwl u_t015_012/r3_w0_wl u_t015_012/r3_w1_wl u_t015_012/r3_r0_rwl u_t015_012/r3_r1_rwl VDD VSS VSUBS
+ detronyx_12t_2w2r_rc4_4x4_routed_5layer_direct
Xu_t030_015 u_t030_015/c0_w0_bl u_t030_015/c0_w0_br u_t030_015/c0_w1_bl u_t030_015/c0_w1_br u_t030_015/c0_r0_rbl
+ u_t030_015/c0_r1_rbl u_t030_015/c1_w0_bl u_t030_015/c1_w0_br u_t030_015/c1_w1_bl u_t030_015/c1_w1_br
+ u_t030_015/c1_r0_rbl u_t030_015/c1_r1_rbl u_t030_015/c2_w0_bl u_t030_015/c2_w0_br u_t030_015/c2_w1_bl
+ u_t030_015/c2_w1_br u_t030_015/c2_r0_rbl u_t030_015/c2_r1_rbl u_t030_015/c3_w0_bl u_t030_015/c3_w0_br
+ u_t030_015/c3_w1_bl u_t030_015/c3_w1_br u_t030_015/c3_r0_rbl u_t030_015/c3_r1_rbl u_t030_015/r0_w0_wl
+ u_t030_015/r0_w1_wl u_t030_015/r0_r0_rwl u_t030_015/r0_r1_rwl u_t030_015/r1_w0_wl u_t030_015/r1_w1_wl
+ u_t030_015/r1_r0_rwl u_t030_015/r1_r1_rwl u_t030_015/r2_w0_wl u_t030_015/r2_w1_wl u_t030_015/r2_r0_rwl
+ u_t030_015/r2_r1_rwl u_t030_015/r3_w0_wl u_t030_015/r3_w1_wl u_t030_015/r3_r0_rwl u_t030_015/r3_r1_rwl VDD VSS VSUBS
+ detronyx_12t_2w2r_rc4_4x4_routed_5layer_direct
Xu_t030_004 u_t030_004/c0_w0_bl u_t030_004/c0_w0_br u_t030_004/c0_w1_bl u_t030_004/c0_w1_br u_t030_004/c0_r0_rbl
+ u_t030_004/c0_r1_rbl u_t030_004/c1_w0_bl u_t030_004/c1_w0_br u_t030_004/c1_w1_bl u_t030_004/c1_w1_br
+ u_t030_004/c1_r0_rbl u_t030_004/c1_r1_rbl u_t030_004/c2_w0_bl u_t030_004/c2_w0_br u_t030_004/c2_w1_bl
+ u_t030_004/c2_w1_br u_t030_004/c2_r0_rbl u_t030_004/c2_r1_rbl u_t030_004/c3_w0_bl u_t030_004/c3_w0_br
+ u_t030_004/c3_w1_bl u_t030_004/c3_w1_br u_t030_004/c3_r0_rbl u_t030_004/c3_r1_rbl u_t030_004/r0_w0_wl
+ u_t030_004/r0_w1_wl u_t030_004/r0_r0_rwl u_t030_004/r0_r1_rwl u_t030_004/r1_w0_wl u_t030_004/r1_w1_wl
+ u_t030_004/r1_r0_rwl u_t030_004/r1_r1_rwl u_t030_004/r2_w0_wl u_t030_004/r2_w1_wl u_t030_004/r2_r0_rwl
+ u_t030_004/r2_r1_rwl u_t030_004/r3_w0_wl u_t030_004/r3_w1_wl u_t030_004/r3_r0_rwl u_t030_004/r3_r1_rwl VDD VSS VSUBS
+ detronyx_12t_2w2r_rc4_4x4_routed_5layer_direct
Xu_t006_001 u_t006_001/c0_w0_bl u_t006_001/c0_w0_br u_t006_001/c0_w1_bl u_t006_001/c0_w1_br u_t006_001/c0_r0_rbl
+ u_t006_001/c0_r1_rbl u_t006_001/c1_w0_bl u_t006_001/c1_w0_br u_t006_001/c1_w1_bl u_t006_001/c1_w1_br
+ u_t006_001/c1_r0_rbl u_t006_001/c1_r1_rbl u_t006_001/c2_w0_bl u_t006_001/c2_w0_br u_t006_001/c2_w1_bl
+ u_t006_001/c2_w1_br u_t006_001/c2_r0_rbl u_t006_001/c2_r1_rbl u_t006_001/c3_w0_bl u_t006_001/c3_w0_br
+ u_t006_001/c3_w1_bl u_t006_001/c3_w1_br u_t006_001/c3_r0_rbl u_t006_001/c3_r1_rbl u_t006_001/r0_w0_wl
+ u_t006_001/r0_w1_wl u_t006_001/r0_r0_rwl u_t006_001/r0_r1_rwl u_t006_001/r1_w0_wl u_t006_001/r1_w1_wl
+ u_t006_001/r1_r0_rwl u_t006_001/r1_r1_rwl u_t006_001/r2_w0_wl u_t006_001/r2_w1_wl u_t006_001/r2_r0_rwl
+ u_t006_001/r2_r1_rwl u_t006_001/r3_w0_wl u_t006_001/r3_w1_wl u_t006_001/r3_r0_rwl u_t006_001/r3_r1_rwl VDD VSS VSUBS
+ detronyx_12t_2w2r_rc4_4x4_routed_5layer_direct
Xu_t006_012 u_t006_012/c0_w0_bl u_t006_012/c0_w0_br u_t006_012/c0_w1_bl u_t006_012/c0_w1_br u_t006_012/c0_r0_rbl
+ u_t006_012/c0_r1_rbl u_t006_012/c1_w0_bl u_t006_012/c1_w0_br u_t006_012/c1_w1_bl u_t006_012/c1_w1_br
+ u_t006_012/c1_r0_rbl u_t006_012/c1_r1_rbl u_t006_012/c2_w0_bl u_t006_012/c2_w0_br u_t006_012/c2_w1_bl
+ u_t006_012/c2_w1_br u_t006_012/c2_r0_rbl u_t006_012/c2_r1_rbl u_t006_012/c3_w0_bl u_t006_012/c3_w0_br
+ u_t006_012/c3_w1_bl u_t006_012/c3_w1_br u_t006_012/c3_r0_rbl u_t006_012/c3_r1_rbl u_t006_012/r0_w0_wl
+ u_t006_012/r0_w1_wl u_t006_012/r0_r0_rwl u_t006_012/r0_r1_rwl u_t006_012/r1_w0_wl u_t006_012/r1_w1_wl
+ u_t006_012/r1_r0_rwl u_t006_012/r1_r1_rwl u_t006_012/r2_w0_wl u_t006_012/r2_w1_wl u_t006_012/r2_r0_rwl
+ u_t006_012/r2_r1_rwl u_t006_012/r3_w0_wl u_t006_012/r3_w1_wl u_t006_012/r3_r0_rwl u_t006_012/r3_r1_rwl VDD VSS VSUBS
+ detronyx_12t_2w2r_rc4_4x4_routed_5layer_direct
Xu_t021_004 u_t021_004/c0_w0_bl u_t021_004/c0_w0_br u_t021_004/c0_w1_bl u_t021_004/c0_w1_br u_t021_004/c0_r0_rbl
+ u_t021_004/c0_r1_rbl u_t021_004/c1_w0_bl u_t021_004/c1_w0_br u_t021_004/c1_w1_bl u_t021_004/c1_w1_br
+ u_t021_004/c1_r0_rbl u_t021_004/c1_r1_rbl u_t021_004/c2_w0_bl u_t021_004/c2_w0_br u_t021_004/c2_w1_bl
+ u_t021_004/c2_w1_br u_t021_004/c2_r0_rbl u_t021_004/c2_r1_rbl u_t021_004/c3_w0_bl u_t021_004/c3_w0_br
+ u_t021_004/c3_w1_bl u_t021_004/c3_w1_br u_t021_004/c3_r0_rbl u_t021_004/c3_r1_rbl u_t021_004/r0_w0_wl
+ u_t021_004/r0_w1_wl u_t021_004/r0_r0_rwl u_t021_004/r0_r1_rwl u_t021_004/r1_w0_wl u_t021_004/r1_w1_wl
+ u_t021_004/r1_r0_rwl u_t021_004/r1_r1_rwl u_t021_004/r2_w0_wl u_t021_004/r2_w1_wl u_t021_004/r2_r0_rwl
+ u_t021_004/r2_r1_rwl u_t021_004/r3_w0_wl u_t021_004/r3_w1_wl u_t021_004/r3_r0_rwl u_t021_004/r3_r1_rwl VDD VSS VSUBS
+ detronyx_12t_2w2r_rc4_4x4_routed_5layer_direct
Xu_t021_015 u_t021_015/c0_w0_bl u_t021_015/c0_w0_br u_t021_015/c0_w1_bl u_t021_015/c0_w1_br u_t021_015/c0_r0_rbl
+ u_t021_015/c0_r1_rbl u_t021_015/c1_w0_bl u_t021_015/c1_w0_br u_t021_015/c1_w1_bl u_t021_015/c1_w1_br
+ u_t021_015/c1_r0_rbl u_t021_015/c1_r1_rbl u_t021_015/c2_w0_bl u_t021_015/c2_w0_br u_t021_015/c2_w1_bl
+ u_t021_015/c2_w1_br u_t021_015/c2_r0_rbl u_t021_015/c2_r1_rbl u_t021_015/c3_w0_bl u_t021_015/c3_w0_br
+ u_t021_015/c3_w1_bl u_t021_015/c3_w1_br u_t021_015/c3_r0_rbl u_t021_015/c3_r1_rbl u_t021_015/r0_w0_wl
+ u_t021_015/r0_w1_wl u_t021_015/r0_r0_rwl u_t021_015/r0_r1_rwl u_t021_015/r1_w0_wl u_t021_015/r1_w1_wl
+ u_t021_015/r1_r0_rwl u_t021_015/r1_r1_rwl u_t021_015/r2_w0_wl u_t021_015/r2_w1_wl u_t021_015/r2_r0_rwl
+ u_t021_015/r2_r1_rwl u_t021_015/r3_w0_wl u_t021_015/r3_w1_wl u_t021_015/r3_r0_rwl u_t021_015/r3_r1_rwl VDD VSS VSUBS
+ detronyx_12t_2w2r_rc4_4x4_routed_5layer_direct
Xu_t012_004 u_t012_004/c0_w0_bl u_t012_004/c0_w0_br u_t012_004/c0_w1_bl u_t012_004/c0_w1_br u_t012_004/c0_r0_rbl
+ u_t012_004/c0_r1_rbl u_t012_004/c1_w0_bl u_t012_004/c1_w0_br u_t012_004/c1_w1_bl u_t012_004/c1_w1_br
+ u_t012_004/c1_r0_rbl u_t012_004/c1_r1_rbl u_t012_004/c2_w0_bl u_t012_004/c2_w0_br u_t012_004/c2_w1_bl
+ u_t012_004/c2_w1_br u_t012_004/c2_r0_rbl u_t012_004/c2_r1_rbl u_t012_004/c3_w0_bl u_t012_004/c3_w0_br
+ u_t012_004/c3_w1_bl u_t012_004/c3_w1_br u_t012_004/c3_r0_rbl u_t012_004/c3_r1_rbl u_t012_004/r0_w0_wl
+ u_t012_004/r0_w1_wl u_t012_004/r0_r0_rwl u_t012_004/r0_r1_rwl u_t012_004/r1_w0_wl u_t012_004/r1_w1_wl
+ u_t012_004/r1_r0_rwl u_t012_004/r1_r1_rwl u_t012_004/r2_w0_wl u_t012_004/r2_w1_wl u_t012_004/r2_r0_rwl
+ u_t012_004/r2_r1_rwl u_t012_004/r3_w0_wl u_t012_004/r3_w1_wl u_t012_004/r3_r0_rwl u_t012_004/r3_r1_rwl VDD VSS VSUBS
+ detronyx_12t_2w2r_rc4_4x4_routed_5layer_direct
Xu_t012_015 u_t012_015/c0_w0_bl u_t012_015/c0_w0_br u_t012_015/c0_w1_bl u_t012_015/c0_w1_br u_t012_015/c0_r0_rbl
+ u_t012_015/c0_r1_rbl u_t012_015/c1_w0_bl u_t012_015/c1_w0_br u_t012_015/c1_w1_bl u_t012_015/c1_w1_br
+ u_t012_015/c1_r0_rbl u_t012_015/c1_r1_rbl u_t012_015/c2_w0_bl u_t012_015/c2_w0_br u_t012_015/c2_w1_bl
+ u_t012_015/c2_w1_br u_t012_015/c2_r0_rbl u_t012_015/c2_r1_rbl u_t012_015/c3_w0_bl u_t012_015/c3_w0_br
+ u_t012_015/c3_w1_bl u_t012_015/c3_w1_br u_t012_015/c3_r0_rbl u_t012_015/c3_r1_rbl u_t012_015/r0_w0_wl
+ u_t012_015/r0_w1_wl u_t012_015/r0_r0_rwl u_t012_015/r0_r1_rwl u_t012_015/r1_w0_wl u_t012_015/r1_w1_wl
+ u_t012_015/r1_r0_rwl u_t012_015/r1_r1_rwl u_t012_015/r2_w0_wl u_t012_015/r2_w1_wl u_t012_015/r2_r0_rwl
+ u_t012_015/r2_r1_rwl u_t012_015/r3_w0_wl u_t012_015/r3_w1_wl u_t012_015/r3_r0_rwl u_t012_015/r3_r1_rwl VDD VSS VSUBS
+ detronyx_12t_2w2r_rc4_4x4_routed_5layer_direct
Xu_t003_015 u_t003_015/c0_w0_bl u_t003_015/c0_w0_br u_t003_015/c0_w1_bl u_t003_015/c0_w1_br u_t003_015/c0_r0_rbl
+ u_t003_015/c0_r1_rbl u_t003_015/c1_w0_bl u_t003_015/c1_w0_br u_t003_015/c1_w1_bl u_t003_015/c1_w1_br
+ u_t003_015/c1_r0_rbl u_t003_015/c1_r1_rbl u_t003_015/c2_w0_bl u_t003_015/c2_w0_br u_t003_015/c2_w1_bl
+ u_t003_015/c2_w1_br u_t003_015/c2_r0_rbl u_t003_015/c2_r1_rbl u_t003_015/c3_w0_bl u_t003_015/c3_w0_br
+ u_t003_015/c3_w1_bl u_t003_015/c3_w1_br u_t003_015/c3_r0_rbl u_t003_015/c3_r1_rbl u_t003_015/r0_w0_wl
+ u_t003_015/r0_w1_wl u_t003_015/r0_r0_rwl u_t003_015/r0_r1_rwl u_t003_015/r1_w0_wl u_t003_015/r1_w1_wl
+ u_t003_015/r1_r0_rwl u_t003_015/r1_r1_rwl u_t003_015/r2_w0_wl u_t003_015/r2_w1_wl u_t003_015/r2_r0_rwl
+ u_t003_015/r2_r1_rwl u_t003_015/r3_w0_wl u_t003_015/r3_w1_wl u_t003_015/r3_r0_rwl u_t003_015/r3_r1_rwl VDD VSS VSUBS
+ detronyx_12t_2w2r_rc4_4x4_routed_5layer_direct
Xu_t003_004 u_t003_004/c0_w0_bl u_t003_004/c0_w0_br u_t003_004/c0_w1_bl u_t003_004/c0_w1_br u_t003_004/c0_r0_rbl
+ u_t003_004/c0_r1_rbl u_t003_004/c1_w0_bl u_t003_004/c1_w0_br u_t003_004/c1_w1_bl u_t003_004/c1_w1_br
+ u_t003_004/c1_r0_rbl u_t003_004/c1_r1_rbl u_t003_004/c2_w0_bl u_t003_004/c2_w0_br u_t003_004/c2_w1_bl
+ u_t003_004/c2_w1_br u_t003_004/c2_r0_rbl u_t003_004/c2_r1_rbl u_t003_004/c3_w0_bl u_t003_004/c3_w0_br
+ u_t003_004/c3_w1_bl u_t003_004/c3_w1_br u_t003_004/c3_r0_rbl u_t003_004/c3_r1_rbl u_t003_004/r0_w0_wl
+ u_t003_004/r0_w1_wl u_t003_004/r0_r0_rwl u_t003_004/r0_r1_rwl u_t003_004/r1_w0_wl u_t003_004/r1_w1_wl
+ u_t003_004/r1_r0_rwl u_t003_004/r1_r1_rwl u_t003_004/r2_w0_wl u_t003_004/r2_w1_wl u_t003_004/r2_r0_rwl
+ u_t003_004/r2_r1_rwl u_t003_004/r3_w0_wl u_t003_004/r3_w1_wl u_t003_004/r3_r0_rwl u_t003_004/r3_r1_rwl VDD VSS VSUBS
+ detronyx_12t_2w2r_rc4_4x4_routed_5layer_direct
Xu_t000_007 u_t000_007/c0_w0_bl u_t000_007/c0_w0_br u_t000_007/c0_w1_bl u_t000_007/c0_w1_br u_t000_007/c0_r0_rbl
+ u_t000_007/c0_r1_rbl u_t000_007/c1_w0_bl u_t000_007/c1_w0_br u_t000_007/c1_w1_bl u_t000_007/c1_w1_br
+ u_t000_007/c1_r0_rbl u_t000_007/c1_r1_rbl u_t000_007/c2_w0_bl u_t000_007/c2_w0_br u_t000_007/c2_w1_bl
+ u_t000_007/c2_w1_br u_t000_007/c2_r0_rbl u_t000_007/c2_r1_rbl u_t000_007/c3_w0_bl u_t000_007/c3_w0_br
+ u_t000_007/c3_w1_bl u_t000_007/c3_w1_br u_t000_007/c3_r0_rbl u_t000_007/c3_r1_rbl u_t000_007/r0_w0_wl
+ u_t000_007/r0_w1_wl u_t000_007/r0_r0_rwl u_t000_007/r0_r1_rwl u_t000_007/r1_w0_wl u_t000_007/r1_w1_wl
+ u_t000_007/r1_r0_rwl u_t000_007/r1_r1_rwl u_t000_007/r2_w0_wl u_t000_007/r2_w1_wl u_t000_007/r2_r0_rwl
+ u_t000_007/r2_r1_rwl u_t000_007/r3_w0_wl u_t000_007/r3_w1_wl u_t000_007/r3_r0_rwl u_t000_007/r3_r1_rwl VDD VSS VSUBS
+ detronyx_12t_2w2r_rc4_4x4_routed_5layer_direct
Xu_t027_010 u_t027_010/c0_w0_bl u_t027_010/c0_w0_br u_t027_010/c0_w1_bl u_t027_010/c0_w1_br u_t027_010/c0_r0_rbl
+ u_t027_010/c0_r1_rbl u_t027_010/c1_w0_bl u_t027_010/c1_w0_br u_t027_010/c1_w1_bl u_t027_010/c1_w1_br
+ u_t027_010/c1_r0_rbl u_t027_010/c1_r1_rbl u_t027_010/c2_w0_bl u_t027_010/c2_w0_br u_t027_010/c2_w1_bl
+ u_t027_010/c2_w1_br u_t027_010/c2_r0_rbl u_t027_010/c2_r1_rbl u_t027_010/c3_w0_bl u_t027_010/c3_w0_br
+ u_t027_010/c3_w1_bl u_t027_010/c3_w1_br u_t027_010/c3_r0_rbl u_t027_010/c3_r1_rbl u_t027_010/r0_w0_wl
+ u_t027_010/r0_w1_wl u_t027_010/r0_r0_rwl u_t027_010/r0_r1_rwl u_t027_010/r1_w0_wl u_t027_010/r1_w1_wl
+ u_t027_010/r1_r0_rwl u_t027_010/r1_r1_rwl u_t027_010/r2_w0_wl u_t027_010/r2_w1_wl u_t027_010/r2_r0_rwl
+ u_t027_010/r2_r1_rwl u_t027_010/r3_w0_wl u_t027_010/r3_w1_wl u_t027_010/r3_r0_rwl u_t027_010/r3_r1_rwl VDD VSS VSUBS
+ detronyx_12t_2w2r_rc4_4x4_routed_5layer_direct
Xu_t018_010 u_t018_010/c0_w0_bl u_t018_010/c0_w0_br u_t018_010/c0_w1_bl u_t018_010/c0_w1_br u_t018_010/c0_r0_rbl
+ u_t018_010/c0_r1_rbl u_t018_010/c1_w0_bl u_t018_010/c1_w0_br u_t018_010/c1_w1_bl u_t018_010/c1_w1_br
+ u_t018_010/c1_r0_rbl u_t018_010/c1_r1_rbl u_t018_010/c2_w0_bl u_t018_010/c2_w0_br u_t018_010/c2_w1_bl
+ u_t018_010/c2_w1_br u_t018_010/c2_r0_rbl u_t018_010/c2_r1_rbl u_t018_010/c3_w0_bl u_t018_010/c3_w0_br
+ u_t018_010/c3_w1_bl u_t018_010/c3_w1_br u_t018_010/c3_r0_rbl u_t018_010/c3_r1_rbl u_t018_010/r0_w0_wl
+ u_t018_010/r0_w1_wl u_t018_010/r0_r0_rwl u_t018_010/r0_r1_rwl u_t018_010/r1_w0_wl u_t018_010/r1_w1_wl
+ u_t018_010/r1_r0_rwl u_t018_010/r1_r1_rwl u_t018_010/r2_w0_wl u_t018_010/r2_w1_wl u_t018_010/r2_r0_rwl
+ u_t018_010/r2_r1_rwl u_t018_010/r3_w0_wl u_t018_010/r3_w1_wl u_t018_010/r3_r0_rwl u_t018_010/r3_r1_rwl VDD VSS VSUBS
+ detronyx_12t_2w2r_rc4_4x4_routed_5layer_direct
Xu_t024_013 u_t024_013/c0_w0_bl u_t024_013/c0_w0_br u_t024_013/c0_w1_bl u_t024_013/c0_w1_br u_t024_013/c0_r0_rbl
+ u_t024_013/c0_r1_rbl u_t024_013/c1_w0_bl u_t024_013/c1_w0_br u_t024_013/c1_w1_bl u_t024_013/c1_w1_br
+ u_t024_013/c1_r0_rbl u_t024_013/c1_r1_rbl u_t024_013/c2_w0_bl u_t024_013/c2_w0_br u_t024_013/c2_w1_bl
+ u_t024_013/c2_w1_br u_t024_013/c2_r0_rbl u_t024_013/c2_r1_rbl u_t024_013/c3_w0_bl u_t024_013/c3_w0_br
+ u_t024_013/c3_w1_bl u_t024_013/c3_w1_br u_t024_013/c3_r0_rbl u_t024_013/c3_r1_rbl u_t024_013/r0_w0_wl
+ u_t024_013/r0_w1_wl u_t024_013/r0_r0_rwl u_t024_013/r0_r1_rwl u_t024_013/r1_w0_wl u_t024_013/r1_w1_wl
+ u_t024_013/r1_r0_rwl u_t024_013/r1_r1_rwl u_t024_013/r2_w0_wl u_t024_013/r2_w1_wl u_t024_013/r2_r0_rwl
+ u_t024_013/r2_r1_rwl u_t024_013/r3_w0_wl u_t024_013/r3_w1_wl u_t024_013/r3_r0_rwl u_t024_013/r3_r1_rwl VDD VSS VSUBS
+ detronyx_12t_2w2r_rc4_4x4_routed_5layer_direct
Xu_t024_002 u_t024_002/c0_w0_bl u_t024_002/c0_w0_br u_t024_002/c0_w1_bl u_t024_002/c0_w1_br u_t024_002/c0_r0_rbl
+ u_t024_002/c0_r1_rbl u_t024_002/c1_w0_bl u_t024_002/c1_w0_br u_t024_002/c1_w1_bl u_t024_002/c1_w1_br
+ u_t024_002/c1_r0_rbl u_t024_002/c1_r1_rbl u_t024_002/c2_w0_bl u_t024_002/c2_w0_br u_t024_002/c2_w1_bl
+ u_t024_002/c2_w1_br u_t024_002/c2_r0_rbl u_t024_002/c2_r1_rbl u_t024_002/c3_w0_bl u_t024_002/c3_w0_br
+ u_t024_002/c3_w1_bl u_t024_002/c3_w1_br u_t024_002/c3_r0_rbl u_t024_002/c3_r1_rbl u_t024_002/r0_w0_wl
+ u_t024_002/r0_w1_wl u_t024_002/r0_r0_rwl u_t024_002/r0_r1_rwl u_t024_002/r1_w0_wl u_t024_002/r1_w1_wl
+ u_t024_002/r1_r0_rwl u_t024_002/r1_r1_rwl u_t024_002/r2_w0_wl u_t024_002/r2_w1_wl u_t024_002/r2_r0_rwl
+ u_t024_002/r2_r1_rwl u_t024_002/r3_w0_wl u_t024_002/r3_w1_wl u_t024_002/r3_r0_rwl u_t024_002/r3_r1_rwl VDD VSS VSUBS
+ detronyx_12t_2w2r_rc4_4x4_routed_5layer_direct
Xu_t009_010 u_t009_010/c0_w0_bl u_t009_010/c0_w0_br u_t009_010/c0_w1_bl u_t009_010/c0_w1_br u_t009_010/c0_r0_rbl
+ u_t009_010/c0_r1_rbl u_t009_010/c1_w0_bl u_t009_010/c1_w0_br u_t009_010/c1_w1_bl u_t009_010/c1_w1_br
+ u_t009_010/c1_r0_rbl u_t009_010/c1_r1_rbl u_t009_010/c2_w0_bl u_t009_010/c2_w0_br u_t009_010/c2_w1_bl
+ u_t009_010/c2_w1_br u_t009_010/c2_r0_rbl u_t009_010/c2_r1_rbl u_t009_010/c3_w0_bl u_t009_010/c3_w0_br
+ u_t009_010/c3_w1_bl u_t009_010/c3_w1_br u_t009_010/c3_r0_rbl u_t009_010/c3_r1_rbl u_t009_010/r0_w0_wl
+ u_t009_010/r0_w1_wl u_t009_010/r0_r0_rwl u_t009_010/r0_r1_rwl u_t009_010/r1_w0_wl u_t009_010/r1_w1_wl
+ u_t009_010/r1_r0_rwl u_t009_010/r1_r1_rwl u_t009_010/r2_w0_wl u_t009_010/r2_w1_wl u_t009_010/r2_r0_rwl
+ u_t009_010/r2_r1_rwl u_t009_010/r3_w0_wl u_t009_010/r3_w1_wl u_t009_010/r3_r0_rwl u_t009_010/r3_r1_rwl VDD VSS VSUBS
+ detronyx_12t_2w2r_rc4_4x4_routed_5layer_direct
Xu_t030_005 u_t030_005/c0_w0_bl u_t030_005/c0_w0_br u_t030_005/c0_w1_bl u_t030_005/c0_w1_br u_t030_005/c0_r0_rbl
+ u_t030_005/c0_r1_rbl u_t030_005/c1_w0_bl u_t030_005/c1_w0_br u_t030_005/c1_w1_bl u_t030_005/c1_w1_br
+ u_t030_005/c1_r0_rbl u_t030_005/c1_r1_rbl u_t030_005/c2_w0_bl u_t030_005/c2_w0_br u_t030_005/c2_w1_bl
+ u_t030_005/c2_w1_br u_t030_005/c2_r0_rbl u_t030_005/c2_r1_rbl u_t030_005/c3_w0_bl u_t030_005/c3_w0_br
+ u_t030_005/c3_w1_bl u_t030_005/c3_w1_br u_t030_005/c3_r0_rbl u_t030_005/c3_r1_rbl u_t030_005/r0_w0_wl
+ u_t030_005/r0_w1_wl u_t030_005/r0_r0_rwl u_t030_005/r0_r1_rwl u_t030_005/r1_w0_wl u_t030_005/r1_w1_wl
+ u_t030_005/r1_r0_rwl u_t030_005/r1_r1_rwl u_t030_005/r2_w0_wl u_t030_005/r2_w1_wl u_t030_005/r2_r0_rwl
+ u_t030_005/r2_r1_rwl u_t030_005/r3_w0_wl u_t030_005/r3_w1_wl u_t030_005/r3_r0_rwl u_t030_005/r3_r1_rwl VDD VSS VSUBS
+ detronyx_12t_2w2r_rc4_4x4_routed_5layer_direct
Xu_t006_002 u_t006_002/c0_w0_bl u_t006_002/c0_w0_br u_t006_002/c0_w1_bl u_t006_002/c0_w1_br u_t006_002/c0_r0_rbl
+ u_t006_002/c0_r1_rbl u_t006_002/c1_w0_bl u_t006_002/c1_w0_br u_t006_002/c1_w1_bl u_t006_002/c1_w1_br
+ u_t006_002/c1_r0_rbl u_t006_002/c1_r1_rbl u_t006_002/c2_w0_bl u_t006_002/c2_w0_br u_t006_002/c2_w1_bl
+ u_t006_002/c2_w1_br u_t006_002/c2_r0_rbl u_t006_002/c2_r1_rbl u_t006_002/c3_w0_bl u_t006_002/c3_w0_br
+ u_t006_002/c3_w1_bl u_t006_002/c3_w1_br u_t006_002/c3_r0_rbl u_t006_002/c3_r1_rbl u_t006_002/r0_w0_wl
+ u_t006_002/r0_w1_wl u_t006_002/r0_r0_rwl u_t006_002/r0_r1_rwl u_t006_002/r1_w0_wl u_t006_002/r1_w1_wl
+ u_t006_002/r1_r0_rwl u_t006_002/r1_r1_rwl u_t006_002/r2_w0_wl u_t006_002/r2_w1_wl u_t006_002/r2_r0_rwl
+ u_t006_002/r2_r1_rwl u_t006_002/r3_w0_wl u_t006_002/r3_w1_wl u_t006_002/r3_r0_rwl u_t006_002/r3_r1_rwl VDD VSS VSUBS
+ detronyx_12t_2w2r_rc4_4x4_routed_5layer_direct
Xu_t015_002 u_t015_002/c0_w0_bl u_t015_002/c0_w0_br u_t015_002/c0_w1_bl u_t015_002/c0_w1_br u_t015_002/c0_r0_rbl
+ u_t015_002/c0_r1_rbl u_t015_002/c1_w0_bl u_t015_002/c1_w0_br u_t015_002/c1_w1_bl u_t015_002/c1_w1_br
+ u_t015_002/c1_r0_rbl u_t015_002/c1_r1_rbl u_t015_002/c2_w0_bl u_t015_002/c2_w0_br u_t015_002/c2_w1_bl
+ u_t015_002/c2_w1_br u_t015_002/c2_r0_rbl u_t015_002/c2_r1_rbl u_t015_002/c3_w0_bl u_t015_002/c3_w0_br
+ u_t015_002/c3_w1_bl u_t015_002/c3_w1_br u_t015_002/c3_r0_rbl u_t015_002/c3_r1_rbl u_t015_002/r0_w0_wl
+ u_t015_002/r0_w1_wl u_t015_002/r0_r0_rwl u_t015_002/r0_r1_rwl u_t015_002/r1_w0_wl u_t015_002/r1_w1_wl
+ u_t015_002/r1_r0_rwl u_t015_002/r1_r1_rwl u_t015_002/r2_w0_wl u_t015_002/r2_w1_wl u_t015_002/r2_r0_rwl
+ u_t015_002/r2_r1_rwl u_t015_002/r3_w0_wl u_t015_002/r3_w1_wl u_t015_002/r3_r0_rwl u_t015_002/r3_r1_rwl VDD VSS VSUBS
+ detronyx_12t_2w2r_rc4_4x4_routed_5layer_direct
Xu_t015_013 u_t015_013/c0_w0_bl u_t015_013/c0_w0_br u_t015_013/c0_w1_bl u_t015_013/c0_w1_br u_t015_013/c0_r0_rbl
+ u_t015_013/c0_r1_rbl u_t015_013/c1_w0_bl u_t015_013/c1_w0_br u_t015_013/c1_w1_bl u_t015_013/c1_w1_br
+ u_t015_013/c1_r0_rbl u_t015_013/c1_r1_rbl u_t015_013/c2_w0_bl u_t015_013/c2_w0_br u_t015_013/c2_w1_bl
+ u_t015_013/c2_w1_br u_t015_013/c2_r0_rbl u_t015_013/c2_r1_rbl u_t015_013/c3_w0_bl u_t015_013/c3_w0_br
+ u_t015_013/c3_w1_bl u_t015_013/c3_w1_br u_t015_013/c3_r0_rbl u_t015_013/c3_r1_rbl u_t015_013/r0_w0_wl
+ u_t015_013/r0_w1_wl u_t015_013/r0_r0_rwl u_t015_013/r0_r1_rwl u_t015_013/r1_w0_wl u_t015_013/r1_w1_wl
+ u_t015_013/r1_r0_rwl u_t015_013/r1_r1_rwl u_t015_013/r2_w0_wl u_t015_013/r2_w1_wl u_t015_013/r2_r0_rwl
+ u_t015_013/r2_r1_rwl u_t015_013/r3_w0_wl u_t015_013/r3_w1_wl u_t015_013/r3_r0_rwl u_t015_013/r3_r1_rwl VDD VSS VSUBS
+ detronyx_12t_2w2r_rc4_4x4_routed_5layer_direct
Xu_t006_013 u_t006_013/c0_w0_bl u_t006_013/c0_w0_br u_t006_013/c0_w1_bl u_t006_013/c0_w1_br u_t006_013/c0_r0_rbl
+ u_t006_013/c0_r1_rbl u_t006_013/c1_w0_bl u_t006_013/c1_w0_br u_t006_013/c1_w1_bl u_t006_013/c1_w1_br
+ u_t006_013/c1_r0_rbl u_t006_013/c1_r1_rbl u_t006_013/c2_w0_bl u_t006_013/c2_w0_br u_t006_013/c2_w1_bl
+ u_t006_013/c2_w1_br u_t006_013/c2_r0_rbl u_t006_013/c2_r1_rbl u_t006_013/c3_w0_bl u_t006_013/c3_w0_br
+ u_t006_013/c3_w1_bl u_t006_013/c3_w1_br u_t006_013/c3_r0_rbl u_t006_013/c3_r1_rbl u_t006_013/r0_w0_wl
+ u_t006_013/r0_w1_wl u_t006_013/r0_r0_rwl u_t006_013/r0_r1_rwl u_t006_013/r1_w0_wl u_t006_013/r1_w1_wl
+ u_t006_013/r1_r0_rwl u_t006_013/r1_r1_rwl u_t006_013/r2_w0_wl u_t006_013/r2_w1_wl u_t006_013/r2_r0_rwl
+ u_t006_013/r2_r1_rwl u_t006_013/r3_w0_wl u_t006_013/r3_w1_wl u_t006_013/r3_r0_rwl u_t006_013/r3_r1_rwl VDD VSS VSUBS
+ detronyx_12t_2w2r_rc4_4x4_routed_5layer_direct
Xu_t021_005 u_t021_005/c0_w0_bl u_t021_005/c0_w0_br u_t021_005/c0_w1_bl u_t021_005/c0_w1_br u_t021_005/c0_r0_rbl
+ u_t021_005/c0_r1_rbl u_t021_005/c1_w0_bl u_t021_005/c1_w0_br u_t021_005/c1_w1_bl u_t021_005/c1_w1_br
+ u_t021_005/c1_r0_rbl u_t021_005/c1_r1_rbl u_t021_005/c2_w0_bl u_t021_005/c2_w0_br u_t021_005/c2_w1_bl
+ u_t021_005/c2_w1_br u_t021_005/c2_r0_rbl u_t021_005/c2_r1_rbl u_t021_005/c3_w0_bl u_t021_005/c3_w0_br
+ u_t021_005/c3_w1_bl u_t021_005/c3_w1_br u_t021_005/c3_r0_rbl u_t021_005/c3_r1_rbl u_t021_005/r0_w0_wl
+ u_t021_005/r0_w1_wl u_t021_005/r0_r0_rwl u_t021_005/r0_r1_rwl u_t021_005/r1_w0_wl u_t021_005/r1_w1_wl
+ u_t021_005/r1_r0_rwl u_t021_005/r1_r1_rwl u_t021_005/r2_w0_wl u_t021_005/r2_w1_wl u_t021_005/r2_r0_rwl
+ u_t021_005/r2_r1_rwl u_t021_005/r3_w0_wl u_t021_005/r3_w1_wl u_t021_005/r3_r0_rwl u_t021_005/r3_r1_rwl VDD VSS VSUBS
+ detronyx_12t_2w2r_rc4_4x4_routed_5layer_direct
Xu_t003_005 u_t003_005/c0_w0_bl u_t003_005/c0_w0_br u_t003_005/c0_w1_bl u_t003_005/c0_w1_br u_t003_005/c0_r0_rbl
+ u_t003_005/c0_r1_rbl u_t003_005/c1_w0_bl u_t003_005/c1_w0_br u_t003_005/c1_w1_bl u_t003_005/c1_w1_br
+ u_t003_005/c1_r0_rbl u_t003_005/c1_r1_rbl u_t003_005/c2_w0_bl u_t003_005/c2_w0_br u_t003_005/c2_w1_bl
+ u_t003_005/c2_w1_br u_t003_005/c2_r0_rbl u_t003_005/c2_r1_rbl u_t003_005/c3_w0_bl u_t003_005/c3_w0_br
+ u_t003_005/c3_w1_bl u_t003_005/c3_w1_br u_t003_005/c3_r0_rbl u_t003_005/c3_r1_rbl u_t003_005/r0_w0_wl
+ u_t003_005/r0_w1_wl u_t003_005/r0_r0_rwl u_t003_005/r0_r1_rwl u_t003_005/r1_w0_wl u_t003_005/r1_w1_wl
+ u_t003_005/r1_r0_rwl u_t003_005/r1_r1_rwl u_t003_005/r2_w0_wl u_t003_005/r2_w1_wl u_t003_005/r2_r0_rwl
+ u_t003_005/r2_r1_rwl u_t003_005/r3_w0_wl u_t003_005/r3_w1_wl u_t003_005/r3_r0_rwl u_t003_005/r3_r1_rwl VDD VSS VSUBS
+ detronyx_12t_2w2r_rc4_4x4_routed_5layer_direct
Xu_t012_005 u_t012_005/c0_w0_bl u_t012_005/c0_w0_br u_t012_005/c0_w1_bl u_t012_005/c0_w1_br u_t012_005/c0_r0_rbl
+ u_t012_005/c0_r1_rbl u_t012_005/c1_w0_bl u_t012_005/c1_w0_br u_t012_005/c1_w1_bl u_t012_005/c1_w1_br
+ u_t012_005/c1_r0_rbl u_t012_005/c1_r1_rbl u_t012_005/c2_w0_bl u_t012_005/c2_w0_br u_t012_005/c2_w1_bl
+ u_t012_005/c2_w1_br u_t012_005/c2_r0_rbl u_t012_005/c2_r1_rbl u_t012_005/c3_w0_bl u_t012_005/c3_w0_br
+ u_t012_005/c3_w1_bl u_t012_005/c3_w1_br u_t012_005/c3_r0_rbl u_t012_005/c3_r1_rbl u_t012_005/r0_w0_wl
+ u_t012_005/r0_w1_wl u_t012_005/r0_r0_rwl u_t012_005/r0_r1_rwl u_t012_005/r1_w0_wl u_t012_005/r1_w1_wl
+ u_t012_005/r1_r0_rwl u_t012_005/r1_r1_rwl u_t012_005/r2_w0_wl u_t012_005/r2_w1_wl u_t012_005/r2_r0_rwl
+ u_t012_005/r2_r1_rwl u_t012_005/r3_w0_wl u_t012_005/r3_w1_wl u_t012_005/r3_r0_rwl u_t012_005/r3_r1_rwl VDD VSS VSUBS
+ detronyx_12t_2w2r_rc4_4x4_routed_5layer_direct
Xu_t000_008 u_t000_008/c0_w0_bl u_t000_008/c0_w0_br u_t000_008/c0_w1_bl u_t000_008/c0_w1_br u_t000_008/c0_r0_rbl
+ u_t000_008/c0_r1_rbl u_t000_008/c1_w0_bl u_t000_008/c1_w0_br u_t000_008/c1_w1_bl u_t000_008/c1_w1_br
+ u_t000_008/c1_r0_rbl u_t000_008/c1_r1_rbl u_t000_008/c2_w0_bl u_t000_008/c2_w0_br u_t000_008/c2_w1_bl
+ u_t000_008/c2_w1_br u_t000_008/c2_r0_rbl u_t000_008/c2_r1_rbl u_t000_008/c3_w0_bl u_t000_008/c3_w0_br
+ u_t000_008/c3_w1_bl u_t000_008/c3_w1_br u_t000_008/c3_r0_rbl u_t000_008/c3_r1_rbl u_t000_008/r0_w0_wl
+ u_t000_008/r0_w1_wl u_t000_008/r0_r0_rwl u_t000_008/r0_r1_rwl u_t000_008/r1_w0_wl u_t000_008/r1_w1_wl
+ u_t000_008/r1_r0_rwl u_t000_008/r1_r1_rwl u_t000_008/r2_w0_wl u_t000_008/r2_w1_wl u_t000_008/r2_r0_rwl
+ u_t000_008/r2_r1_rwl u_t000_008/r3_w0_wl u_t000_008/r3_w1_wl u_t000_008/r3_r0_rwl u_t000_008/r3_r1_rwl VDD VSS VSUBS
+ detronyx_12t_2w2r_rc4_4x4_routed_5layer_direct
Xu_t027_011 u_t027_011/c0_w0_bl u_t027_011/c0_w0_br u_t027_011/c0_w1_bl u_t027_011/c0_w1_br u_t027_011/c0_r0_rbl
+ u_t027_011/c0_r1_rbl u_t027_011/c1_w0_bl u_t027_011/c1_w0_br u_t027_011/c1_w1_bl u_t027_011/c1_w1_br
+ u_t027_011/c1_r0_rbl u_t027_011/c1_r1_rbl u_t027_011/c2_w0_bl u_t027_011/c2_w0_br u_t027_011/c2_w1_bl
+ u_t027_011/c2_w1_br u_t027_011/c2_r0_rbl u_t027_011/c2_r1_rbl u_t027_011/c3_w0_bl u_t027_011/c3_w0_br
+ u_t027_011/c3_w1_bl u_t027_011/c3_w1_br u_t027_011/c3_r0_rbl u_t027_011/c3_r1_rbl u_t027_011/r0_w0_wl
+ u_t027_011/r0_w1_wl u_t027_011/r0_r0_rwl u_t027_011/r0_r1_rwl u_t027_011/r1_w0_wl u_t027_011/r1_w1_wl
+ u_t027_011/r1_r0_rwl u_t027_011/r1_r1_rwl u_t027_011/r2_w0_wl u_t027_011/r2_w1_wl u_t027_011/r2_r0_rwl
+ u_t027_011/r2_r1_rwl u_t027_011/r3_w0_wl u_t027_011/r3_w1_wl u_t027_011/r3_r0_rwl u_t027_011/r3_r1_rwl VDD VSS VSUBS
+ detronyx_12t_2w2r_rc4_4x4_routed_5layer_direct
Xu_t027_000 u_t027_000/c0_w0_bl u_t027_000/c0_w0_br u_t027_000/c0_w1_bl u_t027_000/c0_w1_br u_t027_000/c0_r0_rbl
+ u_t027_000/c0_r1_rbl u_t027_000/c1_w0_bl u_t027_000/c1_w0_br u_t027_000/c1_w1_bl u_t027_000/c1_w1_br
+ u_t027_000/c1_r0_rbl u_t027_000/c1_r1_rbl u_t027_000/c2_w0_bl u_t027_000/c2_w0_br u_t027_000/c2_w1_bl
+ u_t027_000/c2_w1_br u_t027_000/c2_r0_rbl u_t027_000/c2_r1_rbl u_t027_000/c3_w0_bl u_t027_000/c3_w0_br
+ u_t027_000/c3_w1_bl u_t027_000/c3_w1_br u_t027_000/c3_r0_rbl u_t027_000/c3_r1_rbl u_t027_000/r0_w0_wl
+ u_t027_000/r0_w1_wl u_t027_000/r0_r0_rwl u_t027_000/r0_r1_rwl u_t027_000/r1_w0_wl u_t027_000/r1_w1_wl
+ u_t027_000/r1_r0_rwl u_t027_000/r1_r1_rwl u_t027_000/r2_w0_wl u_t027_000/r2_w1_wl u_t027_000/r2_r0_rwl
+ u_t027_000/r2_r1_rwl u_t027_000/r3_w0_wl u_t027_000/r3_w1_wl u_t027_000/r3_r0_rwl u_t027_000/r3_r1_rwl VDD VSS VSUBS
+ detronyx_12t_2w2r_rc4_4x4_routed_5layer_direct
Xu_t018_000 u_t018_000/c0_w0_bl u_t018_000/c0_w0_br u_t018_000/c0_w1_bl u_t018_000/c0_w1_br u_t018_000/c0_r0_rbl
+ u_t018_000/c0_r1_rbl u_t018_000/c1_w0_bl u_t018_000/c1_w0_br u_t018_000/c1_w1_bl u_t018_000/c1_w1_br
+ u_t018_000/c1_r0_rbl u_t018_000/c1_r1_rbl u_t018_000/c2_w0_bl u_t018_000/c2_w0_br u_t018_000/c2_w1_bl
+ u_t018_000/c2_w1_br u_t018_000/c2_r0_rbl u_t018_000/c2_r1_rbl u_t018_000/c3_w0_bl u_t018_000/c3_w0_br
+ u_t018_000/c3_w1_bl u_t018_000/c3_w1_br u_t018_000/c3_r0_rbl u_t018_000/c3_r1_rbl u_t018_000/r0_w0_wl
+ u_t018_000/r0_w1_wl u_t018_000/r0_r0_rwl u_t018_000/r0_r1_rwl u_t018_000/r1_w0_wl u_t018_000/r1_w1_wl
+ u_t018_000/r1_r0_rwl u_t018_000/r1_r1_rwl u_t018_000/r2_w0_wl u_t018_000/r2_w1_wl u_t018_000/r2_r0_rwl
+ u_t018_000/r2_r1_rwl u_t018_000/r3_w0_wl u_t018_000/r3_w1_wl u_t018_000/r3_r0_rwl u_t018_000/r3_r1_rwl VDD VSS VSUBS
+ detronyx_12t_2w2r_rc4_4x4_routed_5layer_direct
Xu_t018_011 u_t018_011/c0_w0_bl u_t018_011/c0_w0_br u_t018_011/c0_w1_bl u_t018_011/c0_w1_br u_t018_011/c0_r0_rbl
+ u_t018_011/c0_r1_rbl u_t018_011/c1_w0_bl u_t018_011/c1_w0_br u_t018_011/c1_w1_bl u_t018_011/c1_w1_br
+ u_t018_011/c1_r0_rbl u_t018_011/c1_r1_rbl u_t018_011/c2_w0_bl u_t018_011/c2_w0_br u_t018_011/c2_w1_bl
+ u_t018_011/c2_w1_br u_t018_011/c2_r0_rbl u_t018_011/c2_r1_rbl u_t018_011/c3_w0_bl u_t018_011/c3_w0_br
+ u_t018_011/c3_w1_bl u_t018_011/c3_w1_br u_t018_011/c3_r0_rbl u_t018_011/c3_r1_rbl u_t018_011/r0_w0_wl
+ u_t018_011/r0_w1_wl u_t018_011/r0_r0_rwl u_t018_011/r0_r1_rwl u_t018_011/r1_w0_wl u_t018_011/r1_w1_wl
+ u_t018_011/r1_r0_rwl u_t018_011/r1_r1_rwl u_t018_011/r2_w0_wl u_t018_011/r2_w1_wl u_t018_011/r2_r0_rwl
+ u_t018_011/r2_r1_rwl u_t018_011/r3_w0_wl u_t018_011/r3_w1_wl u_t018_011/r3_r0_rwl u_t018_011/r3_r1_rwl VDD VSS VSUBS
+ detronyx_12t_2w2r_rc4_4x4_routed_5layer_direct
Xu_t024_014 u_t024_014/c0_w0_bl u_t024_014/c0_w0_br u_t024_014/c0_w1_bl u_t024_014/c0_w1_br u_t024_014/c0_r0_rbl
+ u_t024_014/c0_r1_rbl u_t024_014/c1_w0_bl u_t024_014/c1_w0_br u_t024_014/c1_w1_bl u_t024_014/c1_w1_br
+ u_t024_014/c1_r0_rbl u_t024_014/c1_r1_rbl u_t024_014/c2_w0_bl u_t024_014/c2_w0_br u_t024_014/c2_w1_bl
+ u_t024_014/c2_w1_br u_t024_014/c2_r0_rbl u_t024_014/c2_r1_rbl u_t024_014/c3_w0_bl u_t024_014/c3_w0_br
+ u_t024_014/c3_w1_bl u_t024_014/c3_w1_br u_t024_014/c3_r0_rbl u_t024_014/c3_r1_rbl u_t024_014/r0_w0_wl
+ u_t024_014/r0_w1_wl u_t024_014/r0_r0_rwl u_t024_014/r0_r1_rwl u_t024_014/r1_w0_wl u_t024_014/r1_w1_wl
+ u_t024_014/r1_r0_rwl u_t024_014/r1_r1_rwl u_t024_014/r2_w0_wl u_t024_014/r2_w1_wl u_t024_014/r2_r0_rwl
+ u_t024_014/r2_r1_rwl u_t024_014/r3_w0_wl u_t024_014/r3_w1_wl u_t024_014/r3_r0_rwl u_t024_014/r3_r1_rwl VDD VSS VSUBS
+ detronyx_12t_2w2r_rc4_4x4_routed_5layer_direct
Xu_t024_003 u_t024_003/c0_w0_bl u_t024_003/c0_w0_br u_t024_003/c0_w1_bl u_t024_003/c0_w1_br u_t024_003/c0_r0_rbl
+ u_t024_003/c0_r1_rbl u_t024_003/c1_w0_bl u_t024_003/c1_w0_br u_t024_003/c1_w1_bl u_t024_003/c1_w1_br
+ u_t024_003/c1_r0_rbl u_t024_003/c1_r1_rbl u_t024_003/c2_w0_bl u_t024_003/c2_w0_br u_t024_003/c2_w1_bl
+ u_t024_003/c2_w1_br u_t024_003/c2_r0_rbl u_t024_003/c2_r1_rbl u_t024_003/c3_w0_bl u_t024_003/c3_w0_br
+ u_t024_003/c3_w1_bl u_t024_003/c3_w1_br u_t024_003/c3_r0_rbl u_t024_003/c3_r1_rbl u_t024_003/r0_w0_wl
+ u_t024_003/r0_w1_wl u_t024_003/r0_r0_rwl u_t024_003/r0_r1_rwl u_t024_003/r1_w0_wl u_t024_003/r1_w1_wl
+ u_t024_003/r1_r0_rwl u_t024_003/r1_r1_rwl u_t024_003/r2_w0_wl u_t024_003/r2_w1_wl u_t024_003/r2_r0_rwl
+ u_t024_003/r2_r1_rwl u_t024_003/r3_w0_wl u_t024_003/r3_w1_wl u_t024_003/r3_r0_rwl u_t024_003/r3_r1_rwl VDD VSS VSUBS
+ detronyx_12t_2w2r_rc4_4x4_routed_5layer_direct
Xu_t009_000 u_t009_000/c0_w0_bl u_t009_000/c0_w0_br u_t009_000/c0_w1_bl u_t009_000/c0_w1_br u_t009_000/c0_r0_rbl
+ u_t009_000/c0_r1_rbl u_t009_000/c1_w0_bl u_t009_000/c1_w0_br u_t009_000/c1_w1_bl u_t009_000/c1_w1_br
+ u_t009_000/c1_r0_rbl u_t009_000/c1_r1_rbl u_t009_000/c2_w0_bl u_t009_000/c2_w0_br u_t009_000/c2_w1_bl
+ u_t009_000/c2_w1_br u_t009_000/c2_r0_rbl u_t009_000/c2_r1_rbl u_t009_000/c3_w0_bl u_t009_000/c3_w0_br
+ u_t009_000/c3_w1_bl u_t009_000/c3_w1_br u_t009_000/c3_r0_rbl u_t009_000/c3_r1_rbl u_t009_000/r0_w0_wl
+ u_t009_000/r0_w1_wl u_t009_000/r0_r0_rwl u_t009_000/r0_r1_rwl u_t009_000/r1_w0_wl u_t009_000/r1_w1_wl
+ u_t009_000/r1_r0_rwl u_t009_000/r1_r1_rwl u_t009_000/r2_w0_wl u_t009_000/r2_w1_wl u_t009_000/r2_r0_rwl
+ u_t009_000/r2_r1_rwl u_t009_000/r3_w0_wl u_t009_000/r3_w1_wl u_t009_000/r3_r0_rwl u_t009_000/r3_r1_rwl VDD VSS VSUBS
+ detronyx_12t_2w2r_rc4_4x4_routed_5layer_direct
Xu_t009_011 u_t009_011/c0_w0_bl u_t009_011/c0_w0_br u_t009_011/c0_w1_bl u_t009_011/c0_w1_br u_t009_011/c0_r0_rbl
+ u_t009_011/c0_r1_rbl u_t009_011/c1_w0_bl u_t009_011/c1_w0_br u_t009_011/c1_w1_bl u_t009_011/c1_w1_br
+ u_t009_011/c1_r0_rbl u_t009_011/c1_r1_rbl u_t009_011/c2_w0_bl u_t009_011/c2_w0_br u_t009_011/c2_w1_bl
+ u_t009_011/c2_w1_br u_t009_011/c2_r0_rbl u_t009_011/c2_r1_rbl u_t009_011/c3_w0_bl u_t009_011/c3_w0_br
+ u_t009_011/c3_w1_bl u_t009_011/c3_w1_br u_t009_011/c3_r0_rbl u_t009_011/c3_r1_rbl u_t009_011/r0_w0_wl
+ u_t009_011/r0_w1_wl u_t009_011/r0_r0_rwl u_t009_011/r0_r1_rwl u_t009_011/r1_w0_wl u_t009_011/r1_w1_wl
+ u_t009_011/r1_r0_rwl u_t009_011/r1_r1_rwl u_t009_011/r2_w0_wl u_t009_011/r2_w1_wl u_t009_011/r2_r0_rwl
+ u_t009_011/r2_r1_rwl u_t009_011/r3_w0_wl u_t009_011/r3_w1_wl u_t009_011/r3_r0_rwl u_t009_011/r3_r1_rwl VDD VSS VSUBS
+ detronyx_12t_2w2r_rc4_4x4_routed_5layer_direct
Xu_t030_006 u_t030_006/c0_w0_bl u_t030_006/c0_w0_br u_t030_006/c0_w1_bl u_t030_006/c0_w1_br u_t030_006/c0_r0_rbl
+ u_t030_006/c0_r1_rbl u_t030_006/c1_w0_bl u_t030_006/c1_w0_br u_t030_006/c1_w1_bl u_t030_006/c1_w1_br
+ u_t030_006/c1_r0_rbl u_t030_006/c1_r1_rbl u_t030_006/c2_w0_bl u_t030_006/c2_w0_br u_t030_006/c2_w1_bl
+ u_t030_006/c2_w1_br u_t030_006/c2_r0_rbl u_t030_006/c2_r1_rbl u_t030_006/c3_w0_bl u_t030_006/c3_w0_br
+ u_t030_006/c3_w1_bl u_t030_006/c3_w1_br u_t030_006/c3_r0_rbl u_t030_006/c3_r1_rbl u_t030_006/r0_w0_wl
+ u_t030_006/r0_w1_wl u_t030_006/r0_r0_rwl u_t030_006/r0_r1_rwl u_t030_006/r1_w0_wl u_t030_006/r1_w1_wl
+ u_t030_006/r1_r0_rwl u_t030_006/r1_r1_rwl u_t030_006/r2_w0_wl u_t030_006/r2_w1_wl u_t030_006/r2_r0_rwl
+ u_t030_006/r2_r1_rwl u_t030_006/r3_w0_wl u_t030_006/r3_w1_wl u_t030_006/r3_r0_rwl u_t030_006/r3_r1_rwl VDD VSS VSUBS
+ detronyx_12t_2w2r_rc4_4x4_routed_5layer_direct
Xu_t015_003 u_t015_003/c0_w0_bl u_t015_003/c0_w0_br u_t015_003/c0_w1_bl u_t015_003/c0_w1_br u_t015_003/c0_r0_rbl
+ u_t015_003/c0_r1_rbl u_t015_003/c1_w0_bl u_t015_003/c1_w0_br u_t015_003/c1_w1_bl u_t015_003/c1_w1_br
+ u_t015_003/c1_r0_rbl u_t015_003/c1_r1_rbl u_t015_003/c2_w0_bl u_t015_003/c2_w0_br u_t015_003/c2_w1_bl
+ u_t015_003/c2_w1_br u_t015_003/c2_r0_rbl u_t015_003/c2_r1_rbl u_t015_003/c3_w0_bl u_t015_003/c3_w0_br
+ u_t015_003/c3_w1_bl u_t015_003/c3_w1_br u_t015_003/c3_r0_rbl u_t015_003/c3_r1_rbl u_t015_003/r0_w0_wl
+ u_t015_003/r0_w1_wl u_t015_003/r0_r0_rwl u_t015_003/r0_r1_rwl u_t015_003/r1_w0_wl u_t015_003/r1_w1_wl
+ u_t015_003/r1_r0_rwl u_t015_003/r1_r1_rwl u_t015_003/r2_w0_wl u_t015_003/r2_w1_wl u_t015_003/r2_r0_rwl
+ u_t015_003/r2_r1_rwl u_t015_003/r3_w0_wl u_t015_003/r3_w1_wl u_t015_003/r3_r0_rwl u_t015_003/r3_r1_rwl VDD VSS VSUBS
+ detronyx_12t_2w2r_rc4_4x4_routed_5layer_direct
Xu_t015_014 u_t015_014/c0_w0_bl u_t015_014/c0_w0_br u_t015_014/c0_w1_bl u_t015_014/c0_w1_br u_t015_014/c0_r0_rbl
+ u_t015_014/c0_r1_rbl u_t015_014/c1_w0_bl u_t015_014/c1_w0_br u_t015_014/c1_w1_bl u_t015_014/c1_w1_br
+ u_t015_014/c1_r0_rbl u_t015_014/c1_r1_rbl u_t015_014/c2_w0_bl u_t015_014/c2_w0_br u_t015_014/c2_w1_bl
+ u_t015_014/c2_w1_br u_t015_014/c2_r0_rbl u_t015_014/c2_r1_rbl u_t015_014/c3_w0_bl u_t015_014/c3_w0_br
+ u_t015_014/c3_w1_bl u_t015_014/c3_w1_br u_t015_014/c3_r0_rbl u_t015_014/c3_r1_rbl u_t015_014/r0_w0_wl
+ u_t015_014/r0_w1_wl u_t015_014/r0_r0_rwl u_t015_014/r0_r1_rwl u_t015_014/r1_w0_wl u_t015_014/r1_w1_wl
+ u_t015_014/r1_r0_rwl u_t015_014/r1_r1_rwl u_t015_014/r2_w0_wl u_t015_014/r2_w1_wl u_t015_014/r2_r0_rwl
+ u_t015_014/r2_r1_rwl u_t015_014/r3_w0_wl u_t015_014/r3_w1_wl u_t015_014/r3_r0_rwl u_t015_014/r3_r1_rwl VDD VSS VSUBS
+ detronyx_12t_2w2r_rc4_4x4_routed_5layer_direct
Xu_t006_003 u_t006_003/c0_w0_bl u_t006_003/c0_w0_br u_t006_003/c0_w1_bl u_t006_003/c0_w1_br u_t006_003/c0_r0_rbl
+ u_t006_003/c0_r1_rbl u_t006_003/c1_w0_bl u_t006_003/c1_w0_br u_t006_003/c1_w1_bl u_t006_003/c1_w1_br
+ u_t006_003/c1_r0_rbl u_t006_003/c1_r1_rbl u_t006_003/c2_w0_bl u_t006_003/c2_w0_br u_t006_003/c2_w1_bl
+ u_t006_003/c2_w1_br u_t006_003/c2_r0_rbl u_t006_003/c2_r1_rbl u_t006_003/c3_w0_bl u_t006_003/c3_w0_br
+ u_t006_003/c3_w1_bl u_t006_003/c3_w1_br u_t006_003/c3_r0_rbl u_t006_003/c3_r1_rbl u_t006_003/r0_w0_wl
+ u_t006_003/r0_w1_wl u_t006_003/r0_r0_rwl u_t006_003/r0_r1_rwl u_t006_003/r1_w0_wl u_t006_003/r1_w1_wl
+ u_t006_003/r1_r0_rwl u_t006_003/r1_r1_rwl u_t006_003/r2_w0_wl u_t006_003/r2_w1_wl u_t006_003/r2_r0_rwl
+ u_t006_003/r2_r1_rwl u_t006_003/r3_w0_wl u_t006_003/r3_w1_wl u_t006_003/r3_r0_rwl u_t006_003/r3_r1_rwl VDD VSS VSUBS
+ detronyx_12t_2w2r_rc4_4x4_routed_5layer_direct
Xu_t006_014 u_t006_014/c0_w0_bl u_t006_014/c0_w0_br u_t006_014/c0_w1_bl u_t006_014/c0_w1_br u_t006_014/c0_r0_rbl
+ u_t006_014/c0_r1_rbl u_t006_014/c1_w0_bl u_t006_014/c1_w0_br u_t006_014/c1_w1_bl u_t006_014/c1_w1_br
+ u_t006_014/c1_r0_rbl u_t006_014/c1_r1_rbl u_t006_014/c2_w0_bl u_t006_014/c2_w0_br u_t006_014/c2_w1_bl
+ u_t006_014/c2_w1_br u_t006_014/c2_r0_rbl u_t006_014/c2_r1_rbl u_t006_014/c3_w0_bl u_t006_014/c3_w0_br
+ u_t006_014/c3_w1_bl u_t006_014/c3_w1_br u_t006_014/c3_r0_rbl u_t006_014/c3_r1_rbl u_t006_014/r0_w0_wl
+ u_t006_014/r0_w1_wl u_t006_014/r0_r0_rwl u_t006_014/r0_r1_rwl u_t006_014/r1_w0_wl u_t006_014/r1_w1_wl
+ u_t006_014/r1_r0_rwl u_t006_014/r1_r1_rwl u_t006_014/r2_w0_wl u_t006_014/r2_w1_wl u_t006_014/r2_r0_rwl
+ u_t006_014/r2_r1_rwl u_t006_014/r3_w0_wl u_t006_014/r3_w1_wl u_t006_014/r3_r0_rwl u_t006_014/r3_r1_rwl VDD VSS VSUBS
+ detronyx_12t_2w2r_rc4_4x4_routed_5layer_direct
Xu_t021_006 u_t021_006/c0_w0_bl u_t021_006/c0_w0_br u_t021_006/c0_w1_bl u_t021_006/c0_w1_br u_t021_006/c0_r0_rbl
+ u_t021_006/c0_r1_rbl u_t021_006/c1_w0_bl u_t021_006/c1_w0_br u_t021_006/c1_w1_bl u_t021_006/c1_w1_br
+ u_t021_006/c1_r0_rbl u_t021_006/c1_r1_rbl u_t021_006/c2_w0_bl u_t021_006/c2_w0_br u_t021_006/c2_w1_bl
+ u_t021_006/c2_w1_br u_t021_006/c2_r0_rbl u_t021_006/c2_r1_rbl u_t021_006/c3_w0_bl u_t021_006/c3_w0_br
+ u_t021_006/c3_w1_bl u_t021_006/c3_w1_br u_t021_006/c3_r0_rbl u_t021_006/c3_r1_rbl u_t021_006/r0_w0_wl
+ u_t021_006/r0_w1_wl u_t021_006/r0_r0_rwl u_t021_006/r0_r1_rwl u_t021_006/r1_w0_wl u_t021_006/r1_w1_wl
+ u_t021_006/r1_r0_rwl u_t021_006/r1_r1_rwl u_t021_006/r2_w0_wl u_t021_006/r2_w1_wl u_t021_006/r2_r0_rwl
+ u_t021_006/r2_r1_rwl u_t021_006/r3_w0_wl u_t021_006/r3_w1_wl u_t021_006/r3_r0_rwl u_t021_006/r3_r1_rwl VDD VSS VSUBS
+ detronyx_12t_2w2r_rc4_4x4_routed_5layer_direct
Xu_t012_006 u_t012_006/c0_w0_bl u_t012_006/c0_w0_br u_t012_006/c0_w1_bl u_t012_006/c0_w1_br u_t012_006/c0_r0_rbl
+ u_t012_006/c0_r1_rbl u_t012_006/c1_w0_bl u_t012_006/c1_w0_br u_t012_006/c1_w1_bl u_t012_006/c1_w1_br
+ u_t012_006/c1_r0_rbl u_t012_006/c1_r1_rbl u_t012_006/c2_w0_bl u_t012_006/c2_w0_br u_t012_006/c2_w1_bl
+ u_t012_006/c2_w1_br u_t012_006/c2_r0_rbl u_t012_006/c2_r1_rbl u_t012_006/c3_w0_bl u_t012_006/c3_w0_br
+ u_t012_006/c3_w1_bl u_t012_006/c3_w1_br u_t012_006/c3_r0_rbl u_t012_006/c3_r1_rbl u_t012_006/r0_w0_wl
+ u_t012_006/r0_w1_wl u_t012_006/r0_r0_rwl u_t012_006/r0_r1_rwl u_t012_006/r1_w0_wl u_t012_006/r1_w1_wl
+ u_t012_006/r1_r0_rwl u_t012_006/r1_r1_rwl u_t012_006/r2_w0_wl u_t012_006/r2_w1_wl u_t012_006/r2_r0_rwl
+ u_t012_006/r2_r1_rwl u_t012_006/r3_w0_wl u_t012_006/r3_w1_wl u_t012_006/r3_r0_rwl u_t012_006/r3_r1_rwl VDD VSS VSUBS
+ detronyx_12t_2w2r_rc4_4x4_routed_5layer_direct
Xu_t003_006 u_t003_006/c0_w0_bl u_t003_006/c0_w0_br u_t003_006/c0_w1_bl u_t003_006/c0_w1_br u_t003_006/c0_r0_rbl
+ u_t003_006/c0_r1_rbl u_t003_006/c1_w0_bl u_t003_006/c1_w0_br u_t003_006/c1_w1_bl u_t003_006/c1_w1_br
+ u_t003_006/c1_r0_rbl u_t003_006/c1_r1_rbl u_t003_006/c2_w0_bl u_t003_006/c2_w0_br u_t003_006/c2_w1_bl
+ u_t003_006/c2_w1_br u_t003_006/c2_r0_rbl u_t003_006/c2_r1_rbl u_t003_006/c3_w0_bl u_t003_006/c3_w0_br
+ u_t003_006/c3_w1_bl u_t003_006/c3_w1_br u_t003_006/c3_r0_rbl u_t003_006/c3_r1_rbl u_t003_006/r0_w0_wl
+ u_t003_006/r0_w1_wl u_t003_006/r0_r0_rwl u_t003_006/r0_r1_rwl u_t003_006/r1_w0_wl u_t003_006/r1_w1_wl
+ u_t003_006/r1_r0_rwl u_t003_006/r1_r1_rwl u_t003_006/r2_w0_wl u_t003_006/r2_w1_wl u_t003_006/r2_r0_rwl
+ u_t003_006/r2_r1_rwl u_t003_006/r3_w0_wl u_t003_006/r3_w1_wl u_t003_006/r3_r0_rwl u_t003_006/r3_r1_rwl VDD VSS VSUBS
+ detronyx_12t_2w2r_rc4_4x4_routed_5layer_direct
Xu_t000_009 u_t000_009/c0_w0_bl u_t000_009/c0_w0_br u_t000_009/c0_w1_bl u_t000_009/c0_w1_br u_t000_009/c0_r0_rbl
+ u_t000_009/c0_r1_rbl u_t000_009/c1_w0_bl u_t000_009/c1_w0_br u_t000_009/c1_w1_bl u_t000_009/c1_w1_br
+ u_t000_009/c1_r0_rbl u_t000_009/c1_r1_rbl u_t000_009/c2_w0_bl u_t000_009/c2_w0_br u_t000_009/c2_w1_bl
+ u_t000_009/c2_w1_br u_t000_009/c2_r0_rbl u_t000_009/c2_r1_rbl u_t000_009/c3_w0_bl u_t000_009/c3_w0_br
+ u_t000_009/c3_w1_bl u_t000_009/c3_w1_br u_t000_009/c3_r0_rbl u_t000_009/c3_r1_rbl u_t000_009/r0_w0_wl
+ u_t000_009/r0_w1_wl u_t000_009/r0_r0_rwl u_t000_009/r0_r1_rwl u_t000_009/r1_w0_wl u_t000_009/r1_w1_wl
+ u_t000_009/r1_r0_rwl u_t000_009/r1_r1_rwl u_t000_009/r2_w0_wl u_t000_009/r2_w1_wl u_t000_009/r2_r0_rwl
+ u_t000_009/r2_r1_rwl u_t000_009/r3_w0_wl u_t000_009/r3_w1_wl u_t000_009/r3_r0_rwl u_t000_009/r3_r1_rwl VDD VSS VSUBS
+ detronyx_12t_2w2r_rc4_4x4_routed_5layer_direct
Xu_t027_012 u_t027_012/c0_w0_bl u_t027_012/c0_w0_br u_t027_012/c0_w1_bl u_t027_012/c0_w1_br u_t027_012/c0_r0_rbl
+ u_t027_012/c0_r1_rbl u_t027_012/c1_w0_bl u_t027_012/c1_w0_br u_t027_012/c1_w1_bl u_t027_012/c1_w1_br
+ u_t027_012/c1_r0_rbl u_t027_012/c1_r1_rbl u_t027_012/c2_w0_bl u_t027_012/c2_w0_br u_t027_012/c2_w1_bl
+ u_t027_012/c2_w1_br u_t027_012/c2_r0_rbl u_t027_012/c2_r1_rbl u_t027_012/c3_w0_bl u_t027_012/c3_w0_br
+ u_t027_012/c3_w1_bl u_t027_012/c3_w1_br u_t027_012/c3_r0_rbl u_t027_012/c3_r1_rbl u_t027_012/r0_w0_wl
+ u_t027_012/r0_w1_wl u_t027_012/r0_r0_rwl u_t027_012/r0_r1_rwl u_t027_012/r1_w0_wl u_t027_012/r1_w1_wl
+ u_t027_012/r1_r0_rwl u_t027_012/r1_r1_rwl u_t027_012/r2_w0_wl u_t027_012/r2_w1_wl u_t027_012/r2_r0_rwl
+ u_t027_012/r2_r1_rwl u_t027_012/r3_w0_wl u_t027_012/r3_w1_wl u_t027_012/r3_r0_rwl u_t027_012/r3_r1_rwl VDD VSS VSUBS
+ detronyx_12t_2w2r_rc4_4x4_routed_5layer_direct
Xu_t027_001 u_t027_001/c0_w0_bl u_t027_001/c0_w0_br u_t027_001/c0_w1_bl u_t027_001/c0_w1_br u_t027_001/c0_r0_rbl
+ u_t027_001/c0_r1_rbl u_t027_001/c1_w0_bl u_t027_001/c1_w0_br u_t027_001/c1_w1_bl u_t027_001/c1_w1_br
+ u_t027_001/c1_r0_rbl u_t027_001/c1_r1_rbl u_t027_001/c2_w0_bl u_t027_001/c2_w0_br u_t027_001/c2_w1_bl
+ u_t027_001/c2_w1_br u_t027_001/c2_r0_rbl u_t027_001/c2_r1_rbl u_t027_001/c3_w0_bl u_t027_001/c3_w0_br
+ u_t027_001/c3_w1_bl u_t027_001/c3_w1_br u_t027_001/c3_r0_rbl u_t027_001/c3_r1_rbl u_t027_001/r0_w0_wl
+ u_t027_001/r0_w1_wl u_t027_001/r0_r0_rwl u_t027_001/r0_r1_rwl u_t027_001/r1_w0_wl u_t027_001/r1_w1_wl
+ u_t027_001/r1_r0_rwl u_t027_001/r1_r1_rwl u_t027_001/r2_w0_wl u_t027_001/r2_w1_wl u_t027_001/r2_r0_rwl
+ u_t027_001/r2_r1_rwl u_t027_001/r3_w0_wl u_t027_001/r3_w1_wl u_t027_001/r3_r0_rwl u_t027_001/r3_r1_rwl VDD VSS VSUBS
+ detronyx_12t_2w2r_rc4_4x4_routed_5layer_direct
Xu_t018_001 u_t018_001/c0_w0_bl u_t018_001/c0_w0_br u_t018_001/c0_w1_bl u_t018_001/c0_w1_br u_t018_001/c0_r0_rbl
+ u_t018_001/c0_r1_rbl u_t018_001/c1_w0_bl u_t018_001/c1_w0_br u_t018_001/c1_w1_bl u_t018_001/c1_w1_br
+ u_t018_001/c1_r0_rbl u_t018_001/c1_r1_rbl u_t018_001/c2_w0_bl u_t018_001/c2_w0_br u_t018_001/c2_w1_bl
+ u_t018_001/c2_w1_br u_t018_001/c2_r0_rbl u_t018_001/c2_r1_rbl u_t018_001/c3_w0_bl u_t018_001/c3_w0_br
+ u_t018_001/c3_w1_bl u_t018_001/c3_w1_br u_t018_001/c3_r0_rbl u_t018_001/c3_r1_rbl u_t018_001/r0_w0_wl
+ u_t018_001/r0_w1_wl u_t018_001/r0_r0_rwl u_t018_001/r0_r1_rwl u_t018_001/r1_w0_wl u_t018_001/r1_w1_wl
+ u_t018_001/r1_r0_rwl u_t018_001/r1_r1_rwl u_t018_001/r2_w0_wl u_t018_001/r2_w1_wl u_t018_001/r2_r0_rwl
+ u_t018_001/r2_r1_rwl u_t018_001/r3_w0_wl u_t018_001/r3_w1_wl u_t018_001/r3_r0_rwl u_t018_001/r3_r1_rwl VDD VSS VSUBS
+ detronyx_12t_2w2r_rc4_4x4_routed_5layer_direct
Xu_t018_012 u_t018_012/c0_w0_bl u_t018_012/c0_w0_br u_t018_012/c0_w1_bl u_t018_012/c0_w1_br u_t018_012/c0_r0_rbl
+ u_t018_012/c0_r1_rbl u_t018_012/c1_w0_bl u_t018_012/c1_w0_br u_t018_012/c1_w1_bl u_t018_012/c1_w1_br
+ u_t018_012/c1_r0_rbl u_t018_012/c1_r1_rbl u_t018_012/c2_w0_bl u_t018_012/c2_w0_br u_t018_012/c2_w1_bl
+ u_t018_012/c2_w1_br u_t018_012/c2_r0_rbl u_t018_012/c2_r1_rbl u_t018_012/c3_w0_bl u_t018_012/c3_w0_br
+ u_t018_012/c3_w1_bl u_t018_012/c3_w1_br u_t018_012/c3_r0_rbl u_t018_012/c3_r1_rbl u_t018_012/r0_w0_wl
+ u_t018_012/r0_w1_wl u_t018_012/r0_r0_rwl u_t018_012/r0_r1_rwl u_t018_012/r1_w0_wl u_t018_012/r1_w1_wl
+ u_t018_012/r1_r0_rwl u_t018_012/r1_r1_rwl u_t018_012/r2_w0_wl u_t018_012/r2_w1_wl u_t018_012/r2_r0_rwl
+ u_t018_012/r2_r1_rwl u_t018_012/r3_w0_wl u_t018_012/r3_w1_wl u_t018_012/r3_r0_rwl u_t018_012/r3_r1_rwl VDD VSS VSUBS
+ detronyx_12t_2w2r_rc4_4x4_routed_5layer_direct
Xu_t024_015 u_t024_015/c0_w0_bl u_t024_015/c0_w0_br u_t024_015/c0_w1_bl u_t024_015/c0_w1_br u_t024_015/c0_r0_rbl
+ u_t024_015/c0_r1_rbl u_t024_015/c1_w0_bl u_t024_015/c1_w0_br u_t024_015/c1_w1_bl u_t024_015/c1_w1_br
+ u_t024_015/c1_r0_rbl u_t024_015/c1_r1_rbl u_t024_015/c2_w0_bl u_t024_015/c2_w0_br u_t024_015/c2_w1_bl
+ u_t024_015/c2_w1_br u_t024_015/c2_r0_rbl u_t024_015/c2_r1_rbl u_t024_015/c3_w0_bl u_t024_015/c3_w0_br
+ u_t024_015/c3_w1_bl u_t024_015/c3_w1_br u_t024_015/c3_r0_rbl u_t024_015/c3_r1_rbl u_t024_015/r0_w0_wl
+ u_t024_015/r0_w1_wl u_t024_015/r0_r0_rwl u_t024_015/r0_r1_rwl u_t024_015/r1_w0_wl u_t024_015/r1_w1_wl
+ u_t024_015/r1_r0_rwl u_t024_015/r1_r1_rwl u_t024_015/r2_w0_wl u_t024_015/r2_w1_wl u_t024_015/r2_r0_rwl
+ u_t024_015/r2_r1_rwl u_t024_015/r3_w0_wl u_t024_015/r3_w1_wl u_t024_015/r3_r0_rwl u_t024_015/r3_r1_rwl VDD VSS VSUBS
+ detronyx_12t_2w2r_rc4_4x4_routed_5layer_direct
Xu_t024_004 u_t024_004/c0_w0_bl u_t024_004/c0_w0_br u_t024_004/c0_w1_bl u_t024_004/c0_w1_br u_t024_004/c0_r0_rbl
+ u_t024_004/c0_r1_rbl u_t024_004/c1_w0_bl u_t024_004/c1_w0_br u_t024_004/c1_w1_bl u_t024_004/c1_w1_br
+ u_t024_004/c1_r0_rbl u_t024_004/c1_r1_rbl u_t024_004/c2_w0_bl u_t024_004/c2_w0_br u_t024_004/c2_w1_bl
+ u_t024_004/c2_w1_br u_t024_004/c2_r0_rbl u_t024_004/c2_r1_rbl u_t024_004/c3_w0_bl u_t024_004/c3_w0_br
+ u_t024_004/c3_w1_bl u_t024_004/c3_w1_br u_t024_004/c3_r0_rbl u_t024_004/c3_r1_rbl u_t024_004/r0_w0_wl
+ u_t024_004/r0_w1_wl u_t024_004/r0_r0_rwl u_t024_004/r0_r1_rwl u_t024_004/r1_w0_wl u_t024_004/r1_w1_wl
+ u_t024_004/r1_r0_rwl u_t024_004/r1_r1_rwl u_t024_004/r2_w0_wl u_t024_004/r2_w1_wl u_t024_004/r2_r0_rwl
+ u_t024_004/r2_r1_rwl u_t024_004/r3_w0_wl u_t024_004/r3_w1_wl u_t024_004/r3_r0_rwl u_t024_004/r3_r1_rwl VDD VSS VSUBS
+ detronyx_12t_2w2r_rc4_4x4_routed_5layer_direct
Xu_t009_001 u_t009_001/c0_w0_bl u_t009_001/c0_w0_br u_t009_001/c0_w1_bl u_t009_001/c0_w1_br u_t009_001/c0_r0_rbl
+ u_t009_001/c0_r1_rbl u_t009_001/c1_w0_bl u_t009_001/c1_w0_br u_t009_001/c1_w1_bl u_t009_001/c1_w1_br
+ u_t009_001/c1_r0_rbl u_t009_001/c1_r1_rbl u_t009_001/c2_w0_bl u_t009_001/c2_w0_br u_t009_001/c2_w1_bl
+ u_t009_001/c2_w1_br u_t009_001/c2_r0_rbl u_t009_001/c2_r1_rbl u_t009_001/c3_w0_bl u_t009_001/c3_w0_br
+ u_t009_001/c3_w1_bl u_t009_001/c3_w1_br u_t009_001/c3_r0_rbl u_t009_001/c3_r1_rbl u_t009_001/r0_w0_wl
+ u_t009_001/r0_w1_wl u_t009_001/r0_r0_rwl u_t009_001/r0_r1_rwl u_t009_001/r1_w0_wl u_t009_001/r1_w1_wl
+ u_t009_001/r1_r0_rwl u_t009_001/r1_r1_rwl u_t009_001/r2_w0_wl u_t009_001/r2_w1_wl u_t009_001/r2_r0_rwl
+ u_t009_001/r2_r1_rwl u_t009_001/r3_w0_wl u_t009_001/r3_w1_wl u_t009_001/r3_r0_rwl u_t009_001/r3_r1_rwl VDD VSS VSUBS
+ detronyx_12t_2w2r_rc4_4x4_routed_5layer_direct
Xu_t009_012 u_t009_012/c0_w0_bl u_t009_012/c0_w0_br u_t009_012/c0_w1_bl u_t009_012/c0_w1_br u_t009_012/c0_r0_rbl
+ u_t009_012/c0_r1_rbl u_t009_012/c1_w0_bl u_t009_012/c1_w0_br u_t009_012/c1_w1_bl u_t009_012/c1_w1_br
+ u_t009_012/c1_r0_rbl u_t009_012/c1_r1_rbl u_t009_012/c2_w0_bl u_t009_012/c2_w0_br u_t009_012/c2_w1_bl
+ u_t009_012/c2_w1_br u_t009_012/c2_r0_rbl u_t009_012/c2_r1_rbl u_t009_012/c3_w0_bl u_t009_012/c3_w0_br
+ u_t009_012/c3_w1_bl u_t009_012/c3_w1_br u_t009_012/c3_r0_rbl u_t009_012/c3_r1_rbl u_t009_012/r0_w0_wl
+ u_t009_012/r0_w1_wl u_t009_012/r0_r0_rwl u_t009_012/r0_r1_rwl u_t009_012/r1_w0_wl u_t009_012/r1_w1_wl
+ u_t009_012/r1_r0_rwl u_t009_012/r1_r1_rwl u_t009_012/r2_w0_wl u_t009_012/r2_w1_wl u_t009_012/r2_r0_rwl
+ u_t009_012/r2_r1_rwl u_t009_012/r3_w0_wl u_t009_012/r3_w1_wl u_t009_012/r3_r0_rwl u_t009_012/r3_r1_rwl VDD VSS VSUBS
+ detronyx_12t_2w2r_rc4_4x4_routed_5layer_direct
Xu_t030_007 u_t030_007/c0_w0_bl u_t030_007/c0_w0_br u_t030_007/c0_w1_bl u_t030_007/c0_w1_br u_t030_007/c0_r0_rbl
+ u_t030_007/c0_r1_rbl u_t030_007/c1_w0_bl u_t030_007/c1_w0_br u_t030_007/c1_w1_bl u_t030_007/c1_w1_br
+ u_t030_007/c1_r0_rbl u_t030_007/c1_r1_rbl u_t030_007/c2_w0_bl u_t030_007/c2_w0_br u_t030_007/c2_w1_bl
+ u_t030_007/c2_w1_br u_t030_007/c2_r0_rbl u_t030_007/c2_r1_rbl u_t030_007/c3_w0_bl u_t030_007/c3_w0_br
+ u_t030_007/c3_w1_bl u_t030_007/c3_w1_br u_t030_007/c3_r0_rbl u_t030_007/c3_r1_rbl u_t030_007/r0_w0_wl
+ u_t030_007/r0_w1_wl u_t030_007/r0_r0_rwl u_t030_007/r0_r1_rwl u_t030_007/r1_w0_wl u_t030_007/r1_w1_wl
+ u_t030_007/r1_r0_rwl u_t030_007/r1_r1_rwl u_t030_007/r2_w0_wl u_t030_007/r2_w1_wl u_t030_007/r2_r0_rwl
+ u_t030_007/r2_r1_rwl u_t030_007/r3_w0_wl u_t030_007/r3_w1_wl u_t030_007/r3_r0_rwl u_t030_007/r3_r1_rwl VDD VSS VSUBS
+ detronyx_12t_2w2r_rc4_4x4_routed_5layer_direct
Xu_t015_004 u_t015_004/c0_w0_bl u_t015_004/c0_w0_br u_t015_004/c0_w1_bl u_t015_004/c0_w1_br u_t015_004/c0_r0_rbl
+ u_t015_004/c0_r1_rbl u_t015_004/c1_w0_bl u_t015_004/c1_w0_br u_t015_004/c1_w1_bl u_t015_004/c1_w1_br
+ u_t015_004/c1_r0_rbl u_t015_004/c1_r1_rbl u_t015_004/c2_w0_bl u_t015_004/c2_w0_br u_t015_004/c2_w1_bl
+ u_t015_004/c2_w1_br u_t015_004/c2_r0_rbl u_t015_004/c2_r1_rbl u_t015_004/c3_w0_bl u_t015_004/c3_w0_br
+ u_t015_004/c3_w1_bl u_t015_004/c3_w1_br u_t015_004/c3_r0_rbl u_t015_004/c3_r1_rbl u_t015_004/r0_w0_wl
+ u_t015_004/r0_w1_wl u_t015_004/r0_r0_rwl u_t015_004/r0_r1_rwl u_t015_004/r1_w0_wl u_t015_004/r1_w1_wl
+ u_t015_004/r1_r0_rwl u_t015_004/r1_r1_rwl u_t015_004/r2_w0_wl u_t015_004/r2_w1_wl u_t015_004/r2_r0_rwl
+ u_t015_004/r2_r1_rwl u_t015_004/r3_w0_wl u_t015_004/r3_w1_wl u_t015_004/r3_r0_rwl u_t015_004/r3_r1_rwl VDD VSS VSUBS
+ detronyx_12t_2w2r_rc4_4x4_routed_5layer_direct
Xu_t015_015 u_t015_015/c0_w0_bl u_t015_015/c0_w0_br u_t015_015/c0_w1_bl u_t015_015/c0_w1_br u_t015_015/c0_r0_rbl
+ u_t015_015/c0_r1_rbl u_t015_015/c1_w0_bl u_t015_015/c1_w0_br u_t015_015/c1_w1_bl u_t015_015/c1_w1_br
+ u_t015_015/c1_r0_rbl u_t015_015/c1_r1_rbl u_t015_015/c2_w0_bl u_t015_015/c2_w0_br u_t015_015/c2_w1_bl
+ u_t015_015/c2_w1_br u_t015_015/c2_r0_rbl u_t015_015/c2_r1_rbl u_t015_015/c3_w0_bl u_t015_015/c3_w0_br
+ u_t015_015/c3_w1_bl u_t015_015/c3_w1_br u_t015_015/c3_r0_rbl u_t015_015/c3_r1_rbl u_t015_015/r0_w0_wl
+ u_t015_015/r0_w1_wl u_t015_015/r0_r0_rwl u_t015_015/r0_r1_rwl u_t015_015/r1_w0_wl u_t015_015/r1_w1_wl
+ u_t015_015/r1_r0_rwl u_t015_015/r1_r1_rwl u_t015_015/r2_w0_wl u_t015_015/r2_w1_wl u_t015_015/r2_r0_rwl
+ u_t015_015/r2_r1_rwl u_t015_015/r3_w0_wl u_t015_015/r3_w1_wl u_t015_015/r3_r0_rwl u_t015_015/r3_r1_rwl VDD VSS VSUBS
+ detronyx_12t_2w2r_rc4_4x4_routed_5layer_direct
Xu_t006_004 u_t006_004/c0_w0_bl u_t006_004/c0_w0_br u_t006_004/c0_w1_bl u_t006_004/c0_w1_br u_t006_004/c0_r0_rbl
+ u_t006_004/c0_r1_rbl u_t006_004/c1_w0_bl u_t006_004/c1_w0_br u_t006_004/c1_w1_bl u_t006_004/c1_w1_br
+ u_t006_004/c1_r0_rbl u_t006_004/c1_r1_rbl u_t006_004/c2_w0_bl u_t006_004/c2_w0_br u_t006_004/c2_w1_bl
+ u_t006_004/c2_w1_br u_t006_004/c2_r0_rbl u_t006_004/c2_r1_rbl u_t006_004/c3_w0_bl u_t006_004/c3_w0_br
+ u_t006_004/c3_w1_bl u_t006_004/c3_w1_br u_t006_004/c3_r0_rbl u_t006_004/c3_r1_rbl u_t006_004/r0_w0_wl
+ u_t006_004/r0_w1_wl u_t006_004/r0_r0_rwl u_t006_004/r0_r1_rwl u_t006_004/r1_w0_wl u_t006_004/r1_w1_wl
+ u_t006_004/r1_r0_rwl u_t006_004/r1_r1_rwl u_t006_004/r2_w0_wl u_t006_004/r2_w1_wl u_t006_004/r2_r0_rwl
+ u_t006_004/r2_r1_rwl u_t006_004/r3_w0_wl u_t006_004/r3_w1_wl u_t006_004/r3_r0_rwl u_t006_004/r3_r1_rwl VDD VSS VSUBS
+ detronyx_12t_2w2r_rc4_4x4_routed_5layer_direct
Xu_t006_015 u_t006_015/c0_w0_bl u_t006_015/c0_w0_br u_t006_015/c0_w1_bl u_t006_015/c0_w1_br u_t006_015/c0_r0_rbl
+ u_t006_015/c0_r1_rbl u_t006_015/c1_w0_bl u_t006_015/c1_w0_br u_t006_015/c1_w1_bl u_t006_015/c1_w1_br
+ u_t006_015/c1_r0_rbl u_t006_015/c1_r1_rbl u_t006_015/c2_w0_bl u_t006_015/c2_w0_br u_t006_015/c2_w1_bl
+ u_t006_015/c2_w1_br u_t006_015/c2_r0_rbl u_t006_015/c2_r1_rbl u_t006_015/c3_w0_bl u_t006_015/c3_w0_br
+ u_t006_015/c3_w1_bl u_t006_015/c3_w1_br u_t006_015/c3_r0_rbl u_t006_015/c3_r1_rbl u_t006_015/r0_w0_wl
+ u_t006_015/r0_w1_wl u_t006_015/r0_r0_rwl u_t006_015/r0_r1_rwl u_t006_015/r1_w0_wl u_t006_015/r1_w1_wl
+ u_t006_015/r1_r0_rwl u_t006_015/r1_r1_rwl u_t006_015/r2_w0_wl u_t006_015/r2_w1_wl u_t006_015/r2_r0_rwl
+ u_t006_015/r2_r1_rwl u_t006_015/r3_w0_wl u_t006_015/r3_w1_wl u_t006_015/r3_r0_rwl u_t006_015/r3_r1_rwl VDD VSS VSUBS
+ detronyx_12t_2w2r_rc4_4x4_routed_5layer_direct
Xu_t021_007 u_t021_007/c0_w0_bl u_t021_007/c0_w0_br u_t021_007/c0_w1_bl u_t021_007/c0_w1_br u_t021_007/c0_r0_rbl
+ u_t021_007/c0_r1_rbl u_t021_007/c1_w0_bl u_t021_007/c1_w0_br u_t021_007/c1_w1_bl u_t021_007/c1_w1_br
+ u_t021_007/c1_r0_rbl u_t021_007/c1_r1_rbl u_t021_007/c2_w0_bl u_t021_007/c2_w0_br u_t021_007/c2_w1_bl
+ u_t021_007/c2_w1_br u_t021_007/c2_r0_rbl u_t021_007/c2_r1_rbl u_t021_007/c3_w0_bl u_t021_007/c3_w0_br
+ u_t021_007/c3_w1_bl u_t021_007/c3_w1_br u_t021_007/c3_r0_rbl u_t021_007/c3_r1_rbl u_t021_007/r0_w0_wl
+ u_t021_007/r0_w1_wl u_t021_007/r0_r0_rwl u_t021_007/r0_r1_rwl u_t021_007/r1_w0_wl u_t021_007/r1_w1_wl
+ u_t021_007/r1_r0_rwl u_t021_007/r1_r1_rwl u_t021_007/r2_w0_wl u_t021_007/r2_w1_wl u_t021_007/r2_r0_rwl
+ u_t021_007/r2_r1_rwl u_t021_007/r3_w0_wl u_t021_007/r3_w1_wl u_t021_007/r3_r0_rwl u_t021_007/r3_r1_rwl VDD VSS VSUBS
+ detronyx_12t_2w2r_rc4_4x4_routed_5layer_direct
Xu_t012_007 u_t012_007/c0_w0_bl u_t012_007/c0_w0_br u_t012_007/c0_w1_bl u_t012_007/c0_w1_br u_t012_007/c0_r0_rbl
+ u_t012_007/c0_r1_rbl u_t012_007/c1_w0_bl u_t012_007/c1_w0_br u_t012_007/c1_w1_bl u_t012_007/c1_w1_br
+ u_t012_007/c1_r0_rbl u_t012_007/c1_r1_rbl u_t012_007/c2_w0_bl u_t012_007/c2_w0_br u_t012_007/c2_w1_bl
+ u_t012_007/c2_w1_br u_t012_007/c2_r0_rbl u_t012_007/c2_r1_rbl u_t012_007/c3_w0_bl u_t012_007/c3_w0_br
+ u_t012_007/c3_w1_bl u_t012_007/c3_w1_br u_t012_007/c3_r0_rbl u_t012_007/c3_r1_rbl u_t012_007/r0_w0_wl
+ u_t012_007/r0_w1_wl u_t012_007/r0_r0_rwl u_t012_007/r0_r1_rwl u_t012_007/r1_w0_wl u_t012_007/r1_w1_wl
+ u_t012_007/r1_r0_rwl u_t012_007/r1_r1_rwl u_t012_007/r2_w0_wl u_t012_007/r2_w1_wl u_t012_007/r2_r0_rwl
+ u_t012_007/r2_r1_rwl u_t012_007/r3_w0_wl u_t012_007/r3_w1_wl u_t012_007/r3_r0_rwl u_t012_007/r3_r1_rwl VDD VSS VSUBS
+ detronyx_12t_2w2r_rc4_4x4_routed_5layer_direct
Xu_t003_007 u_t003_007/c0_w0_bl u_t003_007/c0_w0_br u_t003_007/c0_w1_bl u_t003_007/c0_w1_br u_t003_007/c0_r0_rbl
+ u_t003_007/c0_r1_rbl u_t003_007/c1_w0_bl u_t003_007/c1_w0_br u_t003_007/c1_w1_bl u_t003_007/c1_w1_br
+ u_t003_007/c1_r0_rbl u_t003_007/c1_r1_rbl u_t003_007/c2_w0_bl u_t003_007/c2_w0_br u_t003_007/c2_w1_bl
+ u_t003_007/c2_w1_br u_t003_007/c2_r0_rbl u_t003_007/c2_r1_rbl u_t003_007/c3_w0_bl u_t003_007/c3_w0_br
+ u_t003_007/c3_w1_bl u_t003_007/c3_w1_br u_t003_007/c3_r0_rbl u_t003_007/c3_r1_rbl u_t003_007/r0_w0_wl
+ u_t003_007/r0_w1_wl u_t003_007/r0_r0_rwl u_t003_007/r0_r1_rwl u_t003_007/r1_w0_wl u_t003_007/r1_w1_wl
+ u_t003_007/r1_r0_rwl u_t003_007/r1_r1_rwl u_t003_007/r2_w0_wl u_t003_007/r2_w1_wl u_t003_007/r2_r0_rwl
+ u_t003_007/r2_r1_rwl u_t003_007/r3_w0_wl u_t003_007/r3_w1_wl u_t003_007/r3_r0_rwl u_t003_007/r3_r1_rwl VDD VSS VSUBS
+ detronyx_12t_2w2r_rc4_4x4_routed_5layer_direct
Xu_t027_013 u_t027_013/c0_w0_bl u_t027_013/c0_w0_br u_t027_013/c0_w1_bl u_t027_013/c0_w1_br u_t027_013/c0_r0_rbl
+ u_t027_013/c0_r1_rbl u_t027_013/c1_w0_bl u_t027_013/c1_w0_br u_t027_013/c1_w1_bl u_t027_013/c1_w1_br
+ u_t027_013/c1_r0_rbl u_t027_013/c1_r1_rbl u_t027_013/c2_w0_bl u_t027_013/c2_w0_br u_t027_013/c2_w1_bl
+ u_t027_013/c2_w1_br u_t027_013/c2_r0_rbl u_t027_013/c2_r1_rbl u_t027_013/c3_w0_bl u_t027_013/c3_w0_br
+ u_t027_013/c3_w1_bl u_t027_013/c3_w1_br u_t027_013/c3_r0_rbl u_t027_013/c3_r1_rbl u_t027_013/r0_w0_wl
+ u_t027_013/r0_w1_wl u_t027_013/r0_r0_rwl u_t027_013/r0_r1_rwl u_t027_013/r1_w0_wl u_t027_013/r1_w1_wl
+ u_t027_013/r1_r0_rwl u_t027_013/r1_r1_rwl u_t027_013/r2_w0_wl u_t027_013/r2_w1_wl u_t027_013/r2_r0_rwl
+ u_t027_013/r2_r1_rwl u_t027_013/r3_w0_wl u_t027_013/r3_w1_wl u_t027_013/r3_r0_rwl u_t027_013/r3_r1_rwl VDD VSS VSUBS
+ detronyx_12t_2w2r_rc4_4x4_routed_5layer_direct
Xu_t027_002 u_t027_002/c0_w0_bl u_t027_002/c0_w0_br u_t027_002/c0_w1_bl u_t027_002/c0_w1_br u_t027_002/c0_r0_rbl
+ u_t027_002/c0_r1_rbl u_t027_002/c1_w0_bl u_t027_002/c1_w0_br u_t027_002/c1_w1_bl u_t027_002/c1_w1_br
+ u_t027_002/c1_r0_rbl u_t027_002/c1_r1_rbl u_t027_002/c2_w0_bl u_t027_002/c2_w0_br u_t027_002/c2_w1_bl
+ u_t027_002/c2_w1_br u_t027_002/c2_r0_rbl u_t027_002/c2_r1_rbl u_t027_002/c3_w0_bl u_t027_002/c3_w0_br
+ u_t027_002/c3_w1_bl u_t027_002/c3_w1_br u_t027_002/c3_r0_rbl u_t027_002/c3_r1_rbl u_t027_002/r0_w0_wl
+ u_t027_002/r0_w1_wl u_t027_002/r0_r0_rwl u_t027_002/r0_r1_rwl u_t027_002/r1_w0_wl u_t027_002/r1_w1_wl
+ u_t027_002/r1_r0_rwl u_t027_002/r1_r1_rwl u_t027_002/r2_w0_wl u_t027_002/r2_w1_wl u_t027_002/r2_r0_rwl
+ u_t027_002/r2_r1_rwl u_t027_002/r3_w0_wl u_t027_002/r3_w1_wl u_t027_002/r3_r0_rwl u_t027_002/r3_r1_rwl VDD VSS VSUBS
+ detronyx_12t_2w2r_rc4_4x4_routed_5layer_direct
Xu_t018_002 u_t018_002/c0_w0_bl u_t018_002/c0_w0_br u_t018_002/c0_w1_bl u_t018_002/c0_w1_br u_t018_002/c0_r0_rbl
+ u_t018_002/c0_r1_rbl u_t018_002/c1_w0_bl u_t018_002/c1_w0_br u_t018_002/c1_w1_bl u_t018_002/c1_w1_br
+ u_t018_002/c1_r0_rbl u_t018_002/c1_r1_rbl u_t018_002/c2_w0_bl u_t018_002/c2_w0_br u_t018_002/c2_w1_bl
+ u_t018_002/c2_w1_br u_t018_002/c2_r0_rbl u_t018_002/c2_r1_rbl u_t018_002/c3_w0_bl u_t018_002/c3_w0_br
+ u_t018_002/c3_w1_bl u_t018_002/c3_w1_br u_t018_002/c3_r0_rbl u_t018_002/c3_r1_rbl u_t018_002/r0_w0_wl
+ u_t018_002/r0_w1_wl u_t018_002/r0_r0_rwl u_t018_002/r0_r1_rwl u_t018_002/r1_w0_wl u_t018_002/r1_w1_wl
+ u_t018_002/r1_r0_rwl u_t018_002/r1_r1_rwl u_t018_002/r2_w0_wl u_t018_002/r2_w1_wl u_t018_002/r2_r0_rwl
+ u_t018_002/r2_r1_rwl u_t018_002/r3_w0_wl u_t018_002/r3_w1_wl u_t018_002/r3_r0_rwl u_t018_002/r3_r1_rwl VDD VSS VSUBS
+ detronyx_12t_2w2r_rc4_4x4_routed_5layer_direct
Xu_t018_013 u_t018_013/c0_w0_bl u_t018_013/c0_w0_br u_t018_013/c0_w1_bl u_t018_013/c0_w1_br u_t018_013/c0_r0_rbl
+ u_t018_013/c0_r1_rbl u_t018_013/c1_w0_bl u_t018_013/c1_w0_br u_t018_013/c1_w1_bl u_t018_013/c1_w1_br
+ u_t018_013/c1_r0_rbl u_t018_013/c1_r1_rbl u_t018_013/c2_w0_bl u_t018_013/c2_w0_br u_t018_013/c2_w1_bl
+ u_t018_013/c2_w1_br u_t018_013/c2_r0_rbl u_t018_013/c2_r1_rbl u_t018_013/c3_w0_bl u_t018_013/c3_w0_br
+ u_t018_013/c3_w1_bl u_t018_013/c3_w1_br u_t018_013/c3_r0_rbl u_t018_013/c3_r1_rbl u_t018_013/r0_w0_wl
+ u_t018_013/r0_w1_wl u_t018_013/r0_r0_rwl u_t018_013/r0_r1_rwl u_t018_013/r1_w0_wl u_t018_013/r1_w1_wl
+ u_t018_013/r1_r0_rwl u_t018_013/r1_r1_rwl u_t018_013/r2_w0_wl u_t018_013/r2_w1_wl u_t018_013/r2_r0_rwl
+ u_t018_013/r2_r1_rwl u_t018_013/r3_w0_wl u_t018_013/r3_w1_wl u_t018_013/r3_r0_rwl u_t018_013/r3_r1_rwl VDD VSS VSUBS
+ detronyx_12t_2w2r_rc4_4x4_routed_5layer_direct
Xu_t024_005 u_t024_005/c0_w0_bl u_t024_005/c0_w0_br u_t024_005/c0_w1_bl u_t024_005/c0_w1_br u_t024_005/c0_r0_rbl
+ u_t024_005/c0_r1_rbl u_t024_005/c1_w0_bl u_t024_005/c1_w0_br u_t024_005/c1_w1_bl u_t024_005/c1_w1_br
+ u_t024_005/c1_r0_rbl u_t024_005/c1_r1_rbl u_t024_005/c2_w0_bl u_t024_005/c2_w0_br u_t024_005/c2_w1_bl
+ u_t024_005/c2_w1_br u_t024_005/c2_r0_rbl u_t024_005/c2_r1_rbl u_t024_005/c3_w0_bl u_t024_005/c3_w0_br
+ u_t024_005/c3_w1_bl u_t024_005/c3_w1_br u_t024_005/c3_r0_rbl u_t024_005/c3_r1_rbl u_t024_005/r0_w0_wl
+ u_t024_005/r0_w1_wl u_t024_005/r0_r0_rwl u_t024_005/r0_r1_rwl u_t024_005/r1_w0_wl u_t024_005/r1_w1_wl
+ u_t024_005/r1_r0_rwl u_t024_005/r1_r1_rwl u_t024_005/r2_w0_wl u_t024_005/r2_w1_wl u_t024_005/r2_r0_rwl
+ u_t024_005/r2_r1_rwl u_t024_005/r3_w0_wl u_t024_005/r3_w1_wl u_t024_005/r3_r0_rwl u_t024_005/r3_r1_rwl VDD VSS VSUBS
+ detronyx_12t_2w2r_rc4_4x4_routed_5layer_direct
Xu_t009_002 u_t009_002/c0_w0_bl u_t009_002/c0_w0_br u_t009_002/c0_w1_bl u_t009_002/c0_w1_br u_t009_002/c0_r0_rbl
+ u_t009_002/c0_r1_rbl u_t009_002/c1_w0_bl u_t009_002/c1_w0_br u_t009_002/c1_w1_bl u_t009_002/c1_w1_br
+ u_t009_002/c1_r0_rbl u_t009_002/c1_r1_rbl u_t009_002/c2_w0_bl u_t009_002/c2_w0_br u_t009_002/c2_w1_bl
+ u_t009_002/c2_w1_br u_t009_002/c2_r0_rbl u_t009_002/c2_r1_rbl u_t009_002/c3_w0_bl u_t009_002/c3_w0_br
+ u_t009_002/c3_w1_bl u_t009_002/c3_w1_br u_t009_002/c3_r0_rbl u_t009_002/c3_r1_rbl u_t009_002/r0_w0_wl
+ u_t009_002/r0_w1_wl u_t009_002/r0_r0_rwl u_t009_002/r0_r1_rwl u_t009_002/r1_w0_wl u_t009_002/r1_w1_wl
+ u_t009_002/r1_r0_rwl u_t009_002/r1_r1_rwl u_t009_002/r2_w0_wl u_t009_002/r2_w1_wl u_t009_002/r2_r0_rwl
+ u_t009_002/r2_r1_rwl u_t009_002/r3_w0_wl u_t009_002/r3_w1_wl u_t009_002/r3_r0_rwl u_t009_002/r3_r1_rwl VDD VSS VSUBS
+ detronyx_12t_2w2r_rc4_4x4_routed_5layer_direct
Xu_t009_013 u_t009_013/c0_w0_bl u_t009_013/c0_w0_br u_t009_013/c0_w1_bl u_t009_013/c0_w1_br u_t009_013/c0_r0_rbl
+ u_t009_013/c0_r1_rbl u_t009_013/c1_w0_bl u_t009_013/c1_w0_br u_t009_013/c1_w1_bl u_t009_013/c1_w1_br
+ u_t009_013/c1_r0_rbl u_t009_013/c1_r1_rbl u_t009_013/c2_w0_bl u_t009_013/c2_w0_br u_t009_013/c2_w1_bl
+ u_t009_013/c2_w1_br u_t009_013/c2_r0_rbl u_t009_013/c2_r1_rbl u_t009_013/c3_w0_bl u_t009_013/c3_w0_br
+ u_t009_013/c3_w1_bl u_t009_013/c3_w1_br u_t009_013/c3_r0_rbl u_t009_013/c3_r1_rbl u_t009_013/r0_w0_wl
+ u_t009_013/r0_w1_wl u_t009_013/r0_r0_rwl u_t009_013/r0_r1_rwl u_t009_013/r1_w0_wl u_t009_013/r1_w1_wl
+ u_t009_013/r1_r0_rwl u_t009_013/r1_r1_rwl u_t009_013/r2_w0_wl u_t009_013/r2_w1_wl u_t009_013/r2_r0_rwl
+ u_t009_013/r2_r1_rwl u_t009_013/r3_w0_wl u_t009_013/r3_w1_wl u_t009_013/r3_r0_rwl u_t009_013/r3_r1_rwl VDD VSS VSUBS
+ detronyx_12t_2w2r_rc4_4x4_routed_5layer_direct
Xu_t030_008 u_t030_008/c0_w0_bl u_t030_008/c0_w0_br u_t030_008/c0_w1_bl u_t030_008/c0_w1_br u_t030_008/c0_r0_rbl
+ u_t030_008/c0_r1_rbl u_t030_008/c1_w0_bl u_t030_008/c1_w0_br u_t030_008/c1_w1_bl u_t030_008/c1_w1_br
+ u_t030_008/c1_r0_rbl u_t030_008/c1_r1_rbl u_t030_008/c2_w0_bl u_t030_008/c2_w0_br u_t030_008/c2_w1_bl
+ u_t030_008/c2_w1_br u_t030_008/c2_r0_rbl u_t030_008/c2_r1_rbl u_t030_008/c3_w0_bl u_t030_008/c3_w0_br
+ u_t030_008/c3_w1_bl u_t030_008/c3_w1_br u_t030_008/c3_r0_rbl u_t030_008/c3_r1_rbl u_t030_008/r0_w0_wl
+ u_t030_008/r0_w1_wl u_t030_008/r0_r0_rwl u_t030_008/r0_r1_rwl u_t030_008/r1_w0_wl u_t030_008/r1_w1_wl
+ u_t030_008/r1_r0_rwl u_t030_008/r1_r1_rwl u_t030_008/r2_w0_wl u_t030_008/r2_w1_wl u_t030_008/r2_r0_rwl
+ u_t030_008/r2_r1_rwl u_t030_008/r3_w0_wl u_t030_008/r3_w1_wl u_t030_008/r3_r0_rwl u_t030_008/r3_r1_rwl VDD VSS VSUBS
+ detronyx_12t_2w2r_rc4_4x4_routed_5layer_direct
Xu_t015_005 u_t015_005/c0_w0_bl u_t015_005/c0_w0_br u_t015_005/c0_w1_bl u_t015_005/c0_w1_br u_t015_005/c0_r0_rbl
+ u_t015_005/c0_r1_rbl u_t015_005/c1_w0_bl u_t015_005/c1_w0_br u_t015_005/c1_w1_bl u_t015_005/c1_w1_br
+ u_t015_005/c1_r0_rbl u_t015_005/c1_r1_rbl u_t015_005/c2_w0_bl u_t015_005/c2_w0_br u_t015_005/c2_w1_bl
+ u_t015_005/c2_w1_br u_t015_005/c2_r0_rbl u_t015_005/c2_r1_rbl u_t015_005/c3_w0_bl u_t015_005/c3_w0_br
+ u_t015_005/c3_w1_bl u_t015_005/c3_w1_br u_t015_005/c3_r0_rbl u_t015_005/c3_r1_rbl u_t015_005/r0_w0_wl
+ u_t015_005/r0_w1_wl u_t015_005/r0_r0_rwl u_t015_005/r0_r1_rwl u_t015_005/r1_w0_wl u_t015_005/r1_w1_wl
+ u_t015_005/r1_r0_rwl u_t015_005/r1_r1_rwl u_t015_005/r2_w0_wl u_t015_005/r2_w1_wl u_t015_005/r2_r0_rwl
+ u_t015_005/r2_r1_rwl u_t015_005/r3_w0_wl u_t015_005/r3_w1_wl u_t015_005/r3_r0_rwl u_t015_005/r3_r1_rwl VDD VSS VSUBS
+ detronyx_12t_2w2r_rc4_4x4_routed_5layer_direct
Xu_t006_005 u_t006_005/c0_w0_bl u_t006_005/c0_w0_br u_t006_005/c0_w1_bl u_t006_005/c0_w1_br u_t006_005/c0_r0_rbl
+ u_t006_005/c0_r1_rbl u_t006_005/c1_w0_bl u_t006_005/c1_w0_br u_t006_005/c1_w1_bl u_t006_005/c1_w1_br
+ u_t006_005/c1_r0_rbl u_t006_005/c1_r1_rbl u_t006_005/c2_w0_bl u_t006_005/c2_w0_br u_t006_005/c2_w1_bl
+ u_t006_005/c2_w1_br u_t006_005/c2_r0_rbl u_t006_005/c2_r1_rbl u_t006_005/c3_w0_bl u_t006_005/c3_w0_br
+ u_t006_005/c3_w1_bl u_t006_005/c3_w1_br u_t006_005/c3_r0_rbl u_t006_005/c3_r1_rbl u_t006_005/r0_w0_wl
+ u_t006_005/r0_w1_wl u_t006_005/r0_r0_rwl u_t006_005/r0_r1_rwl u_t006_005/r1_w0_wl u_t006_005/r1_w1_wl
+ u_t006_005/r1_r0_rwl u_t006_005/r1_r1_rwl u_t006_005/r2_w0_wl u_t006_005/r2_w1_wl u_t006_005/r2_r0_rwl
+ u_t006_005/r2_r1_rwl u_t006_005/r3_w0_wl u_t006_005/r3_w1_wl u_t006_005/r3_r0_rwl u_t006_005/r3_r1_rwl VDD VSS VSUBS
+ detronyx_12t_2w2r_rc4_4x4_routed_5layer_direct
Xu_t021_008 u_t021_008/c0_w0_bl u_t021_008/c0_w0_br u_t021_008/c0_w1_bl u_t021_008/c0_w1_br u_t021_008/c0_r0_rbl
+ u_t021_008/c0_r1_rbl u_t021_008/c1_w0_bl u_t021_008/c1_w0_br u_t021_008/c1_w1_bl u_t021_008/c1_w1_br
+ u_t021_008/c1_r0_rbl u_t021_008/c1_r1_rbl u_t021_008/c2_w0_bl u_t021_008/c2_w0_br u_t021_008/c2_w1_bl
+ u_t021_008/c2_w1_br u_t021_008/c2_r0_rbl u_t021_008/c2_r1_rbl u_t021_008/c3_w0_bl u_t021_008/c3_w0_br
+ u_t021_008/c3_w1_bl u_t021_008/c3_w1_br u_t021_008/c3_r0_rbl u_t021_008/c3_r1_rbl u_t021_008/r0_w0_wl
+ u_t021_008/r0_w1_wl u_t021_008/r0_r0_rwl u_t021_008/r0_r1_rwl u_t021_008/r1_w0_wl u_t021_008/r1_w1_wl
+ u_t021_008/r1_r0_rwl u_t021_008/r1_r1_rwl u_t021_008/r2_w0_wl u_t021_008/r2_w1_wl u_t021_008/r2_r0_rwl
+ u_t021_008/r2_r1_rwl u_t021_008/r3_w0_wl u_t021_008/r3_w1_wl u_t021_008/r3_r0_rwl u_t021_008/r3_r1_rwl VDD VSS VSUBS
+ detronyx_12t_2w2r_rc4_4x4_routed_5layer_direct
Xu_t012_008 u_t012_008/c0_w0_bl u_t012_008/c0_w0_br u_t012_008/c0_w1_bl u_t012_008/c0_w1_br u_t012_008/c0_r0_rbl
+ u_t012_008/c0_r1_rbl u_t012_008/c1_w0_bl u_t012_008/c1_w0_br u_t012_008/c1_w1_bl u_t012_008/c1_w1_br
+ u_t012_008/c1_r0_rbl u_t012_008/c1_r1_rbl u_t012_008/c2_w0_bl u_t012_008/c2_w0_br u_t012_008/c2_w1_bl
+ u_t012_008/c2_w1_br u_t012_008/c2_r0_rbl u_t012_008/c2_r1_rbl u_t012_008/c3_w0_bl u_t012_008/c3_w0_br
+ u_t012_008/c3_w1_bl u_t012_008/c3_w1_br u_t012_008/c3_r0_rbl u_t012_008/c3_r1_rbl u_t012_008/r0_w0_wl
+ u_t012_008/r0_w1_wl u_t012_008/r0_r0_rwl u_t012_008/r0_r1_rwl u_t012_008/r1_w0_wl u_t012_008/r1_w1_wl
+ u_t012_008/r1_r0_rwl u_t012_008/r1_r1_rwl u_t012_008/r2_w0_wl u_t012_008/r2_w1_wl u_t012_008/r2_r0_rwl
+ u_t012_008/r2_r1_rwl u_t012_008/r3_w0_wl u_t012_008/r3_w1_wl u_t012_008/r3_r0_rwl u_t012_008/r3_r1_rwl VDD VSS VSUBS
+ detronyx_12t_2w2r_rc4_4x4_routed_5layer_direct
Xu_t003_008 u_t003_008/c0_w0_bl u_t003_008/c0_w0_br u_t003_008/c0_w1_bl u_t003_008/c0_w1_br u_t003_008/c0_r0_rbl
+ u_t003_008/c0_r1_rbl u_t003_008/c1_w0_bl u_t003_008/c1_w0_br u_t003_008/c1_w1_bl u_t003_008/c1_w1_br
+ u_t003_008/c1_r0_rbl u_t003_008/c1_r1_rbl u_t003_008/c2_w0_bl u_t003_008/c2_w0_br u_t003_008/c2_w1_bl
+ u_t003_008/c2_w1_br u_t003_008/c2_r0_rbl u_t003_008/c2_r1_rbl u_t003_008/c3_w0_bl u_t003_008/c3_w0_br
+ u_t003_008/c3_w1_bl u_t003_008/c3_w1_br u_t003_008/c3_r0_rbl u_t003_008/c3_r1_rbl u_t003_008/r0_w0_wl
+ u_t003_008/r0_w1_wl u_t003_008/r0_r0_rwl u_t003_008/r0_r1_rwl u_t003_008/r1_w0_wl u_t003_008/r1_w1_wl
+ u_t003_008/r1_r0_rwl u_t003_008/r1_r1_rwl u_t003_008/r2_w0_wl u_t003_008/r2_w1_wl u_t003_008/r2_r0_rwl
+ u_t003_008/r2_r1_rwl u_t003_008/r3_w0_wl u_t003_008/r3_w1_wl u_t003_008/r3_r0_rwl u_t003_008/r3_r1_rwl VDD VSS VSUBS
+ detronyx_12t_2w2r_rc4_4x4_routed_5layer_direct
Xu_t027_014 u_t027_014/c0_w0_bl u_t027_014/c0_w0_br u_t027_014/c0_w1_bl u_t027_014/c0_w1_br u_t027_014/c0_r0_rbl
+ u_t027_014/c0_r1_rbl u_t027_014/c1_w0_bl u_t027_014/c1_w0_br u_t027_014/c1_w1_bl u_t027_014/c1_w1_br
+ u_t027_014/c1_r0_rbl u_t027_014/c1_r1_rbl u_t027_014/c2_w0_bl u_t027_014/c2_w0_br u_t027_014/c2_w1_bl
+ u_t027_014/c2_w1_br u_t027_014/c2_r0_rbl u_t027_014/c2_r1_rbl u_t027_014/c3_w0_bl u_t027_014/c3_w0_br
+ u_t027_014/c3_w1_bl u_t027_014/c3_w1_br u_t027_014/c3_r0_rbl u_t027_014/c3_r1_rbl u_t027_014/r0_w0_wl
+ u_t027_014/r0_w1_wl u_t027_014/r0_r0_rwl u_t027_014/r0_r1_rwl u_t027_014/r1_w0_wl u_t027_014/r1_w1_wl
+ u_t027_014/r1_r0_rwl u_t027_014/r1_r1_rwl u_t027_014/r2_w0_wl u_t027_014/r2_w1_wl u_t027_014/r2_r0_rwl
+ u_t027_014/r2_r1_rwl u_t027_014/r3_w0_wl u_t027_014/r3_w1_wl u_t027_014/r3_r0_rwl u_t027_014/r3_r1_rwl VDD VSS VSUBS
+ detronyx_12t_2w2r_rc4_4x4_routed_5layer_direct
Xu_t027_003 u_t027_003/c0_w0_bl u_t027_003/c0_w0_br u_t027_003/c0_w1_bl u_t027_003/c0_w1_br u_t027_003/c0_r0_rbl
+ u_t027_003/c0_r1_rbl u_t027_003/c1_w0_bl u_t027_003/c1_w0_br u_t027_003/c1_w1_bl u_t027_003/c1_w1_br
+ u_t027_003/c1_r0_rbl u_t027_003/c1_r1_rbl u_t027_003/c2_w0_bl u_t027_003/c2_w0_br u_t027_003/c2_w1_bl
+ u_t027_003/c2_w1_br u_t027_003/c2_r0_rbl u_t027_003/c2_r1_rbl u_t027_003/c3_w0_bl u_t027_003/c3_w0_br
+ u_t027_003/c3_w1_bl u_t027_003/c3_w1_br u_t027_003/c3_r0_rbl u_t027_003/c3_r1_rbl u_t027_003/r0_w0_wl
+ u_t027_003/r0_w1_wl u_t027_003/r0_r0_rwl u_t027_003/r0_r1_rwl u_t027_003/r1_w0_wl u_t027_003/r1_w1_wl
+ u_t027_003/r1_r0_rwl u_t027_003/r1_r1_rwl u_t027_003/r2_w0_wl u_t027_003/r2_w1_wl u_t027_003/r2_r0_rwl
+ u_t027_003/r2_r1_rwl u_t027_003/r3_w0_wl u_t027_003/r3_w1_wl u_t027_003/r3_r0_rwl u_t027_003/r3_r1_rwl VDD VSS VSUBS
+ detronyx_12t_2w2r_rc4_4x4_routed_5layer_direct
Xu_t009_003 u_t009_003/c0_w0_bl u_t009_003/c0_w0_br u_t009_003/c0_w1_bl u_t009_003/c0_w1_br u_t009_003/c0_r0_rbl
+ u_t009_003/c0_r1_rbl u_t009_003/c1_w0_bl u_t009_003/c1_w0_br u_t009_003/c1_w1_bl u_t009_003/c1_w1_br
+ u_t009_003/c1_r0_rbl u_t009_003/c1_r1_rbl u_t009_003/c2_w0_bl u_t009_003/c2_w0_br u_t009_003/c2_w1_bl
+ u_t009_003/c2_w1_br u_t009_003/c2_r0_rbl u_t009_003/c2_r1_rbl u_t009_003/c3_w0_bl u_t009_003/c3_w0_br
+ u_t009_003/c3_w1_bl u_t009_003/c3_w1_br u_t009_003/c3_r0_rbl u_t009_003/c3_r1_rbl u_t009_003/r0_w0_wl
+ u_t009_003/r0_w1_wl u_t009_003/r0_r0_rwl u_t009_003/r0_r1_rwl u_t009_003/r1_w0_wl u_t009_003/r1_w1_wl
+ u_t009_003/r1_r0_rwl u_t009_003/r1_r1_rwl u_t009_003/r2_w0_wl u_t009_003/r2_w1_wl u_t009_003/r2_r0_rwl
+ u_t009_003/r2_r1_rwl u_t009_003/r3_w0_wl u_t009_003/r3_w1_wl u_t009_003/r3_r0_rwl u_t009_003/r3_r1_rwl VDD VSS VSUBS
+ detronyx_12t_2w2r_rc4_4x4_routed_5layer_direct
Xu_t009_014 u_t009_014/c0_w0_bl u_t009_014/c0_w0_br u_t009_014/c0_w1_bl u_t009_014/c0_w1_br u_t009_014/c0_r0_rbl
+ u_t009_014/c0_r1_rbl u_t009_014/c1_w0_bl u_t009_014/c1_w0_br u_t009_014/c1_w1_bl u_t009_014/c1_w1_br
+ u_t009_014/c1_r0_rbl u_t009_014/c1_r1_rbl u_t009_014/c2_w0_bl u_t009_014/c2_w0_br u_t009_014/c2_w1_bl
+ u_t009_014/c2_w1_br u_t009_014/c2_r0_rbl u_t009_014/c2_r1_rbl u_t009_014/c3_w0_bl u_t009_014/c3_w0_br
+ u_t009_014/c3_w1_bl u_t009_014/c3_w1_br u_t009_014/c3_r0_rbl u_t009_014/c3_r1_rbl u_t009_014/r0_w0_wl
+ u_t009_014/r0_w1_wl u_t009_014/r0_r0_rwl u_t009_014/r0_r1_rwl u_t009_014/r1_w0_wl u_t009_014/r1_w1_wl
+ u_t009_014/r1_r0_rwl u_t009_014/r1_r1_rwl u_t009_014/r2_w0_wl u_t009_014/r2_w1_wl u_t009_014/r2_r0_rwl
+ u_t009_014/r2_r1_rwl u_t009_014/r3_w0_wl u_t009_014/r3_w1_wl u_t009_014/r3_r0_rwl u_t009_014/r3_r1_rwl VDD VSS VSUBS
+ detronyx_12t_2w2r_rc4_4x4_routed_5layer_direct
Xu_t018_003 u_t018_003/c0_w0_bl u_t018_003/c0_w0_br u_t018_003/c0_w1_bl u_t018_003/c0_w1_br u_t018_003/c0_r0_rbl
+ u_t018_003/c0_r1_rbl u_t018_003/c1_w0_bl u_t018_003/c1_w0_br u_t018_003/c1_w1_bl u_t018_003/c1_w1_br
+ u_t018_003/c1_r0_rbl u_t018_003/c1_r1_rbl u_t018_003/c2_w0_bl u_t018_003/c2_w0_br u_t018_003/c2_w1_bl
+ u_t018_003/c2_w1_br u_t018_003/c2_r0_rbl u_t018_003/c2_r1_rbl u_t018_003/c3_w0_bl u_t018_003/c3_w0_br
+ u_t018_003/c3_w1_bl u_t018_003/c3_w1_br u_t018_003/c3_r0_rbl u_t018_003/c3_r1_rbl u_t018_003/r0_w0_wl
+ u_t018_003/r0_w1_wl u_t018_003/r0_r0_rwl u_t018_003/r0_r1_rwl u_t018_003/r1_w0_wl u_t018_003/r1_w1_wl
+ u_t018_003/r1_r0_rwl u_t018_003/r1_r1_rwl u_t018_003/r2_w0_wl u_t018_003/r2_w1_wl u_t018_003/r2_r0_rwl
+ u_t018_003/r2_r1_rwl u_t018_003/r3_w0_wl u_t018_003/r3_w1_wl u_t018_003/r3_r0_rwl u_t018_003/r3_r1_rwl VDD VSS VSUBS
+ detronyx_12t_2w2r_rc4_4x4_routed_5layer_direct
Xu_t018_014 u_t018_014/c0_w0_bl u_t018_014/c0_w0_br u_t018_014/c0_w1_bl u_t018_014/c0_w1_br u_t018_014/c0_r0_rbl
+ u_t018_014/c0_r1_rbl u_t018_014/c1_w0_bl u_t018_014/c1_w0_br u_t018_014/c1_w1_bl u_t018_014/c1_w1_br
+ u_t018_014/c1_r0_rbl u_t018_014/c1_r1_rbl u_t018_014/c2_w0_bl u_t018_014/c2_w0_br u_t018_014/c2_w1_bl
+ u_t018_014/c2_w1_br u_t018_014/c2_r0_rbl u_t018_014/c2_r1_rbl u_t018_014/c3_w0_bl u_t018_014/c3_w0_br
+ u_t018_014/c3_w1_bl u_t018_014/c3_w1_br u_t018_014/c3_r0_rbl u_t018_014/c3_r1_rbl u_t018_014/r0_w0_wl
+ u_t018_014/r0_w1_wl u_t018_014/r0_r0_rwl u_t018_014/r0_r1_rwl u_t018_014/r1_w0_wl u_t018_014/r1_w1_wl
+ u_t018_014/r1_r0_rwl u_t018_014/r1_r1_rwl u_t018_014/r2_w0_wl u_t018_014/r2_w1_wl u_t018_014/r2_r0_rwl
+ u_t018_014/r2_r1_rwl u_t018_014/r3_w0_wl u_t018_014/r3_w1_wl u_t018_014/r3_r0_rwl u_t018_014/r3_r1_rwl VDD VSS VSUBS
+ detronyx_12t_2w2r_rc4_4x4_routed_5layer_direct
Xu_t024_006 u_t024_006/c0_w0_bl u_t024_006/c0_w0_br u_t024_006/c0_w1_bl u_t024_006/c0_w1_br u_t024_006/c0_r0_rbl
+ u_t024_006/c0_r1_rbl u_t024_006/c1_w0_bl u_t024_006/c1_w0_br u_t024_006/c1_w1_bl u_t024_006/c1_w1_br
+ u_t024_006/c1_r0_rbl u_t024_006/c1_r1_rbl u_t024_006/c2_w0_bl u_t024_006/c2_w0_br u_t024_006/c2_w1_bl
+ u_t024_006/c2_w1_br u_t024_006/c2_r0_rbl u_t024_006/c2_r1_rbl u_t024_006/c3_w0_bl u_t024_006/c3_w0_br
+ u_t024_006/c3_w1_bl u_t024_006/c3_w1_br u_t024_006/c3_r0_rbl u_t024_006/c3_r1_rbl u_t024_006/r0_w0_wl
+ u_t024_006/r0_w1_wl u_t024_006/r0_r0_rwl u_t024_006/r0_r1_rwl u_t024_006/r1_w0_wl u_t024_006/r1_w1_wl
+ u_t024_006/r1_r0_rwl u_t024_006/r1_r1_rwl u_t024_006/r2_w0_wl u_t024_006/r2_w1_wl u_t024_006/r2_r0_rwl
+ u_t024_006/r2_r1_rwl u_t024_006/r3_w0_wl u_t024_006/r3_w1_wl u_t024_006/r3_r0_rwl u_t024_006/r3_r1_rwl VDD VSS VSUBS
+ detronyx_12t_2w2r_rc4_4x4_routed_5layer_direct
Xu_t015_006 u_t015_006/c0_w0_bl u_t015_006/c0_w0_br u_t015_006/c0_w1_bl u_t015_006/c0_w1_br u_t015_006/c0_r0_rbl
+ u_t015_006/c0_r1_rbl u_t015_006/c1_w0_bl u_t015_006/c1_w0_br u_t015_006/c1_w1_bl u_t015_006/c1_w1_br
+ u_t015_006/c1_r0_rbl u_t015_006/c1_r1_rbl u_t015_006/c2_w0_bl u_t015_006/c2_w0_br u_t015_006/c2_w1_bl
+ u_t015_006/c2_w1_br u_t015_006/c2_r0_rbl u_t015_006/c2_r1_rbl u_t015_006/c3_w0_bl u_t015_006/c3_w0_br
+ u_t015_006/c3_w1_bl u_t015_006/c3_w1_br u_t015_006/c3_r0_rbl u_t015_006/c3_r1_rbl u_t015_006/r0_w0_wl
+ u_t015_006/r0_w1_wl u_t015_006/r0_r0_rwl u_t015_006/r0_r1_rwl u_t015_006/r1_w0_wl u_t015_006/r1_w1_wl
+ u_t015_006/r1_r0_rwl u_t015_006/r1_r1_rwl u_t015_006/r2_w0_wl u_t015_006/r2_w1_wl u_t015_006/r2_r0_rwl
+ u_t015_006/r2_r1_rwl u_t015_006/r3_w0_wl u_t015_006/r3_w1_wl u_t015_006/r3_r0_rwl u_t015_006/r3_r1_rwl VDD VSS VSUBS
+ detronyx_12t_2w2r_rc4_4x4_routed_5layer_direct
Xu_t030_009 u_t030_009/c0_w0_bl u_t030_009/c0_w0_br u_t030_009/c0_w1_bl u_t030_009/c0_w1_br u_t030_009/c0_r0_rbl
+ u_t030_009/c0_r1_rbl u_t030_009/c1_w0_bl u_t030_009/c1_w0_br u_t030_009/c1_w1_bl u_t030_009/c1_w1_br
+ u_t030_009/c1_r0_rbl u_t030_009/c1_r1_rbl u_t030_009/c2_w0_bl u_t030_009/c2_w0_br u_t030_009/c2_w1_bl
+ u_t030_009/c2_w1_br u_t030_009/c2_r0_rbl u_t030_009/c2_r1_rbl u_t030_009/c3_w0_bl u_t030_009/c3_w0_br
+ u_t030_009/c3_w1_bl u_t030_009/c3_w1_br u_t030_009/c3_r0_rbl u_t030_009/c3_r1_rbl u_t030_009/r0_w0_wl
+ u_t030_009/r0_w1_wl u_t030_009/r0_r0_rwl u_t030_009/r0_r1_rwl u_t030_009/r1_w0_wl u_t030_009/r1_w1_wl
+ u_t030_009/r1_r0_rwl u_t030_009/r1_r1_rwl u_t030_009/r2_w0_wl u_t030_009/r2_w1_wl u_t030_009/r2_r0_rwl
+ u_t030_009/r2_r1_rwl u_t030_009/r3_w0_wl u_t030_009/r3_w1_wl u_t030_009/r3_r0_rwl u_t030_009/r3_r1_rwl VDD VSS VSUBS
+ detronyx_12t_2w2r_rc4_4x4_routed_5layer_direct
Xu_t006_006 u_t006_006/c0_w0_bl u_t006_006/c0_w0_br u_t006_006/c0_w1_bl u_t006_006/c0_w1_br u_t006_006/c0_r0_rbl
+ u_t006_006/c0_r1_rbl u_t006_006/c1_w0_bl u_t006_006/c1_w0_br u_t006_006/c1_w1_bl u_t006_006/c1_w1_br
+ u_t006_006/c1_r0_rbl u_t006_006/c1_r1_rbl u_t006_006/c2_w0_bl u_t006_006/c2_w0_br u_t006_006/c2_w1_bl
+ u_t006_006/c2_w1_br u_t006_006/c2_r0_rbl u_t006_006/c2_r1_rbl u_t006_006/c3_w0_bl u_t006_006/c3_w0_br
+ u_t006_006/c3_w1_bl u_t006_006/c3_w1_br u_t006_006/c3_r0_rbl u_t006_006/c3_r1_rbl u_t006_006/r0_w0_wl
+ u_t006_006/r0_w1_wl u_t006_006/r0_r0_rwl u_t006_006/r0_r1_rwl u_t006_006/r1_w0_wl u_t006_006/r1_w1_wl
+ u_t006_006/r1_r0_rwl u_t006_006/r1_r1_rwl u_t006_006/r2_w0_wl u_t006_006/r2_w1_wl u_t006_006/r2_r0_rwl
+ u_t006_006/r2_r1_rwl u_t006_006/r3_w0_wl u_t006_006/r3_w1_wl u_t006_006/r3_r0_rwl u_t006_006/r3_r1_rwl VDD VSS VSUBS
+ detronyx_12t_2w2r_rc4_4x4_routed_5layer_direct
Xu_t021_009 u_t021_009/c0_w0_bl u_t021_009/c0_w0_br u_t021_009/c0_w1_bl u_t021_009/c0_w1_br u_t021_009/c0_r0_rbl
+ u_t021_009/c0_r1_rbl u_t021_009/c1_w0_bl u_t021_009/c1_w0_br u_t021_009/c1_w1_bl u_t021_009/c1_w1_br
+ u_t021_009/c1_r0_rbl u_t021_009/c1_r1_rbl u_t021_009/c2_w0_bl u_t021_009/c2_w0_br u_t021_009/c2_w1_bl
+ u_t021_009/c2_w1_br u_t021_009/c2_r0_rbl u_t021_009/c2_r1_rbl u_t021_009/c3_w0_bl u_t021_009/c3_w0_br
+ u_t021_009/c3_w1_bl u_t021_009/c3_w1_br u_t021_009/c3_r0_rbl u_t021_009/c3_r1_rbl u_t021_009/r0_w0_wl
+ u_t021_009/r0_w1_wl u_t021_009/r0_r0_rwl u_t021_009/r0_r1_rwl u_t021_009/r1_w0_wl u_t021_009/r1_w1_wl
+ u_t021_009/r1_r0_rwl u_t021_009/r1_r1_rwl u_t021_009/r2_w0_wl u_t021_009/r2_w1_wl u_t021_009/r2_r0_rwl
+ u_t021_009/r2_r1_rwl u_t021_009/r3_w0_wl u_t021_009/r3_w1_wl u_t021_009/r3_r0_rwl u_t021_009/r3_r1_rwl VDD VSS VSUBS
+ detronyx_12t_2w2r_rc4_4x4_routed_5layer_direct
Xu_t012_009 u_t012_009/c0_w0_bl u_t012_009/c0_w0_br u_t012_009/c0_w1_bl u_t012_009/c0_w1_br u_t012_009/c0_r0_rbl
+ u_t012_009/c0_r1_rbl u_t012_009/c1_w0_bl u_t012_009/c1_w0_br u_t012_009/c1_w1_bl u_t012_009/c1_w1_br
+ u_t012_009/c1_r0_rbl u_t012_009/c1_r1_rbl u_t012_009/c2_w0_bl u_t012_009/c2_w0_br u_t012_009/c2_w1_bl
+ u_t012_009/c2_w1_br u_t012_009/c2_r0_rbl u_t012_009/c2_r1_rbl u_t012_009/c3_w0_bl u_t012_009/c3_w0_br
+ u_t012_009/c3_w1_bl u_t012_009/c3_w1_br u_t012_009/c3_r0_rbl u_t012_009/c3_r1_rbl u_t012_009/r0_w0_wl
+ u_t012_009/r0_w1_wl u_t012_009/r0_r0_rwl u_t012_009/r0_r1_rwl u_t012_009/r1_w0_wl u_t012_009/r1_w1_wl
+ u_t012_009/r1_r0_rwl u_t012_009/r1_r1_rwl u_t012_009/r2_w0_wl u_t012_009/r2_w1_wl u_t012_009/r2_r0_rwl
+ u_t012_009/r2_r1_rwl u_t012_009/r3_w0_wl u_t012_009/r3_w1_wl u_t012_009/r3_r0_rwl u_t012_009/r3_r1_rwl VDD VSS VSUBS
+ detronyx_12t_2w2r_rc4_4x4_routed_5layer_direct
Xu_t003_009 u_t003_009/c0_w0_bl u_t003_009/c0_w0_br u_t003_009/c0_w1_bl u_t003_009/c0_w1_br u_t003_009/c0_r0_rbl
+ u_t003_009/c0_r1_rbl u_t003_009/c1_w0_bl u_t003_009/c1_w0_br u_t003_009/c1_w1_bl u_t003_009/c1_w1_br
+ u_t003_009/c1_r0_rbl u_t003_009/c1_r1_rbl u_t003_009/c2_w0_bl u_t003_009/c2_w0_br u_t003_009/c2_w1_bl
+ u_t003_009/c2_w1_br u_t003_009/c2_r0_rbl u_t003_009/c2_r1_rbl u_t003_009/c3_w0_bl u_t003_009/c3_w0_br
+ u_t003_009/c3_w1_bl u_t003_009/c3_w1_br u_t003_009/c3_r0_rbl u_t003_009/c3_r1_rbl u_t003_009/r0_w0_wl
+ u_t003_009/r0_w1_wl u_t003_009/r0_r0_rwl u_t003_009/r0_r1_rwl u_t003_009/r1_w0_wl u_t003_009/r1_w1_wl
+ u_t003_009/r1_r0_rwl u_t003_009/r1_r1_rwl u_t003_009/r2_w0_wl u_t003_009/r2_w1_wl u_t003_009/r2_r0_rwl
+ u_t003_009/r2_r1_rwl u_t003_009/r3_w0_wl u_t003_009/r3_w1_wl u_t003_009/r3_r0_rwl u_t003_009/r3_r1_rwl VDD VSS VSUBS
+ detronyx_12t_2w2r_rc4_4x4_routed_5layer_direct
Xu_t027_015 u_t027_015/c0_w0_bl u_t027_015/c0_w0_br u_t027_015/c0_w1_bl u_t027_015/c0_w1_br u_t027_015/c0_r0_rbl
+ u_t027_015/c0_r1_rbl u_t027_015/c1_w0_bl u_t027_015/c1_w0_br u_t027_015/c1_w1_bl u_t027_015/c1_w1_br
+ u_t027_015/c1_r0_rbl u_t027_015/c1_r1_rbl u_t027_015/c2_w0_bl u_t027_015/c2_w0_br u_t027_015/c2_w1_bl
+ u_t027_015/c2_w1_br u_t027_015/c2_r0_rbl u_t027_015/c2_r1_rbl u_t027_015/c3_w0_bl u_t027_015/c3_w0_br
+ u_t027_015/c3_w1_bl u_t027_015/c3_w1_br u_t027_015/c3_r0_rbl u_t027_015/c3_r1_rbl u_t027_015/r0_w0_wl
+ u_t027_015/r0_w1_wl u_t027_015/r0_r0_rwl u_t027_015/r0_r1_rwl u_t027_015/r1_w0_wl u_t027_015/r1_w1_wl
+ u_t027_015/r1_r0_rwl u_t027_015/r1_r1_rwl u_t027_015/r2_w0_wl u_t027_015/r2_w1_wl u_t027_015/r2_r0_rwl
+ u_t027_015/r2_r1_rwl u_t027_015/r3_w0_wl u_t027_015/r3_w1_wl u_t027_015/r3_r0_rwl u_t027_015/r3_r1_rwl VDD VSS VSUBS
+ detronyx_12t_2w2r_rc4_4x4_routed_5layer_direct
Xu_t027_004 u_t027_004/c0_w0_bl u_t027_004/c0_w0_br u_t027_004/c0_w1_bl u_t027_004/c0_w1_br u_t027_004/c0_r0_rbl
+ u_t027_004/c0_r1_rbl u_t027_004/c1_w0_bl u_t027_004/c1_w0_br u_t027_004/c1_w1_bl u_t027_004/c1_w1_br
+ u_t027_004/c1_r0_rbl u_t027_004/c1_r1_rbl u_t027_004/c2_w0_bl u_t027_004/c2_w0_br u_t027_004/c2_w1_bl
+ u_t027_004/c2_w1_br u_t027_004/c2_r0_rbl u_t027_004/c2_r1_rbl u_t027_004/c3_w0_bl u_t027_004/c3_w0_br
+ u_t027_004/c3_w1_bl u_t027_004/c3_w1_br u_t027_004/c3_r0_rbl u_t027_004/c3_r1_rbl u_t027_004/r0_w0_wl
+ u_t027_004/r0_w1_wl u_t027_004/r0_r0_rwl u_t027_004/r0_r1_rwl u_t027_004/r1_w0_wl u_t027_004/r1_w1_wl
+ u_t027_004/r1_r0_rwl u_t027_004/r1_r1_rwl u_t027_004/r2_w0_wl u_t027_004/r2_w1_wl u_t027_004/r2_r0_rwl
+ u_t027_004/r2_r1_rwl u_t027_004/r3_w0_wl u_t027_004/r3_w1_wl u_t027_004/r3_r0_rwl u_t027_004/r3_r1_rwl VDD VSS VSUBS
+ detronyx_12t_2w2r_rc4_4x4_routed_5layer_direct
Xu_t018_004 u_t018_004/c0_w0_bl u_t018_004/c0_w0_br u_t018_004/c0_w1_bl u_t018_004/c0_w1_br u_t018_004/c0_r0_rbl
+ u_t018_004/c0_r1_rbl u_t018_004/c1_w0_bl u_t018_004/c1_w0_br u_t018_004/c1_w1_bl u_t018_004/c1_w1_br
+ u_t018_004/c1_r0_rbl u_t018_004/c1_r1_rbl u_t018_004/c2_w0_bl u_t018_004/c2_w0_br u_t018_004/c2_w1_bl
+ u_t018_004/c2_w1_br u_t018_004/c2_r0_rbl u_t018_004/c2_r1_rbl u_t018_004/c3_w0_bl u_t018_004/c3_w0_br
+ u_t018_004/c3_w1_bl u_t018_004/c3_w1_br u_t018_004/c3_r0_rbl u_t018_004/c3_r1_rbl u_t018_004/r0_w0_wl
+ u_t018_004/r0_w1_wl u_t018_004/r0_r0_rwl u_t018_004/r0_r1_rwl u_t018_004/r1_w0_wl u_t018_004/r1_w1_wl
+ u_t018_004/r1_r0_rwl u_t018_004/r1_r1_rwl u_t018_004/r2_w0_wl u_t018_004/r2_w1_wl u_t018_004/r2_r0_rwl
+ u_t018_004/r2_r1_rwl u_t018_004/r3_w0_wl u_t018_004/r3_w1_wl u_t018_004/r3_r0_rwl u_t018_004/r3_r1_rwl VDD VSS VSUBS
+ detronyx_12t_2w2r_rc4_4x4_routed_5layer_direct
Xu_t018_015 u_t018_015/c0_w0_bl u_t018_015/c0_w0_br u_t018_015/c0_w1_bl u_t018_015/c0_w1_br u_t018_015/c0_r0_rbl
+ u_t018_015/c0_r1_rbl u_t018_015/c1_w0_bl u_t018_015/c1_w0_br u_t018_015/c1_w1_bl u_t018_015/c1_w1_br
+ u_t018_015/c1_r0_rbl u_t018_015/c1_r1_rbl u_t018_015/c2_w0_bl u_t018_015/c2_w0_br u_t018_015/c2_w1_bl
+ u_t018_015/c2_w1_br u_t018_015/c2_r0_rbl u_t018_015/c2_r1_rbl u_t018_015/c3_w0_bl u_t018_015/c3_w0_br
+ u_t018_015/c3_w1_bl u_t018_015/c3_w1_br u_t018_015/c3_r0_rbl u_t018_015/c3_r1_rbl u_t018_015/r0_w0_wl
+ u_t018_015/r0_w1_wl u_t018_015/r0_r0_rwl u_t018_015/r0_r1_rwl u_t018_015/r1_w0_wl u_t018_015/r1_w1_wl
+ u_t018_015/r1_r0_rwl u_t018_015/r1_r1_rwl u_t018_015/r2_w0_wl u_t018_015/r2_w1_wl u_t018_015/r2_r0_rwl
+ u_t018_015/r2_r1_rwl u_t018_015/r3_w0_wl u_t018_015/r3_w1_wl u_t018_015/r3_r0_rwl u_t018_015/r3_r1_rwl VDD VSS VSUBS
+ detronyx_12t_2w2r_rc4_4x4_routed_5layer_direct
Xu_t024_007 u_t024_007/c0_w0_bl u_t024_007/c0_w0_br u_t024_007/c0_w1_bl u_t024_007/c0_w1_br u_t024_007/c0_r0_rbl
+ u_t024_007/c0_r1_rbl u_t024_007/c1_w0_bl u_t024_007/c1_w0_br u_t024_007/c1_w1_bl u_t024_007/c1_w1_br
+ u_t024_007/c1_r0_rbl u_t024_007/c1_r1_rbl u_t024_007/c2_w0_bl u_t024_007/c2_w0_br u_t024_007/c2_w1_bl
+ u_t024_007/c2_w1_br u_t024_007/c2_r0_rbl u_t024_007/c2_r1_rbl u_t024_007/c3_w0_bl u_t024_007/c3_w0_br
+ u_t024_007/c3_w1_bl u_t024_007/c3_w1_br u_t024_007/c3_r0_rbl u_t024_007/c3_r1_rbl u_t024_007/r0_w0_wl
+ u_t024_007/r0_w1_wl u_t024_007/r0_r0_rwl u_t024_007/r0_r1_rwl u_t024_007/r1_w0_wl u_t024_007/r1_w1_wl
+ u_t024_007/r1_r0_rwl u_t024_007/r1_r1_rwl u_t024_007/r2_w0_wl u_t024_007/r2_w1_wl u_t024_007/r2_r0_rwl
+ u_t024_007/r2_r1_rwl u_t024_007/r3_w0_wl u_t024_007/r3_w1_wl u_t024_007/r3_r0_rwl u_t024_007/r3_r1_rwl VDD VSS VSUBS
+ detronyx_12t_2w2r_rc4_4x4_routed_5layer_direct
Xu_t009_004 u_t009_004/c0_w0_bl u_t009_004/c0_w0_br u_t009_004/c0_w1_bl u_t009_004/c0_w1_br u_t009_004/c0_r0_rbl
+ u_t009_004/c0_r1_rbl u_t009_004/c1_w0_bl u_t009_004/c1_w0_br u_t009_004/c1_w1_bl u_t009_004/c1_w1_br
+ u_t009_004/c1_r0_rbl u_t009_004/c1_r1_rbl u_t009_004/c2_w0_bl u_t009_004/c2_w0_br u_t009_004/c2_w1_bl
+ u_t009_004/c2_w1_br u_t009_004/c2_r0_rbl u_t009_004/c2_r1_rbl u_t009_004/c3_w0_bl u_t009_004/c3_w0_br
+ u_t009_004/c3_w1_bl u_t009_004/c3_w1_br u_t009_004/c3_r0_rbl u_t009_004/c3_r1_rbl u_t009_004/r0_w0_wl
+ u_t009_004/r0_w1_wl u_t009_004/r0_r0_rwl u_t009_004/r0_r1_rwl u_t009_004/r1_w0_wl u_t009_004/r1_w1_wl
+ u_t009_004/r1_r0_rwl u_t009_004/r1_r1_rwl u_t009_004/r2_w0_wl u_t009_004/r2_w1_wl u_t009_004/r2_r0_rwl
+ u_t009_004/r2_r1_rwl u_t009_004/r3_w0_wl u_t009_004/r3_w1_wl u_t009_004/r3_r0_rwl u_t009_004/r3_r1_rwl VDD VSS VSUBS
+ detronyx_12t_2w2r_rc4_4x4_routed_5layer_direct
Xu_t009_015 u_t009_015/c0_w0_bl u_t009_015/c0_w0_br u_t009_015/c0_w1_bl u_t009_015/c0_w1_br u_t009_015/c0_r0_rbl
+ u_t009_015/c0_r1_rbl u_t009_015/c1_w0_bl u_t009_015/c1_w0_br u_t009_015/c1_w1_bl u_t009_015/c1_w1_br
+ u_t009_015/c1_r0_rbl u_t009_015/c1_r1_rbl u_t009_015/c2_w0_bl u_t009_015/c2_w0_br u_t009_015/c2_w1_bl
+ u_t009_015/c2_w1_br u_t009_015/c2_r0_rbl u_t009_015/c2_r1_rbl u_t009_015/c3_w0_bl u_t009_015/c3_w0_br
+ u_t009_015/c3_w1_bl u_t009_015/c3_w1_br u_t009_015/c3_r0_rbl u_t009_015/c3_r1_rbl u_t009_015/r0_w0_wl
+ u_t009_015/r0_w1_wl u_t009_015/r0_r0_rwl u_t009_015/r0_r1_rwl u_t009_015/r1_w0_wl u_t009_015/r1_w1_wl
+ u_t009_015/r1_r0_rwl u_t009_015/r1_r1_rwl u_t009_015/r2_w0_wl u_t009_015/r2_w1_wl u_t009_015/r2_r0_rwl
+ u_t009_015/r2_r1_rwl u_t009_015/r3_w0_wl u_t009_015/r3_w1_wl u_t009_015/r3_r0_rwl u_t009_015/r3_r1_rwl VDD VSS VSUBS
+ detronyx_12t_2w2r_rc4_4x4_routed_5layer_direct
Xu_t006_007 u_t006_007/c0_w0_bl u_t006_007/c0_w0_br u_t006_007/c0_w1_bl u_t006_007/c0_w1_br u_t006_007/c0_r0_rbl
+ u_t006_007/c0_r1_rbl u_t006_007/c1_w0_bl u_t006_007/c1_w0_br u_t006_007/c1_w1_bl u_t006_007/c1_w1_br
+ u_t006_007/c1_r0_rbl u_t006_007/c1_r1_rbl u_t006_007/c2_w0_bl u_t006_007/c2_w0_br u_t006_007/c2_w1_bl
+ u_t006_007/c2_w1_br u_t006_007/c2_r0_rbl u_t006_007/c2_r1_rbl u_t006_007/c3_w0_bl u_t006_007/c3_w0_br
+ u_t006_007/c3_w1_bl u_t006_007/c3_w1_br u_t006_007/c3_r0_rbl u_t006_007/c3_r1_rbl u_t006_007/r0_w0_wl
+ u_t006_007/r0_w1_wl u_t006_007/r0_r0_rwl u_t006_007/r0_r1_rwl u_t006_007/r1_w0_wl u_t006_007/r1_w1_wl
+ u_t006_007/r1_r0_rwl u_t006_007/r1_r1_rwl u_t006_007/r2_w0_wl u_t006_007/r2_w1_wl u_t006_007/r2_r0_rwl
+ u_t006_007/r2_r1_rwl u_t006_007/r3_w0_wl u_t006_007/r3_w1_wl u_t006_007/r3_r0_rwl u_t006_007/r3_r1_rwl VDD VSS VSUBS
+ detronyx_12t_2w2r_rc4_4x4_routed_5layer_direct
Xu_t015_007 u_t015_007/c0_w0_bl u_t015_007/c0_w0_br u_t015_007/c0_w1_bl u_t015_007/c0_w1_br u_t015_007/c0_r0_rbl
+ u_t015_007/c0_r1_rbl u_t015_007/c1_w0_bl u_t015_007/c1_w0_br u_t015_007/c1_w1_bl u_t015_007/c1_w1_br
+ u_t015_007/c1_r0_rbl u_t015_007/c1_r1_rbl u_t015_007/c2_w0_bl u_t015_007/c2_w0_br u_t015_007/c2_w1_bl
+ u_t015_007/c2_w1_br u_t015_007/c2_r0_rbl u_t015_007/c2_r1_rbl u_t015_007/c3_w0_bl u_t015_007/c3_w0_br
+ u_t015_007/c3_w1_bl u_t015_007/c3_w1_br u_t015_007/c3_r0_rbl u_t015_007/c3_r1_rbl u_t015_007/r0_w0_wl
+ u_t015_007/r0_w1_wl u_t015_007/r0_r0_rwl u_t015_007/r0_r1_rwl u_t015_007/r1_w0_wl u_t015_007/r1_w1_wl
+ u_t015_007/r1_r0_rwl u_t015_007/r1_r1_rwl u_t015_007/r2_w0_wl u_t015_007/r2_w1_wl u_t015_007/r2_r0_rwl
+ u_t015_007/r2_r1_rwl u_t015_007/r3_w0_wl u_t015_007/r3_w1_wl u_t015_007/r3_r0_rwl u_t015_007/r3_r1_rwl VDD VSS VSUBS
+ detronyx_12t_2w2r_rc4_4x4_routed_5layer_direct
Xu_t011_010 u_t011_010/c0_w0_bl u_t011_010/c0_w0_br u_t011_010/c0_w1_bl u_t011_010/c0_w1_br u_t011_010/c0_r0_rbl
+ u_t011_010/c0_r1_rbl u_t011_010/c1_w0_bl u_t011_010/c1_w0_br u_t011_010/c1_w1_bl u_t011_010/c1_w1_br
+ u_t011_010/c1_r0_rbl u_t011_010/c1_r1_rbl u_t011_010/c2_w0_bl u_t011_010/c2_w0_br u_t011_010/c2_w1_bl
+ u_t011_010/c2_w1_br u_t011_010/c2_r0_rbl u_t011_010/c2_r1_rbl u_t011_010/c3_w0_bl u_t011_010/c3_w0_br
+ u_t011_010/c3_w1_bl u_t011_010/c3_w1_br u_t011_010/c3_r0_rbl u_t011_010/c3_r1_rbl u_t011_010/r0_w0_wl
+ u_t011_010/r0_w1_wl u_t011_010/r0_r0_rwl u_t011_010/r0_r1_rwl u_t011_010/r1_w0_wl u_t011_010/r1_w1_wl
+ u_t011_010/r1_r0_rwl u_t011_010/r1_r1_rwl u_t011_010/r2_w0_wl u_t011_010/r2_w1_wl u_t011_010/r2_r0_rwl
+ u_t011_010/r2_r1_rwl u_t011_010/r3_w0_wl u_t011_010/r3_w1_wl u_t011_010/r3_r0_rwl u_t011_010/r3_r1_rwl VDD VSS VSUBS
+ detronyx_12t_2w2r_rc4_4x4_routed_5layer_direct
Xu_t020_010 u_t020_010/c0_w0_bl u_t020_010/c0_w0_br u_t020_010/c0_w1_bl u_t020_010/c0_w1_br u_t020_010/c0_r0_rbl
+ u_t020_010/c0_r1_rbl u_t020_010/c1_w0_bl u_t020_010/c1_w0_br u_t020_010/c1_w1_bl u_t020_010/c1_w1_br
+ u_t020_010/c1_r0_rbl u_t020_010/c1_r1_rbl u_t020_010/c2_w0_bl u_t020_010/c2_w0_br u_t020_010/c2_w1_bl
+ u_t020_010/c2_w1_br u_t020_010/c2_r0_rbl u_t020_010/c2_r1_rbl u_t020_010/c3_w0_bl u_t020_010/c3_w0_br
+ u_t020_010/c3_w1_bl u_t020_010/c3_w1_br u_t020_010/c3_r0_rbl u_t020_010/c3_r1_rbl u_t020_010/r0_w0_wl
+ u_t020_010/r0_w1_wl u_t020_010/r0_r0_rwl u_t020_010/r0_r1_rwl u_t020_010/r1_w0_wl u_t020_010/r1_w1_wl
+ u_t020_010/r1_r0_rwl u_t020_010/r1_r1_rwl u_t020_010/r2_w0_wl u_t020_010/r2_w1_wl u_t020_010/r2_r0_rwl
+ u_t020_010/r2_r1_rwl u_t020_010/r3_w0_wl u_t020_010/r3_w1_wl u_t020_010/r3_r0_rwl u_t020_010/r3_r1_rwl VDD VSS VSUBS
+ detronyx_12t_2w2r_rc4_4x4_routed_5layer_direct
Xu_t002_010 u_t002_010/c0_w0_bl u_t002_010/c0_w0_br u_t002_010/c0_w1_bl u_t002_010/c0_w1_br u_t002_010/c0_r0_rbl
+ u_t002_010/c0_r1_rbl u_t002_010/c1_w0_bl u_t002_010/c1_w0_br u_t002_010/c1_w1_bl u_t002_010/c1_w1_br
+ u_t002_010/c1_r0_rbl u_t002_010/c1_r1_rbl u_t002_010/c2_w0_bl u_t002_010/c2_w0_br u_t002_010/c2_w1_bl
+ u_t002_010/c2_w1_br u_t002_010/c2_r0_rbl u_t002_010/c2_r1_rbl u_t002_010/c3_w0_bl u_t002_010/c3_w0_br
+ u_t002_010/c3_w1_bl u_t002_010/c3_w1_br u_t002_010/c3_r0_rbl u_t002_010/c3_r1_rbl u_t002_010/r0_w0_wl
+ u_t002_010/r0_w1_wl u_t002_010/r0_r0_rwl u_t002_010/r0_r1_rwl u_t002_010/r1_w0_wl u_t002_010/r1_w1_wl
+ u_t002_010/r1_r0_rwl u_t002_010/r1_r1_rwl u_t002_010/r2_w0_wl u_t002_010/r2_w1_wl u_t002_010/r2_r0_rwl
+ u_t002_010/r2_r1_rwl u_t002_010/r3_w0_wl u_t002_010/r3_w1_wl u_t002_010/r3_r0_rwl u_t002_010/r3_r1_rwl VDD VSS VSUBS
+ detronyx_12t_2w2r_rc4_4x4_routed_5layer_direct
Xu_t027_005 u_t027_005/c0_w0_bl u_t027_005/c0_w0_br u_t027_005/c0_w1_bl u_t027_005/c0_w1_br u_t027_005/c0_r0_rbl
+ u_t027_005/c0_r1_rbl u_t027_005/c1_w0_bl u_t027_005/c1_w0_br u_t027_005/c1_w1_bl u_t027_005/c1_w1_br
+ u_t027_005/c1_r0_rbl u_t027_005/c1_r1_rbl u_t027_005/c2_w0_bl u_t027_005/c2_w0_br u_t027_005/c2_w1_bl
+ u_t027_005/c2_w1_br u_t027_005/c2_r0_rbl u_t027_005/c2_r1_rbl u_t027_005/c3_w0_bl u_t027_005/c3_w0_br
+ u_t027_005/c3_w1_bl u_t027_005/c3_w1_br u_t027_005/c3_r0_rbl u_t027_005/c3_r1_rbl u_t027_005/r0_w0_wl
+ u_t027_005/r0_w1_wl u_t027_005/r0_r0_rwl u_t027_005/r0_r1_rwl u_t027_005/r1_w0_wl u_t027_005/r1_w1_wl
+ u_t027_005/r1_r0_rwl u_t027_005/r1_r1_rwl u_t027_005/r2_w0_wl u_t027_005/r2_w1_wl u_t027_005/r2_r0_rwl
+ u_t027_005/r2_r1_rwl u_t027_005/r3_w0_wl u_t027_005/r3_w1_wl u_t027_005/r3_r0_rwl u_t027_005/r3_r1_rwl VDD VSS VSUBS
+ detronyx_12t_2w2r_rc4_4x4_routed_5layer_direct
Xu_t018_005 u_t018_005/c0_w0_bl u_t018_005/c0_w0_br u_t018_005/c0_w1_bl u_t018_005/c0_w1_br u_t018_005/c0_r0_rbl
+ u_t018_005/c0_r1_rbl u_t018_005/c1_w0_bl u_t018_005/c1_w0_br u_t018_005/c1_w1_bl u_t018_005/c1_w1_br
+ u_t018_005/c1_r0_rbl u_t018_005/c1_r1_rbl u_t018_005/c2_w0_bl u_t018_005/c2_w0_br u_t018_005/c2_w1_bl
+ u_t018_005/c2_w1_br u_t018_005/c2_r0_rbl u_t018_005/c2_r1_rbl u_t018_005/c3_w0_bl u_t018_005/c3_w0_br
+ u_t018_005/c3_w1_bl u_t018_005/c3_w1_br u_t018_005/c3_r0_rbl u_t018_005/c3_r1_rbl u_t018_005/r0_w0_wl
+ u_t018_005/r0_w1_wl u_t018_005/r0_r0_rwl u_t018_005/r0_r1_rwl u_t018_005/r1_w0_wl u_t018_005/r1_w1_wl
+ u_t018_005/r1_r0_rwl u_t018_005/r1_r1_rwl u_t018_005/r2_w0_wl u_t018_005/r2_w1_wl u_t018_005/r2_r0_rwl
+ u_t018_005/r2_r1_rwl u_t018_005/r3_w0_wl u_t018_005/r3_w1_wl u_t018_005/r3_r0_rwl u_t018_005/r3_r1_rwl VDD VSS VSUBS
+ detronyx_12t_2w2r_rc4_4x4_routed_5layer_direct
Xu_t024_008 u_t024_008/c0_w0_bl u_t024_008/c0_w0_br u_t024_008/c0_w1_bl u_t024_008/c0_w1_br u_t024_008/c0_r0_rbl
+ u_t024_008/c0_r1_rbl u_t024_008/c1_w0_bl u_t024_008/c1_w0_br u_t024_008/c1_w1_bl u_t024_008/c1_w1_br
+ u_t024_008/c1_r0_rbl u_t024_008/c1_r1_rbl u_t024_008/c2_w0_bl u_t024_008/c2_w0_br u_t024_008/c2_w1_bl
+ u_t024_008/c2_w1_br u_t024_008/c2_r0_rbl u_t024_008/c2_r1_rbl u_t024_008/c3_w0_bl u_t024_008/c3_w0_br
+ u_t024_008/c3_w1_bl u_t024_008/c3_w1_br u_t024_008/c3_r0_rbl u_t024_008/c3_r1_rbl u_t024_008/r0_w0_wl
+ u_t024_008/r0_w1_wl u_t024_008/r0_r0_rwl u_t024_008/r0_r1_rwl u_t024_008/r1_w0_wl u_t024_008/r1_w1_wl
+ u_t024_008/r1_r0_rwl u_t024_008/r1_r1_rwl u_t024_008/r2_w0_wl u_t024_008/r2_w1_wl u_t024_008/r2_r0_rwl
+ u_t024_008/r2_r1_rwl u_t024_008/r3_w0_wl u_t024_008/r3_w1_wl u_t024_008/r3_r0_rwl u_t024_008/r3_r1_rwl VDD VSS VSUBS
+ detronyx_12t_2w2r_rc4_4x4_routed_5layer_direct
Xu_t009_005 u_t009_005/c0_w0_bl u_t009_005/c0_w0_br u_t009_005/c0_w1_bl u_t009_005/c0_w1_br u_t009_005/c0_r0_rbl
+ u_t009_005/c0_r1_rbl u_t009_005/c1_w0_bl u_t009_005/c1_w0_br u_t009_005/c1_w1_bl u_t009_005/c1_w1_br
+ u_t009_005/c1_r0_rbl u_t009_005/c1_r1_rbl u_t009_005/c2_w0_bl u_t009_005/c2_w0_br u_t009_005/c2_w1_bl
+ u_t009_005/c2_w1_br u_t009_005/c2_r0_rbl u_t009_005/c2_r1_rbl u_t009_005/c3_w0_bl u_t009_005/c3_w0_br
+ u_t009_005/c3_w1_bl u_t009_005/c3_w1_br u_t009_005/c3_r0_rbl u_t009_005/c3_r1_rbl u_t009_005/r0_w0_wl
+ u_t009_005/r0_w1_wl u_t009_005/r0_r0_rwl u_t009_005/r0_r1_rwl u_t009_005/r1_w0_wl u_t009_005/r1_w1_wl
+ u_t009_005/r1_r0_rwl u_t009_005/r1_r1_rwl u_t009_005/r2_w0_wl u_t009_005/r2_w1_wl u_t009_005/r2_r0_rwl
+ u_t009_005/r2_r1_rwl u_t009_005/r3_w0_wl u_t009_005/r3_w1_wl u_t009_005/r3_r0_rwl u_t009_005/r3_r1_rwl VDD VSS VSUBS
+ detronyx_12t_2w2r_rc4_4x4_routed_5layer_direct
Xu_t015_008 u_t015_008/c0_w0_bl u_t015_008/c0_w0_br u_t015_008/c0_w1_bl u_t015_008/c0_w1_br u_t015_008/c0_r0_rbl
+ u_t015_008/c0_r1_rbl u_t015_008/c1_w0_bl u_t015_008/c1_w0_br u_t015_008/c1_w1_bl u_t015_008/c1_w1_br
+ u_t015_008/c1_r0_rbl u_t015_008/c1_r1_rbl u_t015_008/c2_w0_bl u_t015_008/c2_w0_br u_t015_008/c2_w1_bl
+ u_t015_008/c2_w1_br u_t015_008/c2_r0_rbl u_t015_008/c2_r1_rbl u_t015_008/c3_w0_bl u_t015_008/c3_w0_br
+ u_t015_008/c3_w1_bl u_t015_008/c3_w1_br u_t015_008/c3_r0_rbl u_t015_008/c3_r1_rbl u_t015_008/r0_w0_wl
+ u_t015_008/r0_w1_wl u_t015_008/r0_r0_rwl u_t015_008/r0_r1_rwl u_t015_008/r1_w0_wl u_t015_008/r1_w1_wl
+ u_t015_008/r1_r0_rwl u_t015_008/r1_r1_rwl u_t015_008/r2_w0_wl u_t015_008/r2_w1_wl u_t015_008/r2_r0_rwl
+ u_t015_008/r2_r1_rwl u_t015_008/r3_w0_wl u_t015_008/r3_w1_wl u_t015_008/r3_r0_rwl u_t015_008/r3_r1_rwl VDD VSS VSUBS
+ detronyx_12t_2w2r_rc4_4x4_routed_5layer_direct
Xu_t006_008 u_t006_008/c0_w0_bl u_t006_008/c0_w0_br u_t006_008/c0_w1_bl u_t006_008/c0_w1_br u_t006_008/c0_r0_rbl
+ u_t006_008/c0_r1_rbl u_t006_008/c1_w0_bl u_t006_008/c1_w0_br u_t006_008/c1_w1_bl u_t006_008/c1_w1_br
+ u_t006_008/c1_r0_rbl u_t006_008/c1_r1_rbl u_t006_008/c2_w0_bl u_t006_008/c2_w0_br u_t006_008/c2_w1_bl
+ u_t006_008/c2_w1_br u_t006_008/c2_r0_rbl u_t006_008/c2_r1_rbl u_t006_008/c3_w0_bl u_t006_008/c3_w0_br
+ u_t006_008/c3_w1_bl u_t006_008/c3_w1_br u_t006_008/c3_r0_rbl u_t006_008/c3_r1_rbl u_t006_008/r0_w0_wl
+ u_t006_008/r0_w1_wl u_t006_008/r0_r0_rwl u_t006_008/r0_r1_rwl u_t006_008/r1_w0_wl u_t006_008/r1_w1_wl
+ u_t006_008/r1_r0_rwl u_t006_008/r1_r1_rwl u_t006_008/r2_w0_wl u_t006_008/r2_w1_wl u_t006_008/r2_r0_rwl
+ u_t006_008/r2_r1_rwl u_t006_008/r3_w0_wl u_t006_008/r3_w1_wl u_t006_008/r3_r0_rwl u_t006_008/r3_r1_rwl VDD VSS VSUBS
+ detronyx_12t_2w2r_rc4_4x4_routed_5layer_direct
Xu_t020_000 u_t020_000/c0_w0_bl u_t020_000/c0_w0_br u_t020_000/c0_w1_bl u_t020_000/c0_w1_br u_t020_000/c0_r0_rbl
+ u_t020_000/c0_r1_rbl u_t020_000/c1_w0_bl u_t020_000/c1_w0_br u_t020_000/c1_w1_bl u_t020_000/c1_w1_br
+ u_t020_000/c1_r0_rbl u_t020_000/c1_r1_rbl u_t020_000/c2_w0_bl u_t020_000/c2_w0_br u_t020_000/c2_w1_bl
+ u_t020_000/c2_w1_br u_t020_000/c2_r0_rbl u_t020_000/c2_r1_rbl u_t020_000/c3_w0_bl u_t020_000/c3_w0_br
+ u_t020_000/c3_w1_bl u_t020_000/c3_w1_br u_t020_000/c3_r0_rbl u_t020_000/c3_r1_rbl u_t020_000/r0_w0_wl
+ u_t020_000/r0_w1_wl u_t020_000/r0_r0_rwl u_t020_000/r0_r1_rwl u_t020_000/r1_w0_wl u_t020_000/r1_w1_wl
+ u_t020_000/r1_r0_rwl u_t020_000/r1_r1_rwl u_t020_000/r2_w0_wl u_t020_000/r2_w1_wl u_t020_000/r2_r0_rwl
+ u_t020_000/r2_r1_rwl u_t020_000/r3_w0_wl u_t020_000/r3_w1_wl u_t020_000/r3_r0_rwl u_t020_000/r3_r1_rwl VDD VSS VSUBS
+ detronyx_12t_2w2r_rc4_4x4_routed_5layer_direct
Xu_t020_011 u_t020_011/c0_w0_bl u_t020_011/c0_w0_br u_t020_011/c0_w1_bl u_t020_011/c0_w1_br u_t020_011/c0_r0_rbl
+ u_t020_011/c0_r1_rbl u_t020_011/c1_w0_bl u_t020_011/c1_w0_br u_t020_011/c1_w1_bl u_t020_011/c1_w1_br
+ u_t020_011/c1_r0_rbl u_t020_011/c1_r1_rbl u_t020_011/c2_w0_bl u_t020_011/c2_w0_br u_t020_011/c2_w1_bl
+ u_t020_011/c2_w1_br u_t020_011/c2_r0_rbl u_t020_011/c2_r1_rbl u_t020_011/c3_w0_bl u_t020_011/c3_w0_br
+ u_t020_011/c3_w1_bl u_t020_011/c3_w1_br u_t020_011/c3_r0_rbl u_t020_011/c3_r1_rbl u_t020_011/r0_w0_wl
+ u_t020_011/r0_w1_wl u_t020_011/r0_r0_rwl u_t020_011/r0_r1_rwl u_t020_011/r1_w0_wl u_t020_011/r1_w1_wl
+ u_t020_011/r1_r0_rwl u_t020_011/r1_r1_rwl u_t020_011/r2_w0_wl u_t020_011/r2_w1_wl u_t020_011/r2_r0_rwl
+ u_t020_011/r2_r1_rwl u_t020_011/r3_w0_wl u_t020_011/r3_w1_wl u_t020_011/r3_r0_rwl u_t020_011/r3_r1_rwl VDD VSS VSUBS
+ detronyx_12t_2w2r_rc4_4x4_routed_5layer_direct
Xu_t011_000 u_t011_000/c0_w0_bl u_t011_000/c0_w0_br u_t011_000/c0_w1_bl u_t011_000/c0_w1_br u_t011_000/c0_r0_rbl
+ u_t011_000/c0_r1_rbl u_t011_000/c1_w0_bl u_t011_000/c1_w0_br u_t011_000/c1_w1_bl u_t011_000/c1_w1_br
+ u_t011_000/c1_r0_rbl u_t011_000/c1_r1_rbl u_t011_000/c2_w0_bl u_t011_000/c2_w0_br u_t011_000/c2_w1_bl
+ u_t011_000/c2_w1_br u_t011_000/c2_r0_rbl u_t011_000/c2_r1_rbl u_t011_000/c3_w0_bl u_t011_000/c3_w0_br
+ u_t011_000/c3_w1_bl u_t011_000/c3_w1_br u_t011_000/c3_r0_rbl u_t011_000/c3_r1_rbl u_t011_000/r0_w0_wl
+ u_t011_000/r0_w1_wl u_t011_000/r0_r0_rwl u_t011_000/r0_r1_rwl u_t011_000/r1_w0_wl u_t011_000/r1_w1_wl
+ u_t011_000/r1_r0_rwl u_t011_000/r1_r1_rwl u_t011_000/r2_w0_wl u_t011_000/r2_w1_wl u_t011_000/r2_r0_rwl
+ u_t011_000/r2_r1_rwl u_t011_000/r3_w0_wl u_t011_000/r3_w1_wl u_t011_000/r3_r0_rwl u_t011_000/r3_r1_rwl VDD VSS VSUBS
+ detronyx_12t_2w2r_rc4_4x4_routed_5layer_direct
Xu_t011_011 u_t011_011/c0_w0_bl u_t011_011/c0_w0_br u_t011_011/c0_w1_bl u_t011_011/c0_w1_br u_t011_011/c0_r0_rbl
+ u_t011_011/c0_r1_rbl u_t011_011/c1_w0_bl u_t011_011/c1_w0_br u_t011_011/c1_w1_bl u_t011_011/c1_w1_br
+ u_t011_011/c1_r0_rbl u_t011_011/c1_r1_rbl u_t011_011/c2_w0_bl u_t011_011/c2_w0_br u_t011_011/c2_w1_bl
+ u_t011_011/c2_w1_br u_t011_011/c2_r0_rbl u_t011_011/c2_r1_rbl u_t011_011/c3_w0_bl u_t011_011/c3_w0_br
+ u_t011_011/c3_w1_bl u_t011_011/c3_w1_br u_t011_011/c3_r0_rbl u_t011_011/c3_r1_rbl u_t011_011/r0_w0_wl
+ u_t011_011/r0_w1_wl u_t011_011/r0_r0_rwl u_t011_011/r0_r1_rwl u_t011_011/r1_w0_wl u_t011_011/r1_w1_wl
+ u_t011_011/r1_r0_rwl u_t011_011/r1_r1_rwl u_t011_011/r2_w0_wl u_t011_011/r2_w1_wl u_t011_011/r2_r0_rwl
+ u_t011_011/r2_r1_rwl u_t011_011/r3_w0_wl u_t011_011/r3_w1_wl u_t011_011/r3_r0_rwl u_t011_011/r3_r1_rwl VDD VSS VSUBS
+ detronyx_12t_2w2r_rc4_4x4_routed_5layer_direct
Xu_t002_011 u_t002_011/c0_w0_bl u_t002_011/c0_w0_br u_t002_011/c0_w1_bl u_t002_011/c0_w1_br u_t002_011/c0_r0_rbl
+ u_t002_011/c0_r1_rbl u_t002_011/c1_w0_bl u_t002_011/c1_w0_br u_t002_011/c1_w1_bl u_t002_011/c1_w1_br
+ u_t002_011/c1_r0_rbl u_t002_011/c1_r1_rbl u_t002_011/c2_w0_bl u_t002_011/c2_w0_br u_t002_011/c2_w1_bl
+ u_t002_011/c2_w1_br u_t002_011/c2_r0_rbl u_t002_011/c2_r1_rbl u_t002_011/c3_w0_bl u_t002_011/c3_w0_br
+ u_t002_011/c3_w1_bl u_t002_011/c3_w1_br u_t002_011/c3_r0_rbl u_t002_011/c3_r1_rbl u_t002_011/r0_w0_wl
+ u_t002_011/r0_w1_wl u_t002_011/r0_r0_rwl u_t002_011/r0_r1_rwl u_t002_011/r1_w0_wl u_t002_011/r1_w1_wl
+ u_t002_011/r1_r0_rwl u_t002_011/r1_r1_rwl u_t002_011/r2_w0_wl u_t002_011/r2_w1_wl u_t002_011/r2_r0_rwl
+ u_t002_011/r2_r1_rwl u_t002_011/r3_w0_wl u_t002_011/r3_w1_wl u_t002_011/r3_r0_rwl u_t002_011/r3_r1_rwl VDD VSS VSUBS
+ detronyx_12t_2w2r_rc4_4x4_routed_5layer_direct
Xu_t002_000 u_t002_000/c0_w0_bl u_t002_000/c0_w0_br u_t002_000/c0_w1_bl u_t002_000/c0_w1_br u_t002_000/c0_r0_rbl
+ u_t002_000/c0_r1_rbl u_t002_000/c1_w0_bl u_t002_000/c1_w0_br u_t002_000/c1_w1_bl u_t002_000/c1_w1_br
+ u_t002_000/c1_r0_rbl u_t002_000/c1_r1_rbl u_t002_000/c2_w0_bl u_t002_000/c2_w0_br u_t002_000/c2_w1_bl
+ u_t002_000/c2_w1_br u_t002_000/c2_r0_rbl u_t002_000/c2_r1_rbl u_t002_000/c3_w0_bl u_t002_000/c3_w0_br
+ u_t002_000/c3_w1_bl u_t002_000/c3_w1_br u_t002_000/c3_r0_rbl u_t002_000/c3_r1_rbl u_t002_000/r0_w0_wl
+ u_t002_000/r0_w1_wl u_t002_000/r0_r0_rwl u_t002_000/r0_r1_rwl u_t002_000/r1_w0_wl u_t002_000/r1_w1_wl
+ u_t002_000/r1_r0_rwl u_t002_000/r1_r1_rwl u_t002_000/r2_w0_wl u_t002_000/r2_w1_wl u_t002_000/r2_r0_rwl
+ u_t002_000/r2_r1_rwl u_t002_000/r3_w0_wl u_t002_000/r3_w1_wl u_t002_000/r3_r0_rwl u_t002_000/r3_r1_rwl VDD VSS VSUBS
+ detronyx_12t_2w2r_rc4_4x4_routed_5layer_direct
Xu_t027_006 u_t027_006/c0_w0_bl u_t027_006/c0_w0_br u_t027_006/c0_w1_bl u_t027_006/c0_w1_br u_t027_006/c0_r0_rbl
+ u_t027_006/c0_r1_rbl u_t027_006/c1_w0_bl u_t027_006/c1_w0_br u_t027_006/c1_w1_bl u_t027_006/c1_w1_br
+ u_t027_006/c1_r0_rbl u_t027_006/c1_r1_rbl u_t027_006/c2_w0_bl u_t027_006/c2_w0_br u_t027_006/c2_w1_bl
+ u_t027_006/c2_w1_br u_t027_006/c2_r0_rbl u_t027_006/c2_r1_rbl u_t027_006/c3_w0_bl u_t027_006/c3_w0_br
+ u_t027_006/c3_w1_bl u_t027_006/c3_w1_br u_t027_006/c3_r0_rbl u_t027_006/c3_r1_rbl u_t027_006/r0_w0_wl
+ u_t027_006/r0_w1_wl u_t027_006/r0_r0_rwl u_t027_006/r0_r1_rwl u_t027_006/r1_w0_wl u_t027_006/r1_w1_wl
+ u_t027_006/r1_r0_rwl u_t027_006/r1_r1_rwl u_t027_006/r2_w0_wl u_t027_006/r2_w1_wl u_t027_006/r2_r0_rwl
+ u_t027_006/r2_r1_rwl u_t027_006/r3_w0_wl u_t027_006/r3_w1_wl u_t027_006/r3_r0_rwl u_t027_006/r3_r1_rwl VDD VSS VSUBS
+ detronyx_12t_2w2r_rc4_4x4_routed_5layer_direct
Xu_t018_006 u_t018_006/c0_w0_bl u_t018_006/c0_w0_br u_t018_006/c0_w1_bl u_t018_006/c0_w1_br u_t018_006/c0_r0_rbl
+ u_t018_006/c0_r1_rbl u_t018_006/c1_w0_bl u_t018_006/c1_w0_br u_t018_006/c1_w1_bl u_t018_006/c1_w1_br
+ u_t018_006/c1_r0_rbl u_t018_006/c1_r1_rbl u_t018_006/c2_w0_bl u_t018_006/c2_w0_br u_t018_006/c2_w1_bl
+ u_t018_006/c2_w1_br u_t018_006/c2_r0_rbl u_t018_006/c2_r1_rbl u_t018_006/c3_w0_bl u_t018_006/c3_w0_br
+ u_t018_006/c3_w1_bl u_t018_006/c3_w1_br u_t018_006/c3_r0_rbl u_t018_006/c3_r1_rbl u_t018_006/r0_w0_wl
+ u_t018_006/r0_w1_wl u_t018_006/r0_r0_rwl u_t018_006/r0_r1_rwl u_t018_006/r1_w0_wl u_t018_006/r1_w1_wl
+ u_t018_006/r1_r0_rwl u_t018_006/r1_r1_rwl u_t018_006/r2_w0_wl u_t018_006/r2_w1_wl u_t018_006/r2_r0_rwl
+ u_t018_006/r2_r1_rwl u_t018_006/r3_w0_wl u_t018_006/r3_w1_wl u_t018_006/r3_r0_rwl u_t018_006/r3_r1_rwl VDD VSS VSUBS
+ detronyx_12t_2w2r_rc4_4x4_routed_5layer_direct
Xu_t024_009 u_t024_009/c0_w0_bl u_t024_009/c0_w0_br u_t024_009/c0_w1_bl u_t024_009/c0_w1_br u_t024_009/c0_r0_rbl
+ u_t024_009/c0_r1_rbl u_t024_009/c1_w0_bl u_t024_009/c1_w0_br u_t024_009/c1_w1_bl u_t024_009/c1_w1_br
+ u_t024_009/c1_r0_rbl u_t024_009/c1_r1_rbl u_t024_009/c2_w0_bl u_t024_009/c2_w0_br u_t024_009/c2_w1_bl
+ u_t024_009/c2_w1_br u_t024_009/c2_r0_rbl u_t024_009/c2_r1_rbl u_t024_009/c3_w0_bl u_t024_009/c3_w0_br
+ u_t024_009/c3_w1_bl u_t024_009/c3_w1_br u_t024_009/c3_r0_rbl u_t024_009/c3_r1_rbl u_t024_009/r0_w0_wl
+ u_t024_009/r0_w1_wl u_t024_009/r0_r0_rwl u_t024_009/r0_r1_rwl u_t024_009/r1_w0_wl u_t024_009/r1_w1_wl
+ u_t024_009/r1_r0_rwl u_t024_009/r1_r1_rwl u_t024_009/r2_w0_wl u_t024_009/r2_w1_wl u_t024_009/r2_r0_rwl
+ u_t024_009/r2_r1_rwl u_t024_009/r3_w0_wl u_t024_009/r3_w1_wl u_t024_009/r3_r0_rwl u_t024_009/r3_r1_rwl VDD VSS VSUBS
+ detronyx_12t_2w2r_rc4_4x4_routed_5layer_direct
Xu_t009_006 u_t009_006/c0_w0_bl u_t009_006/c0_w0_br u_t009_006/c0_w1_bl u_t009_006/c0_w1_br u_t009_006/c0_r0_rbl
+ u_t009_006/c0_r1_rbl u_t009_006/c1_w0_bl u_t009_006/c1_w0_br u_t009_006/c1_w1_bl u_t009_006/c1_w1_br
+ u_t009_006/c1_r0_rbl u_t009_006/c1_r1_rbl u_t009_006/c2_w0_bl u_t009_006/c2_w0_br u_t009_006/c2_w1_bl
+ u_t009_006/c2_w1_br u_t009_006/c2_r0_rbl u_t009_006/c2_r1_rbl u_t009_006/c3_w0_bl u_t009_006/c3_w0_br
+ u_t009_006/c3_w1_bl u_t009_006/c3_w1_br u_t009_006/c3_r0_rbl u_t009_006/c3_r1_rbl u_t009_006/r0_w0_wl
+ u_t009_006/r0_w1_wl u_t009_006/r0_r0_rwl u_t009_006/r0_r1_rwl u_t009_006/r1_w0_wl u_t009_006/r1_w1_wl
+ u_t009_006/r1_r0_rwl u_t009_006/r1_r1_rwl u_t009_006/r2_w0_wl u_t009_006/r2_w1_wl u_t009_006/r2_r0_rwl
+ u_t009_006/r2_r1_rwl u_t009_006/r3_w0_wl u_t009_006/r3_w1_wl u_t009_006/r3_r0_rwl u_t009_006/r3_r1_rwl VDD VSS VSUBS
+ detronyx_12t_2w2r_rc4_4x4_routed_5layer_direct
Xu_t015_009 u_t015_009/c0_w0_bl u_t015_009/c0_w0_br u_t015_009/c0_w1_bl u_t015_009/c0_w1_br u_t015_009/c0_r0_rbl
+ u_t015_009/c0_r1_rbl u_t015_009/c1_w0_bl u_t015_009/c1_w0_br u_t015_009/c1_w1_bl u_t015_009/c1_w1_br
+ u_t015_009/c1_r0_rbl u_t015_009/c1_r1_rbl u_t015_009/c2_w0_bl u_t015_009/c2_w0_br u_t015_009/c2_w1_bl
+ u_t015_009/c2_w1_br u_t015_009/c2_r0_rbl u_t015_009/c2_r1_rbl u_t015_009/c3_w0_bl u_t015_009/c3_w0_br
+ u_t015_009/c3_w1_bl u_t015_009/c3_w1_br u_t015_009/c3_r0_rbl u_t015_009/c3_r1_rbl u_t015_009/r0_w0_wl
+ u_t015_009/r0_w1_wl u_t015_009/r0_r0_rwl u_t015_009/r0_r1_rwl u_t015_009/r1_w0_wl u_t015_009/r1_w1_wl
+ u_t015_009/r1_r0_rwl u_t015_009/r1_r1_rwl u_t015_009/r2_w0_wl u_t015_009/r2_w1_wl u_t015_009/r2_r0_rwl
+ u_t015_009/r2_r1_rwl u_t015_009/r3_w0_wl u_t015_009/r3_w1_wl u_t015_009/r3_r0_rwl u_t015_009/r3_r1_rwl VDD VSS VSUBS
+ detronyx_12t_2w2r_rc4_4x4_routed_5layer_direct
Xu_t006_009 u_t006_009/c0_w0_bl u_t006_009/c0_w0_br u_t006_009/c0_w1_bl u_t006_009/c0_w1_br u_t006_009/c0_r0_rbl
+ u_t006_009/c0_r1_rbl u_t006_009/c1_w0_bl u_t006_009/c1_w0_br u_t006_009/c1_w1_bl u_t006_009/c1_w1_br
+ u_t006_009/c1_r0_rbl u_t006_009/c1_r1_rbl u_t006_009/c2_w0_bl u_t006_009/c2_w0_br u_t006_009/c2_w1_bl
+ u_t006_009/c2_w1_br u_t006_009/c2_r0_rbl u_t006_009/c2_r1_rbl u_t006_009/c3_w0_bl u_t006_009/c3_w0_br
+ u_t006_009/c3_w1_bl u_t006_009/c3_w1_br u_t006_009/c3_r0_rbl u_t006_009/c3_r1_rbl u_t006_009/r0_w0_wl
+ u_t006_009/r0_w1_wl u_t006_009/r0_r0_rwl u_t006_009/r0_r1_rwl u_t006_009/r1_w0_wl u_t006_009/r1_w1_wl
+ u_t006_009/r1_r0_rwl u_t006_009/r1_r1_rwl u_t006_009/r2_w0_wl u_t006_009/r2_w1_wl u_t006_009/r2_r0_rwl
+ u_t006_009/r2_r1_rwl u_t006_009/r3_w0_wl u_t006_009/r3_w1_wl u_t006_009/r3_r0_rwl u_t006_009/r3_r1_rwl VDD VSS VSUBS
+ detronyx_12t_2w2r_rc4_4x4_routed_5layer_direct
Xu_t020_001 u_t020_001/c0_w0_bl u_t020_001/c0_w0_br u_t020_001/c0_w1_bl u_t020_001/c0_w1_br u_t020_001/c0_r0_rbl
+ u_t020_001/c0_r1_rbl u_t020_001/c1_w0_bl u_t020_001/c1_w0_br u_t020_001/c1_w1_bl u_t020_001/c1_w1_br
+ u_t020_001/c1_r0_rbl u_t020_001/c1_r1_rbl u_t020_001/c2_w0_bl u_t020_001/c2_w0_br u_t020_001/c2_w1_bl
+ u_t020_001/c2_w1_br u_t020_001/c2_r0_rbl u_t020_001/c2_r1_rbl u_t020_001/c3_w0_bl u_t020_001/c3_w0_br
+ u_t020_001/c3_w1_bl u_t020_001/c3_w1_br u_t020_001/c3_r0_rbl u_t020_001/c3_r1_rbl u_t020_001/r0_w0_wl
+ u_t020_001/r0_w1_wl u_t020_001/r0_r0_rwl u_t020_001/r0_r1_rwl u_t020_001/r1_w0_wl u_t020_001/r1_w1_wl
+ u_t020_001/r1_r0_rwl u_t020_001/r1_r1_rwl u_t020_001/r2_w0_wl u_t020_001/r2_w1_wl u_t020_001/r2_r0_rwl
+ u_t020_001/r2_r1_rwl u_t020_001/r3_w0_wl u_t020_001/r3_w1_wl u_t020_001/r3_r0_rwl u_t020_001/r3_r1_rwl VDD VSS VSUBS
+ detronyx_12t_2w2r_rc4_4x4_routed_5layer_direct
Xu_t020_012 u_t020_012/c0_w0_bl u_t020_012/c0_w0_br u_t020_012/c0_w1_bl u_t020_012/c0_w1_br u_t020_012/c0_r0_rbl
+ u_t020_012/c0_r1_rbl u_t020_012/c1_w0_bl u_t020_012/c1_w0_br u_t020_012/c1_w1_bl u_t020_012/c1_w1_br
+ u_t020_012/c1_r0_rbl u_t020_012/c1_r1_rbl u_t020_012/c2_w0_bl u_t020_012/c2_w0_br u_t020_012/c2_w1_bl
+ u_t020_012/c2_w1_br u_t020_012/c2_r0_rbl u_t020_012/c2_r1_rbl u_t020_012/c3_w0_bl u_t020_012/c3_w0_br
+ u_t020_012/c3_w1_bl u_t020_012/c3_w1_br u_t020_012/c3_r0_rbl u_t020_012/c3_r1_rbl u_t020_012/r0_w0_wl
+ u_t020_012/r0_w1_wl u_t020_012/r0_r0_rwl u_t020_012/r0_r1_rwl u_t020_012/r1_w0_wl u_t020_012/r1_w1_wl
+ u_t020_012/r1_r0_rwl u_t020_012/r1_r1_rwl u_t020_012/r2_w0_wl u_t020_012/r2_w1_wl u_t020_012/r2_r0_rwl
+ u_t020_012/r2_r1_rwl u_t020_012/r3_w0_wl u_t020_012/r3_w1_wl u_t020_012/r3_r0_rwl u_t020_012/r3_r1_rwl VDD VSS VSUBS
+ detronyx_12t_2w2r_rc4_4x4_routed_5layer_direct
Xu_t011_001 u_t011_001/c0_w0_bl u_t011_001/c0_w0_br u_t011_001/c0_w1_bl u_t011_001/c0_w1_br u_t011_001/c0_r0_rbl
+ u_t011_001/c0_r1_rbl u_t011_001/c1_w0_bl u_t011_001/c1_w0_br u_t011_001/c1_w1_bl u_t011_001/c1_w1_br
+ u_t011_001/c1_r0_rbl u_t011_001/c1_r1_rbl u_t011_001/c2_w0_bl u_t011_001/c2_w0_br u_t011_001/c2_w1_bl
+ u_t011_001/c2_w1_br u_t011_001/c2_r0_rbl u_t011_001/c2_r1_rbl u_t011_001/c3_w0_bl u_t011_001/c3_w0_br
+ u_t011_001/c3_w1_bl u_t011_001/c3_w1_br u_t011_001/c3_r0_rbl u_t011_001/c3_r1_rbl u_t011_001/r0_w0_wl
+ u_t011_001/r0_w1_wl u_t011_001/r0_r0_rwl u_t011_001/r0_r1_rwl u_t011_001/r1_w0_wl u_t011_001/r1_w1_wl
+ u_t011_001/r1_r0_rwl u_t011_001/r1_r1_rwl u_t011_001/r2_w0_wl u_t011_001/r2_w1_wl u_t011_001/r2_r0_rwl
+ u_t011_001/r2_r1_rwl u_t011_001/r3_w0_wl u_t011_001/r3_w1_wl u_t011_001/r3_r0_rwl u_t011_001/r3_r1_rwl VDD VSS VSUBS
+ detronyx_12t_2w2r_rc4_4x4_routed_5layer_direct
Xu_t011_012 u_t011_012/c0_w0_bl u_t011_012/c0_w0_br u_t011_012/c0_w1_bl u_t011_012/c0_w1_br u_t011_012/c0_r0_rbl
+ u_t011_012/c0_r1_rbl u_t011_012/c1_w0_bl u_t011_012/c1_w0_br u_t011_012/c1_w1_bl u_t011_012/c1_w1_br
+ u_t011_012/c1_r0_rbl u_t011_012/c1_r1_rbl u_t011_012/c2_w0_bl u_t011_012/c2_w0_br u_t011_012/c2_w1_bl
+ u_t011_012/c2_w1_br u_t011_012/c2_r0_rbl u_t011_012/c2_r1_rbl u_t011_012/c3_w0_bl u_t011_012/c3_w0_br
+ u_t011_012/c3_w1_bl u_t011_012/c3_w1_br u_t011_012/c3_r0_rbl u_t011_012/c3_r1_rbl u_t011_012/r0_w0_wl
+ u_t011_012/r0_w1_wl u_t011_012/r0_r0_rwl u_t011_012/r0_r1_rwl u_t011_012/r1_w0_wl u_t011_012/r1_w1_wl
+ u_t011_012/r1_r0_rwl u_t011_012/r1_r1_rwl u_t011_012/r2_w0_wl u_t011_012/r2_w1_wl u_t011_012/r2_r0_rwl
+ u_t011_012/r2_r1_rwl u_t011_012/r3_w0_wl u_t011_012/r3_w1_wl u_t011_012/r3_r0_rwl u_t011_012/r3_r1_rwl VDD VSS VSUBS
+ detronyx_12t_2w2r_rc4_4x4_routed_5layer_direct
Xu_t002_012 u_t002_012/c0_w0_bl u_t002_012/c0_w0_br u_t002_012/c0_w1_bl u_t002_012/c0_w1_br u_t002_012/c0_r0_rbl
+ u_t002_012/c0_r1_rbl u_t002_012/c1_w0_bl u_t002_012/c1_w0_br u_t002_012/c1_w1_bl u_t002_012/c1_w1_br
+ u_t002_012/c1_r0_rbl u_t002_012/c1_r1_rbl u_t002_012/c2_w0_bl u_t002_012/c2_w0_br u_t002_012/c2_w1_bl
+ u_t002_012/c2_w1_br u_t002_012/c2_r0_rbl u_t002_012/c2_r1_rbl u_t002_012/c3_w0_bl u_t002_012/c3_w0_br
+ u_t002_012/c3_w1_bl u_t002_012/c3_w1_br u_t002_012/c3_r0_rbl u_t002_012/c3_r1_rbl u_t002_012/r0_w0_wl
+ u_t002_012/r0_w1_wl u_t002_012/r0_r0_rwl u_t002_012/r0_r1_rwl u_t002_012/r1_w0_wl u_t002_012/r1_w1_wl
+ u_t002_012/r1_r0_rwl u_t002_012/r1_r1_rwl u_t002_012/r2_w0_wl u_t002_012/r2_w1_wl u_t002_012/r2_r0_rwl
+ u_t002_012/r2_r1_rwl u_t002_012/r3_w0_wl u_t002_012/r3_w1_wl u_t002_012/r3_r0_rwl u_t002_012/r3_r1_rwl VDD VSS VSUBS
+ detronyx_12t_2w2r_rc4_4x4_routed_5layer_direct
Xu_t002_001 u_t002_001/c0_w0_bl u_t002_001/c0_w0_br u_t002_001/c0_w1_bl u_t002_001/c0_w1_br u_t002_001/c0_r0_rbl
+ u_t002_001/c0_r1_rbl u_t002_001/c1_w0_bl u_t002_001/c1_w0_br u_t002_001/c1_w1_bl u_t002_001/c1_w1_br
+ u_t002_001/c1_r0_rbl u_t002_001/c1_r1_rbl u_t002_001/c2_w0_bl u_t002_001/c2_w0_br u_t002_001/c2_w1_bl
+ u_t002_001/c2_w1_br u_t002_001/c2_r0_rbl u_t002_001/c2_r1_rbl u_t002_001/c3_w0_bl u_t002_001/c3_w0_br
+ u_t002_001/c3_w1_bl u_t002_001/c3_w1_br u_t002_001/c3_r0_rbl u_t002_001/c3_r1_rbl u_t002_001/r0_w0_wl
+ u_t002_001/r0_w1_wl u_t002_001/r0_r0_rwl u_t002_001/r0_r1_rwl u_t002_001/r1_w0_wl u_t002_001/r1_w1_wl
+ u_t002_001/r1_r0_rwl u_t002_001/r1_r1_rwl u_t002_001/r2_w0_wl u_t002_001/r2_w1_wl u_t002_001/r2_r0_rwl
+ u_t002_001/r2_r1_rwl u_t002_001/r3_w0_wl u_t002_001/r3_w1_wl u_t002_001/r3_r0_rwl u_t002_001/r3_r1_rwl VDD VSS VSUBS
+ detronyx_12t_2w2r_rc4_4x4_routed_5layer_direct
Xu_t027_007 u_t027_007/c0_w0_bl u_t027_007/c0_w0_br u_t027_007/c0_w1_bl u_t027_007/c0_w1_br u_t027_007/c0_r0_rbl
+ u_t027_007/c0_r1_rbl u_t027_007/c1_w0_bl u_t027_007/c1_w0_br u_t027_007/c1_w1_bl u_t027_007/c1_w1_br
+ u_t027_007/c1_r0_rbl u_t027_007/c1_r1_rbl u_t027_007/c2_w0_bl u_t027_007/c2_w0_br u_t027_007/c2_w1_bl
+ u_t027_007/c2_w1_br u_t027_007/c2_r0_rbl u_t027_007/c2_r1_rbl u_t027_007/c3_w0_bl u_t027_007/c3_w0_br
+ u_t027_007/c3_w1_bl u_t027_007/c3_w1_br u_t027_007/c3_r0_rbl u_t027_007/c3_r1_rbl u_t027_007/r0_w0_wl
+ u_t027_007/r0_w1_wl u_t027_007/r0_r0_rwl u_t027_007/r0_r1_rwl u_t027_007/r1_w0_wl u_t027_007/r1_w1_wl
+ u_t027_007/r1_r0_rwl u_t027_007/r1_r1_rwl u_t027_007/r2_w0_wl u_t027_007/r2_w1_wl u_t027_007/r2_r0_rwl
+ u_t027_007/r2_r1_rwl u_t027_007/r3_w0_wl u_t027_007/r3_w1_wl u_t027_007/r3_r0_rwl u_t027_007/r3_r1_rwl VDD VSS VSUBS
+ detronyx_12t_2w2r_rc4_4x4_routed_5layer_direct
Xu_t018_007 u_t018_007/c0_w0_bl u_t018_007/c0_w0_br u_t018_007/c0_w1_bl u_t018_007/c0_w1_br u_t018_007/c0_r0_rbl
+ u_t018_007/c0_r1_rbl u_t018_007/c1_w0_bl u_t018_007/c1_w0_br u_t018_007/c1_w1_bl u_t018_007/c1_w1_br
+ u_t018_007/c1_r0_rbl u_t018_007/c1_r1_rbl u_t018_007/c2_w0_bl u_t018_007/c2_w0_br u_t018_007/c2_w1_bl
+ u_t018_007/c2_w1_br u_t018_007/c2_r0_rbl u_t018_007/c2_r1_rbl u_t018_007/c3_w0_bl u_t018_007/c3_w0_br
+ u_t018_007/c3_w1_bl u_t018_007/c3_w1_br u_t018_007/c3_r0_rbl u_t018_007/c3_r1_rbl u_t018_007/r0_w0_wl
+ u_t018_007/r0_w1_wl u_t018_007/r0_r0_rwl u_t018_007/r0_r1_rwl u_t018_007/r1_w0_wl u_t018_007/r1_w1_wl
+ u_t018_007/r1_r0_rwl u_t018_007/r1_r1_rwl u_t018_007/r2_w0_wl u_t018_007/r2_w1_wl u_t018_007/r2_r0_rwl
+ u_t018_007/r2_r1_rwl u_t018_007/r3_w0_wl u_t018_007/r3_w1_wl u_t018_007/r3_r0_rwl u_t018_007/r3_r1_rwl VDD VSS VSUBS
+ detronyx_12t_2w2r_rc4_4x4_routed_5layer_direct
Xu_t009_007 u_t009_007/c0_w0_bl u_t009_007/c0_w0_br u_t009_007/c0_w1_bl u_t009_007/c0_w1_br u_t009_007/c0_r0_rbl
+ u_t009_007/c0_r1_rbl u_t009_007/c1_w0_bl u_t009_007/c1_w0_br u_t009_007/c1_w1_bl u_t009_007/c1_w1_br
+ u_t009_007/c1_r0_rbl u_t009_007/c1_r1_rbl u_t009_007/c2_w0_bl u_t009_007/c2_w0_br u_t009_007/c2_w1_bl
+ u_t009_007/c2_w1_br u_t009_007/c2_r0_rbl u_t009_007/c2_r1_rbl u_t009_007/c3_w0_bl u_t009_007/c3_w0_br
+ u_t009_007/c3_w1_bl u_t009_007/c3_w1_br u_t009_007/c3_r0_rbl u_t009_007/c3_r1_rbl u_t009_007/r0_w0_wl
+ u_t009_007/r0_w1_wl u_t009_007/r0_r0_rwl u_t009_007/r0_r1_rwl u_t009_007/r1_w0_wl u_t009_007/r1_w1_wl
+ u_t009_007/r1_r0_rwl u_t009_007/r1_r1_rwl u_t009_007/r2_w0_wl u_t009_007/r2_w1_wl u_t009_007/r2_r0_rwl
+ u_t009_007/r2_r1_rwl u_t009_007/r3_w0_wl u_t009_007/r3_w1_wl u_t009_007/r3_r0_rwl u_t009_007/r3_r1_rwl VDD VSS VSUBS
+ detronyx_12t_2w2r_rc4_4x4_routed_5layer_direct
Xu_t023_010 u_t023_010/c0_w0_bl u_t023_010/c0_w0_br u_t023_010/c0_w1_bl u_t023_010/c0_w1_br u_t023_010/c0_r0_rbl
+ u_t023_010/c0_r1_rbl u_t023_010/c1_w0_bl u_t023_010/c1_w0_br u_t023_010/c1_w1_bl u_t023_010/c1_w1_br
+ u_t023_010/c1_r0_rbl u_t023_010/c1_r1_rbl u_t023_010/c2_w0_bl u_t023_010/c2_w0_br u_t023_010/c2_w1_bl
+ u_t023_010/c2_w1_br u_t023_010/c2_r0_rbl u_t023_010/c2_r1_rbl u_t023_010/c3_w0_bl u_t023_010/c3_w0_br
+ u_t023_010/c3_w1_bl u_t023_010/c3_w1_br u_t023_010/c3_r0_rbl u_t023_010/c3_r1_rbl u_t023_010/r0_w0_wl
+ u_t023_010/r0_w1_wl u_t023_010/r0_r0_rwl u_t023_010/r0_r1_rwl u_t023_010/r1_w0_wl u_t023_010/r1_w1_wl
+ u_t023_010/r1_r0_rwl u_t023_010/r1_r1_rwl u_t023_010/r2_w0_wl u_t023_010/r2_w1_wl u_t023_010/r2_r0_rwl
+ u_t023_010/r2_r1_rwl u_t023_010/r3_w0_wl u_t023_010/r3_w1_wl u_t023_010/r3_r0_rwl u_t023_010/r3_r1_rwl VDD VSS VSUBS
+ detronyx_12t_2w2r_rc4_4x4_routed_5layer_direct
Xu_t014_010 u_t014_010/c0_w0_bl u_t014_010/c0_w0_br u_t014_010/c0_w1_bl u_t014_010/c0_w1_br u_t014_010/c0_r0_rbl
+ u_t014_010/c0_r1_rbl u_t014_010/c1_w0_bl u_t014_010/c1_w0_br u_t014_010/c1_w1_bl u_t014_010/c1_w1_br
+ u_t014_010/c1_r0_rbl u_t014_010/c1_r1_rbl u_t014_010/c2_w0_bl u_t014_010/c2_w0_br u_t014_010/c2_w1_bl
+ u_t014_010/c2_w1_br u_t014_010/c2_r0_rbl u_t014_010/c2_r1_rbl u_t014_010/c3_w0_bl u_t014_010/c3_w0_br
+ u_t014_010/c3_w1_bl u_t014_010/c3_w1_br u_t014_010/c3_r0_rbl u_t014_010/c3_r1_rbl u_t014_010/r0_w0_wl
+ u_t014_010/r0_w1_wl u_t014_010/r0_r0_rwl u_t014_010/r0_r1_rwl u_t014_010/r1_w0_wl u_t014_010/r1_w1_wl
+ u_t014_010/r1_r0_rwl u_t014_010/r1_r1_rwl u_t014_010/r2_w0_wl u_t014_010/r2_w1_wl u_t014_010/r2_r0_rwl
+ u_t014_010/r2_r1_rwl u_t014_010/r3_w0_wl u_t014_010/r3_w1_wl u_t014_010/r3_r0_rwl u_t014_010/r3_r1_rwl VDD VSS VSUBS
+ detronyx_12t_2w2r_rc4_4x4_routed_5layer_direct
Xu_t005_010 u_t005_010/c0_w0_bl u_t005_010/c0_w0_br u_t005_010/c0_w1_bl u_t005_010/c0_w1_br u_t005_010/c0_r0_rbl
+ u_t005_010/c0_r1_rbl u_t005_010/c1_w0_bl u_t005_010/c1_w0_br u_t005_010/c1_w1_bl u_t005_010/c1_w1_br
+ u_t005_010/c1_r0_rbl u_t005_010/c1_r1_rbl u_t005_010/c2_w0_bl u_t005_010/c2_w0_br u_t005_010/c2_w1_bl
+ u_t005_010/c2_w1_br u_t005_010/c2_r0_rbl u_t005_010/c2_r1_rbl u_t005_010/c3_w0_bl u_t005_010/c3_w0_br
+ u_t005_010/c3_w1_bl u_t005_010/c3_w1_br u_t005_010/c3_r0_rbl u_t005_010/c3_r1_rbl u_t005_010/r0_w0_wl
+ u_t005_010/r0_w1_wl u_t005_010/r0_r0_rwl u_t005_010/r0_r1_rwl u_t005_010/r1_w0_wl u_t005_010/r1_w1_wl
+ u_t005_010/r1_r0_rwl u_t005_010/r1_r1_rwl u_t005_010/r2_w0_wl u_t005_010/r2_w1_wl u_t005_010/r2_r0_rwl
+ u_t005_010/r2_r1_rwl u_t005_010/r3_w0_wl u_t005_010/r3_w1_wl u_t005_010/r3_r0_rwl u_t005_010/r3_r1_rwl VDD VSS VSUBS
+ detronyx_12t_2w2r_rc4_4x4_routed_5layer_direct
Xu_t020_002 u_t020_002/c0_w0_bl u_t020_002/c0_w0_br u_t020_002/c0_w1_bl u_t020_002/c0_w1_br u_t020_002/c0_r0_rbl
+ u_t020_002/c0_r1_rbl u_t020_002/c1_w0_bl u_t020_002/c1_w0_br u_t020_002/c1_w1_bl u_t020_002/c1_w1_br
+ u_t020_002/c1_r0_rbl u_t020_002/c1_r1_rbl u_t020_002/c2_w0_bl u_t020_002/c2_w0_br u_t020_002/c2_w1_bl
+ u_t020_002/c2_w1_br u_t020_002/c2_r0_rbl u_t020_002/c2_r1_rbl u_t020_002/c3_w0_bl u_t020_002/c3_w0_br
+ u_t020_002/c3_w1_bl u_t020_002/c3_w1_br u_t020_002/c3_r0_rbl u_t020_002/c3_r1_rbl u_t020_002/r0_w0_wl
+ u_t020_002/r0_w1_wl u_t020_002/r0_r0_rwl u_t020_002/r0_r1_rwl u_t020_002/r1_w0_wl u_t020_002/r1_w1_wl
+ u_t020_002/r1_r0_rwl u_t020_002/r1_r1_rwl u_t020_002/r2_w0_wl u_t020_002/r2_w1_wl u_t020_002/r2_r0_rwl
+ u_t020_002/r2_r1_rwl u_t020_002/r3_w0_wl u_t020_002/r3_w1_wl u_t020_002/r3_r0_rwl u_t020_002/r3_r1_rwl VDD VSS VSUBS
+ detronyx_12t_2w2r_rc4_4x4_routed_5layer_direct
Xu_t020_013 u_t020_013/c0_w0_bl u_t020_013/c0_w0_br u_t020_013/c0_w1_bl u_t020_013/c0_w1_br u_t020_013/c0_r0_rbl
+ u_t020_013/c0_r1_rbl u_t020_013/c1_w0_bl u_t020_013/c1_w0_br u_t020_013/c1_w1_bl u_t020_013/c1_w1_br
+ u_t020_013/c1_r0_rbl u_t020_013/c1_r1_rbl u_t020_013/c2_w0_bl u_t020_013/c2_w0_br u_t020_013/c2_w1_bl
+ u_t020_013/c2_w1_br u_t020_013/c2_r0_rbl u_t020_013/c2_r1_rbl u_t020_013/c3_w0_bl u_t020_013/c3_w0_br
+ u_t020_013/c3_w1_bl u_t020_013/c3_w1_br u_t020_013/c3_r0_rbl u_t020_013/c3_r1_rbl u_t020_013/r0_w0_wl
+ u_t020_013/r0_w1_wl u_t020_013/r0_r0_rwl u_t020_013/r0_r1_rwl u_t020_013/r1_w0_wl u_t020_013/r1_w1_wl
+ u_t020_013/r1_r0_rwl u_t020_013/r1_r1_rwl u_t020_013/r2_w0_wl u_t020_013/r2_w1_wl u_t020_013/r2_r0_rwl
+ u_t020_013/r2_r1_rwl u_t020_013/r3_w0_wl u_t020_013/r3_w1_wl u_t020_013/r3_r0_rwl u_t020_013/r3_r1_rwl VDD VSS VSUBS
+ detronyx_12t_2w2r_rc4_4x4_routed_5layer_direct
Xu_t011_002 u_t011_002/c0_w0_bl u_t011_002/c0_w0_br u_t011_002/c0_w1_bl u_t011_002/c0_w1_br u_t011_002/c0_r0_rbl
+ u_t011_002/c0_r1_rbl u_t011_002/c1_w0_bl u_t011_002/c1_w0_br u_t011_002/c1_w1_bl u_t011_002/c1_w1_br
+ u_t011_002/c1_r0_rbl u_t011_002/c1_r1_rbl u_t011_002/c2_w0_bl u_t011_002/c2_w0_br u_t011_002/c2_w1_bl
+ u_t011_002/c2_w1_br u_t011_002/c2_r0_rbl u_t011_002/c2_r1_rbl u_t011_002/c3_w0_bl u_t011_002/c3_w0_br
+ u_t011_002/c3_w1_bl u_t011_002/c3_w1_br u_t011_002/c3_r0_rbl u_t011_002/c3_r1_rbl u_t011_002/r0_w0_wl
+ u_t011_002/r0_w1_wl u_t011_002/r0_r0_rwl u_t011_002/r0_r1_rwl u_t011_002/r1_w0_wl u_t011_002/r1_w1_wl
+ u_t011_002/r1_r0_rwl u_t011_002/r1_r1_rwl u_t011_002/r2_w0_wl u_t011_002/r2_w1_wl u_t011_002/r2_r0_rwl
+ u_t011_002/r2_r1_rwl u_t011_002/r3_w0_wl u_t011_002/r3_w1_wl u_t011_002/r3_r0_rwl u_t011_002/r3_r1_rwl VDD VSS VSUBS
+ detronyx_12t_2w2r_rc4_4x4_routed_5layer_direct
Xu_t011_013 u_t011_013/c0_w0_bl u_t011_013/c0_w0_br u_t011_013/c0_w1_bl u_t011_013/c0_w1_br u_t011_013/c0_r0_rbl
+ u_t011_013/c0_r1_rbl u_t011_013/c1_w0_bl u_t011_013/c1_w0_br u_t011_013/c1_w1_bl u_t011_013/c1_w1_br
+ u_t011_013/c1_r0_rbl u_t011_013/c1_r1_rbl u_t011_013/c2_w0_bl u_t011_013/c2_w0_br u_t011_013/c2_w1_bl
+ u_t011_013/c2_w1_br u_t011_013/c2_r0_rbl u_t011_013/c2_r1_rbl u_t011_013/c3_w0_bl u_t011_013/c3_w0_br
+ u_t011_013/c3_w1_bl u_t011_013/c3_w1_br u_t011_013/c3_r0_rbl u_t011_013/c3_r1_rbl u_t011_013/r0_w0_wl
+ u_t011_013/r0_w1_wl u_t011_013/r0_r0_rwl u_t011_013/r0_r1_rwl u_t011_013/r1_w0_wl u_t011_013/r1_w1_wl
+ u_t011_013/r1_r0_rwl u_t011_013/r1_r1_rwl u_t011_013/r2_w0_wl u_t011_013/r2_w1_wl u_t011_013/r2_r0_rwl
+ u_t011_013/r2_r1_rwl u_t011_013/r3_w0_wl u_t011_013/r3_w1_wl u_t011_013/r3_r0_rwl u_t011_013/r3_r1_rwl VDD VSS VSUBS
+ detronyx_12t_2w2r_rc4_4x4_routed_5layer_direct
Xu_t002_013 u_t002_013/c0_w0_bl u_t002_013/c0_w0_br u_t002_013/c0_w1_bl u_t002_013/c0_w1_br u_t002_013/c0_r0_rbl
+ u_t002_013/c0_r1_rbl u_t002_013/c1_w0_bl u_t002_013/c1_w0_br u_t002_013/c1_w1_bl u_t002_013/c1_w1_br
+ u_t002_013/c1_r0_rbl u_t002_013/c1_r1_rbl u_t002_013/c2_w0_bl u_t002_013/c2_w0_br u_t002_013/c2_w1_bl
+ u_t002_013/c2_w1_br u_t002_013/c2_r0_rbl u_t002_013/c2_r1_rbl u_t002_013/c3_w0_bl u_t002_013/c3_w0_br
+ u_t002_013/c3_w1_bl u_t002_013/c3_w1_br u_t002_013/c3_r0_rbl u_t002_013/c3_r1_rbl u_t002_013/r0_w0_wl
+ u_t002_013/r0_w1_wl u_t002_013/r0_r0_rwl u_t002_013/r0_r1_rwl u_t002_013/r1_w0_wl u_t002_013/r1_w1_wl
+ u_t002_013/r1_r0_rwl u_t002_013/r1_r1_rwl u_t002_013/r2_w0_wl u_t002_013/r2_w1_wl u_t002_013/r2_r0_rwl
+ u_t002_013/r2_r1_rwl u_t002_013/r3_w0_wl u_t002_013/r3_w1_wl u_t002_013/r3_r0_rwl u_t002_013/r3_r1_rwl VDD VSS VSUBS
+ detronyx_12t_2w2r_rc4_4x4_routed_5layer_direct
Xu_t002_002 u_t002_002/c0_w0_bl u_t002_002/c0_w0_br u_t002_002/c0_w1_bl u_t002_002/c0_w1_br u_t002_002/c0_r0_rbl
+ u_t002_002/c0_r1_rbl u_t002_002/c1_w0_bl u_t002_002/c1_w0_br u_t002_002/c1_w1_bl u_t002_002/c1_w1_br
+ u_t002_002/c1_r0_rbl u_t002_002/c1_r1_rbl u_t002_002/c2_w0_bl u_t002_002/c2_w0_br u_t002_002/c2_w1_bl
+ u_t002_002/c2_w1_br u_t002_002/c2_r0_rbl u_t002_002/c2_r1_rbl u_t002_002/c3_w0_bl u_t002_002/c3_w0_br
+ u_t002_002/c3_w1_bl u_t002_002/c3_w1_br u_t002_002/c3_r0_rbl u_t002_002/c3_r1_rbl u_t002_002/r0_w0_wl
+ u_t002_002/r0_w1_wl u_t002_002/r0_r0_rwl u_t002_002/r0_r1_rwl u_t002_002/r1_w0_wl u_t002_002/r1_w1_wl
+ u_t002_002/r1_r0_rwl u_t002_002/r1_r1_rwl u_t002_002/r2_w0_wl u_t002_002/r2_w1_wl u_t002_002/r2_r0_rwl
+ u_t002_002/r2_r1_rwl u_t002_002/r3_w0_wl u_t002_002/r3_w1_wl u_t002_002/r3_r0_rwl u_t002_002/r3_r1_rwl VDD VSS VSUBS
+ detronyx_12t_2w2r_rc4_4x4_routed_5layer_direct
Xu_t027_008 u_t027_008/c0_w0_bl u_t027_008/c0_w0_br u_t027_008/c0_w1_bl u_t027_008/c0_w1_br u_t027_008/c0_r0_rbl
+ u_t027_008/c0_r1_rbl u_t027_008/c1_w0_bl u_t027_008/c1_w0_br u_t027_008/c1_w1_bl u_t027_008/c1_w1_br
+ u_t027_008/c1_r0_rbl u_t027_008/c1_r1_rbl u_t027_008/c2_w0_bl u_t027_008/c2_w0_br u_t027_008/c2_w1_bl
+ u_t027_008/c2_w1_br u_t027_008/c2_r0_rbl u_t027_008/c2_r1_rbl u_t027_008/c3_w0_bl u_t027_008/c3_w0_br
+ u_t027_008/c3_w1_bl u_t027_008/c3_w1_br u_t027_008/c3_r0_rbl u_t027_008/c3_r1_rbl u_t027_008/r0_w0_wl
+ u_t027_008/r0_w1_wl u_t027_008/r0_r0_rwl u_t027_008/r0_r1_rwl u_t027_008/r1_w0_wl u_t027_008/r1_w1_wl
+ u_t027_008/r1_r0_rwl u_t027_008/r1_r1_rwl u_t027_008/r2_w0_wl u_t027_008/r2_w1_wl u_t027_008/r2_r0_rwl
+ u_t027_008/r2_r1_rwl u_t027_008/r3_w0_wl u_t027_008/r3_w1_wl u_t027_008/r3_r0_rwl u_t027_008/r3_r1_rwl VDD VSS VSUBS
+ detronyx_12t_2w2r_rc4_4x4_routed_5layer_direct
Xu_t018_008 u_t018_008/c0_w0_bl u_t018_008/c0_w0_br u_t018_008/c0_w1_bl u_t018_008/c0_w1_br u_t018_008/c0_r0_rbl
+ u_t018_008/c0_r1_rbl u_t018_008/c1_w0_bl u_t018_008/c1_w0_br u_t018_008/c1_w1_bl u_t018_008/c1_w1_br
+ u_t018_008/c1_r0_rbl u_t018_008/c1_r1_rbl u_t018_008/c2_w0_bl u_t018_008/c2_w0_br u_t018_008/c2_w1_bl
+ u_t018_008/c2_w1_br u_t018_008/c2_r0_rbl u_t018_008/c2_r1_rbl u_t018_008/c3_w0_bl u_t018_008/c3_w0_br
+ u_t018_008/c3_w1_bl u_t018_008/c3_w1_br u_t018_008/c3_r0_rbl u_t018_008/c3_r1_rbl u_t018_008/r0_w0_wl
+ u_t018_008/r0_w1_wl u_t018_008/r0_r0_rwl u_t018_008/r0_r1_rwl u_t018_008/r1_w0_wl u_t018_008/r1_w1_wl
+ u_t018_008/r1_r0_rwl u_t018_008/r1_r1_rwl u_t018_008/r2_w0_wl u_t018_008/r2_w1_wl u_t018_008/r2_r0_rwl
+ u_t018_008/r2_r1_rwl u_t018_008/r3_w0_wl u_t018_008/r3_w1_wl u_t018_008/r3_r0_rwl u_t018_008/r3_r1_rwl VDD VSS VSUBS
+ detronyx_12t_2w2r_rc4_4x4_routed_5layer_direct
Xu_t009_008 u_t009_008/c0_w0_bl u_t009_008/c0_w0_br u_t009_008/c0_w1_bl u_t009_008/c0_w1_br u_t009_008/c0_r0_rbl
+ u_t009_008/c0_r1_rbl u_t009_008/c1_w0_bl u_t009_008/c1_w0_br u_t009_008/c1_w1_bl u_t009_008/c1_w1_br
+ u_t009_008/c1_r0_rbl u_t009_008/c1_r1_rbl u_t009_008/c2_w0_bl u_t009_008/c2_w0_br u_t009_008/c2_w1_bl
+ u_t009_008/c2_w1_br u_t009_008/c2_r0_rbl u_t009_008/c2_r1_rbl u_t009_008/c3_w0_bl u_t009_008/c3_w0_br
+ u_t009_008/c3_w1_bl u_t009_008/c3_w1_br u_t009_008/c3_r0_rbl u_t009_008/c3_r1_rbl u_t009_008/r0_w0_wl
+ u_t009_008/r0_w1_wl u_t009_008/r0_r0_rwl u_t009_008/r0_r1_rwl u_t009_008/r1_w0_wl u_t009_008/r1_w1_wl
+ u_t009_008/r1_r0_rwl u_t009_008/r1_r1_rwl u_t009_008/r2_w0_wl u_t009_008/r2_w1_wl u_t009_008/r2_r0_rwl
+ u_t009_008/r2_r1_rwl u_t009_008/r3_w0_wl u_t009_008/r3_w1_wl u_t009_008/r3_r0_rwl u_t009_008/r3_r1_rwl VDD VSS VSUBS
+ detronyx_12t_2w2r_rc4_4x4_routed_5layer_direct
Xu_t023_000 u_t023_000/c0_w0_bl u_t023_000/c0_w0_br u_t023_000/c0_w1_bl u_t023_000/c0_w1_br u_t023_000/c0_r0_rbl
+ u_t023_000/c0_r1_rbl u_t023_000/c1_w0_bl u_t023_000/c1_w0_br u_t023_000/c1_w1_bl u_t023_000/c1_w1_br
+ u_t023_000/c1_r0_rbl u_t023_000/c1_r1_rbl u_t023_000/c2_w0_bl u_t023_000/c2_w0_br u_t023_000/c2_w1_bl
+ u_t023_000/c2_w1_br u_t023_000/c2_r0_rbl u_t023_000/c2_r1_rbl u_t023_000/c3_w0_bl u_t023_000/c3_w0_br
+ u_t023_000/c3_w1_bl u_t023_000/c3_w1_br u_t023_000/c3_r0_rbl u_t023_000/c3_r1_rbl u_t023_000/r0_w0_wl
+ u_t023_000/r0_w1_wl u_t023_000/r0_r0_rwl u_t023_000/r0_r1_rwl u_t023_000/r1_w0_wl u_t023_000/r1_w1_wl
+ u_t023_000/r1_r0_rwl u_t023_000/r1_r1_rwl u_t023_000/r2_w0_wl u_t023_000/r2_w1_wl u_t023_000/r2_r0_rwl
+ u_t023_000/r2_r1_rwl u_t023_000/r3_w0_wl u_t023_000/r3_w1_wl u_t023_000/r3_r0_rwl u_t023_000/r3_r1_rwl VDD VSS VSUBS
+ detronyx_12t_2w2r_rc4_4x4_routed_5layer_direct
Xu_t023_011 u_t023_011/c0_w0_bl u_t023_011/c0_w0_br u_t023_011/c0_w1_bl u_t023_011/c0_w1_br u_t023_011/c0_r0_rbl
+ u_t023_011/c0_r1_rbl u_t023_011/c1_w0_bl u_t023_011/c1_w0_br u_t023_011/c1_w1_bl u_t023_011/c1_w1_br
+ u_t023_011/c1_r0_rbl u_t023_011/c1_r1_rbl u_t023_011/c2_w0_bl u_t023_011/c2_w0_br u_t023_011/c2_w1_bl
+ u_t023_011/c2_w1_br u_t023_011/c2_r0_rbl u_t023_011/c2_r1_rbl u_t023_011/c3_w0_bl u_t023_011/c3_w0_br
+ u_t023_011/c3_w1_bl u_t023_011/c3_w1_br u_t023_011/c3_r0_rbl u_t023_011/c3_r1_rbl u_t023_011/r0_w0_wl
+ u_t023_011/r0_w1_wl u_t023_011/r0_r0_rwl u_t023_011/r0_r1_rwl u_t023_011/r1_w0_wl u_t023_011/r1_w1_wl
+ u_t023_011/r1_r0_rwl u_t023_011/r1_r1_rwl u_t023_011/r2_w0_wl u_t023_011/r2_w1_wl u_t023_011/r2_r0_rwl
+ u_t023_011/r2_r1_rwl u_t023_011/r3_w0_wl u_t023_011/r3_w1_wl u_t023_011/r3_r0_rwl u_t023_011/r3_r1_rwl VDD VSS VSUBS
+ detronyx_12t_2w2r_rc4_4x4_routed_5layer_direct
Xu_t014_000 u_t014_000/c0_w0_bl u_t014_000/c0_w0_br u_t014_000/c0_w1_bl u_t014_000/c0_w1_br u_t014_000/c0_r0_rbl
+ u_t014_000/c0_r1_rbl u_t014_000/c1_w0_bl u_t014_000/c1_w0_br u_t014_000/c1_w1_bl u_t014_000/c1_w1_br
+ u_t014_000/c1_r0_rbl u_t014_000/c1_r1_rbl u_t014_000/c2_w0_bl u_t014_000/c2_w0_br u_t014_000/c2_w1_bl
+ u_t014_000/c2_w1_br u_t014_000/c2_r0_rbl u_t014_000/c2_r1_rbl u_t014_000/c3_w0_bl u_t014_000/c3_w0_br
+ u_t014_000/c3_w1_bl u_t014_000/c3_w1_br u_t014_000/c3_r0_rbl u_t014_000/c3_r1_rbl u_t014_000/r0_w0_wl
+ u_t014_000/r0_w1_wl u_t014_000/r0_r0_rwl u_t014_000/r0_r1_rwl u_t014_000/r1_w0_wl u_t014_000/r1_w1_wl
+ u_t014_000/r1_r0_rwl u_t014_000/r1_r1_rwl u_t014_000/r2_w0_wl u_t014_000/r2_w1_wl u_t014_000/r2_r0_rwl
+ u_t014_000/r2_r1_rwl u_t014_000/r3_w0_wl u_t014_000/r3_w1_wl u_t014_000/r3_r0_rwl u_t014_000/r3_r1_rwl VDD VSS VSUBS
+ detronyx_12t_2w2r_rc4_4x4_routed_5layer_direct
Xu_t014_011 u_t014_011/c0_w0_bl u_t014_011/c0_w0_br u_t014_011/c0_w1_bl u_t014_011/c0_w1_br u_t014_011/c0_r0_rbl
+ u_t014_011/c0_r1_rbl u_t014_011/c1_w0_bl u_t014_011/c1_w0_br u_t014_011/c1_w1_bl u_t014_011/c1_w1_br
+ u_t014_011/c1_r0_rbl u_t014_011/c1_r1_rbl u_t014_011/c2_w0_bl u_t014_011/c2_w0_br u_t014_011/c2_w1_bl
+ u_t014_011/c2_w1_br u_t014_011/c2_r0_rbl u_t014_011/c2_r1_rbl u_t014_011/c3_w0_bl u_t014_011/c3_w0_br
+ u_t014_011/c3_w1_bl u_t014_011/c3_w1_br u_t014_011/c3_r0_rbl u_t014_011/c3_r1_rbl u_t014_011/r0_w0_wl
+ u_t014_011/r0_w1_wl u_t014_011/r0_r0_rwl u_t014_011/r0_r1_rwl u_t014_011/r1_w0_wl u_t014_011/r1_w1_wl
+ u_t014_011/r1_r0_rwl u_t014_011/r1_r1_rwl u_t014_011/r2_w0_wl u_t014_011/r2_w1_wl u_t014_011/r2_r0_rwl
+ u_t014_011/r2_r1_rwl u_t014_011/r3_w0_wl u_t014_011/r3_w1_wl u_t014_011/r3_r0_rwl u_t014_011/r3_r1_rwl VDD VSS VSUBS
+ detronyx_12t_2w2r_rc4_4x4_routed_5layer_direct
Xu_t005_000 u_t005_000/c0_w0_bl u_t005_000/c0_w0_br u_t005_000/c0_w1_bl u_t005_000/c0_w1_br u_t005_000/c0_r0_rbl
+ u_t005_000/c0_r1_rbl u_t005_000/c1_w0_bl u_t005_000/c1_w0_br u_t005_000/c1_w1_bl u_t005_000/c1_w1_br
+ u_t005_000/c1_r0_rbl u_t005_000/c1_r1_rbl u_t005_000/c2_w0_bl u_t005_000/c2_w0_br u_t005_000/c2_w1_bl
+ u_t005_000/c2_w1_br u_t005_000/c2_r0_rbl u_t005_000/c2_r1_rbl u_t005_000/c3_w0_bl u_t005_000/c3_w0_br
+ u_t005_000/c3_w1_bl u_t005_000/c3_w1_br u_t005_000/c3_r0_rbl u_t005_000/c3_r1_rbl u_t005_000/r0_w0_wl
+ u_t005_000/r0_w1_wl u_t005_000/r0_r0_rwl u_t005_000/r0_r1_rwl u_t005_000/r1_w0_wl u_t005_000/r1_w1_wl
+ u_t005_000/r1_r0_rwl u_t005_000/r1_r1_rwl u_t005_000/r2_w0_wl u_t005_000/r2_w1_wl u_t005_000/r2_r0_rwl
+ u_t005_000/r2_r1_rwl u_t005_000/r3_w0_wl u_t005_000/r3_w1_wl u_t005_000/r3_r0_rwl u_t005_000/r3_r1_rwl VDD VSS VSUBS
+ detronyx_12t_2w2r_rc4_4x4_routed_5layer_direct
Xu_t005_011 u_t005_011/c0_w0_bl u_t005_011/c0_w0_br u_t005_011/c0_w1_bl u_t005_011/c0_w1_br u_t005_011/c0_r0_rbl
+ u_t005_011/c0_r1_rbl u_t005_011/c1_w0_bl u_t005_011/c1_w0_br u_t005_011/c1_w1_bl u_t005_011/c1_w1_br
+ u_t005_011/c1_r0_rbl u_t005_011/c1_r1_rbl u_t005_011/c2_w0_bl u_t005_011/c2_w0_br u_t005_011/c2_w1_bl
+ u_t005_011/c2_w1_br u_t005_011/c2_r0_rbl u_t005_011/c2_r1_rbl u_t005_011/c3_w0_bl u_t005_011/c3_w0_br
+ u_t005_011/c3_w1_bl u_t005_011/c3_w1_br u_t005_011/c3_r0_rbl u_t005_011/c3_r1_rbl u_t005_011/r0_w0_wl
+ u_t005_011/r0_w1_wl u_t005_011/r0_r0_rwl u_t005_011/r0_r1_rwl u_t005_011/r1_w0_wl u_t005_011/r1_w1_wl
+ u_t005_011/r1_r0_rwl u_t005_011/r1_r1_rwl u_t005_011/r2_w0_wl u_t005_011/r2_w1_wl u_t005_011/r2_r0_rwl
+ u_t005_011/r2_r1_rwl u_t005_011/r3_w0_wl u_t005_011/r3_w1_wl u_t005_011/r3_r0_rwl u_t005_011/r3_r1_rwl VDD VSS VSUBS
+ detronyx_12t_2w2r_rc4_4x4_routed_5layer_direct
Xu_t020_003 u_t020_003/c0_w0_bl u_t020_003/c0_w0_br u_t020_003/c0_w1_bl u_t020_003/c0_w1_br u_t020_003/c0_r0_rbl
+ u_t020_003/c0_r1_rbl u_t020_003/c1_w0_bl u_t020_003/c1_w0_br u_t020_003/c1_w1_bl u_t020_003/c1_w1_br
+ u_t020_003/c1_r0_rbl u_t020_003/c1_r1_rbl u_t020_003/c2_w0_bl u_t020_003/c2_w0_br u_t020_003/c2_w1_bl
+ u_t020_003/c2_w1_br u_t020_003/c2_r0_rbl u_t020_003/c2_r1_rbl u_t020_003/c3_w0_bl u_t020_003/c3_w0_br
+ u_t020_003/c3_w1_bl u_t020_003/c3_w1_br u_t020_003/c3_r0_rbl u_t020_003/c3_r1_rbl u_t020_003/r0_w0_wl
+ u_t020_003/r0_w1_wl u_t020_003/r0_r0_rwl u_t020_003/r0_r1_rwl u_t020_003/r1_w0_wl u_t020_003/r1_w1_wl
+ u_t020_003/r1_r0_rwl u_t020_003/r1_r1_rwl u_t020_003/r2_w0_wl u_t020_003/r2_w1_wl u_t020_003/r2_r0_rwl
+ u_t020_003/r2_r1_rwl u_t020_003/r3_w0_wl u_t020_003/r3_w1_wl u_t020_003/r3_r0_rwl u_t020_003/r3_r1_rwl VDD VSS VSUBS
+ detronyx_12t_2w2r_rc4_4x4_routed_5layer_direct
Xu_t020_014 u_t020_014/c0_w0_bl u_t020_014/c0_w0_br u_t020_014/c0_w1_bl u_t020_014/c0_w1_br u_t020_014/c0_r0_rbl
+ u_t020_014/c0_r1_rbl u_t020_014/c1_w0_bl u_t020_014/c1_w0_br u_t020_014/c1_w1_bl u_t020_014/c1_w1_br
+ u_t020_014/c1_r0_rbl u_t020_014/c1_r1_rbl u_t020_014/c2_w0_bl u_t020_014/c2_w0_br u_t020_014/c2_w1_bl
+ u_t020_014/c2_w1_br u_t020_014/c2_r0_rbl u_t020_014/c2_r1_rbl u_t020_014/c3_w0_bl u_t020_014/c3_w0_br
+ u_t020_014/c3_w1_bl u_t020_014/c3_w1_br u_t020_014/c3_r0_rbl u_t020_014/c3_r1_rbl u_t020_014/r0_w0_wl
+ u_t020_014/r0_w1_wl u_t020_014/r0_r0_rwl u_t020_014/r0_r1_rwl u_t020_014/r1_w0_wl u_t020_014/r1_w1_wl
+ u_t020_014/r1_r0_rwl u_t020_014/r1_r1_rwl u_t020_014/r2_w0_wl u_t020_014/r2_w1_wl u_t020_014/r2_r0_rwl
+ u_t020_014/r2_r1_rwl u_t020_014/r3_w0_wl u_t020_014/r3_w1_wl u_t020_014/r3_r0_rwl u_t020_014/r3_r1_rwl VDD VSS VSUBS
+ detronyx_12t_2w2r_rc4_4x4_routed_5layer_direct
Xu_t011_003 u_t011_003/c0_w0_bl u_t011_003/c0_w0_br u_t011_003/c0_w1_bl u_t011_003/c0_w1_br u_t011_003/c0_r0_rbl
+ u_t011_003/c0_r1_rbl u_t011_003/c1_w0_bl u_t011_003/c1_w0_br u_t011_003/c1_w1_bl u_t011_003/c1_w1_br
+ u_t011_003/c1_r0_rbl u_t011_003/c1_r1_rbl u_t011_003/c2_w0_bl u_t011_003/c2_w0_br u_t011_003/c2_w1_bl
+ u_t011_003/c2_w1_br u_t011_003/c2_r0_rbl u_t011_003/c2_r1_rbl u_t011_003/c3_w0_bl u_t011_003/c3_w0_br
+ u_t011_003/c3_w1_bl u_t011_003/c3_w1_br u_t011_003/c3_r0_rbl u_t011_003/c3_r1_rbl u_t011_003/r0_w0_wl
+ u_t011_003/r0_w1_wl u_t011_003/r0_r0_rwl u_t011_003/r0_r1_rwl u_t011_003/r1_w0_wl u_t011_003/r1_w1_wl
+ u_t011_003/r1_r0_rwl u_t011_003/r1_r1_rwl u_t011_003/r2_w0_wl u_t011_003/r2_w1_wl u_t011_003/r2_r0_rwl
+ u_t011_003/r2_r1_rwl u_t011_003/r3_w0_wl u_t011_003/r3_w1_wl u_t011_003/r3_r0_rwl u_t011_003/r3_r1_rwl VDD VSS VSUBS
+ detronyx_12t_2w2r_rc4_4x4_routed_5layer_direct
Xu_t011_014 u_t011_014/c0_w0_bl u_t011_014/c0_w0_br u_t011_014/c0_w1_bl u_t011_014/c0_w1_br u_t011_014/c0_r0_rbl
+ u_t011_014/c0_r1_rbl u_t011_014/c1_w0_bl u_t011_014/c1_w0_br u_t011_014/c1_w1_bl u_t011_014/c1_w1_br
+ u_t011_014/c1_r0_rbl u_t011_014/c1_r1_rbl u_t011_014/c2_w0_bl u_t011_014/c2_w0_br u_t011_014/c2_w1_bl
+ u_t011_014/c2_w1_br u_t011_014/c2_r0_rbl u_t011_014/c2_r1_rbl u_t011_014/c3_w0_bl u_t011_014/c3_w0_br
+ u_t011_014/c3_w1_bl u_t011_014/c3_w1_br u_t011_014/c3_r0_rbl u_t011_014/c3_r1_rbl u_t011_014/r0_w0_wl
+ u_t011_014/r0_w1_wl u_t011_014/r0_r0_rwl u_t011_014/r0_r1_rwl u_t011_014/r1_w0_wl u_t011_014/r1_w1_wl
+ u_t011_014/r1_r0_rwl u_t011_014/r1_r1_rwl u_t011_014/r2_w0_wl u_t011_014/r2_w1_wl u_t011_014/r2_r0_rwl
+ u_t011_014/r2_r1_rwl u_t011_014/r3_w0_wl u_t011_014/r3_w1_wl u_t011_014/r3_r0_rwl u_t011_014/r3_r1_rwl VDD VSS VSUBS
+ detronyx_12t_2w2r_rc4_4x4_routed_5layer_direct
Xu_t002_014 u_t002_014/c0_w0_bl u_t002_014/c0_w0_br u_t002_014/c0_w1_bl u_t002_014/c0_w1_br u_t002_014/c0_r0_rbl
+ u_t002_014/c0_r1_rbl u_t002_014/c1_w0_bl u_t002_014/c1_w0_br u_t002_014/c1_w1_bl u_t002_014/c1_w1_br
+ u_t002_014/c1_r0_rbl u_t002_014/c1_r1_rbl u_t002_014/c2_w0_bl u_t002_014/c2_w0_br u_t002_014/c2_w1_bl
+ u_t002_014/c2_w1_br u_t002_014/c2_r0_rbl u_t002_014/c2_r1_rbl u_t002_014/c3_w0_bl u_t002_014/c3_w0_br
+ u_t002_014/c3_w1_bl u_t002_014/c3_w1_br u_t002_014/c3_r0_rbl u_t002_014/c3_r1_rbl u_t002_014/r0_w0_wl
+ u_t002_014/r0_w1_wl u_t002_014/r0_r0_rwl u_t002_014/r0_r1_rwl u_t002_014/r1_w0_wl u_t002_014/r1_w1_wl
+ u_t002_014/r1_r0_rwl u_t002_014/r1_r1_rwl u_t002_014/r2_w0_wl u_t002_014/r2_w1_wl u_t002_014/r2_r0_rwl
+ u_t002_014/r2_r1_rwl u_t002_014/r3_w0_wl u_t002_014/r3_w1_wl u_t002_014/r3_r0_rwl u_t002_014/r3_r1_rwl VDD VSS VSUBS
+ detronyx_12t_2w2r_rc4_4x4_routed_5layer_direct
Xu_t002_003 u_t002_003/c0_w0_bl u_t002_003/c0_w0_br u_t002_003/c0_w1_bl u_t002_003/c0_w1_br u_t002_003/c0_r0_rbl
+ u_t002_003/c0_r1_rbl u_t002_003/c1_w0_bl u_t002_003/c1_w0_br u_t002_003/c1_w1_bl u_t002_003/c1_w1_br
+ u_t002_003/c1_r0_rbl u_t002_003/c1_r1_rbl u_t002_003/c2_w0_bl u_t002_003/c2_w0_br u_t002_003/c2_w1_bl
+ u_t002_003/c2_w1_br u_t002_003/c2_r0_rbl u_t002_003/c2_r1_rbl u_t002_003/c3_w0_bl u_t002_003/c3_w0_br
+ u_t002_003/c3_w1_bl u_t002_003/c3_w1_br u_t002_003/c3_r0_rbl u_t002_003/c3_r1_rbl u_t002_003/r0_w0_wl
+ u_t002_003/r0_w1_wl u_t002_003/r0_r0_rwl u_t002_003/r0_r1_rwl u_t002_003/r1_w0_wl u_t002_003/r1_w1_wl
+ u_t002_003/r1_r0_rwl u_t002_003/r1_r1_rwl u_t002_003/r2_w0_wl u_t002_003/r2_w1_wl u_t002_003/r2_r0_rwl
+ u_t002_003/r2_r1_rwl u_t002_003/r3_w0_wl u_t002_003/r3_w1_wl u_t002_003/r3_r0_rwl u_t002_003/r3_r1_rwl VDD VSS VSUBS
+ detronyx_12t_2w2r_rc4_4x4_routed_5layer_direct
Xu_t027_009 u_t027_009/c0_w0_bl u_t027_009/c0_w0_br u_t027_009/c0_w1_bl u_t027_009/c0_w1_br u_t027_009/c0_r0_rbl
+ u_t027_009/c0_r1_rbl u_t027_009/c1_w0_bl u_t027_009/c1_w0_br u_t027_009/c1_w1_bl u_t027_009/c1_w1_br
+ u_t027_009/c1_r0_rbl u_t027_009/c1_r1_rbl u_t027_009/c2_w0_bl u_t027_009/c2_w0_br u_t027_009/c2_w1_bl
+ u_t027_009/c2_w1_br u_t027_009/c2_r0_rbl u_t027_009/c2_r1_rbl u_t027_009/c3_w0_bl u_t027_009/c3_w0_br
+ u_t027_009/c3_w1_bl u_t027_009/c3_w1_br u_t027_009/c3_r0_rbl u_t027_009/c3_r1_rbl u_t027_009/r0_w0_wl
+ u_t027_009/r0_w1_wl u_t027_009/r0_r0_rwl u_t027_009/r0_r1_rwl u_t027_009/r1_w0_wl u_t027_009/r1_w1_wl
+ u_t027_009/r1_r0_rwl u_t027_009/r1_r1_rwl u_t027_009/r2_w0_wl u_t027_009/r2_w1_wl u_t027_009/r2_r0_rwl
+ u_t027_009/r2_r1_rwl u_t027_009/r3_w0_wl u_t027_009/r3_w1_wl u_t027_009/r3_r0_rwl u_t027_009/r3_r1_rwl VDD VSS VSUBS
+ detronyx_12t_2w2r_rc4_4x4_routed_5layer_direct
Xu_t018_009 u_t018_009/c0_w0_bl u_t018_009/c0_w0_br u_t018_009/c0_w1_bl u_t018_009/c0_w1_br u_t018_009/c0_r0_rbl
+ u_t018_009/c0_r1_rbl u_t018_009/c1_w0_bl u_t018_009/c1_w0_br u_t018_009/c1_w1_bl u_t018_009/c1_w1_br
+ u_t018_009/c1_r0_rbl u_t018_009/c1_r1_rbl u_t018_009/c2_w0_bl u_t018_009/c2_w0_br u_t018_009/c2_w1_bl
+ u_t018_009/c2_w1_br u_t018_009/c2_r0_rbl u_t018_009/c2_r1_rbl u_t018_009/c3_w0_bl u_t018_009/c3_w0_br
+ u_t018_009/c3_w1_bl u_t018_009/c3_w1_br u_t018_009/c3_r0_rbl u_t018_009/c3_r1_rbl u_t018_009/r0_w0_wl
+ u_t018_009/r0_w1_wl u_t018_009/r0_r0_rwl u_t018_009/r0_r1_rwl u_t018_009/r1_w0_wl u_t018_009/r1_w1_wl
+ u_t018_009/r1_r0_rwl u_t018_009/r1_r1_rwl u_t018_009/r2_w0_wl u_t018_009/r2_w1_wl u_t018_009/r2_r0_rwl
+ u_t018_009/r2_r1_rwl u_t018_009/r3_w0_wl u_t018_009/r3_w1_wl u_t018_009/r3_r0_rwl u_t018_009/r3_r1_rwl VDD VSS VSUBS
+ detronyx_12t_2w2r_rc4_4x4_routed_5layer_direct
Xu_t009_009 u_t009_009/c0_w0_bl u_t009_009/c0_w0_br u_t009_009/c0_w1_bl u_t009_009/c0_w1_br u_t009_009/c0_r0_rbl
+ u_t009_009/c0_r1_rbl u_t009_009/c1_w0_bl u_t009_009/c1_w0_br u_t009_009/c1_w1_bl u_t009_009/c1_w1_br
+ u_t009_009/c1_r0_rbl u_t009_009/c1_r1_rbl u_t009_009/c2_w0_bl u_t009_009/c2_w0_br u_t009_009/c2_w1_bl
+ u_t009_009/c2_w1_br u_t009_009/c2_r0_rbl u_t009_009/c2_r1_rbl u_t009_009/c3_w0_bl u_t009_009/c3_w0_br
+ u_t009_009/c3_w1_bl u_t009_009/c3_w1_br u_t009_009/c3_r0_rbl u_t009_009/c3_r1_rbl u_t009_009/r0_w0_wl
+ u_t009_009/r0_w1_wl u_t009_009/r0_r0_rwl u_t009_009/r0_r1_rwl u_t009_009/r1_w0_wl u_t009_009/r1_w1_wl
+ u_t009_009/r1_r0_rwl u_t009_009/r1_r1_rwl u_t009_009/r2_w0_wl u_t009_009/r2_w1_wl u_t009_009/r2_r0_rwl
+ u_t009_009/r2_r1_rwl u_t009_009/r3_w0_wl u_t009_009/r3_w1_wl u_t009_009/r3_r0_rwl u_t009_009/r3_r1_rwl VDD VSS VSUBS
+ detronyx_12t_2w2r_rc4_4x4_routed_5layer_direct
Xu_t023_001 u_t023_001/c0_w0_bl u_t023_001/c0_w0_br u_t023_001/c0_w1_bl u_t023_001/c0_w1_br u_t023_001/c0_r0_rbl
+ u_t023_001/c0_r1_rbl u_t023_001/c1_w0_bl u_t023_001/c1_w0_br u_t023_001/c1_w1_bl u_t023_001/c1_w1_br
+ u_t023_001/c1_r0_rbl u_t023_001/c1_r1_rbl u_t023_001/c2_w0_bl u_t023_001/c2_w0_br u_t023_001/c2_w1_bl
+ u_t023_001/c2_w1_br u_t023_001/c2_r0_rbl u_t023_001/c2_r1_rbl u_t023_001/c3_w0_bl u_t023_001/c3_w0_br
+ u_t023_001/c3_w1_bl u_t023_001/c3_w1_br u_t023_001/c3_r0_rbl u_t023_001/c3_r1_rbl u_t023_001/r0_w0_wl
+ u_t023_001/r0_w1_wl u_t023_001/r0_r0_rwl u_t023_001/r0_r1_rwl u_t023_001/r1_w0_wl u_t023_001/r1_w1_wl
+ u_t023_001/r1_r0_rwl u_t023_001/r1_r1_rwl u_t023_001/r2_w0_wl u_t023_001/r2_w1_wl u_t023_001/r2_r0_rwl
+ u_t023_001/r2_r1_rwl u_t023_001/r3_w0_wl u_t023_001/r3_w1_wl u_t023_001/r3_r0_rwl u_t023_001/r3_r1_rwl VDD VSS VSUBS
+ detronyx_12t_2w2r_rc4_4x4_routed_5layer_direct
Xu_t023_012 u_t023_012/c0_w0_bl u_t023_012/c0_w0_br u_t023_012/c0_w1_bl u_t023_012/c0_w1_br u_t023_012/c0_r0_rbl
+ u_t023_012/c0_r1_rbl u_t023_012/c1_w0_bl u_t023_012/c1_w0_br u_t023_012/c1_w1_bl u_t023_012/c1_w1_br
+ u_t023_012/c1_r0_rbl u_t023_012/c1_r1_rbl u_t023_012/c2_w0_bl u_t023_012/c2_w0_br u_t023_012/c2_w1_bl
+ u_t023_012/c2_w1_br u_t023_012/c2_r0_rbl u_t023_012/c2_r1_rbl u_t023_012/c3_w0_bl u_t023_012/c3_w0_br
+ u_t023_012/c3_w1_bl u_t023_012/c3_w1_br u_t023_012/c3_r0_rbl u_t023_012/c3_r1_rbl u_t023_012/r0_w0_wl
+ u_t023_012/r0_w1_wl u_t023_012/r0_r0_rwl u_t023_012/r0_r1_rwl u_t023_012/r1_w0_wl u_t023_012/r1_w1_wl
+ u_t023_012/r1_r0_rwl u_t023_012/r1_r1_rwl u_t023_012/r2_w0_wl u_t023_012/r2_w1_wl u_t023_012/r2_r0_rwl
+ u_t023_012/r2_r1_rwl u_t023_012/r3_w0_wl u_t023_012/r3_w1_wl u_t023_012/r3_r0_rwl u_t023_012/r3_r1_rwl VDD VSS VSUBS
+ detronyx_12t_2w2r_rc4_4x4_routed_5layer_direct
Xu_t005_001 u_t005_001/c0_w0_bl u_t005_001/c0_w0_br u_t005_001/c0_w1_bl u_t005_001/c0_w1_br u_t005_001/c0_r0_rbl
+ u_t005_001/c0_r1_rbl u_t005_001/c1_w0_bl u_t005_001/c1_w0_br u_t005_001/c1_w1_bl u_t005_001/c1_w1_br
+ u_t005_001/c1_r0_rbl u_t005_001/c1_r1_rbl u_t005_001/c2_w0_bl u_t005_001/c2_w0_br u_t005_001/c2_w1_bl
+ u_t005_001/c2_w1_br u_t005_001/c2_r0_rbl u_t005_001/c2_r1_rbl u_t005_001/c3_w0_bl u_t005_001/c3_w0_br
+ u_t005_001/c3_w1_bl u_t005_001/c3_w1_br u_t005_001/c3_r0_rbl u_t005_001/c3_r1_rbl u_t005_001/r0_w0_wl
+ u_t005_001/r0_w1_wl u_t005_001/r0_r0_rwl u_t005_001/r0_r1_rwl u_t005_001/r1_w0_wl u_t005_001/r1_w1_wl
+ u_t005_001/r1_r0_rwl u_t005_001/r1_r1_rwl u_t005_001/r2_w0_wl u_t005_001/r2_w1_wl u_t005_001/r2_r0_rwl
+ u_t005_001/r2_r1_rwl u_t005_001/r3_w0_wl u_t005_001/r3_w1_wl u_t005_001/r3_r0_rwl u_t005_001/r3_r1_rwl VDD VSS VSUBS
+ detronyx_12t_2w2r_rc4_4x4_routed_5layer_direct
Xu_t005_012 u_t005_012/c0_w0_bl u_t005_012/c0_w0_br u_t005_012/c0_w1_bl u_t005_012/c0_w1_br u_t005_012/c0_r0_rbl
+ u_t005_012/c0_r1_rbl u_t005_012/c1_w0_bl u_t005_012/c1_w0_br u_t005_012/c1_w1_bl u_t005_012/c1_w1_br
+ u_t005_012/c1_r0_rbl u_t005_012/c1_r1_rbl u_t005_012/c2_w0_bl u_t005_012/c2_w0_br u_t005_012/c2_w1_bl
+ u_t005_012/c2_w1_br u_t005_012/c2_r0_rbl u_t005_012/c2_r1_rbl u_t005_012/c3_w0_bl u_t005_012/c3_w0_br
+ u_t005_012/c3_w1_bl u_t005_012/c3_w1_br u_t005_012/c3_r0_rbl u_t005_012/c3_r1_rbl u_t005_012/r0_w0_wl
+ u_t005_012/r0_w1_wl u_t005_012/r0_r0_rwl u_t005_012/r0_r1_rwl u_t005_012/r1_w0_wl u_t005_012/r1_w1_wl
+ u_t005_012/r1_r0_rwl u_t005_012/r1_r1_rwl u_t005_012/r2_w0_wl u_t005_012/r2_w1_wl u_t005_012/r2_r0_rwl
+ u_t005_012/r2_r1_rwl u_t005_012/r3_w0_wl u_t005_012/r3_w1_wl u_t005_012/r3_r0_rwl u_t005_012/r3_r1_rwl VDD VSS VSUBS
+ detronyx_12t_2w2r_rc4_4x4_routed_5layer_direct
Xu_t014_001 u_t014_001/c0_w0_bl u_t014_001/c0_w0_br u_t014_001/c0_w1_bl u_t014_001/c0_w1_br u_t014_001/c0_r0_rbl
+ u_t014_001/c0_r1_rbl u_t014_001/c1_w0_bl u_t014_001/c1_w0_br u_t014_001/c1_w1_bl u_t014_001/c1_w1_br
+ u_t014_001/c1_r0_rbl u_t014_001/c1_r1_rbl u_t014_001/c2_w0_bl u_t014_001/c2_w0_br u_t014_001/c2_w1_bl
+ u_t014_001/c2_w1_br u_t014_001/c2_r0_rbl u_t014_001/c2_r1_rbl u_t014_001/c3_w0_bl u_t014_001/c3_w0_br
+ u_t014_001/c3_w1_bl u_t014_001/c3_w1_br u_t014_001/c3_r0_rbl u_t014_001/c3_r1_rbl u_t014_001/r0_w0_wl
+ u_t014_001/r0_w1_wl u_t014_001/r0_r0_rwl u_t014_001/r0_r1_rwl u_t014_001/r1_w0_wl u_t014_001/r1_w1_wl
+ u_t014_001/r1_r0_rwl u_t014_001/r1_r1_rwl u_t014_001/r2_w0_wl u_t014_001/r2_w1_wl u_t014_001/r2_r0_rwl
+ u_t014_001/r2_r1_rwl u_t014_001/r3_w0_wl u_t014_001/r3_w1_wl u_t014_001/r3_r0_rwl u_t014_001/r3_r1_rwl VDD VSS VSUBS
+ detronyx_12t_2w2r_rc4_4x4_routed_5layer_direct
Xu_t014_012 u_t014_012/c0_w0_bl u_t014_012/c0_w0_br u_t014_012/c0_w1_bl u_t014_012/c0_w1_br u_t014_012/c0_r0_rbl
+ u_t014_012/c0_r1_rbl u_t014_012/c1_w0_bl u_t014_012/c1_w0_br u_t014_012/c1_w1_bl u_t014_012/c1_w1_br
+ u_t014_012/c1_r0_rbl u_t014_012/c1_r1_rbl u_t014_012/c2_w0_bl u_t014_012/c2_w0_br u_t014_012/c2_w1_bl
+ u_t014_012/c2_w1_br u_t014_012/c2_r0_rbl u_t014_012/c2_r1_rbl u_t014_012/c3_w0_bl u_t014_012/c3_w0_br
+ u_t014_012/c3_w1_bl u_t014_012/c3_w1_br u_t014_012/c3_r0_rbl u_t014_012/c3_r1_rbl u_t014_012/r0_w0_wl
+ u_t014_012/r0_w1_wl u_t014_012/r0_r0_rwl u_t014_012/r0_r1_rwl u_t014_012/r1_w0_wl u_t014_012/r1_w1_wl
+ u_t014_012/r1_r0_rwl u_t014_012/r1_r1_rwl u_t014_012/r2_w0_wl u_t014_012/r2_w1_wl u_t014_012/r2_r0_rwl
+ u_t014_012/r2_r1_rwl u_t014_012/r3_w0_wl u_t014_012/r3_w1_wl u_t014_012/r3_r0_rwl u_t014_012/r3_r1_rwl VDD VSS VSUBS
+ detronyx_12t_2w2r_rc4_4x4_routed_5layer_direct
Xu_t011_004 u_t011_004/c0_w0_bl u_t011_004/c0_w0_br u_t011_004/c0_w1_bl u_t011_004/c0_w1_br u_t011_004/c0_r0_rbl
+ u_t011_004/c0_r1_rbl u_t011_004/c1_w0_bl u_t011_004/c1_w0_br u_t011_004/c1_w1_bl u_t011_004/c1_w1_br
+ u_t011_004/c1_r0_rbl u_t011_004/c1_r1_rbl u_t011_004/c2_w0_bl u_t011_004/c2_w0_br u_t011_004/c2_w1_bl
+ u_t011_004/c2_w1_br u_t011_004/c2_r0_rbl u_t011_004/c2_r1_rbl u_t011_004/c3_w0_bl u_t011_004/c3_w0_br
+ u_t011_004/c3_w1_bl u_t011_004/c3_w1_br u_t011_004/c3_r0_rbl u_t011_004/c3_r1_rbl u_t011_004/r0_w0_wl
+ u_t011_004/r0_w1_wl u_t011_004/r0_r0_rwl u_t011_004/r0_r1_rwl u_t011_004/r1_w0_wl u_t011_004/r1_w1_wl
+ u_t011_004/r1_r0_rwl u_t011_004/r1_r1_rwl u_t011_004/r2_w0_wl u_t011_004/r2_w1_wl u_t011_004/r2_r0_rwl
+ u_t011_004/r2_r1_rwl u_t011_004/r3_w0_wl u_t011_004/r3_w1_wl u_t011_004/r3_r0_rwl u_t011_004/r3_r1_rwl VDD VSS VSUBS
+ detronyx_12t_2w2r_rc4_4x4_routed_5layer_direct
Xu_t011_015 u_t011_015/c0_w0_bl u_t011_015/c0_w0_br u_t011_015/c0_w1_bl u_t011_015/c0_w1_br u_t011_015/c0_r0_rbl
+ u_t011_015/c0_r1_rbl u_t011_015/c1_w0_bl u_t011_015/c1_w0_br u_t011_015/c1_w1_bl u_t011_015/c1_w1_br
+ u_t011_015/c1_r0_rbl u_t011_015/c1_r1_rbl u_t011_015/c2_w0_bl u_t011_015/c2_w0_br u_t011_015/c2_w1_bl
+ u_t011_015/c2_w1_br u_t011_015/c2_r0_rbl u_t011_015/c2_r1_rbl u_t011_015/c3_w0_bl u_t011_015/c3_w0_br
+ u_t011_015/c3_w1_bl u_t011_015/c3_w1_br u_t011_015/c3_r0_rbl u_t011_015/c3_r1_rbl u_t011_015/r0_w0_wl
+ u_t011_015/r0_w1_wl u_t011_015/r0_r0_rwl u_t011_015/r0_r1_rwl u_t011_015/r1_w0_wl u_t011_015/r1_w1_wl
+ u_t011_015/r1_r0_rwl u_t011_015/r1_r1_rwl u_t011_015/r2_w0_wl u_t011_015/r2_w1_wl u_t011_015/r2_r0_rwl
+ u_t011_015/r2_r1_rwl u_t011_015/r3_w0_wl u_t011_015/r3_w1_wl u_t011_015/r3_r0_rwl u_t011_015/r3_r1_rwl VDD VSS VSUBS
+ detronyx_12t_2w2r_rc4_4x4_routed_5layer_direct
Xu_t020_004 u_t020_004/c0_w0_bl u_t020_004/c0_w0_br u_t020_004/c0_w1_bl u_t020_004/c0_w1_br u_t020_004/c0_r0_rbl
+ u_t020_004/c0_r1_rbl u_t020_004/c1_w0_bl u_t020_004/c1_w0_br u_t020_004/c1_w1_bl u_t020_004/c1_w1_br
+ u_t020_004/c1_r0_rbl u_t020_004/c1_r1_rbl u_t020_004/c2_w0_bl u_t020_004/c2_w0_br u_t020_004/c2_w1_bl
+ u_t020_004/c2_w1_br u_t020_004/c2_r0_rbl u_t020_004/c2_r1_rbl u_t020_004/c3_w0_bl u_t020_004/c3_w0_br
+ u_t020_004/c3_w1_bl u_t020_004/c3_w1_br u_t020_004/c3_r0_rbl u_t020_004/c3_r1_rbl u_t020_004/r0_w0_wl
+ u_t020_004/r0_w1_wl u_t020_004/r0_r0_rwl u_t020_004/r0_r1_rwl u_t020_004/r1_w0_wl u_t020_004/r1_w1_wl
+ u_t020_004/r1_r0_rwl u_t020_004/r1_r1_rwl u_t020_004/r2_w0_wl u_t020_004/r2_w1_wl u_t020_004/r2_r0_rwl
+ u_t020_004/r2_r1_rwl u_t020_004/r3_w0_wl u_t020_004/r3_w1_wl u_t020_004/r3_r0_rwl u_t020_004/r3_r1_rwl VDD VSS VSUBS
+ detronyx_12t_2w2r_rc4_4x4_routed_5layer_direct
Xu_t020_015 u_t020_015/c0_w0_bl u_t020_015/c0_w0_br u_t020_015/c0_w1_bl u_t020_015/c0_w1_br u_t020_015/c0_r0_rbl
+ u_t020_015/c0_r1_rbl u_t020_015/c1_w0_bl u_t020_015/c1_w0_br u_t020_015/c1_w1_bl u_t020_015/c1_w1_br
+ u_t020_015/c1_r0_rbl u_t020_015/c1_r1_rbl u_t020_015/c2_w0_bl u_t020_015/c2_w0_br u_t020_015/c2_w1_bl
+ u_t020_015/c2_w1_br u_t020_015/c2_r0_rbl u_t020_015/c2_r1_rbl u_t020_015/c3_w0_bl u_t020_015/c3_w0_br
+ u_t020_015/c3_w1_bl u_t020_015/c3_w1_br u_t020_015/c3_r0_rbl u_t020_015/c3_r1_rbl u_t020_015/r0_w0_wl
+ u_t020_015/r0_w1_wl u_t020_015/r0_r0_rwl u_t020_015/r0_r1_rwl u_t020_015/r1_w0_wl u_t020_015/r1_w1_wl
+ u_t020_015/r1_r0_rwl u_t020_015/r1_r1_rwl u_t020_015/r2_w0_wl u_t020_015/r2_w1_wl u_t020_015/r2_r0_rwl
+ u_t020_015/r2_r1_rwl u_t020_015/r3_w0_wl u_t020_015/r3_w1_wl u_t020_015/r3_r0_rwl u_t020_015/r3_r1_rwl VDD VSS VSUBS
+ detronyx_12t_2w2r_rc4_4x4_routed_5layer_direct
Xu_t002_015 u_t002_015/c0_w0_bl u_t002_015/c0_w0_br u_t002_015/c0_w1_bl u_t002_015/c0_w1_br u_t002_015/c0_r0_rbl
+ u_t002_015/c0_r1_rbl u_t002_015/c1_w0_bl u_t002_015/c1_w0_br u_t002_015/c1_w1_bl u_t002_015/c1_w1_br
+ u_t002_015/c1_r0_rbl u_t002_015/c1_r1_rbl u_t002_015/c2_w0_bl u_t002_015/c2_w0_br u_t002_015/c2_w1_bl
+ u_t002_015/c2_w1_br u_t002_015/c2_r0_rbl u_t002_015/c2_r1_rbl u_t002_015/c3_w0_bl u_t002_015/c3_w0_br
+ u_t002_015/c3_w1_bl u_t002_015/c3_w1_br u_t002_015/c3_r0_rbl u_t002_015/c3_r1_rbl u_t002_015/r0_w0_wl
+ u_t002_015/r0_w1_wl u_t002_015/r0_r0_rwl u_t002_015/r0_r1_rwl u_t002_015/r1_w0_wl u_t002_015/r1_w1_wl
+ u_t002_015/r1_r0_rwl u_t002_015/r1_r1_rwl u_t002_015/r2_w0_wl u_t002_015/r2_w1_wl u_t002_015/r2_r0_rwl
+ u_t002_015/r2_r1_rwl u_t002_015/r3_w0_wl u_t002_015/r3_w1_wl u_t002_015/r3_r0_rwl u_t002_015/r3_r1_rwl VDD VSS VSUBS
+ detronyx_12t_2w2r_rc4_4x4_routed_5layer_direct
Xu_t002_004 u_t002_004/c0_w0_bl u_t002_004/c0_w0_br u_t002_004/c0_w1_bl u_t002_004/c0_w1_br u_t002_004/c0_r0_rbl
+ u_t002_004/c0_r1_rbl u_t002_004/c1_w0_bl u_t002_004/c1_w0_br u_t002_004/c1_w1_bl u_t002_004/c1_w1_br
+ u_t002_004/c1_r0_rbl u_t002_004/c1_r1_rbl u_t002_004/c2_w0_bl u_t002_004/c2_w0_br u_t002_004/c2_w1_bl
+ u_t002_004/c2_w1_br u_t002_004/c2_r0_rbl u_t002_004/c2_r1_rbl u_t002_004/c3_w0_bl u_t002_004/c3_w0_br
+ u_t002_004/c3_w1_bl u_t002_004/c3_w1_br u_t002_004/c3_r0_rbl u_t002_004/c3_r1_rbl u_t002_004/r0_w0_wl
+ u_t002_004/r0_w1_wl u_t002_004/r0_r0_rwl u_t002_004/r0_r1_rwl u_t002_004/r1_w0_wl u_t002_004/r1_w1_wl
+ u_t002_004/r1_r0_rwl u_t002_004/r1_r1_rwl u_t002_004/r2_w0_wl u_t002_004/r2_w1_wl u_t002_004/r2_r0_rwl
+ u_t002_004/r2_r1_rwl u_t002_004/r3_w0_wl u_t002_004/r3_w1_wl u_t002_004/r3_r0_rwl u_t002_004/r3_r1_rwl VDD VSS VSUBS
+ detronyx_12t_2w2r_rc4_4x4_routed_5layer_direct
Xu_t026_010 u_t026_010/c0_w0_bl u_t026_010/c0_w0_br u_t026_010/c0_w1_bl u_t026_010/c0_w1_br u_t026_010/c0_r0_rbl
+ u_t026_010/c0_r1_rbl u_t026_010/c1_w0_bl u_t026_010/c1_w0_br u_t026_010/c1_w1_bl u_t026_010/c1_w1_br
+ u_t026_010/c1_r0_rbl u_t026_010/c1_r1_rbl u_t026_010/c2_w0_bl u_t026_010/c2_w0_br u_t026_010/c2_w1_bl
+ u_t026_010/c2_w1_br u_t026_010/c2_r0_rbl u_t026_010/c2_r1_rbl u_t026_010/c3_w0_bl u_t026_010/c3_w0_br
+ u_t026_010/c3_w1_bl u_t026_010/c3_w1_br u_t026_010/c3_r0_rbl u_t026_010/c3_r1_rbl u_t026_010/r0_w0_wl
+ u_t026_010/r0_w1_wl u_t026_010/r0_r0_rwl u_t026_010/r0_r1_rwl u_t026_010/r1_w0_wl u_t026_010/r1_w1_wl
+ u_t026_010/r1_r0_rwl u_t026_010/r1_r1_rwl u_t026_010/r2_w0_wl u_t026_010/r2_w1_wl u_t026_010/r2_r0_rwl
+ u_t026_010/r2_r1_rwl u_t026_010/r3_w0_wl u_t026_010/r3_w1_wl u_t026_010/r3_r0_rwl u_t026_010/r3_r1_rwl VDD VSS VSUBS
+ detronyx_12t_2w2r_rc4_4x4_routed_5layer_direct
Xu_t017_010 u_t017_010/c0_w0_bl u_t017_010/c0_w0_br u_t017_010/c0_w1_bl u_t017_010/c0_w1_br u_t017_010/c0_r0_rbl
+ u_t017_010/c0_r1_rbl u_t017_010/c1_w0_bl u_t017_010/c1_w0_br u_t017_010/c1_w1_bl u_t017_010/c1_w1_br
+ u_t017_010/c1_r0_rbl u_t017_010/c1_r1_rbl u_t017_010/c2_w0_bl u_t017_010/c2_w0_br u_t017_010/c2_w1_bl
+ u_t017_010/c2_w1_br u_t017_010/c2_r0_rbl u_t017_010/c2_r1_rbl u_t017_010/c3_w0_bl u_t017_010/c3_w0_br
+ u_t017_010/c3_w1_bl u_t017_010/c3_w1_br u_t017_010/c3_r0_rbl u_t017_010/c3_r1_rbl u_t017_010/r0_w0_wl
+ u_t017_010/r0_w1_wl u_t017_010/r0_r0_rwl u_t017_010/r0_r1_rwl u_t017_010/r1_w0_wl u_t017_010/r1_w1_wl
+ u_t017_010/r1_r0_rwl u_t017_010/r1_r1_rwl u_t017_010/r2_w0_wl u_t017_010/r2_w1_wl u_t017_010/r2_r0_rwl
+ u_t017_010/r2_r1_rwl u_t017_010/r3_w0_wl u_t017_010/r3_w1_wl u_t017_010/r3_r0_rwl u_t017_010/r3_r1_rwl VDD VSS VSUBS
+ detronyx_12t_2w2r_rc4_4x4_routed_5layer_direct
Xu_t008_010 u_t008_010/c0_w0_bl u_t008_010/c0_w0_br u_t008_010/c0_w1_bl u_t008_010/c0_w1_br u_t008_010/c0_r0_rbl
+ u_t008_010/c0_r1_rbl u_t008_010/c1_w0_bl u_t008_010/c1_w0_br u_t008_010/c1_w1_bl u_t008_010/c1_w1_br
+ u_t008_010/c1_r0_rbl u_t008_010/c1_r1_rbl u_t008_010/c2_w0_bl u_t008_010/c2_w0_br u_t008_010/c2_w1_bl
+ u_t008_010/c2_w1_br u_t008_010/c2_r0_rbl u_t008_010/c2_r1_rbl u_t008_010/c3_w0_bl u_t008_010/c3_w0_br
+ u_t008_010/c3_w1_bl u_t008_010/c3_w1_br u_t008_010/c3_r0_rbl u_t008_010/c3_r1_rbl u_t008_010/r0_w0_wl
+ u_t008_010/r0_w1_wl u_t008_010/r0_r0_rwl u_t008_010/r0_r1_rwl u_t008_010/r1_w0_wl u_t008_010/r1_w1_wl
+ u_t008_010/r1_r0_rwl u_t008_010/r1_r1_rwl u_t008_010/r2_w0_wl u_t008_010/r2_w1_wl u_t008_010/r2_r0_rwl
+ u_t008_010/r2_r1_rwl u_t008_010/r3_w0_wl u_t008_010/r3_w1_wl u_t008_010/r3_r0_rwl u_t008_010/r3_r1_rwl VDD VSS VSUBS
+ detronyx_12t_2w2r_rc4_4x4_routed_5layer_direct
Xu_t023_002 u_t023_002/c0_w0_bl u_t023_002/c0_w0_br u_t023_002/c0_w1_bl u_t023_002/c0_w1_br u_t023_002/c0_r0_rbl
+ u_t023_002/c0_r1_rbl u_t023_002/c1_w0_bl u_t023_002/c1_w0_br u_t023_002/c1_w1_bl u_t023_002/c1_w1_br
+ u_t023_002/c1_r0_rbl u_t023_002/c1_r1_rbl u_t023_002/c2_w0_bl u_t023_002/c2_w0_br u_t023_002/c2_w1_bl
+ u_t023_002/c2_w1_br u_t023_002/c2_r0_rbl u_t023_002/c2_r1_rbl u_t023_002/c3_w0_bl u_t023_002/c3_w0_br
+ u_t023_002/c3_w1_bl u_t023_002/c3_w1_br u_t023_002/c3_r0_rbl u_t023_002/c3_r1_rbl u_t023_002/r0_w0_wl
+ u_t023_002/r0_w1_wl u_t023_002/r0_r0_rwl u_t023_002/r0_r1_rwl u_t023_002/r1_w0_wl u_t023_002/r1_w1_wl
+ u_t023_002/r1_r0_rwl u_t023_002/r1_r1_rwl u_t023_002/r2_w0_wl u_t023_002/r2_w1_wl u_t023_002/r2_r0_rwl
+ u_t023_002/r2_r1_rwl u_t023_002/r3_w0_wl u_t023_002/r3_w1_wl u_t023_002/r3_r0_rwl u_t023_002/r3_r1_rwl VDD VSS VSUBS
+ detronyx_12t_2w2r_rc4_4x4_routed_5layer_direct
Xu_t023_013 u_t023_013/c0_w0_bl u_t023_013/c0_w0_br u_t023_013/c0_w1_bl u_t023_013/c0_w1_br u_t023_013/c0_r0_rbl
+ u_t023_013/c0_r1_rbl u_t023_013/c1_w0_bl u_t023_013/c1_w0_br u_t023_013/c1_w1_bl u_t023_013/c1_w1_br
+ u_t023_013/c1_r0_rbl u_t023_013/c1_r1_rbl u_t023_013/c2_w0_bl u_t023_013/c2_w0_br u_t023_013/c2_w1_bl
+ u_t023_013/c2_w1_br u_t023_013/c2_r0_rbl u_t023_013/c2_r1_rbl u_t023_013/c3_w0_bl u_t023_013/c3_w0_br
+ u_t023_013/c3_w1_bl u_t023_013/c3_w1_br u_t023_013/c3_r0_rbl u_t023_013/c3_r1_rbl u_t023_013/r0_w0_wl
+ u_t023_013/r0_w1_wl u_t023_013/r0_r0_rwl u_t023_013/r0_r1_rwl u_t023_013/r1_w0_wl u_t023_013/r1_w1_wl
+ u_t023_013/r1_r0_rwl u_t023_013/r1_r1_rwl u_t023_013/r2_w0_wl u_t023_013/r2_w1_wl u_t023_013/r2_r0_rwl
+ u_t023_013/r2_r1_rwl u_t023_013/r3_w0_wl u_t023_013/r3_w1_wl u_t023_013/r3_r0_rwl u_t023_013/r3_r1_rwl VDD VSS VSUBS
+ detronyx_12t_2w2r_rc4_4x4_routed_5layer_direct
Xu_t014_002 u_t014_002/c0_w0_bl u_t014_002/c0_w0_br u_t014_002/c0_w1_bl u_t014_002/c0_w1_br u_t014_002/c0_r0_rbl
+ u_t014_002/c0_r1_rbl u_t014_002/c1_w0_bl u_t014_002/c1_w0_br u_t014_002/c1_w1_bl u_t014_002/c1_w1_br
+ u_t014_002/c1_r0_rbl u_t014_002/c1_r1_rbl u_t014_002/c2_w0_bl u_t014_002/c2_w0_br u_t014_002/c2_w1_bl
+ u_t014_002/c2_w1_br u_t014_002/c2_r0_rbl u_t014_002/c2_r1_rbl u_t014_002/c3_w0_bl u_t014_002/c3_w0_br
+ u_t014_002/c3_w1_bl u_t014_002/c3_w1_br u_t014_002/c3_r0_rbl u_t014_002/c3_r1_rbl u_t014_002/r0_w0_wl
+ u_t014_002/r0_w1_wl u_t014_002/r0_r0_rwl u_t014_002/r0_r1_rwl u_t014_002/r1_w0_wl u_t014_002/r1_w1_wl
+ u_t014_002/r1_r0_rwl u_t014_002/r1_r1_rwl u_t014_002/r2_w0_wl u_t014_002/r2_w1_wl u_t014_002/r2_r0_rwl
+ u_t014_002/r2_r1_rwl u_t014_002/r3_w0_wl u_t014_002/r3_w1_wl u_t014_002/r3_r0_rwl u_t014_002/r3_r1_rwl VDD VSS VSUBS
+ detronyx_12t_2w2r_rc4_4x4_routed_5layer_direct
Xu_t014_013 u_t014_013/c0_w0_bl u_t014_013/c0_w0_br u_t014_013/c0_w1_bl u_t014_013/c0_w1_br u_t014_013/c0_r0_rbl
+ u_t014_013/c0_r1_rbl u_t014_013/c1_w0_bl u_t014_013/c1_w0_br u_t014_013/c1_w1_bl u_t014_013/c1_w1_br
+ u_t014_013/c1_r0_rbl u_t014_013/c1_r1_rbl u_t014_013/c2_w0_bl u_t014_013/c2_w0_br u_t014_013/c2_w1_bl
+ u_t014_013/c2_w1_br u_t014_013/c2_r0_rbl u_t014_013/c2_r1_rbl u_t014_013/c3_w0_bl u_t014_013/c3_w0_br
+ u_t014_013/c3_w1_bl u_t014_013/c3_w1_br u_t014_013/c3_r0_rbl u_t014_013/c3_r1_rbl u_t014_013/r0_w0_wl
+ u_t014_013/r0_w1_wl u_t014_013/r0_r0_rwl u_t014_013/r0_r1_rwl u_t014_013/r1_w0_wl u_t014_013/r1_w1_wl
+ u_t014_013/r1_r0_rwl u_t014_013/r1_r1_rwl u_t014_013/r2_w0_wl u_t014_013/r2_w1_wl u_t014_013/r2_r0_rwl
+ u_t014_013/r2_r1_rwl u_t014_013/r3_w0_wl u_t014_013/r3_w1_wl u_t014_013/r3_r0_rwl u_t014_013/r3_r1_rwl VDD VSS VSUBS
+ detronyx_12t_2w2r_rc4_4x4_routed_5layer_direct
Xu_t005_002 u_t005_002/c0_w0_bl u_t005_002/c0_w0_br u_t005_002/c0_w1_bl u_t005_002/c0_w1_br u_t005_002/c0_r0_rbl
+ u_t005_002/c0_r1_rbl u_t005_002/c1_w0_bl u_t005_002/c1_w0_br u_t005_002/c1_w1_bl u_t005_002/c1_w1_br
+ u_t005_002/c1_r0_rbl u_t005_002/c1_r1_rbl u_t005_002/c2_w0_bl u_t005_002/c2_w0_br u_t005_002/c2_w1_bl
+ u_t005_002/c2_w1_br u_t005_002/c2_r0_rbl u_t005_002/c2_r1_rbl u_t005_002/c3_w0_bl u_t005_002/c3_w0_br
+ u_t005_002/c3_w1_bl u_t005_002/c3_w1_br u_t005_002/c3_r0_rbl u_t005_002/c3_r1_rbl u_t005_002/r0_w0_wl
+ u_t005_002/r0_w1_wl u_t005_002/r0_r0_rwl u_t005_002/r0_r1_rwl u_t005_002/r1_w0_wl u_t005_002/r1_w1_wl
+ u_t005_002/r1_r0_rwl u_t005_002/r1_r1_rwl u_t005_002/r2_w0_wl u_t005_002/r2_w1_wl u_t005_002/r2_r0_rwl
+ u_t005_002/r2_r1_rwl u_t005_002/r3_w0_wl u_t005_002/r3_w1_wl u_t005_002/r3_r0_rwl u_t005_002/r3_r1_rwl VDD VSS VSUBS
+ detronyx_12t_2w2r_rc4_4x4_routed_5layer_direct
Xu_t005_013 u_t005_013/c0_w0_bl u_t005_013/c0_w0_br u_t005_013/c0_w1_bl u_t005_013/c0_w1_br u_t005_013/c0_r0_rbl
+ u_t005_013/c0_r1_rbl u_t005_013/c1_w0_bl u_t005_013/c1_w0_br u_t005_013/c1_w1_bl u_t005_013/c1_w1_br
+ u_t005_013/c1_r0_rbl u_t005_013/c1_r1_rbl u_t005_013/c2_w0_bl u_t005_013/c2_w0_br u_t005_013/c2_w1_bl
+ u_t005_013/c2_w1_br u_t005_013/c2_r0_rbl u_t005_013/c2_r1_rbl u_t005_013/c3_w0_bl u_t005_013/c3_w0_br
+ u_t005_013/c3_w1_bl u_t005_013/c3_w1_br u_t005_013/c3_r0_rbl u_t005_013/c3_r1_rbl u_t005_013/r0_w0_wl
+ u_t005_013/r0_w1_wl u_t005_013/r0_r0_rwl u_t005_013/r0_r1_rwl u_t005_013/r1_w0_wl u_t005_013/r1_w1_wl
+ u_t005_013/r1_r0_rwl u_t005_013/r1_r1_rwl u_t005_013/r2_w0_wl u_t005_013/r2_w1_wl u_t005_013/r2_r0_rwl
+ u_t005_013/r2_r1_rwl u_t005_013/r3_w0_wl u_t005_013/r3_w1_wl u_t005_013/r3_r0_rwl u_t005_013/r3_r1_rwl VDD VSS VSUBS
+ detronyx_12t_2w2r_rc4_4x4_routed_5layer_direct
Xu_t020_005 u_t020_005/c0_w0_bl u_t020_005/c0_w0_br u_t020_005/c0_w1_bl u_t020_005/c0_w1_br u_t020_005/c0_r0_rbl
+ u_t020_005/c0_r1_rbl u_t020_005/c1_w0_bl u_t020_005/c1_w0_br u_t020_005/c1_w1_bl u_t020_005/c1_w1_br
+ u_t020_005/c1_r0_rbl u_t020_005/c1_r1_rbl u_t020_005/c2_w0_bl u_t020_005/c2_w0_br u_t020_005/c2_w1_bl
+ u_t020_005/c2_w1_br u_t020_005/c2_r0_rbl u_t020_005/c2_r1_rbl u_t020_005/c3_w0_bl u_t020_005/c3_w0_br
+ u_t020_005/c3_w1_bl u_t020_005/c3_w1_br u_t020_005/c3_r0_rbl u_t020_005/c3_r1_rbl u_t020_005/r0_w0_wl
+ u_t020_005/r0_w1_wl u_t020_005/r0_r0_rwl u_t020_005/r0_r1_rwl u_t020_005/r1_w0_wl u_t020_005/r1_w1_wl
+ u_t020_005/r1_r0_rwl u_t020_005/r1_r1_rwl u_t020_005/r2_w0_wl u_t020_005/r2_w1_wl u_t020_005/r2_r0_rwl
+ u_t020_005/r2_r1_rwl u_t020_005/r3_w0_wl u_t020_005/r3_w1_wl u_t020_005/r3_r0_rwl u_t020_005/r3_r1_rwl VDD VSS VSUBS
+ detronyx_12t_2w2r_rc4_4x4_routed_5layer_direct
Xu_t002_005 u_t002_005/c0_w0_bl u_t002_005/c0_w0_br u_t002_005/c0_w1_bl u_t002_005/c0_w1_br u_t002_005/c0_r0_rbl
+ u_t002_005/c0_r1_rbl u_t002_005/c1_w0_bl u_t002_005/c1_w0_br u_t002_005/c1_w1_bl u_t002_005/c1_w1_br
+ u_t002_005/c1_r0_rbl u_t002_005/c1_r1_rbl u_t002_005/c2_w0_bl u_t002_005/c2_w0_br u_t002_005/c2_w1_bl
+ u_t002_005/c2_w1_br u_t002_005/c2_r0_rbl u_t002_005/c2_r1_rbl u_t002_005/c3_w0_bl u_t002_005/c3_w0_br
+ u_t002_005/c3_w1_bl u_t002_005/c3_w1_br u_t002_005/c3_r0_rbl u_t002_005/c3_r1_rbl u_t002_005/r0_w0_wl
+ u_t002_005/r0_w1_wl u_t002_005/r0_r0_rwl u_t002_005/r0_r1_rwl u_t002_005/r1_w0_wl u_t002_005/r1_w1_wl
+ u_t002_005/r1_r0_rwl u_t002_005/r1_r1_rwl u_t002_005/r2_w0_wl u_t002_005/r2_w1_wl u_t002_005/r2_r0_rwl
+ u_t002_005/r2_r1_rwl u_t002_005/r3_w0_wl u_t002_005/r3_w1_wl u_t002_005/r3_r0_rwl u_t002_005/r3_r1_rwl VDD VSS VSUBS
+ detronyx_12t_2w2r_rc4_4x4_routed_5layer_direct
Xu_t011_005 u_t011_005/c0_w0_bl u_t011_005/c0_w0_br u_t011_005/c0_w1_bl u_t011_005/c0_w1_br u_t011_005/c0_r0_rbl
+ u_t011_005/c0_r1_rbl u_t011_005/c1_w0_bl u_t011_005/c1_w0_br u_t011_005/c1_w1_bl u_t011_005/c1_w1_br
+ u_t011_005/c1_r0_rbl u_t011_005/c1_r1_rbl u_t011_005/c2_w0_bl u_t011_005/c2_w0_br u_t011_005/c2_w1_bl
+ u_t011_005/c2_w1_br u_t011_005/c2_r0_rbl u_t011_005/c2_r1_rbl u_t011_005/c3_w0_bl u_t011_005/c3_w0_br
+ u_t011_005/c3_w1_bl u_t011_005/c3_w1_br u_t011_005/c3_r0_rbl u_t011_005/c3_r1_rbl u_t011_005/r0_w0_wl
+ u_t011_005/r0_w1_wl u_t011_005/r0_r0_rwl u_t011_005/r0_r1_rwl u_t011_005/r1_w0_wl u_t011_005/r1_w1_wl
+ u_t011_005/r1_r0_rwl u_t011_005/r1_r1_rwl u_t011_005/r2_w0_wl u_t011_005/r2_w1_wl u_t011_005/r2_r0_rwl
+ u_t011_005/r2_r1_rwl u_t011_005/r3_w0_wl u_t011_005/r3_w1_wl u_t011_005/r3_r0_rwl u_t011_005/r3_r1_rwl VDD VSS VSUBS
+ detronyx_12t_2w2r_rc4_4x4_routed_5layer_direct
Xu_t026_011 u_t026_011/c0_w0_bl u_t026_011/c0_w0_br u_t026_011/c0_w1_bl u_t026_011/c0_w1_br u_t026_011/c0_r0_rbl
+ u_t026_011/c0_r1_rbl u_t026_011/c1_w0_bl u_t026_011/c1_w0_br u_t026_011/c1_w1_bl u_t026_011/c1_w1_br
+ u_t026_011/c1_r0_rbl u_t026_011/c1_r1_rbl u_t026_011/c2_w0_bl u_t026_011/c2_w0_br u_t026_011/c2_w1_bl
+ u_t026_011/c2_w1_br u_t026_011/c2_r0_rbl u_t026_011/c2_r1_rbl u_t026_011/c3_w0_bl u_t026_011/c3_w0_br
+ u_t026_011/c3_w1_bl u_t026_011/c3_w1_br u_t026_011/c3_r0_rbl u_t026_011/c3_r1_rbl u_t026_011/r0_w0_wl
+ u_t026_011/r0_w1_wl u_t026_011/r0_r0_rwl u_t026_011/r0_r1_rwl u_t026_011/r1_w0_wl u_t026_011/r1_w1_wl
+ u_t026_011/r1_r0_rwl u_t026_011/r1_r1_rwl u_t026_011/r2_w0_wl u_t026_011/r2_w1_wl u_t026_011/r2_r0_rwl
+ u_t026_011/r2_r1_rwl u_t026_011/r3_w0_wl u_t026_011/r3_w1_wl u_t026_011/r3_r0_rwl u_t026_011/r3_r1_rwl VDD VSS VSUBS
+ detronyx_12t_2w2r_rc4_4x4_routed_5layer_direct
Xu_t026_000 u_t026_000/c0_w0_bl u_t026_000/c0_w0_br u_t026_000/c0_w1_bl u_t026_000/c0_w1_br u_t026_000/c0_r0_rbl
+ u_t026_000/c0_r1_rbl u_t026_000/c1_w0_bl u_t026_000/c1_w0_br u_t026_000/c1_w1_bl u_t026_000/c1_w1_br
+ u_t026_000/c1_r0_rbl u_t026_000/c1_r1_rbl u_t026_000/c2_w0_bl u_t026_000/c2_w0_br u_t026_000/c2_w1_bl
+ u_t026_000/c2_w1_br u_t026_000/c2_r0_rbl u_t026_000/c2_r1_rbl u_t026_000/c3_w0_bl u_t026_000/c3_w0_br
+ u_t026_000/c3_w1_bl u_t026_000/c3_w1_br u_t026_000/c3_r0_rbl u_t026_000/c3_r1_rbl u_t026_000/r0_w0_wl
+ u_t026_000/r0_w1_wl u_t026_000/r0_r0_rwl u_t026_000/r0_r1_rwl u_t026_000/r1_w0_wl u_t026_000/r1_w1_wl
+ u_t026_000/r1_r0_rwl u_t026_000/r1_r1_rwl u_t026_000/r2_w0_wl u_t026_000/r2_w1_wl u_t026_000/r2_r0_rwl
+ u_t026_000/r2_r1_rwl u_t026_000/r3_w0_wl u_t026_000/r3_w1_wl u_t026_000/r3_r0_rwl u_t026_000/r3_r1_rwl VDD VSS VSUBS
+ detronyx_12t_2w2r_rc4_4x4_routed_5layer_direct
Xu_t017_000 u_t017_000/c0_w0_bl u_t017_000/c0_w0_br u_t017_000/c0_w1_bl u_t017_000/c0_w1_br u_t017_000/c0_r0_rbl
+ u_t017_000/c0_r1_rbl u_t017_000/c1_w0_bl u_t017_000/c1_w0_br u_t017_000/c1_w1_bl u_t017_000/c1_w1_br
+ u_t017_000/c1_r0_rbl u_t017_000/c1_r1_rbl u_t017_000/c2_w0_bl u_t017_000/c2_w0_br u_t017_000/c2_w1_bl
+ u_t017_000/c2_w1_br u_t017_000/c2_r0_rbl u_t017_000/c2_r1_rbl u_t017_000/c3_w0_bl u_t017_000/c3_w0_br
+ u_t017_000/c3_w1_bl u_t017_000/c3_w1_br u_t017_000/c3_r0_rbl u_t017_000/c3_r1_rbl u_t017_000/r0_w0_wl
+ u_t017_000/r0_w1_wl u_t017_000/r0_r0_rwl u_t017_000/r0_r1_rwl u_t017_000/r1_w0_wl u_t017_000/r1_w1_wl
+ u_t017_000/r1_r0_rwl u_t017_000/r1_r1_rwl u_t017_000/r2_w0_wl u_t017_000/r2_w1_wl u_t017_000/r2_r0_rwl
+ u_t017_000/r2_r1_rwl u_t017_000/r3_w0_wl u_t017_000/r3_w1_wl u_t017_000/r3_r0_rwl u_t017_000/r3_r1_rwl VDD VSS VSUBS
+ detronyx_12t_2w2r_rc4_4x4_routed_5layer_direct
Xu_t017_011 u_t017_011/c0_w0_bl u_t017_011/c0_w0_br u_t017_011/c0_w1_bl u_t017_011/c0_w1_br u_t017_011/c0_r0_rbl
+ u_t017_011/c0_r1_rbl u_t017_011/c1_w0_bl u_t017_011/c1_w0_br u_t017_011/c1_w1_bl u_t017_011/c1_w1_br
+ u_t017_011/c1_r0_rbl u_t017_011/c1_r1_rbl u_t017_011/c2_w0_bl u_t017_011/c2_w0_br u_t017_011/c2_w1_bl
+ u_t017_011/c2_w1_br u_t017_011/c2_r0_rbl u_t017_011/c2_r1_rbl u_t017_011/c3_w0_bl u_t017_011/c3_w0_br
+ u_t017_011/c3_w1_bl u_t017_011/c3_w1_br u_t017_011/c3_r0_rbl u_t017_011/c3_r1_rbl u_t017_011/r0_w0_wl
+ u_t017_011/r0_w1_wl u_t017_011/r0_r0_rwl u_t017_011/r0_r1_rwl u_t017_011/r1_w0_wl u_t017_011/r1_w1_wl
+ u_t017_011/r1_r0_rwl u_t017_011/r1_r1_rwl u_t017_011/r2_w0_wl u_t017_011/r2_w1_wl u_t017_011/r2_r0_rwl
+ u_t017_011/r2_r1_rwl u_t017_011/r3_w0_wl u_t017_011/r3_w1_wl u_t017_011/r3_r0_rwl u_t017_011/r3_r1_rwl VDD VSS VSUBS
+ detronyx_12t_2w2r_rc4_4x4_routed_5layer_direct
Xu_t008_000 u_t008_000/c0_w0_bl u_t008_000/c0_w0_br u_t008_000/c0_w1_bl u_t008_000/c0_w1_br u_t008_000/c0_r0_rbl
+ u_t008_000/c0_r1_rbl u_t008_000/c1_w0_bl u_t008_000/c1_w0_br u_t008_000/c1_w1_bl u_t008_000/c1_w1_br
+ u_t008_000/c1_r0_rbl u_t008_000/c1_r1_rbl u_t008_000/c2_w0_bl u_t008_000/c2_w0_br u_t008_000/c2_w1_bl
+ u_t008_000/c2_w1_br u_t008_000/c2_r0_rbl u_t008_000/c2_r1_rbl u_t008_000/c3_w0_bl u_t008_000/c3_w0_br
+ u_t008_000/c3_w1_bl u_t008_000/c3_w1_br u_t008_000/c3_r0_rbl u_t008_000/c3_r1_rbl u_t008_000/r0_w0_wl
+ u_t008_000/r0_w1_wl u_t008_000/r0_r0_rwl u_t008_000/r0_r1_rwl u_t008_000/r1_w0_wl u_t008_000/r1_w1_wl
+ u_t008_000/r1_r0_rwl u_t008_000/r1_r1_rwl u_t008_000/r2_w0_wl u_t008_000/r2_w1_wl u_t008_000/r2_r0_rwl
+ u_t008_000/r2_r1_rwl u_t008_000/r3_w0_wl u_t008_000/r3_w1_wl u_t008_000/r3_r0_rwl u_t008_000/r3_r1_rwl VDD VSS VSUBS
+ detronyx_12t_2w2r_rc4_4x4_routed_5layer_direct
Xu_t008_011 u_t008_011/c0_w0_bl u_t008_011/c0_w0_br u_t008_011/c0_w1_bl u_t008_011/c0_w1_br u_t008_011/c0_r0_rbl
+ u_t008_011/c0_r1_rbl u_t008_011/c1_w0_bl u_t008_011/c1_w0_br u_t008_011/c1_w1_bl u_t008_011/c1_w1_br
+ u_t008_011/c1_r0_rbl u_t008_011/c1_r1_rbl u_t008_011/c2_w0_bl u_t008_011/c2_w0_br u_t008_011/c2_w1_bl
+ u_t008_011/c2_w1_br u_t008_011/c2_r0_rbl u_t008_011/c2_r1_rbl u_t008_011/c3_w0_bl u_t008_011/c3_w0_br
+ u_t008_011/c3_w1_bl u_t008_011/c3_w1_br u_t008_011/c3_r0_rbl u_t008_011/c3_r1_rbl u_t008_011/r0_w0_wl
+ u_t008_011/r0_w1_wl u_t008_011/r0_r0_rwl u_t008_011/r0_r1_rwl u_t008_011/r1_w0_wl u_t008_011/r1_w1_wl
+ u_t008_011/r1_r0_rwl u_t008_011/r1_r1_rwl u_t008_011/r2_w0_wl u_t008_011/r2_w1_wl u_t008_011/r2_r0_rwl
+ u_t008_011/r2_r1_rwl u_t008_011/r3_w0_wl u_t008_011/r3_w1_wl u_t008_011/r3_r0_rwl u_t008_011/r3_r1_rwl VDD VSS VSUBS
+ detronyx_12t_2w2r_rc4_4x4_routed_5layer_direct
Xu_t023_003 u_t023_003/c0_w0_bl u_t023_003/c0_w0_br u_t023_003/c0_w1_bl u_t023_003/c0_w1_br u_t023_003/c0_r0_rbl
+ u_t023_003/c0_r1_rbl u_t023_003/c1_w0_bl u_t023_003/c1_w0_br u_t023_003/c1_w1_bl u_t023_003/c1_w1_br
+ u_t023_003/c1_r0_rbl u_t023_003/c1_r1_rbl u_t023_003/c2_w0_bl u_t023_003/c2_w0_br u_t023_003/c2_w1_bl
+ u_t023_003/c2_w1_br u_t023_003/c2_r0_rbl u_t023_003/c2_r1_rbl u_t023_003/c3_w0_bl u_t023_003/c3_w0_br
+ u_t023_003/c3_w1_bl u_t023_003/c3_w1_br u_t023_003/c3_r0_rbl u_t023_003/c3_r1_rbl u_t023_003/r0_w0_wl
+ u_t023_003/r0_w1_wl u_t023_003/r0_r0_rwl u_t023_003/r0_r1_rwl u_t023_003/r1_w0_wl u_t023_003/r1_w1_wl
+ u_t023_003/r1_r0_rwl u_t023_003/r1_r1_rwl u_t023_003/r2_w0_wl u_t023_003/r2_w1_wl u_t023_003/r2_r0_rwl
+ u_t023_003/r2_r1_rwl u_t023_003/r3_w0_wl u_t023_003/r3_w1_wl u_t023_003/r3_r0_rwl u_t023_003/r3_r1_rwl VDD VSS VSUBS
+ detronyx_12t_2w2r_rc4_4x4_routed_5layer_direct
Xu_t023_014 u_t023_014/c0_w0_bl u_t023_014/c0_w0_br u_t023_014/c0_w1_bl u_t023_014/c0_w1_br u_t023_014/c0_r0_rbl
+ u_t023_014/c0_r1_rbl u_t023_014/c1_w0_bl u_t023_014/c1_w0_br u_t023_014/c1_w1_bl u_t023_014/c1_w1_br
+ u_t023_014/c1_r0_rbl u_t023_014/c1_r1_rbl u_t023_014/c2_w0_bl u_t023_014/c2_w0_br u_t023_014/c2_w1_bl
+ u_t023_014/c2_w1_br u_t023_014/c2_r0_rbl u_t023_014/c2_r1_rbl u_t023_014/c3_w0_bl u_t023_014/c3_w0_br
+ u_t023_014/c3_w1_bl u_t023_014/c3_w1_br u_t023_014/c3_r0_rbl u_t023_014/c3_r1_rbl u_t023_014/r0_w0_wl
+ u_t023_014/r0_w1_wl u_t023_014/r0_r0_rwl u_t023_014/r0_r1_rwl u_t023_014/r1_w0_wl u_t023_014/r1_w1_wl
+ u_t023_014/r1_r0_rwl u_t023_014/r1_r1_rwl u_t023_014/r2_w0_wl u_t023_014/r2_w1_wl u_t023_014/r2_r0_rwl
+ u_t023_014/r2_r1_rwl u_t023_014/r3_w0_wl u_t023_014/r3_w1_wl u_t023_014/r3_r0_rwl u_t023_014/r3_r1_rwl VDD VSS VSUBS
+ detronyx_12t_2w2r_rc4_4x4_routed_5layer_direct
Xu_t014_003 u_t014_003/c0_w0_bl u_t014_003/c0_w0_br u_t014_003/c0_w1_bl u_t014_003/c0_w1_br u_t014_003/c0_r0_rbl
+ u_t014_003/c0_r1_rbl u_t014_003/c1_w0_bl u_t014_003/c1_w0_br u_t014_003/c1_w1_bl u_t014_003/c1_w1_br
+ u_t014_003/c1_r0_rbl u_t014_003/c1_r1_rbl u_t014_003/c2_w0_bl u_t014_003/c2_w0_br u_t014_003/c2_w1_bl
+ u_t014_003/c2_w1_br u_t014_003/c2_r0_rbl u_t014_003/c2_r1_rbl u_t014_003/c3_w0_bl u_t014_003/c3_w0_br
+ u_t014_003/c3_w1_bl u_t014_003/c3_w1_br u_t014_003/c3_r0_rbl u_t014_003/c3_r1_rbl u_t014_003/r0_w0_wl
+ u_t014_003/r0_w1_wl u_t014_003/r0_r0_rwl u_t014_003/r0_r1_rwl u_t014_003/r1_w0_wl u_t014_003/r1_w1_wl
+ u_t014_003/r1_r0_rwl u_t014_003/r1_r1_rwl u_t014_003/r2_w0_wl u_t014_003/r2_w1_wl u_t014_003/r2_r0_rwl
+ u_t014_003/r2_r1_rwl u_t014_003/r3_w0_wl u_t014_003/r3_w1_wl u_t014_003/r3_r0_rwl u_t014_003/r3_r1_rwl VDD VSS VSUBS
+ detronyx_12t_2w2r_rc4_4x4_routed_5layer_direct
Xu_t014_014 u_t014_014/c0_w0_bl u_t014_014/c0_w0_br u_t014_014/c0_w1_bl u_t014_014/c0_w1_br u_t014_014/c0_r0_rbl
+ u_t014_014/c0_r1_rbl u_t014_014/c1_w0_bl u_t014_014/c1_w0_br u_t014_014/c1_w1_bl u_t014_014/c1_w1_br
+ u_t014_014/c1_r0_rbl u_t014_014/c1_r1_rbl u_t014_014/c2_w0_bl u_t014_014/c2_w0_br u_t014_014/c2_w1_bl
+ u_t014_014/c2_w1_br u_t014_014/c2_r0_rbl u_t014_014/c2_r1_rbl u_t014_014/c3_w0_bl u_t014_014/c3_w0_br
+ u_t014_014/c3_w1_bl u_t014_014/c3_w1_br u_t014_014/c3_r0_rbl u_t014_014/c3_r1_rbl u_t014_014/r0_w0_wl
+ u_t014_014/r0_w1_wl u_t014_014/r0_r0_rwl u_t014_014/r0_r1_rwl u_t014_014/r1_w0_wl u_t014_014/r1_w1_wl
+ u_t014_014/r1_r0_rwl u_t014_014/r1_r1_rwl u_t014_014/r2_w0_wl u_t014_014/r2_w1_wl u_t014_014/r2_r0_rwl
+ u_t014_014/r2_r1_rwl u_t014_014/r3_w0_wl u_t014_014/r3_w1_wl u_t014_014/r3_r0_rwl u_t014_014/r3_r1_rwl VDD VSS VSUBS
+ detronyx_12t_2w2r_rc4_4x4_routed_5layer_direct
Xu_t005_003 u_t005_003/c0_w0_bl u_t005_003/c0_w0_br u_t005_003/c0_w1_bl u_t005_003/c0_w1_br u_t005_003/c0_r0_rbl
+ u_t005_003/c0_r1_rbl u_t005_003/c1_w0_bl u_t005_003/c1_w0_br u_t005_003/c1_w1_bl u_t005_003/c1_w1_br
+ u_t005_003/c1_r0_rbl u_t005_003/c1_r1_rbl u_t005_003/c2_w0_bl u_t005_003/c2_w0_br u_t005_003/c2_w1_bl
+ u_t005_003/c2_w1_br u_t005_003/c2_r0_rbl u_t005_003/c2_r1_rbl u_t005_003/c3_w0_bl u_t005_003/c3_w0_br
+ u_t005_003/c3_w1_bl u_t005_003/c3_w1_br u_t005_003/c3_r0_rbl u_t005_003/c3_r1_rbl u_t005_003/r0_w0_wl
+ u_t005_003/r0_w1_wl u_t005_003/r0_r0_rwl u_t005_003/r0_r1_rwl u_t005_003/r1_w0_wl u_t005_003/r1_w1_wl
+ u_t005_003/r1_r0_rwl u_t005_003/r1_r1_rwl u_t005_003/r2_w0_wl u_t005_003/r2_w1_wl u_t005_003/r2_r0_rwl
+ u_t005_003/r2_r1_rwl u_t005_003/r3_w0_wl u_t005_003/r3_w1_wl u_t005_003/r3_r0_rwl u_t005_003/r3_r1_rwl VDD VSS VSUBS
+ detronyx_12t_2w2r_rc4_4x4_routed_5layer_direct
Xu_t005_014 u_t005_014/c0_w0_bl u_t005_014/c0_w0_br u_t005_014/c0_w1_bl u_t005_014/c0_w1_br u_t005_014/c0_r0_rbl
+ u_t005_014/c0_r1_rbl u_t005_014/c1_w0_bl u_t005_014/c1_w0_br u_t005_014/c1_w1_bl u_t005_014/c1_w1_br
+ u_t005_014/c1_r0_rbl u_t005_014/c1_r1_rbl u_t005_014/c2_w0_bl u_t005_014/c2_w0_br u_t005_014/c2_w1_bl
+ u_t005_014/c2_w1_br u_t005_014/c2_r0_rbl u_t005_014/c2_r1_rbl u_t005_014/c3_w0_bl u_t005_014/c3_w0_br
+ u_t005_014/c3_w1_bl u_t005_014/c3_w1_br u_t005_014/c3_r0_rbl u_t005_014/c3_r1_rbl u_t005_014/r0_w0_wl
+ u_t005_014/r0_w1_wl u_t005_014/r0_r0_rwl u_t005_014/r0_r1_rwl u_t005_014/r1_w0_wl u_t005_014/r1_w1_wl
+ u_t005_014/r1_r0_rwl u_t005_014/r1_r1_rwl u_t005_014/r2_w0_wl u_t005_014/r2_w1_wl u_t005_014/r2_r0_rwl
+ u_t005_014/r2_r1_rwl u_t005_014/r3_w0_wl u_t005_014/r3_w1_wl u_t005_014/r3_r0_rwl u_t005_014/r3_r1_rwl VDD VSS VSUBS
+ detronyx_12t_2w2r_rc4_4x4_routed_5layer_direct
Xu_t020_006 u_t020_006/c0_w0_bl u_t020_006/c0_w0_br u_t020_006/c0_w1_bl u_t020_006/c0_w1_br u_t020_006/c0_r0_rbl
+ u_t020_006/c0_r1_rbl u_t020_006/c1_w0_bl u_t020_006/c1_w0_br u_t020_006/c1_w1_bl u_t020_006/c1_w1_br
+ u_t020_006/c1_r0_rbl u_t020_006/c1_r1_rbl u_t020_006/c2_w0_bl u_t020_006/c2_w0_br u_t020_006/c2_w1_bl
+ u_t020_006/c2_w1_br u_t020_006/c2_r0_rbl u_t020_006/c2_r1_rbl u_t020_006/c3_w0_bl u_t020_006/c3_w0_br
+ u_t020_006/c3_w1_bl u_t020_006/c3_w1_br u_t020_006/c3_r0_rbl u_t020_006/c3_r1_rbl u_t020_006/r0_w0_wl
+ u_t020_006/r0_w1_wl u_t020_006/r0_r0_rwl u_t020_006/r0_r1_rwl u_t020_006/r1_w0_wl u_t020_006/r1_w1_wl
+ u_t020_006/r1_r0_rwl u_t020_006/r1_r1_rwl u_t020_006/r2_w0_wl u_t020_006/r2_w1_wl u_t020_006/r2_r0_rwl
+ u_t020_006/r2_r1_rwl u_t020_006/r3_w0_wl u_t020_006/r3_w1_wl u_t020_006/r3_r0_rwl u_t020_006/r3_r1_rwl VDD VSS VSUBS
+ detronyx_12t_2w2r_rc4_4x4_routed_5layer_direct
Xu_t011_006 u_t011_006/c0_w0_bl u_t011_006/c0_w0_br u_t011_006/c0_w1_bl u_t011_006/c0_w1_br u_t011_006/c0_r0_rbl
+ u_t011_006/c0_r1_rbl u_t011_006/c1_w0_bl u_t011_006/c1_w0_br u_t011_006/c1_w1_bl u_t011_006/c1_w1_br
+ u_t011_006/c1_r0_rbl u_t011_006/c1_r1_rbl u_t011_006/c2_w0_bl u_t011_006/c2_w0_br u_t011_006/c2_w1_bl
+ u_t011_006/c2_w1_br u_t011_006/c2_r0_rbl u_t011_006/c2_r1_rbl u_t011_006/c3_w0_bl u_t011_006/c3_w0_br
+ u_t011_006/c3_w1_bl u_t011_006/c3_w1_br u_t011_006/c3_r0_rbl u_t011_006/c3_r1_rbl u_t011_006/r0_w0_wl
+ u_t011_006/r0_w1_wl u_t011_006/r0_r0_rwl u_t011_006/r0_r1_rwl u_t011_006/r1_w0_wl u_t011_006/r1_w1_wl
+ u_t011_006/r1_r0_rwl u_t011_006/r1_r1_rwl u_t011_006/r2_w0_wl u_t011_006/r2_w1_wl u_t011_006/r2_r0_rwl
+ u_t011_006/r2_r1_rwl u_t011_006/r3_w0_wl u_t011_006/r3_w1_wl u_t011_006/r3_r0_rwl u_t011_006/r3_r1_rwl VDD VSS VSUBS
+ detronyx_12t_2w2r_rc4_4x4_routed_5layer_direct
Xu_t002_006 u_t002_006/c0_w0_bl u_t002_006/c0_w0_br u_t002_006/c0_w1_bl u_t002_006/c0_w1_br u_t002_006/c0_r0_rbl
+ u_t002_006/c0_r1_rbl u_t002_006/c1_w0_bl u_t002_006/c1_w0_br u_t002_006/c1_w1_bl u_t002_006/c1_w1_br
+ u_t002_006/c1_r0_rbl u_t002_006/c1_r1_rbl u_t002_006/c2_w0_bl u_t002_006/c2_w0_br u_t002_006/c2_w1_bl
+ u_t002_006/c2_w1_br u_t002_006/c2_r0_rbl u_t002_006/c2_r1_rbl u_t002_006/c3_w0_bl u_t002_006/c3_w0_br
+ u_t002_006/c3_w1_bl u_t002_006/c3_w1_br u_t002_006/c3_r0_rbl u_t002_006/c3_r1_rbl u_t002_006/r0_w0_wl
+ u_t002_006/r0_w1_wl u_t002_006/r0_r0_rwl u_t002_006/r0_r1_rwl u_t002_006/r1_w0_wl u_t002_006/r1_w1_wl
+ u_t002_006/r1_r0_rwl u_t002_006/r1_r1_rwl u_t002_006/r2_w0_wl u_t002_006/r2_w1_wl u_t002_006/r2_r0_rwl
+ u_t002_006/r2_r1_rwl u_t002_006/r3_w0_wl u_t002_006/r3_w1_wl u_t002_006/r3_r0_rwl u_t002_006/r3_r1_rwl VDD VSS VSUBS
+ detronyx_12t_2w2r_rc4_4x4_routed_5layer_direct
Xu_t026_012 u_t026_012/c0_w0_bl u_t026_012/c0_w0_br u_t026_012/c0_w1_bl u_t026_012/c0_w1_br u_t026_012/c0_r0_rbl
+ u_t026_012/c0_r1_rbl u_t026_012/c1_w0_bl u_t026_012/c1_w0_br u_t026_012/c1_w1_bl u_t026_012/c1_w1_br
+ u_t026_012/c1_r0_rbl u_t026_012/c1_r1_rbl u_t026_012/c2_w0_bl u_t026_012/c2_w0_br u_t026_012/c2_w1_bl
+ u_t026_012/c2_w1_br u_t026_012/c2_r0_rbl u_t026_012/c2_r1_rbl u_t026_012/c3_w0_bl u_t026_012/c3_w0_br
+ u_t026_012/c3_w1_bl u_t026_012/c3_w1_br u_t026_012/c3_r0_rbl u_t026_012/c3_r1_rbl u_t026_012/r0_w0_wl
+ u_t026_012/r0_w1_wl u_t026_012/r0_r0_rwl u_t026_012/r0_r1_rwl u_t026_012/r1_w0_wl u_t026_012/r1_w1_wl
+ u_t026_012/r1_r0_rwl u_t026_012/r1_r1_rwl u_t026_012/r2_w0_wl u_t026_012/r2_w1_wl u_t026_012/r2_r0_rwl
+ u_t026_012/r2_r1_rwl u_t026_012/r3_w0_wl u_t026_012/r3_w1_wl u_t026_012/r3_r0_rwl u_t026_012/r3_r1_rwl VDD VSS VSUBS
+ detronyx_12t_2w2r_rc4_4x4_routed_5layer_direct
Xu_t026_001 u_t026_001/c0_w0_bl u_t026_001/c0_w0_br u_t026_001/c0_w1_bl u_t026_001/c0_w1_br u_t026_001/c0_r0_rbl
+ u_t026_001/c0_r1_rbl u_t026_001/c1_w0_bl u_t026_001/c1_w0_br u_t026_001/c1_w1_bl u_t026_001/c1_w1_br
+ u_t026_001/c1_r0_rbl u_t026_001/c1_r1_rbl u_t026_001/c2_w0_bl u_t026_001/c2_w0_br u_t026_001/c2_w1_bl
+ u_t026_001/c2_w1_br u_t026_001/c2_r0_rbl u_t026_001/c2_r1_rbl u_t026_001/c3_w0_bl u_t026_001/c3_w0_br
+ u_t026_001/c3_w1_bl u_t026_001/c3_w1_br u_t026_001/c3_r0_rbl u_t026_001/c3_r1_rbl u_t026_001/r0_w0_wl
+ u_t026_001/r0_w1_wl u_t026_001/r0_r0_rwl u_t026_001/r0_r1_rwl u_t026_001/r1_w0_wl u_t026_001/r1_w1_wl
+ u_t026_001/r1_r0_rwl u_t026_001/r1_r1_rwl u_t026_001/r2_w0_wl u_t026_001/r2_w1_wl u_t026_001/r2_r0_rwl
+ u_t026_001/r2_r1_rwl u_t026_001/r3_w0_wl u_t026_001/r3_w1_wl u_t026_001/r3_r0_rwl u_t026_001/r3_r1_rwl VDD VSS VSUBS
+ detronyx_12t_2w2r_rc4_4x4_routed_5layer_direct
Xu_t017_001 u_t017_001/c0_w0_bl u_t017_001/c0_w0_br u_t017_001/c0_w1_bl u_t017_001/c0_w1_br u_t017_001/c0_r0_rbl
+ u_t017_001/c0_r1_rbl u_t017_001/c1_w0_bl u_t017_001/c1_w0_br u_t017_001/c1_w1_bl u_t017_001/c1_w1_br
+ u_t017_001/c1_r0_rbl u_t017_001/c1_r1_rbl u_t017_001/c2_w0_bl u_t017_001/c2_w0_br u_t017_001/c2_w1_bl
+ u_t017_001/c2_w1_br u_t017_001/c2_r0_rbl u_t017_001/c2_r1_rbl u_t017_001/c3_w0_bl u_t017_001/c3_w0_br
+ u_t017_001/c3_w1_bl u_t017_001/c3_w1_br u_t017_001/c3_r0_rbl u_t017_001/c3_r1_rbl u_t017_001/r0_w0_wl
+ u_t017_001/r0_w1_wl u_t017_001/r0_r0_rwl u_t017_001/r0_r1_rwl u_t017_001/r1_w0_wl u_t017_001/r1_w1_wl
+ u_t017_001/r1_r0_rwl u_t017_001/r1_r1_rwl u_t017_001/r2_w0_wl u_t017_001/r2_w1_wl u_t017_001/r2_r0_rwl
+ u_t017_001/r2_r1_rwl u_t017_001/r3_w0_wl u_t017_001/r3_w1_wl u_t017_001/r3_r0_rwl u_t017_001/r3_r1_rwl VDD VSS VSUBS
+ detronyx_12t_2w2r_rc4_4x4_routed_5layer_direct
Xu_t017_012 u_t017_012/c0_w0_bl u_t017_012/c0_w0_br u_t017_012/c0_w1_bl u_t017_012/c0_w1_br u_t017_012/c0_r0_rbl
+ u_t017_012/c0_r1_rbl u_t017_012/c1_w0_bl u_t017_012/c1_w0_br u_t017_012/c1_w1_bl u_t017_012/c1_w1_br
+ u_t017_012/c1_r0_rbl u_t017_012/c1_r1_rbl u_t017_012/c2_w0_bl u_t017_012/c2_w0_br u_t017_012/c2_w1_bl
+ u_t017_012/c2_w1_br u_t017_012/c2_r0_rbl u_t017_012/c2_r1_rbl u_t017_012/c3_w0_bl u_t017_012/c3_w0_br
+ u_t017_012/c3_w1_bl u_t017_012/c3_w1_br u_t017_012/c3_r0_rbl u_t017_012/c3_r1_rbl u_t017_012/r0_w0_wl
+ u_t017_012/r0_w1_wl u_t017_012/r0_r0_rwl u_t017_012/r0_r1_rwl u_t017_012/r1_w0_wl u_t017_012/r1_w1_wl
+ u_t017_012/r1_r0_rwl u_t017_012/r1_r1_rwl u_t017_012/r2_w0_wl u_t017_012/r2_w1_wl u_t017_012/r2_r0_rwl
+ u_t017_012/r2_r1_rwl u_t017_012/r3_w0_wl u_t017_012/r3_w1_wl u_t017_012/r3_r0_rwl u_t017_012/r3_r1_rwl VDD VSS VSUBS
+ detronyx_12t_2w2r_rc4_4x4_routed_5layer_direct
Xu_t008_001 u_t008_001/c0_w0_bl u_t008_001/c0_w0_br u_t008_001/c0_w1_bl u_t008_001/c0_w1_br u_t008_001/c0_r0_rbl
+ u_t008_001/c0_r1_rbl u_t008_001/c1_w0_bl u_t008_001/c1_w0_br u_t008_001/c1_w1_bl u_t008_001/c1_w1_br
+ u_t008_001/c1_r0_rbl u_t008_001/c1_r1_rbl u_t008_001/c2_w0_bl u_t008_001/c2_w0_br u_t008_001/c2_w1_bl
+ u_t008_001/c2_w1_br u_t008_001/c2_r0_rbl u_t008_001/c2_r1_rbl u_t008_001/c3_w0_bl u_t008_001/c3_w0_br
+ u_t008_001/c3_w1_bl u_t008_001/c3_w1_br u_t008_001/c3_r0_rbl u_t008_001/c3_r1_rbl u_t008_001/r0_w0_wl
+ u_t008_001/r0_w1_wl u_t008_001/r0_r0_rwl u_t008_001/r0_r1_rwl u_t008_001/r1_w0_wl u_t008_001/r1_w1_wl
+ u_t008_001/r1_r0_rwl u_t008_001/r1_r1_rwl u_t008_001/r2_w0_wl u_t008_001/r2_w1_wl u_t008_001/r2_r0_rwl
+ u_t008_001/r2_r1_rwl u_t008_001/r3_w0_wl u_t008_001/r3_w1_wl u_t008_001/r3_r0_rwl u_t008_001/r3_r1_rwl VDD VSS VSUBS
+ detronyx_12t_2w2r_rc4_4x4_routed_5layer_direct
Xu_t008_012 u_t008_012/c0_w0_bl u_t008_012/c0_w0_br u_t008_012/c0_w1_bl u_t008_012/c0_w1_br u_t008_012/c0_r0_rbl
+ u_t008_012/c0_r1_rbl u_t008_012/c1_w0_bl u_t008_012/c1_w0_br u_t008_012/c1_w1_bl u_t008_012/c1_w1_br
+ u_t008_012/c1_r0_rbl u_t008_012/c1_r1_rbl u_t008_012/c2_w0_bl u_t008_012/c2_w0_br u_t008_012/c2_w1_bl
+ u_t008_012/c2_w1_br u_t008_012/c2_r0_rbl u_t008_012/c2_r1_rbl u_t008_012/c3_w0_bl u_t008_012/c3_w0_br
+ u_t008_012/c3_w1_bl u_t008_012/c3_w1_br u_t008_012/c3_r0_rbl u_t008_012/c3_r1_rbl u_t008_012/r0_w0_wl
+ u_t008_012/r0_w1_wl u_t008_012/r0_r0_rwl u_t008_012/r0_r1_rwl u_t008_012/r1_w0_wl u_t008_012/r1_w1_wl
+ u_t008_012/r1_r0_rwl u_t008_012/r1_r1_rwl u_t008_012/r2_w0_wl u_t008_012/r2_w1_wl u_t008_012/r2_r0_rwl
+ u_t008_012/r2_r1_rwl u_t008_012/r3_w0_wl u_t008_012/r3_w1_wl u_t008_012/r3_r0_rwl u_t008_012/r3_r1_rwl VDD VSS VSUBS
+ detronyx_12t_2w2r_rc4_4x4_routed_5layer_direct
Xu_t023_004 u_t023_004/c0_w0_bl u_t023_004/c0_w0_br u_t023_004/c0_w1_bl u_t023_004/c0_w1_br u_t023_004/c0_r0_rbl
+ u_t023_004/c0_r1_rbl u_t023_004/c1_w0_bl u_t023_004/c1_w0_br u_t023_004/c1_w1_bl u_t023_004/c1_w1_br
+ u_t023_004/c1_r0_rbl u_t023_004/c1_r1_rbl u_t023_004/c2_w0_bl u_t023_004/c2_w0_br u_t023_004/c2_w1_bl
+ u_t023_004/c2_w1_br u_t023_004/c2_r0_rbl u_t023_004/c2_r1_rbl u_t023_004/c3_w0_bl u_t023_004/c3_w0_br
+ u_t023_004/c3_w1_bl u_t023_004/c3_w1_br u_t023_004/c3_r0_rbl u_t023_004/c3_r1_rbl u_t023_004/r0_w0_wl
+ u_t023_004/r0_w1_wl u_t023_004/r0_r0_rwl u_t023_004/r0_r1_rwl u_t023_004/r1_w0_wl u_t023_004/r1_w1_wl
+ u_t023_004/r1_r0_rwl u_t023_004/r1_r1_rwl u_t023_004/r2_w0_wl u_t023_004/r2_w1_wl u_t023_004/r2_r0_rwl
+ u_t023_004/r2_r1_rwl u_t023_004/r3_w0_wl u_t023_004/r3_w1_wl u_t023_004/r3_r0_rwl u_t023_004/r3_r1_rwl VDD VSS VSUBS
+ detronyx_12t_2w2r_rc4_4x4_routed_5layer_direct
Xu_t023_015 u_t023_015/c0_w0_bl u_t023_015/c0_w0_br u_t023_015/c0_w1_bl u_t023_015/c0_w1_br u_t023_015/c0_r0_rbl
+ u_t023_015/c0_r1_rbl u_t023_015/c1_w0_bl u_t023_015/c1_w0_br u_t023_015/c1_w1_bl u_t023_015/c1_w1_br
+ u_t023_015/c1_r0_rbl u_t023_015/c1_r1_rbl u_t023_015/c2_w0_bl u_t023_015/c2_w0_br u_t023_015/c2_w1_bl
+ u_t023_015/c2_w1_br u_t023_015/c2_r0_rbl u_t023_015/c2_r1_rbl u_t023_015/c3_w0_bl u_t023_015/c3_w0_br
+ u_t023_015/c3_w1_bl u_t023_015/c3_w1_br u_t023_015/c3_r0_rbl u_t023_015/c3_r1_rbl u_t023_015/r0_w0_wl
+ u_t023_015/r0_w1_wl u_t023_015/r0_r0_rwl u_t023_015/r0_r1_rwl u_t023_015/r1_w0_wl u_t023_015/r1_w1_wl
+ u_t023_015/r1_r0_rwl u_t023_015/r1_r1_rwl u_t023_015/r2_w0_wl u_t023_015/r2_w1_wl u_t023_015/r2_r0_rwl
+ u_t023_015/r2_r1_rwl u_t023_015/r3_w0_wl u_t023_015/r3_w1_wl u_t023_015/r3_r0_rwl u_t023_015/r3_r1_rwl VDD VSS VSUBS
+ detronyx_12t_2w2r_rc4_4x4_routed_5layer_direct
Xu_t014_004 u_t014_004/c0_w0_bl u_t014_004/c0_w0_br u_t014_004/c0_w1_bl u_t014_004/c0_w1_br u_t014_004/c0_r0_rbl
+ u_t014_004/c0_r1_rbl u_t014_004/c1_w0_bl u_t014_004/c1_w0_br u_t014_004/c1_w1_bl u_t014_004/c1_w1_br
+ u_t014_004/c1_r0_rbl u_t014_004/c1_r1_rbl u_t014_004/c2_w0_bl u_t014_004/c2_w0_br u_t014_004/c2_w1_bl
+ u_t014_004/c2_w1_br u_t014_004/c2_r0_rbl u_t014_004/c2_r1_rbl u_t014_004/c3_w0_bl u_t014_004/c3_w0_br
+ u_t014_004/c3_w1_bl u_t014_004/c3_w1_br u_t014_004/c3_r0_rbl u_t014_004/c3_r1_rbl u_t014_004/r0_w0_wl
+ u_t014_004/r0_w1_wl u_t014_004/r0_r0_rwl u_t014_004/r0_r1_rwl u_t014_004/r1_w0_wl u_t014_004/r1_w1_wl
+ u_t014_004/r1_r0_rwl u_t014_004/r1_r1_rwl u_t014_004/r2_w0_wl u_t014_004/r2_w1_wl u_t014_004/r2_r0_rwl
+ u_t014_004/r2_r1_rwl u_t014_004/r3_w0_wl u_t014_004/r3_w1_wl u_t014_004/r3_r0_rwl u_t014_004/r3_r1_rwl VDD VSS VSUBS
+ detronyx_12t_2w2r_rc4_4x4_routed_5layer_direct
Xu_t014_015 u_t014_015/c0_w0_bl u_t014_015/c0_w0_br u_t014_015/c0_w1_bl u_t014_015/c0_w1_br u_t014_015/c0_r0_rbl
+ u_t014_015/c0_r1_rbl u_t014_015/c1_w0_bl u_t014_015/c1_w0_br u_t014_015/c1_w1_bl u_t014_015/c1_w1_br
+ u_t014_015/c1_r0_rbl u_t014_015/c1_r1_rbl u_t014_015/c2_w0_bl u_t014_015/c2_w0_br u_t014_015/c2_w1_bl
+ u_t014_015/c2_w1_br u_t014_015/c2_r0_rbl u_t014_015/c2_r1_rbl u_t014_015/c3_w0_bl u_t014_015/c3_w0_br
+ u_t014_015/c3_w1_bl u_t014_015/c3_w1_br u_t014_015/c3_r0_rbl u_t014_015/c3_r1_rbl u_t014_015/r0_w0_wl
+ u_t014_015/r0_w1_wl u_t014_015/r0_r0_rwl u_t014_015/r0_r1_rwl u_t014_015/r1_w0_wl u_t014_015/r1_w1_wl
+ u_t014_015/r1_r0_rwl u_t014_015/r1_r1_rwl u_t014_015/r2_w0_wl u_t014_015/r2_w1_wl u_t014_015/r2_r0_rwl
+ u_t014_015/r2_r1_rwl u_t014_015/r3_w0_wl u_t014_015/r3_w1_wl u_t014_015/r3_r0_rwl u_t014_015/r3_r1_rwl VDD VSS VSUBS
+ detronyx_12t_2w2r_rc4_4x4_routed_5layer_direct
Xu_t005_004 u_t005_004/c0_w0_bl u_t005_004/c0_w0_br u_t005_004/c0_w1_bl u_t005_004/c0_w1_br u_t005_004/c0_r0_rbl
+ u_t005_004/c0_r1_rbl u_t005_004/c1_w0_bl u_t005_004/c1_w0_br u_t005_004/c1_w1_bl u_t005_004/c1_w1_br
+ u_t005_004/c1_r0_rbl u_t005_004/c1_r1_rbl u_t005_004/c2_w0_bl u_t005_004/c2_w0_br u_t005_004/c2_w1_bl
+ u_t005_004/c2_w1_br u_t005_004/c2_r0_rbl u_t005_004/c2_r1_rbl u_t005_004/c3_w0_bl u_t005_004/c3_w0_br
+ u_t005_004/c3_w1_bl u_t005_004/c3_w1_br u_t005_004/c3_r0_rbl u_t005_004/c3_r1_rbl u_t005_004/r0_w0_wl
+ u_t005_004/r0_w1_wl u_t005_004/r0_r0_rwl u_t005_004/r0_r1_rwl u_t005_004/r1_w0_wl u_t005_004/r1_w1_wl
+ u_t005_004/r1_r0_rwl u_t005_004/r1_r1_rwl u_t005_004/r2_w0_wl u_t005_004/r2_w1_wl u_t005_004/r2_r0_rwl
+ u_t005_004/r2_r1_rwl u_t005_004/r3_w0_wl u_t005_004/r3_w1_wl u_t005_004/r3_r0_rwl u_t005_004/r3_r1_rwl VDD VSS VSUBS
+ detronyx_12t_2w2r_rc4_4x4_routed_5layer_direct
Xu_t005_015 u_t005_015/c0_w0_bl u_t005_015/c0_w0_br u_t005_015/c0_w1_bl u_t005_015/c0_w1_br u_t005_015/c0_r0_rbl
+ u_t005_015/c0_r1_rbl u_t005_015/c1_w0_bl u_t005_015/c1_w0_br u_t005_015/c1_w1_bl u_t005_015/c1_w1_br
+ u_t005_015/c1_r0_rbl u_t005_015/c1_r1_rbl u_t005_015/c2_w0_bl u_t005_015/c2_w0_br u_t005_015/c2_w1_bl
+ u_t005_015/c2_w1_br u_t005_015/c2_r0_rbl u_t005_015/c2_r1_rbl u_t005_015/c3_w0_bl u_t005_015/c3_w0_br
+ u_t005_015/c3_w1_bl u_t005_015/c3_w1_br u_t005_015/c3_r0_rbl u_t005_015/c3_r1_rbl u_t005_015/r0_w0_wl
+ u_t005_015/r0_w1_wl u_t005_015/r0_r0_rwl u_t005_015/r0_r1_rwl u_t005_015/r1_w0_wl u_t005_015/r1_w1_wl
+ u_t005_015/r1_r0_rwl u_t005_015/r1_r1_rwl u_t005_015/r2_w0_wl u_t005_015/r2_w1_wl u_t005_015/r2_r0_rwl
+ u_t005_015/r2_r1_rwl u_t005_015/r3_w0_wl u_t005_015/r3_w1_wl u_t005_015/r3_r0_rwl u_t005_015/r3_r1_rwl VDD VSS VSUBS
+ detronyx_12t_2w2r_rc4_4x4_routed_5layer_direct
Xu_t020_007 u_t020_007/c0_w0_bl u_t020_007/c0_w0_br u_t020_007/c0_w1_bl u_t020_007/c0_w1_br u_t020_007/c0_r0_rbl
+ u_t020_007/c0_r1_rbl u_t020_007/c1_w0_bl u_t020_007/c1_w0_br u_t020_007/c1_w1_bl u_t020_007/c1_w1_br
+ u_t020_007/c1_r0_rbl u_t020_007/c1_r1_rbl u_t020_007/c2_w0_bl u_t020_007/c2_w0_br u_t020_007/c2_w1_bl
+ u_t020_007/c2_w1_br u_t020_007/c2_r0_rbl u_t020_007/c2_r1_rbl u_t020_007/c3_w0_bl u_t020_007/c3_w0_br
+ u_t020_007/c3_w1_bl u_t020_007/c3_w1_br u_t020_007/c3_r0_rbl u_t020_007/c3_r1_rbl u_t020_007/r0_w0_wl
+ u_t020_007/r0_w1_wl u_t020_007/r0_r0_rwl u_t020_007/r0_r1_rwl u_t020_007/r1_w0_wl u_t020_007/r1_w1_wl
+ u_t020_007/r1_r0_rwl u_t020_007/r1_r1_rwl u_t020_007/r2_w0_wl u_t020_007/r2_w1_wl u_t020_007/r2_r0_rwl
+ u_t020_007/r2_r1_rwl u_t020_007/r3_w0_wl u_t020_007/r3_w1_wl u_t020_007/r3_r0_rwl u_t020_007/r3_r1_rwl VDD VSS VSUBS
+ detronyx_12t_2w2r_rc4_4x4_routed_5layer_direct
Xu_t011_007 u_t011_007/c0_w0_bl u_t011_007/c0_w0_br u_t011_007/c0_w1_bl u_t011_007/c0_w1_br u_t011_007/c0_r0_rbl
+ u_t011_007/c0_r1_rbl u_t011_007/c1_w0_bl u_t011_007/c1_w0_br u_t011_007/c1_w1_bl u_t011_007/c1_w1_br
+ u_t011_007/c1_r0_rbl u_t011_007/c1_r1_rbl u_t011_007/c2_w0_bl u_t011_007/c2_w0_br u_t011_007/c2_w1_bl
+ u_t011_007/c2_w1_br u_t011_007/c2_r0_rbl u_t011_007/c2_r1_rbl u_t011_007/c3_w0_bl u_t011_007/c3_w0_br
+ u_t011_007/c3_w1_bl u_t011_007/c3_w1_br u_t011_007/c3_r0_rbl u_t011_007/c3_r1_rbl u_t011_007/r0_w0_wl
+ u_t011_007/r0_w1_wl u_t011_007/r0_r0_rwl u_t011_007/r0_r1_rwl u_t011_007/r1_w0_wl u_t011_007/r1_w1_wl
+ u_t011_007/r1_r0_rwl u_t011_007/r1_r1_rwl u_t011_007/r2_w0_wl u_t011_007/r2_w1_wl u_t011_007/r2_r0_rwl
+ u_t011_007/r2_r1_rwl u_t011_007/r3_w0_wl u_t011_007/r3_w1_wl u_t011_007/r3_r0_rwl u_t011_007/r3_r1_rwl VDD VSS VSUBS
+ detronyx_12t_2w2r_rc4_4x4_routed_5layer_direct
Xu_t002_007 u_t002_007/c0_w0_bl u_t002_007/c0_w0_br u_t002_007/c0_w1_bl u_t002_007/c0_w1_br u_t002_007/c0_r0_rbl
+ u_t002_007/c0_r1_rbl u_t002_007/c1_w0_bl u_t002_007/c1_w0_br u_t002_007/c1_w1_bl u_t002_007/c1_w1_br
+ u_t002_007/c1_r0_rbl u_t002_007/c1_r1_rbl u_t002_007/c2_w0_bl u_t002_007/c2_w0_br u_t002_007/c2_w1_bl
+ u_t002_007/c2_w1_br u_t002_007/c2_r0_rbl u_t002_007/c2_r1_rbl u_t002_007/c3_w0_bl u_t002_007/c3_w0_br
+ u_t002_007/c3_w1_bl u_t002_007/c3_w1_br u_t002_007/c3_r0_rbl u_t002_007/c3_r1_rbl u_t002_007/r0_w0_wl
+ u_t002_007/r0_w1_wl u_t002_007/r0_r0_rwl u_t002_007/r0_r1_rwl u_t002_007/r1_w0_wl u_t002_007/r1_w1_wl
+ u_t002_007/r1_r0_rwl u_t002_007/r1_r1_rwl u_t002_007/r2_w0_wl u_t002_007/r2_w1_wl u_t002_007/r2_r0_rwl
+ u_t002_007/r2_r1_rwl u_t002_007/r3_w0_wl u_t002_007/r3_w1_wl u_t002_007/r3_r0_rwl u_t002_007/r3_r1_rwl VDD VSS VSUBS
+ detronyx_12t_2w2r_rc4_4x4_routed_5layer_direct
Xu_t029_010 u_t029_010/c0_w0_bl u_t029_010/c0_w0_br u_t029_010/c0_w1_bl u_t029_010/c0_w1_br u_t029_010/c0_r0_rbl
+ u_t029_010/c0_r1_rbl u_t029_010/c1_w0_bl u_t029_010/c1_w0_br u_t029_010/c1_w1_bl u_t029_010/c1_w1_br
+ u_t029_010/c1_r0_rbl u_t029_010/c1_r1_rbl u_t029_010/c2_w0_bl u_t029_010/c2_w0_br u_t029_010/c2_w1_bl
+ u_t029_010/c2_w1_br u_t029_010/c2_r0_rbl u_t029_010/c2_r1_rbl u_t029_010/c3_w0_bl u_t029_010/c3_w0_br
+ u_t029_010/c3_w1_bl u_t029_010/c3_w1_br u_t029_010/c3_r0_rbl u_t029_010/c3_r1_rbl u_t029_010/r0_w0_wl
+ u_t029_010/r0_w1_wl u_t029_010/r0_r0_rwl u_t029_010/r0_r1_rwl u_t029_010/r1_w0_wl u_t029_010/r1_w1_wl
+ u_t029_010/r1_r0_rwl u_t029_010/r1_r1_rwl u_t029_010/r2_w0_wl u_t029_010/r2_w1_wl u_t029_010/r2_r0_rwl
+ u_t029_010/r2_r1_rwl u_t029_010/r3_w0_wl u_t029_010/r3_w1_wl u_t029_010/r3_r0_rwl u_t029_010/r3_r1_rwl VDD VSS VSUBS
+ detronyx_12t_2w2r_rc4_4x4_routed_5layer_direct
Xu_t026_013 u_t026_013/c0_w0_bl u_t026_013/c0_w0_br u_t026_013/c0_w1_bl u_t026_013/c0_w1_br u_t026_013/c0_r0_rbl
+ u_t026_013/c0_r1_rbl u_t026_013/c1_w0_bl u_t026_013/c1_w0_br u_t026_013/c1_w1_bl u_t026_013/c1_w1_br
+ u_t026_013/c1_r0_rbl u_t026_013/c1_r1_rbl u_t026_013/c2_w0_bl u_t026_013/c2_w0_br u_t026_013/c2_w1_bl
+ u_t026_013/c2_w1_br u_t026_013/c2_r0_rbl u_t026_013/c2_r1_rbl u_t026_013/c3_w0_bl u_t026_013/c3_w0_br
+ u_t026_013/c3_w1_bl u_t026_013/c3_w1_br u_t026_013/c3_r0_rbl u_t026_013/c3_r1_rbl u_t026_013/r0_w0_wl
+ u_t026_013/r0_w1_wl u_t026_013/r0_r0_rwl u_t026_013/r0_r1_rwl u_t026_013/r1_w0_wl u_t026_013/r1_w1_wl
+ u_t026_013/r1_r0_rwl u_t026_013/r1_r1_rwl u_t026_013/r2_w0_wl u_t026_013/r2_w1_wl u_t026_013/r2_r0_rwl
+ u_t026_013/r2_r1_rwl u_t026_013/r3_w0_wl u_t026_013/r3_w1_wl u_t026_013/r3_r0_rwl u_t026_013/r3_r1_rwl VDD VSS VSUBS
+ detronyx_12t_2w2r_rc4_4x4_routed_5layer_direct
Xu_t026_002 u_t026_002/c0_w0_bl u_t026_002/c0_w0_br u_t026_002/c0_w1_bl u_t026_002/c0_w1_br u_t026_002/c0_r0_rbl
+ u_t026_002/c0_r1_rbl u_t026_002/c1_w0_bl u_t026_002/c1_w0_br u_t026_002/c1_w1_bl u_t026_002/c1_w1_br
+ u_t026_002/c1_r0_rbl u_t026_002/c1_r1_rbl u_t026_002/c2_w0_bl u_t026_002/c2_w0_br u_t026_002/c2_w1_bl
+ u_t026_002/c2_w1_br u_t026_002/c2_r0_rbl u_t026_002/c2_r1_rbl u_t026_002/c3_w0_bl u_t026_002/c3_w0_br
+ u_t026_002/c3_w1_bl u_t026_002/c3_w1_br u_t026_002/c3_r0_rbl u_t026_002/c3_r1_rbl u_t026_002/r0_w0_wl
+ u_t026_002/r0_w1_wl u_t026_002/r0_r0_rwl u_t026_002/r0_r1_rwl u_t026_002/r1_w0_wl u_t026_002/r1_w1_wl
+ u_t026_002/r1_r0_rwl u_t026_002/r1_r1_rwl u_t026_002/r2_w0_wl u_t026_002/r2_w1_wl u_t026_002/r2_r0_rwl
+ u_t026_002/r2_r1_rwl u_t026_002/r3_w0_wl u_t026_002/r3_w1_wl u_t026_002/r3_r0_rwl u_t026_002/r3_r1_rwl VDD VSS VSUBS
+ detronyx_12t_2w2r_rc4_4x4_routed_5layer_direct
Xu_t017_002 u_t017_002/c0_w0_bl u_t017_002/c0_w0_br u_t017_002/c0_w1_bl u_t017_002/c0_w1_br u_t017_002/c0_r0_rbl
+ u_t017_002/c0_r1_rbl u_t017_002/c1_w0_bl u_t017_002/c1_w0_br u_t017_002/c1_w1_bl u_t017_002/c1_w1_br
+ u_t017_002/c1_r0_rbl u_t017_002/c1_r1_rbl u_t017_002/c2_w0_bl u_t017_002/c2_w0_br u_t017_002/c2_w1_bl
+ u_t017_002/c2_w1_br u_t017_002/c2_r0_rbl u_t017_002/c2_r1_rbl u_t017_002/c3_w0_bl u_t017_002/c3_w0_br
+ u_t017_002/c3_w1_bl u_t017_002/c3_w1_br u_t017_002/c3_r0_rbl u_t017_002/c3_r1_rbl u_t017_002/r0_w0_wl
+ u_t017_002/r0_w1_wl u_t017_002/r0_r0_rwl u_t017_002/r0_r1_rwl u_t017_002/r1_w0_wl u_t017_002/r1_w1_wl
+ u_t017_002/r1_r0_rwl u_t017_002/r1_r1_rwl u_t017_002/r2_w0_wl u_t017_002/r2_w1_wl u_t017_002/r2_r0_rwl
+ u_t017_002/r2_r1_rwl u_t017_002/r3_w0_wl u_t017_002/r3_w1_wl u_t017_002/r3_r0_rwl u_t017_002/r3_r1_rwl VDD VSS VSUBS
+ detronyx_12t_2w2r_rc4_4x4_routed_5layer_direct
Xu_t017_013 u_t017_013/c0_w0_bl u_t017_013/c0_w0_br u_t017_013/c0_w1_bl u_t017_013/c0_w1_br u_t017_013/c0_r0_rbl
+ u_t017_013/c0_r1_rbl u_t017_013/c1_w0_bl u_t017_013/c1_w0_br u_t017_013/c1_w1_bl u_t017_013/c1_w1_br
+ u_t017_013/c1_r0_rbl u_t017_013/c1_r1_rbl u_t017_013/c2_w0_bl u_t017_013/c2_w0_br u_t017_013/c2_w1_bl
+ u_t017_013/c2_w1_br u_t017_013/c2_r0_rbl u_t017_013/c2_r1_rbl u_t017_013/c3_w0_bl u_t017_013/c3_w0_br
+ u_t017_013/c3_w1_bl u_t017_013/c3_w1_br u_t017_013/c3_r0_rbl u_t017_013/c3_r1_rbl u_t017_013/r0_w0_wl
+ u_t017_013/r0_w1_wl u_t017_013/r0_r0_rwl u_t017_013/r0_r1_rwl u_t017_013/r1_w0_wl u_t017_013/r1_w1_wl
+ u_t017_013/r1_r0_rwl u_t017_013/r1_r1_rwl u_t017_013/r2_w0_wl u_t017_013/r2_w1_wl u_t017_013/r2_r0_rwl
+ u_t017_013/r2_r1_rwl u_t017_013/r3_w0_wl u_t017_013/r3_w1_wl u_t017_013/r3_r0_rwl u_t017_013/r3_r1_rwl VDD VSS VSUBS
+ detronyx_12t_2w2r_rc4_4x4_routed_5layer_direct
Xu_t008_002 u_t008_002/c0_w0_bl u_t008_002/c0_w0_br u_t008_002/c0_w1_bl u_t008_002/c0_w1_br u_t008_002/c0_r0_rbl
+ u_t008_002/c0_r1_rbl u_t008_002/c1_w0_bl u_t008_002/c1_w0_br u_t008_002/c1_w1_bl u_t008_002/c1_w1_br
+ u_t008_002/c1_r0_rbl u_t008_002/c1_r1_rbl u_t008_002/c2_w0_bl u_t008_002/c2_w0_br u_t008_002/c2_w1_bl
+ u_t008_002/c2_w1_br u_t008_002/c2_r0_rbl u_t008_002/c2_r1_rbl u_t008_002/c3_w0_bl u_t008_002/c3_w0_br
+ u_t008_002/c3_w1_bl u_t008_002/c3_w1_br u_t008_002/c3_r0_rbl u_t008_002/c3_r1_rbl u_t008_002/r0_w0_wl
+ u_t008_002/r0_w1_wl u_t008_002/r0_r0_rwl u_t008_002/r0_r1_rwl u_t008_002/r1_w0_wl u_t008_002/r1_w1_wl
+ u_t008_002/r1_r0_rwl u_t008_002/r1_r1_rwl u_t008_002/r2_w0_wl u_t008_002/r2_w1_wl u_t008_002/r2_r0_rwl
+ u_t008_002/r2_r1_rwl u_t008_002/r3_w0_wl u_t008_002/r3_w1_wl u_t008_002/r3_r0_rwl u_t008_002/r3_r1_rwl VDD VSS VSUBS
+ detronyx_12t_2w2r_rc4_4x4_routed_5layer_direct
Xu_t008_013 u_t008_013/c0_w0_bl u_t008_013/c0_w0_br u_t008_013/c0_w1_bl u_t008_013/c0_w1_br u_t008_013/c0_r0_rbl
+ u_t008_013/c0_r1_rbl u_t008_013/c1_w0_bl u_t008_013/c1_w0_br u_t008_013/c1_w1_bl u_t008_013/c1_w1_br
+ u_t008_013/c1_r0_rbl u_t008_013/c1_r1_rbl u_t008_013/c2_w0_bl u_t008_013/c2_w0_br u_t008_013/c2_w1_bl
+ u_t008_013/c2_w1_br u_t008_013/c2_r0_rbl u_t008_013/c2_r1_rbl u_t008_013/c3_w0_bl u_t008_013/c3_w0_br
+ u_t008_013/c3_w1_bl u_t008_013/c3_w1_br u_t008_013/c3_r0_rbl u_t008_013/c3_r1_rbl u_t008_013/r0_w0_wl
+ u_t008_013/r0_w1_wl u_t008_013/r0_r0_rwl u_t008_013/r0_r1_rwl u_t008_013/r1_w0_wl u_t008_013/r1_w1_wl
+ u_t008_013/r1_r0_rwl u_t008_013/r1_r1_rwl u_t008_013/r2_w0_wl u_t008_013/r2_w1_wl u_t008_013/r2_r0_rwl
+ u_t008_013/r2_r1_rwl u_t008_013/r3_w0_wl u_t008_013/r3_w1_wl u_t008_013/r3_r0_rwl u_t008_013/r3_r1_rwl VDD VSS VSUBS
+ detronyx_12t_2w2r_rc4_4x4_routed_5layer_direct
Xu_t023_005 u_t023_005/c0_w0_bl u_t023_005/c0_w0_br u_t023_005/c0_w1_bl u_t023_005/c0_w1_br u_t023_005/c0_r0_rbl
+ u_t023_005/c0_r1_rbl u_t023_005/c1_w0_bl u_t023_005/c1_w0_br u_t023_005/c1_w1_bl u_t023_005/c1_w1_br
+ u_t023_005/c1_r0_rbl u_t023_005/c1_r1_rbl u_t023_005/c2_w0_bl u_t023_005/c2_w0_br u_t023_005/c2_w1_bl
+ u_t023_005/c2_w1_br u_t023_005/c2_r0_rbl u_t023_005/c2_r1_rbl u_t023_005/c3_w0_bl u_t023_005/c3_w0_br
+ u_t023_005/c3_w1_bl u_t023_005/c3_w1_br u_t023_005/c3_r0_rbl u_t023_005/c3_r1_rbl u_t023_005/r0_w0_wl
+ u_t023_005/r0_w1_wl u_t023_005/r0_r0_rwl u_t023_005/r0_r1_rwl u_t023_005/r1_w0_wl u_t023_005/r1_w1_wl
+ u_t023_005/r1_r0_rwl u_t023_005/r1_r1_rwl u_t023_005/r2_w0_wl u_t023_005/r2_w1_wl u_t023_005/r2_r0_rwl
+ u_t023_005/r2_r1_rwl u_t023_005/r3_w0_wl u_t023_005/r3_w1_wl u_t023_005/r3_r0_rwl u_t023_005/r3_r1_rwl VDD VSS VSUBS
+ detronyx_12t_2w2r_rc4_4x4_routed_5layer_direct
Xu_t014_005 u_t014_005/c0_w0_bl u_t014_005/c0_w0_br u_t014_005/c0_w1_bl u_t014_005/c0_w1_br u_t014_005/c0_r0_rbl
+ u_t014_005/c0_r1_rbl u_t014_005/c1_w0_bl u_t014_005/c1_w0_br u_t014_005/c1_w1_bl u_t014_005/c1_w1_br
+ u_t014_005/c1_r0_rbl u_t014_005/c1_r1_rbl u_t014_005/c2_w0_bl u_t014_005/c2_w0_br u_t014_005/c2_w1_bl
+ u_t014_005/c2_w1_br u_t014_005/c2_r0_rbl u_t014_005/c2_r1_rbl u_t014_005/c3_w0_bl u_t014_005/c3_w0_br
+ u_t014_005/c3_w1_bl u_t014_005/c3_w1_br u_t014_005/c3_r0_rbl u_t014_005/c3_r1_rbl u_t014_005/r0_w0_wl
+ u_t014_005/r0_w1_wl u_t014_005/r0_r0_rwl u_t014_005/r0_r1_rwl u_t014_005/r1_w0_wl u_t014_005/r1_w1_wl
+ u_t014_005/r1_r0_rwl u_t014_005/r1_r1_rwl u_t014_005/r2_w0_wl u_t014_005/r2_w1_wl u_t014_005/r2_r0_rwl
+ u_t014_005/r2_r1_rwl u_t014_005/r3_w0_wl u_t014_005/r3_w1_wl u_t014_005/r3_r0_rwl u_t014_005/r3_r1_rwl VDD VSS VSUBS
+ detronyx_12t_2w2r_rc4_4x4_routed_5layer_direct
Xu_t005_005 u_t005_005/c0_w0_bl u_t005_005/c0_w0_br u_t005_005/c0_w1_bl u_t005_005/c0_w1_br u_t005_005/c0_r0_rbl
+ u_t005_005/c0_r1_rbl u_t005_005/c1_w0_bl u_t005_005/c1_w0_br u_t005_005/c1_w1_bl u_t005_005/c1_w1_br
+ u_t005_005/c1_r0_rbl u_t005_005/c1_r1_rbl u_t005_005/c2_w0_bl u_t005_005/c2_w0_br u_t005_005/c2_w1_bl
+ u_t005_005/c2_w1_br u_t005_005/c2_r0_rbl u_t005_005/c2_r1_rbl u_t005_005/c3_w0_bl u_t005_005/c3_w0_br
+ u_t005_005/c3_w1_bl u_t005_005/c3_w1_br u_t005_005/c3_r0_rbl u_t005_005/c3_r1_rbl u_t005_005/r0_w0_wl
+ u_t005_005/r0_w1_wl u_t005_005/r0_r0_rwl u_t005_005/r0_r1_rwl u_t005_005/r1_w0_wl u_t005_005/r1_w1_wl
+ u_t005_005/r1_r0_rwl u_t005_005/r1_r1_rwl u_t005_005/r2_w0_wl u_t005_005/r2_w1_wl u_t005_005/r2_r0_rwl
+ u_t005_005/r2_r1_rwl u_t005_005/r3_w0_wl u_t005_005/r3_w1_wl u_t005_005/r3_r0_rwl u_t005_005/r3_r1_rwl VDD VSS VSUBS
+ detronyx_12t_2w2r_rc4_4x4_routed_5layer_direct
Xu_t020_008 u_t020_008/c0_w0_bl u_t020_008/c0_w0_br u_t020_008/c0_w1_bl u_t020_008/c0_w1_br u_t020_008/c0_r0_rbl
+ u_t020_008/c0_r1_rbl u_t020_008/c1_w0_bl u_t020_008/c1_w0_br u_t020_008/c1_w1_bl u_t020_008/c1_w1_br
+ u_t020_008/c1_r0_rbl u_t020_008/c1_r1_rbl u_t020_008/c2_w0_bl u_t020_008/c2_w0_br u_t020_008/c2_w1_bl
+ u_t020_008/c2_w1_br u_t020_008/c2_r0_rbl u_t020_008/c2_r1_rbl u_t020_008/c3_w0_bl u_t020_008/c3_w0_br
+ u_t020_008/c3_w1_bl u_t020_008/c3_w1_br u_t020_008/c3_r0_rbl u_t020_008/c3_r1_rbl u_t020_008/r0_w0_wl
+ u_t020_008/r0_w1_wl u_t020_008/r0_r0_rwl u_t020_008/r0_r1_rwl u_t020_008/r1_w0_wl u_t020_008/r1_w1_wl
+ u_t020_008/r1_r0_rwl u_t020_008/r1_r1_rwl u_t020_008/r2_w0_wl u_t020_008/r2_w1_wl u_t020_008/r2_r0_rwl
+ u_t020_008/r2_r1_rwl u_t020_008/r3_w0_wl u_t020_008/r3_w1_wl u_t020_008/r3_r0_rwl u_t020_008/r3_r1_rwl VDD VSS VSUBS
+ detronyx_12t_2w2r_rc4_4x4_routed_5layer_direct
Xu_t011_008 u_t011_008/c0_w0_bl u_t011_008/c0_w0_br u_t011_008/c0_w1_bl u_t011_008/c0_w1_br u_t011_008/c0_r0_rbl
+ u_t011_008/c0_r1_rbl u_t011_008/c1_w0_bl u_t011_008/c1_w0_br u_t011_008/c1_w1_bl u_t011_008/c1_w1_br
+ u_t011_008/c1_r0_rbl u_t011_008/c1_r1_rbl u_t011_008/c2_w0_bl u_t011_008/c2_w0_br u_t011_008/c2_w1_bl
+ u_t011_008/c2_w1_br u_t011_008/c2_r0_rbl u_t011_008/c2_r1_rbl u_t011_008/c3_w0_bl u_t011_008/c3_w0_br
+ u_t011_008/c3_w1_bl u_t011_008/c3_w1_br u_t011_008/c3_r0_rbl u_t011_008/c3_r1_rbl u_t011_008/r0_w0_wl
+ u_t011_008/r0_w1_wl u_t011_008/r0_r0_rwl u_t011_008/r0_r1_rwl u_t011_008/r1_w0_wl u_t011_008/r1_w1_wl
+ u_t011_008/r1_r0_rwl u_t011_008/r1_r1_rwl u_t011_008/r2_w0_wl u_t011_008/r2_w1_wl u_t011_008/r2_r0_rwl
+ u_t011_008/r2_r1_rwl u_t011_008/r3_w0_wl u_t011_008/r3_w1_wl u_t011_008/r3_r0_rwl u_t011_008/r3_r1_rwl VDD VSS VSUBS
+ detronyx_12t_2w2r_rc4_4x4_routed_5layer_direct
Xu_t002_008 u_t002_008/c0_w0_bl u_t002_008/c0_w0_br u_t002_008/c0_w1_bl u_t002_008/c0_w1_br u_t002_008/c0_r0_rbl
+ u_t002_008/c0_r1_rbl u_t002_008/c1_w0_bl u_t002_008/c1_w0_br u_t002_008/c1_w1_bl u_t002_008/c1_w1_br
+ u_t002_008/c1_r0_rbl u_t002_008/c1_r1_rbl u_t002_008/c2_w0_bl u_t002_008/c2_w0_br u_t002_008/c2_w1_bl
+ u_t002_008/c2_w1_br u_t002_008/c2_r0_rbl u_t002_008/c2_r1_rbl u_t002_008/c3_w0_bl u_t002_008/c3_w0_br
+ u_t002_008/c3_w1_bl u_t002_008/c3_w1_br u_t002_008/c3_r0_rbl u_t002_008/c3_r1_rbl u_t002_008/r0_w0_wl
+ u_t002_008/r0_w1_wl u_t002_008/r0_r0_rwl u_t002_008/r0_r1_rwl u_t002_008/r1_w0_wl u_t002_008/r1_w1_wl
+ u_t002_008/r1_r0_rwl u_t002_008/r1_r1_rwl u_t002_008/r2_w0_wl u_t002_008/r2_w1_wl u_t002_008/r2_r0_rwl
+ u_t002_008/r2_r1_rwl u_t002_008/r3_w0_wl u_t002_008/r3_w1_wl u_t002_008/r3_r0_rwl u_t002_008/r3_r1_rwl VDD VSS VSUBS
+ detronyx_12t_2w2r_rc4_4x4_routed_5layer_direct
Xu_t029_011 u_t029_011/c0_w0_bl u_t029_011/c0_w0_br u_t029_011/c0_w1_bl u_t029_011/c0_w1_br u_t029_011/c0_r0_rbl
+ u_t029_011/c0_r1_rbl u_t029_011/c1_w0_bl u_t029_011/c1_w0_br u_t029_011/c1_w1_bl u_t029_011/c1_w1_br
+ u_t029_011/c1_r0_rbl u_t029_011/c1_r1_rbl u_t029_011/c2_w0_bl u_t029_011/c2_w0_br u_t029_011/c2_w1_bl
+ u_t029_011/c2_w1_br u_t029_011/c2_r0_rbl u_t029_011/c2_r1_rbl u_t029_011/c3_w0_bl u_t029_011/c3_w0_br
+ u_t029_011/c3_w1_bl u_t029_011/c3_w1_br u_t029_011/c3_r0_rbl u_t029_011/c3_r1_rbl u_t029_011/r0_w0_wl
+ u_t029_011/r0_w1_wl u_t029_011/r0_r0_rwl u_t029_011/r0_r1_rwl u_t029_011/r1_w0_wl u_t029_011/r1_w1_wl
+ u_t029_011/r1_r0_rwl u_t029_011/r1_r1_rwl u_t029_011/r2_w0_wl u_t029_011/r2_w1_wl u_t029_011/r2_r0_rwl
+ u_t029_011/r2_r1_rwl u_t029_011/r3_w0_wl u_t029_011/r3_w1_wl u_t029_011/r3_r0_rwl u_t029_011/r3_r1_rwl VDD VSS VSUBS
+ detronyx_12t_2w2r_rc4_4x4_routed_5layer_direct
Xu_t029_000 u_t029_000/c0_w0_bl u_t029_000/c0_w0_br u_t029_000/c0_w1_bl u_t029_000/c0_w1_br u_t029_000/c0_r0_rbl
+ u_t029_000/c0_r1_rbl u_t029_000/c1_w0_bl u_t029_000/c1_w0_br u_t029_000/c1_w1_bl u_t029_000/c1_w1_br
+ u_t029_000/c1_r0_rbl u_t029_000/c1_r1_rbl u_t029_000/c2_w0_bl u_t029_000/c2_w0_br u_t029_000/c2_w1_bl
+ u_t029_000/c2_w1_br u_t029_000/c2_r0_rbl u_t029_000/c2_r1_rbl u_t029_000/c3_w0_bl u_t029_000/c3_w0_br
+ u_t029_000/c3_w1_bl u_t029_000/c3_w1_br u_t029_000/c3_r0_rbl u_t029_000/c3_r1_rbl u_t029_000/r0_w0_wl
+ u_t029_000/r0_w1_wl u_t029_000/r0_r0_rwl u_t029_000/r0_r1_rwl u_t029_000/r1_w0_wl u_t029_000/r1_w1_wl
+ u_t029_000/r1_r0_rwl u_t029_000/r1_r1_rwl u_t029_000/r2_w0_wl u_t029_000/r2_w1_wl u_t029_000/r2_r0_rwl
+ u_t029_000/r2_r1_rwl u_t029_000/r3_w0_wl u_t029_000/r3_w1_wl u_t029_000/r3_r0_rwl u_t029_000/r3_r1_rwl VDD VSS VSUBS
+ detronyx_12t_2w2r_rc4_4x4_routed_5layer_direct
Xu_t026_014 u_t026_014/c0_w0_bl u_t026_014/c0_w0_br u_t026_014/c0_w1_bl u_t026_014/c0_w1_br u_t026_014/c0_r0_rbl
+ u_t026_014/c0_r1_rbl u_t026_014/c1_w0_bl u_t026_014/c1_w0_br u_t026_014/c1_w1_bl u_t026_014/c1_w1_br
+ u_t026_014/c1_r0_rbl u_t026_014/c1_r1_rbl u_t026_014/c2_w0_bl u_t026_014/c2_w0_br u_t026_014/c2_w1_bl
+ u_t026_014/c2_w1_br u_t026_014/c2_r0_rbl u_t026_014/c2_r1_rbl u_t026_014/c3_w0_bl u_t026_014/c3_w0_br
+ u_t026_014/c3_w1_bl u_t026_014/c3_w1_br u_t026_014/c3_r0_rbl u_t026_014/c3_r1_rbl u_t026_014/r0_w0_wl
+ u_t026_014/r0_w1_wl u_t026_014/r0_r0_rwl u_t026_014/r0_r1_rwl u_t026_014/r1_w0_wl u_t026_014/r1_w1_wl
+ u_t026_014/r1_r0_rwl u_t026_014/r1_r1_rwl u_t026_014/r2_w0_wl u_t026_014/r2_w1_wl u_t026_014/r2_r0_rwl
+ u_t026_014/r2_r1_rwl u_t026_014/r3_w0_wl u_t026_014/r3_w1_wl u_t026_014/r3_r0_rwl u_t026_014/r3_r1_rwl VDD VSS VSUBS
+ detronyx_12t_2w2r_rc4_4x4_routed_5layer_direct
Xu_t026_003 u_t026_003/c0_w0_bl u_t026_003/c0_w0_br u_t026_003/c0_w1_bl u_t026_003/c0_w1_br u_t026_003/c0_r0_rbl
+ u_t026_003/c0_r1_rbl u_t026_003/c1_w0_bl u_t026_003/c1_w0_br u_t026_003/c1_w1_bl u_t026_003/c1_w1_br
+ u_t026_003/c1_r0_rbl u_t026_003/c1_r1_rbl u_t026_003/c2_w0_bl u_t026_003/c2_w0_br u_t026_003/c2_w1_bl
+ u_t026_003/c2_w1_br u_t026_003/c2_r0_rbl u_t026_003/c2_r1_rbl u_t026_003/c3_w0_bl u_t026_003/c3_w0_br
+ u_t026_003/c3_w1_bl u_t026_003/c3_w1_br u_t026_003/c3_r0_rbl u_t026_003/c3_r1_rbl u_t026_003/r0_w0_wl
+ u_t026_003/r0_w1_wl u_t026_003/r0_r0_rwl u_t026_003/r0_r1_rwl u_t026_003/r1_w0_wl u_t026_003/r1_w1_wl
+ u_t026_003/r1_r0_rwl u_t026_003/r1_r1_rwl u_t026_003/r2_w0_wl u_t026_003/r2_w1_wl u_t026_003/r2_r0_rwl
+ u_t026_003/r2_r1_rwl u_t026_003/r3_w0_wl u_t026_003/r3_w1_wl u_t026_003/r3_r0_rwl u_t026_003/r3_r1_rwl VDD VSS VSUBS
+ detronyx_12t_2w2r_rc4_4x4_routed_5layer_direct
Xu_t008_003 u_t008_003/c0_w0_bl u_t008_003/c0_w0_br u_t008_003/c0_w1_bl u_t008_003/c0_w1_br u_t008_003/c0_r0_rbl
+ u_t008_003/c0_r1_rbl u_t008_003/c1_w0_bl u_t008_003/c1_w0_br u_t008_003/c1_w1_bl u_t008_003/c1_w1_br
+ u_t008_003/c1_r0_rbl u_t008_003/c1_r1_rbl u_t008_003/c2_w0_bl u_t008_003/c2_w0_br u_t008_003/c2_w1_bl
+ u_t008_003/c2_w1_br u_t008_003/c2_r0_rbl u_t008_003/c2_r1_rbl u_t008_003/c3_w0_bl u_t008_003/c3_w0_br
+ u_t008_003/c3_w1_bl u_t008_003/c3_w1_br u_t008_003/c3_r0_rbl u_t008_003/c3_r1_rbl u_t008_003/r0_w0_wl
+ u_t008_003/r0_w1_wl u_t008_003/r0_r0_rwl u_t008_003/r0_r1_rwl u_t008_003/r1_w0_wl u_t008_003/r1_w1_wl
+ u_t008_003/r1_r0_rwl u_t008_003/r1_r1_rwl u_t008_003/r2_w0_wl u_t008_003/r2_w1_wl u_t008_003/r2_r0_rwl
+ u_t008_003/r2_r1_rwl u_t008_003/r3_w0_wl u_t008_003/r3_w1_wl u_t008_003/r3_r0_rwl u_t008_003/r3_r1_rwl VDD VSS VSUBS
+ detronyx_12t_2w2r_rc4_4x4_routed_5layer_direct
Xu_t017_003 u_t017_003/c0_w0_bl u_t017_003/c0_w0_br u_t017_003/c0_w1_bl u_t017_003/c0_w1_br u_t017_003/c0_r0_rbl
+ u_t017_003/c0_r1_rbl u_t017_003/c1_w0_bl u_t017_003/c1_w0_br u_t017_003/c1_w1_bl u_t017_003/c1_w1_br
+ u_t017_003/c1_r0_rbl u_t017_003/c1_r1_rbl u_t017_003/c2_w0_bl u_t017_003/c2_w0_br u_t017_003/c2_w1_bl
+ u_t017_003/c2_w1_br u_t017_003/c2_r0_rbl u_t017_003/c2_r1_rbl u_t017_003/c3_w0_bl u_t017_003/c3_w0_br
+ u_t017_003/c3_w1_bl u_t017_003/c3_w1_br u_t017_003/c3_r0_rbl u_t017_003/c3_r1_rbl u_t017_003/r0_w0_wl
+ u_t017_003/r0_w1_wl u_t017_003/r0_r0_rwl u_t017_003/r0_r1_rwl u_t017_003/r1_w0_wl u_t017_003/r1_w1_wl
+ u_t017_003/r1_r0_rwl u_t017_003/r1_r1_rwl u_t017_003/r2_w0_wl u_t017_003/r2_w1_wl u_t017_003/r2_r0_rwl
+ u_t017_003/r2_r1_rwl u_t017_003/r3_w0_wl u_t017_003/r3_w1_wl u_t017_003/r3_r0_rwl u_t017_003/r3_r1_rwl VDD VSS VSUBS
+ detronyx_12t_2w2r_rc4_4x4_routed_5layer_direct
Xu_t017_014 u_t017_014/c0_w0_bl u_t017_014/c0_w0_br u_t017_014/c0_w1_bl u_t017_014/c0_w1_br u_t017_014/c0_r0_rbl
+ u_t017_014/c0_r1_rbl u_t017_014/c1_w0_bl u_t017_014/c1_w0_br u_t017_014/c1_w1_bl u_t017_014/c1_w1_br
+ u_t017_014/c1_r0_rbl u_t017_014/c1_r1_rbl u_t017_014/c2_w0_bl u_t017_014/c2_w0_br u_t017_014/c2_w1_bl
+ u_t017_014/c2_w1_br u_t017_014/c2_r0_rbl u_t017_014/c2_r1_rbl u_t017_014/c3_w0_bl u_t017_014/c3_w0_br
+ u_t017_014/c3_w1_bl u_t017_014/c3_w1_br u_t017_014/c3_r0_rbl u_t017_014/c3_r1_rbl u_t017_014/r0_w0_wl
+ u_t017_014/r0_w1_wl u_t017_014/r0_r0_rwl u_t017_014/r0_r1_rwl u_t017_014/r1_w0_wl u_t017_014/r1_w1_wl
+ u_t017_014/r1_r0_rwl u_t017_014/r1_r1_rwl u_t017_014/r2_w0_wl u_t017_014/r2_w1_wl u_t017_014/r2_r0_rwl
+ u_t017_014/r2_r1_rwl u_t017_014/r3_w0_wl u_t017_014/r3_w1_wl u_t017_014/r3_r0_rwl u_t017_014/r3_r1_rwl VDD VSS VSUBS
+ detronyx_12t_2w2r_rc4_4x4_routed_5layer_direct
Xu_t008_014 u_t008_014/c0_w0_bl u_t008_014/c0_w0_br u_t008_014/c0_w1_bl u_t008_014/c0_w1_br u_t008_014/c0_r0_rbl
+ u_t008_014/c0_r1_rbl u_t008_014/c1_w0_bl u_t008_014/c1_w0_br u_t008_014/c1_w1_bl u_t008_014/c1_w1_br
+ u_t008_014/c1_r0_rbl u_t008_014/c1_r1_rbl u_t008_014/c2_w0_bl u_t008_014/c2_w0_br u_t008_014/c2_w1_bl
+ u_t008_014/c2_w1_br u_t008_014/c2_r0_rbl u_t008_014/c2_r1_rbl u_t008_014/c3_w0_bl u_t008_014/c3_w0_br
+ u_t008_014/c3_w1_bl u_t008_014/c3_w1_br u_t008_014/c3_r0_rbl u_t008_014/c3_r1_rbl u_t008_014/r0_w0_wl
+ u_t008_014/r0_w1_wl u_t008_014/r0_r0_rwl u_t008_014/r0_r1_rwl u_t008_014/r1_w0_wl u_t008_014/r1_w1_wl
+ u_t008_014/r1_r0_rwl u_t008_014/r1_r1_rwl u_t008_014/r2_w0_wl u_t008_014/r2_w1_wl u_t008_014/r2_r0_rwl
+ u_t008_014/r2_r1_rwl u_t008_014/r3_w0_wl u_t008_014/r3_w1_wl u_t008_014/r3_r0_rwl u_t008_014/r3_r1_rwl VDD VSS VSUBS
+ detronyx_12t_2w2r_rc4_4x4_routed_5layer_direct
Xu_t023_006 u_t023_006/c0_w0_bl u_t023_006/c0_w0_br u_t023_006/c0_w1_bl u_t023_006/c0_w1_br u_t023_006/c0_r0_rbl
+ u_t023_006/c0_r1_rbl u_t023_006/c1_w0_bl u_t023_006/c1_w0_br u_t023_006/c1_w1_bl u_t023_006/c1_w1_br
+ u_t023_006/c1_r0_rbl u_t023_006/c1_r1_rbl u_t023_006/c2_w0_bl u_t023_006/c2_w0_br u_t023_006/c2_w1_bl
+ u_t023_006/c2_w1_br u_t023_006/c2_r0_rbl u_t023_006/c2_r1_rbl u_t023_006/c3_w0_bl u_t023_006/c3_w0_br
+ u_t023_006/c3_w1_bl u_t023_006/c3_w1_br u_t023_006/c3_r0_rbl u_t023_006/c3_r1_rbl u_t023_006/r0_w0_wl
+ u_t023_006/r0_w1_wl u_t023_006/r0_r0_rwl u_t023_006/r0_r1_rwl u_t023_006/r1_w0_wl u_t023_006/r1_w1_wl
+ u_t023_006/r1_r0_rwl u_t023_006/r1_r1_rwl u_t023_006/r2_w0_wl u_t023_006/r2_w1_wl u_t023_006/r2_r0_rwl
+ u_t023_006/r2_r1_rwl u_t023_006/r3_w0_wl u_t023_006/r3_w1_wl u_t023_006/r3_r0_rwl u_t023_006/r3_r1_rwl VDD VSS VSUBS
+ detronyx_12t_2w2r_rc4_4x4_routed_5layer_direct
Xu_t005_006 u_t005_006/c0_w0_bl u_t005_006/c0_w0_br u_t005_006/c0_w1_bl u_t005_006/c0_w1_br u_t005_006/c0_r0_rbl
+ u_t005_006/c0_r1_rbl u_t005_006/c1_w0_bl u_t005_006/c1_w0_br u_t005_006/c1_w1_bl u_t005_006/c1_w1_br
+ u_t005_006/c1_r0_rbl u_t005_006/c1_r1_rbl u_t005_006/c2_w0_bl u_t005_006/c2_w0_br u_t005_006/c2_w1_bl
+ u_t005_006/c2_w1_br u_t005_006/c2_r0_rbl u_t005_006/c2_r1_rbl u_t005_006/c3_w0_bl u_t005_006/c3_w0_br
+ u_t005_006/c3_w1_bl u_t005_006/c3_w1_br u_t005_006/c3_r0_rbl u_t005_006/c3_r1_rbl u_t005_006/r0_w0_wl
+ u_t005_006/r0_w1_wl u_t005_006/r0_r0_rwl u_t005_006/r0_r1_rwl u_t005_006/r1_w0_wl u_t005_006/r1_w1_wl
+ u_t005_006/r1_r0_rwl u_t005_006/r1_r1_rwl u_t005_006/r2_w0_wl u_t005_006/r2_w1_wl u_t005_006/r2_r0_rwl
+ u_t005_006/r2_r1_rwl u_t005_006/r3_w0_wl u_t005_006/r3_w1_wl u_t005_006/r3_r0_rwl u_t005_006/r3_r1_rwl VDD VSS VSUBS
+ detronyx_12t_2w2r_rc4_4x4_routed_5layer_direct
Xu_t014_006 u_t014_006/c0_w0_bl u_t014_006/c0_w0_br u_t014_006/c0_w1_bl u_t014_006/c0_w1_br u_t014_006/c0_r0_rbl
+ u_t014_006/c0_r1_rbl u_t014_006/c1_w0_bl u_t014_006/c1_w0_br u_t014_006/c1_w1_bl u_t014_006/c1_w1_br
+ u_t014_006/c1_r0_rbl u_t014_006/c1_r1_rbl u_t014_006/c2_w0_bl u_t014_006/c2_w0_br u_t014_006/c2_w1_bl
+ u_t014_006/c2_w1_br u_t014_006/c2_r0_rbl u_t014_006/c2_r1_rbl u_t014_006/c3_w0_bl u_t014_006/c3_w0_br
+ u_t014_006/c3_w1_bl u_t014_006/c3_w1_br u_t014_006/c3_r0_rbl u_t014_006/c3_r1_rbl u_t014_006/r0_w0_wl
+ u_t014_006/r0_w1_wl u_t014_006/r0_r0_rwl u_t014_006/r0_r1_rwl u_t014_006/r1_w0_wl u_t014_006/r1_w1_wl
+ u_t014_006/r1_r0_rwl u_t014_006/r1_r1_rwl u_t014_006/r2_w0_wl u_t014_006/r2_w1_wl u_t014_006/r2_r0_rwl
+ u_t014_006/r2_r1_rwl u_t014_006/r3_w0_wl u_t014_006/r3_w1_wl u_t014_006/r3_r0_rwl u_t014_006/r3_r1_rwl VDD VSS VSUBS
+ detronyx_12t_2w2r_rc4_4x4_routed_5layer_direct
Xu_t011_009 u_t011_009/c0_w0_bl u_t011_009/c0_w0_br u_t011_009/c0_w1_bl u_t011_009/c0_w1_br u_t011_009/c0_r0_rbl
+ u_t011_009/c0_r1_rbl u_t011_009/c1_w0_bl u_t011_009/c1_w0_br u_t011_009/c1_w1_bl u_t011_009/c1_w1_br
+ u_t011_009/c1_r0_rbl u_t011_009/c1_r1_rbl u_t011_009/c2_w0_bl u_t011_009/c2_w0_br u_t011_009/c2_w1_bl
+ u_t011_009/c2_w1_br u_t011_009/c2_r0_rbl u_t011_009/c2_r1_rbl u_t011_009/c3_w0_bl u_t011_009/c3_w0_br
+ u_t011_009/c3_w1_bl u_t011_009/c3_w1_br u_t011_009/c3_r0_rbl u_t011_009/c3_r1_rbl u_t011_009/r0_w0_wl
+ u_t011_009/r0_w1_wl u_t011_009/r0_r0_rwl u_t011_009/r0_r1_rwl u_t011_009/r1_w0_wl u_t011_009/r1_w1_wl
+ u_t011_009/r1_r0_rwl u_t011_009/r1_r1_rwl u_t011_009/r2_w0_wl u_t011_009/r2_w1_wl u_t011_009/r2_r0_rwl
+ u_t011_009/r2_r1_rwl u_t011_009/r3_w0_wl u_t011_009/r3_w1_wl u_t011_009/r3_r0_rwl u_t011_009/r3_r1_rwl VDD VSS VSUBS
+ detronyx_12t_2w2r_rc4_4x4_routed_5layer_direct
Xu_t020_009 u_t020_009/c0_w0_bl u_t020_009/c0_w0_br u_t020_009/c0_w1_bl u_t020_009/c0_w1_br u_t020_009/c0_r0_rbl
+ u_t020_009/c0_r1_rbl u_t020_009/c1_w0_bl u_t020_009/c1_w0_br u_t020_009/c1_w1_bl u_t020_009/c1_w1_br
+ u_t020_009/c1_r0_rbl u_t020_009/c1_r1_rbl u_t020_009/c2_w0_bl u_t020_009/c2_w0_br u_t020_009/c2_w1_bl
+ u_t020_009/c2_w1_br u_t020_009/c2_r0_rbl u_t020_009/c2_r1_rbl u_t020_009/c3_w0_bl u_t020_009/c3_w0_br
+ u_t020_009/c3_w1_bl u_t020_009/c3_w1_br u_t020_009/c3_r0_rbl u_t020_009/c3_r1_rbl u_t020_009/r0_w0_wl
+ u_t020_009/r0_w1_wl u_t020_009/r0_r0_rwl u_t020_009/r0_r1_rwl u_t020_009/r1_w0_wl u_t020_009/r1_w1_wl
+ u_t020_009/r1_r0_rwl u_t020_009/r1_r1_rwl u_t020_009/r2_w0_wl u_t020_009/r2_w1_wl u_t020_009/r2_r0_rwl
+ u_t020_009/r2_r1_rwl u_t020_009/r3_w0_wl u_t020_009/r3_w1_wl u_t020_009/r3_r0_rwl u_t020_009/r3_r1_rwl VDD VSS VSUBS
+ detronyx_12t_2w2r_rc4_4x4_routed_5layer_direct
Xu_t002_009 u_t002_009/c0_w0_bl u_t002_009/c0_w0_br u_t002_009/c0_w1_bl u_t002_009/c0_w1_br u_t002_009/c0_r0_rbl
+ u_t002_009/c0_r1_rbl u_t002_009/c1_w0_bl u_t002_009/c1_w0_br u_t002_009/c1_w1_bl u_t002_009/c1_w1_br
+ u_t002_009/c1_r0_rbl u_t002_009/c1_r1_rbl u_t002_009/c2_w0_bl u_t002_009/c2_w0_br u_t002_009/c2_w1_bl
+ u_t002_009/c2_w1_br u_t002_009/c2_r0_rbl u_t002_009/c2_r1_rbl u_t002_009/c3_w0_bl u_t002_009/c3_w0_br
+ u_t002_009/c3_w1_bl u_t002_009/c3_w1_br u_t002_009/c3_r0_rbl u_t002_009/c3_r1_rbl u_t002_009/r0_w0_wl
+ u_t002_009/r0_w1_wl u_t002_009/r0_r0_rwl u_t002_009/r0_r1_rwl u_t002_009/r1_w0_wl u_t002_009/r1_w1_wl
+ u_t002_009/r1_r0_rwl u_t002_009/r1_r1_rwl u_t002_009/r2_w0_wl u_t002_009/r2_w1_wl u_t002_009/r2_r0_rwl
+ u_t002_009/r2_r1_rwl u_t002_009/r3_w0_wl u_t002_009/r3_w1_wl u_t002_009/r3_r0_rwl u_t002_009/r3_r1_rwl VDD VSS VSUBS
+ detronyx_12t_2w2r_rc4_4x4_routed_5layer_direct
Xu_t029_012 u_t029_012/c0_w0_bl u_t029_012/c0_w0_br u_t029_012/c0_w1_bl u_t029_012/c0_w1_br u_t029_012/c0_r0_rbl
+ u_t029_012/c0_r1_rbl u_t029_012/c1_w0_bl u_t029_012/c1_w0_br u_t029_012/c1_w1_bl u_t029_012/c1_w1_br
+ u_t029_012/c1_r0_rbl u_t029_012/c1_r1_rbl u_t029_012/c2_w0_bl u_t029_012/c2_w0_br u_t029_012/c2_w1_bl
+ u_t029_012/c2_w1_br u_t029_012/c2_r0_rbl u_t029_012/c2_r1_rbl u_t029_012/c3_w0_bl u_t029_012/c3_w0_br
+ u_t029_012/c3_w1_bl u_t029_012/c3_w1_br u_t029_012/c3_r0_rbl u_t029_012/c3_r1_rbl u_t029_012/r0_w0_wl
+ u_t029_012/r0_w1_wl u_t029_012/r0_r0_rwl u_t029_012/r0_r1_rwl u_t029_012/r1_w0_wl u_t029_012/r1_w1_wl
+ u_t029_012/r1_r0_rwl u_t029_012/r1_r1_rwl u_t029_012/r2_w0_wl u_t029_012/r2_w1_wl u_t029_012/r2_r0_rwl
+ u_t029_012/r2_r1_rwl u_t029_012/r3_w0_wl u_t029_012/r3_w1_wl u_t029_012/r3_r0_rwl u_t029_012/r3_r1_rwl VDD VSS VSUBS
+ detronyx_12t_2w2r_rc4_4x4_routed_5layer_direct
Xu_t029_001 u_t029_001/c0_w0_bl u_t029_001/c0_w0_br u_t029_001/c0_w1_bl u_t029_001/c0_w1_br u_t029_001/c0_r0_rbl
+ u_t029_001/c0_r1_rbl u_t029_001/c1_w0_bl u_t029_001/c1_w0_br u_t029_001/c1_w1_bl u_t029_001/c1_w1_br
+ u_t029_001/c1_r0_rbl u_t029_001/c1_r1_rbl u_t029_001/c2_w0_bl u_t029_001/c2_w0_br u_t029_001/c2_w1_bl
+ u_t029_001/c2_w1_br u_t029_001/c2_r0_rbl u_t029_001/c2_r1_rbl u_t029_001/c3_w0_bl u_t029_001/c3_w0_br
+ u_t029_001/c3_w1_bl u_t029_001/c3_w1_br u_t029_001/c3_r0_rbl u_t029_001/c3_r1_rbl u_t029_001/r0_w0_wl
+ u_t029_001/r0_w1_wl u_t029_001/r0_r0_rwl u_t029_001/r0_r1_rwl u_t029_001/r1_w0_wl u_t029_001/r1_w1_wl
+ u_t029_001/r1_r0_rwl u_t029_001/r1_r1_rwl u_t029_001/r2_w0_wl u_t029_001/r2_w1_wl u_t029_001/r2_r0_rwl
+ u_t029_001/r2_r1_rwl u_t029_001/r3_w0_wl u_t029_001/r3_w1_wl u_t029_001/r3_r0_rwl u_t029_001/r3_r1_rwl VDD VSS VSUBS
+ detronyx_12t_2w2r_rc4_4x4_routed_5layer_direct
Xu_t026_015 u_t026_015/c0_w0_bl u_t026_015/c0_w0_br u_t026_015/c0_w1_bl u_t026_015/c0_w1_br u_t026_015/c0_r0_rbl
+ u_t026_015/c0_r1_rbl u_t026_015/c1_w0_bl u_t026_015/c1_w0_br u_t026_015/c1_w1_bl u_t026_015/c1_w1_br
+ u_t026_015/c1_r0_rbl u_t026_015/c1_r1_rbl u_t026_015/c2_w0_bl u_t026_015/c2_w0_br u_t026_015/c2_w1_bl
+ u_t026_015/c2_w1_br u_t026_015/c2_r0_rbl u_t026_015/c2_r1_rbl u_t026_015/c3_w0_bl u_t026_015/c3_w0_br
+ u_t026_015/c3_w1_bl u_t026_015/c3_w1_br u_t026_015/c3_r0_rbl u_t026_015/c3_r1_rbl u_t026_015/r0_w0_wl
+ u_t026_015/r0_w1_wl u_t026_015/r0_r0_rwl u_t026_015/r0_r1_rwl u_t026_015/r1_w0_wl u_t026_015/r1_w1_wl
+ u_t026_015/r1_r0_rwl u_t026_015/r1_r1_rwl u_t026_015/r2_w0_wl u_t026_015/r2_w1_wl u_t026_015/r2_r0_rwl
+ u_t026_015/r2_r1_rwl u_t026_015/r3_w0_wl u_t026_015/r3_w1_wl u_t026_015/r3_r0_rwl u_t026_015/r3_r1_rwl VDD VSS VSUBS
+ detronyx_12t_2w2r_rc4_4x4_routed_5layer_direct
Xu_t026_004 u_t026_004/c0_w0_bl u_t026_004/c0_w0_br u_t026_004/c0_w1_bl u_t026_004/c0_w1_br u_t026_004/c0_r0_rbl
+ u_t026_004/c0_r1_rbl u_t026_004/c1_w0_bl u_t026_004/c1_w0_br u_t026_004/c1_w1_bl u_t026_004/c1_w1_br
+ u_t026_004/c1_r0_rbl u_t026_004/c1_r1_rbl u_t026_004/c2_w0_bl u_t026_004/c2_w0_br u_t026_004/c2_w1_bl
+ u_t026_004/c2_w1_br u_t026_004/c2_r0_rbl u_t026_004/c2_r1_rbl u_t026_004/c3_w0_bl u_t026_004/c3_w0_br
+ u_t026_004/c3_w1_bl u_t026_004/c3_w1_br u_t026_004/c3_r0_rbl u_t026_004/c3_r1_rbl u_t026_004/r0_w0_wl
+ u_t026_004/r0_w1_wl u_t026_004/r0_r0_rwl u_t026_004/r0_r1_rwl u_t026_004/r1_w0_wl u_t026_004/r1_w1_wl
+ u_t026_004/r1_r0_rwl u_t026_004/r1_r1_rwl u_t026_004/r2_w0_wl u_t026_004/r2_w1_wl u_t026_004/r2_r0_rwl
+ u_t026_004/r2_r1_rwl u_t026_004/r3_w0_wl u_t026_004/r3_w1_wl u_t026_004/r3_r0_rwl u_t026_004/r3_r1_rwl VDD VSS VSUBS
+ detronyx_12t_2w2r_rc4_4x4_routed_5layer_direct
Xu_t017_004 u_t017_004/c0_w0_bl u_t017_004/c0_w0_br u_t017_004/c0_w1_bl u_t017_004/c0_w1_br u_t017_004/c0_r0_rbl
+ u_t017_004/c0_r1_rbl u_t017_004/c1_w0_bl u_t017_004/c1_w0_br u_t017_004/c1_w1_bl u_t017_004/c1_w1_br
+ u_t017_004/c1_r0_rbl u_t017_004/c1_r1_rbl u_t017_004/c2_w0_bl u_t017_004/c2_w0_br u_t017_004/c2_w1_bl
+ u_t017_004/c2_w1_br u_t017_004/c2_r0_rbl u_t017_004/c2_r1_rbl u_t017_004/c3_w0_bl u_t017_004/c3_w0_br
+ u_t017_004/c3_w1_bl u_t017_004/c3_w1_br u_t017_004/c3_r0_rbl u_t017_004/c3_r1_rbl u_t017_004/r0_w0_wl
+ u_t017_004/r0_w1_wl u_t017_004/r0_r0_rwl u_t017_004/r0_r1_rwl u_t017_004/r1_w0_wl u_t017_004/r1_w1_wl
+ u_t017_004/r1_r0_rwl u_t017_004/r1_r1_rwl u_t017_004/r2_w0_wl u_t017_004/r2_w1_wl u_t017_004/r2_r0_rwl
+ u_t017_004/r2_r1_rwl u_t017_004/r3_w0_wl u_t017_004/r3_w1_wl u_t017_004/r3_r0_rwl u_t017_004/r3_r1_rwl VDD VSS VSUBS
+ detronyx_12t_2w2r_rc4_4x4_routed_5layer_direct
Xu_t017_015 u_t017_015/c0_w0_bl u_t017_015/c0_w0_br u_t017_015/c0_w1_bl u_t017_015/c0_w1_br u_t017_015/c0_r0_rbl
+ u_t017_015/c0_r1_rbl u_t017_015/c1_w0_bl u_t017_015/c1_w0_br u_t017_015/c1_w1_bl u_t017_015/c1_w1_br
+ u_t017_015/c1_r0_rbl u_t017_015/c1_r1_rbl u_t017_015/c2_w0_bl u_t017_015/c2_w0_br u_t017_015/c2_w1_bl
+ u_t017_015/c2_w1_br u_t017_015/c2_r0_rbl u_t017_015/c2_r1_rbl u_t017_015/c3_w0_bl u_t017_015/c3_w0_br
+ u_t017_015/c3_w1_bl u_t017_015/c3_w1_br u_t017_015/c3_r0_rbl u_t017_015/c3_r1_rbl u_t017_015/r0_w0_wl
+ u_t017_015/r0_w1_wl u_t017_015/r0_r0_rwl u_t017_015/r0_r1_rwl u_t017_015/r1_w0_wl u_t017_015/r1_w1_wl
+ u_t017_015/r1_r0_rwl u_t017_015/r1_r1_rwl u_t017_015/r2_w0_wl u_t017_015/r2_w1_wl u_t017_015/r2_r0_rwl
+ u_t017_015/r2_r1_rwl u_t017_015/r3_w0_wl u_t017_015/r3_w1_wl u_t017_015/r3_r0_rwl u_t017_015/r3_r1_rwl VDD VSS VSUBS
+ detronyx_12t_2w2r_rc4_4x4_routed_5layer_direct
Xu_t008_004 u_t008_004/c0_w0_bl u_t008_004/c0_w0_br u_t008_004/c0_w1_bl u_t008_004/c0_w1_br u_t008_004/c0_r0_rbl
+ u_t008_004/c0_r1_rbl u_t008_004/c1_w0_bl u_t008_004/c1_w0_br u_t008_004/c1_w1_bl u_t008_004/c1_w1_br
+ u_t008_004/c1_r0_rbl u_t008_004/c1_r1_rbl u_t008_004/c2_w0_bl u_t008_004/c2_w0_br u_t008_004/c2_w1_bl
+ u_t008_004/c2_w1_br u_t008_004/c2_r0_rbl u_t008_004/c2_r1_rbl u_t008_004/c3_w0_bl u_t008_004/c3_w0_br
+ u_t008_004/c3_w1_bl u_t008_004/c3_w1_br u_t008_004/c3_r0_rbl u_t008_004/c3_r1_rbl u_t008_004/r0_w0_wl
+ u_t008_004/r0_w1_wl u_t008_004/r0_r0_rwl u_t008_004/r0_r1_rwl u_t008_004/r1_w0_wl u_t008_004/r1_w1_wl
+ u_t008_004/r1_r0_rwl u_t008_004/r1_r1_rwl u_t008_004/r2_w0_wl u_t008_004/r2_w1_wl u_t008_004/r2_r0_rwl
+ u_t008_004/r2_r1_rwl u_t008_004/r3_w0_wl u_t008_004/r3_w1_wl u_t008_004/r3_r0_rwl u_t008_004/r3_r1_rwl VDD VSS VSUBS
+ detronyx_12t_2w2r_rc4_4x4_routed_5layer_direct
Xu_t008_015 u_t008_015/c0_w0_bl u_t008_015/c0_w0_br u_t008_015/c0_w1_bl u_t008_015/c0_w1_br u_t008_015/c0_r0_rbl
+ u_t008_015/c0_r1_rbl u_t008_015/c1_w0_bl u_t008_015/c1_w0_br u_t008_015/c1_w1_bl u_t008_015/c1_w1_br
+ u_t008_015/c1_r0_rbl u_t008_015/c1_r1_rbl u_t008_015/c2_w0_bl u_t008_015/c2_w0_br u_t008_015/c2_w1_bl
+ u_t008_015/c2_w1_br u_t008_015/c2_r0_rbl u_t008_015/c2_r1_rbl u_t008_015/c3_w0_bl u_t008_015/c3_w0_br
+ u_t008_015/c3_w1_bl u_t008_015/c3_w1_br u_t008_015/c3_r0_rbl u_t008_015/c3_r1_rbl u_t008_015/r0_w0_wl
+ u_t008_015/r0_w1_wl u_t008_015/r0_r0_rwl u_t008_015/r0_r1_rwl u_t008_015/r1_w0_wl u_t008_015/r1_w1_wl
+ u_t008_015/r1_r0_rwl u_t008_015/r1_r1_rwl u_t008_015/r2_w0_wl u_t008_015/r2_w1_wl u_t008_015/r2_r0_rwl
+ u_t008_015/r2_r1_rwl u_t008_015/r3_w0_wl u_t008_015/r3_w1_wl u_t008_015/r3_r0_rwl u_t008_015/r3_r1_rwl VDD VSS VSUBS
+ detronyx_12t_2w2r_rc4_4x4_routed_5layer_direct
Xu_t023_007 u_t023_007/c0_w0_bl u_t023_007/c0_w0_br u_t023_007/c0_w1_bl u_t023_007/c0_w1_br u_t023_007/c0_r0_rbl
+ u_t023_007/c0_r1_rbl u_t023_007/c1_w0_bl u_t023_007/c1_w0_br u_t023_007/c1_w1_bl u_t023_007/c1_w1_br
+ u_t023_007/c1_r0_rbl u_t023_007/c1_r1_rbl u_t023_007/c2_w0_bl u_t023_007/c2_w0_br u_t023_007/c2_w1_bl
+ u_t023_007/c2_w1_br u_t023_007/c2_r0_rbl u_t023_007/c2_r1_rbl u_t023_007/c3_w0_bl u_t023_007/c3_w0_br
+ u_t023_007/c3_w1_bl u_t023_007/c3_w1_br u_t023_007/c3_r0_rbl u_t023_007/c3_r1_rbl u_t023_007/r0_w0_wl
+ u_t023_007/r0_w1_wl u_t023_007/r0_r0_rwl u_t023_007/r0_r1_rwl u_t023_007/r1_w0_wl u_t023_007/r1_w1_wl
+ u_t023_007/r1_r0_rwl u_t023_007/r1_r1_rwl u_t023_007/r2_w0_wl u_t023_007/r2_w1_wl u_t023_007/r2_r0_rwl
+ u_t023_007/r2_r1_rwl u_t023_007/r3_w0_wl u_t023_007/r3_w1_wl u_t023_007/r3_r0_rwl u_t023_007/r3_r1_rwl VDD VSS VSUBS
+ detronyx_12t_2w2r_rc4_4x4_routed_5layer_direct
Xu_t014_007 u_t014_007/c0_w0_bl u_t014_007/c0_w0_br u_t014_007/c0_w1_bl u_t014_007/c0_w1_br u_t014_007/c0_r0_rbl
+ u_t014_007/c0_r1_rbl u_t014_007/c1_w0_bl u_t014_007/c1_w0_br u_t014_007/c1_w1_bl u_t014_007/c1_w1_br
+ u_t014_007/c1_r0_rbl u_t014_007/c1_r1_rbl u_t014_007/c2_w0_bl u_t014_007/c2_w0_br u_t014_007/c2_w1_bl
+ u_t014_007/c2_w1_br u_t014_007/c2_r0_rbl u_t014_007/c2_r1_rbl u_t014_007/c3_w0_bl u_t014_007/c3_w0_br
+ u_t014_007/c3_w1_bl u_t014_007/c3_w1_br u_t014_007/c3_r0_rbl u_t014_007/c3_r1_rbl u_t014_007/r0_w0_wl
+ u_t014_007/r0_w1_wl u_t014_007/r0_r0_rwl u_t014_007/r0_r1_rwl u_t014_007/r1_w0_wl u_t014_007/r1_w1_wl
+ u_t014_007/r1_r0_rwl u_t014_007/r1_r1_rwl u_t014_007/r2_w0_wl u_t014_007/r2_w1_wl u_t014_007/r2_r0_rwl
+ u_t014_007/r2_r1_rwl u_t014_007/r3_w0_wl u_t014_007/r3_w1_wl u_t014_007/r3_r0_rwl u_t014_007/r3_r1_rwl VDD VSS VSUBS
+ detronyx_12t_2w2r_rc4_4x4_routed_5layer_direct
Xu_t005_007 u_t005_007/c0_w0_bl u_t005_007/c0_w0_br u_t005_007/c0_w1_bl u_t005_007/c0_w1_br u_t005_007/c0_r0_rbl
+ u_t005_007/c0_r1_rbl u_t005_007/c1_w0_bl u_t005_007/c1_w0_br u_t005_007/c1_w1_bl u_t005_007/c1_w1_br
+ u_t005_007/c1_r0_rbl u_t005_007/c1_r1_rbl u_t005_007/c2_w0_bl u_t005_007/c2_w0_br u_t005_007/c2_w1_bl
+ u_t005_007/c2_w1_br u_t005_007/c2_r0_rbl u_t005_007/c2_r1_rbl u_t005_007/c3_w0_bl u_t005_007/c3_w0_br
+ u_t005_007/c3_w1_bl u_t005_007/c3_w1_br u_t005_007/c3_r0_rbl u_t005_007/c3_r1_rbl u_t005_007/r0_w0_wl
+ u_t005_007/r0_w1_wl u_t005_007/r0_r0_rwl u_t005_007/r0_r1_rwl u_t005_007/r1_w0_wl u_t005_007/r1_w1_wl
+ u_t005_007/r1_r0_rwl u_t005_007/r1_r1_rwl u_t005_007/r2_w0_wl u_t005_007/r2_w1_wl u_t005_007/r2_r0_rwl
+ u_t005_007/r2_r1_rwl u_t005_007/r3_w0_wl u_t005_007/r3_w1_wl u_t005_007/r3_r0_rwl u_t005_007/r3_r1_rwl VDD VSS VSUBS
+ detronyx_12t_2w2r_rc4_4x4_routed_5layer_direct
Xu_t001_010 u_t001_010/c0_w0_bl u_t001_010/c0_w0_br u_t001_010/c0_w1_bl u_t001_010/c0_w1_br u_t001_010/c0_r0_rbl
+ u_t001_010/c0_r1_rbl u_t001_010/c1_w0_bl u_t001_010/c1_w0_br u_t001_010/c1_w1_bl u_t001_010/c1_w1_br
+ u_t001_010/c1_r0_rbl u_t001_010/c1_r1_rbl u_t001_010/c2_w0_bl u_t001_010/c2_w0_br u_t001_010/c2_w1_bl
+ u_t001_010/c2_w1_br u_t001_010/c2_r0_rbl u_t001_010/c2_r1_rbl u_t001_010/c3_w0_bl u_t001_010/c3_w0_br
+ u_t001_010/c3_w1_bl u_t001_010/c3_w1_br u_t001_010/c3_r0_rbl u_t001_010/c3_r1_rbl u_t001_010/r0_w0_wl
+ u_t001_010/r0_w1_wl u_t001_010/r0_r0_rwl u_t001_010/r0_r1_rwl u_t001_010/r1_w0_wl u_t001_010/r1_w1_wl
+ u_t001_010/r1_r0_rwl u_t001_010/r1_r1_rwl u_t001_010/r2_w0_wl u_t001_010/r2_w1_wl u_t001_010/r2_r0_rwl
+ u_t001_010/r2_r1_rwl u_t001_010/r3_w0_wl u_t001_010/r3_w1_wl u_t001_010/r3_r0_rwl u_t001_010/r3_r1_rwl VDD VSS VSUBS
+ detronyx_12t_2w2r_rc4_4x4_routed_5layer_direct
Xu_t010_010 u_t010_010/c0_w0_bl u_t010_010/c0_w0_br u_t010_010/c0_w1_bl u_t010_010/c0_w1_br u_t010_010/c0_r0_rbl
+ u_t010_010/c0_r1_rbl u_t010_010/c1_w0_bl u_t010_010/c1_w0_br u_t010_010/c1_w1_bl u_t010_010/c1_w1_br
+ u_t010_010/c1_r0_rbl u_t010_010/c1_r1_rbl u_t010_010/c2_w0_bl u_t010_010/c2_w0_br u_t010_010/c2_w1_bl
+ u_t010_010/c2_w1_br u_t010_010/c2_r0_rbl u_t010_010/c2_r1_rbl u_t010_010/c3_w0_bl u_t010_010/c3_w0_br
+ u_t010_010/c3_w1_bl u_t010_010/c3_w1_br u_t010_010/c3_r0_rbl u_t010_010/c3_r1_rbl u_t010_010/r0_w0_wl
+ u_t010_010/r0_w1_wl u_t010_010/r0_r0_rwl u_t010_010/r0_r1_rwl u_t010_010/r1_w0_wl u_t010_010/r1_w1_wl
+ u_t010_010/r1_r0_rwl u_t010_010/r1_r1_rwl u_t010_010/r2_w0_wl u_t010_010/r2_w1_wl u_t010_010/r2_r0_rwl
+ u_t010_010/r2_r1_rwl u_t010_010/r3_w0_wl u_t010_010/r3_w1_wl u_t010_010/r3_r0_rwl u_t010_010/r3_r1_rwl VDD VSS VSUBS
+ detronyx_12t_2w2r_rc4_4x4_routed_5layer_direct
Xu_t029_013 u_t029_013/c0_w0_bl u_t029_013/c0_w0_br u_t029_013/c0_w1_bl u_t029_013/c0_w1_br u_t029_013/c0_r0_rbl
+ u_t029_013/c0_r1_rbl u_t029_013/c1_w0_bl u_t029_013/c1_w0_br u_t029_013/c1_w1_bl u_t029_013/c1_w1_br
+ u_t029_013/c1_r0_rbl u_t029_013/c1_r1_rbl u_t029_013/c2_w0_bl u_t029_013/c2_w0_br u_t029_013/c2_w1_bl
+ u_t029_013/c2_w1_br u_t029_013/c2_r0_rbl u_t029_013/c2_r1_rbl u_t029_013/c3_w0_bl u_t029_013/c3_w0_br
+ u_t029_013/c3_w1_bl u_t029_013/c3_w1_br u_t029_013/c3_r0_rbl u_t029_013/c3_r1_rbl u_t029_013/r0_w0_wl
+ u_t029_013/r0_w1_wl u_t029_013/r0_r0_rwl u_t029_013/r0_r1_rwl u_t029_013/r1_w0_wl u_t029_013/r1_w1_wl
+ u_t029_013/r1_r0_rwl u_t029_013/r1_r1_rwl u_t029_013/r2_w0_wl u_t029_013/r2_w1_wl u_t029_013/r2_r0_rwl
+ u_t029_013/r2_r1_rwl u_t029_013/r3_w0_wl u_t029_013/r3_w1_wl u_t029_013/r3_r0_rwl u_t029_013/r3_r1_rwl VDD VSS VSUBS
+ detronyx_12t_2w2r_rc4_4x4_routed_5layer_direct
Xu_t029_002 u_t029_002/c0_w0_bl u_t029_002/c0_w0_br u_t029_002/c0_w1_bl u_t029_002/c0_w1_br u_t029_002/c0_r0_rbl
+ u_t029_002/c0_r1_rbl u_t029_002/c1_w0_bl u_t029_002/c1_w0_br u_t029_002/c1_w1_bl u_t029_002/c1_w1_br
+ u_t029_002/c1_r0_rbl u_t029_002/c1_r1_rbl u_t029_002/c2_w0_bl u_t029_002/c2_w0_br u_t029_002/c2_w1_bl
+ u_t029_002/c2_w1_br u_t029_002/c2_r0_rbl u_t029_002/c2_r1_rbl u_t029_002/c3_w0_bl u_t029_002/c3_w0_br
+ u_t029_002/c3_w1_bl u_t029_002/c3_w1_br u_t029_002/c3_r0_rbl u_t029_002/c3_r1_rbl u_t029_002/r0_w0_wl
+ u_t029_002/r0_w1_wl u_t029_002/r0_r0_rwl u_t029_002/r0_r1_rwl u_t029_002/r1_w0_wl u_t029_002/r1_w1_wl
+ u_t029_002/r1_r0_rwl u_t029_002/r1_r1_rwl u_t029_002/r2_w0_wl u_t029_002/r2_w1_wl u_t029_002/r2_r0_rwl
+ u_t029_002/r2_r1_rwl u_t029_002/r3_w0_wl u_t029_002/r3_w1_wl u_t029_002/r3_r0_rwl u_t029_002/r3_r1_rwl VDD VSS VSUBS
+ detronyx_12t_2w2r_rc4_4x4_routed_5layer_direct
Xu_t026_005 u_t026_005/c0_w0_bl u_t026_005/c0_w0_br u_t026_005/c0_w1_bl u_t026_005/c0_w1_br u_t026_005/c0_r0_rbl
+ u_t026_005/c0_r1_rbl u_t026_005/c1_w0_bl u_t026_005/c1_w0_br u_t026_005/c1_w1_bl u_t026_005/c1_w1_br
+ u_t026_005/c1_r0_rbl u_t026_005/c1_r1_rbl u_t026_005/c2_w0_bl u_t026_005/c2_w0_br u_t026_005/c2_w1_bl
+ u_t026_005/c2_w1_br u_t026_005/c2_r0_rbl u_t026_005/c2_r1_rbl u_t026_005/c3_w0_bl u_t026_005/c3_w0_br
+ u_t026_005/c3_w1_bl u_t026_005/c3_w1_br u_t026_005/c3_r0_rbl u_t026_005/c3_r1_rbl u_t026_005/r0_w0_wl
+ u_t026_005/r0_w1_wl u_t026_005/r0_r0_rwl u_t026_005/r0_r1_rwl u_t026_005/r1_w0_wl u_t026_005/r1_w1_wl
+ u_t026_005/r1_r0_rwl u_t026_005/r1_r1_rwl u_t026_005/r2_w0_wl u_t026_005/r2_w1_wl u_t026_005/r2_r0_rwl
+ u_t026_005/r2_r1_rwl u_t026_005/r3_w0_wl u_t026_005/r3_w1_wl u_t026_005/r3_r0_rwl u_t026_005/r3_r1_rwl VDD VSS VSUBS
+ detronyx_12t_2w2r_rc4_4x4_routed_5layer_direct
Xu_t017_005 u_t017_005/c0_w0_bl u_t017_005/c0_w0_br u_t017_005/c0_w1_bl u_t017_005/c0_w1_br u_t017_005/c0_r0_rbl
+ u_t017_005/c0_r1_rbl u_t017_005/c1_w0_bl u_t017_005/c1_w0_br u_t017_005/c1_w1_bl u_t017_005/c1_w1_br
+ u_t017_005/c1_r0_rbl u_t017_005/c1_r1_rbl u_t017_005/c2_w0_bl u_t017_005/c2_w0_br u_t017_005/c2_w1_bl
+ u_t017_005/c2_w1_br u_t017_005/c2_r0_rbl u_t017_005/c2_r1_rbl u_t017_005/c3_w0_bl u_t017_005/c3_w0_br
+ u_t017_005/c3_w1_bl u_t017_005/c3_w1_br u_t017_005/c3_r0_rbl u_t017_005/c3_r1_rbl u_t017_005/r0_w0_wl
+ u_t017_005/r0_w1_wl u_t017_005/r0_r0_rwl u_t017_005/r0_r1_rwl u_t017_005/r1_w0_wl u_t017_005/r1_w1_wl
+ u_t017_005/r1_r0_rwl u_t017_005/r1_r1_rwl u_t017_005/r2_w0_wl u_t017_005/r2_w1_wl u_t017_005/r2_r0_rwl
+ u_t017_005/r2_r1_rwl u_t017_005/r3_w0_wl u_t017_005/r3_w1_wl u_t017_005/r3_r0_rwl u_t017_005/r3_r1_rwl VDD VSS VSUBS
+ detronyx_12t_2w2r_rc4_4x4_routed_5layer_direct
Xu_t008_005 u_t008_005/c0_w0_bl u_t008_005/c0_w0_br u_t008_005/c0_w1_bl u_t008_005/c0_w1_br u_t008_005/c0_r0_rbl
+ u_t008_005/c0_r1_rbl u_t008_005/c1_w0_bl u_t008_005/c1_w0_br u_t008_005/c1_w1_bl u_t008_005/c1_w1_br
+ u_t008_005/c1_r0_rbl u_t008_005/c1_r1_rbl u_t008_005/c2_w0_bl u_t008_005/c2_w0_br u_t008_005/c2_w1_bl
+ u_t008_005/c2_w1_br u_t008_005/c2_r0_rbl u_t008_005/c2_r1_rbl u_t008_005/c3_w0_bl u_t008_005/c3_w0_br
+ u_t008_005/c3_w1_bl u_t008_005/c3_w1_br u_t008_005/c3_r0_rbl u_t008_005/c3_r1_rbl u_t008_005/r0_w0_wl
+ u_t008_005/r0_w1_wl u_t008_005/r0_r0_rwl u_t008_005/r0_r1_rwl u_t008_005/r1_w0_wl u_t008_005/r1_w1_wl
+ u_t008_005/r1_r0_rwl u_t008_005/r1_r1_rwl u_t008_005/r2_w0_wl u_t008_005/r2_w1_wl u_t008_005/r2_r0_rwl
+ u_t008_005/r2_r1_rwl u_t008_005/r3_w0_wl u_t008_005/r3_w1_wl u_t008_005/r3_r0_rwl u_t008_005/r3_r1_rwl VDD VSS VSUBS
+ detronyx_12t_2w2r_rc4_4x4_routed_5layer_direct
Xu_t023_008 u_t023_008/c0_w0_bl u_t023_008/c0_w0_br u_t023_008/c0_w1_bl u_t023_008/c0_w1_br u_t023_008/c0_r0_rbl
+ u_t023_008/c0_r1_rbl u_t023_008/c1_w0_bl u_t023_008/c1_w0_br u_t023_008/c1_w1_bl u_t023_008/c1_w1_br
+ u_t023_008/c1_r0_rbl u_t023_008/c1_r1_rbl u_t023_008/c2_w0_bl u_t023_008/c2_w0_br u_t023_008/c2_w1_bl
+ u_t023_008/c2_w1_br u_t023_008/c2_r0_rbl u_t023_008/c2_r1_rbl u_t023_008/c3_w0_bl u_t023_008/c3_w0_br
+ u_t023_008/c3_w1_bl u_t023_008/c3_w1_br u_t023_008/c3_r0_rbl u_t023_008/c3_r1_rbl u_t023_008/r0_w0_wl
+ u_t023_008/r0_w1_wl u_t023_008/r0_r0_rwl u_t023_008/r0_r1_rwl u_t023_008/r1_w0_wl u_t023_008/r1_w1_wl
+ u_t023_008/r1_r0_rwl u_t023_008/r1_r1_rwl u_t023_008/r2_w0_wl u_t023_008/r2_w1_wl u_t023_008/r2_r0_rwl
+ u_t023_008/r2_r1_rwl u_t023_008/r3_w0_wl u_t023_008/r3_w1_wl u_t023_008/r3_r0_rwl u_t023_008/r3_r1_rwl VDD VSS VSUBS
+ detronyx_12t_2w2r_rc4_4x4_routed_5layer_direct
Xu_t014_008 u_t014_008/c0_w0_bl u_t014_008/c0_w0_br u_t014_008/c0_w1_bl u_t014_008/c0_w1_br u_t014_008/c0_r0_rbl
+ u_t014_008/c0_r1_rbl u_t014_008/c1_w0_bl u_t014_008/c1_w0_br u_t014_008/c1_w1_bl u_t014_008/c1_w1_br
+ u_t014_008/c1_r0_rbl u_t014_008/c1_r1_rbl u_t014_008/c2_w0_bl u_t014_008/c2_w0_br u_t014_008/c2_w1_bl
+ u_t014_008/c2_w1_br u_t014_008/c2_r0_rbl u_t014_008/c2_r1_rbl u_t014_008/c3_w0_bl u_t014_008/c3_w0_br
+ u_t014_008/c3_w1_bl u_t014_008/c3_w1_br u_t014_008/c3_r0_rbl u_t014_008/c3_r1_rbl u_t014_008/r0_w0_wl
+ u_t014_008/r0_w1_wl u_t014_008/r0_r0_rwl u_t014_008/r0_r1_rwl u_t014_008/r1_w0_wl u_t014_008/r1_w1_wl
+ u_t014_008/r1_r0_rwl u_t014_008/r1_r1_rwl u_t014_008/r2_w0_wl u_t014_008/r2_w1_wl u_t014_008/r2_r0_rwl
+ u_t014_008/r2_r1_rwl u_t014_008/r3_w0_wl u_t014_008/r3_w1_wl u_t014_008/r3_r0_rwl u_t014_008/r3_r1_rwl VDD VSS VSUBS
+ detronyx_12t_2w2r_rc4_4x4_routed_5layer_direct
Xu_t005_008 u_t005_008/c0_w0_bl u_t005_008/c0_w0_br u_t005_008/c0_w1_bl u_t005_008/c0_w1_br u_t005_008/c0_r0_rbl
+ u_t005_008/c0_r1_rbl u_t005_008/c1_w0_bl u_t005_008/c1_w0_br u_t005_008/c1_w1_bl u_t005_008/c1_w1_br
+ u_t005_008/c1_r0_rbl u_t005_008/c1_r1_rbl u_t005_008/c2_w0_bl u_t005_008/c2_w0_br u_t005_008/c2_w1_bl
+ u_t005_008/c2_w1_br u_t005_008/c2_r0_rbl u_t005_008/c2_r1_rbl u_t005_008/c3_w0_bl u_t005_008/c3_w0_br
+ u_t005_008/c3_w1_bl u_t005_008/c3_w1_br u_t005_008/c3_r0_rbl u_t005_008/c3_r1_rbl u_t005_008/r0_w0_wl
+ u_t005_008/r0_w1_wl u_t005_008/r0_r0_rwl u_t005_008/r0_r1_rwl u_t005_008/r1_w0_wl u_t005_008/r1_w1_wl
+ u_t005_008/r1_r0_rwl u_t005_008/r1_r1_rwl u_t005_008/r2_w0_wl u_t005_008/r2_w1_wl u_t005_008/r2_r0_rwl
+ u_t005_008/r2_r1_rwl u_t005_008/r3_w0_wl u_t005_008/r3_w1_wl u_t005_008/r3_r0_rwl u_t005_008/r3_r1_rwl VDD VSS VSUBS
+ detronyx_12t_2w2r_rc4_4x4_routed_5layer_direct
Xu_t010_000 u_t010_000/c0_w0_bl u_t010_000/c0_w0_br u_t010_000/c0_w1_bl u_t010_000/c0_w1_br u_t010_000/c0_r0_rbl
+ u_t010_000/c0_r1_rbl u_t010_000/c1_w0_bl u_t010_000/c1_w0_br u_t010_000/c1_w1_bl u_t010_000/c1_w1_br
+ u_t010_000/c1_r0_rbl u_t010_000/c1_r1_rbl u_t010_000/c2_w0_bl u_t010_000/c2_w0_br u_t010_000/c2_w1_bl
+ u_t010_000/c2_w1_br u_t010_000/c2_r0_rbl u_t010_000/c2_r1_rbl u_t010_000/c3_w0_bl u_t010_000/c3_w0_br
+ u_t010_000/c3_w1_bl u_t010_000/c3_w1_br u_t010_000/c3_r0_rbl u_t010_000/c3_r1_rbl u_t010_000/r0_w0_wl
+ u_t010_000/r0_w1_wl u_t010_000/r0_r0_rwl u_t010_000/r0_r1_rwl u_t010_000/r1_w0_wl u_t010_000/r1_w1_wl
+ u_t010_000/r1_r0_rwl u_t010_000/r1_r1_rwl u_t010_000/r2_w0_wl u_t010_000/r2_w1_wl u_t010_000/r2_r0_rwl
+ u_t010_000/r2_r1_rwl u_t010_000/r3_w0_wl u_t010_000/r3_w1_wl u_t010_000/r3_r0_rwl u_t010_000/r3_r1_rwl VDD VSS VSUBS
+ detronyx_12t_2w2r_rc4_4x4_routed_5layer_direct
Xu_t010_011 u_t010_011/c0_w0_bl u_t010_011/c0_w0_br u_t010_011/c0_w1_bl u_t010_011/c0_w1_br u_t010_011/c0_r0_rbl
+ u_t010_011/c0_r1_rbl u_t010_011/c1_w0_bl u_t010_011/c1_w0_br u_t010_011/c1_w1_bl u_t010_011/c1_w1_br
+ u_t010_011/c1_r0_rbl u_t010_011/c1_r1_rbl u_t010_011/c2_w0_bl u_t010_011/c2_w0_br u_t010_011/c2_w1_bl
+ u_t010_011/c2_w1_br u_t010_011/c2_r0_rbl u_t010_011/c2_r1_rbl u_t010_011/c3_w0_bl u_t010_011/c3_w0_br
+ u_t010_011/c3_w1_bl u_t010_011/c3_w1_br u_t010_011/c3_r0_rbl u_t010_011/c3_r1_rbl u_t010_011/r0_w0_wl
+ u_t010_011/r0_w1_wl u_t010_011/r0_r0_rwl u_t010_011/r0_r1_rwl u_t010_011/r1_w0_wl u_t010_011/r1_w1_wl
+ u_t010_011/r1_r0_rwl u_t010_011/r1_r1_rwl u_t010_011/r2_w0_wl u_t010_011/r2_w1_wl u_t010_011/r2_r0_rwl
+ u_t010_011/r2_r1_rwl u_t010_011/r3_w0_wl u_t010_011/r3_w1_wl u_t010_011/r3_r0_rwl u_t010_011/r3_r1_rwl VDD VSS VSUBS
+ detronyx_12t_2w2r_rc4_4x4_routed_5layer_direct
Xu_t001_011 u_t001_011/c0_w0_bl u_t001_011/c0_w0_br u_t001_011/c0_w1_bl u_t001_011/c0_w1_br u_t001_011/c0_r0_rbl
+ u_t001_011/c0_r1_rbl u_t001_011/c1_w0_bl u_t001_011/c1_w0_br u_t001_011/c1_w1_bl u_t001_011/c1_w1_br
+ u_t001_011/c1_r0_rbl u_t001_011/c1_r1_rbl u_t001_011/c2_w0_bl u_t001_011/c2_w0_br u_t001_011/c2_w1_bl
+ u_t001_011/c2_w1_br u_t001_011/c2_r0_rbl u_t001_011/c2_r1_rbl u_t001_011/c3_w0_bl u_t001_011/c3_w0_br
+ u_t001_011/c3_w1_bl u_t001_011/c3_w1_br u_t001_011/c3_r0_rbl u_t001_011/c3_r1_rbl u_t001_011/r0_w0_wl
+ u_t001_011/r0_w1_wl u_t001_011/r0_r0_rwl u_t001_011/r0_r1_rwl u_t001_011/r1_w0_wl u_t001_011/r1_w1_wl
+ u_t001_011/r1_r0_rwl u_t001_011/r1_r1_rwl u_t001_011/r2_w0_wl u_t001_011/r2_w1_wl u_t001_011/r2_r0_rwl
+ u_t001_011/r2_r1_rwl u_t001_011/r3_w0_wl u_t001_011/r3_w1_wl u_t001_011/r3_r0_rwl u_t001_011/r3_r1_rwl VDD VSS VSUBS
+ detronyx_12t_2w2r_rc4_4x4_routed_5layer_direct
Xu_t001_000 u_t001_000/c0_w0_bl u_t001_000/c0_w0_br u_t001_000/c0_w1_bl u_t001_000/c0_w1_br u_t001_000/c0_r0_rbl
+ u_t001_000/c0_r1_rbl u_t001_000/c1_w0_bl u_t001_000/c1_w0_br u_t001_000/c1_w1_bl u_t001_000/c1_w1_br
+ u_t001_000/c1_r0_rbl u_t001_000/c1_r1_rbl u_t001_000/c2_w0_bl u_t001_000/c2_w0_br u_t001_000/c2_w1_bl
+ u_t001_000/c2_w1_br u_t001_000/c2_r0_rbl u_t001_000/c2_r1_rbl u_t001_000/c3_w0_bl u_t001_000/c3_w0_br
+ u_t001_000/c3_w1_bl u_t001_000/c3_w1_br u_t001_000/c3_r0_rbl u_t001_000/c3_r1_rbl u_t001_000/r0_w0_wl
+ u_t001_000/r0_w1_wl u_t001_000/r0_r0_rwl u_t001_000/r0_r1_rwl u_t001_000/r1_w0_wl u_t001_000/r1_w1_wl
+ u_t001_000/r1_r0_rwl u_t001_000/r1_r1_rwl u_t001_000/r2_w0_wl u_t001_000/r2_w1_wl u_t001_000/r2_r0_rwl
+ u_t001_000/r2_r1_rwl u_t001_000/r3_w0_wl u_t001_000/r3_w1_wl u_t001_000/r3_r0_rwl u_t001_000/r3_r1_rwl VDD VSS VSUBS
+ detronyx_12t_2w2r_rc4_4x4_routed_5layer_direct
Xu_t029_014 u_t029_014/c0_w0_bl u_t029_014/c0_w0_br u_t029_014/c0_w1_bl u_t029_014/c0_w1_br u_t029_014/c0_r0_rbl
+ u_t029_014/c0_r1_rbl u_t029_014/c1_w0_bl u_t029_014/c1_w0_br u_t029_014/c1_w1_bl u_t029_014/c1_w1_br
+ u_t029_014/c1_r0_rbl u_t029_014/c1_r1_rbl u_t029_014/c2_w0_bl u_t029_014/c2_w0_br u_t029_014/c2_w1_bl
+ u_t029_014/c2_w1_br u_t029_014/c2_r0_rbl u_t029_014/c2_r1_rbl u_t029_014/c3_w0_bl u_t029_014/c3_w0_br
+ u_t029_014/c3_w1_bl u_t029_014/c3_w1_br u_t029_014/c3_r0_rbl u_t029_014/c3_r1_rbl u_t029_014/r0_w0_wl
+ u_t029_014/r0_w1_wl u_t029_014/r0_r0_rwl u_t029_014/r0_r1_rwl u_t029_014/r1_w0_wl u_t029_014/r1_w1_wl
+ u_t029_014/r1_r0_rwl u_t029_014/r1_r1_rwl u_t029_014/r2_w0_wl u_t029_014/r2_w1_wl u_t029_014/r2_r0_rwl
+ u_t029_014/r2_r1_rwl u_t029_014/r3_w0_wl u_t029_014/r3_w1_wl u_t029_014/r3_r0_rwl u_t029_014/r3_r1_rwl VDD VSS VSUBS
+ detronyx_12t_2w2r_rc4_4x4_routed_5layer_direct
Xu_t029_003 u_t029_003/c0_w0_bl u_t029_003/c0_w0_br u_t029_003/c0_w1_bl u_t029_003/c0_w1_br u_t029_003/c0_r0_rbl
+ u_t029_003/c0_r1_rbl u_t029_003/c1_w0_bl u_t029_003/c1_w0_br u_t029_003/c1_w1_bl u_t029_003/c1_w1_br
+ u_t029_003/c1_r0_rbl u_t029_003/c1_r1_rbl u_t029_003/c2_w0_bl u_t029_003/c2_w0_br u_t029_003/c2_w1_bl
+ u_t029_003/c2_w1_br u_t029_003/c2_r0_rbl u_t029_003/c2_r1_rbl u_t029_003/c3_w0_bl u_t029_003/c3_w0_br
+ u_t029_003/c3_w1_bl u_t029_003/c3_w1_br u_t029_003/c3_r0_rbl u_t029_003/c3_r1_rbl u_t029_003/r0_w0_wl
+ u_t029_003/r0_w1_wl u_t029_003/r0_r0_rwl u_t029_003/r0_r1_rwl u_t029_003/r1_w0_wl u_t029_003/r1_w1_wl
+ u_t029_003/r1_r0_rwl u_t029_003/r1_r1_rwl u_t029_003/r2_w0_wl u_t029_003/r2_w1_wl u_t029_003/r2_r0_rwl
+ u_t029_003/r2_r1_rwl u_t029_003/r3_w0_wl u_t029_003/r3_w1_wl u_t029_003/r3_r0_rwl u_t029_003/r3_r1_rwl VDD VSS VSUBS
+ detronyx_12t_2w2r_rc4_4x4_routed_5layer_direct
Xu_t026_006 u_t026_006/c0_w0_bl u_t026_006/c0_w0_br u_t026_006/c0_w1_bl u_t026_006/c0_w1_br u_t026_006/c0_r0_rbl
+ u_t026_006/c0_r1_rbl u_t026_006/c1_w0_bl u_t026_006/c1_w0_br u_t026_006/c1_w1_bl u_t026_006/c1_w1_br
+ u_t026_006/c1_r0_rbl u_t026_006/c1_r1_rbl u_t026_006/c2_w0_bl u_t026_006/c2_w0_br u_t026_006/c2_w1_bl
+ u_t026_006/c2_w1_br u_t026_006/c2_r0_rbl u_t026_006/c2_r1_rbl u_t026_006/c3_w0_bl u_t026_006/c3_w0_br
+ u_t026_006/c3_w1_bl u_t026_006/c3_w1_br u_t026_006/c3_r0_rbl u_t026_006/c3_r1_rbl u_t026_006/r0_w0_wl
+ u_t026_006/r0_w1_wl u_t026_006/r0_r0_rwl u_t026_006/r0_r1_rwl u_t026_006/r1_w0_wl u_t026_006/r1_w1_wl
+ u_t026_006/r1_r0_rwl u_t026_006/r1_r1_rwl u_t026_006/r2_w0_wl u_t026_006/r2_w1_wl u_t026_006/r2_r0_rwl
+ u_t026_006/r2_r1_rwl u_t026_006/r3_w0_wl u_t026_006/r3_w1_wl u_t026_006/r3_r0_rwl u_t026_006/r3_r1_rwl VDD VSS VSUBS
+ detronyx_12t_2w2r_rc4_4x4_routed_5layer_direct
Xu_t017_006 u_t017_006/c0_w0_bl u_t017_006/c0_w0_br u_t017_006/c0_w1_bl u_t017_006/c0_w1_br u_t017_006/c0_r0_rbl
+ u_t017_006/c0_r1_rbl u_t017_006/c1_w0_bl u_t017_006/c1_w0_br u_t017_006/c1_w1_bl u_t017_006/c1_w1_br
+ u_t017_006/c1_r0_rbl u_t017_006/c1_r1_rbl u_t017_006/c2_w0_bl u_t017_006/c2_w0_br u_t017_006/c2_w1_bl
+ u_t017_006/c2_w1_br u_t017_006/c2_r0_rbl u_t017_006/c2_r1_rbl u_t017_006/c3_w0_bl u_t017_006/c3_w0_br
+ u_t017_006/c3_w1_bl u_t017_006/c3_w1_br u_t017_006/c3_r0_rbl u_t017_006/c3_r1_rbl u_t017_006/r0_w0_wl
+ u_t017_006/r0_w1_wl u_t017_006/r0_r0_rwl u_t017_006/r0_r1_rwl u_t017_006/r1_w0_wl u_t017_006/r1_w1_wl
+ u_t017_006/r1_r0_rwl u_t017_006/r1_r1_rwl u_t017_006/r2_w0_wl u_t017_006/r2_w1_wl u_t017_006/r2_r0_rwl
+ u_t017_006/r2_r1_rwl u_t017_006/r3_w0_wl u_t017_006/r3_w1_wl u_t017_006/r3_r0_rwl u_t017_006/r3_r1_rwl VDD VSS VSUBS
+ detronyx_12t_2w2r_rc4_4x4_routed_5layer_direct
Xu_t008_006 u_t008_006/c0_w0_bl u_t008_006/c0_w0_br u_t008_006/c0_w1_bl u_t008_006/c0_w1_br u_t008_006/c0_r0_rbl
+ u_t008_006/c0_r1_rbl u_t008_006/c1_w0_bl u_t008_006/c1_w0_br u_t008_006/c1_w1_bl u_t008_006/c1_w1_br
+ u_t008_006/c1_r0_rbl u_t008_006/c1_r1_rbl u_t008_006/c2_w0_bl u_t008_006/c2_w0_br u_t008_006/c2_w1_bl
+ u_t008_006/c2_w1_br u_t008_006/c2_r0_rbl u_t008_006/c2_r1_rbl u_t008_006/c3_w0_bl u_t008_006/c3_w0_br
+ u_t008_006/c3_w1_bl u_t008_006/c3_w1_br u_t008_006/c3_r0_rbl u_t008_006/c3_r1_rbl u_t008_006/r0_w0_wl
+ u_t008_006/r0_w1_wl u_t008_006/r0_r0_rwl u_t008_006/r0_r1_rwl u_t008_006/r1_w0_wl u_t008_006/r1_w1_wl
+ u_t008_006/r1_r0_rwl u_t008_006/r1_r1_rwl u_t008_006/r2_w0_wl u_t008_006/r2_w1_wl u_t008_006/r2_r0_rwl
+ u_t008_006/r2_r1_rwl u_t008_006/r3_w0_wl u_t008_006/r3_w1_wl u_t008_006/r3_r0_rwl u_t008_006/r3_r1_rwl VDD VSS VSUBS
+ detronyx_12t_2w2r_rc4_4x4_routed_5layer_direct
Xu_t023_009 u_t023_009/c0_w0_bl u_t023_009/c0_w0_br u_t023_009/c0_w1_bl u_t023_009/c0_w1_br u_t023_009/c0_r0_rbl
+ u_t023_009/c0_r1_rbl u_t023_009/c1_w0_bl u_t023_009/c1_w0_br u_t023_009/c1_w1_bl u_t023_009/c1_w1_br
+ u_t023_009/c1_r0_rbl u_t023_009/c1_r1_rbl u_t023_009/c2_w0_bl u_t023_009/c2_w0_br u_t023_009/c2_w1_bl
+ u_t023_009/c2_w1_br u_t023_009/c2_r0_rbl u_t023_009/c2_r1_rbl u_t023_009/c3_w0_bl u_t023_009/c3_w0_br
+ u_t023_009/c3_w1_bl u_t023_009/c3_w1_br u_t023_009/c3_r0_rbl u_t023_009/c3_r1_rbl u_t023_009/r0_w0_wl
+ u_t023_009/r0_w1_wl u_t023_009/r0_r0_rwl u_t023_009/r0_r1_rwl u_t023_009/r1_w0_wl u_t023_009/r1_w1_wl
+ u_t023_009/r1_r0_rwl u_t023_009/r1_r1_rwl u_t023_009/r2_w0_wl u_t023_009/r2_w1_wl u_t023_009/r2_r0_rwl
+ u_t023_009/r2_r1_rwl u_t023_009/r3_w0_wl u_t023_009/r3_w1_wl u_t023_009/r3_r0_rwl u_t023_009/r3_r1_rwl VDD VSS VSUBS
+ detronyx_12t_2w2r_rc4_4x4_routed_5layer_direct
Xu_t014_009 u_t014_009/c0_w0_bl u_t014_009/c0_w0_br u_t014_009/c0_w1_bl u_t014_009/c0_w1_br u_t014_009/c0_r0_rbl
+ u_t014_009/c0_r1_rbl u_t014_009/c1_w0_bl u_t014_009/c1_w0_br u_t014_009/c1_w1_bl u_t014_009/c1_w1_br
+ u_t014_009/c1_r0_rbl u_t014_009/c1_r1_rbl u_t014_009/c2_w0_bl u_t014_009/c2_w0_br u_t014_009/c2_w1_bl
+ u_t014_009/c2_w1_br u_t014_009/c2_r0_rbl u_t014_009/c2_r1_rbl u_t014_009/c3_w0_bl u_t014_009/c3_w0_br
+ u_t014_009/c3_w1_bl u_t014_009/c3_w1_br u_t014_009/c3_r0_rbl u_t014_009/c3_r1_rbl u_t014_009/r0_w0_wl
+ u_t014_009/r0_w1_wl u_t014_009/r0_r0_rwl u_t014_009/r0_r1_rwl u_t014_009/r1_w0_wl u_t014_009/r1_w1_wl
+ u_t014_009/r1_r0_rwl u_t014_009/r1_r1_rwl u_t014_009/r2_w0_wl u_t014_009/r2_w1_wl u_t014_009/r2_r0_rwl
+ u_t014_009/r2_r1_rwl u_t014_009/r3_w0_wl u_t014_009/r3_w1_wl u_t014_009/r3_r0_rwl u_t014_009/r3_r1_rwl VDD VSS VSUBS
+ detronyx_12t_2w2r_rc4_4x4_routed_5layer_direct
Xu_t005_009 u_t005_009/c0_w0_bl u_t005_009/c0_w0_br u_t005_009/c0_w1_bl u_t005_009/c0_w1_br u_t005_009/c0_r0_rbl
+ u_t005_009/c0_r1_rbl u_t005_009/c1_w0_bl u_t005_009/c1_w0_br u_t005_009/c1_w1_bl u_t005_009/c1_w1_br
+ u_t005_009/c1_r0_rbl u_t005_009/c1_r1_rbl u_t005_009/c2_w0_bl u_t005_009/c2_w0_br u_t005_009/c2_w1_bl
+ u_t005_009/c2_w1_br u_t005_009/c2_r0_rbl u_t005_009/c2_r1_rbl u_t005_009/c3_w0_bl u_t005_009/c3_w0_br
+ u_t005_009/c3_w1_bl u_t005_009/c3_w1_br u_t005_009/c3_r0_rbl u_t005_009/c3_r1_rbl u_t005_009/r0_w0_wl
+ u_t005_009/r0_w1_wl u_t005_009/r0_r0_rwl u_t005_009/r0_r1_rwl u_t005_009/r1_w0_wl u_t005_009/r1_w1_wl
+ u_t005_009/r1_r0_rwl u_t005_009/r1_r1_rwl u_t005_009/r2_w0_wl u_t005_009/r2_w1_wl u_t005_009/r2_r0_rwl
+ u_t005_009/r2_r1_rwl u_t005_009/r3_w0_wl u_t005_009/r3_w1_wl u_t005_009/r3_r0_rwl u_t005_009/r3_r1_rwl VDD VSS VSUBS
+ detronyx_12t_2w2r_rc4_4x4_routed_5layer_direct
Xu_t010_001 u_t010_001/c0_w0_bl u_t010_001/c0_w0_br u_t010_001/c0_w1_bl u_t010_001/c0_w1_br u_t010_001/c0_r0_rbl
+ u_t010_001/c0_r1_rbl u_t010_001/c1_w0_bl u_t010_001/c1_w0_br u_t010_001/c1_w1_bl u_t010_001/c1_w1_br
+ u_t010_001/c1_r0_rbl u_t010_001/c1_r1_rbl u_t010_001/c2_w0_bl u_t010_001/c2_w0_br u_t010_001/c2_w1_bl
+ u_t010_001/c2_w1_br u_t010_001/c2_r0_rbl u_t010_001/c2_r1_rbl u_t010_001/c3_w0_bl u_t010_001/c3_w0_br
+ u_t010_001/c3_w1_bl u_t010_001/c3_w1_br u_t010_001/c3_r0_rbl u_t010_001/c3_r1_rbl u_t010_001/r0_w0_wl
+ u_t010_001/r0_w1_wl u_t010_001/r0_r0_rwl u_t010_001/r0_r1_rwl u_t010_001/r1_w0_wl u_t010_001/r1_w1_wl
+ u_t010_001/r1_r0_rwl u_t010_001/r1_r1_rwl u_t010_001/r2_w0_wl u_t010_001/r2_w1_wl u_t010_001/r2_r0_rwl
+ u_t010_001/r2_r1_rwl u_t010_001/r3_w0_wl u_t010_001/r3_w1_wl u_t010_001/r3_r0_rwl u_t010_001/r3_r1_rwl VDD VSS VSUBS
+ detronyx_12t_2w2r_rc4_4x4_routed_5layer_direct
Xu_t010_012 u_t010_012/c0_w0_bl u_t010_012/c0_w0_br u_t010_012/c0_w1_bl u_t010_012/c0_w1_br u_t010_012/c0_r0_rbl
+ u_t010_012/c0_r1_rbl u_t010_012/c1_w0_bl u_t010_012/c1_w0_br u_t010_012/c1_w1_bl u_t010_012/c1_w1_br
+ u_t010_012/c1_r0_rbl u_t010_012/c1_r1_rbl u_t010_012/c2_w0_bl u_t010_012/c2_w0_br u_t010_012/c2_w1_bl
+ u_t010_012/c2_w1_br u_t010_012/c2_r0_rbl u_t010_012/c2_r1_rbl u_t010_012/c3_w0_bl u_t010_012/c3_w0_br
+ u_t010_012/c3_w1_bl u_t010_012/c3_w1_br u_t010_012/c3_r0_rbl u_t010_012/c3_r1_rbl u_t010_012/r0_w0_wl
+ u_t010_012/r0_w1_wl u_t010_012/r0_r0_rwl u_t010_012/r0_r1_rwl u_t010_012/r1_w0_wl u_t010_012/r1_w1_wl
+ u_t010_012/r1_r0_rwl u_t010_012/r1_r1_rwl u_t010_012/r2_w0_wl u_t010_012/r2_w1_wl u_t010_012/r2_r0_rwl
+ u_t010_012/r2_r1_rwl u_t010_012/r3_w0_wl u_t010_012/r3_w1_wl u_t010_012/r3_r0_rwl u_t010_012/r3_r1_rwl VDD VSS VSUBS
+ detronyx_12t_2w2r_rc4_4x4_routed_5layer_direct
Xu_t001_012 u_t001_012/c0_w0_bl u_t001_012/c0_w0_br u_t001_012/c0_w1_bl u_t001_012/c0_w1_br u_t001_012/c0_r0_rbl
+ u_t001_012/c0_r1_rbl u_t001_012/c1_w0_bl u_t001_012/c1_w0_br u_t001_012/c1_w1_bl u_t001_012/c1_w1_br
+ u_t001_012/c1_r0_rbl u_t001_012/c1_r1_rbl u_t001_012/c2_w0_bl u_t001_012/c2_w0_br u_t001_012/c2_w1_bl
+ u_t001_012/c2_w1_br u_t001_012/c2_r0_rbl u_t001_012/c2_r1_rbl u_t001_012/c3_w0_bl u_t001_012/c3_w0_br
+ u_t001_012/c3_w1_bl u_t001_012/c3_w1_br u_t001_012/c3_r0_rbl u_t001_012/c3_r1_rbl u_t001_012/r0_w0_wl
+ u_t001_012/r0_w1_wl u_t001_012/r0_r0_rwl u_t001_012/r0_r1_rwl u_t001_012/r1_w0_wl u_t001_012/r1_w1_wl
+ u_t001_012/r1_r0_rwl u_t001_012/r1_r1_rwl u_t001_012/r2_w0_wl u_t001_012/r2_w1_wl u_t001_012/r2_r0_rwl
+ u_t001_012/r2_r1_rwl u_t001_012/r3_w0_wl u_t001_012/r3_w1_wl u_t001_012/r3_r0_rwl u_t001_012/r3_r1_rwl VDD VSS VSUBS
+ detronyx_12t_2w2r_rc4_4x4_routed_5layer_direct
Xu_t001_001 u_t001_001/c0_w0_bl u_t001_001/c0_w0_br u_t001_001/c0_w1_bl u_t001_001/c0_w1_br u_t001_001/c0_r0_rbl
+ u_t001_001/c0_r1_rbl u_t001_001/c1_w0_bl u_t001_001/c1_w0_br u_t001_001/c1_w1_bl u_t001_001/c1_w1_br
+ u_t001_001/c1_r0_rbl u_t001_001/c1_r1_rbl u_t001_001/c2_w0_bl u_t001_001/c2_w0_br u_t001_001/c2_w1_bl
+ u_t001_001/c2_w1_br u_t001_001/c2_r0_rbl u_t001_001/c2_r1_rbl u_t001_001/c3_w0_bl u_t001_001/c3_w0_br
+ u_t001_001/c3_w1_bl u_t001_001/c3_w1_br u_t001_001/c3_r0_rbl u_t001_001/c3_r1_rbl u_t001_001/r0_w0_wl
+ u_t001_001/r0_w1_wl u_t001_001/r0_r0_rwl u_t001_001/r0_r1_rwl u_t001_001/r1_w0_wl u_t001_001/r1_w1_wl
+ u_t001_001/r1_r0_rwl u_t001_001/r1_r1_rwl u_t001_001/r2_w0_wl u_t001_001/r2_w1_wl u_t001_001/r2_r0_rwl
+ u_t001_001/r2_r1_rwl u_t001_001/r3_w0_wl u_t001_001/r3_w1_wl u_t001_001/r3_r0_rwl u_t001_001/r3_r1_rwl VDD VSS VSUBS
+ detronyx_12t_2w2r_rc4_4x4_routed_5layer_direct
.ends gf180mcu_3v3_12t_2r2w_sram_1024x8
