* Array-only 12T 2W2R SRAM macro blackbox. Periphery is not included yet.
.subckt gf180mcu_3v3_12t_2r2w_sram_1024x8 clk w0_en w1_en r0_en r1_en w0_addr[0] w0_addr[1] w0_addr[2] w0_addr[3] w0_addr[4] w0_addr[5] w0_addr[6] w0_addr[7] w0_addr[8] w0_addr[9] w1_addr[0] w1_addr[1] w1_addr[2] w1_addr[3] w1_addr[4] w1_addr[5] w1_addr[6] w1_addr[7] w1_addr[8] w1_addr[9] r0_addr[0] r0_addr[1] r0_addr[2] r0_addr[3] r0_addr[4] r0_addr[5] r0_addr[6] r0_addr[7] r0_addr[8] r0_addr[9] r1_addr[0] r1_addr[1] r1_addr[2] r1_addr[3] r1_addr[4] r1_addr[5] r1_addr[6] r1_addr[7] r1_addr[8] r1_addr[9] w0_data[0] w0_data[1] w0_data[2] w0_data[3] w0_data[4] w0_data[5] w0_data[6] w0_data[7] w1_data[0] w1_data[1] w1_data[2] w1_data[3] w1_data[4] w1_data[5] w1_data[6] w1_data[7] r0_data[0] r0_data[1] r0_data[2] r0_data[3] r0_data[4] r0_data[5] r0_data[6] r0_data[7] r1_data[0] r1_data[1] r1_data[2] r1_data[3] r1_data[4] r1_data[5] r1_data[6] r1_data[7] VDD VSS
.ends gf180mcu_3v3_12t_2r2w_sram_1024x8
