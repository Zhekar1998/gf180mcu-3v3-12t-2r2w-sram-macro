* Array-only 12T 2W2R SRAM macro blackbox. Periphery is not included yet.
.subckt gf180mcu_3v3_12t_2r2w_sram_512x32 clk w0_en w1_en r0_en r1_en w0_addr[0] w0_addr[1] w0_addr[2] w0_addr[3] w0_addr[4] w0_addr[5] w0_addr[6] w0_addr[7] w0_addr[8] w1_addr[0] w1_addr[1] w1_addr[2] w1_addr[3] w1_addr[4] w1_addr[5] w1_addr[6] w1_addr[7] w1_addr[8] r0_addr[0] r0_addr[1] r0_addr[2] r0_addr[3] r0_addr[4] r0_addr[5] r0_addr[6] r0_addr[7] r0_addr[8] r1_addr[0] r1_addr[1] r1_addr[2] r1_addr[3] r1_addr[4] r1_addr[5] r1_addr[6] r1_addr[7] r1_addr[8] w0_data[0] w0_data[1] w0_data[2] w0_data[3] w0_data[4] w0_data[5] w0_data[6] w0_data[7] w0_data[8] w0_data[9] w0_data[10] w0_data[11] w0_data[12] w0_data[13] w0_data[14] w0_data[15] w0_data[16] w0_data[17] w0_data[18] w0_data[19] w0_data[20] w0_data[21] w0_data[22] w0_data[23] w0_data[24] w0_data[25] w0_data[26] w0_data[27] w0_data[28] w0_data[29] w0_data[30] w0_data[31] w1_data[0] w1_data[1] w1_data[2] w1_data[3] w1_data[4] w1_data[5] w1_data[6] w1_data[7] w1_data[8] w1_data[9] w1_data[10] w1_data[11] w1_data[12] w1_data[13] w1_data[14] w1_data[15] w1_data[16] w1_data[17] w1_data[18] w1_data[19] w1_data[20] w1_data[21] w1_data[22] w1_data[23] w1_data[24] w1_data[25] w1_data[26] w1_data[27] w1_data[28] w1_data[29] w1_data[30] w1_data[31] r0_data[0] r0_data[1] r0_data[2] r0_data[3] r0_data[4] r0_data[5] r0_data[6] r0_data[7] r0_data[8] r0_data[9] r0_data[10] r0_data[11] r0_data[12] r0_data[13] r0_data[14] r0_data[15] r0_data[16] r0_data[17] r0_data[18] r0_data[19] r0_data[20] r0_data[21] r0_data[22] r0_data[23] r0_data[24] r0_data[25] r0_data[26] r0_data[27] r0_data[28] r0_data[29] r0_data[30] r0_data[31] r1_data[0] r1_data[1] r1_data[2] r1_data[3] r1_data[4] r1_data[5] r1_data[6] r1_data[7] r1_data[8] r1_data[9] r1_data[10] r1_data[11] r1_data[12] r1_data[13] r1_data[14] r1_data[15] r1_data[16] r1_data[17] r1_data[18] r1_data[19] r1_data[20] r1_data[21] r1_data[22] r1_data[23] r1_data[24] r1_data[25] r1_data[26] r1_data[27] r1_data[28] r1_data[29] r1_data[30] r1_data[31] VDD VSS
.ends gf180mcu_3v3_12t_2r2w_sram_512x32
