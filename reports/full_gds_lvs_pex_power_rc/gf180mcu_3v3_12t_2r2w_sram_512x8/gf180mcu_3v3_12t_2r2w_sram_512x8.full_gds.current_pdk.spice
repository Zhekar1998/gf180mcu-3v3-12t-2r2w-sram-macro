* NGSPICE file created from gf180mcu_3v3_12t_2r2w_sram_512x8.ext - technology: gf180mcuD

.subckt detronyx_12t_write_driver_rc1 VDD VSS din wen wbl0 wbr0
X0 VDD a_240_2348# a_326_9670# VDD pfet_03v3 ad=0.1232p pd=1u as=0.1232p ps=1u w=0.56u l=0.28u
X1 VSS wen a_988_2348# VSS nfet_03v3 ad=0.4642p pd=2.99u as=0.4642p ps=2.99u w=1.055u l=0.28u
X2 VDD wen a_326_9670# VDD pfet_03v3 ad=0.1232p pd=1u as=0.1232p ps=1u w=0.56u l=0.28u
X3 VSS a_844_5266# a_328_6681# VSS nfet_03v3 ad=0.4642p pd=2.99u as=0.4642p ps=2.99u w=1.055u l=0.28u
X4 VSS wen a_240_3807# VSS nfet_03v3 ad=0.4642p pd=2.99u as=0.4642p ps=2.99u w=1.055u l=0.28u
X5 VDD wen a_326_11114# VDD pfet_03v3 ad=0.1232p pd=1u as=0.1232p ps=1u w=0.56u l=0.28u
X6 VDD wen a_844_2348# VDD pfet_03v3 ad=0.1232p pd=1u as=0.1232p ps=1u w=0.56u l=0.28u
X7 a_240_3807# a_240_2348# a_326_9670# VSS nfet_03v3 ad=0.4642p pd=2.99u as=0.4642p ps=2.99u w=1.055u l=0.28u
X8 VDD din a_844_5266# VDD pfet_03v3 ad=0.1232p pd=1u as=0.1232p ps=1u w=0.56u l=0.28u
X9 VDD wen a_844_5266# VDD pfet_03v3 ad=0.1232p pd=1u as=0.1232p ps=1u w=0.56u l=0.28u
X10 VDD a_240_2348# a_326_11114# VDD pfet_03v3 ad=0.1232p pd=1u as=0.1232p ps=1u w=0.56u l=0.28u
X11 VDD a_844_2348# wbl0 VDD pfet_03v3 ad=0.1232p pd=1u as=0.1232p ps=1u w=0.56u l=0.28u
X12 VDD a_844_5266# a_328_6681# VDD pfet_03v3 ad=0.1232p pd=1u as=0.1232p ps=1u w=0.56u l=0.28u
X13 VSS a_844_3807# wbl0 VSS nfet_03v3 ad=0.4642p pd=2.99u as=0.4642p ps=2.99u w=1.055u l=0.28u
X14 VDD din a_844_2348# VDD pfet_03v3 ad=0.1232p pd=1u as=0.1232p ps=1u w=0.56u l=0.28u
X15 a_988_5266# din a_844_5266# VSS nfet_03v3 ad=0.4642p pd=2.99u as=0.4642p ps=2.99u w=1.055u l=0.28u
X16 a_240_5266# a_240_2348# a_326_11114# VSS nfet_03v3 ad=0.4642p pd=2.99u as=0.4642p ps=2.99u w=1.055u l=0.28u
X17 VDD a_326_9670# a_844_3807# VDD pfet_03v3 ad=0.1232p pd=1u as=0.1232p ps=1u w=0.56u l=0.28u
X18 a_988_2348# din a_844_2348# VSS nfet_03v3 ad=0.4642p pd=2.99u as=0.4642p ps=2.99u w=1.055u l=0.28u
X19 VSS wen a_240_5266# VSS nfet_03v3 ad=0.4642p pd=2.99u as=0.4642p ps=2.99u w=1.055u l=0.28u
X20 VSS din a_240_2348# VSS nfet_03v3 ad=0.4642p pd=2.99u as=0.4642p ps=2.99u w=1.055u l=0.28u
X21 VSS a_326_9670# a_844_3807# VSS nfet_03v3 ad=0.4642p pd=2.99u as=0.4642p ps=2.99u w=1.055u l=0.28u
X22 VDD din a_240_2348# VDD pfet_03v3 ad=0.1232p pd=1u as=0.1232p ps=1u w=0.56u l=0.28u
X23 VSS wen a_988_5266# VSS nfet_03v3 ad=0.4642p pd=2.99u as=0.4642p ps=2.99u w=1.055u l=0.28u
X24 VDD a_326_11114# wbr0 VDD pfet_03v3 ad=0.1232p pd=1u as=0.1232p ps=1u w=0.56u l=0.28u
X25 VSS a_328_6681# wbr0 VSS nfet_03v3 ad=0.4642p pd=2.99u as=0.4642p ps=2.99u w=1.055u l=0.28u
.ends

.subckt detronyx_12t_precharge_sense_rc1 VDD VSS pchgb ren rbl0 dout
X0 VDD rbl0 a_240_2172# VDD pfet_03v3 ad=0.1232p pd=1u as=0.1232p ps=1u w=0.56u l=0.28u
X1 VSS a_240_2172# a_672_2172# VSS nfet_03v3 ad=0.4642p pd=2.99u as=0.4642p ps=2.99u w=1.055u l=0.28u
X2 VSS rbl0 a_240_2172# VSS nfet_03v3 ad=0.4642p pd=2.99u as=0.4642p ps=2.99u w=1.055u l=0.28u
X3 VDD pchgb rbl0 VDD pfet_03v3 ad=0.1232p pd=1u as=0.1232p ps=1u w=0.56u l=0.28u
X4 VDD a_672_2172# dout VDD pfet_03v3 ad=0.1232p pd=1u as=0.1232p ps=1u w=0.56u l=0.28u
X5 VSS a_672_2172# dout VSS nfet_03v3 ad=0.4642p pd=2.99u as=0.4642p ps=2.99u w=1.055u l=0.28u
X6 VDD a_240_2172# a_672_2172# VDD pfet_03v3 ad=0.1232p pd=1u as=0.1232p ps=1u w=0.56u l=0.28u
.ends

.subckt gf180mcu_as_sc_mcu7t3v3__inv_2 VDD VSS Y A VNW VPW
X0 VDD A Y VNW pfet_03v3 ad=0.6072p pd=3.64u as=0.3588p ps=1.9u w=1.38u l=0.28u
X1 Y A VSS VPW nfet_03v3 ad=0.26p pd=1.52u as=0.44p ps=2.88u w=1u l=0.28u
X2 Y A VDD VNW pfet_03v3 ad=0.3588p pd=1.9u as=0.6072p ps=3.64u w=1.38u l=0.28u
X3 VSS A Y VPW nfet_03v3 ad=0.44p pd=2.88u as=0.26p ps=1.52u w=1u l=0.28u
.ends

.subckt gf180mcu_as_sc_mcu7t3v3__nand4_2 VDD VSS A B C D Y VNW VPW
X0 VDD A Y VNW pfet_03v3 ad=0.3588p pd=1.9u as=0.3588p ps=1.9u w=1.38u l=0.28u
X1 Y D a_796_68# VPW nfet_03v3 ad=0.26p pd=1.52u as=0.26p ps=1.52u w=1u l=0.28u
X2 VSS A a_28_68# VPW nfet_03v3 ad=0.26p pd=1.52u as=0.44p ps=2.88u w=1u l=0.28u
X3 VDD C Y VNW pfet_03v3 ad=0.3588p pd=1.9u as=0.3588p ps=1.9u w=1.38u l=0.28u
X4 a_796_68# C a_492_68# VPW nfet_03v3 ad=0.26p pd=1.52u as=0.26p ps=1.52u w=1u l=0.28u
X5 Y B VDD VNW pfet_03v3 ad=0.3588p pd=1.9u as=0.3588p ps=1.9u w=1.38u l=0.28u
X6 a_28_68# B a_492_68# VPW nfet_03v3 ad=0.44p pd=2.88u as=0.26p ps=1.52u w=1u l=0.28u
X7 Y D VDD VNW pfet_03v3 ad=0.3588p pd=1.9u as=0.3588p ps=1.9u w=1.38u l=0.28u
X8 VDD B Y VNW pfet_03v3 ad=0.8004p pd=2.54u as=0.3588p ps=1.9u w=1.38u l=0.28u
X9 Y C VDD VNW pfet_03v3 ad=0.3588p pd=1.9u as=0.8004p ps=2.54u w=1.38u l=0.28u
X10 a_492_68# C a_796_68# VPW nfet_03v3 ad=0.26p pd=1.52u as=0.44p ps=2.88u w=1u l=0.28u
X11 a_492_68# B a_28_68# VPW nfet_03v3 ad=0.26p pd=1.52u as=0.26p ps=1.52u w=1u l=0.28u
X12 VDD D Y VNW pfet_03v3 ad=0.6348p pd=3.68u as=0.3588p ps=1.9u w=1.38u l=0.28u
X13 Y A VDD VNW pfet_03v3 ad=0.3588p pd=1.9u as=0.6072p ps=3.64u w=1.38u l=0.28u
X14 a_796_68# D Y VPW nfet_03v3 ad=0.46p pd=2.92u as=0.26p ps=1.52u w=1u l=0.28u
X15 a_28_68# A VSS VPW nfet_03v3 ad=0.26p pd=1.52u as=0.26p ps=1.52u w=1u l=0.28u
.ends

.subckt detronyx_12t_2w2r_rc4_4x4_routed_5layer_direct c0_w0_bl c0_w0_br c0_w1_bl
+ c0_w1_br c0_r0_rbl c0_r1_rbl c1_w0_bl c1_w0_br c1_w1_bl c1_w1_br c1_r0_rbl c1_r1_rbl
+ c2_w0_bl c2_w0_br c2_w1_bl c2_w1_br c2_r0_rbl c2_r1_rbl c3_w0_bl c3_w0_br c3_w1_bl
+ c3_w1_br c3_r0_rbl c3_r1_rbl r0_w0_wl r0_w1_wl r0_r0_rwl r0_r1_rwl r1_w0_wl r1_w1_wl
+ r1_r0_rwl r1_r1_rwl r2_w0_wl r2_w1_wl r2_r0_rwl r2_r1_rwl r3_w0_wl r3_w1_wl r3_r0_rwl
+ r3_r1_rwl VDD VSS VSUBS
X0 a_684_1814# a_484_1742# a_680_1660# VSUBS nfet_03v3 ad=0.1288p pd=1.48u as=0.1208p ps=1.42u w=0.28u l=0.36u
X1 a_1365_936# a_1283_888# a_1421_1243# w_1283_1162# pfet_03v3 ad=0.1238p pd=1.44u as=0.3061p ps=2.445u w=0.28u l=0.28u
X2 a_2215_1938# a_2159_1894# a_2071_1938# VSUBS nfet_03v3 ad=0.1378p pd=1.05u as=0.2332p ps=1.94u w=0.53u l=0.28u
X3 a_82_1708# a_484_2028# a_532_1946# VSUBS nfet_03v3 ad=0.1288p pd=1.48u as=0.1208p ps=1.42u w=0.28u l=0.36u
X4 a_2648_1708# a_2566_1660# a_2704_1752# VSUBS nfet_03v3 ad=0.3133p pd=2.64u as=0.342p ps=2.21u w=0.45u l=0.28u
X5 a_3658_932# a_3602_888# a_3498_932# VSUBS nfet_03v3 ad=0.23585p pd=1.95u as=0.1378p ps=1.05u w=0.53u l=0.28u
X6 a_932_1938# a_876_1894# a_788_1938# VSUBS nfet_03v3 ad=0.1378p pd=1.05u as=0.2332p ps=1.94u w=0.53u l=0.28u
X7 a_3250_2100# a_3050_2028# a_3246_1946# VSUBS nfet_03v3 ad=0.1288p pd=1.48u as=0.1208p ps=1.42u w=0.28u l=0.36u
X8 a_2375_160# a_2319_116# a_2215_160# VSUBS nfet_03v3 ad=0.23585p pd=1.95u as=0.1378p ps=1.05u w=0.53u l=0.28u
X9 a_1365_936# a_1283_888# a_1421_980# VSUBS nfet_03v3 ad=0.3133p pd=2.64u as=0.342p ps=2.21u w=0.45u l=0.28u
X10 a_4533_2100# a_4333_2028# a_4529_1946# VSUBS nfet_03v3 ad=0.1288p pd=1.48u as=0.1208p ps=1.42u w=0.28u l=0.36u
X11 a_82_164# a_0_116# a_138_471# w_0_390# pfet_03v3 ad=0.1238p pd=1.44u as=0.3061p ps=2.445u w=0.28u l=0.28u
X12 a_82_936# a_484_970# a_532_888# VSUBS nfet_03v3 ad=0.1288p pd=1.48u as=0.1208p ps=1.42u w=0.28u l=0.36u
X13 a_3931_1708# a_3849_1660# a_3987_2015# w_3849_1934# pfet_03v3 ad=0.1238p pd=1.44u as=0.3061p ps=2.445u w=0.28u l=0.28u
X14 a_1967_1042# a_1767_970# a_1963_888# VSUBS nfet_03v3 ad=0.1288p pd=1.48u as=0.1208p ps=1.42u w=0.28u l=0.36u
X15 a_1421_2787# a_1365_2480# a_1283_2432# w_1283_2706# pfet_03v3 ad=0.3061p pd=2.445u as=0.1238p ps=1.44u w=0.28u l=0.28u
X16 a_1365_2480# a_1767_2514# a_1815_2432# VSUBS nfet_03v3 ad=0.1288p pd=1.48u as=0.1208p ps=1.42u w=0.28u l=0.36u
X17 a_2704_2787# a_2648_2480# a_2566_2432# w_2566_2706# pfet_03v3 ad=0.3061p pd=2.445u as=0.1238p ps=1.44u w=0.28u l=0.28u
X18 a_138_2787# a_82_2480# a_0_2432# w_0_2706# pfet_03v3 ad=0.3061p pd=2.445u as=0.1238p ps=1.44u w=0.28u l=0.28u
X19 a_2648_936# a_3050_1256# a_3098_1174# VSUBS nfet_03v3 ad=0.1288p pd=1.48u as=0.1208p ps=1.42u w=0.28u l=0.36u
X20 a_1365_2480# a_1767_2800# a_1815_2718# VSUBS nfet_03v3 ad=0.1288p pd=1.48u as=0.1208p ps=1.42u w=0.28u l=0.36u
X21 a_2704_980# a_2648_936# a_2566_888# VSUBS nfet_03v3 ad=0.342p pd=2.21u as=0.3133p ps=2.64u w=0.45u l=0.28u
X22 a_82_1708# a_0_1660# a_138_1752# VSUBS nfet_03v3 ad=0.3133p pd=2.64u as=0.342p ps=2.21u w=0.45u l=0.28u
X23 a_3931_164# a_4333_198# a_4381_116# VSUBS nfet_03v3 ad=0.1288p pd=1.48u as=0.1208p ps=1.42u w=0.28u l=0.36u
X24 a_1092_160# a_1036_116# a_932_160# VSUBS nfet_03v3 ad=0.23585p pd=1.95u as=0.1378p ps=1.05u w=0.53u l=0.28u
X25 a_82_164# a_0_116# a_138_208# VSUBS nfet_03v3 ad=0.3133p pd=2.64u as=0.342p ps=2.21u w=0.45u l=0.28u
X26 a_4941_932# a_4885_1122# a_4781_1166# VSUBS nfet_03v3 ad=0.23585p pd=1.95u as=0.1378p ps=1.05u w=0.53u l=0.28u
X27 a_3931_164# a_4333_484# a_4381_402# VSUBS nfet_03v3 ad=0.1288p pd=1.48u as=0.1208p ps=1.42u w=0.28u l=0.36u
X28 a_2648_164# a_2566_116# a_2704_471# w_2566_390# pfet_03v3 ad=0.1238p pd=1.44u as=0.3061p ps=2.445u w=0.28u l=0.28u
X29 a_3498_1166# a_3442_1122# a_3354_1166# VSUBS nfet_03v3 ad=0.1378p pd=1.05u as=0.2332p ps=1.94u w=0.53u l=0.28u
X30 a_4533_270# a_4333_198# a_4529_116# VSUBS nfet_03v3 ad=0.1288p pd=1.48u as=0.1208p ps=1.42u w=0.28u l=0.36u
X31 a_2375_932# a_2319_888# a_2215_932# VSUBS nfet_03v3 ad=0.23585p pd=1.95u as=0.1378p ps=1.05u w=0.53u l=0.28u
X32 a_4781_1166# a_4725_1122# a_4637_1166# VSUBS nfet_03v3 ad=0.1378p pd=1.05u as=0.2332p ps=1.94u w=0.53u l=0.28u
X33 a_3658_1704# a_3602_1660# a_3498_1704# VSUBS nfet_03v3 ad=0.23585p pd=1.95u as=0.1378p ps=1.05u w=0.53u l=0.28u
X34 a_684_2586# a_484_2514# a_680_2432# VSUBS nfet_03v3 ad=0.1288p pd=1.48u as=0.1208p ps=1.42u w=0.28u l=0.36u
X35 a_1365_1708# a_1283_1660# a_1421_2015# w_1283_1934# pfet_03v3 ad=0.1238p pd=1.44u as=0.3061p ps=2.445u w=0.28u l=0.28u
X36 a_4533_556# a_4333_484# a_4529_402# VSUBS nfet_03v3 ad=0.1288p pd=1.48u as=0.1208p ps=1.42u w=0.28u l=0.36u
X37 a_1092_2476# a_1036_2666# a_932_2710# VSUBS nfet_03v3 ad=0.23585p pd=1.95u as=0.1378p ps=1.05u w=0.53u l=0.28u
X38 a_2215_1704# a_2159_1660# a_2071_1704# VSUBS nfet_03v3 ad=0.1378p pd=1.05u as=0.2332p ps=1.94u w=0.53u l=0.28u
X39 a_3987_471# a_3931_164# a_3849_116# w_3849_390# pfet_03v3 ad=0.3061p pd=2.445u as=0.1238p ps=1.44u w=0.28u l=0.28u
X40 a_4781_394# a_4725_350# a_4637_394# VSUBS nfet_03v3 ad=0.1378p pd=1.05u as=0.2332p ps=1.94u w=0.53u l=0.28u
X41 a_1421_980# a_1365_936# a_1283_888# VSUBS nfet_03v3 ad=0.342p pd=2.21u as=0.3133p ps=2.64u w=0.45u l=0.28u
X42 a_684_2872# a_484_2800# a_680_2718# VSUBS nfet_03v3 ad=0.1288p pd=1.48u as=0.1208p ps=1.42u w=0.28u l=0.36u
X43 a_2375_2476# a_2319_2666# a_2215_2710# VSUBS nfet_03v3 ad=0.23585p pd=1.95u as=0.1378p ps=1.05u w=0.53u l=0.28u
X44 a_2648_2480# a_2566_2432# a_2704_2524# VSUBS nfet_03v3 ad=0.3133p pd=2.64u as=0.342p ps=2.21u w=0.45u l=0.28u
X45 a_932_1704# a_876_1660# a_788_1704# VSUBS nfet_03v3 ad=0.1378p pd=1.05u as=0.2332p ps=1.94u w=0.53u l=0.28u
X46 a_2648_164# a_2566_116# a_2704_208# VSUBS nfet_03v3 ad=0.3133p pd=2.64u as=0.342p ps=2.21u w=0.45u l=0.28u
X47 a_1967_1328# a_1767_1256# a_1963_1174# VSUBS nfet_03v3 ad=0.1288p pd=1.48u as=0.1208p ps=1.42u w=0.28u l=0.36u
X48 a_82_1708# a_484_1742# a_532_1660# VSUBS nfet_03v3 ad=0.1288p pd=1.48u as=0.1208p ps=1.42u w=0.28u l=0.36u
X49 a_3250_1814# a_3050_1742# a_3246_1660# VSUBS nfet_03v3 ad=0.1288p pd=1.48u as=0.1208p ps=1.42u w=0.28u l=0.36u
X50 a_3250_270# a_3050_198# a_3246_116# VSUBS nfet_03v3 ad=0.1288p pd=1.48u as=0.1208p ps=1.42u w=0.28u l=0.36u
X51 a_2648_164# a_3050_198# a_3098_116# VSUBS nfet_03v3 ad=0.1288p pd=1.48u as=0.1208p ps=1.42u w=0.28u l=0.36u
X52 a_1092_932# a_1036_888# a_932_932# VSUBS nfet_03v3 ad=0.23585p pd=1.95u as=0.1378p ps=1.05u w=0.53u l=0.28u
X53 a_4941_1704# a_4885_1894# a_4781_1938# VSUBS nfet_03v3 ad=0.23585p pd=1.95u as=0.1378p ps=1.05u w=0.53u l=0.28u
X54 a_4533_1814# a_4333_1742# a_4529_1660# VSUBS nfet_03v3 ad=0.1288p pd=1.48u as=0.1208p ps=1.42u w=0.28u l=0.36u
X55 a_2648_1708# a_3050_2028# a_3098_1946# VSUBS nfet_03v3 ad=0.1288p pd=1.48u as=0.1208p ps=1.42u w=0.28u l=0.36u
X56 a_3250_556# a_3050_484# a_3246_402# VSUBS nfet_03v3 ad=0.1288p pd=1.48u as=0.1208p ps=1.42u w=0.28u l=0.36u
X57 a_2648_164# a_3050_484# a_3098_402# VSUBS nfet_03v3 ad=0.1288p pd=1.48u as=0.1208p ps=1.42u w=0.28u l=0.36u
X58 a_2648_936# a_2566_888# a_2704_1243# w_2566_1162# pfet_03v3 ad=0.1238p pd=1.44u as=0.3061p ps=2.445u w=0.28u l=0.28u
X59 a_3498_1938# a_3442_1894# a_3354_1938# VSUBS nfet_03v3 ad=0.1378p pd=1.05u as=0.2332p ps=1.94u w=0.53u l=0.28u
X60 a_1365_164# a_1283_116# a_1421_471# w_1283_390# pfet_03v3 ad=0.1238p pd=1.44u as=0.3061p ps=2.445u w=0.28u l=0.28u
X61 a_82_2480# a_0_2432# a_138_2524# VSUBS nfet_03v3 ad=0.3133p pd=2.64u as=0.342p ps=2.21u w=0.45u l=0.28u
X62 a_4781_1938# a_4725_1894# a_4637_1938# VSUBS nfet_03v3 ad=0.1378p pd=1.05u as=0.2332p ps=1.94u w=0.53u l=0.28u
X63 a_3498_394# a_3442_350# a_3354_394# VSUBS nfet_03v3 ad=0.1378p pd=1.05u as=0.2332p ps=1.94u w=0.53u l=0.28u
X64 a_1365_936# a_1767_970# a_1815_888# VSUBS nfet_03v3 ad=0.1288p pd=1.48u as=0.1208p ps=1.42u w=0.28u l=0.36u
X65 a_3987_208# a_3931_164# a_3849_116# VSUBS nfet_03v3 ad=0.342p pd=2.21u as=0.3133p ps=2.64u w=0.45u l=0.28u
X66 a_3931_936# a_3849_888# a_3987_980# VSUBS nfet_03v3 ad=0.3133p pd=2.64u as=0.342p ps=2.21u w=0.45u l=0.28u
X67 a_1421_1752# a_1365_1708# a_1283_1660# VSUBS nfet_03v3 ad=0.342p pd=2.21u as=0.3133p ps=2.64u w=0.45u l=0.28u
X68 a_1092_2476# a_1036_2432# a_932_2476# VSUBS nfet_03v3 ad=0.23585p pd=1.95u as=0.1378p ps=1.05u w=0.53u l=0.28u
X69 a_138_980# a_82_936# a_0_888# VSUBS nfet_03v3 ad=0.342p pd=2.21u as=0.3133p ps=2.64u w=0.45u l=0.28u
X70 a_2375_2476# a_2319_2432# a_2215_2476# VSUBS nfet_03v3 ad=0.23585p pd=1.95u as=0.1378p ps=1.05u w=0.53u l=0.28u
X71 a_2704_1752# a_2648_1708# a_2566_1660# VSUBS nfet_03v3 ad=0.342p pd=2.21u as=0.3133p ps=2.64u w=0.45u l=0.28u
X72 a_2704_471# a_2648_164# a_2566_116# w_2566_390# pfet_03v3 ad=0.3061p pd=2.445u as=0.1238p ps=1.44u w=0.28u l=0.28u
X73 a_138_1752# a_82_1708# a_0_1660# VSUBS nfet_03v3 ad=0.342p pd=2.21u as=0.3133p ps=2.64u w=0.45u l=0.28u
X74 a_3987_2787# a_3931_2480# a_3849_2432# w_3849_2706# pfet_03v3 ad=0.3061p pd=2.445u as=0.1238p ps=1.44u w=0.28u l=0.28u
X75 a_4941_160# a_4885_350# a_4781_394# VSUBS nfet_03v3 ad=0.23585p pd=1.95u as=0.1378p ps=1.05u w=0.53u l=0.28u
X76 a_3931_936# a_4333_1256# a_4381_1174# VSUBS nfet_03v3 ad=0.1288p pd=1.48u as=0.1208p ps=1.42u w=0.28u l=0.36u
X77 a_82_936# a_0_888# a_138_1243# w_0_1162# pfet_03v3 ad=0.1238p pd=1.44u as=0.3061p ps=2.445u w=0.28u l=0.28u
X78 a_1365_164# a_1283_116# a_1421_208# VSUBS nfet_03v3 ad=0.3133p pd=2.64u as=0.342p ps=2.21u w=0.45u l=0.28u
X79 a_4781_160# a_4725_116# a_4637_160# VSUBS nfet_03v3 ad=0.1378p pd=1.05u as=0.2332p ps=1.94u w=0.53u l=0.28u
X80 a_684_270# a_484_198# a_680_116# VSUBS nfet_03v3 ad=0.1288p pd=1.48u as=0.1208p ps=1.42u w=0.28u l=0.36u
X81 a_1421_471# a_1365_164# a_1283_116# w_1283_390# pfet_03v3 ad=0.3061p pd=2.445u as=0.1238p ps=1.44u w=0.28u l=0.28u
X82 a_684_556# a_484_484# a_680_402# VSUBS nfet_03v3 ad=0.1288p pd=1.48u as=0.1208p ps=1.42u w=0.28u l=0.36u
X83 a_3931_2480# a_3849_2432# a_3987_2787# w_3849_2706# pfet_03v3 ad=0.1238p pd=1.44u as=0.3061p ps=2.445u w=0.28u l=0.28u
X84 a_1967_2100# a_1767_2028# a_1963_1946# VSUBS nfet_03v3 ad=0.1288p pd=1.48u as=0.1208p ps=1.42u w=0.28u l=0.36u
X85 a_2215_394# a_2159_350# a_2071_394# VSUBS nfet_03v3 ad=0.1378p pd=1.05u as=0.2332p ps=1.94u w=0.53u l=0.28u
X86 a_82_2480# a_484_2514# a_532_2432# VSUBS nfet_03v3 ad=0.1288p pd=1.48u as=0.1208p ps=1.42u w=0.28u l=0.36u
X87 a_2704_208# a_2648_164# a_2566_116# VSUBS nfet_03v3 ad=0.342p pd=2.21u as=0.3133p ps=2.64u w=0.45u l=0.28u
X88 a_932_394# a_876_350# a_788_394# VSUBS nfet_03v3 ad=0.1378p pd=1.05u as=0.2332p ps=1.94u w=0.53u l=0.28u
X89 a_3250_2586# a_3050_2514# a_3246_2432# VSUBS nfet_03v3 ad=0.1288p pd=1.48u as=0.1208p ps=1.42u w=0.28u l=0.36u
X90 a_4941_1704# a_4885_1660# a_4781_1704# VSUBS nfet_03v3 ad=0.23585p pd=1.95u as=0.1378p ps=1.05u w=0.53u l=0.28u
X91 a_4533_2586# a_4333_2514# a_4529_2432# VSUBS nfet_03v3 ad=0.1288p pd=1.48u as=0.1208p ps=1.42u w=0.28u l=0.36u
X92 a_82_2480# a_484_2800# a_532_2718# VSUBS nfet_03v3 ad=0.1288p pd=1.48u as=0.1208p ps=1.42u w=0.28u l=0.36u
X93 a_2648_1708# a_2566_1660# a_2704_2015# w_2566_1934# pfet_03v3 ad=0.1238p pd=1.44u as=0.3061p ps=2.445u w=0.28u l=0.28u
X94 a_3250_2872# a_3050_2800# a_3246_2718# VSUBS nfet_03v3 ad=0.1288p pd=1.48u as=0.1208p ps=1.42u w=0.28u l=0.36u
X95 a_3498_1704# a_3442_1660# a_3354_1704# VSUBS nfet_03v3 ad=0.1378p pd=1.05u as=0.2332p ps=1.94u w=0.53u l=0.28u
X96 a_3658_2476# a_3602_2666# a_3498_2710# VSUBS nfet_03v3 ad=0.23585p pd=1.95u as=0.1378p ps=1.05u w=0.53u l=0.28u
X97 a_4533_2872# a_4333_2800# a_4529_2718# VSUBS nfet_03v3 ad=0.1288p pd=1.48u as=0.1208p ps=1.42u w=0.28u l=0.36u
X98 a_4781_1704# a_4725_1660# a_4637_1704# VSUBS nfet_03v3 ad=0.1378p pd=1.05u as=0.2332p ps=1.94u w=0.53u l=0.28u
X99 a_3498_160# a_3442_116# a_3354_160# VSUBS nfet_03v3 ad=0.1378p pd=1.05u as=0.2332p ps=1.94u w=0.53u l=0.28u
X100 a_1421_2524# a_1365_2480# a_1283_2432# VSUBS nfet_03v3 ad=0.342p pd=2.21u as=0.3133p ps=2.64u w=0.45u l=0.28u
X101 a_2215_2710# a_2159_2666# a_2071_2710# VSUBS nfet_03v3 ad=0.1378p pd=1.05u as=0.2332p ps=1.94u w=0.53u l=0.28u
X102 a_2648_1708# a_3050_1742# a_3098_1660# VSUBS nfet_03v3 ad=0.1288p pd=1.48u as=0.1208p ps=1.42u w=0.28u l=0.36u
X103 a_1365_936# a_1767_1256# a_1815_1174# VSUBS nfet_03v3 ad=0.1288p pd=1.48u as=0.1208p ps=1.42u w=0.28u l=0.36u
X104 a_2704_2524# a_2648_2480# a_2566_2432# VSUBS nfet_03v3 ad=0.342p pd=2.21u as=0.3133p ps=2.64u w=0.45u l=0.28u
X105 a_932_2710# a_876_2666# a_788_2710# VSUBS nfet_03v3 ad=0.1378p pd=1.05u as=0.2332p ps=1.94u w=0.53u l=0.28u
X106 a_138_2524# a_82_2480# a_0_2432# VSUBS nfet_03v3 ad=0.342p pd=2.21u as=0.3133p ps=2.64u w=0.45u l=0.28u
X107 a_4781_932# a_4725_888# a_4637_932# VSUBS nfet_03v3 ad=0.1378p pd=1.05u as=0.2332p ps=1.94u w=0.53u l=0.28u
X108 a_1421_208# a_1365_164# a_1283_116# VSUBS nfet_03v3 ad=0.342p pd=2.21u as=0.3133p ps=2.64u w=0.45u l=0.28u
X109 a_1421_1243# a_1365_936# a_1283_888# w_1283_1162# pfet_03v3 ad=0.3061p pd=2.445u as=0.1238p ps=1.44u w=0.28u l=0.28u
X110 a_138_471# a_82_164# a_0_116# w_0_390# pfet_03v3 ad=0.3061p pd=2.445u as=0.1238p ps=1.44u w=0.28u l=0.28u
X111 a_2704_1243# a_2648_936# a_2566_888# w_2566_1162# pfet_03v3 ad=0.3061p pd=2.445u as=0.1238p ps=1.44u w=0.28u l=0.28u
X112 a_82_1708# a_0_1660# a_138_2015# w_0_1934# pfet_03v3 ad=0.1238p pd=1.44u as=0.3061p ps=2.445u w=0.28u l=0.28u
X113 a_3931_1708# a_4333_2028# a_4381_1946# VSUBS nfet_03v3 ad=0.1288p pd=1.48u as=0.1208p ps=1.42u w=0.28u l=0.36u
X114 a_4941_160# a_4885_116# a_4781_160# VSUBS nfet_03v3 ad=0.23585p pd=1.95u as=0.1378p ps=1.05u w=0.53u l=0.28u
X115 a_138_1243# a_82_936# a_0_888# w_0_1162# pfet_03v3 ad=0.3061p pd=2.445u as=0.1238p ps=1.44u w=0.28u l=0.28u
X116 a_3931_164# a_3849_116# a_3987_471# w_3849_390# pfet_03v3 ad=0.1238p pd=1.44u as=0.3061p ps=2.445u w=0.28u l=0.28u
X117 a_3931_936# a_4333_970# a_4381_888# VSUBS nfet_03v3 ad=0.1288p pd=1.48u as=0.1208p ps=1.42u w=0.28u l=0.36u
X118 a_1365_2480# a_1283_2432# a_1421_2787# w_1283_2706# pfet_03v3 ad=0.1238p pd=1.44u as=0.3061p ps=2.445u w=0.28u l=0.28u
X119 a_1092_932# a_1036_1122# a_932_1166# VSUBS nfet_03v3 ad=0.23585p pd=1.95u as=0.1378p ps=1.05u w=0.53u l=0.28u
X120 a_3987_1752# a_3931_1708# a_3849_1660# VSUBS nfet_03v3 ad=0.342p pd=2.21u as=0.3133p ps=2.64u w=0.45u l=0.28u
X121 a_4533_1042# a_4333_970# a_4529_888# VSUBS nfet_03v3 ad=0.1288p pd=1.48u as=0.1208p ps=1.42u w=0.28u l=0.36u
X122 a_3658_2476# a_3602_2432# a_3498_2476# VSUBS nfet_03v3 ad=0.23585p pd=1.95u as=0.1378p ps=1.05u w=0.53u l=0.28u
X123 a_2375_932# a_2319_1122# a_2215_1166# VSUBS nfet_03v3 ad=0.23585p pd=1.95u as=0.1378p ps=1.05u w=0.53u l=0.28u
X124 a_684_1328# a_484_1256# a_680_1174# VSUBS nfet_03v3 ad=0.1288p pd=1.48u as=0.1208p ps=1.42u w=0.28u l=0.36u
X125 a_2215_160# a_2159_116# a_2071_160# VSUBS nfet_03v3 ad=0.1378p pd=1.05u as=0.2332p ps=1.94u w=0.53u l=0.28u
X126 a_3498_932# a_3442_888# a_3354_932# VSUBS nfet_03v3 ad=0.1378p pd=1.05u as=0.2332p ps=1.94u w=0.53u l=0.28u
X127 a_2215_2476# a_2159_2432# a_2071_2476# VSUBS nfet_03v3 ad=0.1378p pd=1.05u as=0.2332p ps=1.94u w=0.53u l=0.28u
X128 a_932_160# a_876_116# a_788_160# VSUBS nfet_03v3 ad=0.1378p pd=1.05u as=0.2332p ps=1.94u w=0.53u l=0.28u
X129 a_82_164# a_484_198# a_532_116# VSUBS nfet_03v3 ad=0.1288p pd=1.48u as=0.1208p ps=1.42u w=0.28u l=0.36u
X130 a_932_2476# a_876_2432# a_788_2476# VSUBS nfet_03v3 ad=0.1378p pd=1.05u as=0.2332p ps=1.94u w=0.53u l=0.28u
X131 a_3931_1708# a_3849_1660# a_3987_1752# VSUBS nfet_03v3 ad=0.3133p pd=2.64u as=0.342p ps=2.21u w=0.45u l=0.28u
X132 a_3931_164# a_3849_116# a_3987_208# VSUBS nfet_03v3 ad=0.3133p pd=2.64u as=0.342p ps=2.21u w=0.45u l=0.28u
X133 a_1967_270# a_1767_198# a_1963_116# VSUBS nfet_03v3 ad=0.1288p pd=1.48u as=0.1208p ps=1.42u w=0.28u l=0.36u
X134 a_1967_1814# a_1767_1742# a_1963_1660# VSUBS nfet_03v3 ad=0.1288p pd=1.48u as=0.1208p ps=1.42u w=0.28u l=0.36u
X135 a_82_164# a_484_484# a_532_402# VSUBS nfet_03v3 ad=0.1288p pd=1.48u as=0.1208p ps=1.42u w=0.28u l=0.36u
X136 a_138_208# a_82_164# a_0_116# VSUBS nfet_03v3 ad=0.342p pd=2.21u as=0.3133p ps=2.64u w=0.45u l=0.28u
X137 a_1967_556# a_1767_484# a_1963_402# VSUBS nfet_03v3 ad=0.1288p pd=1.48u as=0.1208p ps=1.42u w=0.28u l=0.36u
X138 a_1365_1708# a_1767_2028# a_1815_1946# VSUBS nfet_03v3 ad=0.1288p pd=1.48u as=0.1208p ps=1.42u w=0.28u l=0.36u
X139 a_4941_932# a_4885_888# a_4781_932# VSUBS nfet_03v3 ad=0.23585p pd=1.95u as=0.1378p ps=1.05u w=0.53u l=0.28u
X140 a_2648_2480# a_3050_2514# a_3098_2432# VSUBS nfet_03v3 ad=0.1288p pd=1.48u as=0.1208p ps=1.42u w=0.28u l=0.36u
X141 a_3250_1042# a_3050_970# a_3246_888# VSUBS nfet_03v3 ad=0.1288p pd=1.48u as=0.1208p ps=1.42u w=0.28u l=0.36u
X142 a_2648_936# a_3050_970# a_3098_888# VSUBS nfet_03v3 ad=0.1288p pd=1.48u as=0.1208p ps=1.42u w=0.28u l=0.36u
X143 a_2648_2480# a_3050_2800# a_3098_2718# VSUBS nfet_03v3 ad=0.1288p pd=1.48u as=0.1208p ps=1.42u w=0.28u l=0.36u
X144 a_1421_2015# a_1365_1708# a_1283_1660# w_1283_1934# pfet_03v3 ad=0.3061p pd=2.445u as=0.1238p ps=1.44u w=0.28u l=0.28u
X145 a_1092_1704# a_1036_1894# a_932_1938# VSUBS nfet_03v3 ad=0.23585p pd=1.95u as=0.1378p ps=1.05u w=0.53u l=0.28u
X146 a_3658_160# a_3602_350# a_3498_394# VSUBS nfet_03v3 ad=0.23585p pd=1.95u as=0.1378p ps=1.05u w=0.53u l=0.28u
X147 a_2375_1704# a_2319_1894# a_2215_1938# VSUBS nfet_03v3 ad=0.23585p pd=1.95u as=0.1378p ps=1.05u w=0.53u l=0.28u
X148 a_2704_2015# a_2648_1708# a_2566_1660# w_2566_1934# pfet_03v3 ad=0.3061p pd=2.445u as=0.1238p ps=1.44u w=0.28u l=0.28u
X149 a_138_2015# a_82_1708# a_0_1660# w_0_1934# pfet_03v3 ad=0.3061p pd=2.445u as=0.1238p ps=1.44u w=0.28u l=0.28u
X150 a_4941_2476# a_4885_2666# a_4781_2710# VSUBS nfet_03v3 ad=0.23585p pd=1.95u as=0.1378p ps=1.05u w=0.53u l=0.28u
X151 a_2215_932# a_2159_888# a_2071_932# VSUBS nfet_03v3 ad=0.1378p pd=1.05u as=0.2332p ps=1.94u w=0.53u l=0.28u
X152 a_932_932# a_876_888# a_788_932# VSUBS nfet_03v3 ad=0.1378p pd=1.05u as=0.2332p ps=1.94u w=0.53u l=0.28u
X153 a_1365_1708# a_1283_1660# a_1421_1752# VSUBS nfet_03v3 ad=0.3133p pd=2.64u as=0.342p ps=2.21u w=0.45u l=0.28u
X154 a_3498_2710# a_3442_2666# a_3354_2710# VSUBS nfet_03v3 ad=0.1378p pd=1.05u as=0.2332p ps=1.94u w=0.53u l=0.28u
X155 a_3987_2524# a_3931_2480# a_3849_2432# VSUBS nfet_03v3 ad=0.342p pd=2.21u as=0.3133p ps=2.64u w=0.45u l=0.28u
X156 a_3931_1708# a_4333_1742# a_4381_1660# VSUBS nfet_03v3 ad=0.1288p pd=1.48u as=0.1208p ps=1.42u w=0.28u l=0.36u
X157 a_4781_2710# a_4725_2666# a_4637_2710# VSUBS nfet_03v3 ad=0.1378p pd=1.05u as=0.2332p ps=1.94u w=0.53u l=0.28u
X158 a_684_2100# a_484_2028# a_680_1946# VSUBS nfet_03v3 ad=0.1288p pd=1.48u as=0.1208p ps=1.42u w=0.28u l=0.36u
X159 a_82_936# a_0_888# a_138_980# VSUBS nfet_03v3 ad=0.3133p pd=2.64u as=0.342p ps=2.21u w=0.45u l=0.28u
X160 a_3931_2480# a_3849_2432# a_3987_2524# VSUBS nfet_03v3 ad=0.3133p pd=2.64u as=0.342p ps=2.21u w=0.45u l=0.28u
X161 a_3987_1243# a_3931_936# a_3849_888# w_3849_1162# pfet_03v3 ad=0.3061p pd=2.445u as=0.1238p ps=1.44u w=0.28u l=0.28u
X162 a_2648_2480# a_2566_2432# a_2704_2787# w_2566_2706# pfet_03v3 ad=0.1238p pd=1.44u as=0.3061p ps=2.445u w=0.28u l=0.28u
X163 a_684_1042# a_484_970# a_680_888# VSUBS nfet_03v3 ad=0.1288p pd=1.48u as=0.1208p ps=1.42u w=0.28u l=0.36u
X164 a_1967_2586# a_1767_2514# a_1963_2432# VSUBS nfet_03v3 ad=0.1288p pd=1.48u as=0.1208p ps=1.42u w=0.28u l=0.36u
X165 a_3250_1328# a_3050_1256# a_3246_1174# VSUBS nfet_03v3 ad=0.1288p pd=1.48u as=0.1208p ps=1.42u w=0.28u l=0.36u
X166 a_82_936# a_484_1256# a_532_1174# VSUBS nfet_03v3 ad=0.1288p pd=1.48u as=0.1208p ps=1.42u w=0.28u l=0.36u
X167 a_1967_2872# a_1767_2800# a_1963_2718# VSUBS nfet_03v3 ad=0.1288p pd=1.48u as=0.1208p ps=1.42u w=0.28u l=0.36u
X168 a_4941_2476# a_4885_2432# a_4781_2476# VSUBS nfet_03v3 ad=0.23585p pd=1.95u as=0.1378p ps=1.05u w=0.53u l=0.28u
X169 a_2375_160# a_2319_350# a_2215_394# VSUBS nfet_03v3 ad=0.23585p pd=1.95u as=0.1378p ps=1.05u w=0.53u l=0.28u
X170 a_1365_164# a_1767_198# a_1815_116# VSUBS nfet_03v3 ad=0.1288p pd=1.48u as=0.1208p ps=1.42u w=0.28u l=0.36u
X171 a_4533_1328# a_4333_1256# a_4529_1174# VSUBS nfet_03v3 ad=0.1288p pd=1.48u as=0.1208p ps=1.42u w=0.28u l=0.36u
X172 a_3658_932# a_3602_1122# a_3498_1166# VSUBS nfet_03v3 ad=0.23585p pd=1.95u as=0.1378p ps=1.05u w=0.53u l=0.28u
X173 a_3931_936# a_3849_888# a_3987_1243# w_3849_1162# pfet_03v3 ad=0.1238p pd=1.44u as=0.3061p ps=2.445u w=0.28u l=0.28u
X174 a_3498_2476# a_3442_2432# a_3354_2476# VSUBS nfet_03v3 ad=0.1378p pd=1.05u as=0.2332p ps=1.94u w=0.53u l=0.28u
X175 a_1365_164# a_1767_484# a_1815_402# VSUBS nfet_03v3 ad=0.1288p pd=1.48u as=0.1208p ps=1.42u w=0.28u l=0.36u
X176 a_2215_1166# a_2159_1122# a_2071_1166# VSUBS nfet_03v3 ad=0.1378p pd=1.05u as=0.2332p ps=1.94u w=0.53u l=0.28u
X177 a_4781_2476# a_4725_2432# a_4637_2476# VSUBS nfet_03v3 ad=0.1378p pd=1.05u as=0.2332p ps=1.94u w=0.53u l=0.28u
X178 a_1092_1704# a_1036_1660# a_932_1704# VSUBS nfet_03v3 ad=0.23585p pd=1.95u as=0.1378p ps=1.05u w=0.53u l=0.28u
X179 a_3658_160# a_3602_116# a_3498_160# VSUBS nfet_03v3 ad=0.23585p pd=1.95u as=0.1378p ps=1.05u w=0.53u l=0.28u
X180 a_1365_1708# a_1767_1742# a_1815_1660# VSUBS nfet_03v3 ad=0.1288p pd=1.48u as=0.1208p ps=1.42u w=0.28u l=0.36u
X181 a_2375_1704# a_2319_1660# a_2215_1704# VSUBS nfet_03v3 ad=0.23585p pd=1.95u as=0.1378p ps=1.05u w=0.53u l=0.28u
X182 a_2648_936# a_2566_888# a_2704_980# VSUBS nfet_03v3 ad=0.3133p pd=2.64u as=0.342p ps=2.21u w=0.45u l=0.28u
X183 a_932_1166# a_876_1122# a_788_1166# VSUBS nfet_03v3 ad=0.1378p pd=1.05u as=0.2332p ps=1.94u w=0.53u l=0.28u
X184 a_82_2480# a_0_2432# a_138_2787# w_0_2706# pfet_03v3 ad=0.1238p pd=1.44u as=0.3061p ps=2.445u w=0.28u l=0.28u
X185 a_1365_2480# a_1283_2432# a_1421_2524# VSUBS nfet_03v3 ad=0.3133p pd=2.64u as=0.342p ps=2.21u w=0.45u l=0.28u
X186 a_3931_2480# a_4333_2514# a_4381_2432# VSUBS nfet_03v3 ad=0.1288p pd=1.48u as=0.1208p ps=1.42u w=0.28u l=0.36u
X187 a_1092_160# a_1036_350# a_932_394# VSUBS nfet_03v3 ad=0.23585p pd=1.95u as=0.1378p ps=1.05u w=0.53u l=0.28u
X188 a_3931_2480# a_4333_2800# a_4381_2718# VSUBS nfet_03v3 ad=0.1288p pd=1.48u as=0.1208p ps=1.42u w=0.28u l=0.36u
X189 a_3987_980# a_3931_936# a_3849_888# VSUBS nfet_03v3 ad=0.342p pd=2.21u as=0.3133p ps=2.64u w=0.45u l=0.28u
X190 a_3987_2015# a_3931_1708# a_3849_1660# w_3849_1934# pfet_03v3 ad=0.3061p pd=2.445u as=0.1238p ps=1.44u w=0.28u l=0.28u
X191 a_3658_1704# a_3602_1894# a_3498_1938# VSUBS nfet_03v3 ad=0.23585p pd=1.95u as=0.1378p ps=1.05u w=0.53u l=0.28u
.ends

.subckt gf180mcu_as_sc_mcu7t3v3__nand2_2 VDD VSS Y B A VNW VPW
X0 VDD A Y VNW pfet_03v3 ad=0.3588p pd=1.9u as=0.3588p ps=1.9u w=1.38u l=0.28u
X1 VSS A a_28_68# VPW nfet_03v3 ad=0.26p pd=1.52u as=0.44p ps=2.88u w=1u l=0.28u
X2 Y B VDD VNW pfet_03v3 ad=0.3588p pd=1.9u as=0.3588p ps=1.9u w=1.38u l=0.28u
X3 a_28_68# B Y VPW nfet_03v3 ad=0.515p pd=3.03u as=0.26p ps=1.52u w=1u l=0.28u
X4 VDD B Y VNW pfet_03v3 ad=0.7176p pd=3.8u as=0.3588p ps=1.9u w=1.38u l=0.28u
X5 Y B a_28_68# VPW nfet_03v3 ad=0.26p pd=1.52u as=0.26p ps=1.52u w=1u l=0.28u
X6 Y A VDD VNW pfet_03v3 ad=0.3588p pd=1.9u as=0.6072p ps=3.64u w=1.38u l=0.28u
X7 a_28_68# A VSS VPW nfet_03v3 ad=0.26p pd=1.52u as=0.26p ps=1.52u w=1u l=0.28u
.ends

.subckt gf180mcu_as_sc_mcu7t3v3__nor2_2 VDD VSS Y B A VNW VPW
X0 a_28_440# A VDD VNW pfet_03v3 ad=0.3588p pd=1.9u as=0.3588p ps=1.9u w=1.38u l=0.28u
X1 Y A VSS VPW nfet_03v3 ad=0.26p pd=1.52u as=0.44p ps=2.88u w=1u l=0.28u
X2 Y B a_28_440# VNW pfet_03v3 ad=0.3588p pd=1.9u as=0.3588p ps=1.9u w=1.38u l=0.28u
X3 VSS B Y VPW nfet_03v3 ad=0.515p pd=3.03u as=0.26p ps=1.52u w=1u l=0.28u
X4 a_28_440# B Y VNW pfet_03v3 ad=0.7176p pd=3.8u as=0.3588p ps=1.9u w=1.38u l=0.28u
X5 Y B VSS VPW nfet_03v3 ad=0.26p pd=1.52u as=0.26p ps=1.52u w=1u l=0.28u
X6 VDD A a_28_440# VNW pfet_03v3 ad=0.3588p pd=1.9u as=0.6072p ps=3.64u w=1.38u l=0.28u
X7 VSS A Y VPW nfet_03v3 ad=0.26p pd=1.52u as=0.26p ps=1.52u w=1u l=0.28u
.ends

.subckt gf180mcu_as_sc_mcu7t3v3__nand3_2 VDD VSS A B C Y VNW VPW
X0 VDD A Y VNW pfet_03v3 ad=0.3588p pd=1.9u as=0.3588p ps=1.9u w=1.38u l=0.28u
X1 VSS A a_28_68# VPW nfet_03v3 ad=0.26p pd=1.52u as=0.44p ps=2.88u w=1u l=0.28u
X2 VDD C Y VNW pfet_03v3 ad=0.621p pd=3.66u as=0.3588p ps=1.9u w=1.38u l=0.28u
X3 a_492_68# C Y VPW nfet_03v3 ad=0.45p pd=2.9u as=0.26p ps=1.52u w=1u l=0.28u
X4 Y B VDD VNW pfet_03v3 ad=0.3588p pd=1.9u as=0.3588p ps=1.9u w=1.38u l=0.28u
X5 a_28_68# B a_492_68# VPW nfet_03v3 ad=0.44p pd=2.88u as=0.26p ps=1.52u w=1u l=0.28u
X6 VDD B Y VNW pfet_03v3 ad=0.8004p pd=2.54u as=0.3588p ps=1.9u w=1.38u l=0.28u
X7 Y C VDD VNW pfet_03v3 ad=0.3588p pd=1.9u as=0.8004p ps=2.54u w=1.38u l=0.28u
X8 Y C a_492_68# VPW nfet_03v3 ad=0.26p pd=1.52u as=0.44p ps=2.88u w=1u l=0.28u
X9 a_492_68# B a_28_68# VPW nfet_03v3 ad=0.26p pd=1.52u as=0.26p ps=1.52u w=1u l=0.28u
X10 Y A VDD VNW pfet_03v3 ad=0.3588p pd=1.9u as=0.6072p ps=3.64u w=1.38u l=0.28u
X11 a_28_68# A VSS VPW nfet_03v3 ad=0.26p pd=1.52u as=0.26p ps=1.52u w=1u l=0.28u
.ends

.subckt gf180mcu_3v3_12t_2r2w_sram_512x8_array_control_core clk w0_data[0] w0_data[1]
+ w0_data[2] w0_data[3] w0_data[4] w0_data[5] w0_data[6] w0_data[7] w1_data[0] w1_data[1]
+ w1_data[2] w1_data[3] w1_data[4] w1_data[5] w1_data[6] w1_data[7] r0_data[0] r0_data[1]
+ r0_data[2] r0_data[3] r0_data[4] r0_data[5] r0_data[6] r0_data[7] r1_data[0] r1_data[1]
+ r1_data[2] r1_data[3] r1_data[4] r1_data[5] r1_data[6] r1_data[7] u_t000_013/c3_w1_br
+ u_t001_006/c1_r0_rbl u_t001_010/r3_r1_rwl u_t001_012/c3_w0_bl u_t001_011/c2_r1_rbl
+ u_t001_013/c3_r0_rbl u_t005_009/c2_w0_bl u_t000_015/r3_w0_wl u_t006_001/r3_w1_wl
+ u_t004_000/r0_w1_wl u_t006_010/c2_w1_bl u_t001_008/c2_w1_br u_t001_001/c0_w1_bl
+ a_200_39400# u_t001_007/c1_w0_br u_t001_004/c3_w1_bl u_t000_004/c2_w1_br u_t000_009/c2_w0_bl
+ u_t001_003/c2_w0_bl u_t001_014/c1_w1_br u_t014_013/c2_w0_bl u_t001_015/c0_r0_rbl
+ u_t011_000/r1_w1_wl u_t001_000/c0_r1_rbl u_t001_001/r3_w1_wl u_t001_002/c1_r0_rbl
+ u_t001_013/c0_w0_br u_t000_003/c2_r1_rbl u_t001_010/c2_w1_bl a_22600_3000# u_t000_005/c3_r0_rbl
+ a_14200_45000# u_t012_015/c2_w0_bl u_t015_009/c2_w1_bl u_t001_009/c1_r1_rbl u_t011_011/c2_w0_bl
+ u_t009_011/c2_w0_bl u_t000_012/c3_w0_br a_200_19800# u_t000_012/r1_w0_wl u_t014_005/c2_w1_bl
+ u_t001_005/c0_w1_br u_t007_013/c2_w0_bl u_t012_007/c2_w1_bl u_t000_007/c1_w1_bl
+ u_t001_008/c3_w1_br u_t001_001/c1_w1_bl u_t005_015/c2_w0_bl u_t010_009/c2_w1_bl
+ u_t011_003/c2_w1_bl u_t001_007/c2_w0_br u_t001_011/c0_r0_rbl u_t001_000/c0_w0_bl
+ u_t001_007/r0_w0_wl u_t008_009/c2_w1_bl a_14200_25400# u_t000_012/c1_r1_rbl u_t009_003/c2_w1_bl
+ u_t004_011/c2_w0_bl u_t001_003/c3_w0_bl u_t001_014/c2_w1_br m4_4600_10138# u_t000_003/c2_w0_br
+ u_t007_005/c2_w1_bl u_t001_006/r3_r0_rwl u_t002_013/c2_w0_bl u_t001_005/c1_r1_rbl
+ u_t001_007/c2_r0_rbl u_t009_000/r2_w1_wl u_t001_013/c1_w0_br u_t001_010/c3_w1_bl
+ u_t000_008/c3_r1_rbl u_t005_007/c2_w1_bl u_t000_010/c2_w1_br u_t000_015/c2_w0_bl
+ u_t001_012/c3_r1_rbl u_t011_015/r0_w0_wl u_t009_015/r0_w0_wl u_t003_009/c2_w1_bl
+ u_t004_003/c2_w1_bl u_t015_008/c2_w0_bl u_t002_005/c2_w1_bl u_t000_003/c0_r0_rbl
+ a_200_28200# u_t001_005/c1_w1_br u_t000_007/c2_w1_bl u_t000_010/c2_r0_rbl u_t001_004/c0_w0_br
+ u_t001_001/c2_w1_bl u_t012_001/r0_w1_wl u_t000_006/c1_w0_bl u_t004_015/r0_w0_wl
+ u_t001_007/c3_w0_br u_t001_014/c0_r1_rbl u_t001_002/r3_r0_rwl u_t001_000/c1_w0_bl
+ u_t001_011/c0_w1_br u_t001_001/c1_r1_rbl u_t001_003/c2_r0_rbl u_t000_004/r2_w1_wl
+ u_t010_008/c2_w0_bl u_t000_013/c1_w1_bl u_t008_008/c2_w0_bl u_t001_014/c3_w1_br
+ u_t000_003/r1_w0_wl u_t001_009/r3_r1_rwl u_t009_000/r3_w1_wl u_t001_013/c2_w0_br
+ u_t001_013/r0_w0_wl u_t011_015/r1_w0_wl a_22600_64600# u_t005_001/r0_w1_wl u_t009_015/r1_w0_wl
+ u_t001_008/c0_w1_bl u_t003_008/c2_w0_bl u_t000_008/c1_r0_rbl u_t001_005/c2_w1_br
+ u_t004_000/r3_w1_wl u_t001_010/c0_r1_rbl u_t001_012/c1_r0_rbl a_14200_14200# u_t001_004/c1_w0_br
+ u_t015_014/c2_w0_bl u_t001_001/c3_w1_bl u_t001_008/r3_w1_wl u_t012_001/r1_w1_wl
+ u_t000_000/c3_r1_rbl u_t000_001/c2_w1_br u_t000_001/r0_w1_wl u_t004_015/r1_w0_wl
+ u_t001_005/r3_r1_rwl u_t001_000/c2_w0_bl u_t001_011/c1_w1_br u_t000_000/c1_w0_br
+ u_t001_006/c2_r1_rbl u_t014_010/c2_w0_bl a_200_61800# u_t001_008/c3_r0_rbl u_t001_010/c0_w0_br
+ u_t012_012/c2_w0_bl u_t000_012/c1_w0_bl u_t001_013/c3_w0_br u_t015_006/c2_w1_bl
+ u_t010_014/c2_w0_bl u_t011_015/r2_w0_wl u_t008_014/c2_w0_bl u_t005_001/r1_w1_wl
+ u_t009_015/r2_w0_wl u_t013_008/c2_w1_bl a_200_17000# u_t014_002/c2_w1_bl u_t001_008/c1_w1_bl
+ u_t001_002/c0_w1_br u_t007_010/c2_w0_bl u_t012_004/c2_w1_bl u_t001_007/c0_w0_bl
+ gf180mcu_as_sc_mcu7t3v3__inv_2_761/Y u_t000_004/c1_w1_bl u_t001_005/c3_w1_br u_t001_005/r1_w1_wl
+ u_t005_012/c2_w0_bl u_t001_001/r3_r1_rwl u_t010_006/c2_w1_bl u_t001_015/c1_r1_rbl
+ u_t001_014/c0_w1_bl u_t000_003/c0_w0_bl u_t001_002/c2_r1_rbl u_t001_004/c2_w0_br
+ u_t008_006/c2_w1_bl u_t001_004/r0_w0_wl u_t001_004/c3_r0_rbl u_t000_006/VDD u_t012_001/r2_w1_wl
+ u_t003_014/c2_w0_bl u_t000_001/r1_w1_wl u_t004_015/r2_w0_wl u_t000_006/c3_w0_bl
+ u_t000_010/c0_w1_bl u_t001_000/c3_w0_bl u_t001_011/c2_w1_br u_t006_008/c2_w1_bl
+ u_t000_000/r0_w0_wl u_t007_002/c2_w1_bl u_t002_010/c2_w0_bl u_t000_013/c3_w1_bl
+ u_t001_010/c1_w0_br u_t001_014/r3_w1_wl a_22600_53400# u_t005_004/c2_w1_bl u_t000_013/c0_r0_rbl
+ u_t000_012/c2_w0_bl u_t000_000/c1_r0_rbl u_t003_006/c2_w1_bl u_t011_015/r3_w0_wl
+ u_t005_001/r2_w1_wl u_t000_006/r2_r1_rwl u_t001_006/c0_r0_rbl u_t009_015/r3_w0_wl
+ u_t000_007/c1_r1_rbl u_t001_008/c2_w1_bl u_t000_009/c2_r0_rbl u_t001_012/r3_r0_rwl
+ u_t000_008/c1_w1_br u_t002_002/c2_w1_bl u_t001_011/c1_r1_rbl u_t001_002/c1_w1_br
+ u_t001_013/c2_r0_rbl u_t000_014/c3_r1_rbl u_t001_000/c3_r0_rbl u_t001_007/c1_w0_bl
+ u_t000_004/c2_w1_bl u_t001_001/c0_w0_br u_t011_009/c2_w0_bl m4_7400_10138# u_t001_014/c1_w1_bl
+ u_t009_009/c2_w0_bl u_t001_004/c3_w0_br a_200_50600# u_t001_007/c3_r1_rbl u_t012_001/r3_w1_wl
+ a_22600_33800# u_t000_001/r2_w1_wl u_t001_013/c0_w0_bl u_t004_015/r3_w0_wl u_t012_010/c2_w1_bl
+ u_t008_000/r0_w1_wl a_22600_200# u_t001_011/c3_w1_br u_t000_000/r1_w0_wl u_t001_010/c2_w0_br
+ u_t001_010/r0_w0_wl u_t000_002/r2_r1_rwl u_t001_002/c0_r0_rbl u_t000_012/c3_w0_bl
+ u_t004_009/c2_w0_bl u_t001_005/c0_w1_bl u_t015_000/r1_w1_wl u_t005_001/r3_w1_wl
+ u_t001_009/c0_r1_rbl u_t003_000/r0_w1_wl u_t001_008/c3_w1_bl u_t005_010/c2_w1_bl
+ u_t001_015/r3_r1_rwl u_t000_001/c0_w1_bl u_t001_002/c2_w1_br u_t001_007/c2_w0_bl
+ u_t001_003/c3_r1_rbl u_t000_007/c1_w0_br u_t000_004/c3_w1_bl u_t001_001/c1_w0_br
+ u_t015_011/c2_w0_bl u_t001_005/r3_w1_wl u_t001_014/c2_w1_bl u_t000_014/c1_w1_br
+ u_t013_013/c2_w0_bl u_t010_000/r1_w1_wl u_t000_001/r3_w1_wl u_t001_013/c1_w0_bl
+ a_22600_42200# u_t000_010/c2_w1_bl u_t000_012/c0_r1_rbl u_t011_015/c2_w0_bl u_t000_014/c1_r0_rbl
+ a_25400_64600# u_t000_003/VDD u_t009_015/c2_w0_bl u_t001_010/c3_w0_br u_t000_012/VDD
+ u_t014_009/c2_w1_bl u_t001_004/r1_r1_rwl u_t015_003/c2_w1_bl u_t010_011/c2_w0_bl
+ u_t001_009/c0_w1_br u_t001_005/c0_r1_rbl u_t001_007/c1_r0_rbl u_t008_011/c2_w0_bl
+ u_t013_005/c2_w1_bl u_t001_011/r3_r1_rwl u_t001_005/c1_w1_bl u_t001_012/c2_r1_rbl
+ u_t015_000/r2_w1_wl u_t001_014/c3_r0_rbl a_17000_200# u_t006_013/c2_w0_bl u_t003_000/r1_w1_wl
+ u_t011_007/c2_w1_bl u_t001_004/c0_w0_bl u_t009_007/c2_w1_bl u_t001_002/c3_w1_br
+ u_t001_002/r1_w1_wl u_t004_015/c2_w0_bl u_t015_015/r0_w0_wl u_t001_007/c3_w0_bl
+ u_t010_003/c2_w1_bl a_22600_22600# u_t001_011/c0_w1_bl u_t007_009/c2_w1_bl u_t000_000/c0_w0_bl
+ u_t001_001/c2_w0_br u_t001_001/r0_w0_wl u_t008_003/c2_w1_bl u_t003_011/c2_w0_bl
+ u_t001_014/c3_w1_bl u_t000_003/c3_w0_bl u_t006_005/c2_w1_bl u_t010_000/r2_w1_wl
+ u_t001_013/c2_w0_bl u_t001_000/r1_r1_rwl u_t000_013/c1_w0_br u_t001_001/c0_r1_rbl
+ u_t001_011/r3_w1_wl u_t004_007/c2_w1_bl u_t001_003/c1_r0_rbl u_t000_004/c2_r1_rbl
+ u_t010_015/r0_w0_wl u_t000_006/c3_r0_rbl u_t008_015/r0_w0_wl u_t002_009/c2_w1_bl
+ u_t001_010/c3_r0_rbl u_t001_009/c1_w1_br u_t003_003/c2_w1_bl u_t014_008/c2_w0_bl
+ u_t001_008/c0_w0_br u_t001_005/c2_w1_bl u_t000_005/c1_w1_br u_t001_004/c1_w0_bl
+ u_t001_015/c0_w1_br u_t000_004/c0_w0_br u_t000_001/c2_w1_bl u_t011_001/r0_w1_wl
+ u_t015_015/r1_w0_wl u_t003_015/r0_w0_wl u_t009_001/r0_w1_wl u_t000_007/c3_w0_br
+ u_t001_011/c1_w1_bl u_t000_007/r1_w0_wl u_t000_011/c0_w1_br u_t001_001/c3_w0_br
+ a_22600_31000# u_t001_012/c0_r0_rbl u_t001_010/c0_w0_bl u_t000_013/c1_r1_rbl u_t007_008/c2_w0_bl
+ u_t000_014/c3_w1_br u_t001_013/c3_w0_bl u_t008_000/r3_w1_wl u_t001_007/r3_r0_rwl
+ u_t001_006/c1_r1_rbl u_t001_008/c2_r0_rbl u_t010_015/r1_w0_wl u_t004_001/r0_w1_wl
+ u_t008_015/r1_w0_wl u_t001_013/c3_r1_rbl u_t000_008/c0_w1_bl u_t001_009/c2_w1_br
+ a_19800_64600# u_t001_002/c0_w1_bl u_t002_008/c2_w0_bl u_t001_008/c1_w0_br u_t001_005/c3_w1_bl
+ a_22600_11400# a_25400_200# u_t000_004/c0_r0_rbl u_t001_004/c2_w0_bl u_t001_015/c1_w1_br
+ u_t014_014/c2_w0_bl u_t011_001/r1_w1_wl u_t001_002/r3_w1_wl u_t015_015/r2_w0_wl
+ u_t000_011/c2_r0_rbl u_t009_001/r1_w1_wl u_t003_015/r1_w0_wl u_t001_014/c0_w0_br
+ u_t001_011/c2_w1_bl u_t000_000/c2_w0_bl u_t013_010/c2_w0_bl a_19800_200# u_t001_003/r3_r0_rwl
+ u_t001_015/c0_r1_rbl u_t001_010/c1_w0_bl u_t001_002/c1_r1_rbl u_t000_010/c0_w0_br
+ u_t001_004/c2_r0_rbl u_t011_012/c2_w0_bl u_t000_013/c3_w0_br u_t009_012/c2_w0_bl
+ u_t000_013/r1_w0_wl u_t014_006/c2_w1_bl u_t010_015/r2_w0_wl u_t001_006/c0_w1_br
+ u_t007_014/c2_w0_bl u_t004_001/r1_w1_wl u_t008_015/r2_w0_wl u_t012_008/c2_w1_bl
+ u_t013_002/c2_w1_bl u_t001_009/c3_w1_br u_t001_002/c1_w1_bl u_t000_002/c0_w1_br
+ u_t006_010/c2_w0_bl a_200_47800# u_t011_004/c2_w1_bl u_t001_008/c2_w0_br u_t001_008/r0_w0_wl
+ u_t001_001/c0_w0_bl u_t009_004/c2_w1_bl u_t000_005/c3_w1_br u_t004_012/c2_w0_bl
+ u_t001_004/c3_w0_bl u_t007_006/c2_w1_bl u_t001_011/c0_r1_rbl u_t011_001/r2_w1_wl
+ u_t001_013/c1_r0_rbl u_t015_015/r3_w0_wl u_t002_014/c2_w0_bl u_t001_000/c2_r0_rbl
+ u_t009_001/r2_w1_wl u_t003_015/r2_w0_wl u_t001_014/c1_w0_br u_t001_011/c3_w1_bl
+ u_t000_011/c2_w1_br u_t005_008/c2_w1_bl a_28200_64600# a_14200_53400# u_t006_002/c2_w1_bl
+ a_22600_59000# u_t001_010/c2_w0_bl u_t001_006/r3_r1_rwl u_t001_007/c2_r1_rbl u_t001_009/c3_r0_rbl
+ u_t004_004/c2_w1_bl u_t015_009/c2_w0_bl u_t002_006/c2_w1_bl u_t010_015/r3_w0_wl
+ u_t001_006/c1_w1_br u_t004_001/r2_w1_wl u_t008_015/r3_w0_wl u_t000_008/c2_w1_bl
+ u_t001_005/c0_w0_br u_t001_002/c2_w1_bl u_t000_003/c0_r1_rbl u_t001_008/c3_w0_br
+ u_t001_001/c1_w0_bl u_t001_012/c0_w1_br u_t000_005/r2_w1_wl u_t000_001/c0_w0_br
+ u_t000_010/c2_r1_rbl a_14200_33800# a_200_56200# u_t010_009/c2_w0_bl a_22600_39400#
+ a_19800_3000# u_t000_014/c1_w1_bl u_t008_009/c2_w0_bl u_t000_004/c3_w0_br u_t000_004/r1_w0_wl
+ u_t011_001/r3_w1_wl u_t001_002/r3_r1_rwl u_t009_001/r3_w1_wl u_t001_003/c2_r1_rbl
+ u_t003_015/r3_w0_wl u_t011_010/c2_w1_bl u_t001_005/c3_r0_rbl u_t001_014/c2_w0_br
+ u_t007_000/r0_w1_wl u_t001_014/r0_w0_wl u_t009_010/c2_w1_bl u_t001_010/c3_w0_bl
+ u_t000_010/c2_w0_br u_t001_009/c0_w1_bl u_t003_009/c2_w0_bl u_t001_006/VDD m4_32600_10138#
+ u_t000_001/c1_r0_rbl u_t001_006/c2_w1_br u_t014_000/r1_w1_wl a_25400_3000# a_200_36600#
+ u_t004_001/r3_w1_wl a_22600_19800# u_t004_010/c2_w1_bl u_t001_005/c1_w0_br u_t000_007/r2_r1_rwl
+ u_t001_002/c3_w1_bl u_t001_009/r3_w1_wl u_t015_015/c2_w0_bl u_t001_007/c0_r0_rbl
+ u_t000_002/c2_w1_br u_t000_008/c1_r1_rbl u_t000_007/c2_w0_bl u_t001_013/r3_r0_rwl
+ u_t001_001/c2_w0_bl u_t001_012/c1_r1_rbl u_t001_012/c1_w1_br u_t001_014/c2_r0_rbl
+ u_t014_011/c2_w0_bl u_t001_001/c3_r0_rbl a_14200_42200# u_t001_011/c0_w0_br u_t012_013/c2_w0_bl
+ a_17000_64600# u_t000_013/c1_w0_bl u_t001_014/c3_w0_br u_t007_000/r1_w1_wl u_t001_008/c3_r1_rbl
+ u_t015_007/c2_w1_bl u_t010_015/c2_w0_bl u_t008_015/c2_w0_bl u_t000_010/c0_r0_rbl
+ u_t013_009/c2_w1_bl u_t000_010/r1_w0_wl u_t014_003/c2_w1_bl u_t001_009/c1_w1_bl
+ u_t000_009/c0_w1_br a_28200_200# u_t001_003/c0_w1_br u_t007_011/c2_w0_bl u_t012_005/c2_w1_bl
+ u_t000_003/r2_r1_rwl u_t001_008/c0_w0_bl u_t001_003/c0_r0_rbl u_t000_005/c1_w1_bl
+ u_t001_006/c3_w1_br u_t014_000/r2_w1_wl u_t001_006/r1_w1_wl u_t005_013/c2_w0_bl
+ u_t002_000/r1_w1_wl u_t010_007/c2_w1_bl u_t001_010/c2_r0_rbl u_t001_015/c0_w1_bl
+ a_200_45000# a_14200_22600# u_t001_005/c2_w0_br u_t008_007/c2_w1_bl u_t001_005/r0_w0_wl
+ a_22600_28200# u_t003_015/c2_w0_bl u_t014_015/r0_w0_wl u_t001_001/c3_w0_bl u_t000_011/c0_w1_bl
+ u_t001_012/c2_w1_br u_t006_009/c2_w1_bl u_t000_001/c2_w0_br u_t000_001/r0_w0_wl
+ u_t007_003/c2_w1_bl u_t001_004/c3_r1_rbl u_t002_011/c2_w0_bl u_t000_014/c3_w1_bl
+ u_t001_011/c1_w0_br u_t001_015/r3_w1_wl u_t005_005/c2_w1_bl u_t000_013/c2_w0_bl
+ u_t003_007/c2_w1_bl u_t015_001/r0_w1_wl u_t000_013/c0_r1_rbl u_t000_015/c1_r0_rbl
+ u_t007_015/r0_w0_wl u_t000_000/c1_r1_rbl u_t001_014/VDD u_t001_009/c2_w1_bl u_t000_002/c2_r0_rbl
+ a_200_25400# u_t002_003/c2_w1_bl m4_21400_10138# u_t001_003/c1_w1_br u_t013_008/c2_w0_bl
+ u_t001_005/r1_r1_rwl u_t001_008/c1_w0_bl u_t001_006/c0_r1_rbl u_t001_008/c1_r0_rbl
+ gf180mcu_as_sc_mcu7t3v3__inv_2_336/A u_t000_005/c2_w1_bl u_t001_002/c0_w0_br u_t001_012/r3_r1_rwl
+ u_t002_000/r2_w1_wl u_t001_013/c2_r1_rbl u_t001_015/c1_w1_bl u_t000_004/c1_w0_bl
+ u_t001_000/c3_r1_rbl u_t001_005/c3_w0_br u_t001_003/VDD u_t010_001/r0_w1_wl u_t000_002/r2_w1_wl
+ u_t014_015/r1_w0_wl u_t001_012/VDD a_14200_31000# u_t001_014/c0_w0_bl u_t008_001/r0_w1_wl
+ u_t002_015/r0_w0_wl u_t001_012/c3_w1_br u_t000_001/r1_w0_wl u_t000_010/c0_w0_bl
+ u_t001_011/c2_w0_br u_t006_008/c2_w0_bl u_t001_011/r0_w0_wl a_22600_61800# u_t000_013/c3_w0_bl
+ u_t001_001/r1_r1_rwl u_t001_006/c0_w1_bl u_t015_001/r1_w1_wl u_t001_002/c0_r1_rbl
+ u_t003_001/r0_w1_wl u_t001_004/c1_r0_rbl u_t007_015/r1_w0_wl u_t001_009/c3_w1_bl
+ u_t000_005/c2_r1_rbl u_t000_007/c3_r0_rbl u_t000_009/c2_w1_br u_t000_002/c0_w1_bl
+ u_t001_003/c2_w1_br u_t001_011/c3_r0_rbl a_14200_11400# u_t001_008/c2_w0_bl a_22600_17000#
+ u_t000_005/c3_w1_bl u_t015_012/c2_w0_bl u_t001_002/c1_w0_br u_t001_006/r3_w1_wl
+ a_22600_8600# u_t000_015/c1_w1_br u_t013_014/c2_w0_bl u_t010_001/r1_w1_wl u_t014_015/r2_w0_wl
+ u_t001_014/c1_w0_bl u_t008_001/r1_w1_wl u_t002_015/r1_w0_wl u_t012_010/c2_w0_bl
+ u_t001_011/c3_w0_br u_t015_004/c2_w1_bl u_t001_013/c0_r0_rbl u_t010_012/c2_w0_bl
+ u_t000_014/c1_r1_rbl u_t001_000/c1_r0_rbl u_t008_012/c2_w0_bl a_200_14200# u_t000_004/VDD
+ u_t013_006/c2_w1_bl u_t000_013/VDD u_t001_006/c1_w1_bl u_t015_001/r2_w1_wl u_t006_014/c2_w0_bl
+ u_t001_008/r3_r0_rwl u_t003_001/r1_w1_wl m4_10200_10138# u_t001_000/c0_w1_br u_t001_007/c1_r1_rbl
+ u_t007_015/r2_w0_wl u_t011_008/c2_w1_bl u_t001_009/c2_r0_rbl u_t001_005/c0_w0_bl
+ u_t012_002/c2_w1_bl u_t009_008/c2_w1_bl u_t001_003/c3_w1_br u_t001_003/r1_w1_wl
+ u_t001_014/c3_r1_rbl u_t005_010/c2_w0_bl u_t001_008/c3_w0_bl u_t010_004/c2_w1_bl
+ u_t000_008/c2_w0_br u_t001_012/c0_w1_bl u_t000_001/c0_w0_bl u_t001_002/c2_w0_br
+ u_t008_004/c2_w1_bl u_t001_002/r0_w0_wl m4_15800_10138# u_t003_012/c2_w0_bl u_t000_004/c3_w0_bl
+ u_t006_006/c2_w1_bl u_t010_001/r2_w1_wl u_t000_005/c0_r0_rbl u_t014_015/r3_w0_wl
+ u_t001_014/c2_w0_bl a_14200_59000# u_t008_001/r2_w1_wl u_t000_014/c1_w0_br u_t002_015/r2_w0_wl
+ u_t000_011/c3_w1_bl u_t001_012/r3_w1_wl a_22600_50600# u_t004_008/c2_w1_bl u_t000_010/c1_r1_rbl
+ u_t000_012/c2_r0_rbl u_t005_002/c2_w1_bl a_200_8600# u_t000_010/c2_w0_bl u_t001_004/r3_r0_rwl
+ u_t003_004/c2_w1_bl u_t001_003/c1_r1_rbl u_t014_009/c2_w0_bl u_t001_005/c2_r0_rbl
+ u_t000_006/c3_r1_rbl u_t001_009/c0_w0_br u_t001_006/c2_w1_bl u_t015_001/r3_w1_wl
+ u_t001_010/c3_r1_rbl u_t000_006/c1_w1_br u_t013_000/r0_w1_wl u_t003_001/r2_w1_wl
+ u_t001_000/c1_w1_br u_t007_015/r3_w0_wl u_t015_010/c2_w1_bl u_t001_005/c1_w0_bl
+ gf180mcu_as_sc_mcu7t3v3__inv_2_153/Y u_t000_002/c2_w1_bl a_14200_39400# u_t001_012/c1_w1_bl
+ u_t000_008/r1_w0_wl u_t001_002/c3_w0_br u_t000_012/c0_w1_br u_t001_011/c0_w0_bl
+ u_t007_009/c2_w0_bl u_t010_001/r3_w1_wl u_t001_014/c3_w0_bl u_t008_001/r3_w1_wl
+ u_t010_010/c2_w1_bl u_t002_015/r3_w0_wl u_t001_000/r3_r0_rwl u_t001_012/c0_r1_rbl
+ u_t001_014/c1_r0_rbl u_t008_010/c2_w1_bl u_t001_001/c2_r0_rbl u_t000_009/c0_w1_bl
+ u_t001_007/r3_r1_rwl m4_24200_10138# u_t001_003/c0_w1_bl u_t001_008/c2_r1_rbl u_t002_009/c2_w0_bl
+ a_14200_19800# u_t001_009/c1_w0_br u_t001_006/c3_w1_bl u_t003_001/r3_w1_wl gf180mcu_as_sc_mcu7t3v3__inv_2_743/Y
+ u_t001_000/c2_w1_br m4_29800_10138# u_t001_005/c2_w0_bl u_t003_010/c2_w1_bl u_t000_005/c1_w0_br
+ u_t014_015/c2_w0_bl u_t001_003/r3_w1_wl u_t001_012/c2_w1_bl u_t001_015/c0_w0_br
+ u_t000_001/c2_w0_bl u_t000_004/c0_r1_rbl u_t000_006/c1_r0_rbl gf180mcu_as_sc_mcu7t3v3__inv_2_344/A
+ u_t013_011/c2_w0_bl u_t001_010/c1_r0_rbl u_t001_011/c1_w0_bl u_t000_011/c0_w0_br
+ u_t000_011/c2_r1_rbl u_t000_013/c3_r0_rbl u_t011_013/c2_w0_bl u_t009_013/c2_w0_bl
+ u_t000_014/c3_w0_br u_t006_000/r1_w1_wl u_t000_014/r1_w0_wl u_t014_007/c2_w1_bl
+ u_t001_003/r3_r1_rwl u_t001_004/c2_r1_rbl u_t001_006/c3_r0_rbl u_t001_007/c0_w1_br
+ u_t007_015/c2_w0_bl u_t012_009/c2_w1_bl u_t013_003/c2_w1_bl u_t001_003/c1_w1_bl
+ u_t000_003/c0_w1_br u_t006_011/c2_w0_bl u_t011_005/c2_w1_bl u_t000_008/c0_w0_bl
+ u_t001_009/c2_w0_br u_t001_002/c0_w0_bl u_t001_009/r0_w0_wl u_t009_005/c2_w1_bl
+ u_t000_006/c3_w1_br u_t013_000/r2_w1_wl a_14200_28200# u_t001_000/c3_w1_br u_t004_013/c2_w0_bl
+ u_t001_000/r1_w1_wl u_t001_005/c3_w0_bl gf180mcu_as_sc_mcu7t3v3__inv_2_18/Y u_t007_007/c2_w1_bl
+ u_t002_015/c2_w0_bl u_t013_015/r0_w0_wl u_t001_015/c1_w0_br u_t001_012/c3_w1_bl
+ u_t001_008/c0_r0_rbl u_t005_009/c2_w1_bl u_t000_009/c1_r1_rbl u_t001_014/r3_r0_rwl
+ u_t006_003/c2_w1_bl u_t001_011/c2_w0_bl u_t001_013/c1_r1_rbl u_t001_000/c2_r1_rbl
+ u_t001_002/c3_r0_rbl u_t004_005/c2_w1_bl u_t006_000/r2_w1_wl u_t002_007/c2_w1_bl
+ u_t001_009/c3_r1_rbl u_t001_007/c1_w1_br u_t014_001/r0_w1_wl u_t006_015/r0_w0_wl
+ u_t000_009/c2_w1_bl u_t001_006/c0_w0_br u_t000_011/c0_r0_rbl u_t001_003/c2_w1_bl
+ u_t012_008/c2_w0_bl u_t001_009/c3_w0_br u_t001_002/c1_w0_bl m4_18600_10138# u_t001_013/c0_w1_br
+ u_t000_002/c0_w0_br u_t013_000/r3_w1_wl u_t000_006/r2_w1_wl u_t000_004/r2_r1_rwl
+ u_t001_000/r2_w1_wl u_t001_004/c0_r0_rbl u_t000_005/c3_w0_br u_t001_010/r3_r0_rwl
+ u_t000_005/r1_w0_wl u_t001_011/c2_r0_rbl u_t013_015/r1_w0_wl u_t007_001/r0_w1_wl
+ gf180mcu_as_sc_mcu7t3v3__inv_2_9/A u_t001_015/r0_w0_wl gf180mcu_as_sc_mcu7t3v3__inv_2_382/A
+ u_t000_012/c3_w1_br a_14200_61800# u_t001_011/c3_w0_bl u_t000_011/c2_w0_br gf180mcu_as_sc_mcu7t3v3__inv_2_27/Y
+ u_t005_008/c2_w0_bl u_t001_005/c3_r1_rbl u_t001_007/c2_w1_br u_t014_001/r1_w1_wl
+ u_t001_000/c0_w1_bl u_t002_001/r0_w1_wl u_t006_015/r1_w0_wl gf180mcu_as_sc_mcu7t3v3__inv_2_923/Y
+ a_14200_17000# u_t000_000/r2_r1_rwl u_t001_006/c1_w0_br u_t001_003/c3_w1_bl u_t001_000/c0_r0_rbl
+ u_t000_003/c2_w1_br u_t000_001/c1_r1_rbl u_t000_003/c2_r0_rbl u_t000_008/c2_w0_bl
+ u_t001_002/c2_w0_bl u_t001_013/c1_w1_br u_t001_006/r1_r1_rwl u_t014_012/c2_w0_bl
+ u_t001_000/r3_w1_wl u_t001_007/c0_r1_rbl u_t001_009/c1_r0_rbl a_22600_47800# u_t001_012/c0_w0_br
+ u_t001_013/r3_r1_rwl u_t012_014/c2_w0_bl u_t001_014/c2_r1_rbl u_t013_015/r2_w0_wl
+ u_t000_014/c1_w0_bl u_t001_001/c3_r1_rbl u_t007_001/r1_w1_wl u_t001_015/r1_w0_wl
+ u_t015_008/c2_w1_bl u_t011_010/c2_w0_bl u_t009_010/c2_w0_bl u_t000_011/r1_w0_wl
+ m4_27000_10138# u_t014_004/c2_w1_bl u_t001_004/c0_w1_br u_t007_012/c2_w0_bl u_t012_006/c2_w1_bl
+ u_t001_009/c0_w0_bl a_17000_3000# u_t000_010/c0_r1_rbl u_t000_006/c1_w1_bl u_t001_007/c3_w1_br
+ u_t014_001/r2_w1_wl u_t001_007/r1_w1_wl u_t001_000/c1_w1_bl gf180mcu_as_sc_mcu7t3v3__inv_2_466/A
+ u_t005_014/c2_w0_bl u_t002_001/r1_w1_wl u_t006_015/r2_w0_wl u_t010_008/c2_w1_bl
+ u_t001_002/r1_r1_rwl u_t001_006/c2_w0_br u_t011_002/c2_w1_bl u_t001_003/c0_r1_rbl
+ u_t001_006/r0_w0_wl u_t008_008/c2_w1_bl u_t001_005/c1_r0_rbl u_t009_002/c2_w1_bl
+ u_t004_010/c2_w0_bl u_t000_008/c3_r0_rbl u_t001_002/c3_w0_bl gf180mcu_as_sc_mcu7t3v3__inv_2_545/Y
+ u_t001_013/c2_w1_br u_t001_010/c2_r1_rbl u_t000_002/c2_w0_br u_t001_012/c3_r0_rbl
+ u_t007_004/c2_w1_bl u_t002_012/c2_w0_bl u_t001_012/c1_w0_br a_14200_50600# u_t005_006/c2_w1_bl
+ a_22600_56200# u_t013_015/r3_w0_wl u_t000_014/c2_w0_bl u_t007_001/r2_w1_wl u_t001_015/r2_w0_wl
+ u_t003_008/c2_w1_bl u_t004_002/c2_w1_bl gf180mcu_as_sc_mcu7t3v3__inv_2_717/A gf180mcu_as_sc_mcu7t3v3__inv_2_878/Y
+ u_t002_004/c2_w1_bl u_t001_004/c1_w1_br u_t013_009/c2_w0_bl u_t001_014/c0_r0_rbl
+ u_t001_009/c1_w0_bl u_t001_001/c1_r0_rbl u_t000_015/c1_r1_rbl u_t000_009/c0_w0_br
+ u_t000_006/c2_w1_bl u_t001_003/c0_w0_br u_t014_001/r3_w1_wl u_t000_002/c2_r1_rbl
+ u_t001_000/c2_w1_bl u_t001_005/VDD u_t012_000/r0_w1_wl u_t000_000/c1_w1_br u_t002_001/r2_w1_wl
+ u_t014_010/c2_w1_bl u_t006_015/r3_w0_wl u_t000_005/c1_w0_bl u_t001_006/c3_w0_br
+ u_t001_009/r3_r0_rwl u_t001_010/c0_w1_br a_200_53400# u_t001_008/c1_r1_rbl u_t000_003/r2_w1_wl
+ a_22600_36600# u_t001_015/c0_w0_bl u_t000_012/c1_w1_bl u_t001_013/c3_w1_br gf180mcu_as_sc_mcu7t3v3__inv_2_908/Y
+ u_t000_002/r1_w0_wl u_t001_004/VDD u_t001_012/c2_w0_br u_t006_009/c2_w0_bl a_28200_3000#
+ u_t001_012/r0_w0_wl u_t007_001/r3_w1_wl u_t001_015/r3_w0_wl u_t007_010/c2_w1_bl
+ u_t001_007/c0_w1_bl u_t001_010/c0_r0_rbl u_t000_011/c1_r1_rbl u_t000_000/c3_r0_rbl
+ a_200_33800# u_t000_003/c0_w1_bl u_t001_004/c2_w1_br u_t001_009/c2_w0_bl u_t001_005/r3_r0_rwl
+ u_t000_006/c3_w1_bl u_t001_004/c1_r1_rbl u_t001_006/c2_r0_rbl u_t001_003/c1_w0_br
+ u_t015_013/c2_w0_bl u_t001_000/c3_w1_bl u_t001_007/r3_w1_wl u_t000_007/c3_r1_rbl
+ u_t002_001/r3_w1_wl u_t000_000/r0_w1_wl u_t001_011/c3_r1_rbl u_t002_010/c2_w1_bl
+ u_t001_010/c1_w1_br u_t013_015/c2_w0_bl u_t001_015/c1_w0_bl gf180mcu_as_sc_mcu7t3v3__inv_2_917/Y
+ a_22600_45000# u_t012_011/c2_w0_bl u_t000_011/c1_w0_bl u_t000_002/c0_r0_rbl u_t001_012/c3_w0_br
+ u_t015_005/c2_w1_bl u_t010_013/c2_w0_bl u_t008_013/c2_w0_bl u_t013_007/c2_w1_bl
+ u_t001_007/c1_w1_bl u_t001_001/r3_r0_rwl u_t001_013/c0_r1_rbl u_t001_015/c1_r0_rbl
+ u_t006_015/c2_w0_bl u_t001_001/c0_w1_br u_t001_000/c1_r1_rbl u_t011_009/c2_w1_bl
+ u_t001_002/c2_r0_rbl u_t001_006/c0_w0_bl u_t012_003/c2_w1_bl u_t000_005/VDD u_t009_009/c2_w1_bl
+ u_t000_014/VDD u_t001_004/c3_w1_br u_t001_004/r1_w1_wl gf180mcu_as_sc_mcu7t3v3__inv_2_177/Y
+ u_t005_011/c2_w0_bl u_t001_009/c3_w0_bl u_t001_008/r3_r1_rwl a_200_42200# u_t010_005/c2_w1_bl
+ u_t001_013/c0_w1_bl u_t000_009/c2_w0_br u_t000_002/c0_w0_bl a_22600_25400# u_t001_003/c2_w0_br
+ u_t001_009/c2_r1_rbl gf180mcu_as_sc_mcu7t3v3__inv_2_580/A u_t008_005/c2_w1_bl u_t001_003/r0_w0_wl
+ a_14200_8600# u_t000_000/c3_w1_br u_t003_013/c2_w0_bl u_t000_005/c3_w0_bl u_t001_010/c2_w1_br
+ u_t006_007/c2_w1_bl u_t001_015/c2_w0_bl u_t012_015/r0_w0_wl u_t000_015/c1_w0_br
+ u_t000_012/c3_w1_bl u_t001_013/r3_w1_wl u_t004_009/c2_w1_bl u_t005_003/c2_w1_bl
+ u_t000_011/c2_w0_bl u_t000_005/c0_r1_rbl u_t000_007/c1_r0_rbl u_t003_005/c2_w1_bl
+ u_t001_011/c1_r0_rbl gf180mcu_as_sc_mcu7t3v3__inv_2_553/A u_t000_012/c2_r1_rbl u_t000_014/c3_r0_rbl
+ u_t005_000/r2_w1_wl u_t001_015/VSS a_200_22600# u_t001_007/c2_w1_bl u_t000_007/c1_w1_br
+ u_t001_004/r3_r1_rwl u_t013_001/r0_w1_wl u_t001_001/c1_w1_br u_t001_005/c2_r1_rbl
+ gf180mcu_as_sc_mcu7t3v3__inv_2_752/Y u_t001_006/c1_w0_bl u_t001_007/c3_r0_rbl u_t005_015/r0_w0_wl
+ u_t000_003/c2_w1_bl u_t001_000/c0_w0_br u_t011_008/c2_w0_bl u_t001_013/c1_w1_bl
+ u_t009_008/c2_w0_bl u_t000_009/r1_w0_wl u_t001_003/c3_w0_br u_t012_000/r3_w1_wl
+ gf180mcu_as_sc_mcu7t3v3__inv_2_887/Y u_t000_000/r2_w1_wl u_t001_012/c0_w0_bl u_t001_013/VDD
+ u_t001_010/c3_w1_br u_t001_011/VDD u_t012_015/r1_w0_wl m4_1566_13000# u_t006_001/r0_w1_wl
+ u_t000_015/r0_w0_wl u_t001_009/c0_r0_rbl u_t000_011/c3_w0_bl u_t004_008/c2_w0_bl
+ u_t001_015/r3_r0_rwl u_t001_000/r3_r1_rwl u_t001_014/c1_r1_rbl u_t001_004/c0_w1_bl
+ u_t001_001/c2_r1_rbl u_t001_003/c3_r0_rbl u_t005_000/r3_w1_wl u_t001_007/c3_w1_bl
+ m4_10808_10138# u_t013_001/r1_w1_wl u_t001_001/c2_w1_br a_200_31000# u_t001_001/r0_w1_wl
+ a_22600_14200# u_t001_006/c2_w0_bl u_t005_015/r1_w0_wl u_t000_006/c1_w0_br u_t001_000/c1_w0_br
+ u_t001_004/r3_w1_wl u_t015_010/c2_w0_bl u_t001_013/c2_w1_bl a_22600_5800# u_t000_012/c0_r0_rbl
+ a_14200_47800# u_t000_002/c2_w0_bl u_t000_013/c1_w1_br u_t013_012/c2_w0_bl u_t000_000/r3_w1_wl
+ u_t000_015/VSS u_t000_011/VDD u_t001_012/c1_w0_bl u_t000_012/c0_w0_br u_t000_005/r2_r1_rwl
+ u_t001_005/c0_r0_rbl gf180mcu_as_sc_mcu7t3v3__inv_2_574/A u_t011_014/c2_w0_bl u_t000_006/c1_r1_rbl
+ u_t012_015/r2_w0_wl u_t009_014/c2_w0_bl u_t001_011/r3_r0_rwl u_t006_001/r1_w1_wl
+ u_t000_015/r1_w0_wl u_t001_010/c1_r1_rbl u_t014_008/c2_w1_bl u_t001_012/c2_r0_rbl
+ u_t015_002/c2_w1_bl u_t000_013/c3_r1_rbl u_t010_010/c2_w0_bl u_t001_008/c0_w1_br
+ a_200_11400# u_t008_010/c2_w0_bl u_t013_004/c2_w1_bl u_t001_004/c1_w1_bl u_t000_004/c0_w1_br
+ u_t001_006/c3_r1_rbl u_t006_012/c2_w0_bl u_t000_009/c0_w0_bl u_t011_006/c2_w1_bl
+ gf180mcu_as_sc_mcu7t3v3__inv_2_930/A u_t001_003/c0_w0_bl u_t009_006/c2_w1_bl u_t000_007/c3_w1_br
+ u_t013_001/r2_w1_wl u_t001_001/c3_w1_br u_t004_014/c2_w0_bl u_t001_001/r1_w1_wl
+ u_t001_006/c3_w0_bl u_t005_015/r2_w0_wl u_t010_002/c2_w1_bl u_t001_010/c0_w1_bl
+ u_t007_008/c2_w1_bl u_t001_000/c2_w0_br u_t001_000/r0_w0_wl u_t008_002/c2_w1_bl
+ u_t003_010/c2_w0_bl u_t000_001/r2_r1_rwl u_t001_013/c3_w1_bl u_t001_001/c0_r0_rbl
+ u_t006_004/c2_w1_bl u_t000_004/c2_r0_rbl a_14200_56200# u_t001_012/c2_w0_bl u_t001_007/r1_r1_rwl
+ u_t001_010/r3_w1_wl u_t004_006/c2_w1_bl u_t001_008/c0_r1_rbl u_t012_015/r3_w0_wl
+ gf180mcu_as_sc_mcu7t3v3__inv_2_611/Y u_t000_015/r2_w0_wl u_t001_014/r3_r1_rwl u_t006_001/r2_w1_wl
+ gf180mcu_as_sc_mcu7t3v3__inv_2_589/A u_t002_008/c2_w1_bl u_t001_002/c3_r1_rbl u_t003_002/c2_w1_bl
+ u_t001_008/c1_w1_br u_t001_007/c0_w0_br u_t001_004/c2_w1_bl u_t012_009/c2_w0_bl
+ u_t001_003/c1_w0_bl VSUBS u_t001_014/c0_w1_br u_t000_003/c0_w0_br u_t013_001/r3_w1_wl
+ u_t000_000/c2_w1_bl u_t000_007/r2_w1_wl u_t011_000/r0_w1_wl gf180mcu_as_sc_mcu7t3v3__inv_2_776/Y
+ a_14200_36600# a_200_59000# u_t000_011/c0_r1_rbl u_t001_001/r2_w1_wl u_t000_013/c1_r0_rbl
+ u_t005_015/r3_w0_wl u_t013_010/c2_w1_bl u_t000_006/c3_w0_br u_t001_010/c1_w1_bl
+ u_t000_006/r1_w0_wl u_t000_010/c0_w1_br u_t001_000/c3_w0_br u_t001_003/r1_r1_rwl
+ gf180mcu_as_sc_mcu7t3v3__inv_2_562/A u_t001_004/c0_r1_rbl VSS
Xgf180mcu_as_sc_mcu7t3v3__inv_2_814 VSS VSS VSS VSS gf180mcu_as_sc_mcu7t3v3__inv_2_815/VNW
+ VSUBS gf180mcu_as_sc_mcu7t3v3__inv_2
Xgf180mcu_as_sc_mcu7t3v3__inv_2_803 gf180mcu_as_sc_mcu7t3v3__inv_2_803/VDD VSS gf180mcu_as_sc_mcu7t3v3__inv_2_803/Y
+ VSS gf180mcu_as_sc_mcu7t3v3__inv_2_803/VNW VSUBS gf180mcu_as_sc_mcu7t3v3__inv_2
Xgf180mcu_as_sc_mcu7t3v3__inv_2_825 gf180mcu_as_sc_mcu7t3v3__inv_2_827/VDD gf180mcu_as_sc_mcu7t3v3__inv_2_830/VSS
+ gf180mcu_as_sc_mcu7t3v3__inv_2_825/Y VSS gf180mcu_as_sc_mcu7t3v3__inv_2_827/VNW
+ VSUBS gf180mcu_as_sc_mcu7t3v3__inv_2
Xgf180mcu_as_sc_mcu7t3v3__inv_2_836 gf180mcu_as_sc_mcu7t3v3__inv_2_836/VDD gf180mcu_as_sc_mcu7t3v3__inv_2_839/VDD
+ gf180mcu_as_sc_mcu7t3v3__inv_2_836/Y VSS gf180mcu_as_sc_mcu7t3v3__inv_2_836/VNW
+ VSUBS gf180mcu_as_sc_mcu7t3v3__inv_2
Xgf180mcu_as_sc_mcu7t3v3__inv_2_869 gf180mcu_as_sc_mcu7t3v3__inv_2_869/VDD VSS VSS
+ VSS gf180mcu_as_sc_mcu7t3v3__inv_2_869/VNW VSUBS gf180mcu_as_sc_mcu7t3v3__inv_2
Xgf180mcu_as_sc_mcu7t3v3__inv_2_858 gf180mcu_as_sc_mcu7t3v3__inv_2_860/VDD gf180mcu_as_sc_mcu7t3v3__inv_2_863/VDD
+ gf180mcu_as_sc_mcu7t3v3__inv_2_858/Y VSS gf180mcu_as_sc_mcu7t3v3__inv_2_860/VNW
+ VSUBS gf180mcu_as_sc_mcu7t3v3__inv_2
Xgf180mcu_as_sc_mcu7t3v3__inv_2_847 gf180mcu_as_sc_mcu7t3v3__inv_2_848/VDD gf180mcu_as_sc_mcu7t3v3__inv_2_854/VDD
+ gf180mcu_as_sc_mcu7t3v3__inv_2_847/Y VSS gf180mcu_as_sc_mcu7t3v3__inv_2_848/VNW
+ VSUBS gf180mcu_as_sc_mcu7t3v3__inv_2
Xgf180mcu_as_sc_mcu7t3v3__nand4_2_113 VSS VSS VSS VSS VSS VSS gf180mcu_as_sc_mcu7t3v3__nand4_2_113/Y
+ gf180mcu_as_sc_mcu7t3v3__inv_2_443/VNW VSUBS gf180mcu_as_sc_mcu7t3v3__nand4_2
Xgf180mcu_as_sc_mcu7t3v3__nand4_2_102 VSS VSS VSS VSS VSS VSS VSS gf180mcu_as_sc_mcu7t3v3__inv_2_410/VNW
+ VSUBS gf180mcu_as_sc_mcu7t3v3__nand4_2
Xgf180mcu_as_sc_mcu7t3v3__nand4_2_135 VSS VSS VSS VSS VSS VSS gf180mcu_as_sc_mcu7t3v3__nand4_2_135/Y
+ gf180mcu_as_sc_mcu7t3v3__inv_2_507/VNW VSUBS gf180mcu_as_sc_mcu7t3v3__nand4_2
Xgf180mcu_as_sc_mcu7t3v3__nand4_2_146 gf180mcu_as_sc_mcu7t3v3__inv_2_540/VDD gf180mcu_as_sc_mcu7t3v3__inv_2_543/VDD
+ VSS VSS VSS VSS VSS gf180mcu_as_sc_mcu7t3v3__inv_2_540/VNW VSUBS gf180mcu_as_sc_mcu7t3v3__nand4_2
Xgf180mcu_as_sc_mcu7t3v3__nand4_2_124 VSS VSS VSS VSS VSS VSS VSS gf180mcu_as_sc_mcu7t3v3__inv_2_474/VNW
+ VSUBS gf180mcu_as_sc_mcu7t3v3__nand4_2
Xgf180mcu_as_sc_mcu7t3v3__nand4_2_157 VSS VSS VSS VSS VSS VSS VSS gf180mcu_as_sc_mcu7t3v3__inv_2_573/VNW
+ VSUBS gf180mcu_as_sc_mcu7t3v3__nand4_2
Xgf180mcu_as_sc_mcu7t3v3__nand4_2_168 gf180mcu_as_sc_mcu7t3v3__inv_2_609/VDD gf180mcu_as_sc_mcu7t3v3__inv_2_612/VDD
+ VSS VSS VSS VSS VSS gf180mcu_as_sc_mcu7t3v3__inv_2_609/VNW VSUBS gf180mcu_as_sc_mcu7t3v3__nand4_2
Xgf180mcu_as_sc_mcu7t3v3__nand4_2_179 VSS VSS VSS VSS VSS VSS gf180mcu_as_sc_mcu7t3v3__nand4_2_179/Y
+ gf180mcu_as_sc_mcu7t3v3__inv_2_716/VNW VSUBS gf180mcu_as_sc_mcu7t3v3__nand4_2
Xgf180mcu_as_sc_mcu7t3v3__nand4_2_41 gf180mcu_as_sc_mcu7t3v3__inv_2_123/VDD gf180mcu_as_sc_mcu7t3v3__inv_2_177/VDD
+ VSS VSS VSS VSS VSS gf180mcu_as_sc_mcu7t3v3__inv_2_123/VNW VSUBS gf180mcu_as_sc_mcu7t3v3__nand4_2
Xgf180mcu_as_sc_mcu7t3v3__nand4_2_63 VSS VSS VSS VSS VSS VSS VSS gf180mcu_as_sc_mcu7t3v3__inv_2_290/VNW
+ VSUBS gf180mcu_as_sc_mcu7t3v3__nand4_2
Xgf180mcu_as_sc_mcu7t3v3__nand4_2_74 gf180mcu_as_sc_mcu7t3v3__inv_2_338/VDD VSS VSS
+ VSS VSS VSS VSS gf180mcu_as_sc_mcu7t3v3__inv_2_338/VNW VSUBS gf180mcu_as_sc_mcu7t3v3__nand4_2
Xgf180mcu_as_sc_mcu7t3v3__nand4_2_96 VSS VSS VSS VSS VSS VSS VSS gf180mcu_as_sc_mcu7t3v3__inv_2_390/VNW
+ VSUBS gf180mcu_as_sc_mcu7t3v3__nand4_2
Xgf180mcu_as_sc_mcu7t3v3__nand4_2_52 gf180mcu_as_sc_mcu7t3v3__inv_2_159/VDD gf180mcu_as_sc_mcu7t3v3__inv_2_159/VDD
+ VSS VSS VSS VSS VSS gf180mcu_as_sc_mcu7t3v3__inv_2_156/VNW VSUBS gf180mcu_as_sc_mcu7t3v3__nand4_2
Xgf180mcu_as_sc_mcu7t3v3__nand4_2_30 VSS gf180mcu_as_sc_mcu7t3v3__inv_2_93/VDD VSS
+ VSS VSS VSS gf180mcu_as_sc_mcu7t3v3__nand4_2_30/Y gf180mcu_as_sc_mcu7t3v3__inv_2_90/VNW
+ VSUBS gf180mcu_as_sc_mcu7t3v3__nand4_2
Xgf180mcu_as_sc_mcu7t3v3__nand4_2_85 gf180mcu_as_sc_mcu7t3v3__inv_2_932/VSS VSS VSS
+ VSS VSS VSS VSS gf180mcu_as_sc_mcu7t3v3__inv_2_357/VNW VSUBS gf180mcu_as_sc_mcu7t3v3__nand4_2
Xgf180mcu_as_sc_mcu7t3v3__inv_2_633 VSS VSS VSS VSS gf180mcu_as_sc_mcu7t3v3__inv_2_634/VNW
+ VSUBS gf180mcu_as_sc_mcu7t3v3__inv_2
Xgf180mcu_as_sc_mcu7t3v3__inv_2_622 VSS VSS VSS VSS gf180mcu_as_sc_mcu7t3v3__inv_2_622/VNW
+ VSUBS gf180mcu_as_sc_mcu7t3v3__inv_2
Xgf180mcu_as_sc_mcu7t3v3__inv_2_611 gf180mcu_as_sc_mcu7t3v3__inv_2_612/VDD VSS gf180mcu_as_sc_mcu7t3v3__inv_2_611/Y
+ gf180mcu_as_sc_mcu7t3v3__inv_2_612/Y gf180mcu_as_sc_mcu7t3v3__inv_2_612/VNW VSUBS
+ gf180mcu_as_sc_mcu7t3v3__inv_2
Xgf180mcu_as_sc_mcu7t3v3__inv_2_600 gf180mcu_as_sc_mcu7t3v3__inv_2_600/VDD gf180mcu_as_sc_mcu7t3v3__inv_2_603/VDD
+ gf180mcu_as_sc_mcu7t3v3__inv_2_600/Y VSS gf180mcu_as_sc_mcu7t3v3__inv_2_600/VNW
+ VSUBS gf180mcu_as_sc_mcu7t3v3__inv_2
Xgf180mcu_as_sc_mcu7t3v3__inv_2_644 VSS VSS VSS VSS gf180mcu_as_sc_mcu7t3v3__inv_2_645/VNW
+ VSUBS gf180mcu_as_sc_mcu7t3v3__inv_2
Xgf180mcu_as_sc_mcu7t3v3__inv_2_666 gf180mcu_as_sc_mcu7t3v3__inv_2_713/VDD gf180mcu_as_sc_mcu7t3v3__nor2_2_8/VSS
+ VSS VSS gf180mcu_as_sc_mcu7t3v3__inv_2_713/VNW VSUBS gf180mcu_as_sc_mcu7t3v3__inv_2
Xgf180mcu_as_sc_mcu7t3v3__inv_2_655 gf180mcu_as_sc_mcu7t3v3__inv_2_713/VDD gf180mcu_as_sc_mcu7t3v3__nor2_2_8/VSS
+ VSS VSS gf180mcu_as_sc_mcu7t3v3__inv_2_713/VNW VSUBS gf180mcu_as_sc_mcu7t3v3__inv_2
Xgf180mcu_as_sc_mcu7t3v3__inv_2_677 gf180mcu_as_sc_mcu7t3v3__inv_2_713/VDD gf180mcu_as_sc_mcu7t3v3__nor2_2_8/VSS
+ VSS VSS gf180mcu_as_sc_mcu7t3v3__inv_2_713/VNW VSUBS gf180mcu_as_sc_mcu7t3v3__inv_2
Xgf180mcu_as_sc_mcu7t3v3__inv_2_688 gf180mcu_as_sc_mcu7t3v3__nor2_2_8/VDD gf180mcu_as_sc_mcu7t3v3__inv_2_710/VSS
+ VSS VSS gf180mcu_as_sc_mcu7t3v3__nor2_2_8/VNW VSUBS gf180mcu_as_sc_mcu7t3v3__inv_2
Xu_t008_007 u_t008_007/c0_w0_bl u_t008_007/c0_w0_br u_t008_007/c0_w1_bl u_t008_007/c0_w1_br
+ u_t008_007/c0_r0_rbl u_t008_007/c0_r1_rbl u_t008_007/c1_w0_bl u_t008_007/c1_w0_br
+ u_t008_007/c1_w1_bl u_t008_007/c1_w1_br u_t008_007/c1_r0_rbl u_t008_007/c1_r1_rbl
+ u_t008_007/c2_w0_bl u_t008_007/c2_w0_br u_t008_007/c2_w1_bl u_t008_007/c2_w1_br
+ u_t008_007/c2_r0_rbl u_t008_007/c2_r1_rbl u_t008_007/c3_w0_bl u_t008_007/c3_w0_br
+ u_t008_007/c3_w1_bl u_t008_007/c3_w1_br u_t008_007/c3_r0_rbl u_t008_007/c3_r1_rbl
+ u_t008_007/r0_w0_wl u_t008_007/r0_w1_wl u_t008_007/r0_r0_rwl u_t008_007/r0_r1_rwl
+ u_t008_007/r1_w0_wl u_t008_007/r1_w1_wl u_t008_007/r1_r0_rwl u_t008_007/r1_r1_rwl
+ u_t008_007/r2_w0_wl u_t008_007/r2_w1_wl u_t008_007/r2_r0_rwl u_t008_007/r2_r1_rwl
+ u_t008_007/r3_w0_wl u_t008_007/r3_w1_wl u_t008_007/r3_r0_rwl u_t008_007/r3_r1_rwl
+ VSS u_t008_015/VSS VSUBS detronyx_12t_2w2r_rc4_4x4_routed_5layer_direct
Xgf180mcu_as_sc_mcu7t3v3__inv_2_699 gf180mcu_as_sc_mcu7t3v3__inv_2_713/VDD gf180mcu_as_sc_mcu7t3v3__inv_2_713/VSS
+ gf180mcu_as_sc_mcu7t3v3__inv_2_699/Y VSS gf180mcu_as_sc_mcu7t3v3__inv_2_713/VNW
+ VSUBS gf180mcu_as_sc_mcu7t3v3__inv_2
Xu_t013_010 u_t013_010/c0_w0_bl u_t013_010/c0_w0_br u_t013_010/c0_w1_bl u_t013_010/c0_w1_br
+ u_t013_010/c0_r0_rbl u_t013_010/c0_r1_rbl u_t013_010/c1_w0_bl u_t013_010/c1_w0_br
+ u_t013_010/c1_w1_bl u_t013_010/c1_w1_br u_t013_010/c1_r0_rbl u_t013_010/c1_r1_rbl
+ u_t013_010/c2_w0_bl u_t013_010/c2_w0_br u_t013_010/c2_w1_bl u_t013_010/c2_w1_br
+ u_t013_010/c2_r0_rbl u_t013_010/c2_r1_rbl u_t013_010/c3_w0_bl u_t013_010/c3_w0_br
+ u_t013_010/c3_w1_bl u_t013_010/c3_w1_br u_t013_010/c3_r0_rbl u_t013_010/c3_r1_rbl
+ u_t013_010/r0_w0_wl u_t013_010/r0_w1_wl u_t013_010/r0_r0_rwl u_t013_010/r0_r1_rwl
+ u_t013_010/r1_w0_wl u_t013_010/r1_w1_wl u_t013_010/r1_r0_rwl u_t013_010/r1_r1_rwl
+ u_t013_010/r2_w0_wl u_t013_010/r2_w1_wl u_t013_010/r2_r0_rwl u_t013_010/r2_r1_rwl
+ u_t013_010/r3_w0_wl u_t013_010/r3_w1_wl u_t013_010/r3_r0_rwl u_t013_010/r3_r1_rwl
+ VSS u_t013_015/VSS VSUBS detronyx_12t_2w2r_rc4_4x4_routed_5layer_direct
Xgf180mcu_as_sc_mcu7t3v3__inv_2_463 VSS VSS VSS VSS gf180mcu_as_sc_mcu7t3v3__inv_2_465/VNW
+ VSUBS gf180mcu_as_sc_mcu7t3v3__inv_2
Xgf180mcu_as_sc_mcu7t3v3__inv_2_452 VSS VSS VSS VSS gf180mcu_as_sc_mcu7t3v3__inv_2_452/VNW
+ VSUBS gf180mcu_as_sc_mcu7t3v3__inv_2
Xgf180mcu_as_sc_mcu7t3v3__inv_2_441 VSS VSS VSS VSS gf180mcu_as_sc_mcu7t3v3__inv_2_443/VNW
+ VSUBS gf180mcu_as_sc_mcu7t3v3__inv_2
Xgf180mcu_as_sc_mcu7t3v3__inv_2_430 VSS VSS VSS VSS gf180mcu_as_sc_mcu7t3v3__inv_2_431/VNW
+ VSUBS gf180mcu_as_sc_mcu7t3v3__inv_2
Xgf180mcu_as_sc_mcu7t3v3__inv_2_496 VSS VSS VSS VSS gf180mcu_as_sc_mcu7t3v3__inv_2_498/VNW
+ VSUBS gf180mcu_as_sc_mcu7t3v3__inv_2
Xgf180mcu_as_sc_mcu7t3v3__inv_2_485 VSS VSS VSS VSS gf180mcu_as_sc_mcu7t3v3__inv_2_486/VNW
+ VSUBS gf180mcu_as_sc_mcu7t3v3__inv_2
Xgf180mcu_as_sc_mcu7t3v3__inv_2_474 VSS VSS VSS VSS gf180mcu_as_sc_mcu7t3v3__inv_2_474/VNW
+ VSUBS gf180mcu_as_sc_mcu7t3v3__inv_2
Xu_t004_010 u_t004_010/c0_w0_bl u_t004_010/c0_w0_br u_t004_010/c0_w1_bl u_t004_010/c0_w1_br
+ u_t004_010/c0_r0_rbl u_t004_010/c0_r1_rbl u_t004_010/c1_w0_bl u_t004_010/c1_w0_br
+ u_t004_010/c1_w1_bl u_t004_010/c1_w1_br u_t004_010/c1_r0_rbl u_t004_010/c1_r1_rbl
+ u_t004_010/c2_w0_bl u_t004_010/c2_w0_br u_t004_010/c2_w1_bl u_t004_010/c2_w1_br
+ u_t004_010/c2_r0_rbl u_t004_010/c2_r1_rbl u_t004_010/c3_w0_bl u_t004_010/c3_w0_br
+ u_t004_010/c3_w1_bl u_t004_010/c3_w1_br u_t004_010/c3_r0_rbl u_t004_010/c3_r1_rbl
+ u_t004_010/r0_w0_wl u_t004_010/r0_w1_wl u_t004_010/r0_r0_rwl u_t004_010/r0_r1_rwl
+ u_t004_010/r1_w0_wl u_t004_010/r1_w1_wl u_t004_010/r1_r0_rwl u_t004_010/r1_r1_rwl
+ u_t004_010/r2_w0_wl u_t004_010/r2_w1_wl u_t004_010/r2_r0_rwl u_t004_010/r2_r1_rwl
+ u_t004_010/r3_w0_wl u_t004_010/r3_w1_wl u_t004_010/r3_r0_rwl u_t004_010/r3_r1_rwl
+ VSS u_t004_015/VSS VSUBS detronyx_12t_2w2r_rc4_4x4_routed_5layer_direct
Xu_t010_013 u_t010_013/c0_w0_bl u_t010_013/c0_w0_br u_t010_013/c0_w1_bl u_t010_013/c0_w1_br
+ u_t010_013/c0_r0_rbl u_t010_013/c0_r1_rbl u_t010_013/c1_w0_bl u_t010_013/c1_w0_br
+ u_t010_013/c1_w1_bl u_t010_013/c1_w1_br u_t010_013/c1_r0_rbl u_t010_013/c1_r1_rbl
+ u_t010_013/c2_w0_bl u_t010_013/c2_w0_br u_t010_013/c2_w1_bl u_t010_013/c2_w1_br
+ u_t010_013/c2_r0_rbl u_t010_013/c2_r1_rbl u_t010_013/c3_w0_bl u_t010_013/c3_w0_br
+ u_t010_013/c3_w1_bl u_t010_013/c3_w1_br u_t010_013/c3_r0_rbl u_t010_013/c3_r1_rbl
+ u_t010_013/r0_w0_wl u_t010_013/r0_w1_wl u_t010_013/r0_r0_rwl u_t010_013/r0_r1_rwl
+ u_t010_013/r1_w0_wl u_t010_013/r1_w1_wl u_t010_013/r1_r0_rwl u_t010_013/r1_r1_rwl
+ u_t010_013/r2_w0_wl u_t010_013/r2_w1_wl u_t010_013/r2_r0_rwl u_t010_013/r2_r1_rwl
+ u_t010_013/r3_w0_wl u_t010_013/r3_w1_wl u_t010_013/r3_r0_rwl u_t010_013/r3_r1_rwl
+ u_t010_013/VDD u_t010_013/VSS VSUBS detronyx_12t_2w2r_rc4_4x4_routed_5layer_direct
Xu_t010_002 u_t010_002/c0_w0_bl u_t010_002/c0_w0_br u_t010_002/c0_w1_bl u_t010_002/c0_w1_br
+ u_t010_002/c0_r0_rbl u_t010_002/c0_r1_rbl u_t010_002/c1_w0_bl u_t010_002/c1_w0_br
+ u_t010_002/c1_w1_bl u_t010_002/c1_w1_br u_t010_002/c1_r0_rbl u_t010_002/c1_r1_rbl
+ u_t010_002/c2_w0_bl u_t010_002/c2_w0_br u_t010_002/c2_w1_bl u_t010_002/c2_w1_br
+ u_t010_002/c2_r0_rbl u_t010_002/c2_r1_rbl u_t010_002/c3_w0_bl u_t010_002/c3_w0_br
+ u_t010_002/c3_w1_bl u_t010_002/c3_w1_br u_t010_002/c3_r0_rbl u_t010_002/c3_r1_rbl
+ u_t010_002/r0_w0_wl u_t010_002/r0_w1_wl u_t010_002/r0_r0_rwl u_t010_002/r0_r1_rwl
+ u_t010_002/r1_w0_wl u_t010_002/r1_w1_wl u_t010_002/r1_r0_rwl u_t010_002/r1_r1_rwl
+ u_t010_002/r2_w0_wl u_t010_002/r2_w1_wl u_t010_002/r2_r0_rwl u_t010_002/r2_r1_rwl
+ u_t010_002/r3_w0_wl u_t010_002/r3_w1_wl u_t010_002/r3_r0_rwl u_t010_002/r3_r1_rwl
+ VSS u_t010_002/VSS VSUBS detronyx_12t_2w2r_rc4_4x4_routed_5layer_direct
Xu_t001_002 u_t001_002/c0_w0_bl u_t001_002/c0_w0_br u_t001_002/c0_w1_bl u_t001_002/c0_w1_br
+ u_t001_002/c0_r0_rbl u_t001_002/c0_r1_rbl u_t001_002/c1_w0_bl u_t001_002/c1_w0_br
+ u_t001_002/c1_w1_bl u_t001_002/c1_w1_br u_t001_002/c1_r0_rbl u_t001_002/c1_r1_rbl
+ u_t001_002/c2_w0_bl u_t001_002/c2_w0_br u_t001_002/c2_w1_bl u_t001_002/c2_w1_br
+ u_t001_002/c2_r0_rbl u_t001_002/c2_r1_rbl u_t001_002/c3_w0_bl u_t001_002/c3_w0_br
+ u_t001_002/c3_w1_bl u_t001_002/c3_w1_br u_t001_002/c3_r0_rbl u_t001_002/c3_r1_rbl
+ u_t001_002/r0_w0_wl u_t001_002/r0_w1_wl u_t001_002/r0_r0_rwl u_t001_002/r0_r1_rwl
+ u_t001_002/r1_w0_wl u_t001_002/r1_w1_wl u_t001_002/r1_r0_rwl u_t001_002/r1_r1_rwl
+ u_t001_002/r2_w0_wl u_t001_002/r2_w1_wl u_t001_002/r2_r0_rwl u_t001_002/r2_r1_rwl
+ u_t001_002/r3_w0_wl u_t001_002/r3_w1_wl u_t001_002/r3_r0_rwl u_t001_002/r3_r1_rwl
+ VSS u_t001_015/VSS VSUBS detronyx_12t_2w2r_rc4_4x4_routed_5layer_direct
Xu_t001_013 u_t001_013/c0_w0_bl u_t001_013/c0_w0_br u_t001_013/c0_w1_bl u_t001_013/c0_w1_br
+ u_t001_013/c0_r0_rbl u_t001_013/c0_r1_rbl u_t001_013/c1_w0_bl u_t001_013/c1_w0_br
+ u_t001_013/c1_w1_bl u_t001_013/c1_w1_br u_t001_013/c1_r0_rbl u_t001_013/c1_r1_rbl
+ u_t001_013/c2_w0_bl u_t001_013/c2_w0_br u_t001_013/c2_w1_bl u_t001_013/c2_w1_br
+ u_t001_013/c2_r0_rbl u_t001_013/c2_r1_rbl u_t001_013/c3_w0_bl u_t001_013/c3_w0_br
+ u_t001_013/c3_w1_bl u_t001_013/c3_w1_br u_t001_013/c3_r0_rbl u_t001_013/c3_r1_rbl
+ u_t001_013/r0_w0_wl u_t001_013/r0_w1_wl u_t001_013/r0_r0_rwl u_t001_013/r0_r1_rwl
+ u_t001_013/r1_w0_wl u_t001_013/r1_w1_wl u_t001_013/r1_r0_rwl u_t001_013/r1_r1_rwl
+ u_t001_013/r2_w0_wl u_t001_013/r2_w1_wl u_t001_013/r2_r0_rwl u_t001_013/r2_r1_rwl
+ u_t001_013/r3_w0_wl u_t001_013/r3_w1_wl u_t001_013/r3_r0_rwl u_t001_013/r3_r1_rwl
+ u_t001_013/VDD u_t001_015/VSS VSUBS detronyx_12t_2w2r_rc4_4x4_routed_5layer_direct
Xgf180mcu_as_sc_mcu7t3v3__inv_2_293 VSS VSS VSS VSS gf180mcu_as_sc_mcu7t3v3__inv_2_294/VNW
+ VSUBS gf180mcu_as_sc_mcu7t3v3__inv_2
Xgf180mcu_as_sc_mcu7t3v3__inv_2_282 gf180mcu_as_sc_mcu7t3v3__nor2_2_5/VDD gf180mcu_as_sc_mcu7t3v3__nor2_2_5/VSS
+ VSS VSS gf180mcu_as_sc_mcu7t3v3__nor2_2_5/VNW VSUBS gf180mcu_as_sc_mcu7t3v3__inv_2
Xgf180mcu_as_sc_mcu7t3v3__inv_2_260 gf180mcu_as_sc_mcu7t3v3__nor2_2_4/VDD gf180mcu_as_sc_mcu7t3v3__nand3_2_8/VSS
+ VSS VSS gf180mcu_as_sc_mcu7t3v3__nor2_2_4/VNW VSUBS gf180mcu_as_sc_mcu7t3v3__inv_2
Xgf180mcu_as_sc_mcu7t3v3__inv_2_271 gf180mcu_as_sc_mcu7t3v3__nor2_2_6/VDD gf180mcu_as_sc_mcu7t3v3__nand3_2_1/VSS
+ VSS VSS gf180mcu_as_sc_mcu7t3v3__nor2_2_6/VNW VSUBS gf180mcu_as_sc_mcu7t3v3__inv_2
Xgf180mcu_as_sc_mcu7t3v3__inv_2_19 VSS VSS VSS gf180mcu_as_sc_mcu7t3v3__inv_2_27/Y
+ gf180mcu_as_sc_mcu7t3v3__inv_2_21/VNW VSUBS gf180mcu_as_sc_mcu7t3v3__inv_2
Xgf180mcu_as_sc_mcu7t3v3__nand2_2_0 gf180mcu_as_sc_mcu7t3v3__nand2_2_9/VDD gf180mcu_as_sc_mcu7t3v3__nor2_2_4/VSS
+ VSS VSS VSS gf180mcu_as_sc_mcu7t3v3__nand2_2_9/VNW VSUBS gf180mcu_as_sc_mcu7t3v3__nand2_2
Xgf180mcu_as_sc_mcu7t3v3__inv_2_815 VSS VSS VSS VSS gf180mcu_as_sc_mcu7t3v3__inv_2_815/VNW
+ VSUBS gf180mcu_as_sc_mcu7t3v3__inv_2
Xgf180mcu_as_sc_mcu7t3v3__inv_2_804 VSS VSS gf180mcu_as_sc_mcu7t3v3__inv_2_804/Y VSS
+ gf180mcu_as_sc_mcu7t3v3__inv_2_806/VNW VSUBS gf180mcu_as_sc_mcu7t3v3__inv_2
Xgf180mcu_as_sc_mcu7t3v3__inv_2_826 gf180mcu_as_sc_mcu7t3v3__inv_2_827/VDD gf180mcu_as_sc_mcu7t3v3__inv_2_830/VSS
+ gf180mcu_as_sc_mcu7t3v3__inv_2_826/Y VSS gf180mcu_as_sc_mcu7t3v3__inv_2_827/VNW
+ VSUBS gf180mcu_as_sc_mcu7t3v3__inv_2
Xgf180mcu_as_sc_mcu7t3v3__inv_2_859 gf180mcu_as_sc_mcu7t3v3__inv_2_860/VDD gf180mcu_as_sc_mcu7t3v3__inv_2_863/VDD
+ VSS VSS gf180mcu_as_sc_mcu7t3v3__inv_2_860/VNW VSUBS gf180mcu_as_sc_mcu7t3v3__inv_2
Xgf180mcu_as_sc_mcu7t3v3__inv_2_848 gf180mcu_as_sc_mcu7t3v3__inv_2_848/VDD gf180mcu_as_sc_mcu7t3v3__inv_2_854/VDD
+ gf180mcu_as_sc_mcu7t3v3__inv_2_848/Y VSS gf180mcu_as_sc_mcu7t3v3__inv_2_848/VNW
+ VSUBS gf180mcu_as_sc_mcu7t3v3__inv_2
Xgf180mcu_as_sc_mcu7t3v3__inv_2_837 gf180mcu_as_sc_mcu7t3v3__inv_2_839/VDD gf180mcu_as_sc_mcu7t3v3__inv_2_845/VDD
+ gf180mcu_as_sc_mcu7t3v3__inv_2_837/Y VSS gf180mcu_as_sc_mcu7t3v3__inv_2_839/VNW
+ VSUBS gf180mcu_as_sc_mcu7t3v3__inv_2
Xgf180mcu_as_sc_mcu7t3v3__nand4_2_20 VSS gf180mcu_as_sc_mcu7t3v3__inv_2_63/VDD VSS
+ VSS VSS VSS VSS gf180mcu_as_sc_mcu7t3v3__inv_2_60/VNW VSUBS gf180mcu_as_sc_mcu7t3v3__nand4_2
Xgf180mcu_as_sc_mcu7t3v3__nand4_2_114 VSS VSS VSS VSS VSS VSS gf180mcu_as_sc_mcu7t3v3__nand4_2_114/Y
+ gf180mcu_as_sc_mcu7t3v3__inv_2_446/VNW VSUBS gf180mcu_as_sc_mcu7t3v3__nand4_2
Xgf180mcu_as_sc_mcu7t3v3__nand4_2_53 gf180mcu_as_sc_mcu7t3v3__inv_2_159/VDD gf180mcu_as_sc_mcu7t3v3__inv_2_162/VDD
+ VSS VSS VSS VSS VSS gf180mcu_as_sc_mcu7t3v3__inv_2_159/VNW VSUBS gf180mcu_as_sc_mcu7t3v3__nand4_2
Xgf180mcu_as_sc_mcu7t3v3__nand4_2_31 gf180mcu_as_sc_mcu7t3v3__inv_2_93/VDD VSS VSS
+ VSS VSS VSS gf180mcu_as_sc_mcu7t3v3__nand4_2_31/Y gf180mcu_as_sc_mcu7t3v3__inv_2_93/VNW
+ VSUBS gf180mcu_as_sc_mcu7t3v3__nand4_2
Xgf180mcu_as_sc_mcu7t3v3__nand4_2_103 VSS VSS VSS VSS VSS VSS VSS gf180mcu_as_sc_mcu7t3v3__inv_2_413/VNW
+ VSUBS gf180mcu_as_sc_mcu7t3v3__nand4_2
Xgf180mcu_as_sc_mcu7t3v3__nand4_2_42 gf180mcu_as_sc_mcu7t3v3__inv_2_923/VSS VSS VSS
+ VSS VSS VSS VSS gf180mcu_as_sc_mcu7t3v3__inv_2_126/VNW VSUBS gf180mcu_as_sc_mcu7t3v3__nand4_2
Xgf180mcu_as_sc_mcu7t3v3__nand4_2_147 gf180mcu_as_sc_mcu7t3v3__inv_2_543/VDD gf180mcu_as_sc_mcu7t3v3__inv_2_546/VDD
+ VSS VSS VSS VSS VSS gf180mcu_as_sc_mcu7t3v3__inv_2_543/VNW VSUBS gf180mcu_as_sc_mcu7t3v3__nand4_2
Xgf180mcu_as_sc_mcu7t3v3__nand4_2_125 VSS VSS VSS VSS VSS VSS VSS gf180mcu_as_sc_mcu7t3v3__inv_2_477/VNW
+ VSUBS gf180mcu_as_sc_mcu7t3v3__nand4_2
Xgf180mcu_as_sc_mcu7t3v3__nand4_2_136 VSS VSS VSS VSS VSS VSS VSS gf180mcu_as_sc_mcu7t3v3__inv_2_510/VNW
+ VSUBS gf180mcu_as_sc_mcu7t3v3__nand4_2
Xgf180mcu_as_sc_mcu7t3v3__nand4_2_169 gf180mcu_as_sc_mcu7t3v3__inv_2_612/VDD VSS VSS
+ VSS VSS VSS VSS gf180mcu_as_sc_mcu7t3v3__inv_2_612/VNW VSUBS gf180mcu_as_sc_mcu7t3v3__nand4_2
Xgf180mcu_as_sc_mcu7t3v3__nand4_2_158 gf180mcu_as_sc_mcu7t3v3__inv_2_579/VDD VSS VSS
+ VSS VSS VSS VSS gf180mcu_as_sc_mcu7t3v3__inv_2_579/VNW VSUBS gf180mcu_as_sc_mcu7t3v3__nand4_2
Xgf180mcu_as_sc_mcu7t3v3__nand4_2_75 VSS VSS VSS VSS VSS VSS VSS gf180mcu_as_sc_mcu7t3v3__inv_2_342/VNW
+ VSUBS gf180mcu_as_sc_mcu7t3v3__nand4_2
Xgf180mcu_as_sc_mcu7t3v3__nand4_2_64 VSS VSS VSS VSS VSS VSS gf180mcu_as_sc_mcu7t3v3__nand4_2_64/Y
+ gf180mcu_as_sc_mcu7t3v3__inv_2_294/VNW VSUBS gf180mcu_as_sc_mcu7t3v3__nand4_2
Xgf180mcu_as_sc_mcu7t3v3__nand4_2_97 VSS gf180mcu_as_sc_mcu7t3v3__inv_2_396/VDD VSS
+ VSS VSS VSS VSS gf180mcu_as_sc_mcu7t3v3__inv_2_393/VNW VSUBS gf180mcu_as_sc_mcu7t3v3__nand4_2
Xgf180mcu_as_sc_mcu7t3v3__nand4_2_86 VSS gf180mcu_as_sc_mcu7t3v3__inv_2_363/VDD VSS
+ VSS VSS VSS VSS gf180mcu_as_sc_mcu7t3v3__inv_2_360/VNW VSUBS gf180mcu_as_sc_mcu7t3v3__nand4_2
Xu_t008_008 u_t008_008/c0_w0_bl u_t008_008/c0_w0_br u_t008_008/c0_w1_bl u_t008_008/c0_w1_br
+ u_t008_008/c0_r0_rbl u_t008_008/c0_r1_rbl u_t008_008/c1_w0_bl u_t008_008/c1_w0_br
+ u_t008_008/c1_w1_bl u_t008_008/c1_w1_br u_t008_008/c1_r0_rbl u_t008_008/c1_r1_rbl
+ u_t008_008/c2_w0_bl u_t008_008/c2_w0_br u_t008_008/c2_w1_bl u_t008_008/c2_w1_br
+ u_t008_008/c2_r0_rbl u_t008_008/c2_r1_rbl u_t008_008/c3_w0_bl u_t008_008/c3_w0_br
+ u_t008_008/c3_w1_bl u_t008_008/c3_w1_br u_t008_008/c3_r0_rbl u_t008_008/c3_r1_rbl
+ u_t008_008/r0_w0_wl u_t008_008/r0_w1_wl u_t008_008/r0_r0_rwl u_t008_008/r0_r1_rwl
+ u_t008_008/r1_w0_wl u_t008_008/r1_w1_wl u_t008_008/r1_r0_rwl u_t008_008/r1_r1_rwl
+ u_t008_008/r2_w0_wl u_t008_008/r2_w1_wl u_t008_008/r2_r0_rwl u_t008_008/r2_r1_rwl
+ u_t008_008/r3_w0_wl u_t008_008/r3_w1_wl u_t008_008/r3_r0_rwl u_t008_008/r3_r1_rwl
+ VSS u_t008_015/VSS VSUBS detronyx_12t_2w2r_rc4_4x4_routed_5layer_direct
Xgf180mcu_as_sc_mcu7t3v3__inv_2_634 VSS VSS gf180mcu_as_sc_mcu7t3v3__inv_2_634/Y VSS
+ gf180mcu_as_sc_mcu7t3v3__inv_2_634/VNW VSUBS gf180mcu_as_sc_mcu7t3v3__inv_2
Xgf180mcu_as_sc_mcu7t3v3__inv_2_612 gf180mcu_as_sc_mcu7t3v3__inv_2_612/VDD VSS gf180mcu_as_sc_mcu7t3v3__inv_2_612/Y
+ VSS gf180mcu_as_sc_mcu7t3v3__inv_2_612/VNW VSUBS gf180mcu_as_sc_mcu7t3v3__inv_2
Xgf180mcu_as_sc_mcu7t3v3__inv_2_601 gf180mcu_as_sc_mcu7t3v3__inv_2_603/VDD VSS gf180mcu_as_sc_mcu7t3v3__inv_2_601/Y
+ gf180mcu_as_sc_mcu7t3v3__inv_2_611/Y gf180mcu_as_sc_mcu7t3v3__inv_2_603/VNW VSUBS
+ gf180mcu_as_sc_mcu7t3v3__inv_2
Xgf180mcu_as_sc_mcu7t3v3__inv_2_623 VSS VSS VSS VSS gf180mcu_as_sc_mcu7t3v3__inv_2_625/VNW
+ VSUBS gf180mcu_as_sc_mcu7t3v3__inv_2
Xgf180mcu_as_sc_mcu7t3v3__inv_2_645 VSS VSS gf180mcu_as_sc_mcu7t3v3__inv_2_645/Y VSS
+ gf180mcu_as_sc_mcu7t3v3__inv_2_645/VNW VSUBS gf180mcu_as_sc_mcu7t3v3__inv_2
Xgf180mcu_as_sc_mcu7t3v3__inv_2_667 gf180mcu_as_sc_mcu7t3v3__inv_2_713/VDD gf180mcu_as_sc_mcu7t3v3__inv_2_713/VSS
+ VSS VSS gf180mcu_as_sc_mcu7t3v3__inv_2_713/VNW VSUBS gf180mcu_as_sc_mcu7t3v3__inv_2
Xgf180mcu_as_sc_mcu7t3v3__inv_2_689 gf180mcu_as_sc_mcu7t3v3__nor2_2_8/VDD gf180mcu_as_sc_mcu7t3v3__nor2_2_8/VSS
+ VSS VSS gf180mcu_as_sc_mcu7t3v3__nor2_2_8/VNW VSUBS gf180mcu_as_sc_mcu7t3v3__inv_2
Xgf180mcu_as_sc_mcu7t3v3__inv_2_656 gf180mcu_as_sc_mcu7t3v3__nor2_2_8/VDD gf180mcu_as_sc_mcu7t3v3__inv_2_710/VSS
+ VSS VSS gf180mcu_as_sc_mcu7t3v3__nor2_2_8/VNW VSUBS gf180mcu_as_sc_mcu7t3v3__inv_2
Xgf180mcu_as_sc_mcu7t3v3__inv_2_678 gf180mcu_as_sc_mcu7t3v3__nor2_2_8/VDD gf180mcu_as_sc_mcu7t3v3__inv_2_710/VSS
+ VSS VSS gf180mcu_as_sc_mcu7t3v3__nor2_2_8/VNW VSUBS gf180mcu_as_sc_mcu7t3v3__inv_2
Xu_t013_000 u_t013_000/c0_w0_bl u_t013_000/c0_w0_br u_t013_000/c0_w1_bl u_t013_000/c0_w1_br
+ u_t013_000/c0_r0_rbl u_t013_000/c0_r1_rbl u_t013_000/c1_w0_bl u_t013_000/c1_w0_br
+ u_t013_000/c1_w1_bl u_t013_000/c1_w1_br u_t013_000/c1_r0_rbl u_t013_000/c1_r1_rbl
+ u_t013_000/c2_w0_bl u_t013_000/c2_w0_br u_t013_000/c2_w1_bl u_t013_000/c2_w1_br
+ u_t013_000/c2_r0_rbl u_t013_000/c2_r1_rbl u_t013_000/c3_w0_bl u_t013_000/c3_w0_br
+ u_t013_000/c3_w1_bl u_t013_000/c3_w1_br u_t013_000/c3_r0_rbl u_t013_000/c3_r1_rbl
+ u_t013_000/r0_w0_wl u_t013_000/r0_w1_wl u_t013_000/r0_r0_rwl u_t013_000/r0_r1_rwl
+ u_t013_000/r1_w0_wl u_t013_000/r1_w1_wl u_t013_000/r1_r0_rwl u_t013_000/r1_r1_rwl
+ u_t013_000/r2_w0_wl u_t013_000/r2_w1_wl u_t013_000/r2_r0_rwl u_t013_000/r2_r1_rwl
+ u_t013_000/r3_w0_wl u_t013_000/r3_w1_wl u_t013_000/r3_r0_rwl u_t013_000/r3_r1_rwl
+ VSS u_t013_015/VSS VSUBS detronyx_12t_2w2r_rc4_4x4_routed_5layer_direct
Xu_t013_011 u_t013_011/c0_w0_bl u_t013_011/c0_w0_br u_t013_011/c0_w1_bl u_t013_011/c0_w1_br
+ u_t013_011/c0_r0_rbl u_t013_011/c0_r1_rbl u_t013_011/c1_w0_bl u_t013_011/c1_w0_br
+ u_t013_011/c1_w1_bl u_t013_011/c1_w1_br u_t013_011/c1_r0_rbl u_t013_011/c1_r1_rbl
+ u_t013_011/c2_w0_bl u_t013_011/c2_w0_br u_t013_011/c2_w1_bl u_t013_011/c2_w1_br
+ u_t013_011/c2_r0_rbl u_t013_011/c2_r1_rbl u_t013_011/c3_w0_bl u_t013_011/c3_w0_br
+ u_t013_011/c3_w1_bl u_t013_011/c3_w1_br u_t013_011/c3_r0_rbl u_t013_011/c3_r1_rbl
+ u_t013_011/r0_w0_wl u_t013_011/r0_w1_wl u_t013_011/r0_r0_rwl u_t013_011/r0_r1_rwl
+ u_t013_011/r1_w0_wl u_t013_011/r1_w1_wl u_t013_011/r1_r0_rwl u_t013_011/r1_r1_rwl
+ u_t013_011/r2_w0_wl u_t013_011/r2_w1_wl u_t013_011/r2_r0_rwl u_t013_011/r2_r1_rwl
+ u_t013_011/r3_w0_wl u_t013_011/r3_w1_wl u_t013_011/r3_r0_rwl u_t013_011/r3_r1_rwl
+ u_t013_011/VDD u_t013_015/VSS VSUBS detronyx_12t_2w2r_rc4_4x4_routed_5layer_direct
Xgf180mcu_as_sc_mcu7t3v3__inv_2_420 VSS VSS VSS VSS gf180mcu_as_sc_mcu7t3v3__inv_2_422/VNW
+ VSUBS gf180mcu_as_sc_mcu7t3v3__inv_2
Xgf180mcu_as_sc_mcu7t3v3__inv_2_464 VSS VSS VSS VSS gf180mcu_as_sc_mcu7t3v3__inv_2_465/VNW
+ VSUBS gf180mcu_as_sc_mcu7t3v3__inv_2
Xgf180mcu_as_sc_mcu7t3v3__inv_2_453 VSS VSS VSS VSS gf180mcu_as_sc_mcu7t3v3__inv_2_455/VNW
+ VSUBS gf180mcu_as_sc_mcu7t3v3__inv_2
Xgf180mcu_as_sc_mcu7t3v3__inv_2_442 VSS VSS VSS VSS gf180mcu_as_sc_mcu7t3v3__inv_2_443/VNW
+ VSUBS gf180mcu_as_sc_mcu7t3v3__inv_2
Xgf180mcu_as_sc_mcu7t3v3__inv_2_431 VSS VSS VSS VSS gf180mcu_as_sc_mcu7t3v3__inv_2_431/VNW
+ VSUBS gf180mcu_as_sc_mcu7t3v3__inv_2
Xgf180mcu_as_sc_mcu7t3v3__inv_2_497 VSS VSS VSS VSS gf180mcu_as_sc_mcu7t3v3__inv_2_498/VNW
+ VSUBS gf180mcu_as_sc_mcu7t3v3__inv_2
Xgf180mcu_as_sc_mcu7t3v3__inv_2_486 VSS VSS VSS VSS gf180mcu_as_sc_mcu7t3v3__inv_2_486/VNW
+ VSUBS gf180mcu_as_sc_mcu7t3v3__inv_2
Xgf180mcu_as_sc_mcu7t3v3__inv_2_475 VSS VSS VSS VSS gf180mcu_as_sc_mcu7t3v3__inv_2_477/VNW
+ VSUBS gf180mcu_as_sc_mcu7t3v3__inv_2
Xu_t004_000 u_t004_000/c0_w0_bl u_t004_000/c0_w0_br u_t004_000/c0_w1_bl u_t004_000/c0_w1_br
+ u_t004_000/c0_r0_rbl u_t004_000/c0_r1_rbl u_t004_000/c1_w0_bl u_t004_000/c1_w0_br
+ u_t004_000/c1_w1_bl u_t004_000/c1_w1_br u_t004_000/c1_r0_rbl u_t004_000/c1_r1_rbl
+ u_t004_000/c2_w0_bl u_t004_000/c2_w0_br u_t004_000/c2_w1_bl u_t004_000/c2_w1_br
+ u_t004_000/c2_r0_rbl u_t004_000/c2_r1_rbl u_t004_000/c3_w0_bl u_t004_000/c3_w0_br
+ u_t004_000/c3_w1_bl u_t004_000/c3_w1_br u_t004_000/c3_r0_rbl u_t004_000/c3_r1_rbl
+ u_t004_000/r0_w0_wl u_t004_000/r0_w1_wl u_t004_000/r0_r0_rwl u_t004_000/r0_r1_rwl
+ u_t004_000/r1_w0_wl u_t004_000/r1_w1_wl u_t004_000/r1_r0_rwl u_t004_000/r1_r1_rwl
+ u_t004_000/r2_w0_wl u_t004_000/r2_w1_wl u_t004_000/r2_r0_rwl u_t004_000/r2_r1_rwl
+ u_t004_000/r3_w0_wl u_t004_000/r3_w1_wl u_t004_000/r3_r0_rwl u_t004_000/r3_r1_rwl
+ VSS u_t004_015/VSS VSUBS detronyx_12t_2w2r_rc4_4x4_routed_5layer_direct
Xu_t004_011 u_t004_011/c0_w0_bl u_t004_011/c0_w0_br u_t004_011/c0_w1_bl u_t004_011/c0_w1_br
+ u_t004_011/c0_r0_rbl u_t004_011/c0_r1_rbl u_t004_011/c1_w0_bl u_t004_011/c1_w0_br
+ u_t004_011/c1_w1_bl u_t004_011/c1_w1_br u_t004_011/c1_r0_rbl u_t004_011/c1_r1_rbl
+ u_t004_011/c2_w0_bl u_t004_011/c2_w0_br u_t004_011/c2_w1_bl u_t004_011/c2_w1_br
+ u_t004_011/c2_r0_rbl u_t004_011/c2_r1_rbl u_t004_011/c3_w0_bl u_t004_011/c3_w0_br
+ u_t004_011/c3_w1_bl u_t004_011/c3_w1_br u_t004_011/c3_r0_rbl u_t004_011/c3_r1_rbl
+ u_t004_011/r0_w0_wl u_t004_011/r0_w1_wl u_t004_011/r0_r0_rwl u_t004_011/r0_r1_rwl
+ u_t004_011/r1_w0_wl u_t004_011/r1_w1_wl u_t004_011/r1_r0_rwl u_t004_011/r1_r1_rwl
+ u_t004_011/r2_w0_wl u_t004_011/r2_w1_wl u_t004_011/r2_r0_rwl u_t004_011/r2_r1_rwl
+ u_t004_011/r3_w0_wl u_t004_011/r3_w1_wl u_t004_011/r3_r0_rwl u_t004_011/r3_r1_rwl
+ u_t004_011/VDD u_t004_015/VSS VSUBS detronyx_12t_2w2r_rc4_4x4_routed_5layer_direct
Xu_t010_014 u_t010_014/c0_w0_bl u_t010_014/c0_w0_br u_t010_014/c0_w1_bl u_t010_014/c0_w1_br
+ u_t010_014/c0_r0_rbl u_t010_014/c0_r1_rbl u_t010_014/c1_w0_bl u_t010_014/c1_w0_br
+ u_t010_014/c1_w1_bl u_t010_014/c1_w1_br u_t010_014/c1_r0_rbl u_t010_014/c1_r1_rbl
+ u_t010_014/c2_w0_bl u_t010_014/c2_w0_br u_t010_014/c2_w1_bl u_t010_014/c2_w1_br
+ u_t010_014/c2_r0_rbl u_t010_014/c2_r1_rbl u_t010_014/c3_w0_bl u_t010_014/c3_w0_br
+ u_t010_014/c3_w1_bl u_t010_014/c3_w1_br u_t010_014/c3_r0_rbl u_t010_014/c3_r1_rbl
+ u_t010_014/r0_w0_wl u_t010_014/r0_w1_wl u_t010_014/r0_r0_rwl u_t010_014/r0_r1_rwl
+ u_t010_014/r1_w0_wl u_t010_014/r1_w1_wl u_t010_014/r1_r0_rwl u_t010_014/r1_r1_rwl
+ u_t010_014/r2_w0_wl u_t010_014/r2_w1_wl u_t010_014/r2_r0_rwl u_t010_014/r2_r1_rwl
+ u_t010_014/r3_w0_wl u_t010_014/r3_w1_wl u_t010_014/r3_r0_rwl u_t010_014/r3_r1_rwl
+ u_t010_014/VDD u_t010_015/VSS VSUBS detronyx_12t_2w2r_rc4_4x4_routed_5layer_direct
Xu_t010_003 u_t010_003/c0_w0_bl u_t010_003/c0_w0_br u_t010_003/c0_w1_bl u_t010_003/c0_w1_br
+ u_t010_003/c0_r0_rbl u_t010_003/c0_r1_rbl u_t010_003/c1_w0_bl u_t010_003/c1_w0_br
+ u_t010_003/c1_w1_bl u_t010_003/c1_w1_br u_t010_003/c1_r0_rbl u_t010_003/c1_r1_rbl
+ u_t010_003/c2_w0_bl u_t010_003/c2_w0_br u_t010_003/c2_w1_bl u_t010_003/c2_w1_br
+ u_t010_003/c2_r0_rbl u_t010_003/c2_r1_rbl u_t010_003/c3_w0_bl u_t010_003/c3_w0_br
+ u_t010_003/c3_w1_bl u_t010_003/c3_w1_br u_t010_003/c3_r0_rbl u_t010_003/c3_r1_rbl
+ u_t010_003/r0_w0_wl u_t010_003/r0_w1_wl u_t010_003/r0_r0_rwl u_t010_003/r0_r1_rwl
+ u_t010_003/r1_w0_wl u_t010_003/r1_w1_wl u_t010_003/r1_r0_rwl u_t010_003/r1_r1_rwl
+ u_t010_003/r2_w0_wl u_t010_003/r2_w1_wl u_t010_003/r2_r0_rwl u_t010_003/r2_r1_rwl
+ u_t010_003/r3_w0_wl u_t010_003/r3_w1_wl u_t010_003/r3_r0_rwl u_t010_003/r3_r1_rwl
+ u_t010_003/VDD u_t010_003/VSS VSUBS detronyx_12t_2w2r_rc4_4x4_routed_5layer_direct
Xu_t001_003 u_t001_003/c0_w0_bl u_t001_003/c0_w0_br u_t001_003/c0_w1_bl u_t001_003/c0_w1_br
+ u_t001_003/c0_r0_rbl u_t001_003/c0_r1_rbl u_t001_003/c1_w0_bl u_t001_003/c1_w0_br
+ u_t001_003/c1_w1_bl u_t001_003/c1_w1_br u_t001_003/c1_r0_rbl u_t001_003/c1_r1_rbl
+ u_t001_003/c2_w0_bl u_t001_003/c2_w0_br u_t001_003/c2_w1_bl u_t001_003/c2_w1_br
+ u_t001_003/c2_r0_rbl u_t001_003/c2_r1_rbl u_t001_003/c3_w0_bl u_t001_003/c3_w0_br
+ u_t001_003/c3_w1_bl u_t001_003/c3_w1_br u_t001_003/c3_r0_rbl u_t001_003/c3_r1_rbl
+ u_t001_003/r0_w0_wl u_t001_003/r0_w1_wl u_t001_003/r0_r0_rwl u_t001_003/r0_r1_rwl
+ u_t001_003/r1_w0_wl u_t001_003/r1_w1_wl u_t001_003/r1_r0_rwl u_t001_003/r1_r1_rwl
+ u_t001_003/r2_w0_wl u_t001_003/r2_w1_wl u_t001_003/r2_r0_rwl u_t001_003/r2_r1_rwl
+ u_t001_003/r3_w0_wl u_t001_003/r3_w1_wl u_t001_003/r3_r0_rwl u_t001_003/r3_r1_rwl
+ u_t001_003/VDD u_t001_015/VSS VSUBS detronyx_12t_2w2r_rc4_4x4_routed_5layer_direct
Xu_t001_014 u_t001_014/c0_w0_bl u_t001_014/c0_w0_br u_t001_014/c0_w1_bl u_t001_014/c0_w1_br
+ u_t001_014/c0_r0_rbl u_t001_014/c0_r1_rbl u_t001_014/c1_w0_bl u_t001_014/c1_w0_br
+ u_t001_014/c1_w1_bl u_t001_014/c1_w1_br u_t001_014/c1_r0_rbl u_t001_014/c1_r1_rbl
+ u_t001_014/c2_w0_bl u_t001_014/c2_w0_br u_t001_014/c2_w1_bl u_t001_014/c2_w1_br
+ u_t001_014/c2_r0_rbl u_t001_014/c2_r1_rbl u_t001_014/c3_w0_bl u_t001_014/c3_w0_br
+ u_t001_014/c3_w1_bl u_t001_014/c3_w1_br u_t001_014/c3_r0_rbl u_t001_014/c3_r1_rbl
+ u_t001_014/r0_w0_wl u_t001_014/r0_w1_wl u_t001_014/r0_r0_rwl u_t001_014/r0_r1_rwl
+ u_t001_014/r1_w0_wl u_t001_014/r1_w1_wl u_t001_014/r1_r0_rwl u_t001_014/r1_r1_rwl
+ u_t001_014/r2_w0_wl u_t001_014/r2_w1_wl u_t001_014/r2_r0_rwl u_t001_014/r2_r1_rwl
+ u_t001_014/r3_w0_wl u_t001_014/r3_w1_wl u_t001_014/r3_r0_rwl u_t001_014/r3_r1_rwl
+ u_t001_014/VDD u_t001_015/VSS VSUBS detronyx_12t_2w2r_rc4_4x4_routed_5layer_direct
Xgf180mcu_as_sc_mcu7t3v3__inv_2_261 gf180mcu_as_sc_mcu7t3v3__nor2_2_5/VDD gf180mcu_as_sc_mcu7t3v3__nor2_2_5/VSS
+ VSS VSS gf180mcu_as_sc_mcu7t3v3__nor2_2_5/VNW VSUBS gf180mcu_as_sc_mcu7t3v3__inv_2
Xgf180mcu_as_sc_mcu7t3v3__inv_2_250 gf180mcu_as_sc_mcu7t3v3__nand2_2_9/VDD gf180mcu_as_sc_mcu7t3v3__nor2_2_6/VSS
+ VSS VSS gf180mcu_as_sc_mcu7t3v3__nand2_2_9/VNW VSUBS gf180mcu_as_sc_mcu7t3v3__inv_2
Xgf180mcu_as_sc_mcu7t3v3__inv_2_294 VSS VSS gf180mcu_as_sc_mcu7t3v3__inv_2_294/Y VSS
+ gf180mcu_as_sc_mcu7t3v3__inv_2_294/VNW VSUBS gf180mcu_as_sc_mcu7t3v3__inv_2
Xgf180mcu_as_sc_mcu7t3v3__inv_2_272 gf180mcu_as_sc_mcu7t3v3__nor2_2_5/VDD gf180mcu_as_sc_mcu7t3v3__nor2_2_5/VSS
+ VSS VSS gf180mcu_as_sc_mcu7t3v3__nor2_2_5/VNW VSUBS gf180mcu_as_sc_mcu7t3v3__inv_2
Xgf180mcu_as_sc_mcu7t3v3__inv_2_283 gf180mcu_as_sc_mcu7t3v3__nor2_2_5/VDD gf180mcu_as_sc_mcu7t3v3__nand3_2_8/VSS
+ VSS VSS gf180mcu_as_sc_mcu7t3v3__nor2_2_5/VNW VSUBS gf180mcu_as_sc_mcu7t3v3__inv_2
Xgf180mcu_as_sc_mcu7t3v3__nand2_2_1 gf180mcu_as_sc_mcu7t3v3__nand2_2_9/VDD gf180mcu_as_sc_mcu7t3v3__nor2_2_6/VSS
+ VSS VSS VSS gf180mcu_as_sc_mcu7t3v3__nand2_2_9/VNW VSUBS gf180mcu_as_sc_mcu7t3v3__nand2_2
Xgf180mcu_as_sc_mcu7t3v3__inv_2_805 VSS VSS VSS VSS gf180mcu_as_sc_mcu7t3v3__inv_2_806/VNW
+ VSUBS gf180mcu_as_sc_mcu7t3v3__inv_2
Xgf180mcu_as_sc_mcu7t3v3__inv_2_827 gf180mcu_as_sc_mcu7t3v3__inv_2_827/VDD gf180mcu_as_sc_mcu7t3v3__inv_2_830/VSS
+ gf180mcu_as_sc_mcu7t3v3__inv_2_827/Y VSS gf180mcu_as_sc_mcu7t3v3__inv_2_827/VNW
+ VSUBS gf180mcu_as_sc_mcu7t3v3__inv_2
Xgf180mcu_as_sc_mcu7t3v3__inv_2_816 VSS VSS gf180mcu_as_sc_mcu7t3v3__inv_2_816/Y VSS
+ gf180mcu_as_sc_mcu7t3v3__inv_2_818/VNW VSUBS gf180mcu_as_sc_mcu7t3v3__inv_2
Xgf180mcu_as_sc_mcu7t3v3__inv_2_849 gf180mcu_as_sc_mcu7t3v3__inv_2_854/VDD gf180mcu_as_sc_mcu7t3v3__inv_2_854/VDD
+ gf180mcu_as_sc_mcu7t3v3__inv_2_849/Y VSS gf180mcu_as_sc_mcu7t3v3__inv_2_851/VNW
+ VSUBS gf180mcu_as_sc_mcu7t3v3__inv_2
Xgf180mcu_as_sc_mcu7t3v3__inv_2_838 gf180mcu_as_sc_mcu7t3v3__inv_2_839/VDD gf180mcu_as_sc_mcu7t3v3__inv_2_845/VDD
+ gf180mcu_as_sc_mcu7t3v3__inv_2_838/Y VSS gf180mcu_as_sc_mcu7t3v3__inv_2_839/VNW
+ VSUBS gf180mcu_as_sc_mcu7t3v3__inv_2
Xgf180mcu_as_sc_mcu7t3v3__nand4_2_115 VSS VSS VSS VSS VSS VSS VSS gf180mcu_as_sc_mcu7t3v3__inv_2_449/VNW
+ VSUBS gf180mcu_as_sc_mcu7t3v3__nand4_2
Xgf180mcu_as_sc_mcu7t3v3__nand4_2_104 VSS VSS VSS VSS VSS VSS gf180mcu_as_sc_mcu7t3v3__nand4_2_104/Y
+ gf180mcu_as_sc_mcu7t3v3__inv_2_416/VNW VSUBS gf180mcu_as_sc_mcu7t3v3__nand4_2
Xgf180mcu_as_sc_mcu7t3v3__nand4_2_126 VSS VSS VSS VSS VSS VSS gf180mcu_as_sc_mcu7t3v3__nand4_2_126/Y
+ gf180mcu_as_sc_mcu7t3v3__inv_2_480/VNW VSUBS gf180mcu_as_sc_mcu7t3v3__nand4_2
Xgf180mcu_as_sc_mcu7t3v3__nand4_2_21 gf180mcu_as_sc_mcu7t3v3__inv_2_63/VDD gf180mcu_as_sc_mcu7t3v3__inv_2_63/VSS
+ VSS VSS VSS VSS gf180mcu_as_sc_mcu7t3v3__nand4_2_21/Y gf180mcu_as_sc_mcu7t3v3__inv_2_63/VNW
+ VSUBS gf180mcu_as_sc_mcu7t3v3__nand4_2
Xgf180mcu_as_sc_mcu7t3v3__nand4_2_76 VSS gf180mcu_as_sc_mcu7t3v3__inv_2_345/VSS VSS
+ VSS VSS VSS VSS gf180mcu_as_sc_mcu7t3v3__inv_2_345/VNW VSUBS gf180mcu_as_sc_mcu7t3v3__nand4_2
Xgf180mcu_as_sc_mcu7t3v3__nand4_2_65 VSS VSS VSS VSS VSS VSS gf180mcu_as_sc_mcu7t3v3__nand4_2_65/Y
+ gf180mcu_as_sc_mcu7t3v3__inv_2_298/VNW VSUBS gf180mcu_as_sc_mcu7t3v3__nand4_2
Xgf180mcu_as_sc_mcu7t3v3__nand4_2_10 gf180mcu_as_sc_mcu7t3v3__inv_2_47/VDD gf180mcu_as_sc_mcu7t3v3__inv_2_47/VSS
+ VSS VSS VSS VSS gf180mcu_as_sc_mcu7t3v3__nand4_2_10/Y gf180mcu_as_sc_mcu7t3v3__inv_2_47/VNW
+ VSUBS gf180mcu_as_sc_mcu7t3v3__nand4_2
Xgf180mcu_as_sc_mcu7t3v3__nand4_2_54 gf180mcu_as_sc_mcu7t3v3__inv_2_162/VDD gf180mcu_as_sc_mcu7t3v3__inv_2_165/VDD
+ VSS VSS VSS VSS VSS gf180mcu_as_sc_mcu7t3v3__inv_2_162/VNW VSUBS gf180mcu_as_sc_mcu7t3v3__nand4_2
Xgf180mcu_as_sc_mcu7t3v3__nand4_2_32 VSS VSS VSS VSS VSS VSS VSS gf180mcu_as_sc_mcu7t3v3__inv_2_96/VNW
+ VSUBS gf180mcu_as_sc_mcu7t3v3__nand4_2
Xgf180mcu_as_sc_mcu7t3v3__nand4_2_43 VSS gf180mcu_as_sc_mcu7t3v3__inv_2_132/VDD VSS
+ VSS VSS VSS VSS gf180mcu_as_sc_mcu7t3v3__inv_2_129/VNW VSUBS gf180mcu_as_sc_mcu7t3v3__nand4_2
Xgf180mcu_as_sc_mcu7t3v3__nand4_2_148 gf180mcu_as_sc_mcu7t3v3__inv_2_546/VDD VSS VSS
+ VSS VSS VSS VSS gf180mcu_as_sc_mcu7t3v3__inv_2_546/VNW VSUBS gf180mcu_as_sc_mcu7t3v3__nand4_2
Xgf180mcu_as_sc_mcu7t3v3__nand4_2_137 VSS VSS VSS VSS VSS VSS gf180mcu_as_sc_mcu7t3v3__nand4_2_137/Y
+ gf180mcu_as_sc_mcu7t3v3__inv_2_513/VNW VSUBS gf180mcu_as_sc_mcu7t3v3__nand4_2
Xgf180mcu_as_sc_mcu7t3v3__nand4_2_159 VSS VSS VSS VSS VSS VSS VSS gf180mcu_as_sc_mcu7t3v3__inv_2_582/VNW
+ VSUBS gf180mcu_as_sc_mcu7t3v3__nand4_2
Xgf180mcu_as_sc_mcu7t3v3__nand4_2_98 gf180mcu_as_sc_mcu7t3v3__inv_2_396/VDD VSS VSS
+ VSS VSS VSS VSS gf180mcu_as_sc_mcu7t3v3__inv_2_396/VNW VSUBS gf180mcu_as_sc_mcu7t3v3__nand4_2
Xgf180mcu_as_sc_mcu7t3v3__nand4_2_87 gf180mcu_as_sc_mcu7t3v3__inv_2_363/VDD gf180mcu_as_sc_mcu7t3v3__inv_2_366/VDD
+ VSS VSS VSS VSS VSS gf180mcu_as_sc_mcu7t3v3__inv_2_363/VNW VSUBS gf180mcu_as_sc_mcu7t3v3__nand4_2
Xgf180mcu_as_sc_mcu7t3v3__inv_2_602 gf180mcu_as_sc_mcu7t3v3__inv_2_603/VDD VSS gf180mcu_as_sc_mcu7t3v3__inv_2_611/Y
+ gf180mcu_as_sc_mcu7t3v3__inv_2_603/Y gf180mcu_as_sc_mcu7t3v3__inv_2_603/VNW VSUBS
+ gf180mcu_as_sc_mcu7t3v3__inv_2
Xu_t008_009 u_t008_009/c0_w0_bl u_t008_009/c0_w0_br u_t008_009/c0_w1_bl u_t008_009/c0_w1_br
+ u_t008_009/c0_r0_rbl u_t008_009/c0_r1_rbl u_t008_009/c1_w0_bl u_t008_009/c1_w0_br
+ u_t008_009/c1_w1_bl u_t008_009/c1_w1_br u_t008_009/c1_r0_rbl u_t008_009/c1_r1_rbl
+ u_t008_009/c2_w0_bl u_t008_009/c2_w0_br u_t008_009/c2_w1_bl u_t008_009/c2_w1_br
+ u_t008_009/c2_r0_rbl u_t008_009/c2_r1_rbl u_t008_009/c3_w0_bl u_t008_009/c3_w0_br
+ u_t008_009/c3_w1_bl u_t008_009/c3_w1_br u_t008_009/c3_r0_rbl u_t008_009/c3_r1_rbl
+ u_t008_009/r0_w0_wl u_t008_009/r0_w1_wl u_t008_009/r0_r0_rwl u_t008_009/r0_r1_rwl
+ u_t008_009/r1_w0_wl u_t008_009/r1_w1_wl u_t008_009/r1_r0_rwl u_t008_009/r1_r1_rwl
+ u_t008_009/r2_w0_wl u_t008_009/r2_w1_wl u_t008_009/r2_r0_rwl u_t008_009/r2_r1_rwl
+ u_t008_009/r3_w0_wl u_t008_009/r3_w1_wl u_t008_009/r3_r0_rwl u_t008_009/r3_r1_rwl
+ VSS u_t008_015/VSS VSUBS detronyx_12t_2w2r_rc4_4x4_routed_5layer_direct
Xgf180mcu_as_sc_mcu7t3v3__inv_2_613 VSS gf180mcu_as_sc_mcu7t3v3__inv_2_618/VDD gf180mcu_as_sc_mcu7t3v3__inv_2_613/Y
+ gf180mcu_as_sc_mcu7t3v3__inv_2_717/A gf180mcu_as_sc_mcu7t3v3__inv_2_615/VNW VSUBS
+ gf180mcu_as_sc_mcu7t3v3__inv_2
Xgf180mcu_as_sc_mcu7t3v3__inv_2_624 VSS VSS VSS VSS gf180mcu_as_sc_mcu7t3v3__inv_2_625/VNW
+ VSUBS gf180mcu_as_sc_mcu7t3v3__inv_2
Xgf180mcu_as_sc_mcu7t3v3__inv_2_635 VSS VSS VSS VSS gf180mcu_as_sc_mcu7t3v3__inv_2_637/VNW
+ VSUBS gf180mcu_as_sc_mcu7t3v3__inv_2
Xgf180mcu_as_sc_mcu7t3v3__inv_2_679 VSS VSS gf180mcu_as_sc_mcu7t3v3__inv_2_679/Y VSS
+ gf180mcu_as_sc_mcu7t3v3__inv_2_703/VNW VSUBS gf180mcu_as_sc_mcu7t3v3__inv_2
Xgf180mcu_as_sc_mcu7t3v3__inv_2_646 gf180mcu_as_sc_mcu7t3v3__inv_2_713/VDD gf180mcu_as_sc_mcu7t3v3__nor2_2_8/VSS
+ gf180mcu_as_sc_mcu7t3v3__inv_2_646/Y VSS gf180mcu_as_sc_mcu7t3v3__inv_2_713/VNW
+ VSUBS gf180mcu_as_sc_mcu7t3v3__inv_2
Xgf180mcu_as_sc_mcu7t3v3__inv_2_657 gf180mcu_as_sc_mcu7t3v3__nor2_2_8/VDD gf180mcu_as_sc_mcu7t3v3__nor2_2_8/VSS
+ VSS VSS gf180mcu_as_sc_mcu7t3v3__nor2_2_8/VNW VSUBS gf180mcu_as_sc_mcu7t3v3__inv_2
Xgf180mcu_as_sc_mcu7t3v3__inv_2_668 gf180mcu_as_sc_mcu7t3v3__nor2_2_8/VDD gf180mcu_as_sc_mcu7t3v3__inv_2_710/VSS
+ gf180mcu_as_sc_mcu7t3v3__inv_2_668/Y VSS gf180mcu_as_sc_mcu7t3v3__nor2_2_8/VNW VSUBS
+ gf180mcu_as_sc_mcu7t3v3__inv_2
Xu_t013_012 u_t013_012/c0_w0_bl u_t013_012/c0_w0_br u_t013_012/c0_w1_bl u_t013_012/c0_w1_br
+ u_t013_012/c0_r0_rbl u_t013_012/c0_r1_rbl u_t013_012/c1_w0_bl u_t013_012/c1_w0_br
+ u_t013_012/c1_w1_bl u_t013_012/c1_w1_br u_t013_012/c1_r0_rbl u_t013_012/c1_r1_rbl
+ u_t013_012/c2_w0_bl u_t013_012/c2_w0_br u_t013_012/c2_w1_bl u_t013_012/c2_w1_br
+ u_t013_012/c2_r0_rbl u_t013_012/c2_r1_rbl u_t013_012/c3_w0_bl u_t013_012/c3_w0_br
+ u_t013_012/c3_w1_bl u_t013_012/c3_w1_br u_t013_012/c3_r0_rbl u_t013_012/c3_r1_rbl
+ u_t013_012/r0_w0_wl u_t013_012/r0_w1_wl u_t013_012/r0_r0_rwl u_t013_012/r0_r1_rwl
+ u_t013_012/r1_w0_wl u_t013_012/r1_w1_wl u_t013_012/r1_r0_rwl u_t013_012/r1_r1_rwl
+ u_t013_012/r2_w0_wl u_t013_012/r2_w1_wl u_t013_012/r2_r0_rwl u_t013_012/r2_r1_rwl
+ u_t013_012/r3_w0_wl u_t013_012/r3_w1_wl u_t013_012/r3_r0_rwl u_t013_012/r3_r1_rwl
+ u_t013_012/VDD u_t013_015/VSS VSUBS detronyx_12t_2w2r_rc4_4x4_routed_5layer_direct
Xu_t013_001 u_t013_001/c0_w0_bl u_t013_001/c0_w0_br u_t013_001/c0_w1_bl u_t013_001/c0_w1_br
+ u_t013_001/c0_r0_rbl u_t013_001/c0_r1_rbl u_t013_001/c1_w0_bl u_t013_001/c1_w0_br
+ u_t013_001/c1_w1_bl u_t013_001/c1_w1_br u_t013_001/c1_r0_rbl u_t013_001/c1_r1_rbl
+ u_t013_001/c2_w0_bl u_t013_001/c2_w0_br u_t013_001/c2_w1_bl u_t013_001/c2_w1_br
+ u_t013_001/c2_r0_rbl u_t013_001/c2_r1_rbl u_t013_001/c3_w0_bl u_t013_001/c3_w0_br
+ u_t013_001/c3_w1_bl u_t013_001/c3_w1_br u_t013_001/c3_r0_rbl u_t013_001/c3_r1_rbl
+ u_t013_001/r0_w0_wl u_t013_001/r0_w1_wl u_t013_001/r0_r0_rwl u_t013_001/r0_r1_rwl
+ u_t013_001/r1_w0_wl u_t013_001/r1_w1_wl u_t013_001/r1_r0_rwl u_t013_001/r1_r1_rwl
+ u_t013_001/r2_w0_wl u_t013_001/r2_w1_wl u_t013_001/r2_r0_rwl u_t013_001/r2_r1_rwl
+ u_t013_001/r3_w0_wl u_t013_001/r3_w1_wl u_t013_001/r3_r0_rwl u_t013_001/r3_r1_rwl
+ VSS u_t013_015/VSS VSUBS detronyx_12t_2w2r_rc4_4x4_routed_5layer_direct
Xgf180mcu_as_sc_mcu7t3v3__inv_2_454 VSS VSS VSS VSS gf180mcu_as_sc_mcu7t3v3__inv_2_455/VNW
+ VSUBS gf180mcu_as_sc_mcu7t3v3__inv_2
Xgf180mcu_as_sc_mcu7t3v3__inv_2_443 VSS VSS gf180mcu_as_sc_mcu7t3v3__inv_2_443/Y VSS
+ gf180mcu_as_sc_mcu7t3v3__inv_2_443/VNW VSUBS gf180mcu_as_sc_mcu7t3v3__inv_2
Xgf180mcu_as_sc_mcu7t3v3__inv_2_432 VSS VSS VSS VSS gf180mcu_as_sc_mcu7t3v3__inv_2_434/VNW
+ VSUBS gf180mcu_as_sc_mcu7t3v3__inv_2
Xgf180mcu_as_sc_mcu7t3v3__inv_2_421 VSS VSS VSS VSS gf180mcu_as_sc_mcu7t3v3__inv_2_422/VNW
+ VSUBS gf180mcu_as_sc_mcu7t3v3__inv_2
Xgf180mcu_as_sc_mcu7t3v3__inv_2_410 VSS VSS VSS VSS gf180mcu_as_sc_mcu7t3v3__inv_2_410/VNW
+ VSUBS gf180mcu_as_sc_mcu7t3v3__inv_2
Xgf180mcu_as_sc_mcu7t3v3__inv_2_465 VSS VSS gf180mcu_as_sc_mcu7t3v3__inv_2_465/Y VSS
+ gf180mcu_as_sc_mcu7t3v3__inv_2_465/VNW VSUBS gf180mcu_as_sc_mcu7t3v3__inv_2
Xgf180mcu_as_sc_mcu7t3v3__inv_2_498 VSS VSS gf180mcu_as_sc_mcu7t3v3__inv_2_498/Y VSS
+ gf180mcu_as_sc_mcu7t3v3__inv_2_498/VNW VSUBS gf180mcu_as_sc_mcu7t3v3__inv_2
Xgf180mcu_as_sc_mcu7t3v3__inv_2_487 VSS VSS VSS VSS gf180mcu_as_sc_mcu7t3v3__inv_2_489/VNW
+ VSUBS gf180mcu_as_sc_mcu7t3v3__inv_2
Xgf180mcu_as_sc_mcu7t3v3__inv_2_476 VSS VSS VSS VSS gf180mcu_as_sc_mcu7t3v3__inv_2_477/VNW
+ VSUBS gf180mcu_as_sc_mcu7t3v3__inv_2
Xu_t004_001 u_t004_001/c0_w0_bl u_t004_001/c0_w0_br u_t004_001/c0_w1_bl u_t004_001/c0_w1_br
+ u_t004_001/c0_r0_rbl u_t004_001/c0_r1_rbl u_t004_001/c1_w0_bl u_t004_001/c1_w0_br
+ u_t004_001/c1_w1_bl u_t004_001/c1_w1_br u_t004_001/c1_r0_rbl u_t004_001/c1_r1_rbl
+ u_t004_001/c2_w0_bl u_t004_001/c2_w0_br u_t004_001/c2_w1_bl u_t004_001/c2_w1_br
+ u_t004_001/c2_r0_rbl u_t004_001/c2_r1_rbl u_t004_001/c3_w0_bl u_t004_001/c3_w0_br
+ u_t004_001/c3_w1_bl u_t004_001/c3_w1_br u_t004_001/c3_r0_rbl u_t004_001/c3_r1_rbl
+ u_t004_001/r0_w0_wl u_t004_001/r0_w1_wl u_t004_001/r0_r0_rwl u_t004_001/r0_r1_rwl
+ u_t004_001/r1_w0_wl u_t004_001/r1_w1_wl u_t004_001/r1_r0_rwl u_t004_001/r1_r1_rwl
+ u_t004_001/r2_w0_wl u_t004_001/r2_w1_wl u_t004_001/r2_r0_rwl u_t004_001/r2_r1_rwl
+ u_t004_001/r3_w0_wl u_t004_001/r3_w1_wl u_t004_001/r3_r0_rwl u_t004_001/r3_r1_rwl
+ VSS u_t004_015/VSS VSUBS detronyx_12t_2w2r_rc4_4x4_routed_5layer_direct
Xu_t004_012 u_t004_012/c0_w0_bl u_t004_012/c0_w0_br u_t004_012/c0_w1_bl u_t004_012/c0_w1_br
+ u_t004_012/c0_r0_rbl u_t004_012/c0_r1_rbl u_t004_012/c1_w0_bl u_t004_012/c1_w0_br
+ u_t004_012/c1_w1_bl u_t004_012/c1_w1_br u_t004_012/c1_r0_rbl u_t004_012/c1_r1_rbl
+ u_t004_012/c2_w0_bl u_t004_012/c2_w0_br u_t004_012/c2_w1_bl u_t004_012/c2_w1_br
+ u_t004_012/c2_r0_rbl u_t004_012/c2_r1_rbl u_t004_012/c3_w0_bl u_t004_012/c3_w0_br
+ u_t004_012/c3_w1_bl u_t004_012/c3_w1_br u_t004_012/c3_r0_rbl u_t004_012/c3_r1_rbl
+ u_t004_012/r0_w0_wl u_t004_012/r0_w1_wl u_t004_012/r0_r0_rwl u_t004_012/r0_r1_rwl
+ u_t004_012/r1_w0_wl u_t004_012/r1_w1_wl u_t004_012/r1_r0_rwl u_t004_012/r1_r1_rwl
+ u_t004_012/r2_w0_wl u_t004_012/r2_w1_wl u_t004_012/r2_r0_rwl u_t004_012/r2_r1_rwl
+ u_t004_012/r3_w0_wl u_t004_012/r3_w1_wl u_t004_012/r3_r0_rwl u_t004_012/r3_r1_rwl
+ u_t004_012/VDD u_t004_015/VSS VSUBS detronyx_12t_2w2r_rc4_4x4_routed_5layer_direct
Xu_t010_015 u_t010_015/c0_w0_bl u_t010_015/c0_w0_br u_t010_015/c0_w1_bl u_t010_015/c0_w1_br
+ u_t010_015/c0_r0_rbl u_t010_015/c0_r1_rbl u_t010_015/c1_w0_bl u_t010_015/c1_w0_br
+ u_t010_015/c1_w1_bl u_t010_015/c1_w1_br u_t010_015/c1_r0_rbl u_t010_015/c1_r1_rbl
+ u_t010_015/c2_w0_bl u_t010_015/c2_w0_br u_t010_015/c2_w1_bl u_t010_015/c2_w1_br
+ u_t010_015/c2_r0_rbl u_t010_015/c2_r1_rbl u_t010_015/c3_w0_bl u_t010_015/c3_w0_br
+ u_t010_015/c3_w1_bl u_t010_015/c3_w1_br u_t010_015/c3_r0_rbl u_t010_015/c3_r1_rbl
+ u_t010_015/r0_w0_wl u_t010_015/r0_w1_wl u_t010_015/r0_r0_rwl u_t010_015/r0_r1_rwl
+ u_t010_015/r1_w0_wl u_t010_015/r1_w1_wl u_t010_015/r1_r0_rwl u_t010_015/r1_r1_rwl
+ u_t010_015/r2_w0_wl u_t010_015/r2_w1_wl u_t010_015/r2_r0_rwl u_t010_015/r2_r1_rwl
+ u_t010_015/r3_w0_wl u_t010_015/r3_w1_wl u_t010_015/r3_r0_rwl u_t010_015/r3_r1_rwl
+ VSS u_t010_015/VSS VSUBS detronyx_12t_2w2r_rc4_4x4_routed_5layer_direct
Xu_t010_004 u_t010_004/c0_w0_bl u_t010_004/c0_w0_br u_t010_004/c0_w1_bl u_t010_004/c0_w1_br
+ u_t010_004/c0_r0_rbl u_t010_004/c0_r1_rbl u_t010_004/c1_w0_bl u_t010_004/c1_w0_br
+ u_t010_004/c1_w1_bl u_t010_004/c1_w1_br u_t010_004/c1_r0_rbl u_t010_004/c1_r1_rbl
+ u_t010_004/c2_w0_bl u_t010_004/c2_w0_br u_t010_004/c2_w1_bl u_t010_004/c2_w1_br
+ u_t010_004/c2_r0_rbl u_t010_004/c2_r1_rbl u_t010_004/c3_w0_bl u_t010_004/c3_w0_br
+ u_t010_004/c3_w1_bl u_t010_004/c3_w1_br u_t010_004/c3_r0_rbl u_t010_004/c3_r1_rbl
+ u_t010_004/r0_w0_wl u_t010_004/r0_w1_wl u_t010_004/r0_r0_rwl u_t010_004/r0_r1_rwl
+ u_t010_004/r1_w0_wl u_t010_004/r1_w1_wl u_t010_004/r1_r0_rwl u_t010_004/r1_r1_rwl
+ u_t010_004/r2_w0_wl u_t010_004/r2_w1_wl u_t010_004/r2_r0_rwl u_t010_004/r2_r1_rwl
+ u_t010_004/r3_w0_wl u_t010_004/r3_w1_wl u_t010_004/r3_r0_rwl u_t010_004/r3_r1_rwl
+ u_t010_004/VDD u_t010_004/VSS VSUBS detronyx_12t_2w2r_rc4_4x4_routed_5layer_direct
Xu_t001_004 u_t001_004/c0_w0_bl u_t001_004/c0_w0_br u_t001_004/c0_w1_bl u_t001_004/c0_w1_br
+ u_t001_004/c0_r0_rbl u_t001_004/c0_r1_rbl u_t001_004/c1_w0_bl u_t001_004/c1_w0_br
+ u_t001_004/c1_w1_bl u_t001_004/c1_w1_br u_t001_004/c1_r0_rbl u_t001_004/c1_r1_rbl
+ u_t001_004/c2_w0_bl u_t001_004/c2_w0_br u_t001_004/c2_w1_bl u_t001_004/c2_w1_br
+ u_t001_004/c2_r0_rbl u_t001_004/c2_r1_rbl u_t001_004/c3_w0_bl u_t001_004/c3_w0_br
+ u_t001_004/c3_w1_bl u_t001_004/c3_w1_br u_t001_004/c3_r0_rbl u_t001_004/c3_r1_rbl
+ u_t001_004/r0_w0_wl u_t001_004/r0_w1_wl u_t001_004/r0_r0_rwl u_t001_004/r0_r1_rwl
+ u_t001_004/r1_w0_wl u_t001_004/r1_w1_wl u_t001_004/r1_r0_rwl u_t001_004/r1_r1_rwl
+ u_t001_004/r2_w0_wl u_t001_004/r2_w1_wl u_t001_004/r2_r0_rwl u_t001_004/r2_r1_rwl
+ u_t001_004/r3_w0_wl u_t001_004/r3_w1_wl u_t001_004/r3_r0_rwl u_t001_004/r3_r1_rwl
+ u_t001_004/VDD u_t001_015/VSS VSUBS detronyx_12t_2w2r_rc4_4x4_routed_5layer_direct
Xu_t001_015 u_t001_015/c0_w0_bl u_t001_015/c0_w0_br u_t001_015/c0_w1_bl u_t001_015/c0_w1_br
+ u_t001_015/c0_r0_rbl u_t001_015/c0_r1_rbl u_t001_015/c1_w0_bl u_t001_015/c1_w0_br
+ u_t001_015/c1_w1_bl u_t001_015/c1_w1_br u_t001_015/c1_r0_rbl u_t001_015/c1_r1_rbl
+ u_t001_015/c2_w0_bl u_t001_015/c2_w0_br u_t001_015/c2_w1_bl u_t001_015/c2_w1_br
+ u_t001_015/c2_r0_rbl u_t001_015/c2_r1_rbl u_t001_015/c3_w0_bl u_t001_015/c3_w0_br
+ u_t001_015/c3_w1_bl u_t001_015/c3_w1_br u_t001_015/c3_r0_rbl u_t001_015/c3_r1_rbl
+ u_t001_015/r0_w0_wl u_t001_015/r0_w1_wl u_t001_015/r0_r0_rwl u_t001_015/r0_r1_rwl
+ u_t001_015/r1_w0_wl u_t001_015/r1_w1_wl u_t001_015/r1_r0_rwl u_t001_015/r1_r1_rwl
+ u_t001_015/r2_w0_wl u_t001_015/r2_w1_wl u_t001_015/r2_r0_rwl u_t001_015/r2_r1_rwl
+ u_t001_015/r3_w0_wl u_t001_015/r3_w1_wl u_t001_015/r3_r0_rwl u_t001_015/r3_r1_rwl
+ VSS u_t001_015/VSS VSUBS detronyx_12t_2w2r_rc4_4x4_routed_5layer_direct
Xgf180mcu_as_sc_mcu7t3v3__inv_2_284 VSS VSS VSS VSS gf180mcu_as_sc_mcu7t3v3__inv_2_286/VNW
+ VSUBS gf180mcu_as_sc_mcu7t3v3__inv_2
Xgf180mcu_as_sc_mcu7t3v3__inv_2_295 VSS VSS VSS VSS gf180mcu_as_sc_mcu7t3v3__inv_2_299/VNW
+ VSUBS gf180mcu_as_sc_mcu7t3v3__inv_2
Xgf180mcu_as_sc_mcu7t3v3__inv_2_262 gf180mcu_as_sc_mcu7t3v3__nor2_2_5/VDD gf180mcu_as_sc_mcu7t3v3__nand3_2_8/VSS
+ VSS VSS gf180mcu_as_sc_mcu7t3v3__nor2_2_5/VNW VSUBS gf180mcu_as_sc_mcu7t3v3__inv_2
Xgf180mcu_as_sc_mcu7t3v3__inv_2_273 gf180mcu_as_sc_mcu7t3v3__nor2_2_5/VDD gf180mcu_as_sc_mcu7t3v3__nand3_2_8/VSS
+ VSS VSS gf180mcu_as_sc_mcu7t3v3__nor2_2_5/VNW VSUBS gf180mcu_as_sc_mcu7t3v3__inv_2
Xgf180mcu_as_sc_mcu7t3v3__inv_2_240 gf180mcu_as_sc_mcu7t3v3__nor2_2_4/VDD gf180mcu_as_sc_mcu7t3v3__nor2_2_4/VSS
+ VSS VSS gf180mcu_as_sc_mcu7t3v3__nor2_2_4/VNW VSUBS gf180mcu_as_sc_mcu7t3v3__inv_2
Xgf180mcu_as_sc_mcu7t3v3__inv_2_251 gf180mcu_as_sc_mcu7t3v3__nor2_2_6/VDD gf180mcu_as_sc_mcu7t3v3__nor2_2_6/VSS
+ VSS VSS gf180mcu_as_sc_mcu7t3v3__nor2_2_6/VNW VSUBS gf180mcu_as_sc_mcu7t3v3__inv_2
Xgf180mcu_as_sc_mcu7t3v3__nand2_2_2 gf180mcu_as_sc_mcu7t3v3__nor2_2_6/VDD gf180mcu_as_sc_mcu7t3v3__nand3_2_1/VSS
+ VSS VSS VSS gf180mcu_as_sc_mcu7t3v3__nor2_2_6/VNW VSUBS gf180mcu_as_sc_mcu7t3v3__nand2_2
Xgf180mcu_as_sc_mcu7t3v3__inv_2_806 VSS VSS VSS VSS gf180mcu_as_sc_mcu7t3v3__inv_2_806/VNW
+ VSUBS gf180mcu_as_sc_mcu7t3v3__inv_2
Xgf180mcu_as_sc_mcu7t3v3__inv_2_828 gf180mcu_as_sc_mcu7t3v3__inv_2_830/VSS gf180mcu_as_sc_mcu7t3v3__inv_2_830/VSS
+ gf180mcu_as_sc_mcu7t3v3__inv_2_828/Y VSS gf180mcu_as_sc_mcu7t3v3__inv_2_830/VNW
+ VSUBS gf180mcu_as_sc_mcu7t3v3__inv_2
Xgf180mcu_as_sc_mcu7t3v3__inv_2_817 VSS VSS VSS VSS gf180mcu_as_sc_mcu7t3v3__inv_2_818/VNW
+ VSUBS gf180mcu_as_sc_mcu7t3v3__inv_2
Xgf180mcu_as_sc_mcu7t3v3__inv_2_839 gf180mcu_as_sc_mcu7t3v3__inv_2_839/VDD gf180mcu_as_sc_mcu7t3v3__inv_2_845/VDD
+ gf180mcu_as_sc_mcu7t3v3__inv_2_839/Y VSS gf180mcu_as_sc_mcu7t3v3__inv_2_839/VNW
+ VSUBS gf180mcu_as_sc_mcu7t3v3__inv_2
Xgf180mcu_as_sc_mcu7t3v3__nand4_2_116 VSS VSS VSS VSS VSS VSS VSS gf180mcu_as_sc_mcu7t3v3__inv_2_452/VNW
+ VSUBS gf180mcu_as_sc_mcu7t3v3__nand4_2
Xgf180mcu_as_sc_mcu7t3v3__nand4_2_105 VSS VSS VSS VSS VSS VSS VSS gf180mcu_as_sc_mcu7t3v3__inv_2_419/VNW
+ VSUBS gf180mcu_as_sc_mcu7t3v3__nand4_2
Xgf180mcu_as_sc_mcu7t3v3__nand4_2_149 VSS gf180mcu_as_sc_mcu7t3v3__inv_2_552/VDD VSS
+ VSS VSS VSS VSS gf180mcu_as_sc_mcu7t3v3__inv_2_549/VNW VSUBS gf180mcu_as_sc_mcu7t3v3__nand4_2
Xgf180mcu_as_sc_mcu7t3v3__nand4_2_127 VSS VSS VSS VSS VSS VSS VSS gf180mcu_as_sc_mcu7t3v3__inv_2_483/VNW
+ VSUBS gf180mcu_as_sc_mcu7t3v3__nand4_2
Xgf180mcu_as_sc_mcu7t3v3__nand4_2_138 VSS VSS VSS VSS VSS VSS gf180mcu_as_sc_mcu7t3v3__nand4_2_138/Y
+ gf180mcu_as_sc_mcu7t3v3__inv_2_516/VNW VSUBS gf180mcu_as_sc_mcu7t3v3__nand4_2
Xgf180mcu_as_sc_mcu7t3v3__nand4_2_77 gf180mcu_as_sc_mcu7t3v3__inv_2_345/VSS VSS VSS
+ VSS VSS VSS VSS gf180mcu_as_sc_mcu7t3v3__inv_2_326/VNW VSUBS gf180mcu_as_sc_mcu7t3v3__nand4_2
Xgf180mcu_as_sc_mcu7t3v3__nand4_2_66 VSS VSS VSS VSS VSS VSS VSS gf180mcu_as_sc_mcu7t3v3__inv_2_307/VNW
+ VSUBS gf180mcu_as_sc_mcu7t3v3__nand4_2
Xgf180mcu_as_sc_mcu7t3v3__nand4_2_11 gf180mcu_as_sc_mcu7t3v3__inv_2_47/VSS VSS VSS
+ VSS VSS VSS VSS gf180mcu_as_sc_mcu7t3v3__inv_2_34/VNW VSUBS gf180mcu_as_sc_mcu7t3v3__nand4_2
Xgf180mcu_as_sc_mcu7t3v3__nand4_2_99 VSS VSS VSS VSS VSS VSS VSS gf180mcu_as_sc_mcu7t3v3__inv_2_399/VNW
+ VSUBS gf180mcu_as_sc_mcu7t3v3__nand4_2
Xgf180mcu_as_sc_mcu7t3v3__nand4_2_55 gf180mcu_as_sc_mcu7t3v3__inv_2_165/VDD VSS VSS
+ VSS VSS VSS VSS gf180mcu_as_sc_mcu7t3v3__inv_2_165/VNW VSUBS gf180mcu_as_sc_mcu7t3v3__nand4_2
Xgf180mcu_as_sc_mcu7t3v3__nand4_2_33 VSS VSS VSS VSS VSS VSS gf180mcu_as_sc_mcu7t3v3__nand4_2_33/Y
+ gf180mcu_as_sc_mcu7t3v3__inv_2_99/VNW VSUBS gf180mcu_as_sc_mcu7t3v3__nand4_2
Xgf180mcu_as_sc_mcu7t3v3__nand4_2_88 gf180mcu_as_sc_mcu7t3v3__inv_2_366/VDD VSS VSS
+ VSS VSS VSS VSS gf180mcu_as_sc_mcu7t3v3__inv_2_366/VNW VSUBS gf180mcu_as_sc_mcu7t3v3__nand4_2
Xgf180mcu_as_sc_mcu7t3v3__nand4_2_44 gf180mcu_as_sc_mcu7t3v3__inv_2_132/VDD gf180mcu_as_sc_mcu7t3v3__inv_2_135/VDD
+ VSS VSS VSS VSS VSS gf180mcu_as_sc_mcu7t3v3__inv_2_132/VNW VSUBS gf180mcu_as_sc_mcu7t3v3__nand4_2
Xgf180mcu_as_sc_mcu7t3v3__nand4_2_22 gf180mcu_as_sc_mcu7t3v3__inv_2_66/VDD VSS VSS
+ VSS VSS VSS VSS gf180mcu_as_sc_mcu7t3v3__inv_2_66/VNW VSUBS gf180mcu_as_sc_mcu7t3v3__nand4_2
Xgf180mcu_as_sc_mcu7t3v3__inv_2_614 VSS gf180mcu_as_sc_mcu7t3v3__inv_2_618/VDD gf180mcu_as_sc_mcu7t3v3__inv_2_717/A
+ gf180mcu_as_sc_mcu7t3v3__inv_2_615/Y gf180mcu_as_sc_mcu7t3v3__inv_2_615/VNW VSUBS
+ gf180mcu_as_sc_mcu7t3v3__inv_2
Xgf180mcu_as_sc_mcu7t3v3__inv_2_603 gf180mcu_as_sc_mcu7t3v3__inv_2_603/VDD VSS gf180mcu_as_sc_mcu7t3v3__inv_2_603/Y
+ VSS gf180mcu_as_sc_mcu7t3v3__inv_2_603/VNW VSUBS gf180mcu_as_sc_mcu7t3v3__inv_2
Xgf180mcu_as_sc_mcu7t3v3__inv_2_625 VSS VSS VSS VSS gf180mcu_as_sc_mcu7t3v3__inv_2_625/VNW
+ VSUBS gf180mcu_as_sc_mcu7t3v3__inv_2
Xgf180mcu_as_sc_mcu7t3v3__inv_2_636 VSS VSS VSS VSS gf180mcu_as_sc_mcu7t3v3__inv_2_637/VNW
+ VSUBS gf180mcu_as_sc_mcu7t3v3__inv_2
Xgf180mcu_as_sc_mcu7t3v3__inv_2_647 gf180mcu_as_sc_mcu7t3v3__inv_2_713/VDD gf180mcu_as_sc_mcu7t3v3__inv_2_713/VSS
+ gf180mcu_as_sc_mcu7t3v3__inv_2_647/Y VSS gf180mcu_as_sc_mcu7t3v3__inv_2_713/VNW
+ VSUBS gf180mcu_as_sc_mcu7t3v3__inv_2
Xgf180mcu_as_sc_mcu7t3v3__inv_2_658 gf180mcu_as_sc_mcu7t3v3__inv_2_713/VDD gf180mcu_as_sc_mcu7t3v3__nor2_2_8/VSS
+ VSS VSS gf180mcu_as_sc_mcu7t3v3__inv_2_713/VNW VSUBS gf180mcu_as_sc_mcu7t3v3__inv_2
Xgf180mcu_as_sc_mcu7t3v3__inv_2_669 gf180mcu_as_sc_mcu7t3v3__nor2_2_8/VDD gf180mcu_as_sc_mcu7t3v3__nor2_2_8/VSS
+ gf180mcu_as_sc_mcu7t3v3__inv_2_669/Y VSS gf180mcu_as_sc_mcu7t3v3__nor2_2_8/VNW VSUBS
+ gf180mcu_as_sc_mcu7t3v3__inv_2
Xu_t007_010 u_t007_010/c0_w0_bl u_t007_010/c0_w0_br u_t007_010/c0_w1_bl u_t007_010/c0_w1_br
+ u_t007_010/c0_r0_rbl u_t007_010/c0_r1_rbl u_t007_010/c1_w0_bl u_t007_010/c1_w0_br
+ u_t007_010/c1_w1_bl u_t007_010/c1_w1_br u_t007_010/c1_r0_rbl u_t007_010/c1_r1_rbl
+ u_t007_010/c2_w0_bl u_t007_010/c2_w0_br u_t007_010/c2_w1_bl u_t007_010/c2_w1_br
+ u_t007_010/c2_r0_rbl u_t007_010/c2_r1_rbl u_t007_010/c3_w0_bl u_t007_010/c3_w0_br
+ u_t007_010/c3_w1_bl u_t007_010/c3_w1_br u_t007_010/c3_r0_rbl u_t007_010/c3_r1_rbl
+ u_t007_010/r0_w0_wl u_t007_010/r0_w1_wl u_t007_010/r0_r0_rwl u_t007_010/r0_r1_rwl
+ u_t007_010/r1_w0_wl u_t007_010/r1_w1_wl u_t007_010/r1_r0_rwl u_t007_010/r1_r1_rwl
+ u_t007_010/r2_w0_wl u_t007_010/r2_w1_wl u_t007_010/r2_r0_rwl u_t007_010/r2_r1_rwl
+ u_t007_010/r3_w0_wl u_t007_010/r3_w1_wl u_t007_010/r3_r0_rwl u_t007_010/r3_r1_rwl
+ VSS u_t007_010/VSS VSUBS detronyx_12t_2w2r_rc4_4x4_routed_5layer_direct
Xu_t013_013 u_t013_013/c0_w0_bl u_t013_013/c0_w0_br u_t013_013/c0_w1_bl u_t013_013/c0_w1_br
+ u_t013_013/c0_r0_rbl u_t013_013/c0_r1_rbl u_t013_013/c1_w0_bl u_t013_013/c1_w0_br
+ u_t013_013/c1_w1_bl u_t013_013/c1_w1_br u_t013_013/c1_r0_rbl u_t013_013/c1_r1_rbl
+ u_t013_013/c2_w0_bl u_t013_013/c2_w0_br u_t013_013/c2_w1_bl u_t013_013/c2_w1_br
+ u_t013_013/c2_r0_rbl u_t013_013/c2_r1_rbl u_t013_013/c3_w0_bl u_t013_013/c3_w0_br
+ u_t013_013/c3_w1_bl u_t013_013/c3_w1_br u_t013_013/c3_r0_rbl u_t013_013/c3_r1_rbl
+ u_t013_013/r0_w0_wl u_t013_013/r0_w1_wl u_t013_013/r0_r0_rwl u_t013_013/r0_r1_rwl
+ u_t013_013/r1_w0_wl u_t013_013/r1_w1_wl u_t013_013/r1_r0_rwl u_t013_013/r1_r1_rwl
+ u_t013_013/r2_w0_wl u_t013_013/r2_w1_wl u_t013_013/r2_r0_rwl u_t013_013/r2_r1_rwl
+ u_t013_013/r3_w0_wl u_t013_013/r3_w1_wl u_t013_013/r3_r0_rwl u_t013_013/r3_r1_rwl
+ u_t013_013/VDD u_t013_015/VSS VSUBS detronyx_12t_2w2r_rc4_4x4_routed_5layer_direct
Xu_t013_002 u_t013_002/c0_w0_bl u_t013_002/c0_w0_br u_t013_002/c0_w1_bl u_t013_002/c0_w1_br
+ u_t013_002/c0_r0_rbl u_t013_002/c0_r1_rbl u_t013_002/c1_w0_bl u_t013_002/c1_w0_br
+ u_t013_002/c1_w1_bl u_t013_002/c1_w1_br u_t013_002/c1_r0_rbl u_t013_002/c1_r1_rbl
+ u_t013_002/c2_w0_bl u_t013_002/c2_w0_br u_t013_002/c2_w1_bl u_t013_002/c2_w1_br
+ u_t013_002/c2_r0_rbl u_t013_002/c2_r1_rbl u_t013_002/c3_w0_bl u_t013_002/c3_w0_br
+ u_t013_002/c3_w1_bl u_t013_002/c3_w1_br u_t013_002/c3_r0_rbl u_t013_002/c3_r1_rbl
+ u_t013_002/r0_w0_wl u_t013_002/r0_w1_wl u_t013_002/r0_r0_rwl u_t013_002/r0_r1_rwl
+ u_t013_002/r1_w0_wl u_t013_002/r1_w1_wl u_t013_002/r1_r0_rwl u_t013_002/r1_r1_rwl
+ u_t013_002/r2_w0_wl u_t013_002/r2_w1_wl u_t013_002/r2_r0_rwl u_t013_002/r2_r1_rwl
+ u_t013_002/r3_w0_wl u_t013_002/r3_w1_wl u_t013_002/r3_r0_rwl u_t013_002/r3_r1_rwl
+ VSS u_t013_015/VSS VSUBS detronyx_12t_2w2r_rc4_4x4_routed_5layer_direct
Xgf180mcu_as_sc_mcu7t3v3__inv_2_466 gf180mcu_as_sc_mcu7t3v3__inv_2_468/VDD VSS gf180mcu_as_sc_mcu7t3v3__inv_2_466/Y
+ gf180mcu_as_sc_mcu7t3v3__inv_2_466/A gf180mcu_as_sc_mcu7t3v3__inv_2_468/VNW VSUBS
+ gf180mcu_as_sc_mcu7t3v3__inv_2
Xgf180mcu_as_sc_mcu7t3v3__inv_2_400 VSS gf180mcu_as_sc_mcu7t3v3__inv_2_405/VDD gf180mcu_as_sc_mcu7t3v3__inv_2_400/Y
+ gf180mcu_as_sc_mcu7t3v3__inv_2_466/A gf180mcu_as_sc_mcu7t3v3__inv_2_402/VNW VSUBS
+ gf180mcu_as_sc_mcu7t3v3__inv_2
Xgf180mcu_as_sc_mcu7t3v3__inv_2_455 VSS VSS gf180mcu_as_sc_mcu7t3v3__inv_2_455/Y VSS
+ gf180mcu_as_sc_mcu7t3v3__inv_2_455/VNW VSUBS gf180mcu_as_sc_mcu7t3v3__inv_2
Xgf180mcu_as_sc_mcu7t3v3__inv_2_444 VSS VSS VSS VSS gf180mcu_as_sc_mcu7t3v3__inv_2_446/VNW
+ VSUBS gf180mcu_as_sc_mcu7t3v3__inv_2
Xgf180mcu_as_sc_mcu7t3v3__inv_2_433 VSS VSS VSS VSS gf180mcu_as_sc_mcu7t3v3__inv_2_434/VNW
+ VSUBS gf180mcu_as_sc_mcu7t3v3__inv_2
Xgf180mcu_as_sc_mcu7t3v3__inv_2_422 VSS VSS VSS VSS gf180mcu_as_sc_mcu7t3v3__inv_2_422/VNW
+ VSUBS gf180mcu_as_sc_mcu7t3v3__inv_2
Xgf180mcu_as_sc_mcu7t3v3__inv_2_411 VSS VSS VSS VSS gf180mcu_as_sc_mcu7t3v3__inv_2_413/VNW
+ VSUBS gf180mcu_as_sc_mcu7t3v3__inv_2
Xgf180mcu_as_sc_mcu7t3v3__inv_2_477 VSS VSS VSS VSS gf180mcu_as_sc_mcu7t3v3__inv_2_477/VNW
+ VSUBS gf180mcu_as_sc_mcu7t3v3__inv_2
Xu_t004_002 u_t004_002/c0_w0_bl u_t004_002/c0_w0_br u_t004_002/c0_w1_bl u_t004_002/c0_w1_br
+ u_t004_002/c0_r0_rbl u_t004_002/c0_r1_rbl u_t004_002/c1_w0_bl u_t004_002/c1_w0_br
+ u_t004_002/c1_w1_bl u_t004_002/c1_w1_br u_t004_002/c1_r0_rbl u_t004_002/c1_r1_rbl
+ u_t004_002/c2_w0_bl u_t004_002/c2_w0_br u_t004_002/c2_w1_bl u_t004_002/c2_w1_br
+ u_t004_002/c2_r0_rbl u_t004_002/c2_r1_rbl u_t004_002/c3_w0_bl u_t004_002/c3_w0_br
+ u_t004_002/c3_w1_bl u_t004_002/c3_w1_br u_t004_002/c3_r0_rbl u_t004_002/c3_r1_rbl
+ u_t004_002/r0_w0_wl u_t004_002/r0_w1_wl u_t004_002/r0_r0_rwl u_t004_002/r0_r1_rwl
+ u_t004_002/r1_w0_wl u_t004_002/r1_w1_wl u_t004_002/r1_r0_rwl u_t004_002/r1_r1_rwl
+ u_t004_002/r2_w0_wl u_t004_002/r2_w1_wl u_t004_002/r2_r0_rwl u_t004_002/r2_r1_rwl
+ u_t004_002/r3_w0_wl u_t004_002/r3_w1_wl u_t004_002/r3_r0_rwl u_t004_002/r3_r1_rwl
+ VSS u_t004_015/VSS VSUBS detronyx_12t_2w2r_rc4_4x4_routed_5layer_direct
Xu_t004_013 u_t004_013/c0_w0_bl u_t004_013/c0_w0_br u_t004_013/c0_w1_bl u_t004_013/c0_w1_br
+ u_t004_013/c0_r0_rbl u_t004_013/c0_r1_rbl u_t004_013/c1_w0_bl u_t004_013/c1_w0_br
+ u_t004_013/c1_w1_bl u_t004_013/c1_w1_br u_t004_013/c1_r0_rbl u_t004_013/c1_r1_rbl
+ u_t004_013/c2_w0_bl u_t004_013/c2_w0_br u_t004_013/c2_w1_bl u_t004_013/c2_w1_br
+ u_t004_013/c2_r0_rbl u_t004_013/c2_r1_rbl u_t004_013/c3_w0_bl u_t004_013/c3_w0_br
+ u_t004_013/c3_w1_bl u_t004_013/c3_w1_br u_t004_013/c3_r0_rbl u_t004_013/c3_r1_rbl
+ u_t004_013/r0_w0_wl u_t004_013/r0_w1_wl u_t004_013/r0_r0_rwl u_t004_013/r0_r1_rwl
+ u_t004_013/r1_w0_wl u_t004_013/r1_w1_wl u_t004_013/r1_r0_rwl u_t004_013/r1_r1_rwl
+ u_t004_013/r2_w0_wl u_t004_013/r2_w1_wl u_t004_013/r2_r0_rwl u_t004_013/r2_r1_rwl
+ u_t004_013/r3_w0_wl u_t004_013/r3_w1_wl u_t004_013/r3_r0_rwl u_t004_013/r3_r1_rwl
+ u_t004_013/VDD u_t004_015/VSS VSUBS detronyx_12t_2w2r_rc4_4x4_routed_5layer_direct
Xgf180mcu_as_sc_mcu7t3v3__inv_2_499 VSS VSS VSS VSS gf180mcu_as_sc_mcu7t3v3__inv_2_501/VNW
+ VSUBS gf180mcu_as_sc_mcu7t3v3__inv_2
Xgf180mcu_as_sc_mcu7t3v3__inv_2_488 VSS VSS VSS VSS gf180mcu_as_sc_mcu7t3v3__inv_2_489/VNW
+ VSUBS gf180mcu_as_sc_mcu7t3v3__inv_2
Xu_t010_005 u_t010_005/c0_w0_bl u_t010_005/c0_w0_br u_t010_005/c0_w1_bl u_t010_005/c0_w1_br
+ u_t010_005/c0_r0_rbl u_t010_005/c0_r1_rbl u_t010_005/c1_w0_bl u_t010_005/c1_w0_br
+ u_t010_005/c1_w1_bl u_t010_005/c1_w1_br u_t010_005/c1_r0_rbl u_t010_005/c1_r1_rbl
+ u_t010_005/c2_w0_bl u_t010_005/c2_w0_br u_t010_005/c2_w1_bl u_t010_005/c2_w1_br
+ u_t010_005/c2_r0_rbl u_t010_005/c2_r1_rbl u_t010_005/c3_w0_bl u_t010_005/c3_w0_br
+ u_t010_005/c3_w1_bl u_t010_005/c3_w1_br u_t010_005/c3_r0_rbl u_t010_005/c3_r1_rbl
+ u_t010_005/r0_w0_wl u_t010_005/r0_w1_wl u_t010_005/r0_r0_rwl u_t010_005/r0_r1_rwl
+ u_t010_005/r1_w0_wl u_t010_005/r1_w1_wl u_t010_005/r1_r0_rwl u_t010_005/r1_r1_rwl
+ u_t010_005/r2_w0_wl u_t010_005/r2_w1_wl u_t010_005/r2_r0_rwl u_t010_005/r2_r1_rwl
+ u_t010_005/r3_w0_wl u_t010_005/r3_w1_wl u_t010_005/r3_r0_rwl u_t010_005/r3_r1_rwl
+ u_t010_005/VDD u_t010_005/VSS VSUBS detronyx_12t_2w2r_rc4_4x4_routed_5layer_direct
Xu_t001_005 u_t001_005/c0_w0_bl u_t001_005/c0_w0_br u_t001_005/c0_w1_bl u_t001_005/c0_w1_br
+ u_t001_005/c0_r0_rbl u_t001_005/c0_r1_rbl u_t001_005/c1_w0_bl u_t001_005/c1_w0_br
+ u_t001_005/c1_w1_bl u_t001_005/c1_w1_br u_t001_005/c1_r0_rbl u_t001_005/c1_r1_rbl
+ u_t001_005/c2_w0_bl u_t001_005/c2_w0_br u_t001_005/c2_w1_bl u_t001_005/c2_w1_br
+ u_t001_005/c2_r0_rbl u_t001_005/c2_r1_rbl u_t001_005/c3_w0_bl u_t001_005/c3_w0_br
+ u_t001_005/c3_w1_bl u_t001_005/c3_w1_br u_t001_005/c3_r0_rbl u_t001_005/c3_r1_rbl
+ u_t001_005/r0_w0_wl u_t001_005/r0_w1_wl u_t001_005/r0_r0_rwl u_t001_005/r0_r1_rwl
+ u_t001_005/r1_w0_wl u_t001_005/r1_w1_wl u_t001_005/r1_r0_rwl u_t001_005/r1_r1_rwl
+ u_t001_005/r2_w0_wl u_t001_005/r2_w1_wl u_t001_005/r2_r0_rwl u_t001_005/r2_r1_rwl
+ u_t001_005/r3_w0_wl u_t001_005/r3_w1_wl u_t001_005/r3_r0_rwl u_t001_005/r3_r1_rwl
+ u_t001_005/VDD u_t001_015/VSS VSUBS detronyx_12t_2w2r_rc4_4x4_routed_5layer_direct
Xgf180mcu_as_sc_mcu7t3v3__inv_2_285 VSS VSS VSS VSS gf180mcu_as_sc_mcu7t3v3__inv_2_286/VNW
+ VSUBS gf180mcu_as_sc_mcu7t3v3__inv_2
Xgf180mcu_as_sc_mcu7t3v3__inv_2_296 VSS VSS VSS VSS gf180mcu_as_sc_mcu7t3v3__inv_2_298/VNW
+ VSUBS gf180mcu_as_sc_mcu7t3v3__inv_2
Xgf180mcu_as_sc_mcu7t3v3__inv_2_241 gf180mcu_as_sc_mcu7t3v3__nor2_2_5/VDD gf180mcu_as_sc_mcu7t3v3__nor2_2_5/VSS
+ gf180mcu_as_sc_mcu7t3v3__inv_2_241/Y VSS gf180mcu_as_sc_mcu7t3v3__nor2_2_5/VNW VSUBS
+ gf180mcu_as_sc_mcu7t3v3__inv_2
Xgf180mcu_as_sc_mcu7t3v3__inv_2_252 gf180mcu_as_sc_mcu7t3v3__nor2_2_5/VDD gf180mcu_as_sc_mcu7t3v3__nor2_2_5/VSS
+ VSS VSS gf180mcu_as_sc_mcu7t3v3__nor2_2_5/VNW VSUBS gf180mcu_as_sc_mcu7t3v3__inv_2
Xgf180mcu_as_sc_mcu7t3v3__inv_2_263 gf180mcu_as_sc_mcu7t3v3__nor2_2_4/VDD gf180mcu_as_sc_mcu7t3v3__nand3_2_8/VSS
+ VSS VSS gf180mcu_as_sc_mcu7t3v3__nor2_2_4/VNW VSUBS gf180mcu_as_sc_mcu7t3v3__inv_2
Xgf180mcu_as_sc_mcu7t3v3__inv_2_274 gf180mcu_as_sc_mcu7t3v3__nor2_2_4/VDD gf180mcu_as_sc_mcu7t3v3__nand3_2_8/VSS
+ gf180mcu_as_sc_mcu7t3v3__inv_2_274/Y VSS gf180mcu_as_sc_mcu7t3v3__nor2_2_4/VNW VSUBS
+ gf180mcu_as_sc_mcu7t3v3__inv_2
Xgf180mcu_as_sc_mcu7t3v3__inv_2_230 gf180mcu_as_sc_mcu7t3v3__nand2_2_9/VDD gf180mcu_as_sc_mcu7t3v3__nor2_2_4/VSS
+ VSS VSS gf180mcu_as_sc_mcu7t3v3__nand2_2_9/VNW VSUBS gf180mcu_as_sc_mcu7t3v3__inv_2
Xgf180mcu_as_sc_mcu7t3v3__nand2_2_3 gf180mcu_as_sc_mcu7t3v3__nor2_2_5/VDD gf180mcu_as_sc_mcu7t3v3__nand3_2_8/VSS
+ VSS VSS VSS gf180mcu_as_sc_mcu7t3v3__nor2_2_5/VNW VSUBS gf180mcu_as_sc_mcu7t3v3__nand2_2
Xgf180mcu_as_sc_mcu7t3v3__inv_2_807 VSS gf180mcu_as_sc_mcu7t3v3__inv_2_812/VDD gf180mcu_as_sc_mcu7t3v3__inv_2_807/Y
+ VSS gf180mcu_as_sc_mcu7t3v3__inv_2_809/VNW VSUBS gf180mcu_as_sc_mcu7t3v3__inv_2
Xgf180mcu_as_sc_mcu7t3v3__inv_2_818 VSS VSS VSS VSS gf180mcu_as_sc_mcu7t3v3__inv_2_818/VNW
+ VSUBS gf180mcu_as_sc_mcu7t3v3__inv_2
Xgf180mcu_as_sc_mcu7t3v3__inv_2_829 gf180mcu_as_sc_mcu7t3v3__inv_2_830/VSS gf180mcu_as_sc_mcu7t3v3__inv_2_830/VSS
+ VSS VSS gf180mcu_as_sc_mcu7t3v3__inv_2_830/VNW VSUBS gf180mcu_as_sc_mcu7t3v3__inv_2
Xgf180mcu_as_sc_mcu7t3v3__nand4_2_117 VSS VSS VSS VSS VSS VSS gf180mcu_as_sc_mcu7t3v3__nand4_2_117/Y
+ gf180mcu_as_sc_mcu7t3v3__inv_2_455/VNW VSUBS gf180mcu_as_sc_mcu7t3v3__nand4_2
Xgf180mcu_as_sc_mcu7t3v3__nand4_2_106 VSS VSS VSS VSS VSS VSS VSS gf180mcu_as_sc_mcu7t3v3__inv_2_422/VNW
+ VSUBS gf180mcu_as_sc_mcu7t3v3__nand4_2
Xgf180mcu_as_sc_mcu7t3v3__nand4_2_128 VSS VSS VSS VSS VSS VSS VSS gf180mcu_as_sc_mcu7t3v3__inv_2_486/VNW
+ VSUBS gf180mcu_as_sc_mcu7t3v3__nand4_2
Xgf180mcu_as_sc_mcu7t3v3__nand4_2_139 VSS VSS VSS VSS VSS VSS VSS gf180mcu_as_sc_mcu7t3v3__inv_2_519/VNW
+ VSUBS gf180mcu_as_sc_mcu7t3v3__nand4_2
Xgf180mcu_as_sc_mcu7t3v3__nand4_2_12 VSS gf180mcu_as_sc_mcu7t3v3__inv_2_39/VDD VSS
+ VSS VSS VSS gf180mcu_as_sc_mcu7t3v3__nand4_2_12/Y gf180mcu_as_sc_mcu7t3v3__inv_2_36/VNW
+ VSUBS gf180mcu_as_sc_mcu7t3v3__nand4_2
Xgf180mcu_as_sc_mcu7t3v3__nand4_2_78 VSS VSS VSS VSS VSS VSS VSS gf180mcu_as_sc_mcu7t3v3__inv_2_339/VNW
+ VSUBS gf180mcu_as_sc_mcu7t3v3__nand4_2
Xgf180mcu_as_sc_mcu7t3v3__nand4_2_67 VSS VSS VSS VSS VSS VSS gf180mcu_as_sc_mcu7t3v3__nand4_2_67/Y
+ gf180mcu_as_sc_mcu7t3v3__inv_2_299/VNW VSUBS gf180mcu_as_sc_mcu7t3v3__nand4_2
Xgf180mcu_as_sc_mcu7t3v3__nand4_2_56 VSS gf180mcu_as_sc_mcu7t3v3__inv_2_171/VDD VSS
+ VSS VSS VSS VSS gf180mcu_as_sc_mcu7t3v3__inv_2_168/VNW VSUBS gf180mcu_as_sc_mcu7t3v3__nand4_2
Xgf180mcu_as_sc_mcu7t3v3__nand4_2_34 VSS gf180mcu_as_sc_mcu7t3v3__inv_2_105/VDD VSS
+ VSS VSS VSS gf180mcu_as_sc_mcu7t3v3__nand4_2_34/Y gf180mcu_as_sc_mcu7t3v3__inv_2_102/VNW
+ VSUBS gf180mcu_as_sc_mcu7t3v3__nand4_2
Xgf180mcu_as_sc_mcu7t3v3__nand4_2_89 VSS gf180mcu_as_sc_mcu7t3v3__inv_2_372/VDD VSS
+ VSS VSS VSS VSS gf180mcu_as_sc_mcu7t3v3__inv_2_369/VNW VSUBS gf180mcu_as_sc_mcu7t3v3__nand4_2
Xgf180mcu_as_sc_mcu7t3v3__nand4_2_45 gf180mcu_as_sc_mcu7t3v3__inv_2_135/VDD VSS VSS
+ VSS VSS VSS VSS gf180mcu_as_sc_mcu7t3v3__inv_2_135/VNW VSUBS gf180mcu_as_sc_mcu7t3v3__nand4_2
Xgf180mcu_as_sc_mcu7t3v3__nand4_2_23 VSS gf180mcu_as_sc_mcu7t3v3__inv_2_72/VDD VSS
+ VSS VSS VSS VSS gf180mcu_as_sc_mcu7t3v3__inv_2_69/VNW VSUBS gf180mcu_as_sc_mcu7t3v3__nand4_2
Xgf180mcu_as_sc_mcu7t3v3__inv_2_615 VSS gf180mcu_as_sc_mcu7t3v3__inv_2_618/VDD gf180mcu_as_sc_mcu7t3v3__inv_2_615/Y
+ VSS gf180mcu_as_sc_mcu7t3v3__inv_2_615/VNW VSUBS gf180mcu_as_sc_mcu7t3v3__inv_2
Xgf180mcu_as_sc_mcu7t3v3__inv_2_626 VSS VSS VSS VSS gf180mcu_as_sc_mcu7t3v3__inv_2_630/VNW
+ VSUBS gf180mcu_as_sc_mcu7t3v3__inv_2
Xgf180mcu_as_sc_mcu7t3v3__inv_2_604 VSS gf180mcu_as_sc_mcu7t3v3__inv_2_609/VDD gf180mcu_as_sc_mcu7t3v3__inv_2_604/Y
+ gf180mcu_as_sc_mcu7t3v3__inv_2_611/Y gf180mcu_as_sc_mcu7t3v3__inv_2_606/VNW VSUBS
+ gf180mcu_as_sc_mcu7t3v3__inv_2
Xgf180mcu_as_sc_mcu7t3v3__inv_2_637 VSS VSS VSS VSS gf180mcu_as_sc_mcu7t3v3__inv_2_637/VNW
+ VSUBS gf180mcu_as_sc_mcu7t3v3__inv_2
Xgf180mcu_as_sc_mcu7t3v3__inv_2_659 gf180mcu_as_sc_mcu7t3v3__inv_2_713/VDD gf180mcu_as_sc_mcu7t3v3__inv_2_713/VSS
+ VSS VSS gf180mcu_as_sc_mcu7t3v3__inv_2_713/VNW VSUBS gf180mcu_as_sc_mcu7t3v3__inv_2
Xgf180mcu_as_sc_mcu7t3v3__inv_2_648 gf180mcu_as_sc_mcu7t3v3__nor2_2_8/VDD gf180mcu_as_sc_mcu7t3v3__inv_2_710/VSS
+ VSS VSS gf180mcu_as_sc_mcu7t3v3__nor2_2_8/VNW VSUBS gf180mcu_as_sc_mcu7t3v3__inv_2
Xu_t007_000 u_t007_000/c0_w0_bl u_t007_000/c0_w0_br u_t007_000/c0_w1_bl u_t007_000/c0_w1_br
+ u_t007_000/c0_r0_rbl u_t007_000/c0_r1_rbl u_t007_000/c1_w0_bl u_t007_000/c1_w0_br
+ u_t007_000/c1_w1_bl u_t007_000/c1_w1_br u_t007_000/c1_r0_rbl u_t007_000/c1_r1_rbl
+ u_t007_000/c2_w0_bl u_t007_000/c2_w0_br u_t007_000/c2_w1_bl u_t007_000/c2_w1_br
+ u_t007_000/c2_r0_rbl u_t007_000/c2_r1_rbl u_t007_000/c3_w0_bl u_t007_000/c3_w0_br
+ u_t007_000/c3_w1_bl u_t007_000/c3_w1_br u_t007_000/c3_r0_rbl u_t007_000/c3_r1_rbl
+ u_t007_000/r0_w0_wl u_t007_000/r0_w1_wl u_t007_000/r0_r0_rwl u_t007_000/r0_r1_rwl
+ u_t007_000/r1_w0_wl u_t007_000/r1_w1_wl u_t007_000/r1_r0_rwl u_t007_000/r1_r1_rwl
+ u_t007_000/r2_w0_wl u_t007_000/r2_w1_wl u_t007_000/r2_r0_rwl u_t007_000/r2_r1_rwl
+ u_t007_000/r3_w0_wl u_t007_000/r3_w1_wl u_t007_000/r3_r0_rwl u_t007_000/r3_r1_rwl
+ VSS u_t007_002/VSS VSUBS detronyx_12t_2w2r_rc4_4x4_routed_5layer_direct
Xu_t007_011 u_t007_011/c0_w0_bl u_t007_011/c0_w0_br u_t007_011/c0_w1_bl u_t007_011/c0_w1_br
+ u_t007_011/c0_r0_rbl u_t007_011/c0_r1_rbl u_t007_011/c1_w0_bl u_t007_011/c1_w0_br
+ u_t007_011/c1_w1_bl u_t007_011/c1_w1_br u_t007_011/c1_r0_rbl u_t007_011/c1_r1_rbl
+ u_t007_011/c2_w0_bl u_t007_011/c2_w0_br u_t007_011/c2_w1_bl u_t007_011/c2_w1_br
+ u_t007_011/c2_r0_rbl u_t007_011/c2_r1_rbl u_t007_011/c3_w0_bl u_t007_011/c3_w0_br
+ u_t007_011/c3_w1_bl u_t007_011/c3_w1_br u_t007_011/c3_r0_rbl u_t007_011/c3_r1_rbl
+ u_t007_011/r0_w0_wl u_t007_011/r0_w1_wl u_t007_011/r0_r0_rwl u_t007_011/r0_r1_rwl
+ u_t007_011/r1_w0_wl u_t007_011/r1_w1_wl u_t007_011/r1_r0_rwl u_t007_011/r1_r1_rwl
+ u_t007_011/r2_w0_wl u_t007_011/r2_w1_wl u_t007_011/r2_r0_rwl u_t007_011/r2_r1_rwl
+ u_t007_011/r3_w0_wl u_t007_011/r3_w1_wl u_t007_011/r3_r0_rwl u_t007_011/r3_r1_rwl
+ u_t008_011/VDD u_t007_011/VSS VSUBS detronyx_12t_2w2r_rc4_4x4_routed_5layer_direct
Xu_t013_014 u_t013_014/c0_w0_bl u_t013_014/c0_w0_br u_t013_014/c0_w1_bl u_t013_014/c0_w1_br
+ u_t013_014/c0_r0_rbl u_t013_014/c0_r1_rbl u_t013_014/c1_w0_bl u_t013_014/c1_w0_br
+ u_t013_014/c1_w1_bl u_t013_014/c1_w1_br u_t013_014/c1_r0_rbl u_t013_014/c1_r1_rbl
+ u_t013_014/c2_w0_bl u_t013_014/c2_w0_br u_t013_014/c2_w1_bl u_t013_014/c2_w1_br
+ u_t013_014/c2_r0_rbl u_t013_014/c2_r1_rbl u_t013_014/c3_w0_bl u_t013_014/c3_w0_br
+ u_t013_014/c3_w1_bl u_t013_014/c3_w1_br u_t013_014/c3_r0_rbl u_t013_014/c3_r1_rbl
+ u_t013_014/r0_w0_wl u_t013_014/r0_w1_wl u_t013_014/r0_r0_rwl u_t013_014/r0_r1_rwl
+ u_t013_014/r1_w0_wl u_t013_014/r1_w1_wl u_t013_014/r1_r0_rwl u_t013_014/r1_r1_rwl
+ u_t013_014/r2_w0_wl u_t013_014/r2_w1_wl u_t013_014/r2_r0_rwl u_t013_014/r2_r1_rwl
+ u_t013_014/r3_w0_wl u_t013_014/r3_w1_wl u_t013_014/r3_r0_rwl u_t013_014/r3_r1_rwl
+ u_t013_014/VDD u_t013_015/VSS VSUBS detronyx_12t_2w2r_rc4_4x4_routed_5layer_direct
Xu_t013_003 u_t013_003/c0_w0_bl u_t013_003/c0_w0_br u_t013_003/c0_w1_bl u_t013_003/c0_w1_br
+ u_t013_003/c0_r0_rbl u_t013_003/c0_r1_rbl u_t013_003/c1_w0_bl u_t013_003/c1_w0_br
+ u_t013_003/c1_w1_bl u_t013_003/c1_w1_br u_t013_003/c1_r0_rbl u_t013_003/c1_r1_rbl
+ u_t013_003/c2_w0_bl u_t013_003/c2_w0_br u_t013_003/c2_w1_bl u_t013_003/c2_w1_br
+ u_t013_003/c2_r0_rbl u_t013_003/c2_r1_rbl u_t013_003/c3_w0_bl u_t013_003/c3_w0_br
+ u_t013_003/c3_w1_bl u_t013_003/c3_w1_br u_t013_003/c3_r0_rbl u_t013_003/c3_r1_rbl
+ u_t013_003/r0_w0_wl u_t013_003/r0_w1_wl u_t013_003/r0_r0_rwl u_t013_003/r0_r1_rwl
+ u_t013_003/r1_w0_wl u_t013_003/r1_w1_wl u_t013_003/r1_r0_rwl u_t013_003/r1_r1_rwl
+ u_t013_003/r2_w0_wl u_t013_003/r2_w1_wl u_t013_003/r2_r0_rwl u_t013_003/r2_r1_rwl
+ u_t013_003/r3_w0_wl u_t013_003/r3_w1_wl u_t013_003/r3_r0_rwl u_t013_003/r3_r1_rwl
+ u_t013_003/VDD u_t013_015/VSS VSUBS detronyx_12t_2w2r_rc4_4x4_routed_5layer_direct
Xgf180mcu_as_sc_mcu7t3v3__inv_2_467 gf180mcu_as_sc_mcu7t3v3__inv_2_468/VDD VSS gf180mcu_as_sc_mcu7t3v3__inv_2_467/Y
+ gf180mcu_as_sc_mcu7t3v3__inv_2_468/Y gf180mcu_as_sc_mcu7t3v3__inv_2_468/VNW VSUBS
+ gf180mcu_as_sc_mcu7t3v3__inv_2
Xgf180mcu_as_sc_mcu7t3v3__inv_2_456 VSS VSS VSS VSS gf180mcu_as_sc_mcu7t3v3__inv_2_458/VNW
+ VSUBS gf180mcu_as_sc_mcu7t3v3__inv_2
Xgf180mcu_as_sc_mcu7t3v3__inv_2_401 VSS gf180mcu_as_sc_mcu7t3v3__inv_2_405/VDD gf180mcu_as_sc_mcu7t3v3__inv_2_401/Y
+ gf180mcu_as_sc_mcu7t3v3__inv_2_402/Y gf180mcu_as_sc_mcu7t3v3__inv_2_402/VNW VSUBS
+ gf180mcu_as_sc_mcu7t3v3__inv_2
Xgf180mcu_as_sc_mcu7t3v3__inv_2_445 VSS VSS VSS VSS gf180mcu_as_sc_mcu7t3v3__inv_2_446/VNW
+ VSUBS gf180mcu_as_sc_mcu7t3v3__inv_2
Xgf180mcu_as_sc_mcu7t3v3__inv_2_434 VSS VSS gf180mcu_as_sc_mcu7t3v3__inv_2_434/Y VSS
+ gf180mcu_as_sc_mcu7t3v3__inv_2_434/VNW VSUBS gf180mcu_as_sc_mcu7t3v3__inv_2
Xgf180mcu_as_sc_mcu7t3v3__inv_2_423 VSS VSS VSS VSS gf180mcu_as_sc_mcu7t3v3__inv_2_425/VNW
+ VSUBS gf180mcu_as_sc_mcu7t3v3__inv_2
Xgf180mcu_as_sc_mcu7t3v3__inv_2_412 VSS VSS VSS VSS gf180mcu_as_sc_mcu7t3v3__inv_2_413/VNW
+ VSUBS gf180mcu_as_sc_mcu7t3v3__inv_2
Xgf180mcu_as_sc_mcu7t3v3__inv_2_489 VSS VSS gf180mcu_as_sc_mcu7t3v3__inv_2_489/Y VSS
+ gf180mcu_as_sc_mcu7t3v3__inv_2_489/VNW VSUBS gf180mcu_as_sc_mcu7t3v3__inv_2
Xgf180mcu_as_sc_mcu7t3v3__inv_2_478 VSS VSS VSS VSS gf180mcu_as_sc_mcu7t3v3__inv_2_480/VNW
+ VSUBS gf180mcu_as_sc_mcu7t3v3__inv_2
Xu_t004_003 u_t004_003/c0_w0_bl u_t004_003/c0_w0_br u_t004_003/c0_w1_bl u_t004_003/c0_w1_br
+ u_t004_003/c0_r0_rbl u_t004_003/c0_r1_rbl u_t004_003/c1_w0_bl u_t004_003/c1_w0_br
+ u_t004_003/c1_w1_bl u_t004_003/c1_w1_br u_t004_003/c1_r0_rbl u_t004_003/c1_r1_rbl
+ u_t004_003/c2_w0_bl u_t004_003/c2_w0_br u_t004_003/c2_w1_bl u_t004_003/c2_w1_br
+ u_t004_003/c2_r0_rbl u_t004_003/c2_r1_rbl u_t004_003/c3_w0_bl u_t004_003/c3_w0_br
+ u_t004_003/c3_w1_bl u_t004_003/c3_w1_br u_t004_003/c3_r0_rbl u_t004_003/c3_r1_rbl
+ u_t004_003/r0_w0_wl u_t004_003/r0_w1_wl u_t004_003/r0_r0_rwl u_t004_003/r0_r1_rwl
+ u_t004_003/r1_w0_wl u_t004_003/r1_w1_wl u_t004_003/r1_r0_rwl u_t004_003/r1_r1_rwl
+ u_t004_003/r2_w0_wl u_t004_003/r2_w1_wl u_t004_003/r2_r0_rwl u_t004_003/r2_r1_rwl
+ u_t004_003/r3_w0_wl u_t004_003/r3_w1_wl u_t004_003/r3_r0_rwl u_t004_003/r3_r1_rwl
+ u_t004_003/VDD u_t004_015/VSS VSUBS detronyx_12t_2w2r_rc4_4x4_routed_5layer_direct
Xu_t004_014 u_t004_014/c0_w0_bl u_t004_014/c0_w0_br u_t004_014/c0_w1_bl u_t004_014/c0_w1_br
+ u_t004_014/c0_r0_rbl u_t004_014/c0_r1_rbl u_t004_014/c1_w0_bl u_t004_014/c1_w0_br
+ u_t004_014/c1_w1_bl u_t004_014/c1_w1_br u_t004_014/c1_r0_rbl u_t004_014/c1_r1_rbl
+ u_t004_014/c2_w0_bl u_t004_014/c2_w0_br u_t004_014/c2_w1_bl u_t004_014/c2_w1_br
+ u_t004_014/c2_r0_rbl u_t004_014/c2_r1_rbl u_t004_014/c3_w0_bl u_t004_014/c3_w0_br
+ u_t004_014/c3_w1_bl u_t004_014/c3_w1_br u_t004_014/c3_r0_rbl u_t004_014/c3_r1_rbl
+ u_t004_014/r0_w0_wl u_t004_014/r0_w1_wl u_t004_014/r0_r0_rwl u_t004_014/r0_r1_rwl
+ u_t004_014/r1_w0_wl u_t004_014/r1_w1_wl u_t004_014/r1_r0_rwl u_t004_014/r1_r1_rwl
+ u_t004_014/r2_w0_wl u_t004_014/r2_w1_wl u_t004_014/r2_r0_rwl u_t004_014/r2_r1_rwl
+ u_t004_014/r3_w0_wl u_t004_014/r3_w1_wl u_t004_014/r3_r0_rwl u_t004_014/r3_r1_rwl
+ u_t004_014/VDD u_t004_015/VSS VSUBS detronyx_12t_2w2r_rc4_4x4_routed_5layer_direct
Xu_t010_006 u_t010_006/c0_w0_bl u_t010_006/c0_w0_br u_t010_006/c0_w1_bl u_t010_006/c0_w1_br
+ u_t010_006/c0_r0_rbl u_t010_006/c0_r1_rbl u_t010_006/c1_w0_bl u_t010_006/c1_w0_br
+ u_t010_006/c1_w1_bl u_t010_006/c1_w1_br u_t010_006/c1_r0_rbl u_t010_006/c1_r1_rbl
+ u_t010_006/c2_w0_bl u_t010_006/c2_w0_br u_t010_006/c2_w1_bl u_t010_006/c2_w1_br
+ u_t010_006/c2_r0_rbl u_t010_006/c2_r1_rbl u_t010_006/c3_w0_bl u_t010_006/c3_w0_br
+ u_t010_006/c3_w1_bl u_t010_006/c3_w1_br u_t010_006/c3_r0_rbl u_t010_006/c3_r1_rbl
+ u_t010_006/r0_w0_wl u_t010_006/r0_w1_wl u_t010_006/r0_r0_rwl u_t010_006/r0_r1_rwl
+ u_t010_006/r1_w0_wl u_t010_006/r1_w1_wl u_t010_006/r1_r0_rwl u_t010_006/r1_r1_rwl
+ u_t010_006/r2_w0_wl u_t010_006/r2_w1_wl u_t010_006/r2_r0_rwl u_t010_006/r2_r1_rwl
+ u_t010_006/r3_w0_wl u_t010_006/r3_w1_wl u_t010_006/r3_r0_rwl u_t010_006/r3_r1_rwl
+ u_t010_006/VDD u_t010_009/VSS VSUBS detronyx_12t_2w2r_rc4_4x4_routed_5layer_direct
Xu_t001_006 u_t001_006/c0_w0_bl u_t001_006/c0_w0_br u_t001_006/c0_w1_bl u_t001_006/c0_w1_br
+ u_t001_006/c0_r0_rbl u_t001_006/c0_r1_rbl u_t001_006/c1_w0_bl u_t001_006/c1_w0_br
+ u_t001_006/c1_w1_bl u_t001_006/c1_w1_br u_t001_006/c1_r0_rbl u_t001_006/c1_r1_rbl
+ u_t001_006/c2_w0_bl u_t001_006/c2_w0_br u_t001_006/c2_w1_bl u_t001_006/c2_w1_br
+ u_t001_006/c2_r0_rbl u_t001_006/c2_r1_rbl u_t001_006/c3_w0_bl u_t001_006/c3_w0_br
+ u_t001_006/c3_w1_bl u_t001_006/c3_w1_br u_t001_006/c3_r0_rbl u_t001_006/c3_r1_rbl
+ u_t001_006/r0_w0_wl u_t001_006/r0_w1_wl u_t001_006/r0_r0_rwl u_t001_006/r0_r1_rwl
+ u_t001_006/r1_w0_wl u_t001_006/r1_w1_wl u_t001_006/r1_r0_rwl u_t001_006/r1_r1_rwl
+ u_t001_006/r2_w0_wl u_t001_006/r2_w1_wl u_t001_006/r2_r0_rwl u_t001_006/r2_r1_rwl
+ u_t001_006/r3_w0_wl u_t001_006/r3_w1_wl u_t001_006/r3_r0_rwl u_t001_006/r3_r1_rwl
+ u_t001_006/VDD u_t001_015/VSS VSUBS detronyx_12t_2w2r_rc4_4x4_routed_5layer_direct
Xgf180mcu_as_sc_mcu7t3v3__inv_2_286 VSS VSS gf180mcu_as_sc_mcu7t3v3__inv_2_286/Y VSS
+ gf180mcu_as_sc_mcu7t3v3__inv_2_286/VNW VSUBS gf180mcu_as_sc_mcu7t3v3__inv_2
Xgf180mcu_as_sc_mcu7t3v3__inv_2_297 VSS VSS VSS VSS gf180mcu_as_sc_mcu7t3v3__inv_2_298/VNW
+ VSUBS gf180mcu_as_sc_mcu7t3v3__inv_2
Xgf180mcu_as_sc_mcu7t3v3__inv_2_275 gf180mcu_as_sc_mcu7t3v3__nor2_2_5/VDD gf180mcu_as_sc_mcu7t3v3__nor2_2_5/VSS
+ gf180mcu_as_sc_mcu7t3v3__inv_2_275/Y VSS gf180mcu_as_sc_mcu7t3v3__nor2_2_5/VNW VSUBS
+ gf180mcu_as_sc_mcu7t3v3__inv_2
Xgf180mcu_as_sc_mcu7t3v3__inv_2_242 gf180mcu_as_sc_mcu7t3v3__nor2_2_5/VDD gf180mcu_as_sc_mcu7t3v3__nand3_2_8/VSS
+ gf180mcu_as_sc_mcu7t3v3__inv_2_242/Y VSS gf180mcu_as_sc_mcu7t3v3__nor2_2_5/VNW VSUBS
+ gf180mcu_as_sc_mcu7t3v3__inv_2
Xgf180mcu_as_sc_mcu7t3v3__inv_2_253 gf180mcu_as_sc_mcu7t3v3__nor2_2_5/VDD gf180mcu_as_sc_mcu7t3v3__nand3_2_8/VSS
+ VSS VSS gf180mcu_as_sc_mcu7t3v3__nor2_2_5/VNW VSUBS gf180mcu_as_sc_mcu7t3v3__inv_2
Xgf180mcu_as_sc_mcu7t3v3__inv_2_264 gf180mcu_as_sc_mcu7t3v3__nor2_2_4/VDD gf180mcu_as_sc_mcu7t3v3__nor2_2_4/VSS
+ VSS VSS gf180mcu_as_sc_mcu7t3v3__nor2_2_4/VNW VSUBS gf180mcu_as_sc_mcu7t3v3__inv_2
Xgf180mcu_as_sc_mcu7t3v3__inv_2_220 gf180mcu_as_sc_mcu7t3v3__nor2_2_6/VDD gf180mcu_as_sc_mcu7t3v3__nand3_2_1/VSS
+ VSS VSS gf180mcu_as_sc_mcu7t3v3__nor2_2_6/VNW VSUBS gf180mcu_as_sc_mcu7t3v3__inv_2
Xgf180mcu_as_sc_mcu7t3v3__inv_2_231 gf180mcu_as_sc_mcu7t3v3__nand2_2_9/VDD gf180mcu_as_sc_mcu7t3v3__nor2_2_6/VSS
+ VSS VSS gf180mcu_as_sc_mcu7t3v3__nand2_2_9/VNW VSUBS gf180mcu_as_sc_mcu7t3v3__inv_2
Xgf180mcu_as_sc_mcu7t3v3__nand2_2_4 gf180mcu_as_sc_mcu7t3v3__nor2_2_6/VDD gf180mcu_as_sc_mcu7t3v3__nor2_2_6/VSS
+ VSS VSS VSS gf180mcu_as_sc_mcu7t3v3__nor2_2_6/VNW VSUBS gf180mcu_as_sc_mcu7t3v3__nand2_2
Xgf180mcu_as_sc_mcu7t3v3__inv_2_808 VSS gf180mcu_as_sc_mcu7t3v3__inv_2_812/VDD gf180mcu_as_sc_mcu7t3v3__inv_2_808/Y
+ VSS gf180mcu_as_sc_mcu7t3v3__inv_2_809/VNW VSUBS gf180mcu_as_sc_mcu7t3v3__inv_2
Xgf180mcu_as_sc_mcu7t3v3__inv_2_819 VSS gf180mcu_as_sc_mcu7t3v3__inv_2_827/VDD gf180mcu_as_sc_mcu7t3v3__inv_2_819/Y
+ VSS gf180mcu_as_sc_mcu7t3v3__inv_2_821/VNW VSUBS gf180mcu_as_sc_mcu7t3v3__inv_2
Xgf180mcu_as_sc_mcu7t3v3__nand4_2_13 gf180mcu_as_sc_mcu7t3v3__inv_2_39/VDD gf180mcu_as_sc_mcu7t3v3__inv_2_45/VDD
+ VSS VSS VSS VSS gf180mcu_as_sc_mcu7t3v3__nand4_2_13/Y gf180mcu_as_sc_mcu7t3v3__inv_2_39/VNW
+ VSUBS gf180mcu_as_sc_mcu7t3v3__nand4_2
Xgf180mcu_as_sc_mcu7t3v3__nand4_2_118 VSS VSS VSS VSS VSS VSS VSS gf180mcu_as_sc_mcu7t3v3__inv_2_458/VNW
+ VSUBS gf180mcu_as_sc_mcu7t3v3__nand4_2
Xgf180mcu_as_sc_mcu7t3v3__nand4_2_35 gf180mcu_as_sc_mcu7t3v3__inv_2_105/VDD VSS VSS
+ VSS VSS VSS VSS gf180mcu_as_sc_mcu7t3v3__inv_2_105/VNW VSUBS gf180mcu_as_sc_mcu7t3v3__nand4_2
Xgf180mcu_as_sc_mcu7t3v3__nand4_2_107 VSS VSS VSS VSS VSS VSS gf180mcu_as_sc_mcu7t3v3__nand4_2_107/Y
+ gf180mcu_as_sc_mcu7t3v3__inv_2_425/VNW VSUBS gf180mcu_as_sc_mcu7t3v3__nand4_2
Xgf180mcu_as_sc_mcu7t3v3__nand4_2_24 gf180mcu_as_sc_mcu7t3v3__inv_2_72/VDD gf180mcu_as_sc_mcu7t3v3__inv_2_75/VDD
+ VSS VSS VSS VSS gf180mcu_as_sc_mcu7t3v3__nand4_2_24/Y gf180mcu_as_sc_mcu7t3v3__inv_2_72/VNW
+ VSUBS gf180mcu_as_sc_mcu7t3v3__nand4_2
Xgf180mcu_as_sc_mcu7t3v3__nand4_2_129 VSS VSS VSS VSS VSS VSS gf180mcu_as_sc_mcu7t3v3__nand4_2_129/Y
+ gf180mcu_as_sc_mcu7t3v3__inv_2_489/VNW VSUBS gf180mcu_as_sc_mcu7t3v3__nand4_2
Xgf180mcu_as_sc_mcu7t3v3__nand4_2_79 VSS gf180mcu_as_sc_mcu7t3v3__inv_2_348/VDD VSS
+ VSS VSS VSS VSS gf180mcu_as_sc_mcu7t3v3__inv_2_343/VNW VSUBS gf180mcu_as_sc_mcu7t3v3__nand4_2
Xgf180mcu_as_sc_mcu7t3v3__nand4_2_68 VSS VSS VSS VSS VSS VSS gf180mcu_as_sc_mcu7t3v3__nand4_2_68/Y
+ gf180mcu_as_sc_mcu7t3v3__inv_2_318/VNW VSUBS gf180mcu_as_sc_mcu7t3v3__nand4_2
Xgf180mcu_as_sc_mcu7t3v3__nand4_2_57 gf180mcu_as_sc_mcu7t3v3__inv_2_171/VDD gf180mcu_as_sc_mcu7t3v3__inv_2_173/VDD
+ VSS VSS VSS VSS VSS gf180mcu_as_sc_mcu7t3v3__inv_2_171/VNW VSUBS gf180mcu_as_sc_mcu7t3v3__nand4_2
Xgf180mcu_as_sc_mcu7t3v3__nand4_2_46 VSS gf180mcu_as_sc_mcu7t3v3__inv_2_141/VDD VSS
+ VSS VSS VSS VSS gf180mcu_as_sc_mcu7t3v3__inv_2_138/VNW VSUBS gf180mcu_as_sc_mcu7t3v3__nand4_2
Xgf180mcu_as_sc_mcu7t3v3__inv_2_616 gf180mcu_as_sc_mcu7t3v3__inv_2_618/VDD gf180mcu_as_sc_mcu7t3v3__inv_2_719/VDD
+ gf180mcu_as_sc_mcu7t3v3__inv_2_616/Y gf180mcu_as_sc_mcu7t3v3__inv_2_717/A gf180mcu_as_sc_mcu7t3v3__inv_2_618/VNW
+ VSUBS gf180mcu_as_sc_mcu7t3v3__inv_2
Xgf180mcu_as_sc_mcu7t3v3__inv_2_638 VSS VSS VSS VSS gf180mcu_as_sc_mcu7t3v3__inv_2_642/VNW
+ VSUBS gf180mcu_as_sc_mcu7t3v3__inv_2
Xgf180mcu_as_sc_mcu7t3v3__inv_2_605 VSS gf180mcu_as_sc_mcu7t3v3__inv_2_609/VDD gf180mcu_as_sc_mcu7t3v3__inv_2_611/Y
+ gf180mcu_as_sc_mcu7t3v3__inv_2_606/Y gf180mcu_as_sc_mcu7t3v3__inv_2_606/VNW VSUBS
+ gf180mcu_as_sc_mcu7t3v3__inv_2
Xgf180mcu_as_sc_mcu7t3v3__inv_2_627 VSS VSS VSS VSS gf180mcu_as_sc_mcu7t3v3__inv_2_629/VNW
+ VSUBS gf180mcu_as_sc_mcu7t3v3__inv_2
Xgf180mcu_as_sc_mcu7t3v3__inv_2_649 gf180mcu_as_sc_mcu7t3v3__nor2_2_8/VDD gf180mcu_as_sc_mcu7t3v3__nor2_2_8/VSS
+ VSS VSS gf180mcu_as_sc_mcu7t3v3__nor2_2_8/VNW VSUBS gf180mcu_as_sc_mcu7t3v3__inv_2
Xu_t007_001 u_t007_001/c0_w0_bl u_t007_001/c0_w0_br u_t007_001/c0_w1_bl u_t007_001/c0_w1_br
+ u_t007_001/c0_r0_rbl u_t007_001/c0_r1_rbl u_t007_001/c1_w0_bl u_t007_001/c1_w0_br
+ u_t007_001/c1_w1_bl u_t007_001/c1_w1_br u_t007_001/c1_r0_rbl u_t007_001/c1_r1_rbl
+ u_t007_001/c2_w0_bl u_t007_001/c2_w0_br u_t007_001/c2_w1_bl u_t007_001/c2_w1_br
+ u_t007_001/c2_r0_rbl u_t007_001/c2_r1_rbl u_t007_001/c3_w0_bl u_t007_001/c3_w0_br
+ u_t007_001/c3_w1_bl u_t007_001/c3_w1_br u_t007_001/c3_r0_rbl u_t007_001/c3_r1_rbl
+ u_t007_001/r0_w0_wl u_t007_001/r0_w1_wl u_t007_001/r0_r0_rwl u_t007_001/r0_r1_rwl
+ u_t007_001/r1_w0_wl u_t007_001/r1_w1_wl u_t007_001/r1_r0_rwl u_t007_001/r1_r1_rwl
+ u_t007_001/r2_w0_wl u_t007_001/r2_w1_wl u_t007_001/r2_r0_rwl u_t007_001/r2_r1_rwl
+ u_t007_001/r3_w0_wl u_t007_001/r3_w1_wl u_t007_001/r3_r0_rwl u_t007_001/r3_r1_rwl
+ VSS u_t007_002/VSS VSUBS detronyx_12t_2w2r_rc4_4x4_routed_5layer_direct
Xu_t007_012 u_t007_012/c0_w0_bl u_t007_012/c0_w0_br u_t007_012/c0_w1_bl u_t007_012/c0_w1_br
+ u_t007_012/c0_r0_rbl u_t007_012/c0_r1_rbl u_t007_012/c1_w0_bl u_t007_012/c1_w0_br
+ u_t007_012/c1_w1_bl u_t007_012/c1_w1_br u_t007_012/c1_r0_rbl u_t007_012/c1_r1_rbl
+ u_t007_012/c2_w0_bl u_t007_012/c2_w0_br u_t007_012/c2_w1_bl u_t007_012/c2_w1_br
+ u_t007_012/c2_r0_rbl u_t007_012/c2_r1_rbl u_t007_012/c3_w0_bl u_t007_012/c3_w0_br
+ u_t007_012/c3_w1_bl u_t007_012/c3_w1_br u_t007_012/c3_r0_rbl u_t007_012/c3_r1_rbl
+ u_t007_012/r0_w0_wl u_t007_012/r0_w1_wl u_t007_012/r0_r0_rwl u_t007_012/r0_r1_rwl
+ u_t007_012/r1_w0_wl u_t007_012/r1_w1_wl u_t007_012/r1_r0_rwl u_t007_012/r1_r1_rwl
+ u_t007_012/r2_w0_wl u_t007_012/r2_w1_wl u_t007_012/r2_r0_rwl u_t007_012/r2_r1_rwl
+ u_t007_012/r3_w0_wl u_t007_012/r3_w1_wl u_t007_012/r3_r0_rwl u_t007_012/r3_r1_rwl
+ u_t008_012/VDD u_t007_012/VSS VSUBS detronyx_12t_2w2r_rc4_4x4_routed_5layer_direct
Xu_t013_015 u_t013_015/c0_w0_bl u_t013_015/c0_w0_br u_t013_015/c0_w1_bl u_t013_015/c0_w1_br
+ u_t013_015/c0_r0_rbl u_t013_015/c0_r1_rbl u_t013_015/c1_w0_bl u_t013_015/c1_w0_br
+ u_t013_015/c1_w1_bl u_t013_015/c1_w1_br u_t013_015/c1_r0_rbl u_t013_015/c1_r1_rbl
+ u_t013_015/c2_w0_bl u_t013_015/c2_w0_br u_t013_015/c2_w1_bl u_t013_015/c2_w1_br
+ u_t013_015/c2_r0_rbl u_t013_015/c2_r1_rbl u_t013_015/c3_w0_bl u_t013_015/c3_w0_br
+ u_t013_015/c3_w1_bl u_t013_015/c3_w1_br u_t013_015/c3_r0_rbl u_t013_015/c3_r1_rbl
+ u_t013_015/r0_w0_wl u_t013_015/r0_w1_wl u_t013_015/r0_r0_rwl u_t013_015/r0_r1_rwl
+ u_t013_015/r1_w0_wl u_t013_015/r1_w1_wl u_t013_015/r1_r0_rwl u_t013_015/r1_r1_rwl
+ u_t013_015/r2_w0_wl u_t013_015/r2_w1_wl u_t013_015/r2_r0_rwl u_t013_015/r2_r1_rwl
+ u_t013_015/r3_w0_wl u_t013_015/r3_w1_wl u_t013_015/r3_r0_rwl u_t013_015/r3_r1_rwl
+ VSS u_t013_015/VSS VSUBS detronyx_12t_2w2r_rc4_4x4_routed_5layer_direct
Xu_t013_004 u_t013_004/c0_w0_bl u_t013_004/c0_w0_br u_t013_004/c0_w1_bl u_t013_004/c0_w1_br
+ u_t013_004/c0_r0_rbl u_t013_004/c0_r1_rbl u_t013_004/c1_w0_bl u_t013_004/c1_w0_br
+ u_t013_004/c1_w1_bl u_t013_004/c1_w1_br u_t013_004/c1_r0_rbl u_t013_004/c1_r1_rbl
+ u_t013_004/c2_w0_bl u_t013_004/c2_w0_br u_t013_004/c2_w1_bl u_t013_004/c2_w1_br
+ u_t013_004/c2_r0_rbl u_t013_004/c2_r1_rbl u_t013_004/c3_w0_bl u_t013_004/c3_w0_br
+ u_t013_004/c3_w1_bl u_t013_004/c3_w1_br u_t013_004/c3_r0_rbl u_t013_004/c3_r1_rbl
+ u_t013_004/r0_w0_wl u_t013_004/r0_w1_wl u_t013_004/r0_r0_rwl u_t013_004/r0_r1_rwl
+ u_t013_004/r1_w0_wl u_t013_004/r1_w1_wl u_t013_004/r1_r0_rwl u_t013_004/r1_r1_rwl
+ u_t013_004/r2_w0_wl u_t013_004/r2_w1_wl u_t013_004/r2_r0_rwl u_t013_004/r2_r1_rwl
+ u_t013_004/r3_w0_wl u_t013_004/r3_w1_wl u_t013_004/r3_r0_rwl u_t013_004/r3_r1_rwl
+ u_t013_004/VDD u_t013_015/VSS VSUBS detronyx_12t_2w2r_rc4_4x4_routed_5layer_direct
Xgf180mcu_as_sc_mcu7t3v3__inv_2_402 VSS gf180mcu_as_sc_mcu7t3v3__inv_2_405/VDD gf180mcu_as_sc_mcu7t3v3__inv_2_402/Y
+ VSS gf180mcu_as_sc_mcu7t3v3__inv_2_402/VNW VSUBS gf180mcu_as_sc_mcu7t3v3__inv_2
Xgf180mcu_as_sc_mcu7t3v3__inv_2_468 gf180mcu_as_sc_mcu7t3v3__inv_2_468/VDD VSS gf180mcu_as_sc_mcu7t3v3__inv_2_468/Y
+ VSS gf180mcu_as_sc_mcu7t3v3__inv_2_468/VNW VSUBS gf180mcu_as_sc_mcu7t3v3__inv_2
Xgf180mcu_as_sc_mcu7t3v3__inv_2_457 VSS VSS VSS VSS gf180mcu_as_sc_mcu7t3v3__inv_2_458/VNW
+ VSUBS gf180mcu_as_sc_mcu7t3v3__inv_2
Xgf180mcu_as_sc_mcu7t3v3__inv_2_446 VSS VSS gf180mcu_as_sc_mcu7t3v3__inv_2_446/Y VSS
+ gf180mcu_as_sc_mcu7t3v3__inv_2_446/VNW VSUBS gf180mcu_as_sc_mcu7t3v3__inv_2
Xgf180mcu_as_sc_mcu7t3v3__inv_2_435 VSS VSS VSS VSS gf180mcu_as_sc_mcu7t3v3__inv_2_437/VNW
+ VSUBS gf180mcu_as_sc_mcu7t3v3__inv_2
Xgf180mcu_as_sc_mcu7t3v3__inv_2_424 VSS VSS VSS VSS gf180mcu_as_sc_mcu7t3v3__inv_2_425/VNW
+ VSUBS gf180mcu_as_sc_mcu7t3v3__inv_2
Xgf180mcu_as_sc_mcu7t3v3__inv_2_413 VSS VSS VSS VSS gf180mcu_as_sc_mcu7t3v3__inv_2_413/VNW
+ VSUBS gf180mcu_as_sc_mcu7t3v3__inv_2
Xgf180mcu_as_sc_mcu7t3v3__inv_2_479 VSS VSS VSS VSS gf180mcu_as_sc_mcu7t3v3__inv_2_480/VNW
+ VSUBS gf180mcu_as_sc_mcu7t3v3__inv_2
Xu_t004_004 u_t004_004/c0_w0_bl u_t004_004/c0_w0_br u_t004_004/c0_w1_bl u_t004_004/c0_w1_br
+ u_t004_004/c0_r0_rbl u_t004_004/c0_r1_rbl u_t004_004/c1_w0_bl u_t004_004/c1_w0_br
+ u_t004_004/c1_w1_bl u_t004_004/c1_w1_br u_t004_004/c1_r0_rbl u_t004_004/c1_r1_rbl
+ u_t004_004/c2_w0_bl u_t004_004/c2_w0_br u_t004_004/c2_w1_bl u_t004_004/c2_w1_br
+ u_t004_004/c2_r0_rbl u_t004_004/c2_r1_rbl u_t004_004/c3_w0_bl u_t004_004/c3_w0_br
+ u_t004_004/c3_w1_bl u_t004_004/c3_w1_br u_t004_004/c3_r0_rbl u_t004_004/c3_r1_rbl
+ u_t004_004/r0_w0_wl u_t004_004/r0_w1_wl u_t004_004/r0_r0_rwl u_t004_004/r0_r1_rwl
+ u_t004_004/r1_w0_wl u_t004_004/r1_w1_wl u_t004_004/r1_r0_rwl u_t004_004/r1_r1_rwl
+ u_t004_004/r2_w0_wl u_t004_004/r2_w1_wl u_t004_004/r2_r0_rwl u_t004_004/r2_r1_rwl
+ u_t004_004/r3_w0_wl u_t004_004/r3_w1_wl u_t004_004/r3_r0_rwl u_t004_004/r3_r1_rwl
+ u_t004_004/VDD u_t004_015/VSS VSUBS detronyx_12t_2w2r_rc4_4x4_routed_5layer_direct
Xu_t004_015 u_t004_015/c0_w0_bl u_t004_015/c0_w0_br u_t004_015/c0_w1_bl u_t004_015/c0_w1_br
+ u_t004_015/c0_r0_rbl u_t004_015/c0_r1_rbl u_t004_015/c1_w0_bl u_t004_015/c1_w0_br
+ u_t004_015/c1_w1_bl u_t004_015/c1_w1_br u_t004_015/c1_r0_rbl u_t004_015/c1_r1_rbl
+ u_t004_015/c2_w0_bl u_t004_015/c2_w0_br u_t004_015/c2_w1_bl u_t004_015/c2_w1_br
+ u_t004_015/c2_r0_rbl u_t004_015/c2_r1_rbl u_t004_015/c3_w0_bl u_t004_015/c3_w0_br
+ u_t004_015/c3_w1_bl u_t004_015/c3_w1_br u_t004_015/c3_r0_rbl u_t004_015/c3_r1_rbl
+ u_t004_015/r0_w0_wl u_t004_015/r0_w1_wl u_t004_015/r0_r0_rwl u_t004_015/r0_r1_rwl
+ u_t004_015/r1_w0_wl u_t004_015/r1_w1_wl u_t004_015/r1_r0_rwl u_t004_015/r1_r1_rwl
+ u_t004_015/r2_w0_wl u_t004_015/r2_w1_wl u_t004_015/r2_r0_rwl u_t004_015/r2_r1_rwl
+ u_t004_015/r3_w0_wl u_t004_015/r3_w1_wl u_t004_015/r3_r0_rwl u_t004_015/r3_r1_rwl
+ VSS u_t004_015/VSS VSUBS detronyx_12t_2w2r_rc4_4x4_routed_5layer_direct
Xu_t010_007 u_t010_007/c0_w0_bl u_t010_007/c0_w0_br u_t010_007/c0_w1_bl u_t010_007/c0_w1_br
+ u_t010_007/c0_r0_rbl u_t010_007/c0_r1_rbl u_t010_007/c1_w0_bl u_t010_007/c1_w0_br
+ u_t010_007/c1_w1_bl u_t010_007/c1_w1_br u_t010_007/c1_r0_rbl u_t010_007/c1_r1_rbl
+ u_t010_007/c2_w0_bl u_t010_007/c2_w0_br u_t010_007/c2_w1_bl u_t010_007/c2_w1_br
+ u_t010_007/c2_r0_rbl u_t010_007/c2_r1_rbl u_t010_007/c3_w0_bl u_t010_007/c3_w0_br
+ u_t010_007/c3_w1_bl u_t010_007/c3_w1_br u_t010_007/c3_r0_rbl u_t010_007/c3_r1_rbl
+ u_t010_007/r0_w0_wl u_t010_007/r0_w1_wl u_t010_007/r0_r0_rwl u_t010_007/r0_r1_rwl
+ u_t010_007/r1_w0_wl u_t010_007/r1_w1_wl u_t010_007/r1_r0_rwl u_t010_007/r1_r1_rwl
+ u_t010_007/r2_w0_wl u_t010_007/r2_w1_wl u_t010_007/r2_r0_rwl u_t010_007/r2_r1_rwl
+ u_t010_007/r3_w0_wl u_t010_007/r3_w1_wl u_t010_007/r3_r0_rwl u_t010_007/r3_r1_rwl
+ VSS u_t010_009/VSS VSUBS detronyx_12t_2w2r_rc4_4x4_routed_5layer_direct
Xu_t001_007 u_t001_007/c0_w0_bl u_t001_007/c0_w0_br u_t001_007/c0_w1_bl u_t001_007/c0_w1_br
+ u_t001_007/c0_r0_rbl u_t001_007/c0_r1_rbl u_t001_007/c1_w0_bl u_t001_007/c1_w0_br
+ u_t001_007/c1_w1_bl u_t001_007/c1_w1_br u_t001_007/c1_r0_rbl u_t001_007/c1_r1_rbl
+ u_t001_007/c2_w0_bl u_t001_007/c2_w0_br u_t001_007/c2_w1_bl u_t001_007/c2_w1_br
+ u_t001_007/c2_r0_rbl u_t001_007/c2_r1_rbl u_t001_007/c3_w0_bl u_t001_007/c3_w0_br
+ u_t001_007/c3_w1_bl u_t001_007/c3_w1_br u_t001_007/c3_r0_rbl u_t001_007/c3_r1_rbl
+ u_t001_007/r0_w0_wl u_t001_007/r0_w1_wl u_t001_007/r0_r0_rwl u_t001_007/r0_r1_rwl
+ u_t001_007/r1_w0_wl u_t001_007/r1_w1_wl u_t001_007/r1_r0_rwl u_t001_007/r1_r1_rwl
+ u_t001_007/r2_w0_wl u_t001_007/r2_w1_wl u_t001_007/r2_r0_rwl u_t001_007/r2_r1_rwl
+ u_t001_007/r3_w0_wl u_t001_007/r3_w1_wl u_t001_007/r3_r0_rwl u_t001_007/r3_r1_rwl
+ VSS u_t001_015/VSS VSUBS detronyx_12t_2w2r_rc4_4x4_routed_5layer_direct
Xgf180mcu_as_sc_mcu7t3v3__inv_2_232 gf180mcu_as_sc_mcu7t3v3__nor2_2_4/VDD gf180mcu_as_sc_mcu7t3v3__nand3_2_8/VSS
+ VSS VSS gf180mcu_as_sc_mcu7t3v3__nor2_2_4/VNW VSUBS gf180mcu_as_sc_mcu7t3v3__inv_2
Xgf180mcu_as_sc_mcu7t3v3__inv_2_243 gf180mcu_as_sc_mcu7t3v3__nor2_2_4/VDD gf180mcu_as_sc_mcu7t3v3__nand3_2_8/VSS
+ gf180mcu_as_sc_mcu7t3v3__inv_2_243/Y VSS gf180mcu_as_sc_mcu7t3v3__nor2_2_4/VNW VSUBS
+ gf180mcu_as_sc_mcu7t3v3__inv_2
Xgf180mcu_as_sc_mcu7t3v3__inv_2_210 gf180mcu_as_sc_mcu7t3v3__nand2_2_9/VDD gf180mcu_as_sc_mcu7t3v3__nor2_2_6/VSS
+ VSS VSS gf180mcu_as_sc_mcu7t3v3__nand2_2_9/VNW VSUBS gf180mcu_as_sc_mcu7t3v3__inv_2
Xgf180mcu_as_sc_mcu7t3v3__inv_2_221 gf180mcu_as_sc_mcu7t3v3__nand2_2_9/VDD gf180mcu_as_sc_mcu7t3v3__nor2_2_4/VSS
+ VSS VSS gf180mcu_as_sc_mcu7t3v3__nand2_2_9/VNW VSUBS gf180mcu_as_sc_mcu7t3v3__inv_2
Xgf180mcu_as_sc_mcu7t3v3__inv_2_298 VSS VSS gf180mcu_as_sc_mcu7t3v3__inv_2_298/Y VSS
+ gf180mcu_as_sc_mcu7t3v3__inv_2_298/VNW VSUBS gf180mcu_as_sc_mcu7t3v3__inv_2
Xgf180mcu_as_sc_mcu7t3v3__inv_2_287 VSS VSS VSS VSS gf180mcu_as_sc_mcu7t3v3__inv_2_307/VNW
+ VSUBS gf180mcu_as_sc_mcu7t3v3__inv_2
Xgf180mcu_as_sc_mcu7t3v3__inv_2_254 gf180mcu_as_sc_mcu7t3v3__nor2_2_4/VDD gf180mcu_as_sc_mcu7t3v3__nand3_2_8/VSS
+ VSS VSS gf180mcu_as_sc_mcu7t3v3__nor2_2_4/VNW VSUBS gf180mcu_as_sc_mcu7t3v3__inv_2
Xgf180mcu_as_sc_mcu7t3v3__inv_2_276 gf180mcu_as_sc_mcu7t3v3__nor2_2_5/VDD gf180mcu_as_sc_mcu7t3v3__nand3_2_8/VSS
+ gf180mcu_as_sc_mcu7t3v3__inv_2_276/Y VSS gf180mcu_as_sc_mcu7t3v3__nor2_2_5/VNW VSUBS
+ gf180mcu_as_sc_mcu7t3v3__inv_2
Xgf180mcu_as_sc_mcu7t3v3__inv_2_265 gf180mcu_as_sc_mcu7t3v3__nand2_2_9/VDD gf180mcu_as_sc_mcu7t3v3__nor2_2_4/VSS
+ VSS VSS gf180mcu_as_sc_mcu7t3v3__nand2_2_9/VNW VSUBS gf180mcu_as_sc_mcu7t3v3__inv_2
Xgf180mcu_as_sc_mcu7t3v3__nor2_2_0 gf180mcu_as_sc_mcu7t3v3__nor2_2_4/VDD gf180mcu_as_sc_mcu7t3v3__nor2_2_4/VSS
+ VSS VSS VSS gf180mcu_as_sc_mcu7t3v3__nor2_2_4/VNW VSUBS gf180mcu_as_sc_mcu7t3v3__nor2_2
Xgf180mcu_as_sc_mcu7t3v3__nand2_2_5 gf180mcu_as_sc_mcu7t3v3__nor2_2_6/VDD gf180mcu_as_sc_mcu7t3v3__nand3_2_1/VSS
+ VSS VSS VSS gf180mcu_as_sc_mcu7t3v3__nor2_2_6/VNW VSUBS gf180mcu_as_sc_mcu7t3v3__nand2_2
Xgf180mcu_as_sc_mcu7t3v3__inv_2_809 VSS gf180mcu_as_sc_mcu7t3v3__inv_2_812/VDD gf180mcu_as_sc_mcu7t3v3__inv_2_809/Y
+ VSS gf180mcu_as_sc_mcu7t3v3__inv_2_809/VNW VSUBS gf180mcu_as_sc_mcu7t3v3__inv_2
Xgf180mcu_as_sc_mcu7t3v3__nand4_2_108 VSS VSS VSS VSS VSS VSS gf180mcu_as_sc_mcu7t3v3__nand4_2_108/Y
+ gf180mcu_as_sc_mcu7t3v3__inv_2_428/VNW VSUBS gf180mcu_as_sc_mcu7t3v3__nand4_2
Xgf180mcu_as_sc_mcu7t3v3__nand4_2_119 VSS VSS VSS VSS VSS VSS VSS gf180mcu_as_sc_mcu7t3v3__inv_2_461/VNW
+ VSUBS gf180mcu_as_sc_mcu7t3v3__nand4_2
Xgf180mcu_as_sc_mcu7t3v3__nand4_2_58 gf180mcu_as_sc_mcu7t3v3__inv_2_63/VSS VSS VSS
+ VSS VSS VSS gf180mcu_as_sc_mcu7t3v3__nand4_2_58/Y gf180mcu_as_sc_mcu7t3v3__inv_2_179/VNW
+ VSUBS gf180mcu_as_sc_mcu7t3v3__nand4_2
Xgf180mcu_as_sc_mcu7t3v3__nand4_2_14 gf180mcu_as_sc_mcu7t3v3__inv_2_45/VDD gf180mcu_as_sc_mcu7t3v3__inv_2_45/VDD
+ VSS VSS VSS VSS VSS gf180mcu_as_sc_mcu7t3v3__inv_2_42/VNW VSUBS gf180mcu_as_sc_mcu7t3v3__nand4_2
Xgf180mcu_as_sc_mcu7t3v3__nand4_2_36 VSS VSS VSS VSS VSS VSS VSS gf180mcu_as_sc_mcu7t3v3__inv_2_108/VNW
+ VSUBS gf180mcu_as_sc_mcu7t3v3__nand4_2
Xgf180mcu_as_sc_mcu7t3v3__nand4_2_47 gf180mcu_as_sc_mcu7t3v3__inv_2_141/VDD gf180mcu_as_sc_mcu7t3v3__inv_2_144/VDD
+ VSS VSS VSS VSS VSS gf180mcu_as_sc_mcu7t3v3__inv_2_141/VNW VSUBS gf180mcu_as_sc_mcu7t3v3__nand4_2
Xgf180mcu_as_sc_mcu7t3v3__nand4_2_25 gf180mcu_as_sc_mcu7t3v3__inv_2_75/VDD VSS VSS
+ VSS VSS VSS VSS gf180mcu_as_sc_mcu7t3v3__inv_2_75/VNW VSUBS gf180mcu_as_sc_mcu7t3v3__nand4_2
Xgf180mcu_as_sc_mcu7t3v3__nand4_2_69 VSS VSS VSS VSS VSS VSS VSS gf180mcu_as_sc_mcu7t3v3__inv_2_218/VNW
+ VSUBS gf180mcu_as_sc_mcu7t3v3__nand4_2
Xgf180mcu_as_sc_mcu7t3v3__inv_2_617 gf180mcu_as_sc_mcu7t3v3__inv_2_618/VDD gf180mcu_as_sc_mcu7t3v3__inv_2_719/VDD
+ gf180mcu_as_sc_mcu7t3v3__inv_2_617/Y gf180mcu_as_sc_mcu7t3v3__inv_2_618/Y gf180mcu_as_sc_mcu7t3v3__inv_2_618/VNW
+ VSUBS gf180mcu_as_sc_mcu7t3v3__inv_2
Xgf180mcu_as_sc_mcu7t3v3__inv_2_606 VSS gf180mcu_as_sc_mcu7t3v3__inv_2_609/VDD gf180mcu_as_sc_mcu7t3v3__inv_2_606/Y
+ VSS gf180mcu_as_sc_mcu7t3v3__inv_2_606/VNW VSUBS gf180mcu_as_sc_mcu7t3v3__inv_2
Xgf180mcu_as_sc_mcu7t3v3__inv_2_628 VSS VSS VSS VSS gf180mcu_as_sc_mcu7t3v3__inv_2_629/VNW
+ VSUBS gf180mcu_as_sc_mcu7t3v3__inv_2
Xgf180mcu_as_sc_mcu7t3v3__inv_2_639 VSS VSS VSS VSS gf180mcu_as_sc_mcu7t3v3__inv_2_641/VNW
+ VSUBS gf180mcu_as_sc_mcu7t3v3__inv_2
Xu_t007_002 u_t007_002/c0_w0_bl u_t007_002/c0_w0_br u_t007_002/c0_w1_bl u_t007_002/c0_w1_br
+ u_t007_002/c0_r0_rbl u_t007_002/c0_r1_rbl u_t007_002/c1_w0_bl u_t007_002/c1_w0_br
+ u_t007_002/c1_w1_bl u_t007_002/c1_w1_br u_t007_002/c1_r0_rbl u_t007_002/c1_r1_rbl
+ u_t007_002/c2_w0_bl u_t007_002/c2_w0_br u_t007_002/c2_w1_bl u_t007_002/c2_w1_br
+ u_t007_002/c2_r0_rbl u_t007_002/c2_r1_rbl u_t007_002/c3_w0_bl u_t007_002/c3_w0_br
+ u_t007_002/c3_w1_bl u_t007_002/c3_w1_br u_t007_002/c3_r0_rbl u_t007_002/c3_r1_rbl
+ u_t007_002/r0_w0_wl u_t007_002/r0_w1_wl u_t007_002/r0_r0_rwl u_t007_002/r0_r1_rwl
+ u_t007_002/r1_w0_wl u_t007_002/r1_w1_wl u_t007_002/r1_r0_rwl u_t007_002/r1_r1_rwl
+ u_t007_002/r2_w0_wl u_t007_002/r2_w1_wl u_t007_002/r2_r0_rwl u_t007_002/r2_r1_rwl
+ u_t007_002/r3_w0_wl u_t007_002/r3_w1_wl u_t007_002/r3_r0_rwl u_t007_002/r3_r1_rwl
+ VSS u_t007_002/VSS VSUBS detronyx_12t_2w2r_rc4_4x4_routed_5layer_direct
Xu_t007_013 u_t007_013/c0_w0_bl u_t007_013/c0_w0_br u_t007_013/c0_w1_bl u_t007_013/c0_w1_br
+ u_t007_013/c0_r0_rbl u_t007_013/c0_r1_rbl u_t007_013/c1_w0_bl u_t007_013/c1_w0_br
+ u_t007_013/c1_w1_bl u_t007_013/c1_w1_br u_t007_013/c1_r0_rbl u_t007_013/c1_r1_rbl
+ u_t007_013/c2_w0_bl u_t007_013/c2_w0_br u_t007_013/c2_w1_bl u_t007_013/c2_w1_br
+ u_t007_013/c2_r0_rbl u_t007_013/c2_r1_rbl u_t007_013/c3_w0_bl u_t007_013/c3_w0_br
+ u_t007_013/c3_w1_bl u_t007_013/c3_w1_br u_t007_013/c3_r0_rbl u_t007_013/c3_r1_rbl
+ u_t007_013/r0_w0_wl u_t007_013/r0_w1_wl u_t007_013/r0_r0_rwl u_t007_013/r0_r1_rwl
+ u_t007_013/r1_w0_wl u_t007_013/r1_w1_wl u_t007_013/r1_r0_rwl u_t007_013/r1_r1_rwl
+ u_t007_013/r2_w0_wl u_t007_013/r2_w1_wl u_t007_013/r2_r0_rwl u_t007_013/r2_r1_rwl
+ u_t007_013/r3_w0_wl u_t007_013/r3_w1_wl u_t007_013/r3_r0_rwl u_t007_013/r3_r1_rwl
+ u_t008_013/VDD u_t007_013/VSS VSUBS detronyx_12t_2w2r_rc4_4x4_routed_5layer_direct
Xu_t013_005 u_t013_005/c0_w0_bl u_t013_005/c0_w0_br u_t013_005/c0_w1_bl u_t013_005/c0_w1_br
+ u_t013_005/c0_r0_rbl u_t013_005/c0_r1_rbl u_t013_005/c1_w0_bl u_t013_005/c1_w0_br
+ u_t013_005/c1_w1_bl u_t013_005/c1_w1_br u_t013_005/c1_r0_rbl u_t013_005/c1_r1_rbl
+ u_t013_005/c2_w0_bl u_t013_005/c2_w0_br u_t013_005/c2_w1_bl u_t013_005/c2_w1_br
+ u_t013_005/c2_r0_rbl u_t013_005/c2_r1_rbl u_t013_005/c3_w0_bl u_t013_005/c3_w0_br
+ u_t013_005/c3_w1_bl u_t013_005/c3_w1_br u_t013_005/c3_r0_rbl u_t013_005/c3_r1_rbl
+ u_t013_005/r0_w0_wl u_t013_005/r0_w1_wl u_t013_005/r0_r0_rwl u_t013_005/r0_r1_rwl
+ u_t013_005/r1_w0_wl u_t013_005/r1_w1_wl u_t013_005/r1_r0_rwl u_t013_005/r1_r1_rwl
+ u_t013_005/r2_w0_wl u_t013_005/r2_w1_wl u_t013_005/r2_r0_rwl u_t013_005/r2_r1_rwl
+ u_t013_005/r3_w0_wl u_t013_005/r3_w1_wl u_t013_005/r3_r0_rwl u_t013_005/r3_r1_rwl
+ u_t013_005/VDD u_t013_015/VSS VSUBS detronyx_12t_2w2r_rc4_4x4_routed_5layer_direct
Xgf180mcu_as_sc_mcu7t3v3__inv_2_403 gf180mcu_as_sc_mcu7t3v3__inv_2_405/VDD VSS gf180mcu_as_sc_mcu7t3v3__inv_2_403/Y
+ gf180mcu_as_sc_mcu7t3v3__inv_2_466/A gf180mcu_as_sc_mcu7t3v3__inv_2_405/VNW VSUBS
+ gf180mcu_as_sc_mcu7t3v3__inv_2
Xgf180mcu_as_sc_mcu7t3v3__inv_2_436 VSS VSS VSS VSS gf180mcu_as_sc_mcu7t3v3__inv_2_437/VNW
+ VSUBS gf180mcu_as_sc_mcu7t3v3__inv_2
Xgf180mcu_as_sc_mcu7t3v3__inv_2_425 VSS VSS gf180mcu_as_sc_mcu7t3v3__inv_2_425/Y VSS
+ gf180mcu_as_sc_mcu7t3v3__inv_2_425/VNW VSUBS gf180mcu_as_sc_mcu7t3v3__inv_2
Xgf180mcu_as_sc_mcu7t3v3__inv_2_414 VSS VSS VSS VSS gf180mcu_as_sc_mcu7t3v3__inv_2_416/VNW
+ VSUBS gf180mcu_as_sc_mcu7t3v3__inv_2
Xgf180mcu_as_sc_mcu7t3v3__inv_2_458 VSS VSS VSS VSS gf180mcu_as_sc_mcu7t3v3__inv_2_458/VNW
+ VSUBS gf180mcu_as_sc_mcu7t3v3__inv_2
Xgf180mcu_as_sc_mcu7t3v3__inv_2_447 VSS VSS VSS VSS gf180mcu_as_sc_mcu7t3v3__inv_2_449/VNW
+ VSUBS gf180mcu_as_sc_mcu7t3v3__inv_2
Xgf180mcu_as_sc_mcu7t3v3__inv_2_469 VSS VSS VSS VSS gf180mcu_as_sc_mcu7t3v3__inv_2_471/VNW
+ VSUBS gf180mcu_as_sc_mcu7t3v3__inv_2
Xu_t004_005 u_t004_005/c0_w0_bl u_t004_005/c0_w0_br u_t004_005/c0_w1_bl u_t004_005/c0_w1_br
+ u_t004_005/c0_r0_rbl u_t004_005/c0_r1_rbl u_t004_005/c1_w0_bl u_t004_005/c1_w0_br
+ u_t004_005/c1_w1_bl u_t004_005/c1_w1_br u_t004_005/c1_r0_rbl u_t004_005/c1_r1_rbl
+ u_t004_005/c2_w0_bl u_t004_005/c2_w0_br u_t004_005/c2_w1_bl u_t004_005/c2_w1_br
+ u_t004_005/c2_r0_rbl u_t004_005/c2_r1_rbl u_t004_005/c3_w0_bl u_t004_005/c3_w0_br
+ u_t004_005/c3_w1_bl u_t004_005/c3_w1_br u_t004_005/c3_r0_rbl u_t004_005/c3_r1_rbl
+ u_t004_005/r0_w0_wl u_t004_005/r0_w1_wl u_t004_005/r0_r0_rwl u_t004_005/r0_r1_rwl
+ u_t004_005/r1_w0_wl u_t004_005/r1_w1_wl u_t004_005/r1_r0_rwl u_t004_005/r1_r1_rwl
+ u_t004_005/r2_w0_wl u_t004_005/r2_w1_wl u_t004_005/r2_r0_rwl u_t004_005/r2_r1_rwl
+ u_t004_005/r3_w0_wl u_t004_005/r3_w1_wl u_t004_005/r3_r0_rwl u_t004_005/r3_r1_rwl
+ u_t004_005/VDD u_t004_015/VSS VSUBS detronyx_12t_2w2r_rc4_4x4_routed_5layer_direct
Xu_t010_008 u_t010_008/c0_w0_bl u_t010_008/c0_w0_br u_t010_008/c0_w1_bl u_t010_008/c0_w1_br
+ u_t010_008/c0_r0_rbl u_t010_008/c0_r1_rbl u_t010_008/c1_w0_bl u_t010_008/c1_w0_br
+ u_t010_008/c1_w1_bl u_t010_008/c1_w1_br u_t010_008/c1_r0_rbl u_t010_008/c1_r1_rbl
+ u_t010_008/c2_w0_bl u_t010_008/c2_w0_br u_t010_008/c2_w1_bl u_t010_008/c2_w1_br
+ u_t010_008/c2_r0_rbl u_t010_008/c2_r1_rbl u_t010_008/c3_w0_bl u_t010_008/c3_w0_br
+ u_t010_008/c3_w1_bl u_t010_008/c3_w1_br u_t010_008/c3_r0_rbl u_t010_008/c3_r1_rbl
+ u_t010_008/r0_w0_wl u_t010_008/r0_w1_wl u_t010_008/r0_r0_rwl u_t010_008/r0_r1_rwl
+ u_t010_008/r1_w0_wl u_t010_008/r1_w1_wl u_t010_008/r1_r0_rwl u_t010_008/r1_r1_rwl
+ u_t010_008/r2_w0_wl u_t010_008/r2_w1_wl u_t010_008/r2_r0_rwl u_t010_008/r2_r1_rwl
+ u_t010_008/r3_w0_wl u_t010_008/r3_w1_wl u_t010_008/r3_r0_rwl u_t010_008/r3_r1_rwl
+ VSS u_t010_009/VSS VSUBS detronyx_12t_2w2r_rc4_4x4_routed_5layer_direct
Xu_t001_008 u_t001_008/c0_w0_bl u_t001_008/c0_w0_br u_t001_008/c0_w1_bl u_t001_008/c0_w1_br
+ u_t001_008/c0_r0_rbl u_t001_008/c0_r1_rbl u_t001_008/c1_w0_bl u_t001_008/c1_w0_br
+ u_t001_008/c1_w1_bl u_t001_008/c1_w1_br u_t001_008/c1_r0_rbl u_t001_008/c1_r1_rbl
+ u_t001_008/c2_w0_bl u_t001_008/c2_w0_br u_t001_008/c2_w1_bl u_t001_008/c2_w1_br
+ u_t001_008/c2_r0_rbl u_t001_008/c2_r1_rbl u_t001_008/c3_w0_bl u_t001_008/c3_w0_br
+ u_t001_008/c3_w1_bl u_t001_008/c3_w1_br u_t001_008/c3_r0_rbl u_t001_008/c3_r1_rbl
+ u_t001_008/r0_w0_wl u_t001_008/r0_w1_wl u_t001_008/r0_r0_rwl u_t001_008/r0_r1_rwl
+ u_t001_008/r1_w0_wl u_t001_008/r1_w1_wl u_t001_008/r1_r0_rwl u_t001_008/r1_r1_rwl
+ u_t001_008/r2_w0_wl u_t001_008/r2_w1_wl u_t001_008/r2_r0_rwl u_t001_008/r2_r1_rwl
+ u_t001_008/r3_w0_wl u_t001_008/r3_w1_wl u_t001_008/r3_r0_rwl u_t001_008/r3_r1_rwl
+ VSS u_t001_015/VSS VSUBS detronyx_12t_2w2r_rc4_4x4_routed_5layer_direct
Xgf180mcu_as_sc_mcu7t3v3__inv_2_211 gf180mcu_as_sc_mcu7t3v3__nor2_2_5/VDD gf180mcu_as_sc_mcu7t3v3__nor2_2_5/VSS
+ VSS VSS gf180mcu_as_sc_mcu7t3v3__nor2_2_5/VNW VSUBS gf180mcu_as_sc_mcu7t3v3__inv_2
Xgf180mcu_as_sc_mcu7t3v3__inv_2_277 gf180mcu_as_sc_mcu7t3v3__nor2_2_4/VDD gf180mcu_as_sc_mcu7t3v3__nand3_2_8/VSS
+ gf180mcu_as_sc_mcu7t3v3__inv_2_277/Y VSS gf180mcu_as_sc_mcu7t3v3__nor2_2_4/VNW VSUBS
+ gf180mcu_as_sc_mcu7t3v3__inv_2
Xgf180mcu_as_sc_mcu7t3v3__inv_2_233 gf180mcu_as_sc_mcu7t3v3__nor2_2_4/VDD gf180mcu_as_sc_mcu7t3v3__nor2_2_4/VSS
+ VSS VSS gf180mcu_as_sc_mcu7t3v3__nor2_2_4/VNW VSUBS gf180mcu_as_sc_mcu7t3v3__inv_2
Xgf180mcu_as_sc_mcu7t3v3__inv_2_244 gf180mcu_as_sc_mcu7t3v3__nor2_2_4/VDD gf180mcu_as_sc_mcu7t3v3__nor2_2_4/VSS
+ gf180mcu_as_sc_mcu7t3v3__inv_2_244/Y VSS gf180mcu_as_sc_mcu7t3v3__nor2_2_4/VNW VSUBS
+ gf180mcu_as_sc_mcu7t3v3__inv_2
Xgf180mcu_as_sc_mcu7t3v3__inv_2_255 gf180mcu_as_sc_mcu7t3v3__nor2_2_4/VDD gf180mcu_as_sc_mcu7t3v3__nor2_2_4/VSS
+ VSS VSS gf180mcu_as_sc_mcu7t3v3__nor2_2_4/VNW VSUBS gf180mcu_as_sc_mcu7t3v3__inv_2
Xgf180mcu_as_sc_mcu7t3v3__inv_2_266 gf180mcu_as_sc_mcu7t3v3__nand2_2_9/VDD gf180mcu_as_sc_mcu7t3v3__nor2_2_6/VSS
+ VSS VSS gf180mcu_as_sc_mcu7t3v3__nand2_2_9/VNW VSUBS gf180mcu_as_sc_mcu7t3v3__inv_2
Xgf180mcu_as_sc_mcu7t3v3__inv_2_222 gf180mcu_as_sc_mcu7t3v3__nand2_2_9/VDD gf180mcu_as_sc_mcu7t3v3__nor2_2_6/VSS
+ VSS VSS gf180mcu_as_sc_mcu7t3v3__nand2_2_9/VNW VSUBS gf180mcu_as_sc_mcu7t3v3__inv_2
Xgf180mcu_as_sc_mcu7t3v3__inv_2_200 gf180mcu_as_sc_mcu7t3v3__nand2_2_9/VDD gf180mcu_as_sc_mcu7t3v3__nor2_2_4/VSS
+ VSS VSS gf180mcu_as_sc_mcu7t3v3__nand2_2_9/VNW VSUBS gf180mcu_as_sc_mcu7t3v3__inv_2
Xgf180mcu_as_sc_mcu7t3v3__inv_2_288 VSS VSS VSS VSS gf180mcu_as_sc_mcu7t3v3__inv_2_290/VNW
+ VSUBS gf180mcu_as_sc_mcu7t3v3__inv_2
Xgf180mcu_as_sc_mcu7t3v3__inv_2_299 VSS VSS VSS VSS gf180mcu_as_sc_mcu7t3v3__inv_2_299/VNW
+ VSUBS gf180mcu_as_sc_mcu7t3v3__inv_2
Xgf180mcu_as_sc_mcu7t3v3__nand2_2_6 gf180mcu_as_sc_mcu7t3v3__nor2_2_4/VDD gf180mcu_as_sc_mcu7t3v3__nand3_2_8/VSS
+ VSS VSS VSS gf180mcu_as_sc_mcu7t3v3__nor2_2_4/VNW VSUBS gf180mcu_as_sc_mcu7t3v3__nand2_2
Xgf180mcu_as_sc_mcu7t3v3__nor2_2_1 gf180mcu_as_sc_mcu7t3v3__nor2_2_6/VDD gf180mcu_as_sc_mcu7t3v3__nor2_2_6/VSS
+ VSS VSS VSS gf180mcu_as_sc_mcu7t3v3__nor2_2_6/VNW VSUBS gf180mcu_as_sc_mcu7t3v3__nor2_2
Xgf180mcu_as_sc_mcu7t3v3__nand4_2_109 VSS VSS VSS VSS VSS VSS VSS gf180mcu_as_sc_mcu7t3v3__inv_2_431/VNW
+ VSUBS gf180mcu_as_sc_mcu7t3v3__nand4_2
Xgf180mcu_as_sc_mcu7t3v3__nand4_2_59 gf180mcu_as_sc_mcu7t3v3__inv_2_177/VDD gf180mcu_as_sc_mcu7t3v3__inv_2_15/VDD
+ VSS VSS VSS VSS VSS gf180mcu_as_sc_mcu7t3v3__inv_2_177/VNW VSUBS gf180mcu_as_sc_mcu7t3v3__nand4_2
Xgf180mcu_as_sc_mcu7t3v3__nand4_2_15 gf180mcu_as_sc_mcu7t3v3__inv_2_45/VDD gf180mcu_as_sc_mcu7t3v3__inv_2_47/VDD
+ VSS VSS VSS VSS gf180mcu_as_sc_mcu7t3v3__nand4_2_15/Y gf180mcu_as_sc_mcu7t3v3__inv_2_45/VNW
+ VSUBS gf180mcu_as_sc_mcu7t3v3__nand4_2
Xgf180mcu_as_sc_mcu7t3v3__nand4_2_37 VSS gf180mcu_as_sc_mcu7t3v3__inv_2_114/VDD VSS
+ VSS VSS VSS gf180mcu_as_sc_mcu7t3v3__nand4_2_37/Y gf180mcu_as_sc_mcu7t3v3__inv_2_111/VNW
+ VSUBS gf180mcu_as_sc_mcu7t3v3__nand4_2
Xgf180mcu_as_sc_mcu7t3v3__nand4_2_48 gf180mcu_as_sc_mcu7t3v3__inv_2_144/VDD VSS VSS
+ VSS VSS VSS VSS gf180mcu_as_sc_mcu7t3v3__inv_2_144/VNW VSUBS gf180mcu_as_sc_mcu7t3v3__nand4_2
Xgf180mcu_as_sc_mcu7t3v3__nand4_2_26 VSS gf180mcu_as_sc_mcu7t3v3__inv_2_81/VDD VSS
+ VSS VSS VSS VSS gf180mcu_as_sc_mcu7t3v3__inv_2_78/VNW VSUBS gf180mcu_as_sc_mcu7t3v3__nand4_2
Xgf180mcu_as_sc_mcu7t3v3__inv_2_618 gf180mcu_as_sc_mcu7t3v3__inv_2_618/VDD gf180mcu_as_sc_mcu7t3v3__inv_2_719/VDD
+ gf180mcu_as_sc_mcu7t3v3__inv_2_618/Y VSS gf180mcu_as_sc_mcu7t3v3__inv_2_618/VNW
+ VSUBS gf180mcu_as_sc_mcu7t3v3__inv_2
Xgf180mcu_as_sc_mcu7t3v3__inv_2_607 gf180mcu_as_sc_mcu7t3v3__inv_2_609/VDD gf180mcu_as_sc_mcu7t3v3__inv_2_612/VDD
+ gf180mcu_as_sc_mcu7t3v3__inv_2_607/Y gf180mcu_as_sc_mcu7t3v3__inv_2_611/Y gf180mcu_as_sc_mcu7t3v3__inv_2_609/VNW
+ VSUBS gf180mcu_as_sc_mcu7t3v3__inv_2
Xgf180mcu_as_sc_mcu7t3v3__inv_2_629 VSS VSS VSS VSS gf180mcu_as_sc_mcu7t3v3__inv_2_629/VNW
+ VSUBS gf180mcu_as_sc_mcu7t3v3__inv_2
Xu_t007_003 u_t007_003/c0_w0_bl u_t007_003/c0_w0_br u_t007_003/c0_w1_bl u_t007_003/c0_w1_br
+ u_t007_003/c0_r0_rbl u_t007_003/c0_r1_rbl u_t007_003/c1_w0_bl u_t007_003/c1_w0_br
+ u_t007_003/c1_w1_bl u_t007_003/c1_w1_br u_t007_003/c1_r0_rbl u_t007_003/c1_r1_rbl
+ u_t007_003/c2_w0_bl u_t007_003/c2_w0_br u_t007_003/c2_w1_bl u_t007_003/c2_w1_br
+ u_t007_003/c2_r0_rbl u_t007_003/c2_r1_rbl u_t007_003/c3_w0_bl u_t007_003/c3_w0_br
+ u_t007_003/c3_w1_bl u_t007_003/c3_w1_br u_t007_003/c3_r0_rbl u_t007_003/c3_r1_rbl
+ u_t007_003/r0_w0_wl u_t007_003/r0_w1_wl u_t007_003/r0_r0_rwl u_t007_003/r0_r1_rwl
+ u_t007_003/r1_w0_wl u_t007_003/r1_w1_wl u_t007_003/r1_r0_rwl u_t007_003/r1_r1_rwl
+ u_t007_003/r2_w0_wl u_t007_003/r2_w1_wl u_t007_003/r2_r0_rwl u_t007_003/r2_r1_rwl
+ u_t007_003/r3_w0_wl u_t007_003/r3_w1_wl u_t007_003/r3_r0_rwl u_t007_003/r3_r1_rwl
+ u_t008_003/VDD u_t007_003/VSS VSUBS detronyx_12t_2w2r_rc4_4x4_routed_5layer_direct
Xu_t007_014 u_t007_014/c0_w0_bl u_t007_014/c0_w0_br u_t007_014/c0_w1_bl u_t007_014/c0_w1_br
+ u_t007_014/c0_r0_rbl u_t007_014/c0_r1_rbl u_t007_014/c1_w0_bl u_t007_014/c1_w0_br
+ u_t007_014/c1_w1_bl u_t007_014/c1_w1_br u_t007_014/c1_r0_rbl u_t007_014/c1_r1_rbl
+ u_t007_014/c2_w0_bl u_t007_014/c2_w0_br u_t007_014/c2_w1_bl u_t007_014/c2_w1_br
+ u_t007_014/c2_r0_rbl u_t007_014/c2_r1_rbl u_t007_014/c3_w0_bl u_t007_014/c3_w0_br
+ u_t007_014/c3_w1_bl u_t007_014/c3_w1_br u_t007_014/c3_r0_rbl u_t007_014/c3_r1_rbl
+ u_t007_014/r0_w0_wl u_t007_014/r0_w1_wl u_t007_014/r0_r0_rwl u_t007_014/r0_r1_rwl
+ u_t007_014/r1_w0_wl u_t007_014/r1_w1_wl u_t007_014/r1_r0_rwl u_t007_014/r1_r1_rwl
+ u_t007_014/r2_w0_wl u_t007_014/r2_w1_wl u_t007_014/r2_r0_rwl u_t007_014/r2_r1_rwl
+ u_t007_014/r3_w0_wl u_t007_014/r3_w1_wl u_t007_014/r3_r0_rwl u_t007_014/r3_r1_rwl
+ u_t008_014/VDD u_t007_015/VSS VSUBS detronyx_12t_2w2r_rc4_4x4_routed_5layer_direct
Xu_t013_006 u_t013_006/c0_w0_bl u_t013_006/c0_w0_br u_t013_006/c0_w1_bl u_t013_006/c0_w1_br
+ u_t013_006/c0_r0_rbl u_t013_006/c0_r1_rbl u_t013_006/c1_w0_bl u_t013_006/c1_w0_br
+ u_t013_006/c1_w1_bl u_t013_006/c1_w1_br u_t013_006/c1_r0_rbl u_t013_006/c1_r1_rbl
+ u_t013_006/c2_w0_bl u_t013_006/c2_w0_br u_t013_006/c2_w1_bl u_t013_006/c2_w1_br
+ u_t013_006/c2_r0_rbl u_t013_006/c2_r1_rbl u_t013_006/c3_w0_bl u_t013_006/c3_w0_br
+ u_t013_006/c3_w1_bl u_t013_006/c3_w1_br u_t013_006/c3_r0_rbl u_t013_006/c3_r1_rbl
+ u_t013_006/r0_w0_wl u_t013_006/r0_w1_wl u_t013_006/r0_r0_rwl u_t013_006/r0_r1_rwl
+ u_t013_006/r1_w0_wl u_t013_006/r1_w1_wl u_t013_006/r1_r0_rwl u_t013_006/r1_r1_rwl
+ u_t013_006/r2_w0_wl u_t013_006/r2_w1_wl u_t013_006/r2_r0_rwl u_t013_006/r2_r1_rwl
+ u_t013_006/r3_w0_wl u_t013_006/r3_w1_wl u_t013_006/r3_r0_rwl u_t013_006/r3_r1_rwl
+ u_t013_006/VDD u_t013_015/VSS VSUBS detronyx_12t_2w2r_rc4_4x4_routed_5layer_direct
Xgf180mcu_as_sc_mcu7t3v3__inv_2_459 VSS VSS VSS VSS gf180mcu_as_sc_mcu7t3v3__inv_2_461/VNW
+ VSUBS gf180mcu_as_sc_mcu7t3v3__inv_2
Xgf180mcu_as_sc_mcu7t3v3__inv_2_404 gf180mcu_as_sc_mcu7t3v3__inv_2_405/VDD VSS gf180mcu_as_sc_mcu7t3v3__inv_2_466/A
+ gf180mcu_as_sc_mcu7t3v3__inv_2_405/Y gf180mcu_as_sc_mcu7t3v3__inv_2_405/VNW VSUBS
+ gf180mcu_as_sc_mcu7t3v3__inv_2
Xgf180mcu_as_sc_mcu7t3v3__inv_2_448 VSS VSS VSS VSS gf180mcu_as_sc_mcu7t3v3__inv_2_449/VNW
+ VSUBS gf180mcu_as_sc_mcu7t3v3__inv_2
Xgf180mcu_as_sc_mcu7t3v3__inv_2_437 VSS VSS gf180mcu_as_sc_mcu7t3v3__inv_2_437/Y VSS
+ gf180mcu_as_sc_mcu7t3v3__inv_2_437/VNW VSUBS gf180mcu_as_sc_mcu7t3v3__inv_2
Xgf180mcu_as_sc_mcu7t3v3__inv_2_426 VSS VSS VSS VSS gf180mcu_as_sc_mcu7t3v3__inv_2_428/VNW
+ VSUBS gf180mcu_as_sc_mcu7t3v3__inv_2
Xgf180mcu_as_sc_mcu7t3v3__inv_2_415 VSS VSS VSS VSS gf180mcu_as_sc_mcu7t3v3__inv_2_416/VNW
+ VSUBS gf180mcu_as_sc_mcu7t3v3__inv_2
Xu_t004_006 u_t004_006/c0_w0_bl u_t004_006/c0_w0_br u_t004_006/c0_w1_bl u_t004_006/c0_w1_br
+ u_t004_006/c0_r0_rbl u_t004_006/c0_r1_rbl u_t004_006/c1_w0_bl u_t004_006/c1_w0_br
+ u_t004_006/c1_w1_bl u_t004_006/c1_w1_br u_t004_006/c1_r0_rbl u_t004_006/c1_r1_rbl
+ u_t004_006/c2_w0_bl u_t004_006/c2_w0_br u_t004_006/c2_w1_bl u_t004_006/c2_w1_br
+ u_t004_006/c2_r0_rbl u_t004_006/c2_r1_rbl u_t004_006/c3_w0_bl u_t004_006/c3_w0_br
+ u_t004_006/c3_w1_bl u_t004_006/c3_w1_br u_t004_006/c3_r0_rbl u_t004_006/c3_r1_rbl
+ u_t004_006/r0_w0_wl u_t004_006/r0_w1_wl u_t004_006/r0_r0_rwl u_t004_006/r0_r1_rwl
+ u_t004_006/r1_w0_wl u_t004_006/r1_w1_wl u_t004_006/r1_r0_rwl u_t004_006/r1_r1_rwl
+ u_t004_006/r2_w0_wl u_t004_006/r2_w1_wl u_t004_006/r2_r0_rwl u_t004_006/r2_r1_rwl
+ u_t004_006/r3_w0_wl u_t004_006/r3_w1_wl u_t004_006/r3_r0_rwl u_t004_006/r3_r1_rwl
+ u_t004_006/VDD u_t004_015/VSS VSUBS detronyx_12t_2w2r_rc4_4x4_routed_5layer_direct
Xu_t010_009 u_t010_009/c0_w0_bl u_t010_009/c0_w0_br u_t010_009/c0_w1_bl u_t010_009/c0_w1_br
+ u_t010_009/c0_r0_rbl u_t010_009/c0_r1_rbl u_t010_009/c1_w0_bl u_t010_009/c1_w0_br
+ u_t010_009/c1_w1_bl u_t010_009/c1_w1_br u_t010_009/c1_r0_rbl u_t010_009/c1_r1_rbl
+ u_t010_009/c2_w0_bl u_t010_009/c2_w0_br u_t010_009/c2_w1_bl u_t010_009/c2_w1_br
+ u_t010_009/c2_r0_rbl u_t010_009/c2_r1_rbl u_t010_009/c3_w0_bl u_t010_009/c3_w0_br
+ u_t010_009/c3_w1_bl u_t010_009/c3_w1_br u_t010_009/c3_r0_rbl u_t010_009/c3_r1_rbl
+ u_t010_009/r0_w0_wl u_t010_009/r0_w1_wl u_t010_009/r0_r0_rwl u_t010_009/r0_r1_rwl
+ u_t010_009/r1_w0_wl u_t010_009/r1_w1_wl u_t010_009/r1_r0_rwl u_t010_009/r1_r1_rwl
+ u_t010_009/r2_w0_wl u_t010_009/r2_w1_wl u_t010_009/r2_r0_rwl u_t010_009/r2_r1_rwl
+ u_t010_009/r3_w0_wl u_t010_009/r3_w1_wl u_t010_009/r3_r0_rwl u_t010_009/r3_r1_rwl
+ VSS u_t010_009/VSS VSUBS detronyx_12t_2w2r_rc4_4x4_routed_5layer_direct
Xu_t001_009 u_t001_009/c0_w0_bl u_t001_009/c0_w0_br u_t001_009/c0_w1_bl u_t001_009/c0_w1_br
+ u_t001_009/c0_r0_rbl u_t001_009/c0_r1_rbl u_t001_009/c1_w0_bl u_t001_009/c1_w0_br
+ u_t001_009/c1_w1_bl u_t001_009/c1_w1_br u_t001_009/c1_r0_rbl u_t001_009/c1_r1_rbl
+ u_t001_009/c2_w0_bl u_t001_009/c2_w0_br u_t001_009/c2_w1_bl u_t001_009/c2_w1_br
+ u_t001_009/c2_r0_rbl u_t001_009/c2_r1_rbl u_t001_009/c3_w0_bl u_t001_009/c3_w0_br
+ u_t001_009/c3_w1_bl u_t001_009/c3_w1_br u_t001_009/c3_r0_rbl u_t001_009/c3_r1_rbl
+ u_t001_009/r0_w0_wl u_t001_009/r0_w1_wl u_t001_009/r0_r0_rwl u_t001_009/r0_r1_rwl
+ u_t001_009/r1_w0_wl u_t001_009/r1_w1_wl u_t001_009/r1_r0_rwl u_t001_009/r1_r1_rwl
+ u_t001_009/r2_w0_wl u_t001_009/r2_w1_wl u_t001_009/r2_r0_rwl u_t001_009/r2_r1_rwl
+ u_t001_009/r3_w0_wl u_t001_009/r3_w1_wl u_t001_009/r3_r0_rwl u_t001_009/r3_r1_rwl
+ VSS u_t001_015/VSS VSUBS detronyx_12t_2w2r_rc4_4x4_routed_5layer_direct
Xgf180mcu_as_sc_mcu7t3v3__inv_2_289 VSS VSS VSS VSS gf180mcu_as_sc_mcu7t3v3__inv_2_290/VNW
+ VSUBS gf180mcu_as_sc_mcu7t3v3__inv_2
Xgf180mcu_as_sc_mcu7t3v3__inv_2_234 gf180mcu_as_sc_mcu7t3v3__nor2_2_5/VDD gf180mcu_as_sc_mcu7t3v3__nor2_2_5/VSS
+ VSS VSS gf180mcu_as_sc_mcu7t3v3__nor2_2_5/VNW VSUBS gf180mcu_as_sc_mcu7t3v3__inv_2
Xgf180mcu_as_sc_mcu7t3v3__inv_2_212 gf180mcu_as_sc_mcu7t3v3__nor2_2_5/VDD gf180mcu_as_sc_mcu7t3v3__nand3_2_8/VSS
+ VSS VSS gf180mcu_as_sc_mcu7t3v3__nor2_2_5/VNW VSUBS gf180mcu_as_sc_mcu7t3v3__inv_2
Xgf180mcu_as_sc_mcu7t3v3__inv_2_267 gf180mcu_as_sc_mcu7t3v3__nor2_2_6/VDD gf180mcu_as_sc_mcu7t3v3__nor2_2_6/VSS
+ VSS VSS gf180mcu_as_sc_mcu7t3v3__nor2_2_6/VNW VSUBS gf180mcu_as_sc_mcu7t3v3__inv_2
Xgf180mcu_as_sc_mcu7t3v3__inv_2_223 gf180mcu_as_sc_mcu7t3v3__nor2_2_6/VDD gf180mcu_as_sc_mcu7t3v3__nor2_2_6/VSS
+ VSS VSS gf180mcu_as_sc_mcu7t3v3__nor2_2_6/VNW VSUBS gf180mcu_as_sc_mcu7t3v3__inv_2
Xgf180mcu_as_sc_mcu7t3v3__inv_2_201 gf180mcu_as_sc_mcu7t3v3__nand2_2_9/VDD gf180mcu_as_sc_mcu7t3v3__nor2_2_6/VSS
+ VSS VSS gf180mcu_as_sc_mcu7t3v3__nand2_2_9/VNW VSUBS gf180mcu_as_sc_mcu7t3v3__inv_2
Xgf180mcu_as_sc_mcu7t3v3__inv_2_278 gf180mcu_as_sc_mcu7t3v3__nand2_2_9/VDD gf180mcu_as_sc_mcu7t3v3__nor2_2_4/VSS
+ gf180mcu_as_sc_mcu7t3v3__inv_2_278/Y VSS gf180mcu_as_sc_mcu7t3v3__nand2_2_9/VNW
+ VSUBS gf180mcu_as_sc_mcu7t3v3__inv_2
Xgf180mcu_as_sc_mcu7t3v3__inv_2_256 gf180mcu_as_sc_mcu7t3v3__nand2_2_9/VDD gf180mcu_as_sc_mcu7t3v3__nor2_2_4/VSS
+ VSS VSS gf180mcu_as_sc_mcu7t3v3__nand2_2_9/VNW VSUBS gf180mcu_as_sc_mcu7t3v3__inv_2
Xgf180mcu_as_sc_mcu7t3v3__inv_2_245 gf180mcu_as_sc_mcu7t3v3__nand2_2_9/VDD gf180mcu_as_sc_mcu7t3v3__nor2_2_4/VSS
+ gf180mcu_as_sc_mcu7t3v3__inv_2_245/Y VSS gf180mcu_as_sc_mcu7t3v3__nand2_2_9/VNW
+ VSUBS gf180mcu_as_sc_mcu7t3v3__inv_2
Xgf180mcu_as_sc_mcu7t3v3__inv_2_790 gf180mcu_as_sc_mcu7t3v3__inv_2_791/VDD gf180mcu_as_sc_mcu7t3v3__inv_2_794/VDD
+ gf180mcu_as_sc_mcu7t3v3__inv_2_790/Y VSS gf180mcu_as_sc_mcu7t3v3__inv_2_791/VNW
+ VSUBS gf180mcu_as_sc_mcu7t3v3__inv_2
Xgf180mcu_as_sc_mcu7t3v3__nor2_2_2 gf180mcu_as_sc_mcu7t3v3__nor2_2_5/VDD gf180mcu_as_sc_mcu7t3v3__nor2_2_5/VSS
+ VSS VSS VSS gf180mcu_as_sc_mcu7t3v3__nor2_2_5/VNW VSUBS gf180mcu_as_sc_mcu7t3v3__nor2_2
Xgf180mcu_as_sc_mcu7t3v3__nand2_2_7 gf180mcu_as_sc_mcu7t3v3__nor2_2_4/VDD gf180mcu_as_sc_mcu7t3v3__nor2_2_4/VSS
+ VSS VSS VSS gf180mcu_as_sc_mcu7t3v3__nor2_2_4/VNW VSUBS gf180mcu_as_sc_mcu7t3v3__nand2_2
Xgf180mcu_as_sc_mcu7t3v3__nand4_2_16 VSS VSS VSS VSS VSS VSS VSS gf180mcu_as_sc_mcu7t3v3__inv_2_50/VNW
+ VSUBS gf180mcu_as_sc_mcu7t3v3__nand4_2
Xgf180mcu_as_sc_mcu7t3v3__nand4_2_38 gf180mcu_as_sc_mcu7t3v3__inv_2_114/VDD VSS VSS
+ VSS VSS VSS VSS gf180mcu_as_sc_mcu7t3v3__inv_2_114/VNW VSUBS gf180mcu_as_sc_mcu7t3v3__nand4_2
Xgf180mcu_as_sc_mcu7t3v3__nand4_2_49 VSS VSS VSS VSS VSS VSS VSS gf180mcu_as_sc_mcu7t3v3__inv_2_147/VNW
+ VSUBS gf180mcu_as_sc_mcu7t3v3__nand4_2
Xgf180mcu_as_sc_mcu7t3v3__nand4_2_27 gf180mcu_as_sc_mcu7t3v3__inv_2_81/VDD gf180mcu_as_sc_mcu7t3v3__inv_2_84/VDD
+ VSS VSS VSS VSS gf180mcu_as_sc_mcu7t3v3__nand4_2_27/Y gf180mcu_as_sc_mcu7t3v3__inv_2_81/VNW
+ VSUBS gf180mcu_as_sc_mcu7t3v3__nand4_2
Xgf180mcu_as_sc_mcu7t3v3__inv_2_608 gf180mcu_as_sc_mcu7t3v3__inv_2_609/VDD gf180mcu_as_sc_mcu7t3v3__inv_2_612/VDD
+ gf180mcu_as_sc_mcu7t3v3__inv_2_608/Y gf180mcu_as_sc_mcu7t3v3__inv_2_609/Y gf180mcu_as_sc_mcu7t3v3__inv_2_609/VNW
+ VSUBS gf180mcu_as_sc_mcu7t3v3__inv_2
Xgf180mcu_as_sc_mcu7t3v3__inv_2_619 VSS VSS VSS VSS gf180mcu_as_sc_mcu7t3v3__inv_2_630/VNW
+ VSUBS gf180mcu_as_sc_mcu7t3v3__inv_2
Xu_t007_004 u_t007_004/c0_w0_bl u_t007_004/c0_w0_br u_t007_004/c0_w1_bl u_t007_004/c0_w1_br
+ u_t007_004/c0_r0_rbl u_t007_004/c0_r1_rbl u_t007_004/c1_w0_bl u_t007_004/c1_w0_br
+ u_t007_004/c1_w1_bl u_t007_004/c1_w1_br u_t007_004/c1_r0_rbl u_t007_004/c1_r1_rbl
+ u_t007_004/c2_w0_bl u_t007_004/c2_w0_br u_t007_004/c2_w1_bl u_t007_004/c2_w1_br
+ u_t007_004/c2_r0_rbl u_t007_004/c2_r1_rbl u_t007_004/c3_w0_bl u_t007_004/c3_w0_br
+ u_t007_004/c3_w1_bl u_t007_004/c3_w1_br u_t007_004/c3_r0_rbl u_t007_004/c3_r1_rbl
+ u_t007_004/r0_w0_wl u_t007_004/r0_w1_wl u_t007_004/r0_r0_rwl u_t007_004/r0_r1_rwl
+ u_t007_004/r1_w0_wl u_t007_004/r1_w1_wl u_t007_004/r1_r0_rwl u_t007_004/r1_r1_rwl
+ u_t007_004/r2_w0_wl u_t007_004/r2_w1_wl u_t007_004/r2_r0_rwl u_t007_004/r2_r1_rwl
+ u_t007_004/r3_w0_wl u_t007_004/r3_w1_wl u_t007_004/r3_r0_rwl u_t007_004/r3_r1_rwl
+ u_t008_004/VDD u_t007_004/VSS VSUBS detronyx_12t_2w2r_rc4_4x4_routed_5layer_direct
Xu_t007_015 u_t007_015/c0_w0_bl u_t007_015/c0_w0_br u_t007_015/c0_w1_bl u_t007_015/c0_w1_br
+ u_t007_015/c0_r0_rbl u_t007_015/c0_r1_rbl u_t007_015/c1_w0_bl u_t007_015/c1_w0_br
+ u_t007_015/c1_w1_bl u_t007_015/c1_w1_br u_t007_015/c1_r0_rbl u_t007_015/c1_r1_rbl
+ u_t007_015/c2_w0_bl u_t007_015/c2_w0_br u_t007_015/c2_w1_bl u_t007_015/c2_w1_br
+ u_t007_015/c2_r0_rbl u_t007_015/c2_r1_rbl u_t007_015/c3_w0_bl u_t007_015/c3_w0_br
+ u_t007_015/c3_w1_bl u_t007_015/c3_w1_br u_t007_015/c3_r0_rbl u_t007_015/c3_r1_rbl
+ u_t007_015/r0_w0_wl u_t007_015/r0_w1_wl u_t007_015/r0_r0_rwl u_t007_015/r0_r1_rwl
+ u_t007_015/r1_w0_wl u_t007_015/r1_w1_wl u_t007_015/r1_r0_rwl u_t007_015/r1_r1_rwl
+ u_t007_015/r2_w0_wl u_t007_015/r2_w1_wl u_t007_015/r2_r0_rwl u_t007_015/r2_r1_rwl
+ u_t007_015/r3_w0_wl u_t007_015/r3_w1_wl u_t007_015/r3_r0_rwl u_t007_015/r3_r1_rwl
+ VSS u_t007_015/VSS VSUBS detronyx_12t_2w2r_rc4_4x4_routed_5layer_direct
Xu_t013_007 u_t013_007/c0_w0_bl u_t013_007/c0_w0_br u_t013_007/c0_w1_bl u_t013_007/c0_w1_br
+ u_t013_007/c0_r0_rbl u_t013_007/c0_r1_rbl u_t013_007/c1_w0_bl u_t013_007/c1_w0_br
+ u_t013_007/c1_w1_bl u_t013_007/c1_w1_br u_t013_007/c1_r0_rbl u_t013_007/c1_r1_rbl
+ u_t013_007/c2_w0_bl u_t013_007/c2_w0_br u_t013_007/c2_w1_bl u_t013_007/c2_w1_br
+ u_t013_007/c2_r0_rbl u_t013_007/c2_r1_rbl u_t013_007/c3_w0_bl u_t013_007/c3_w0_br
+ u_t013_007/c3_w1_bl u_t013_007/c3_w1_br u_t013_007/c3_r0_rbl u_t013_007/c3_r1_rbl
+ u_t013_007/r0_w0_wl u_t013_007/r0_w1_wl u_t013_007/r0_r0_rwl u_t013_007/r0_r1_rwl
+ u_t013_007/r1_w0_wl u_t013_007/r1_w1_wl u_t013_007/r1_r0_rwl u_t013_007/r1_r1_rwl
+ u_t013_007/r2_w0_wl u_t013_007/r2_w1_wl u_t013_007/r2_r0_rwl u_t013_007/r2_r1_rwl
+ u_t013_007/r3_w0_wl u_t013_007/r3_w1_wl u_t013_007/r3_r0_rwl u_t013_007/r3_r1_rwl
+ VSS u_t013_015/VSS VSUBS detronyx_12t_2w2r_rc4_4x4_routed_5layer_direct
Xgf180mcu_as_sc_mcu7t3v3__inv_2_405 gf180mcu_as_sc_mcu7t3v3__inv_2_405/VDD VSS gf180mcu_as_sc_mcu7t3v3__inv_2_405/Y
+ VSS gf180mcu_as_sc_mcu7t3v3__inv_2_405/VNW VSUBS gf180mcu_as_sc_mcu7t3v3__inv_2
Xgf180mcu_as_sc_mcu7t3v3__inv_2_449 VSS VSS VSS VSS gf180mcu_as_sc_mcu7t3v3__inv_2_449/VNW
+ VSUBS gf180mcu_as_sc_mcu7t3v3__inv_2
Xgf180mcu_as_sc_mcu7t3v3__inv_2_438 VSS VSS VSS VSS gf180mcu_as_sc_mcu7t3v3__inv_2_440/VNW
+ VSUBS gf180mcu_as_sc_mcu7t3v3__inv_2
Xgf180mcu_as_sc_mcu7t3v3__inv_2_427 VSS VSS VSS VSS gf180mcu_as_sc_mcu7t3v3__inv_2_428/VNW
+ VSUBS gf180mcu_as_sc_mcu7t3v3__inv_2
Xgf180mcu_as_sc_mcu7t3v3__inv_2_416 VSS VSS gf180mcu_as_sc_mcu7t3v3__inv_2_416/Y VSS
+ gf180mcu_as_sc_mcu7t3v3__inv_2_416/VNW VSUBS gf180mcu_as_sc_mcu7t3v3__inv_2
Xu_t004_007 u_t004_007/c0_w0_bl u_t004_007/c0_w0_br u_t004_007/c0_w1_bl u_t004_007/c0_w1_br
+ u_t004_007/c0_r0_rbl u_t004_007/c0_r1_rbl u_t004_007/c1_w0_bl u_t004_007/c1_w0_br
+ u_t004_007/c1_w1_bl u_t004_007/c1_w1_br u_t004_007/c1_r0_rbl u_t004_007/c1_r1_rbl
+ u_t004_007/c2_w0_bl u_t004_007/c2_w0_br u_t004_007/c2_w1_bl u_t004_007/c2_w1_br
+ u_t004_007/c2_r0_rbl u_t004_007/c2_r1_rbl u_t004_007/c3_w0_bl u_t004_007/c3_w0_br
+ u_t004_007/c3_w1_bl u_t004_007/c3_w1_br u_t004_007/c3_r0_rbl u_t004_007/c3_r1_rbl
+ u_t004_007/r0_w0_wl u_t004_007/r0_w1_wl u_t004_007/r0_r0_rwl u_t004_007/r0_r1_rwl
+ u_t004_007/r1_w0_wl u_t004_007/r1_w1_wl u_t004_007/r1_r0_rwl u_t004_007/r1_r1_rwl
+ u_t004_007/r2_w0_wl u_t004_007/r2_w1_wl u_t004_007/r2_r0_rwl u_t004_007/r2_r1_rwl
+ u_t004_007/r3_w0_wl u_t004_007/r3_w1_wl u_t004_007/r3_r0_rwl u_t004_007/r3_r1_rwl
+ VSS u_t004_015/VSS VSUBS detronyx_12t_2w2r_rc4_4x4_routed_5layer_direct
Xgf180mcu_as_sc_mcu7t3v3__inv_2_213 gf180mcu_as_sc_mcu7t3v3__nor2_2_5/VDD gf180mcu_as_sc_mcu7t3v3__nor2_2_5/VSS
+ VSS VSS gf180mcu_as_sc_mcu7t3v3__nor2_2_5/VNW VSUBS gf180mcu_as_sc_mcu7t3v3__inv_2
Xgf180mcu_as_sc_mcu7t3v3__inv_2_235 gf180mcu_as_sc_mcu7t3v3__nor2_2_5/VDD gf180mcu_as_sc_mcu7t3v3__nand3_2_8/VSS
+ VSS VSS gf180mcu_as_sc_mcu7t3v3__nor2_2_5/VNW VSUBS gf180mcu_as_sc_mcu7t3v3__inv_2
Xgf180mcu_as_sc_mcu7t3v3__inv_2_268 gf180mcu_as_sc_mcu7t3v3__nor2_2_6/VDD gf180mcu_as_sc_mcu7t3v3__nand3_2_1/VSS
+ gf180mcu_as_sc_mcu7t3v3__inv_2_268/Y VSS gf180mcu_as_sc_mcu7t3v3__nor2_2_6/VNW VSUBS
+ gf180mcu_as_sc_mcu7t3v3__inv_2
Xgf180mcu_as_sc_mcu7t3v3__inv_2_224 gf180mcu_as_sc_mcu7t3v3__nor2_2_6/VDD gf180mcu_as_sc_mcu7t3v3__nand3_2_1/VSS
+ VSS VSS gf180mcu_as_sc_mcu7t3v3__nor2_2_6/VNW VSUBS gf180mcu_as_sc_mcu7t3v3__inv_2
Xgf180mcu_as_sc_mcu7t3v3__inv_2_202 gf180mcu_as_sc_mcu7t3v3__nor2_2_6/VDD gf180mcu_as_sc_mcu7t3v3__nor2_2_6/VSS
+ VSS VSS gf180mcu_as_sc_mcu7t3v3__nor2_2_6/VNW VSUBS gf180mcu_as_sc_mcu7t3v3__inv_2
Xgf180mcu_as_sc_mcu7t3v3__inv_2_279 gf180mcu_as_sc_mcu7t3v3__nand2_2_9/VDD gf180mcu_as_sc_mcu7t3v3__nor2_2_6/VSS
+ gf180mcu_as_sc_mcu7t3v3__inv_2_279/Y VSS gf180mcu_as_sc_mcu7t3v3__nand2_2_9/VNW
+ VSUBS gf180mcu_as_sc_mcu7t3v3__inv_2
Xgf180mcu_as_sc_mcu7t3v3__inv_2_257 gf180mcu_as_sc_mcu7t3v3__nand2_2_9/VDD gf180mcu_as_sc_mcu7t3v3__nor2_2_6/VSS
+ VSS VSS gf180mcu_as_sc_mcu7t3v3__nand2_2_9/VNW VSUBS gf180mcu_as_sc_mcu7t3v3__inv_2
Xgf180mcu_as_sc_mcu7t3v3__inv_2_246 gf180mcu_as_sc_mcu7t3v3__nand2_2_9/VDD gf180mcu_as_sc_mcu7t3v3__nor2_2_6/VSS
+ VSS VSS gf180mcu_as_sc_mcu7t3v3__nand2_2_9/VNW VSUBS gf180mcu_as_sc_mcu7t3v3__inv_2
Xu_t000_010 u_t000_010/c0_w0_bl u_t000_010/c0_w0_br u_t000_010/c0_w1_bl u_t000_010/c0_w1_br
+ u_t000_010/c0_r0_rbl u_t000_010/c0_r1_rbl u_t000_010/c1_w0_bl u_t000_010/c1_w0_br
+ u_t000_010/c1_w1_bl u_t000_010/c1_w1_br u_t000_010/c1_r0_rbl u_t000_010/c1_r1_rbl
+ u_t000_010/c2_w0_bl u_t000_010/c2_w0_br u_t000_010/c2_w1_bl u_t000_010/c2_w1_br
+ u_t000_010/c2_r0_rbl u_t000_010/c2_r1_rbl u_t000_010/c3_w0_bl u_t000_010/c3_w0_br
+ u_t000_010/c3_w1_bl u_t000_010/c3_w1_br u_t000_010/c3_r0_rbl u_t000_010/c3_r1_rbl
+ u_t000_010/r0_w0_wl u_t000_010/r0_w1_wl u_t000_010/r0_r0_rwl u_t000_010/r0_r1_rwl
+ u_t000_010/r1_w0_wl u_t000_010/r1_w1_wl u_t000_010/r1_r0_rwl u_t000_010/r1_r1_rwl
+ u_t000_010/r2_w0_wl u_t000_010/r2_w1_wl u_t000_010/r2_r0_rwl u_t000_010/r2_r1_rwl
+ u_t000_010/r3_w0_wl u_t000_010/r3_w1_wl u_t000_010/r3_r0_rwl u_t000_010/r3_r1_rwl
+ VSS u_t000_015/VSS VSUBS detronyx_12t_2w2r_rc4_4x4_routed_5layer_direct
Xgf180mcu_as_sc_mcu7t3v3__inv_2_791 gf180mcu_as_sc_mcu7t3v3__inv_2_791/VDD gf180mcu_as_sc_mcu7t3v3__inv_2_794/VDD
+ gf180mcu_as_sc_mcu7t3v3__inv_2_791/Y VSS gf180mcu_as_sc_mcu7t3v3__inv_2_791/VNW
+ VSUBS gf180mcu_as_sc_mcu7t3v3__inv_2
Xgf180mcu_as_sc_mcu7t3v3__inv_2_780 gf180mcu_as_sc_mcu7t3v3__inv_2_782/VDD gf180mcu_as_sc_mcu7t3v3__inv_2_785/VDD
+ gf180mcu_as_sc_mcu7t3v3__inv_2_780/Y VSS gf180mcu_as_sc_mcu7t3v3__inv_2_782/VNW
+ VSUBS gf180mcu_as_sc_mcu7t3v3__inv_2
Xgf180mcu_as_sc_mcu7t3v3__nor2_2_3 gf180mcu_as_sc_mcu7t3v3__nor2_2_4/VDD gf180mcu_as_sc_mcu7t3v3__nor2_2_4/VSS
+ VSS VSS VSS gf180mcu_as_sc_mcu7t3v3__nor2_2_4/VNW VSUBS gf180mcu_as_sc_mcu7t3v3__nor2_2
Xgf180mcu_as_sc_mcu7t3v3__nand2_2_8 gf180mcu_as_sc_mcu7t3v3__nand2_2_9/VDD gf180mcu_as_sc_mcu7t3v3__nor2_2_4/VSS
+ VSS VSS VSS gf180mcu_as_sc_mcu7t3v3__nand2_2_9/VNW VSUBS gf180mcu_as_sc_mcu7t3v3__nand2_2
Xgf180mcu_as_sc_mcu7t3v3__nand4_2_17 VSS gf180mcu_as_sc_mcu7t3v3__inv_2_56/VDD VSS
+ VSS VSS VSS gf180mcu_as_sc_mcu7t3v3__nand4_2_17/Y gf180mcu_as_sc_mcu7t3v3__inv_2_53/VNW
+ VSUBS gf180mcu_as_sc_mcu7t3v3__nand4_2
Xgf180mcu_as_sc_mcu7t3v3__nand4_2_39 gf180mcu_as_sc_mcu7t3v3__inv_2_173/VDD VSS VSS
+ VSS VSS VSS VSS gf180mcu_as_sc_mcu7t3v3__inv_2_173/VNW VSUBS gf180mcu_as_sc_mcu7t3v3__nand4_2
Xgf180mcu_as_sc_mcu7t3v3__nand4_2_28 gf180mcu_as_sc_mcu7t3v3__inv_2_84/VDD VSS VSS
+ VSS VSS VSS gf180mcu_as_sc_mcu7t3v3__nand4_2_28/Y gf180mcu_as_sc_mcu7t3v3__inv_2_84/VNW
+ VSUBS gf180mcu_as_sc_mcu7t3v3__nand4_2
Xgf180mcu_as_sc_mcu7t3v3__inv_2_609 gf180mcu_as_sc_mcu7t3v3__inv_2_609/VDD gf180mcu_as_sc_mcu7t3v3__inv_2_612/VDD
+ gf180mcu_as_sc_mcu7t3v3__inv_2_609/Y VSS gf180mcu_as_sc_mcu7t3v3__inv_2_609/VNW
+ VSUBS gf180mcu_as_sc_mcu7t3v3__inv_2
Xu_t007_005 u_t007_005/c0_w0_bl u_t007_005/c0_w0_br u_t007_005/c0_w1_bl u_t007_005/c0_w1_br
+ u_t007_005/c0_r0_rbl u_t007_005/c0_r1_rbl u_t007_005/c1_w0_bl u_t007_005/c1_w0_br
+ u_t007_005/c1_w1_bl u_t007_005/c1_w1_br u_t007_005/c1_r0_rbl u_t007_005/c1_r1_rbl
+ u_t007_005/c2_w0_bl u_t007_005/c2_w0_br u_t007_005/c2_w1_bl u_t007_005/c2_w1_br
+ u_t007_005/c2_r0_rbl u_t007_005/c2_r1_rbl u_t007_005/c3_w0_bl u_t007_005/c3_w0_br
+ u_t007_005/c3_w1_bl u_t007_005/c3_w1_br u_t007_005/c3_r0_rbl u_t007_005/c3_r1_rbl
+ u_t007_005/r0_w0_wl u_t007_005/r0_w1_wl u_t007_005/r0_r0_rwl u_t007_005/r0_r1_rwl
+ u_t007_005/r1_w0_wl u_t007_005/r1_w1_wl u_t007_005/r1_r0_rwl u_t007_005/r1_r1_rwl
+ u_t007_005/r2_w0_wl u_t007_005/r2_w1_wl u_t007_005/r2_r0_rwl u_t007_005/r2_r1_rwl
+ u_t007_005/r3_w0_wl u_t007_005/r3_w1_wl u_t007_005/r3_r0_rwl u_t007_005/r3_r1_rwl
+ u_t008_005/VDD u_t007_005/VSS VSUBS detronyx_12t_2w2r_rc4_4x4_routed_5layer_direct
Xu_t013_008 u_t013_008/c0_w0_bl u_t013_008/c0_w0_br u_t013_008/c0_w1_bl u_t013_008/c0_w1_br
+ u_t013_008/c0_r0_rbl u_t013_008/c0_r1_rbl u_t013_008/c1_w0_bl u_t013_008/c1_w0_br
+ u_t013_008/c1_w1_bl u_t013_008/c1_w1_br u_t013_008/c1_r0_rbl u_t013_008/c1_r1_rbl
+ u_t013_008/c2_w0_bl u_t013_008/c2_w0_br u_t013_008/c2_w1_bl u_t013_008/c2_w1_br
+ u_t013_008/c2_r0_rbl u_t013_008/c2_r1_rbl u_t013_008/c3_w0_bl u_t013_008/c3_w0_br
+ u_t013_008/c3_w1_bl u_t013_008/c3_w1_br u_t013_008/c3_r0_rbl u_t013_008/c3_r1_rbl
+ u_t013_008/r0_w0_wl u_t013_008/r0_w1_wl u_t013_008/r0_r0_rwl u_t013_008/r0_r1_rwl
+ u_t013_008/r1_w0_wl u_t013_008/r1_w1_wl u_t013_008/r1_r0_rwl u_t013_008/r1_r1_rwl
+ u_t013_008/r2_w0_wl u_t013_008/r2_w1_wl u_t013_008/r2_r0_rwl u_t013_008/r2_r1_rwl
+ u_t013_008/r3_w0_wl u_t013_008/r3_w1_wl u_t013_008/r3_r0_rwl u_t013_008/r3_r1_rwl
+ VSS u_t013_015/VSS VSUBS detronyx_12t_2w2r_rc4_4x4_routed_5layer_direct
Xgf180mcu_as_sc_mcu7t3v3__inv_2_406 VSS VSS VSS VSS gf180mcu_as_sc_mcu7t3v3__inv_2_462/VNW
+ VSUBS gf180mcu_as_sc_mcu7t3v3__inv_2
Xgf180mcu_as_sc_mcu7t3v3__inv_2_439 VSS VSS VSS VSS gf180mcu_as_sc_mcu7t3v3__inv_2_440/VNW
+ VSUBS gf180mcu_as_sc_mcu7t3v3__inv_2
Xgf180mcu_as_sc_mcu7t3v3__inv_2_428 VSS VSS gf180mcu_as_sc_mcu7t3v3__inv_2_428/Y VSS
+ gf180mcu_as_sc_mcu7t3v3__inv_2_428/VNW VSUBS gf180mcu_as_sc_mcu7t3v3__inv_2
Xgf180mcu_as_sc_mcu7t3v3__inv_2_417 VSS VSS VSS VSS gf180mcu_as_sc_mcu7t3v3__inv_2_419/VNW
+ VSUBS gf180mcu_as_sc_mcu7t3v3__inv_2
Xu_t004_008 u_t004_008/c0_w0_bl u_t004_008/c0_w0_br u_t004_008/c0_w1_bl u_t004_008/c0_w1_br
+ u_t004_008/c0_r0_rbl u_t004_008/c0_r1_rbl u_t004_008/c1_w0_bl u_t004_008/c1_w0_br
+ u_t004_008/c1_w1_bl u_t004_008/c1_w1_br u_t004_008/c1_r0_rbl u_t004_008/c1_r1_rbl
+ u_t004_008/c2_w0_bl u_t004_008/c2_w0_br u_t004_008/c2_w1_bl u_t004_008/c2_w1_br
+ u_t004_008/c2_r0_rbl u_t004_008/c2_r1_rbl u_t004_008/c3_w0_bl u_t004_008/c3_w0_br
+ u_t004_008/c3_w1_bl u_t004_008/c3_w1_br u_t004_008/c3_r0_rbl u_t004_008/c3_r1_rbl
+ u_t004_008/r0_w0_wl u_t004_008/r0_w1_wl u_t004_008/r0_r0_rwl u_t004_008/r0_r1_rwl
+ u_t004_008/r1_w0_wl u_t004_008/r1_w1_wl u_t004_008/r1_r0_rwl u_t004_008/r1_r1_rwl
+ u_t004_008/r2_w0_wl u_t004_008/r2_w1_wl u_t004_008/r2_r0_rwl u_t004_008/r2_r1_rwl
+ u_t004_008/r3_w0_wl u_t004_008/r3_w1_wl u_t004_008/r3_r0_rwl u_t004_008/r3_r1_rwl
+ VSS u_t004_015/VSS VSUBS detronyx_12t_2w2r_rc4_4x4_routed_5layer_direct
Xgf180mcu_as_sc_mcu7t3v3__nand4_2_250 gf180mcu_as_sc_mcu7t3v3__inv_2_908/VDD VSS VSS
+ VSS VSS VSS VSS gf180mcu_as_sc_mcu7t3v3__inv_2_908/VNW VSUBS gf180mcu_as_sc_mcu7t3v3__nand4_2
Xgf180mcu_as_sc_mcu7t3v3__inv_2_225 gf180mcu_as_sc_mcu7t3v3__nor2_2_5/VDD gf180mcu_as_sc_mcu7t3v3__nor2_2_5/VSS
+ VSS VSS gf180mcu_as_sc_mcu7t3v3__nor2_2_5/VNW VSUBS gf180mcu_as_sc_mcu7t3v3__inv_2
Xgf180mcu_as_sc_mcu7t3v3__inv_2_214 gf180mcu_as_sc_mcu7t3v3__nor2_2_5/VDD gf180mcu_as_sc_mcu7t3v3__nand3_2_8/VSS
+ VSS VSS gf180mcu_as_sc_mcu7t3v3__nor2_2_5/VNW VSUBS gf180mcu_as_sc_mcu7t3v3__inv_2
Xgf180mcu_as_sc_mcu7t3v3__inv_2_203 gf180mcu_as_sc_mcu7t3v3__nor2_2_6/VDD gf180mcu_as_sc_mcu7t3v3__nor2_2_6/VSS
+ VSS VSS gf180mcu_as_sc_mcu7t3v3__nor2_2_6/VNW VSUBS gf180mcu_as_sc_mcu7t3v3__inv_2
Xgf180mcu_as_sc_mcu7t3v3__inv_2_269 gf180mcu_as_sc_mcu7t3v3__nor2_2_4/VDD gf180mcu_as_sc_mcu7t3v3__nor2_2_4/VSS
+ gf180mcu_as_sc_mcu7t3v3__inv_2_269/Y VSS gf180mcu_as_sc_mcu7t3v3__nor2_2_4/VNW VSUBS
+ gf180mcu_as_sc_mcu7t3v3__inv_2
Xgf180mcu_as_sc_mcu7t3v3__inv_2_258 gf180mcu_as_sc_mcu7t3v3__nor2_2_6/VDD gf180mcu_as_sc_mcu7t3v3__nor2_2_6/VSS
+ VSS VSS gf180mcu_as_sc_mcu7t3v3__nor2_2_6/VNW VSUBS gf180mcu_as_sc_mcu7t3v3__inv_2
Xgf180mcu_as_sc_mcu7t3v3__inv_2_247 gf180mcu_as_sc_mcu7t3v3__nor2_2_6/VDD gf180mcu_as_sc_mcu7t3v3__nor2_2_6/VSS
+ VSS VSS gf180mcu_as_sc_mcu7t3v3__nor2_2_6/VNW VSUBS gf180mcu_as_sc_mcu7t3v3__inv_2
Xgf180mcu_as_sc_mcu7t3v3__inv_2_236 gf180mcu_as_sc_mcu7t3v3__nor2_2_6/VDD gf180mcu_as_sc_mcu7t3v3__nand3_2_1/VSS
+ VSS VSS gf180mcu_as_sc_mcu7t3v3__nor2_2_6/VNW VSUBS gf180mcu_as_sc_mcu7t3v3__inv_2
Xu_t000_000 u_t000_000/c0_w0_bl u_t000_000/c0_w0_br u_t000_000/c0_w1_bl u_t000_000/c0_w1_br
+ u_t000_000/c0_r0_rbl u_t000_000/c0_r1_rbl u_t000_000/c1_w0_bl u_t000_000/c1_w0_br
+ u_t000_000/c1_w1_bl u_t000_000/c1_w1_br u_t000_000/c1_r0_rbl u_t000_000/c1_r1_rbl
+ u_t000_000/c2_w0_bl u_t000_000/c2_w0_br u_t000_000/c2_w1_bl u_t000_000/c2_w1_br
+ u_t000_000/c2_r0_rbl u_t000_000/c2_r1_rbl u_t000_000/c3_w0_bl u_t000_000/c3_w0_br
+ u_t000_000/c3_w1_bl u_t000_000/c3_w1_br u_t000_000/c3_r0_rbl u_t000_000/c3_r1_rbl
+ u_t000_000/r0_w0_wl u_t000_000/r0_w1_wl u_t000_000/r0_r0_rwl u_t000_000/r0_r1_rwl
+ u_t000_000/r1_w0_wl u_t000_000/r1_w1_wl u_t000_000/r1_r0_rwl u_t000_000/r1_r1_rwl
+ u_t000_000/r2_w0_wl u_t000_000/r2_w1_wl u_t000_000/r2_r0_rwl u_t000_000/r2_r1_rwl
+ u_t000_000/r3_w0_wl u_t000_000/r3_w1_wl u_t000_000/r3_r0_rwl u_t000_000/r3_r1_rwl
+ VSS u_t000_015/VSS VSUBS detronyx_12t_2w2r_rc4_4x4_routed_5layer_direct
Xu_t000_011 u_t000_011/c0_w0_bl u_t000_011/c0_w0_br u_t000_011/c0_w1_bl u_t000_011/c0_w1_br
+ u_t000_011/c0_r0_rbl u_t000_011/c0_r1_rbl u_t000_011/c1_w0_bl u_t000_011/c1_w0_br
+ u_t000_011/c1_w1_bl u_t000_011/c1_w1_br u_t000_011/c1_r0_rbl u_t000_011/c1_r1_rbl
+ u_t000_011/c2_w0_bl u_t000_011/c2_w0_br u_t000_011/c2_w1_bl u_t000_011/c2_w1_br
+ u_t000_011/c2_r0_rbl u_t000_011/c2_r1_rbl u_t000_011/c3_w0_bl u_t000_011/c3_w0_br
+ u_t000_011/c3_w1_bl u_t000_011/c3_w1_br u_t000_011/c3_r0_rbl u_t000_011/c3_r1_rbl
+ u_t000_011/r0_w0_wl u_t000_011/r0_w1_wl u_t000_011/r0_r0_rwl u_t000_011/r0_r1_rwl
+ u_t000_011/r1_w0_wl u_t000_011/r1_w1_wl u_t000_011/r1_r0_rwl u_t000_011/r1_r1_rwl
+ u_t000_011/r2_w0_wl u_t000_011/r2_w1_wl u_t000_011/r2_r0_rwl u_t000_011/r2_r1_rwl
+ u_t000_011/r3_w0_wl u_t000_011/r3_w1_wl u_t000_011/r3_r0_rwl u_t000_011/r3_r1_rwl
+ u_t000_011/VDD u_t000_015/VSS VSUBS detronyx_12t_2w2r_rc4_4x4_routed_5layer_direct
Xgf180mcu_as_sc_mcu7t3v3__inv_2_781 gf180mcu_as_sc_mcu7t3v3__inv_2_782/VDD gf180mcu_as_sc_mcu7t3v3__inv_2_785/VDD
+ gf180mcu_as_sc_mcu7t3v3__inv_2_781/Y VSS gf180mcu_as_sc_mcu7t3v3__inv_2_782/VNW
+ VSUBS gf180mcu_as_sc_mcu7t3v3__inv_2
Xgf180mcu_as_sc_mcu7t3v3__inv_2_770 VSS VSS gf180mcu_as_sc_mcu7t3v3__inv_2_776/Y VSS
+ gf180mcu_as_sc_mcu7t3v3__inv_2_770/VNW VSUBS gf180mcu_as_sc_mcu7t3v3__inv_2
Xgf180mcu_as_sc_mcu7t3v3__inv_2_792 gf180mcu_as_sc_mcu7t3v3__inv_2_794/VDD gf180mcu_as_sc_mcu7t3v3__inv_2_797/VDD
+ gf180mcu_as_sc_mcu7t3v3__inv_2_792/Y VSS gf180mcu_as_sc_mcu7t3v3__inv_2_794/VNW
+ VSUBS gf180mcu_as_sc_mcu7t3v3__inv_2
Xgf180mcu_as_sc_mcu7t3v3__nor2_2_4 gf180mcu_as_sc_mcu7t3v3__nor2_2_4/VDD gf180mcu_as_sc_mcu7t3v3__nor2_2_4/VSS
+ VSS VSS VSS gf180mcu_as_sc_mcu7t3v3__nor2_2_4/VNW VSUBS gf180mcu_as_sc_mcu7t3v3__nor2_2
Xgf180mcu_as_sc_mcu7t3v3__nand2_2_9 gf180mcu_as_sc_mcu7t3v3__nand2_2_9/VDD gf180mcu_as_sc_mcu7t3v3__nor2_2_6/VSS
+ VSS VSS VSS gf180mcu_as_sc_mcu7t3v3__nand2_2_9/VNW VSUBS gf180mcu_as_sc_mcu7t3v3__nand2_2
Xgf180mcu_as_sc_mcu7t3v3__nand4_2_18 gf180mcu_as_sc_mcu7t3v3__inv_2_56/VDD VSS VSS
+ VSS VSS VSS gf180mcu_as_sc_mcu7t3v3__nand4_2_18/Y gf180mcu_as_sc_mcu7t3v3__inv_2_56/VNW
+ VSUBS gf180mcu_as_sc_mcu7t3v3__nand4_2
Xgf180mcu_as_sc_mcu7t3v3__nand4_2_29 VSS VSS VSS VSS VSS VSS VSS gf180mcu_as_sc_mcu7t3v3__inv_2_87/VNW
+ VSUBS gf180mcu_as_sc_mcu7t3v3__nand4_2
Xu_t007_006 u_t007_006/c0_w0_bl u_t007_006/c0_w0_br u_t007_006/c0_w1_bl u_t007_006/c0_w1_br
+ u_t007_006/c0_r0_rbl u_t007_006/c0_r1_rbl u_t007_006/c1_w0_bl u_t007_006/c1_w0_br
+ u_t007_006/c1_w1_bl u_t007_006/c1_w1_br u_t007_006/c1_r0_rbl u_t007_006/c1_r1_rbl
+ u_t007_006/c2_w0_bl u_t007_006/c2_w0_br u_t007_006/c2_w1_bl u_t007_006/c2_w1_br
+ u_t007_006/c2_r0_rbl u_t007_006/c2_r1_rbl u_t007_006/c3_w0_bl u_t007_006/c3_w0_br
+ u_t007_006/c3_w1_bl u_t007_006/c3_w1_br u_t007_006/c3_r0_rbl u_t007_006/c3_r1_rbl
+ u_t007_006/r0_w0_wl u_t007_006/r0_w1_wl u_t007_006/r0_r0_rwl u_t007_006/r0_r1_rwl
+ u_t007_006/r1_w0_wl u_t007_006/r1_w1_wl u_t007_006/r1_r0_rwl u_t007_006/r1_r1_rwl
+ u_t007_006/r2_w0_wl u_t007_006/r2_w1_wl u_t007_006/r2_r0_rwl u_t007_006/r2_r1_rwl
+ u_t007_006/r3_w0_wl u_t007_006/r3_w1_wl u_t007_006/r3_r0_rwl u_t007_006/r3_r1_rwl
+ u_t008_006/VDD u_t007_009/VSS VSUBS detronyx_12t_2w2r_rc4_4x4_routed_5layer_direct
Xgf180mcu_as_sc_mcu7t3v3__inv_2_0 gf180mcu_as_sc_mcu7t3v3__inv_2_9/VDD gf180mcu_as_sc_mcu7t3v3__inv_2_9/VDD
+ gf180mcu_as_sc_mcu7t3v3__inv_2_9/A VSS gf180mcu_as_sc_mcu7t3v3__inv_2_0/VNW VSUBS
+ gf180mcu_as_sc_mcu7t3v3__inv_2
Xu_t013_009 u_t013_009/c0_w0_bl u_t013_009/c0_w0_br u_t013_009/c0_w1_bl u_t013_009/c0_w1_br
+ u_t013_009/c0_r0_rbl u_t013_009/c0_r1_rbl u_t013_009/c1_w0_bl u_t013_009/c1_w0_br
+ u_t013_009/c1_w1_bl u_t013_009/c1_w1_br u_t013_009/c1_r0_rbl u_t013_009/c1_r1_rbl
+ u_t013_009/c2_w0_bl u_t013_009/c2_w0_br u_t013_009/c2_w1_bl u_t013_009/c2_w1_br
+ u_t013_009/c2_r0_rbl u_t013_009/c2_r1_rbl u_t013_009/c3_w0_bl u_t013_009/c3_w0_br
+ u_t013_009/c3_w1_bl u_t013_009/c3_w1_br u_t013_009/c3_r0_rbl u_t013_009/c3_r1_rbl
+ u_t013_009/r0_w0_wl u_t013_009/r0_w1_wl u_t013_009/r0_r0_rwl u_t013_009/r0_r1_rwl
+ u_t013_009/r1_w0_wl u_t013_009/r1_w1_wl u_t013_009/r1_r0_rwl u_t013_009/r1_r1_rwl
+ u_t013_009/r2_w0_wl u_t013_009/r2_w1_wl u_t013_009/r2_r0_rwl u_t013_009/r2_r1_rwl
+ u_t013_009/r3_w0_wl u_t013_009/r3_w1_wl u_t013_009/r3_r0_rwl u_t013_009/r3_r1_rwl
+ VSS u_t013_015/VSS VSUBS detronyx_12t_2w2r_rc4_4x4_routed_5layer_direct
Xgf180mcu_as_sc_mcu7t3v3__inv_2_407 VSS VSS gf180mcu_as_sc_mcu7t3v3__inv_2_407/Y VSS
+ gf180mcu_as_sc_mcu7t3v3__inv_2_462/VNW VSUBS gf180mcu_as_sc_mcu7t3v3__inv_2
Xgf180mcu_as_sc_mcu7t3v3__inv_2_418 VSS VSS VSS VSS gf180mcu_as_sc_mcu7t3v3__inv_2_419/VNW
+ VSUBS gf180mcu_as_sc_mcu7t3v3__inv_2
Xgf180mcu_as_sc_mcu7t3v3__inv_2_429 VSS VSS VSS VSS gf180mcu_as_sc_mcu7t3v3__inv_2_431/VNW
+ VSUBS gf180mcu_as_sc_mcu7t3v3__inv_2
Xu_t004_009 u_t004_009/c0_w0_bl u_t004_009/c0_w0_br u_t004_009/c0_w1_bl u_t004_009/c0_w1_br
+ u_t004_009/c0_r0_rbl u_t004_009/c0_r1_rbl u_t004_009/c1_w0_bl u_t004_009/c1_w0_br
+ u_t004_009/c1_w1_bl u_t004_009/c1_w1_br u_t004_009/c1_r0_rbl u_t004_009/c1_r1_rbl
+ u_t004_009/c2_w0_bl u_t004_009/c2_w0_br u_t004_009/c2_w1_bl u_t004_009/c2_w1_br
+ u_t004_009/c2_r0_rbl u_t004_009/c2_r1_rbl u_t004_009/c3_w0_bl u_t004_009/c3_w0_br
+ u_t004_009/c3_w1_bl u_t004_009/c3_w1_br u_t004_009/c3_r0_rbl u_t004_009/c3_r1_rbl
+ u_t004_009/r0_w0_wl u_t004_009/r0_w1_wl u_t004_009/r0_r0_rwl u_t004_009/r0_r1_rwl
+ u_t004_009/r1_w0_wl u_t004_009/r1_w1_wl u_t004_009/r1_r0_rwl u_t004_009/r1_r1_rwl
+ u_t004_009/r2_w0_wl u_t004_009/r2_w1_wl u_t004_009/r2_r0_rwl u_t004_009/r2_r1_rwl
+ u_t004_009/r3_w0_wl u_t004_009/r3_w1_wl u_t004_009/r3_r0_rwl u_t004_009/r3_r1_rwl
+ VSS u_t004_015/VSS VSUBS detronyx_12t_2w2r_rc4_4x4_routed_5layer_direct
Xgf180mcu_as_sc_mcu7t3v3__inv_2_930 gf180mcu_as_sc_mcu7t3v3__inv_2_932/VDD gf180mcu_as_sc_mcu7t3v3__inv_2_932/VSS
+ VSS gf180mcu_as_sc_mcu7t3v3__inv_2_930/A gf180mcu_as_sc_mcu7t3v3__inv_2_932/VNW
+ VSUBS gf180mcu_as_sc_mcu7t3v3__inv_2
Xgf180mcu_as_sc_mcu7t3v3__nand4_2_251 VSS gf180mcu_as_sc_mcu7t3v3__inv_2_914/VDD VSS
+ VSS VSS VSS VSS gf180mcu_as_sc_mcu7t3v3__inv_2_911/VNW VSUBS gf180mcu_as_sc_mcu7t3v3__nand4_2
Xgf180mcu_as_sc_mcu7t3v3__nand4_2_240 gf180mcu_as_sc_mcu7t3v3__inv_2_878/VDD gf180mcu_as_sc_mcu7t3v3__inv_2_884/VDD
+ VSS VSS VSS VSS VSS gf180mcu_as_sc_mcu7t3v3__inv_2_878/VNW VSUBS gf180mcu_as_sc_mcu7t3v3__nand4_2
Xgf180mcu_as_sc_mcu7t3v3__inv_2_237 gf180mcu_as_sc_mcu7t3v3__nor2_2_5/VDD gf180mcu_as_sc_mcu7t3v3__nor2_2_5/VSS
+ VSS VSS gf180mcu_as_sc_mcu7t3v3__nor2_2_5/VNW VSUBS gf180mcu_as_sc_mcu7t3v3__inv_2
Xgf180mcu_as_sc_mcu7t3v3__inv_2_215 gf180mcu_as_sc_mcu7t3v3__nor2_2_4/VDD gf180mcu_as_sc_mcu7t3v3__nand3_2_8/VSS
+ VSS VSS gf180mcu_as_sc_mcu7t3v3__nor2_2_4/VNW VSUBS gf180mcu_as_sc_mcu7t3v3__inv_2
Xgf180mcu_as_sc_mcu7t3v3__inv_2_226 gf180mcu_as_sc_mcu7t3v3__nor2_2_5/VDD gf180mcu_as_sc_mcu7t3v3__nand3_2_8/VSS
+ VSS VSS gf180mcu_as_sc_mcu7t3v3__nor2_2_5/VNW VSUBS gf180mcu_as_sc_mcu7t3v3__inv_2
Xgf180mcu_as_sc_mcu7t3v3__inv_2_204 gf180mcu_as_sc_mcu7t3v3__nor2_2_4/VDD gf180mcu_as_sc_mcu7t3v3__nor2_2_4/VSS
+ VSS VSS gf180mcu_as_sc_mcu7t3v3__nor2_2_4/VNW VSUBS gf180mcu_as_sc_mcu7t3v3__inv_2
Xgf180mcu_as_sc_mcu7t3v3__inv_2_259 gf180mcu_as_sc_mcu7t3v3__nor2_2_6/VDD gf180mcu_as_sc_mcu7t3v3__nand3_2_1/VSS
+ VSS VSS gf180mcu_as_sc_mcu7t3v3__nor2_2_6/VNW VSUBS gf180mcu_as_sc_mcu7t3v3__inv_2
Xgf180mcu_as_sc_mcu7t3v3__inv_2_248 gf180mcu_as_sc_mcu7t3v3__nor2_2_6/VDD gf180mcu_as_sc_mcu7t3v3__nand3_2_1/VSS
+ VSS VSS gf180mcu_as_sc_mcu7t3v3__nor2_2_6/VNW VSUBS gf180mcu_as_sc_mcu7t3v3__inv_2
Xu_t000_001 u_t000_001/c0_w0_bl u_t000_001/c0_w0_br u_t000_001/c0_w1_bl u_t000_001/c0_w1_br
+ u_t000_001/c0_r0_rbl u_t000_001/c0_r1_rbl u_t000_001/c1_w0_bl u_t000_001/c1_w0_br
+ u_t000_001/c1_w1_bl u_t000_001/c1_w1_br u_t000_001/c1_r0_rbl u_t000_001/c1_r1_rbl
+ u_t000_001/c2_w0_bl u_t000_001/c2_w0_br u_t000_001/c2_w1_bl u_t000_001/c2_w1_br
+ u_t000_001/c2_r0_rbl u_t000_001/c2_r1_rbl u_t000_001/c3_w0_bl u_t000_001/c3_w0_br
+ u_t000_001/c3_w1_bl u_t000_001/c3_w1_br u_t000_001/c3_r0_rbl u_t000_001/c3_r1_rbl
+ u_t000_001/r0_w0_wl u_t000_001/r0_w1_wl u_t000_001/r0_r0_rwl u_t000_001/r0_r1_rwl
+ u_t000_001/r1_w0_wl u_t000_001/r1_w1_wl u_t000_001/r1_r0_rwl u_t000_001/r1_r1_rwl
+ u_t000_001/r2_w0_wl u_t000_001/r2_w1_wl u_t000_001/r2_r0_rwl u_t000_001/r2_r1_rwl
+ u_t000_001/r3_w0_wl u_t000_001/r3_w1_wl u_t000_001/r3_r0_rwl u_t000_001/r3_r1_rwl
+ VSS u_t000_015/VSS VSUBS detronyx_12t_2w2r_rc4_4x4_routed_5layer_direct
Xu_t000_012 u_t000_012/c0_w0_bl u_t000_012/c0_w0_br u_t000_012/c0_w1_bl u_t000_012/c0_w1_br
+ u_t000_012/c0_r0_rbl u_t000_012/c0_r1_rbl u_t000_012/c1_w0_bl u_t000_012/c1_w0_br
+ u_t000_012/c1_w1_bl u_t000_012/c1_w1_br u_t000_012/c1_r0_rbl u_t000_012/c1_r1_rbl
+ u_t000_012/c2_w0_bl u_t000_012/c2_w0_br u_t000_012/c2_w1_bl u_t000_012/c2_w1_br
+ u_t000_012/c2_r0_rbl u_t000_012/c2_r1_rbl u_t000_012/c3_w0_bl u_t000_012/c3_w0_br
+ u_t000_012/c3_w1_bl u_t000_012/c3_w1_br u_t000_012/c3_r0_rbl u_t000_012/c3_r1_rbl
+ u_t000_012/r0_w0_wl u_t000_012/r0_w1_wl u_t000_012/r0_r0_rwl u_t000_012/r0_r1_rwl
+ u_t000_012/r1_w0_wl u_t000_012/r1_w1_wl u_t000_012/r1_r0_rwl u_t000_012/r1_r1_rwl
+ u_t000_012/r2_w0_wl u_t000_012/r2_w1_wl u_t000_012/r2_r0_rwl u_t000_012/r2_r1_rwl
+ u_t000_012/r3_w0_wl u_t000_012/r3_w1_wl u_t000_012/r3_r0_rwl u_t000_012/r3_r1_rwl
+ u_t000_012/VDD u_t000_015/VSS VSUBS detronyx_12t_2w2r_rc4_4x4_routed_5layer_direct
Xgf180mcu_as_sc_mcu7t3v3__inv_2_760 gf180mcu_as_sc_mcu7t3v3__inv_2_761/VDD VSS gf180mcu_as_sc_mcu7t3v3__inv_2_760/Y
+ gf180mcu_as_sc_mcu7t3v3__inv_2_761/Y gf180mcu_as_sc_mcu7t3v3__inv_2_761/VNW VSUBS
+ gf180mcu_as_sc_mcu7t3v3__inv_2
Xgf180mcu_as_sc_mcu7t3v3__inv_2_793 gf180mcu_as_sc_mcu7t3v3__inv_2_794/VDD gf180mcu_as_sc_mcu7t3v3__inv_2_797/VDD
+ VSS VSS gf180mcu_as_sc_mcu7t3v3__inv_2_794/VNW VSUBS gf180mcu_as_sc_mcu7t3v3__inv_2
Xgf180mcu_as_sc_mcu7t3v3__inv_2_782 gf180mcu_as_sc_mcu7t3v3__inv_2_782/VDD gf180mcu_as_sc_mcu7t3v3__inv_2_785/VDD
+ gf180mcu_as_sc_mcu7t3v3__inv_2_782/Y VSS gf180mcu_as_sc_mcu7t3v3__inv_2_782/VNW
+ VSUBS gf180mcu_as_sc_mcu7t3v3__inv_2
Xgf180mcu_as_sc_mcu7t3v3__inv_2_771 VSS gf180mcu_as_sc_mcu7t3v3__inv_2_776/VDD VSS
+ gf180mcu_as_sc_mcu7t3v3__inv_2_776/Y gf180mcu_as_sc_mcu7t3v3__inv_2_773/VNW VSUBS
+ gf180mcu_as_sc_mcu7t3v3__inv_2
Xgf180mcu_as_sc_mcu7t3v3__inv_2_590 VSS VSS gf180mcu_as_sc_mcu7t3v3__inv_2_590/Y gf180mcu_as_sc_mcu7t3v3__inv_2_591/Y
+ gf180mcu_as_sc_mcu7t3v3__inv_2_591/VNW VSUBS gf180mcu_as_sc_mcu7t3v3__inv_2
Xgf180mcu_as_sc_mcu7t3v3__nor2_2_5 gf180mcu_as_sc_mcu7t3v3__nor2_2_5/VDD gf180mcu_as_sc_mcu7t3v3__nor2_2_5/VSS
+ VSS VSS VSS gf180mcu_as_sc_mcu7t3v3__nor2_2_5/VNW VSUBS gf180mcu_as_sc_mcu7t3v3__nor2_2
Xgf180mcu_as_sc_mcu7t3v3__nand4_2_19 VSS VSS VSS VSS VSS VSS VSS gf180mcu_as_sc_mcu7t3v3__inv_2_59/VNW
+ VSUBS gf180mcu_as_sc_mcu7t3v3__nand4_2
Xgf180mcu_as_sc_mcu7t3v3__nand3_2_30 gf180mcu_as_sc_mcu7t3v3__nor2_2_8/VDD gf180mcu_as_sc_mcu7t3v3__inv_2_710/VSS
+ VSS VSS VSS VSS gf180mcu_as_sc_mcu7t3v3__nor2_2_8/VNW VSUBS gf180mcu_as_sc_mcu7t3v3__nand3_2
Xu_t007_007 u_t007_007/c0_w0_bl u_t007_007/c0_w0_br u_t007_007/c0_w1_bl u_t007_007/c0_w1_br
+ u_t007_007/c0_r0_rbl u_t007_007/c0_r1_rbl u_t007_007/c1_w0_bl u_t007_007/c1_w0_br
+ u_t007_007/c1_w1_bl u_t007_007/c1_w1_br u_t007_007/c1_r0_rbl u_t007_007/c1_r1_rbl
+ u_t007_007/c2_w0_bl u_t007_007/c2_w0_br u_t007_007/c2_w1_bl u_t007_007/c2_w1_br
+ u_t007_007/c2_r0_rbl u_t007_007/c2_r1_rbl u_t007_007/c3_w0_bl u_t007_007/c3_w0_br
+ u_t007_007/c3_w1_bl u_t007_007/c3_w1_br u_t007_007/c3_r0_rbl u_t007_007/c3_r1_rbl
+ u_t007_007/r0_w0_wl u_t007_007/r0_w1_wl u_t007_007/r0_r0_rwl u_t007_007/r0_r1_rwl
+ u_t007_007/r1_w0_wl u_t007_007/r1_w1_wl u_t007_007/r1_r0_rwl u_t007_007/r1_r1_rwl
+ u_t007_007/r2_w0_wl u_t007_007/r2_w1_wl u_t007_007/r2_r0_rwl u_t007_007/r2_r1_rwl
+ u_t007_007/r3_w0_wl u_t007_007/r3_w1_wl u_t007_007/r3_r0_rwl u_t007_007/r3_r1_rwl
+ VSS u_t007_009/VSS VSUBS detronyx_12t_2w2r_rc4_4x4_routed_5layer_direct
Xgf180mcu_as_sc_mcu7t3v3__inv_2_1 gf180mcu_as_sc_mcu7t3v3__inv_2_9/VDD gf180mcu_as_sc_mcu7t3v3__inv_2_9/VSS
+ gf180mcu_as_sc_mcu7t3v3__inv_2_1/Y gf180mcu_as_sc_mcu7t3v3__inv_2_9/A gf180mcu_as_sc_mcu7t3v3__inv_2_9/VNW
+ VSUBS gf180mcu_as_sc_mcu7t3v3__inv_2
Xgf180mcu_as_sc_mcu7t3v3__inv_2_419 VSS VSS VSS VSS gf180mcu_as_sc_mcu7t3v3__inv_2_419/VNW
+ VSUBS gf180mcu_as_sc_mcu7t3v3__inv_2
Xgf180mcu_as_sc_mcu7t3v3__inv_2_408 VSS VSS VSS VSS gf180mcu_as_sc_mcu7t3v3__inv_2_410/VNW
+ VSUBS gf180mcu_as_sc_mcu7t3v3__inv_2
Xu_t012_010 u_t012_010/c0_w0_bl u_t012_010/c0_w0_br u_t012_010/c0_w1_bl u_t012_010/c0_w1_br
+ u_t012_010/c0_r0_rbl u_t012_010/c0_r1_rbl u_t012_010/c1_w0_bl u_t012_010/c1_w0_br
+ u_t012_010/c1_w1_bl u_t012_010/c1_w1_br u_t012_010/c1_r0_rbl u_t012_010/c1_r1_rbl
+ u_t012_010/c2_w0_bl u_t012_010/c2_w0_br u_t012_010/c2_w1_bl u_t012_010/c2_w1_br
+ u_t012_010/c2_r0_rbl u_t012_010/c2_r1_rbl u_t012_010/c3_w0_bl u_t012_010/c3_w0_br
+ u_t012_010/c3_w1_bl u_t012_010/c3_w1_br u_t012_010/c3_r0_rbl u_t012_010/c3_r1_rbl
+ u_t012_010/r0_w0_wl u_t012_010/r0_w1_wl u_t012_010/r0_r0_rwl u_t012_010/r0_r1_rwl
+ u_t012_010/r1_w0_wl u_t012_010/r1_w1_wl u_t012_010/r1_r0_rwl u_t012_010/r1_r1_rwl
+ u_t012_010/r2_w0_wl u_t012_010/r2_w1_wl u_t012_010/r2_r0_rwl u_t012_010/r2_r1_rwl
+ u_t012_010/r3_w0_wl u_t012_010/r3_w1_wl u_t012_010/r3_r0_rwl u_t012_010/r3_r1_rwl
+ VSS u_t012_015/VSS VSUBS detronyx_12t_2w2r_rc4_4x4_routed_5layer_direct
Xgf180mcu_as_sc_mcu7t3v3__inv_2_931 gf180mcu_as_sc_mcu7t3v3__inv_2_932/VDD gf180mcu_as_sc_mcu7t3v3__inv_2_932/VSS
+ gf180mcu_as_sc_mcu7t3v3__inv_2_931/Y gf180mcu_as_sc_mcu7t3v3__inv_2_932/Y gf180mcu_as_sc_mcu7t3v3__inv_2_932/VNW
+ VSUBS gf180mcu_as_sc_mcu7t3v3__inv_2
Xgf180mcu_as_sc_mcu7t3v3__inv_2_920 gf180mcu_as_sc_mcu7t3v3__inv_2_920/VDD VSS gf180mcu_as_sc_mcu7t3v3__inv_2_920/Y
+ VSS gf180mcu_as_sc_mcu7t3v3__inv_2_920/VNW VSUBS gf180mcu_as_sc_mcu7t3v3__inv_2
Xu_t003_010 u_t003_010/c0_w0_bl u_t003_010/c0_w0_br u_t003_010/c0_w1_bl u_t003_010/c0_w1_br
+ u_t003_010/c0_r0_rbl u_t003_010/c0_r1_rbl u_t003_010/c1_w0_bl u_t003_010/c1_w0_br
+ u_t003_010/c1_w1_bl u_t003_010/c1_w1_br u_t003_010/c1_r0_rbl u_t003_010/c1_r1_rbl
+ u_t003_010/c2_w0_bl u_t003_010/c2_w0_br u_t003_010/c2_w1_bl u_t003_010/c2_w1_br
+ u_t003_010/c2_r0_rbl u_t003_010/c2_r1_rbl u_t003_010/c3_w0_bl u_t003_010/c3_w0_br
+ u_t003_010/c3_w1_bl u_t003_010/c3_w1_br u_t003_010/c3_r0_rbl u_t003_010/c3_r1_rbl
+ u_t003_010/r0_w0_wl u_t003_010/r0_w1_wl u_t003_010/r0_r0_rwl u_t003_010/r0_r1_rwl
+ u_t003_010/r1_w0_wl u_t003_010/r1_w1_wl u_t003_010/r1_r0_rwl u_t003_010/r1_r1_rwl
+ u_t003_010/r2_w0_wl u_t003_010/r2_w1_wl u_t003_010/r2_r0_rwl u_t003_010/r2_r1_rwl
+ u_t003_010/r3_w0_wl u_t003_010/r3_w1_wl u_t003_010/r3_r0_rwl u_t003_010/r3_r1_rwl
+ VSS u_t003_010/VSS VSUBS detronyx_12t_2w2r_rc4_4x4_routed_5layer_direct
Xgf180mcu_as_sc_mcu7t3v3__nand4_2_252 gf180mcu_as_sc_mcu7t3v3__inv_2_920/VDD VSS VSS
+ VSS VSS VSS gf180mcu_as_sc_mcu7t3v3__nand4_2_252/Y gf180mcu_as_sc_mcu7t3v3__inv_2_920/VNW
+ VSUBS gf180mcu_as_sc_mcu7t3v3__nand4_2
Xgf180mcu_as_sc_mcu7t3v3__nand4_2_230 gf180mcu_as_sc_mcu7t3v3__inv_2_848/VDD gf180mcu_as_sc_mcu7t3v3__inv_2_854/VDD
+ VSS VSS VSS VSS gf180mcu_as_sc_mcu7t3v3__nand4_2_230/Y gf180mcu_as_sc_mcu7t3v3__inv_2_848/VNW
+ VSUBS gf180mcu_as_sc_mcu7t3v3__nand4_2
Xgf180mcu_as_sc_mcu7t3v3__nand4_2_241 gf180mcu_as_sc_mcu7t3v3__inv_2_884/VDD gf180mcu_as_sc_mcu7t3v3__inv_2_884/VDD
+ VSS VSS VSS VSS VSS gf180mcu_as_sc_mcu7t3v3__inv_2_881/VNW VSUBS gf180mcu_as_sc_mcu7t3v3__nand4_2
Xgf180mcu_as_sc_mcu7t3v3__inv_2_216 VSS VSS VSS VSS gf180mcu_as_sc_mcu7t3v3__inv_2_218/VNW
+ VSUBS gf180mcu_as_sc_mcu7t3v3__inv_2
Xgf180mcu_as_sc_mcu7t3v3__inv_2_227 gf180mcu_as_sc_mcu7t3v3__nor2_2_4/VDD gf180mcu_as_sc_mcu7t3v3__nand3_2_8/VSS
+ VSS VSS gf180mcu_as_sc_mcu7t3v3__nor2_2_4/VNW VSUBS gf180mcu_as_sc_mcu7t3v3__inv_2
Xgf180mcu_as_sc_mcu7t3v3__inv_2_238 gf180mcu_as_sc_mcu7t3v3__nor2_2_5/VDD gf180mcu_as_sc_mcu7t3v3__nand3_2_8/VSS
+ VSS VSS gf180mcu_as_sc_mcu7t3v3__nor2_2_5/VNW VSUBS gf180mcu_as_sc_mcu7t3v3__inv_2
Xgf180mcu_as_sc_mcu7t3v3__inv_2_249 gf180mcu_as_sc_mcu7t3v3__nand2_2_9/VDD gf180mcu_as_sc_mcu7t3v3__nor2_2_4/VSS
+ VSS VSS gf180mcu_as_sc_mcu7t3v3__nand2_2_9/VNW VSUBS gf180mcu_as_sc_mcu7t3v3__inv_2
Xgf180mcu_as_sc_mcu7t3v3__inv_2_205 gf180mcu_as_sc_mcu7t3v3__nand2_2_9/VDD gf180mcu_as_sc_mcu7t3v3__nor2_2_4/VSS
+ VSS VSS gf180mcu_as_sc_mcu7t3v3__nand2_2_9/VNW VSUBS gf180mcu_as_sc_mcu7t3v3__inv_2
Xu_t000_002 u_t000_002/c0_w0_bl u_t000_002/c0_w0_br u_t000_002/c0_w1_bl u_t000_002/c0_w1_br
+ u_t000_002/c0_r0_rbl u_t000_002/c0_r1_rbl u_t000_002/c1_w0_bl u_t000_002/c1_w0_br
+ u_t000_002/c1_w1_bl u_t000_002/c1_w1_br u_t000_002/c1_r0_rbl u_t000_002/c1_r1_rbl
+ u_t000_002/c2_w0_bl u_t000_002/c2_w0_br u_t000_002/c2_w1_bl u_t000_002/c2_w1_br
+ u_t000_002/c2_r0_rbl u_t000_002/c2_r1_rbl u_t000_002/c3_w0_bl u_t000_002/c3_w0_br
+ u_t000_002/c3_w1_bl u_t000_002/c3_w1_br u_t000_002/c3_r0_rbl u_t000_002/c3_r1_rbl
+ u_t000_002/r0_w0_wl u_t000_002/r0_w1_wl u_t000_002/r0_r0_rwl u_t000_002/r0_r1_rwl
+ u_t000_002/r1_w0_wl u_t000_002/r1_w1_wl u_t000_002/r1_r0_rwl u_t000_002/r1_r1_rwl
+ u_t000_002/r2_w0_wl u_t000_002/r2_w1_wl u_t000_002/r2_r0_rwl u_t000_002/r2_r1_rwl
+ u_t000_002/r3_w0_wl u_t000_002/r3_w1_wl u_t000_002/r3_r0_rwl u_t000_002/r3_r1_rwl
+ VSS u_t000_015/VSS VSUBS detronyx_12t_2w2r_rc4_4x4_routed_5layer_direct
Xu_t000_013 u_t000_013/c0_w0_bl u_t000_013/c0_w0_br u_t000_013/c0_w1_bl u_t000_013/c0_w1_br
+ u_t000_013/c0_r0_rbl u_t000_013/c0_r1_rbl u_t000_013/c1_w0_bl u_t000_013/c1_w0_br
+ u_t000_013/c1_w1_bl u_t000_013/c1_w1_br u_t000_013/c1_r0_rbl u_t000_013/c1_r1_rbl
+ u_t000_013/c2_w0_bl u_t000_013/c2_w0_br u_t000_013/c2_w1_bl u_t000_013/c2_w1_br
+ u_t000_013/c2_r0_rbl u_t000_013/c2_r1_rbl u_t000_013/c3_w0_bl u_t000_013/c3_w0_br
+ u_t000_013/c3_w1_bl u_t000_013/c3_w1_br u_t000_013/c3_r0_rbl u_t000_013/c3_r1_rbl
+ u_t000_013/r0_w0_wl u_t000_013/r0_w1_wl u_t000_013/r0_r0_rwl u_t000_013/r0_r1_rwl
+ u_t000_013/r1_w0_wl u_t000_013/r1_w1_wl u_t000_013/r1_r0_rwl u_t000_013/r1_r1_rwl
+ u_t000_013/r2_w0_wl u_t000_013/r2_w1_wl u_t000_013/r2_r0_rwl u_t000_013/r2_r1_rwl
+ u_t000_013/r3_w0_wl u_t000_013/r3_w1_wl u_t000_013/r3_r0_rwl u_t000_013/r3_r1_rwl
+ u_t000_013/VDD u_t000_015/VSS VSUBS detronyx_12t_2w2r_rc4_4x4_routed_5layer_direct
Xgf180mcu_as_sc_mcu7t3v3__inv_2_761 gf180mcu_as_sc_mcu7t3v3__inv_2_761/VDD VSS gf180mcu_as_sc_mcu7t3v3__inv_2_761/Y
+ VSS gf180mcu_as_sc_mcu7t3v3__inv_2_761/VNW VSUBS gf180mcu_as_sc_mcu7t3v3__inv_2
Xgf180mcu_as_sc_mcu7t3v3__inv_2_750 gf180mcu_as_sc_mcu7t3v3__inv_2_752/VDD VSS VSS
+ gf180mcu_as_sc_mcu7t3v3__inv_2_752/Y gf180mcu_as_sc_mcu7t3v3__inv_2_752/VNW VSUBS
+ gf180mcu_as_sc_mcu7t3v3__inv_2
Xgf180mcu_as_sc_mcu7t3v3__inv_2_794 gf180mcu_as_sc_mcu7t3v3__inv_2_794/VDD gf180mcu_as_sc_mcu7t3v3__inv_2_797/VDD
+ VSS VSS gf180mcu_as_sc_mcu7t3v3__inv_2_794/VNW VSUBS gf180mcu_as_sc_mcu7t3v3__inv_2
Xgf180mcu_as_sc_mcu7t3v3__inv_2_783 gf180mcu_as_sc_mcu7t3v3__inv_2_785/VDD gf180mcu_as_sc_mcu7t3v3__inv_2_788/VDD
+ gf180mcu_as_sc_mcu7t3v3__inv_2_783/Y VSS gf180mcu_as_sc_mcu7t3v3__inv_2_785/VNW
+ VSUBS gf180mcu_as_sc_mcu7t3v3__inv_2
Xgf180mcu_as_sc_mcu7t3v3__inv_2_772 VSS gf180mcu_as_sc_mcu7t3v3__inv_2_776/VDD gf180mcu_as_sc_mcu7t3v3__inv_2_772/Y
+ gf180mcu_as_sc_mcu7t3v3__inv_2_776/Y gf180mcu_as_sc_mcu7t3v3__inv_2_773/VNW VSUBS
+ gf180mcu_as_sc_mcu7t3v3__inv_2
Xgf180mcu_as_sc_mcu7t3v3__inv_2_591 VSS VSS gf180mcu_as_sc_mcu7t3v3__inv_2_591/Y VSS
+ gf180mcu_as_sc_mcu7t3v3__inv_2_591/VNW VSUBS gf180mcu_as_sc_mcu7t3v3__inv_2
Xgf180mcu_as_sc_mcu7t3v3__inv_2_580 VSS VSS gf180mcu_as_sc_mcu7t3v3__inv_2_580/Y gf180mcu_as_sc_mcu7t3v3__inv_2_580/A
+ gf180mcu_as_sc_mcu7t3v3__inv_2_582/VNW VSUBS gf180mcu_as_sc_mcu7t3v3__inv_2
Xgf180mcu_as_sc_mcu7t3v3__nor2_2_6 gf180mcu_as_sc_mcu7t3v3__nor2_2_6/VDD gf180mcu_as_sc_mcu7t3v3__nor2_2_6/VSS
+ VSS VSS VSS gf180mcu_as_sc_mcu7t3v3__nor2_2_6/VNW VSUBS gf180mcu_as_sc_mcu7t3v3__nor2_2
Xgf180mcu_as_sc_mcu7t3v3__nand3_2_20 gf180mcu_as_sc_mcu7t3v3__nor2_2_6/VDD gf180mcu_as_sc_mcu7t3v3__nor2_2_6/VSS
+ VSS VSS VSS VSS gf180mcu_as_sc_mcu7t3v3__nor2_2_6/VNW VSUBS gf180mcu_as_sc_mcu7t3v3__nand3_2
Xgf180mcu_as_sc_mcu7t3v3__nand3_2_31 gf180mcu_as_sc_mcu7t3v3__nor2_2_8/VDD gf180mcu_as_sc_mcu7t3v3__nor2_2_8/VSS
+ VSS VSS VSS VSS gf180mcu_as_sc_mcu7t3v3__nor2_2_8/VNW VSUBS gf180mcu_as_sc_mcu7t3v3__nand3_2
Xu_t007_008 u_t007_008/c0_w0_bl u_t007_008/c0_w0_br u_t007_008/c0_w1_bl u_t007_008/c0_w1_br
+ u_t007_008/c0_r0_rbl u_t007_008/c0_r1_rbl u_t007_008/c1_w0_bl u_t007_008/c1_w0_br
+ u_t007_008/c1_w1_bl u_t007_008/c1_w1_br u_t007_008/c1_r0_rbl u_t007_008/c1_r1_rbl
+ u_t007_008/c2_w0_bl u_t007_008/c2_w0_br u_t007_008/c2_w1_bl u_t007_008/c2_w1_br
+ u_t007_008/c2_r0_rbl u_t007_008/c2_r1_rbl u_t007_008/c3_w0_bl u_t007_008/c3_w0_br
+ u_t007_008/c3_w1_bl u_t007_008/c3_w1_br u_t007_008/c3_r0_rbl u_t007_008/c3_r1_rbl
+ u_t007_008/r0_w0_wl u_t007_008/r0_w1_wl u_t007_008/r0_r0_rwl u_t007_008/r0_r1_rwl
+ u_t007_008/r1_w0_wl u_t007_008/r1_w1_wl u_t007_008/r1_r0_rwl u_t007_008/r1_r1_rwl
+ u_t007_008/r2_w0_wl u_t007_008/r2_w1_wl u_t007_008/r2_r0_rwl u_t007_008/r2_r1_rwl
+ u_t007_008/r3_w0_wl u_t007_008/r3_w1_wl u_t007_008/r3_r0_rwl u_t007_008/r3_r1_rwl
+ VSS u_t007_009/VSS VSUBS detronyx_12t_2w2r_rc4_4x4_routed_5layer_direct
Xgf180mcu_as_sc_mcu7t3v3__inv_2_2 gf180mcu_as_sc_mcu7t3v3__inv_2_9/VDD gf180mcu_as_sc_mcu7t3v3__inv_2_9/VSS
+ gf180mcu_as_sc_mcu7t3v3__inv_2_9/A VSS gf180mcu_as_sc_mcu7t3v3__inv_2_9/VNW VSUBS
+ gf180mcu_as_sc_mcu7t3v3__inv_2
Xgf180mcu_as_sc_mcu7t3v3__inv_2_409 VSS VSS VSS VSS gf180mcu_as_sc_mcu7t3v3__inv_2_410/VNW
+ VSUBS gf180mcu_as_sc_mcu7t3v3__inv_2
Xu_t012_000 u_t012_000/c0_w0_bl u_t012_000/c0_w0_br u_t012_000/c0_w1_bl u_t012_000/c0_w1_br
+ u_t012_000/c0_r0_rbl u_t012_000/c0_r1_rbl u_t012_000/c1_w0_bl u_t012_000/c1_w0_br
+ u_t012_000/c1_w1_bl u_t012_000/c1_w1_br u_t012_000/c1_r0_rbl u_t012_000/c1_r1_rbl
+ u_t012_000/c2_w0_bl u_t012_000/c2_w0_br u_t012_000/c2_w1_bl u_t012_000/c2_w1_br
+ u_t012_000/c2_r0_rbl u_t012_000/c2_r1_rbl u_t012_000/c3_w0_bl u_t012_000/c3_w0_br
+ u_t012_000/c3_w1_bl u_t012_000/c3_w1_br u_t012_000/c3_r0_rbl u_t012_000/c3_r1_rbl
+ u_t012_000/r0_w0_wl u_t012_000/r0_w1_wl u_t012_000/r0_r0_rwl u_t012_000/r0_r1_rwl
+ u_t012_000/r1_w0_wl u_t012_000/r1_w1_wl u_t012_000/r1_r0_rwl u_t012_000/r1_r1_rwl
+ u_t012_000/r2_w0_wl u_t012_000/r2_w1_wl u_t012_000/r2_r0_rwl u_t012_000/r2_r1_rwl
+ u_t012_000/r3_w0_wl u_t012_000/r3_w1_wl u_t012_000/r3_r0_rwl u_t012_000/r3_r1_rwl
+ VSS u_t012_015/VSS VSUBS detronyx_12t_2w2r_rc4_4x4_routed_5layer_direct
Xu_t012_011 u_t012_011/c0_w0_bl u_t012_011/c0_w0_br u_t012_011/c0_w1_bl u_t012_011/c0_w1_br
+ u_t012_011/c0_r0_rbl u_t012_011/c0_r1_rbl u_t012_011/c1_w0_bl u_t012_011/c1_w0_br
+ u_t012_011/c1_w1_bl u_t012_011/c1_w1_br u_t012_011/c1_r0_rbl u_t012_011/c1_r1_rbl
+ u_t012_011/c2_w0_bl u_t012_011/c2_w0_br u_t012_011/c2_w1_bl u_t012_011/c2_w1_br
+ u_t012_011/c2_r0_rbl u_t012_011/c2_r1_rbl u_t012_011/c3_w0_bl u_t012_011/c3_w0_br
+ u_t012_011/c3_w1_bl u_t012_011/c3_w1_br u_t012_011/c3_r0_rbl u_t012_011/c3_r1_rbl
+ u_t012_011/r0_w0_wl u_t012_011/r0_w1_wl u_t012_011/r0_r0_rwl u_t012_011/r0_r1_rwl
+ u_t012_011/r1_w0_wl u_t012_011/r1_w1_wl u_t012_011/r1_r0_rwl u_t012_011/r1_r1_rwl
+ u_t012_011/r2_w0_wl u_t012_011/r2_w1_wl u_t012_011/r2_r0_rwl u_t012_011/r2_r1_rwl
+ u_t012_011/r3_w0_wl u_t012_011/r3_w1_wl u_t012_011/r3_r0_rwl u_t012_011/r3_r1_rwl
+ u_t012_011/VDD u_t012_015/VSS VSUBS detronyx_12t_2w2r_rc4_4x4_routed_5layer_direct
Xgf180mcu_as_sc_mcu7t3v3__inv_2_932 gf180mcu_as_sc_mcu7t3v3__inv_2_932/VDD gf180mcu_as_sc_mcu7t3v3__inv_2_932/VSS
+ gf180mcu_as_sc_mcu7t3v3__inv_2_932/Y VSS gf180mcu_as_sc_mcu7t3v3__inv_2_932/VNW
+ VSUBS gf180mcu_as_sc_mcu7t3v3__inv_2
Xgf180mcu_as_sc_mcu7t3v3__inv_2_921 gf180mcu_as_sc_mcu7t3v3__inv_2_923/VDD gf180mcu_as_sc_mcu7t3v3__inv_2_923/VSS
+ VSS gf180mcu_as_sc_mcu7t3v3__inv_2_923/Y gf180mcu_as_sc_mcu7t3v3__inv_2_923/VNW
+ VSUBS gf180mcu_as_sc_mcu7t3v3__inv_2
Xgf180mcu_as_sc_mcu7t3v3__inv_2_910 VSS gf180mcu_as_sc_mcu7t3v3__inv_2_914/VDD gf180mcu_as_sc_mcu7t3v3__inv_2_917/Y
+ gf180mcu_as_sc_mcu7t3v3__inv_2_917/Y gf180mcu_as_sc_mcu7t3v3__inv_2_911/VNW VSUBS
+ gf180mcu_as_sc_mcu7t3v3__inv_2
Xu_t003_000 u_t003_000/c0_w0_bl u_t003_000/c0_w0_br u_t003_000/c0_w1_bl u_t003_000/c0_w1_br
+ u_t003_000/c0_r0_rbl u_t003_000/c0_r1_rbl u_t003_000/c1_w0_bl u_t003_000/c1_w0_br
+ u_t003_000/c1_w1_bl u_t003_000/c1_w1_br u_t003_000/c1_r0_rbl u_t003_000/c1_r1_rbl
+ u_t003_000/c2_w0_bl u_t003_000/c2_w0_br u_t003_000/c2_w1_bl u_t003_000/c2_w1_br
+ u_t003_000/c2_r0_rbl u_t003_000/c2_r1_rbl u_t003_000/c3_w0_bl u_t003_000/c3_w0_br
+ u_t003_000/c3_w1_bl u_t003_000/c3_w1_br u_t003_000/c3_r0_rbl u_t003_000/c3_r1_rbl
+ u_t003_000/r0_w0_wl u_t003_000/r0_w1_wl u_t003_000/r0_r0_rwl u_t003_000/r0_r1_rwl
+ u_t003_000/r1_w0_wl u_t003_000/r1_w1_wl u_t003_000/r1_r0_rwl u_t003_000/r1_r1_rwl
+ u_t003_000/r2_w0_wl u_t003_000/r2_w1_wl u_t003_000/r2_r0_rwl u_t003_000/r2_r1_rwl
+ u_t003_000/r3_w0_wl u_t003_000/r3_w1_wl u_t003_000/r3_r0_rwl u_t003_000/r3_r1_rwl
+ VSS u_t003_002/VSS VSUBS detronyx_12t_2w2r_rc4_4x4_routed_5layer_direct
Xu_t003_011 u_t003_011/c0_w0_bl u_t003_011/c0_w0_br u_t003_011/c0_w1_bl u_t003_011/c0_w1_br
+ u_t003_011/c0_r0_rbl u_t003_011/c0_r1_rbl u_t003_011/c1_w0_bl u_t003_011/c1_w0_br
+ u_t003_011/c1_w1_bl u_t003_011/c1_w1_br u_t003_011/c1_r0_rbl u_t003_011/c1_r1_rbl
+ u_t003_011/c2_w0_bl u_t003_011/c2_w0_br u_t003_011/c2_w1_bl u_t003_011/c2_w1_br
+ u_t003_011/c2_r0_rbl u_t003_011/c2_r1_rbl u_t003_011/c3_w0_bl u_t003_011/c3_w0_br
+ u_t003_011/c3_w1_bl u_t003_011/c3_w1_br u_t003_011/c3_r0_rbl u_t003_011/c3_r1_rbl
+ u_t003_011/r0_w0_wl u_t003_011/r0_w1_wl u_t003_011/r0_r0_rwl u_t003_011/r0_r1_rwl
+ u_t003_011/r1_w0_wl u_t003_011/r1_w1_wl u_t003_011/r1_r0_rwl u_t003_011/r1_r1_rwl
+ u_t003_011/r2_w0_wl u_t003_011/r2_w1_wl u_t003_011/r2_r0_rwl u_t003_011/r2_r1_rwl
+ u_t003_011/r3_w0_wl u_t003_011/r3_w1_wl u_t003_011/r3_r0_rwl u_t003_011/r3_r1_rwl
+ u_t004_011/VDD u_t003_011/VSS VSUBS detronyx_12t_2w2r_rc4_4x4_routed_5layer_direct
Xgf180mcu_as_sc_mcu7t3v3__nand4_2_220 VSS VSS VSS VSS VSS VSS VSS gf180mcu_as_sc_mcu7t3v3__inv_2_818/VNW
+ VSUBS gf180mcu_as_sc_mcu7t3v3__nand4_2
Xgf180mcu_as_sc_mcu7t3v3__nand4_2_253 gf180mcu_as_sc_mcu7t3v3__inv_2_917/VDD VSS VSS
+ VSS VSS VSS VSS gf180mcu_as_sc_mcu7t3v3__inv_2_917/VNW VSUBS gf180mcu_as_sc_mcu7t3v3__nand4_2
Xgf180mcu_as_sc_mcu7t3v3__nand4_2_231 gf180mcu_as_sc_mcu7t3v3__inv_2_854/VDD gf180mcu_as_sc_mcu7t3v3__inv_2_854/VDD
+ VSS VSS VSS VSS VSS gf180mcu_as_sc_mcu7t3v3__inv_2_851/VNW VSUBS gf180mcu_as_sc_mcu7t3v3__nand4_2
Xgf180mcu_as_sc_mcu7t3v3__nand4_2_242 gf180mcu_as_sc_mcu7t3v3__inv_2_884/VDD gf180mcu_as_sc_mcu7t3v3__inv_2_887/VDD
+ VSS VSS VSS VSS VSS gf180mcu_as_sc_mcu7t3v3__inv_2_884/VNW VSUBS gf180mcu_as_sc_mcu7t3v3__nand4_2
Xgf180mcu_as_sc_mcu7t3v3__inv_2_217 VSS VSS VSS VSS gf180mcu_as_sc_mcu7t3v3__inv_2_218/VNW
+ VSUBS gf180mcu_as_sc_mcu7t3v3__inv_2
Xgf180mcu_as_sc_mcu7t3v3__inv_2_228 gf180mcu_as_sc_mcu7t3v3__nor2_2_4/VDD gf180mcu_as_sc_mcu7t3v3__nand3_2_8/VSS
+ VSS VSS gf180mcu_as_sc_mcu7t3v3__nor2_2_4/VNW VSUBS gf180mcu_as_sc_mcu7t3v3__inv_2
Xgf180mcu_as_sc_mcu7t3v3__inv_2_239 gf180mcu_as_sc_mcu7t3v3__nor2_2_4/VDD gf180mcu_as_sc_mcu7t3v3__nand3_2_8/VSS
+ VSS VSS gf180mcu_as_sc_mcu7t3v3__nor2_2_4/VNW VSUBS gf180mcu_as_sc_mcu7t3v3__inv_2
Xgf180mcu_as_sc_mcu7t3v3__inv_2_206 gf180mcu_as_sc_mcu7t3v3__nand2_2_9/VDD gf180mcu_as_sc_mcu7t3v3__nor2_2_6/VSS
+ VSS VSS gf180mcu_as_sc_mcu7t3v3__nand2_2_9/VNW VSUBS gf180mcu_as_sc_mcu7t3v3__inv_2
Xu_t000_003 u_t000_003/c0_w0_bl u_t000_003/c0_w0_br u_t000_003/c0_w1_bl u_t000_003/c0_w1_br
+ u_t000_003/c0_r0_rbl u_t000_003/c0_r1_rbl u_t000_003/c1_w0_bl u_t000_003/c1_w0_br
+ u_t000_003/c1_w1_bl u_t000_003/c1_w1_br u_t000_003/c1_r0_rbl u_t000_003/c1_r1_rbl
+ u_t000_003/c2_w0_bl u_t000_003/c2_w0_br u_t000_003/c2_w1_bl u_t000_003/c2_w1_br
+ u_t000_003/c2_r0_rbl u_t000_003/c2_r1_rbl u_t000_003/c3_w0_bl u_t000_003/c3_w0_br
+ u_t000_003/c3_w1_bl u_t000_003/c3_w1_br u_t000_003/c3_r0_rbl u_t000_003/c3_r1_rbl
+ u_t000_003/r0_w0_wl u_t000_003/r0_w1_wl u_t000_003/r0_r0_rwl u_t000_003/r0_r1_rwl
+ u_t000_003/r1_w0_wl u_t000_003/r1_w1_wl u_t000_003/r1_r0_rwl u_t000_003/r1_r1_rwl
+ u_t000_003/r2_w0_wl u_t000_003/r2_w1_wl u_t000_003/r2_r0_rwl u_t000_003/r2_r1_rwl
+ u_t000_003/r3_w0_wl u_t000_003/r3_w1_wl u_t000_003/r3_r0_rwl u_t000_003/r3_r1_rwl
+ u_t000_003/VDD u_t000_015/VSS VSUBS detronyx_12t_2w2r_rc4_4x4_routed_5layer_direct
Xu_t000_014 u_t000_014/c0_w0_bl u_t000_014/c0_w0_br u_t000_014/c0_w1_bl u_t000_014/c0_w1_br
+ u_t000_014/c0_r0_rbl u_t000_014/c0_r1_rbl u_t000_014/c1_w0_bl u_t000_014/c1_w0_br
+ u_t000_014/c1_w1_bl u_t000_014/c1_w1_br u_t000_014/c1_r0_rbl u_t000_014/c1_r1_rbl
+ u_t000_014/c2_w0_bl u_t000_014/c2_w0_br u_t000_014/c2_w1_bl u_t000_014/c2_w1_br
+ u_t000_014/c2_r0_rbl u_t000_014/c2_r1_rbl u_t000_014/c3_w0_bl u_t000_014/c3_w0_br
+ u_t000_014/c3_w1_bl u_t000_014/c3_w1_br u_t000_014/c3_r0_rbl u_t000_014/c3_r1_rbl
+ u_t000_014/r0_w0_wl u_t000_014/r0_w1_wl u_t000_014/r0_r0_rwl u_t000_014/r0_r1_rwl
+ u_t000_014/r1_w0_wl u_t000_014/r1_w1_wl u_t000_014/r1_r0_rwl u_t000_014/r1_r1_rwl
+ u_t000_014/r2_w0_wl u_t000_014/r2_w1_wl u_t000_014/r2_r0_rwl u_t000_014/r2_r1_rwl
+ u_t000_014/r3_w0_wl u_t000_014/r3_w1_wl u_t000_014/r3_r0_rwl u_t000_014/r3_r1_rwl
+ u_t000_014/VDD u_t000_015/VSS VSUBS detronyx_12t_2w2r_rc4_4x4_routed_5layer_direct
Xgf180mcu_as_sc_mcu7t3v3__inv_2_762 VSS VSS VSS gf180mcu_as_sc_mcu7t3v3__inv_2_923/Y
+ gf180mcu_as_sc_mcu7t3v3__inv_2_764/VNW VSUBS gf180mcu_as_sc_mcu7t3v3__inv_2
Xgf180mcu_as_sc_mcu7t3v3__inv_2_751 gf180mcu_as_sc_mcu7t3v3__inv_2_752/VDD VSS gf180mcu_as_sc_mcu7t3v3__inv_2_751/Y
+ gf180mcu_as_sc_mcu7t3v3__inv_2_752/Y gf180mcu_as_sc_mcu7t3v3__inv_2_752/VNW VSUBS
+ gf180mcu_as_sc_mcu7t3v3__inv_2
Xgf180mcu_as_sc_mcu7t3v3__inv_2_795 gf180mcu_as_sc_mcu7t3v3__inv_2_797/VDD gf180mcu_as_sc_mcu7t3v3__inv_2_800/VDD
+ gf180mcu_as_sc_mcu7t3v3__inv_2_795/Y VSS gf180mcu_as_sc_mcu7t3v3__inv_2_797/VNW
+ VSUBS gf180mcu_as_sc_mcu7t3v3__inv_2
Xgf180mcu_as_sc_mcu7t3v3__inv_2_740 gf180mcu_as_sc_mcu7t3v3__inv_2_740/VDD gf180mcu_as_sc_mcu7t3v3__inv_2_743/VDD
+ gf180mcu_as_sc_mcu7t3v3__inv_2_743/Y VSS gf180mcu_as_sc_mcu7t3v3__inv_2_740/VNW
+ VSUBS gf180mcu_as_sc_mcu7t3v3__inv_2
Xgf180mcu_as_sc_mcu7t3v3__inv_2_784 gf180mcu_as_sc_mcu7t3v3__inv_2_785/VDD gf180mcu_as_sc_mcu7t3v3__inv_2_788/VDD
+ VSS VSS gf180mcu_as_sc_mcu7t3v3__inv_2_785/VNW VSUBS gf180mcu_as_sc_mcu7t3v3__inv_2
Xgf180mcu_as_sc_mcu7t3v3__inv_2_773 VSS gf180mcu_as_sc_mcu7t3v3__inv_2_776/VDD gf180mcu_as_sc_mcu7t3v3__inv_2_776/Y
+ VSS gf180mcu_as_sc_mcu7t3v3__inv_2_773/VNW VSUBS gf180mcu_as_sc_mcu7t3v3__inv_2
Xgf180mcu_as_sc_mcu7t3v3__inv_2_570 VSS gf180mcu_as_sc_mcu7t3v3__inv_2_932/VDD gf180mcu_as_sc_mcu7t3v3__inv_2_570/Y
+ VSS gf180mcu_as_sc_mcu7t3v3__inv_2_570/VNW VSUBS gf180mcu_as_sc_mcu7t3v3__inv_2
Xgf180mcu_as_sc_mcu7t3v3__inv_2_581 VSS VSS gf180mcu_as_sc_mcu7t3v3__inv_2_581/Y gf180mcu_as_sc_mcu7t3v3__inv_2_582/Y
+ gf180mcu_as_sc_mcu7t3v3__inv_2_582/VNW VSUBS gf180mcu_as_sc_mcu7t3v3__inv_2
Xgf180mcu_as_sc_mcu7t3v3__inv_2_592 VSS VSS gf180mcu_as_sc_mcu7t3v3__inv_2_592/Y gf180mcu_as_sc_mcu7t3v3__inv_2_611/Y
+ gf180mcu_as_sc_mcu7t3v3__inv_2_594/VNW VSUBS gf180mcu_as_sc_mcu7t3v3__inv_2
Xgf180mcu_as_sc_mcu7t3v3__nor2_2_7 gf180mcu_as_sc_mcu7t3v3__nor2_2_8/VDD gf180mcu_as_sc_mcu7t3v3__nor2_2_8/VSS
+ VSS VSS VSS gf180mcu_as_sc_mcu7t3v3__nor2_2_8/VNW VSUBS gf180mcu_as_sc_mcu7t3v3__nor2_2
Xgf180mcu_as_sc_mcu7t3v3__nand3_2_21 gf180mcu_as_sc_mcu7t3v3__nor2_2_6/VDD gf180mcu_as_sc_mcu7t3v3__nand3_2_1/VSS
+ VSS VSS VSS VSS gf180mcu_as_sc_mcu7t3v3__nor2_2_6/VNW VSUBS gf180mcu_as_sc_mcu7t3v3__nand3_2
Xgf180mcu_as_sc_mcu7t3v3__nand3_2_10 gf180mcu_as_sc_mcu7t3v3__nand2_2_9/VDD gf180mcu_as_sc_mcu7t3v3__nor2_2_4/VSS
+ VSS VSS VSS VSS gf180mcu_as_sc_mcu7t3v3__nand2_2_9/VNW VSUBS gf180mcu_as_sc_mcu7t3v3__nand3_2
Xgf180mcu_as_sc_mcu7t3v3__nand3_2_32 gf180mcu_as_sc_mcu7t3v3__inv_2_713/VDD gf180mcu_as_sc_mcu7t3v3__nor2_2_8/VSS
+ VSS VSS VSS VSS gf180mcu_as_sc_mcu7t3v3__inv_2_713/VNW VSUBS gf180mcu_as_sc_mcu7t3v3__nand3_2
Xu_t007_009 u_t007_009/c0_w0_bl u_t007_009/c0_w0_br u_t007_009/c0_w1_bl u_t007_009/c0_w1_br
+ u_t007_009/c0_r0_rbl u_t007_009/c0_r1_rbl u_t007_009/c1_w0_bl u_t007_009/c1_w0_br
+ u_t007_009/c1_w1_bl u_t007_009/c1_w1_br u_t007_009/c1_r0_rbl u_t007_009/c1_r1_rbl
+ u_t007_009/c2_w0_bl u_t007_009/c2_w0_br u_t007_009/c2_w1_bl u_t007_009/c2_w1_br
+ u_t007_009/c2_r0_rbl u_t007_009/c2_r1_rbl u_t007_009/c3_w0_bl u_t007_009/c3_w0_br
+ u_t007_009/c3_w1_bl u_t007_009/c3_w1_br u_t007_009/c3_r0_rbl u_t007_009/c3_r1_rbl
+ u_t007_009/r0_w0_wl u_t007_009/r0_w1_wl u_t007_009/r0_r0_rwl u_t007_009/r0_r1_rwl
+ u_t007_009/r1_w0_wl u_t007_009/r1_w1_wl u_t007_009/r1_r0_rwl u_t007_009/r1_r1_rwl
+ u_t007_009/r2_w0_wl u_t007_009/r2_w1_wl u_t007_009/r2_r0_rwl u_t007_009/r2_r1_rwl
+ u_t007_009/r3_w0_wl u_t007_009/r3_w1_wl u_t007_009/r3_r0_rwl u_t007_009/r3_r1_rwl
+ VSS u_t007_009/VSS VSUBS detronyx_12t_2w2r_rc4_4x4_routed_5layer_direct
Xgf180mcu_as_sc_mcu7t3v3__inv_2_3 gf180mcu_as_sc_mcu7t3v3__inv_2_9/VSS gf180mcu_as_sc_mcu7t3v3__inv_2_8/VDD
+ VSS gf180mcu_as_sc_mcu7t3v3__inv_2_9/A gf180mcu_as_sc_mcu7t3v3__inv_2_5/VNW VSUBS
+ gf180mcu_as_sc_mcu7t3v3__inv_2
Xu_t012_012 u_t012_012/c0_w0_bl u_t012_012/c0_w0_br u_t012_012/c0_w1_bl u_t012_012/c0_w1_br
+ u_t012_012/c0_r0_rbl u_t012_012/c0_r1_rbl u_t012_012/c1_w0_bl u_t012_012/c1_w0_br
+ u_t012_012/c1_w1_bl u_t012_012/c1_w1_br u_t012_012/c1_r0_rbl u_t012_012/c1_r1_rbl
+ u_t012_012/c2_w0_bl u_t012_012/c2_w0_br u_t012_012/c2_w1_bl u_t012_012/c2_w1_br
+ u_t012_012/c2_r0_rbl u_t012_012/c2_r1_rbl u_t012_012/c3_w0_bl u_t012_012/c3_w0_br
+ u_t012_012/c3_w1_bl u_t012_012/c3_w1_br u_t012_012/c3_r0_rbl u_t012_012/c3_r1_rbl
+ u_t012_012/r0_w0_wl u_t012_012/r0_w1_wl u_t012_012/r0_r0_rwl u_t012_012/r0_r1_rwl
+ u_t012_012/r1_w0_wl u_t012_012/r1_w1_wl u_t012_012/r1_r0_rwl u_t012_012/r1_r1_rwl
+ u_t012_012/r2_w0_wl u_t012_012/r2_w1_wl u_t012_012/r2_r0_rwl u_t012_012/r2_r1_rwl
+ u_t012_012/r3_w0_wl u_t012_012/r3_w1_wl u_t012_012/r3_r0_rwl u_t012_012/r3_r1_rwl
+ u_t012_012/VDD u_t012_015/VSS VSUBS detronyx_12t_2w2r_rc4_4x4_routed_5layer_direct
Xu_t012_001 u_t012_001/c0_w0_bl u_t012_001/c0_w0_br u_t012_001/c0_w1_bl u_t012_001/c0_w1_br
+ u_t012_001/c0_r0_rbl u_t012_001/c0_r1_rbl u_t012_001/c1_w0_bl u_t012_001/c1_w0_br
+ u_t012_001/c1_w1_bl u_t012_001/c1_w1_br u_t012_001/c1_r0_rbl u_t012_001/c1_r1_rbl
+ u_t012_001/c2_w0_bl u_t012_001/c2_w0_br u_t012_001/c2_w1_bl u_t012_001/c2_w1_br
+ u_t012_001/c2_r0_rbl u_t012_001/c2_r1_rbl u_t012_001/c3_w0_bl u_t012_001/c3_w0_br
+ u_t012_001/c3_w1_bl u_t012_001/c3_w1_br u_t012_001/c3_r0_rbl u_t012_001/c3_r1_rbl
+ u_t012_001/r0_w0_wl u_t012_001/r0_w1_wl u_t012_001/r0_r0_rwl u_t012_001/r0_r1_rwl
+ u_t012_001/r1_w0_wl u_t012_001/r1_w1_wl u_t012_001/r1_r0_rwl u_t012_001/r1_r1_rwl
+ u_t012_001/r2_w0_wl u_t012_001/r2_w1_wl u_t012_001/r2_r0_rwl u_t012_001/r2_r1_rwl
+ u_t012_001/r3_w0_wl u_t012_001/r3_w1_wl u_t012_001/r3_r0_rwl u_t012_001/r3_r1_rwl
+ VSS u_t012_015/VSS VSUBS detronyx_12t_2w2r_rc4_4x4_routed_5layer_direct
Xgf180mcu_as_sc_mcu7t3v3__inv_2_922 gf180mcu_as_sc_mcu7t3v3__inv_2_923/VDD gf180mcu_as_sc_mcu7t3v3__inv_2_923/VSS
+ gf180mcu_as_sc_mcu7t3v3__inv_2_922/Y gf180mcu_as_sc_mcu7t3v3__inv_2_923/Y gf180mcu_as_sc_mcu7t3v3__inv_2_923/VNW
+ VSUBS gf180mcu_as_sc_mcu7t3v3__inv_2
Xgf180mcu_as_sc_mcu7t3v3__inv_2_911 VSS gf180mcu_as_sc_mcu7t3v3__inv_2_914/VDD gf180mcu_as_sc_mcu7t3v3__inv_2_917/Y
+ VSS gf180mcu_as_sc_mcu7t3v3__inv_2_911/VNW VSUBS gf180mcu_as_sc_mcu7t3v3__inv_2
Xgf180mcu_as_sc_mcu7t3v3__inv_2_900 gf180mcu_as_sc_mcu7t3v3__inv_2_902/VDD gf180mcu_as_sc_mcu7t3v3__inv_2_905/VDD
+ VSS gf180mcu_as_sc_mcu7t3v3__inv_2_908/Y gf180mcu_as_sc_mcu7t3v3__inv_2_902/VNW
+ VSUBS gf180mcu_as_sc_mcu7t3v3__inv_2
Xu_t003_001 u_t003_001/c0_w0_bl u_t003_001/c0_w0_br u_t003_001/c0_w1_bl u_t003_001/c0_w1_br
+ u_t003_001/c0_r0_rbl u_t003_001/c0_r1_rbl u_t003_001/c1_w0_bl u_t003_001/c1_w0_br
+ u_t003_001/c1_w1_bl u_t003_001/c1_w1_br u_t003_001/c1_r0_rbl u_t003_001/c1_r1_rbl
+ u_t003_001/c2_w0_bl u_t003_001/c2_w0_br u_t003_001/c2_w1_bl u_t003_001/c2_w1_br
+ u_t003_001/c2_r0_rbl u_t003_001/c2_r1_rbl u_t003_001/c3_w0_bl u_t003_001/c3_w0_br
+ u_t003_001/c3_w1_bl u_t003_001/c3_w1_br u_t003_001/c3_r0_rbl u_t003_001/c3_r1_rbl
+ u_t003_001/r0_w0_wl u_t003_001/r0_w1_wl u_t003_001/r0_r0_rwl u_t003_001/r0_r1_rwl
+ u_t003_001/r1_w0_wl u_t003_001/r1_w1_wl u_t003_001/r1_r0_rwl u_t003_001/r1_r1_rwl
+ u_t003_001/r2_w0_wl u_t003_001/r2_w1_wl u_t003_001/r2_r0_rwl u_t003_001/r2_r1_rwl
+ u_t003_001/r3_w0_wl u_t003_001/r3_w1_wl u_t003_001/r3_r0_rwl u_t003_001/r3_r1_rwl
+ VSS u_t003_002/VSS VSUBS detronyx_12t_2w2r_rc4_4x4_routed_5layer_direct
Xu_t003_012 u_t003_012/c0_w0_bl u_t003_012/c0_w0_br u_t003_012/c0_w1_bl u_t003_012/c0_w1_br
+ u_t003_012/c0_r0_rbl u_t003_012/c0_r1_rbl u_t003_012/c1_w0_bl u_t003_012/c1_w0_br
+ u_t003_012/c1_w1_bl u_t003_012/c1_w1_br u_t003_012/c1_r0_rbl u_t003_012/c1_r1_rbl
+ u_t003_012/c2_w0_bl u_t003_012/c2_w0_br u_t003_012/c2_w1_bl u_t003_012/c2_w1_br
+ u_t003_012/c2_r0_rbl u_t003_012/c2_r1_rbl u_t003_012/c3_w0_bl u_t003_012/c3_w0_br
+ u_t003_012/c3_w1_bl u_t003_012/c3_w1_br u_t003_012/c3_r0_rbl u_t003_012/c3_r1_rbl
+ u_t003_012/r0_w0_wl u_t003_012/r0_w1_wl u_t003_012/r0_r0_rwl u_t003_012/r0_r1_rwl
+ u_t003_012/r1_w0_wl u_t003_012/r1_w1_wl u_t003_012/r1_r0_rwl u_t003_012/r1_r1_rwl
+ u_t003_012/r2_w0_wl u_t003_012/r2_w1_wl u_t003_012/r2_r0_rwl u_t003_012/r2_r1_rwl
+ u_t003_012/r3_w0_wl u_t003_012/r3_w1_wl u_t003_012/r3_r0_rwl u_t003_012/r3_r1_rwl
+ u_t004_012/VDD u_t003_012/VSS VSUBS detronyx_12t_2w2r_rc4_4x4_routed_5layer_direct
Xgf180mcu_as_sc_mcu7t3v3__nand4_2_254 gf180mcu_as_sc_mcu7t3v3__inv_2_923/VDD gf180mcu_as_sc_mcu7t3v3__inv_2_923/VSS
+ VSS VSS VSS VSS VSS gf180mcu_as_sc_mcu7t3v3__inv_2_923/VNW VSUBS gf180mcu_as_sc_mcu7t3v3__nand4_2
Xgf180mcu_as_sc_mcu7t3v3__nand4_2_210 gf180mcu_as_sc_mcu7t3v3__inv_2_788/VDD gf180mcu_as_sc_mcu7t3v3__inv_2_791/VDD
+ VSS VSS VSS VSS VSS gf180mcu_as_sc_mcu7t3v3__inv_2_788/VNW VSUBS gf180mcu_as_sc_mcu7t3v3__nand4_2
Xgf180mcu_as_sc_mcu7t3v3__nand4_2_221 VSS gf180mcu_as_sc_mcu7t3v3__inv_2_827/VDD VSS
+ VSS VSS VSS gf180mcu_as_sc_mcu7t3v3__nand4_2_221/Y gf180mcu_as_sc_mcu7t3v3__inv_2_821/VNW
+ VSUBS gf180mcu_as_sc_mcu7t3v3__nand4_2
Xgf180mcu_as_sc_mcu7t3v3__nand4_2_232 gf180mcu_as_sc_mcu7t3v3__inv_2_854/VDD gf180mcu_as_sc_mcu7t3v3__inv_2_857/VDD
+ VSS VSS VSS VSS gf180mcu_as_sc_mcu7t3v3__nand4_2_232/Y gf180mcu_as_sc_mcu7t3v3__inv_2_854/VNW
+ VSUBS gf180mcu_as_sc_mcu7t3v3__nand4_2
Xgf180mcu_as_sc_mcu7t3v3__nand4_2_243 gf180mcu_as_sc_mcu7t3v3__inv_2_887/VDD gf180mcu_as_sc_mcu7t3v3__inv_2_893/VDD
+ VSS VSS VSS VSS VSS gf180mcu_as_sc_mcu7t3v3__inv_2_887/VNW VSUBS gf180mcu_as_sc_mcu7t3v3__nand4_2
Xgf180mcu_as_sc_mcu7t3v3__inv_2_207 gf180mcu_as_sc_mcu7t3v3__nor2_2_6/VDD gf180mcu_as_sc_mcu7t3v3__nor2_2_6/VSS
+ VSS VSS gf180mcu_as_sc_mcu7t3v3__nor2_2_6/VNW VSUBS gf180mcu_as_sc_mcu7t3v3__inv_2
Xgf180mcu_as_sc_mcu7t3v3__inv_2_218 VSS VSS VSS VSS gf180mcu_as_sc_mcu7t3v3__inv_2_218/VNW
+ VSUBS gf180mcu_as_sc_mcu7t3v3__inv_2
Xgf180mcu_as_sc_mcu7t3v3__inv_2_229 gf180mcu_as_sc_mcu7t3v3__nor2_2_4/VDD gf180mcu_as_sc_mcu7t3v3__nor2_2_4/VSS
+ VSS VSS gf180mcu_as_sc_mcu7t3v3__nor2_2_4/VNW VSUBS gf180mcu_as_sc_mcu7t3v3__inv_2
Xu_t000_004 u_t000_004/c0_w0_bl u_t000_004/c0_w0_br u_t000_004/c0_w1_bl u_t000_004/c0_w1_br
+ u_t000_004/c0_r0_rbl u_t000_004/c0_r1_rbl u_t000_004/c1_w0_bl u_t000_004/c1_w0_br
+ u_t000_004/c1_w1_bl u_t000_004/c1_w1_br u_t000_004/c1_r0_rbl u_t000_004/c1_r1_rbl
+ u_t000_004/c2_w0_bl u_t000_004/c2_w0_br u_t000_004/c2_w1_bl u_t000_004/c2_w1_br
+ u_t000_004/c2_r0_rbl u_t000_004/c2_r1_rbl u_t000_004/c3_w0_bl u_t000_004/c3_w0_br
+ u_t000_004/c3_w1_bl u_t000_004/c3_w1_br u_t000_004/c3_r0_rbl u_t000_004/c3_r1_rbl
+ u_t000_004/r0_w0_wl u_t000_004/r0_w1_wl u_t000_004/r0_r0_rwl u_t000_004/r0_r1_rwl
+ u_t000_004/r1_w0_wl u_t000_004/r1_w1_wl u_t000_004/r1_r0_rwl u_t000_004/r1_r1_rwl
+ u_t000_004/r2_w0_wl u_t000_004/r2_w1_wl u_t000_004/r2_r0_rwl u_t000_004/r2_r1_rwl
+ u_t000_004/r3_w0_wl u_t000_004/r3_w1_wl u_t000_004/r3_r0_rwl u_t000_004/r3_r1_rwl
+ u_t000_004/VDD u_t000_015/VSS VSUBS detronyx_12t_2w2r_rc4_4x4_routed_5layer_direct
Xu_t000_015 u_t000_015/c0_w0_bl u_t000_015/c0_w0_br u_t000_015/c0_w1_bl u_t000_015/c0_w1_br
+ u_t000_015/c0_r0_rbl u_t000_015/c0_r1_rbl u_t000_015/c1_w0_bl u_t000_015/c1_w0_br
+ u_t000_015/c1_w1_bl u_t000_015/c1_w1_br u_t000_015/c1_r0_rbl u_t000_015/c1_r1_rbl
+ u_t000_015/c2_w0_bl u_t000_015/c2_w0_br u_t000_015/c2_w1_bl u_t000_015/c2_w1_br
+ u_t000_015/c2_r0_rbl u_t000_015/c2_r1_rbl u_t000_015/c3_w0_bl u_t000_015/c3_w0_br
+ u_t000_015/c3_w1_bl u_t000_015/c3_w1_br u_t000_015/c3_r0_rbl u_t000_015/c3_r1_rbl
+ u_t000_015/r0_w0_wl u_t000_015/r0_w1_wl u_t000_015/r0_r0_rwl u_t000_015/r0_r1_rwl
+ u_t000_015/r1_w0_wl u_t000_015/r1_w1_wl u_t000_015/r1_r0_rwl u_t000_015/r1_r1_rwl
+ u_t000_015/r2_w0_wl u_t000_015/r2_w1_wl u_t000_015/r2_r0_rwl u_t000_015/r2_r1_rwl
+ u_t000_015/r3_w0_wl u_t000_015/r3_w1_wl u_t000_015/r3_r0_rwl u_t000_015/r3_r1_rwl
+ VSS u_t000_015/VSS VSUBS detronyx_12t_2w2r_rc4_4x4_routed_5layer_direct
Xgf180mcu_as_sc_mcu7t3v3__inv_2_763 VSS VSS gf180mcu_as_sc_mcu7t3v3__inv_2_923/Y gf180mcu_as_sc_mcu7t3v3__inv_2_923/Y
+ gf180mcu_as_sc_mcu7t3v3__inv_2_764/VNW VSUBS gf180mcu_as_sc_mcu7t3v3__inv_2
Xgf180mcu_as_sc_mcu7t3v3__inv_2_752 gf180mcu_as_sc_mcu7t3v3__inv_2_752/VDD VSS gf180mcu_as_sc_mcu7t3v3__inv_2_752/Y
+ VSS gf180mcu_as_sc_mcu7t3v3__inv_2_752/VNW VSUBS gf180mcu_as_sc_mcu7t3v3__inv_2
Xgf180mcu_as_sc_mcu7t3v3__inv_2_741 gf180mcu_as_sc_mcu7t3v3__inv_2_743/VDD gf180mcu_as_sc_mcu7t3v3__inv_2_746/VDD
+ VSS gf180mcu_as_sc_mcu7t3v3__inv_2_743/Y gf180mcu_as_sc_mcu7t3v3__inv_2_743/VNW
+ VSUBS gf180mcu_as_sc_mcu7t3v3__inv_2
Xgf180mcu_as_sc_mcu7t3v3__inv_2_730 gf180mcu_as_sc_mcu7t3v3__inv_2_731/VDD gf180mcu_as_sc_mcu7t3v3__inv_2_734/VDD
+ gf180mcu_as_sc_mcu7t3v3__inv_2_730/Y gf180mcu_as_sc_mcu7t3v3__inv_2_743/Y gf180mcu_as_sc_mcu7t3v3__inv_2_731/VNW
+ VSUBS gf180mcu_as_sc_mcu7t3v3__inv_2
Xgf180mcu_as_sc_mcu7t3v3__inv_2_796 gf180mcu_as_sc_mcu7t3v3__inv_2_797/VDD gf180mcu_as_sc_mcu7t3v3__inv_2_800/VDD
+ VSS VSS gf180mcu_as_sc_mcu7t3v3__inv_2_797/VNW VSUBS gf180mcu_as_sc_mcu7t3v3__inv_2
Xgf180mcu_as_sc_mcu7t3v3__inv_2_785 gf180mcu_as_sc_mcu7t3v3__inv_2_785/VDD gf180mcu_as_sc_mcu7t3v3__inv_2_788/VDD
+ VSS VSS gf180mcu_as_sc_mcu7t3v3__inv_2_785/VNW VSUBS gf180mcu_as_sc_mcu7t3v3__inv_2
Xgf180mcu_as_sc_mcu7t3v3__inv_2_774 gf180mcu_as_sc_mcu7t3v3__inv_2_776/VDD gf180mcu_as_sc_mcu7t3v3__inv_2_776/VSS
+ VSS gf180mcu_as_sc_mcu7t3v3__inv_2_776/Y gf180mcu_as_sc_mcu7t3v3__inv_2_776/VNW
+ VSUBS gf180mcu_as_sc_mcu7t3v3__inv_2
Xgf180mcu_as_sc_mcu7t3v3__inv_2_560 VSS gf180mcu_as_sc_mcu7t3v3__inv_2_564/VDD gf180mcu_as_sc_mcu7t3v3__inv_2_560/Y
+ gf180mcu_as_sc_mcu7t3v3__inv_2_561/Y gf180mcu_as_sc_mcu7t3v3__inv_2_561/VNW VSUBS
+ gf180mcu_as_sc_mcu7t3v3__inv_2
Xgf180mcu_as_sc_mcu7t3v3__inv_2_571 VSS VSS gf180mcu_as_sc_mcu7t3v3__inv_2_571/Y gf180mcu_as_sc_mcu7t3v3__inv_2_574/A
+ gf180mcu_as_sc_mcu7t3v3__inv_2_573/VNW VSUBS gf180mcu_as_sc_mcu7t3v3__inv_2
Xgf180mcu_as_sc_mcu7t3v3__inv_2_593 VSS VSS gf180mcu_as_sc_mcu7t3v3__inv_2_611/Y gf180mcu_as_sc_mcu7t3v3__inv_2_594/Y
+ gf180mcu_as_sc_mcu7t3v3__inv_2_594/VNW VSUBS gf180mcu_as_sc_mcu7t3v3__inv_2
Xgf180mcu_as_sc_mcu7t3v3__inv_2_582 VSS VSS gf180mcu_as_sc_mcu7t3v3__inv_2_582/Y VSS
+ gf180mcu_as_sc_mcu7t3v3__inv_2_582/VNW VSUBS gf180mcu_as_sc_mcu7t3v3__inv_2
Xgf180mcu_as_sc_mcu7t3v3__nor2_2_8 gf180mcu_as_sc_mcu7t3v3__nor2_2_8/VDD gf180mcu_as_sc_mcu7t3v3__nor2_2_8/VSS
+ VSS VSS VSS gf180mcu_as_sc_mcu7t3v3__nor2_2_8/VNW VSUBS gf180mcu_as_sc_mcu7t3v3__nor2_2
Xgf180mcu_as_sc_mcu7t3v3__inv_2_390 VSS VSS gf180mcu_as_sc_mcu7t3v3__inv_2_390/Y VSS
+ gf180mcu_as_sc_mcu7t3v3__inv_2_390/VNW VSUBS gf180mcu_as_sc_mcu7t3v3__inv_2
Xgf180mcu_as_sc_mcu7t3v3__nand3_2_11 gf180mcu_as_sc_mcu7t3v3__nand2_2_9/VDD gf180mcu_as_sc_mcu7t3v3__nor2_2_6/VSS
+ VSS VSS VSS VSS gf180mcu_as_sc_mcu7t3v3__nand2_2_9/VNW VSUBS gf180mcu_as_sc_mcu7t3v3__nand3_2
Xgf180mcu_as_sc_mcu7t3v3__nand3_2_33 gf180mcu_as_sc_mcu7t3v3__inv_2_713/VDD gf180mcu_as_sc_mcu7t3v3__inv_2_713/VSS
+ VSS VSS VSS VSS gf180mcu_as_sc_mcu7t3v3__inv_2_713/VNW VSUBS gf180mcu_as_sc_mcu7t3v3__nand3_2
Xgf180mcu_as_sc_mcu7t3v3__nand3_2_22 gf180mcu_as_sc_mcu7t3v3__nor2_2_8/VDD gf180mcu_as_sc_mcu7t3v3__inv_2_710/VSS
+ VSS VSS VSS VSS gf180mcu_as_sc_mcu7t3v3__nor2_2_8/VNW VSUBS gf180mcu_as_sc_mcu7t3v3__nand3_2
Xu_t015_010 u_t015_010/c0_w0_bl u_t015_010/c0_w0_br u_t015_010/c0_w1_bl u_t015_010/c0_w1_br
+ u_t015_010/c0_r0_rbl u_t015_010/c0_r1_rbl u_t015_010/c1_w0_bl u_t015_010/c1_w0_br
+ u_t015_010/c1_w1_bl u_t015_010/c1_w1_br u_t015_010/c1_r0_rbl u_t015_010/c1_r1_rbl
+ u_t015_010/c2_w0_bl u_t015_010/c2_w0_br u_t015_010/c2_w1_bl u_t015_010/c2_w1_br
+ u_t015_010/c2_r0_rbl u_t015_010/c2_r1_rbl u_t015_010/c3_w0_bl u_t015_010/c3_w0_br
+ u_t015_010/c3_w1_bl u_t015_010/c3_w1_br u_t015_010/c3_r0_rbl u_t015_010/c3_r1_rbl
+ u_t015_010/r0_w0_wl u_t015_010/r0_w1_wl u_t015_010/r0_r0_rwl u_t015_010/r0_r1_rwl
+ u_t015_010/r1_w0_wl u_t015_010/r1_w1_wl u_t015_010/r1_r0_rwl u_t015_010/r1_r1_rwl
+ u_t015_010/r2_w0_wl u_t015_010/r2_w1_wl u_t015_010/r2_r0_rwl u_t015_010/r2_r1_rwl
+ u_t015_010/r3_w0_wl u_t015_010/r3_w1_wl u_t015_010/r3_r0_rwl u_t015_010/r3_r1_rwl
+ VSS u_t015_010/VSS VSUBS detronyx_12t_2w2r_rc4_4x4_routed_5layer_direct
Xgf180mcu_as_sc_mcu7t3v3__inv_2_4 gf180mcu_as_sc_mcu7t3v3__inv_2_9/VSS gf180mcu_as_sc_mcu7t3v3__inv_2_8/VDD
+ gf180mcu_as_sc_mcu7t3v3__inv_2_4/Y gf180mcu_as_sc_mcu7t3v3__inv_2_9/A gf180mcu_as_sc_mcu7t3v3__inv_2_5/VNW
+ VSUBS gf180mcu_as_sc_mcu7t3v3__inv_2
Xu_t006_010 u_t006_010/c0_w0_bl u_t006_010/c0_w0_br u_t006_010/c0_w1_bl u_t006_010/c0_w1_br
+ u_t006_010/c0_r0_rbl u_t006_010/c0_r1_rbl u_t006_010/c1_w0_bl u_t006_010/c1_w0_br
+ u_t006_010/c1_w1_bl u_t006_010/c1_w1_br u_t006_010/c1_r0_rbl u_t006_010/c1_r1_rbl
+ u_t006_010/c2_w0_bl u_t006_010/c2_w0_br u_t006_010/c2_w1_bl u_t006_010/c2_w1_br
+ u_t006_010/c2_r0_rbl u_t006_010/c2_r1_rbl u_t006_010/c3_w0_bl u_t006_010/c3_w0_br
+ u_t006_010/c3_w1_bl u_t006_010/c3_w1_br u_t006_010/c3_r0_rbl u_t006_010/c3_r1_rbl
+ u_t006_010/r0_w0_wl u_t006_010/r0_w1_wl u_t006_010/r0_r0_rwl u_t006_010/r0_r1_rwl
+ u_t006_010/r1_w0_wl u_t006_010/r1_w1_wl u_t006_010/r1_r0_rwl u_t006_010/r1_r1_rwl
+ u_t006_010/r2_w0_wl u_t006_010/r2_w1_wl u_t006_010/r2_r0_rwl u_t006_010/r2_r1_rwl
+ u_t006_010/r3_w0_wl u_t006_010/r3_w1_wl u_t006_010/r3_r0_rwl u_t006_010/r3_r1_rwl
+ VSS u_t006_010/VSS VSUBS detronyx_12t_2w2r_rc4_4x4_routed_5layer_direct
Xu_t012_013 u_t012_013/c0_w0_bl u_t012_013/c0_w0_br u_t012_013/c0_w1_bl u_t012_013/c0_w1_br
+ u_t012_013/c0_r0_rbl u_t012_013/c0_r1_rbl u_t012_013/c1_w0_bl u_t012_013/c1_w0_br
+ u_t012_013/c1_w1_bl u_t012_013/c1_w1_br u_t012_013/c1_r0_rbl u_t012_013/c1_r1_rbl
+ u_t012_013/c2_w0_bl u_t012_013/c2_w0_br u_t012_013/c2_w1_bl u_t012_013/c2_w1_br
+ u_t012_013/c2_r0_rbl u_t012_013/c2_r1_rbl u_t012_013/c3_w0_bl u_t012_013/c3_w0_br
+ u_t012_013/c3_w1_bl u_t012_013/c3_w1_br u_t012_013/c3_r0_rbl u_t012_013/c3_r1_rbl
+ u_t012_013/r0_w0_wl u_t012_013/r0_w1_wl u_t012_013/r0_r0_rwl u_t012_013/r0_r1_rwl
+ u_t012_013/r1_w0_wl u_t012_013/r1_w1_wl u_t012_013/r1_r0_rwl u_t012_013/r1_r1_rwl
+ u_t012_013/r2_w0_wl u_t012_013/r2_w1_wl u_t012_013/r2_r0_rwl u_t012_013/r2_r1_rwl
+ u_t012_013/r3_w0_wl u_t012_013/r3_w1_wl u_t012_013/r3_r0_rwl u_t012_013/r3_r1_rwl
+ u_t012_013/VDD u_t012_015/VSS VSUBS detronyx_12t_2w2r_rc4_4x4_routed_5layer_direct
Xu_t012_002 u_t012_002/c0_w0_bl u_t012_002/c0_w0_br u_t012_002/c0_w1_bl u_t012_002/c0_w1_br
+ u_t012_002/c0_r0_rbl u_t012_002/c0_r1_rbl u_t012_002/c1_w0_bl u_t012_002/c1_w0_br
+ u_t012_002/c1_w1_bl u_t012_002/c1_w1_br u_t012_002/c1_r0_rbl u_t012_002/c1_r1_rbl
+ u_t012_002/c2_w0_bl u_t012_002/c2_w0_br u_t012_002/c2_w1_bl u_t012_002/c2_w1_br
+ u_t012_002/c2_r0_rbl u_t012_002/c2_r1_rbl u_t012_002/c3_w0_bl u_t012_002/c3_w0_br
+ u_t012_002/c3_w1_bl u_t012_002/c3_w1_br u_t012_002/c3_r0_rbl u_t012_002/c3_r1_rbl
+ u_t012_002/r0_w0_wl u_t012_002/r0_w1_wl u_t012_002/r0_r0_rwl u_t012_002/r0_r1_rwl
+ u_t012_002/r1_w0_wl u_t012_002/r1_w1_wl u_t012_002/r1_r0_rwl u_t012_002/r1_r1_rwl
+ u_t012_002/r2_w0_wl u_t012_002/r2_w1_wl u_t012_002/r2_r0_rwl u_t012_002/r2_r1_rwl
+ u_t012_002/r3_w0_wl u_t012_002/r3_w1_wl u_t012_002/r3_r0_rwl u_t012_002/r3_r1_rwl
+ VSS u_t012_015/VSS VSUBS detronyx_12t_2w2r_rc4_4x4_routed_5layer_direct
Xgf180mcu_as_sc_mcu7t3v3__inv_2_923 gf180mcu_as_sc_mcu7t3v3__inv_2_923/VDD gf180mcu_as_sc_mcu7t3v3__inv_2_923/VSS
+ gf180mcu_as_sc_mcu7t3v3__inv_2_923/Y VSS gf180mcu_as_sc_mcu7t3v3__inv_2_923/VNW
+ VSUBS gf180mcu_as_sc_mcu7t3v3__inv_2
Xgf180mcu_as_sc_mcu7t3v3__inv_2_912 gf180mcu_as_sc_mcu7t3v3__inv_2_914/VDD gf180mcu_as_sc_mcu7t3v3__inv_2_917/VDD
+ VSS gf180mcu_as_sc_mcu7t3v3__inv_2_917/Y gf180mcu_as_sc_mcu7t3v3__inv_2_914/VNW
+ VSUBS gf180mcu_as_sc_mcu7t3v3__inv_2
Xgf180mcu_as_sc_mcu7t3v3__inv_2_901 gf180mcu_as_sc_mcu7t3v3__inv_2_902/VDD gf180mcu_as_sc_mcu7t3v3__inv_2_905/VDD
+ gf180mcu_as_sc_mcu7t3v3__inv_2_908/Y gf180mcu_as_sc_mcu7t3v3__inv_2_908/Y gf180mcu_as_sc_mcu7t3v3__inv_2_902/VNW
+ VSUBS gf180mcu_as_sc_mcu7t3v3__inv_2
Xu_t003_002 u_t003_002/c0_w0_bl u_t003_002/c0_w0_br u_t003_002/c0_w1_bl u_t003_002/c0_w1_br
+ u_t003_002/c0_r0_rbl u_t003_002/c0_r1_rbl u_t003_002/c1_w0_bl u_t003_002/c1_w0_br
+ u_t003_002/c1_w1_bl u_t003_002/c1_w1_br u_t003_002/c1_r0_rbl u_t003_002/c1_r1_rbl
+ u_t003_002/c2_w0_bl u_t003_002/c2_w0_br u_t003_002/c2_w1_bl u_t003_002/c2_w1_br
+ u_t003_002/c2_r0_rbl u_t003_002/c2_r1_rbl u_t003_002/c3_w0_bl u_t003_002/c3_w0_br
+ u_t003_002/c3_w1_bl u_t003_002/c3_w1_br u_t003_002/c3_r0_rbl u_t003_002/c3_r1_rbl
+ u_t003_002/r0_w0_wl u_t003_002/r0_w1_wl u_t003_002/r0_r0_rwl u_t003_002/r0_r1_rwl
+ u_t003_002/r1_w0_wl u_t003_002/r1_w1_wl u_t003_002/r1_r0_rwl u_t003_002/r1_r1_rwl
+ u_t003_002/r2_w0_wl u_t003_002/r2_w1_wl u_t003_002/r2_r0_rwl u_t003_002/r2_r1_rwl
+ u_t003_002/r3_w0_wl u_t003_002/r3_w1_wl u_t003_002/r3_r0_rwl u_t003_002/r3_r1_rwl
+ VSS u_t003_002/VSS VSUBS detronyx_12t_2w2r_rc4_4x4_routed_5layer_direct
Xu_t003_013 u_t003_013/c0_w0_bl u_t003_013/c0_w0_br u_t003_013/c0_w1_bl u_t003_013/c0_w1_br
+ u_t003_013/c0_r0_rbl u_t003_013/c0_r1_rbl u_t003_013/c1_w0_bl u_t003_013/c1_w0_br
+ u_t003_013/c1_w1_bl u_t003_013/c1_w1_br u_t003_013/c1_r0_rbl u_t003_013/c1_r1_rbl
+ u_t003_013/c2_w0_bl u_t003_013/c2_w0_br u_t003_013/c2_w1_bl u_t003_013/c2_w1_br
+ u_t003_013/c2_r0_rbl u_t003_013/c2_r1_rbl u_t003_013/c3_w0_bl u_t003_013/c3_w0_br
+ u_t003_013/c3_w1_bl u_t003_013/c3_w1_br u_t003_013/c3_r0_rbl u_t003_013/c3_r1_rbl
+ u_t003_013/r0_w0_wl u_t003_013/r0_w1_wl u_t003_013/r0_r0_rwl u_t003_013/r0_r1_rwl
+ u_t003_013/r1_w0_wl u_t003_013/r1_w1_wl u_t003_013/r1_r0_rwl u_t003_013/r1_r1_rwl
+ u_t003_013/r2_w0_wl u_t003_013/r2_w1_wl u_t003_013/r2_r0_rwl u_t003_013/r2_r1_rwl
+ u_t003_013/r3_w0_wl u_t003_013/r3_w1_wl u_t003_013/r3_r0_rwl u_t003_013/r3_r1_rwl
+ u_t004_013/VDD u_t003_013/VSS VSUBS detronyx_12t_2w2r_rc4_4x4_routed_5layer_direct
Xgf180mcu_as_sc_mcu7t3v3__nand4_2_255 gf180mcu_as_sc_mcu7t3v3__inv_2_926/VDD gf180mcu_as_sc_mcu7t3v3__inv_2_66/VDD
+ VSS VSS VSS VSS gf180mcu_as_sc_mcu7t3v3__nand4_2_255/Y gf180mcu_as_sc_mcu7t3v3__inv_2_926/VNW
+ VSUBS gf180mcu_as_sc_mcu7t3v3__nand4_2
Xgf180mcu_as_sc_mcu7t3v3__nand4_2_222 VSS gf180mcu_as_sc_mcu7t3v3__inv_2_926/VDD VSS
+ VSS VSS VSS gf180mcu_as_sc_mcu7t3v3__nand4_2_222/Y gf180mcu_as_sc_mcu7t3v3__inv_2_824/VNW
+ VSUBS gf180mcu_as_sc_mcu7t3v3__nand4_2
Xgf180mcu_as_sc_mcu7t3v3__nand4_2_200 VSS gf180mcu_as_sc_mcu7t3v3__inv_2_761/VDD VSS
+ VSS VSS VSS VSS gf180mcu_as_sc_mcu7t3v3__inv_2_758/VNW VSUBS gf180mcu_as_sc_mcu7t3v3__nand4_2
Xgf180mcu_as_sc_mcu7t3v3__nand4_2_211 gf180mcu_as_sc_mcu7t3v3__inv_2_791/VDD gf180mcu_as_sc_mcu7t3v3__inv_2_794/VDD
+ VSS VSS VSS VSS gf180mcu_as_sc_mcu7t3v3__nand4_2_211/Y gf180mcu_as_sc_mcu7t3v3__inv_2_791/VNW
+ VSUBS gf180mcu_as_sc_mcu7t3v3__nand4_2
Xgf180mcu_as_sc_mcu7t3v3__nand4_2_233 gf180mcu_as_sc_mcu7t3v3__inv_2_857/VDD gf180mcu_as_sc_mcu7t3v3__inv_2_860/VDD
+ VSS VSS VSS VSS gf180mcu_as_sc_mcu7t3v3__nand4_2_233/Y gf180mcu_as_sc_mcu7t3v3__inv_2_857/VNW
+ VSUBS gf180mcu_as_sc_mcu7t3v3__nand4_2
Xgf180mcu_as_sc_mcu7t3v3__nand4_2_244 gf180mcu_as_sc_mcu7t3v3__inv_2_893/VDD gf180mcu_as_sc_mcu7t3v3__inv_2_893/VDD
+ VSS VSS VSS VSS VSS gf180mcu_as_sc_mcu7t3v3__inv_2_890/VNW VSUBS gf180mcu_as_sc_mcu7t3v3__nand4_2
Xgf180mcu_as_sc_mcu7t3v3__inv_2_219 gf180mcu_as_sc_mcu7t3v3__nor2_2_4/VDD gf180mcu_as_sc_mcu7t3v3__nor2_2_4/VSS
+ VSS VSS gf180mcu_as_sc_mcu7t3v3__nor2_2_4/VNW VSUBS gf180mcu_as_sc_mcu7t3v3__inv_2
Xgf180mcu_as_sc_mcu7t3v3__inv_2_208 gf180mcu_as_sc_mcu7t3v3__nor2_2_6/VDD gf180mcu_as_sc_mcu7t3v3__nand3_2_1/VSS
+ VSS VSS gf180mcu_as_sc_mcu7t3v3__nor2_2_6/VNW VSUBS gf180mcu_as_sc_mcu7t3v3__inv_2
Xu_t000_005 u_t000_005/c0_w0_bl u_t000_005/c0_w0_br u_t000_005/c0_w1_bl u_t000_005/c0_w1_br
+ u_t000_005/c0_r0_rbl u_t000_005/c0_r1_rbl u_t000_005/c1_w0_bl u_t000_005/c1_w0_br
+ u_t000_005/c1_w1_bl u_t000_005/c1_w1_br u_t000_005/c1_r0_rbl u_t000_005/c1_r1_rbl
+ u_t000_005/c2_w0_bl u_t000_005/c2_w0_br u_t000_005/c2_w1_bl u_t000_005/c2_w1_br
+ u_t000_005/c2_r0_rbl u_t000_005/c2_r1_rbl u_t000_005/c3_w0_bl u_t000_005/c3_w0_br
+ u_t000_005/c3_w1_bl u_t000_005/c3_w1_br u_t000_005/c3_r0_rbl u_t000_005/c3_r1_rbl
+ u_t000_005/r0_w0_wl u_t000_005/r0_w1_wl u_t000_005/r0_r0_rwl u_t000_005/r0_r1_rwl
+ u_t000_005/r1_w0_wl u_t000_005/r1_w1_wl u_t000_005/r1_r0_rwl u_t000_005/r1_r1_rwl
+ u_t000_005/r2_w0_wl u_t000_005/r2_w1_wl u_t000_005/r2_r0_rwl u_t000_005/r2_r1_rwl
+ u_t000_005/r3_w0_wl u_t000_005/r3_w1_wl u_t000_005/r3_r0_rwl u_t000_005/r3_r1_rwl
+ u_t000_005/VDD u_t000_015/VSS VSUBS detronyx_12t_2w2r_rc4_4x4_routed_5layer_direct
Xgf180mcu_as_sc_mcu7t3v3__inv_2_764 VSS VSS gf180mcu_as_sc_mcu7t3v3__inv_2_923/Y VSS
+ gf180mcu_as_sc_mcu7t3v3__inv_2_764/VNW VSUBS gf180mcu_as_sc_mcu7t3v3__inv_2
Xgf180mcu_as_sc_mcu7t3v3__inv_2_753 VSS VSS VSS gf180mcu_as_sc_mcu7t3v3__inv_2_761/Y
+ gf180mcu_as_sc_mcu7t3v3__inv_2_755/VNW VSUBS gf180mcu_as_sc_mcu7t3v3__inv_2
Xgf180mcu_as_sc_mcu7t3v3__inv_2_797 gf180mcu_as_sc_mcu7t3v3__inv_2_797/VDD gf180mcu_as_sc_mcu7t3v3__inv_2_800/VDD
+ VSS VSS gf180mcu_as_sc_mcu7t3v3__inv_2_797/VNW VSUBS gf180mcu_as_sc_mcu7t3v3__inv_2
Xgf180mcu_as_sc_mcu7t3v3__inv_2_742 gf180mcu_as_sc_mcu7t3v3__inv_2_743/VDD gf180mcu_as_sc_mcu7t3v3__inv_2_746/VDD
+ gf180mcu_as_sc_mcu7t3v3__inv_2_743/Y gf180mcu_as_sc_mcu7t3v3__inv_2_743/Y gf180mcu_as_sc_mcu7t3v3__inv_2_743/VNW
+ VSUBS gf180mcu_as_sc_mcu7t3v3__inv_2
Xgf180mcu_as_sc_mcu7t3v3__inv_2_786 gf180mcu_as_sc_mcu7t3v3__inv_2_788/VDD gf180mcu_as_sc_mcu7t3v3__inv_2_791/VDD
+ gf180mcu_as_sc_mcu7t3v3__inv_2_786/Y VSS gf180mcu_as_sc_mcu7t3v3__inv_2_788/VNW
+ VSUBS gf180mcu_as_sc_mcu7t3v3__inv_2
Xgf180mcu_as_sc_mcu7t3v3__inv_2_731 gf180mcu_as_sc_mcu7t3v3__inv_2_731/VDD gf180mcu_as_sc_mcu7t3v3__inv_2_734/VDD
+ gf180mcu_as_sc_mcu7t3v3__inv_2_743/Y VSS gf180mcu_as_sc_mcu7t3v3__inv_2_731/VNW
+ VSUBS gf180mcu_as_sc_mcu7t3v3__inv_2
Xgf180mcu_as_sc_mcu7t3v3__inv_2_775 gf180mcu_as_sc_mcu7t3v3__inv_2_776/VDD gf180mcu_as_sc_mcu7t3v3__inv_2_776/VSS
+ gf180mcu_as_sc_mcu7t3v3__inv_2_775/Y gf180mcu_as_sc_mcu7t3v3__inv_2_776/Y gf180mcu_as_sc_mcu7t3v3__inv_2_776/VNW
+ VSUBS gf180mcu_as_sc_mcu7t3v3__inv_2
Xgf180mcu_as_sc_mcu7t3v3__inv_2_720 VSS VSS VSS VSS gf180mcu_as_sc_mcu7t3v3__inv_2_722/VNW
+ VSUBS gf180mcu_as_sc_mcu7t3v3__inv_2
Xgf180mcu_as_sc_mcu7t3v3__nand4_2_0 gf180mcu_as_sc_mcu7t3v3__inv_2_9/VDD gf180mcu_as_sc_mcu7t3v3__inv_2_9/VSS
+ VSS VSS VSS VSS VSS gf180mcu_as_sc_mcu7t3v3__inv_2_9/VNW VSUBS gf180mcu_as_sc_mcu7t3v3__nand4_2
Xgf180mcu_as_sc_mcu7t3v3__inv_2_561 VSS gf180mcu_as_sc_mcu7t3v3__inv_2_564/VDD gf180mcu_as_sc_mcu7t3v3__inv_2_561/Y
+ VSS gf180mcu_as_sc_mcu7t3v3__inv_2_561/VNW VSUBS gf180mcu_as_sc_mcu7t3v3__inv_2
Xgf180mcu_as_sc_mcu7t3v3__inv_2_550 gf180mcu_as_sc_mcu7t3v3__inv_2_552/VDD gf180mcu_as_sc_mcu7t3v3__inv_2_555/VDD
+ gf180mcu_as_sc_mcu7t3v3__inv_2_550/Y gf180mcu_as_sc_mcu7t3v3__inv_2_553/A gf180mcu_as_sc_mcu7t3v3__inv_2_552/VNW
+ VSUBS gf180mcu_as_sc_mcu7t3v3__inv_2
Xgf180mcu_as_sc_mcu7t3v3__inv_2_572 VSS VSS gf180mcu_as_sc_mcu7t3v3__inv_2_574/A gf180mcu_as_sc_mcu7t3v3__inv_2_573/Y
+ gf180mcu_as_sc_mcu7t3v3__inv_2_573/VNW VSUBS gf180mcu_as_sc_mcu7t3v3__inv_2
Xgf180mcu_as_sc_mcu7t3v3__inv_2_594 VSS VSS gf180mcu_as_sc_mcu7t3v3__inv_2_594/Y VSS
+ gf180mcu_as_sc_mcu7t3v3__inv_2_594/VNW VSUBS gf180mcu_as_sc_mcu7t3v3__inv_2
Xgf180mcu_as_sc_mcu7t3v3__inv_2_583 VSS VSS VSS gf180mcu_as_sc_mcu7t3v3__inv_2_589/A
+ gf180mcu_as_sc_mcu7t3v3__inv_2_585/VNW VSUBS gf180mcu_as_sc_mcu7t3v3__inv_2
Xgf180mcu_as_sc_mcu7t3v3__inv_2_391 VSS gf180mcu_as_sc_mcu7t3v3__inv_2_396/VDD gf180mcu_as_sc_mcu7t3v3__inv_2_391/Y
+ gf180mcu_as_sc_mcu7t3v3__inv_2_466/A gf180mcu_as_sc_mcu7t3v3__inv_2_393/VNW VSUBS
+ gf180mcu_as_sc_mcu7t3v3__inv_2
Xgf180mcu_as_sc_mcu7t3v3__inv_2_380 VSS gf180mcu_as_sc_mcu7t3v3__inv_2_384/VDD gf180mcu_as_sc_mcu7t3v3__inv_2_380/Y
+ gf180mcu_as_sc_mcu7t3v3__inv_2_381/Y gf180mcu_as_sc_mcu7t3v3__inv_2_381/VNW VSUBS
+ gf180mcu_as_sc_mcu7t3v3__inv_2
Xgf180mcu_as_sc_mcu7t3v3__nand3_2_12 gf180mcu_as_sc_mcu7t3v3__nand2_2_9/VDD gf180mcu_as_sc_mcu7t3v3__nor2_2_6/VSS
+ VSS VSS VSS VSS gf180mcu_as_sc_mcu7t3v3__nand2_2_9/VNW VSUBS gf180mcu_as_sc_mcu7t3v3__nand3_2
Xgf180mcu_as_sc_mcu7t3v3__nand3_2_23 gf180mcu_as_sc_mcu7t3v3__nor2_2_8/VDD gf180mcu_as_sc_mcu7t3v3__nor2_2_8/VSS
+ VSS VSS VSS VSS gf180mcu_as_sc_mcu7t3v3__nor2_2_8/VNW VSUBS gf180mcu_as_sc_mcu7t3v3__nand3_2
Xu_t015_000 u_t015_000/c0_w0_bl u_t015_000/c0_w0_br u_t015_000/c0_w1_bl u_t015_000/c0_w1_br
+ u_t015_000/c0_r0_rbl u_t015_000/c0_r1_rbl u_t015_000/c1_w0_bl u_t015_000/c1_w0_br
+ u_t015_000/c1_w1_bl u_t015_000/c1_w1_br u_t015_000/c1_r0_rbl u_t015_000/c1_r1_rbl
+ u_t015_000/c2_w0_bl u_t015_000/c2_w0_br u_t015_000/c2_w1_bl u_t015_000/c2_w1_br
+ u_t015_000/c2_r0_rbl u_t015_000/c2_r1_rbl u_t015_000/c3_w0_bl u_t015_000/c3_w0_br
+ u_t015_000/c3_w1_bl u_t015_000/c3_w1_br u_t015_000/c3_r0_rbl u_t015_000/c3_r1_rbl
+ u_t015_000/r0_w0_wl u_t015_000/r0_w1_wl u_t015_000/r0_r0_rwl u_t015_000/r0_r1_rwl
+ u_t015_000/r1_w0_wl u_t015_000/r1_w1_wl u_t015_000/r1_r0_rwl u_t015_000/r1_r1_rwl
+ u_t015_000/r2_w0_wl u_t015_000/r2_w1_wl u_t015_000/r2_r0_rwl u_t015_000/r2_r1_rwl
+ u_t015_000/r3_w0_wl u_t015_000/r3_w1_wl u_t015_000/r3_r0_rwl u_t015_000/r3_r1_rwl
+ VSS u_t015_002/VSS VSUBS detronyx_12t_2w2r_rc4_4x4_routed_5layer_direct
Xu_t015_011 u_t015_011/c0_w0_bl u_t015_011/c0_w0_br u_t015_011/c0_w1_bl u_t015_011/c0_w1_br
+ u_t015_011/c0_r0_rbl u_t015_011/c0_r1_rbl u_t015_011/c1_w0_bl u_t015_011/c1_w0_br
+ u_t015_011/c1_w1_bl u_t015_011/c1_w1_br u_t015_011/c1_r0_rbl u_t015_011/c1_r1_rbl
+ u_t015_011/c2_w0_bl u_t015_011/c2_w0_br u_t015_011/c2_w1_bl u_t015_011/c2_w1_br
+ u_t015_011/c2_r0_rbl u_t015_011/c2_r1_rbl u_t015_011/c3_w0_bl u_t015_011/c3_w0_br
+ u_t015_011/c3_w1_bl u_t015_011/c3_w1_br u_t015_011/c3_r0_rbl u_t015_011/c3_r1_rbl
+ u_t015_011/r0_w0_wl u_t015_011/r0_w1_wl u_t015_011/r0_r0_rwl u_t015_011/r0_r1_rwl
+ u_t015_011/r1_w0_wl u_t015_011/r1_w1_wl u_t015_011/r1_r0_rwl u_t015_011/r1_r1_rwl
+ u_t015_011/r2_w0_wl u_t015_011/r2_w1_wl u_t015_011/r2_r0_rwl u_t015_011/r2_r1_rwl
+ u_t015_011/r3_w0_wl u_t015_011/r3_w1_wl u_t015_011/r3_r0_rwl u_t015_011/r3_r1_rwl
+ u_t015_011/VDD u_t015_011/VSS VSUBS detronyx_12t_2w2r_rc4_4x4_routed_5layer_direct
Xgf180mcu_as_sc_mcu7t3v3__inv_2_5 gf180mcu_as_sc_mcu7t3v3__inv_2_9/VSS gf180mcu_as_sc_mcu7t3v3__inv_2_8/VDD
+ gf180mcu_as_sc_mcu7t3v3__inv_2_9/A VSS gf180mcu_as_sc_mcu7t3v3__inv_2_5/VNW VSUBS
+ gf180mcu_as_sc_mcu7t3v3__inv_2
Xu_t006_000 u_t006_000/c0_w0_bl u_t006_000/c0_w0_br u_t006_000/c0_w1_bl u_t006_000/c0_w1_br
+ u_t006_000/c0_r0_rbl u_t006_000/c0_r1_rbl u_t006_000/c1_w0_bl u_t006_000/c1_w0_br
+ u_t006_000/c1_w1_bl u_t006_000/c1_w1_br u_t006_000/c1_r0_rbl u_t006_000/c1_r1_rbl
+ u_t006_000/c2_w0_bl u_t006_000/c2_w0_br u_t006_000/c2_w1_bl u_t006_000/c2_w1_br
+ u_t006_000/c2_r0_rbl u_t006_000/c2_r1_rbl u_t006_000/c3_w0_bl u_t006_000/c3_w0_br
+ u_t006_000/c3_w1_bl u_t006_000/c3_w1_br u_t006_000/c3_r0_rbl u_t006_000/c3_r1_rbl
+ u_t006_000/r0_w0_wl u_t006_000/r0_w1_wl u_t006_000/r0_r0_rwl u_t006_000/r0_r1_rwl
+ u_t006_000/r1_w0_wl u_t006_000/r1_w1_wl u_t006_000/r1_r0_rwl u_t006_000/r1_r1_rwl
+ u_t006_000/r2_w0_wl u_t006_000/r2_w1_wl u_t006_000/r2_r0_rwl u_t006_000/r2_r1_rwl
+ u_t006_000/r3_w0_wl u_t006_000/r3_w1_wl u_t006_000/r3_r0_rwl u_t006_000/r3_r1_rwl
+ VSS u_t006_002/VSS VSUBS detronyx_12t_2w2r_rc4_4x4_routed_5layer_direct
Xu_t006_011 u_t006_011/c0_w0_bl u_t006_011/c0_w0_br u_t006_011/c0_w1_bl u_t006_011/c0_w1_br
+ u_t006_011/c0_r0_rbl u_t006_011/c0_r1_rbl u_t006_011/c1_w0_bl u_t006_011/c1_w0_br
+ u_t006_011/c1_w1_bl u_t006_011/c1_w1_br u_t006_011/c1_r0_rbl u_t006_011/c1_r1_rbl
+ u_t006_011/c2_w0_bl u_t006_011/c2_w0_br u_t006_011/c2_w1_bl u_t006_011/c2_w1_br
+ u_t006_011/c2_r0_rbl u_t006_011/c2_r1_rbl u_t006_011/c3_w0_bl u_t006_011/c3_w0_br
+ u_t006_011/c3_w1_bl u_t006_011/c3_w1_br u_t006_011/c3_r0_rbl u_t006_011/c3_r1_rbl
+ u_t006_011/r0_w0_wl u_t006_011/r0_w1_wl u_t006_011/r0_r0_rwl u_t006_011/r0_r1_rwl
+ u_t006_011/r1_w0_wl u_t006_011/r1_w1_wl u_t006_011/r1_r0_rwl u_t006_011/r1_r1_rwl
+ u_t006_011/r2_w0_wl u_t006_011/r2_w1_wl u_t006_011/r2_r0_rwl u_t006_011/r2_r1_rwl
+ u_t006_011/r3_w0_wl u_t006_011/r3_w1_wl u_t006_011/r3_r0_rwl u_t006_011/r3_r1_rwl
+ u_t006_011/VDD u_t006_011/VSS VSUBS detronyx_12t_2w2r_rc4_4x4_routed_5layer_direct
Xu_t012_014 u_t012_014/c0_w0_bl u_t012_014/c0_w0_br u_t012_014/c0_w1_bl u_t012_014/c0_w1_br
+ u_t012_014/c0_r0_rbl u_t012_014/c0_r1_rbl u_t012_014/c1_w0_bl u_t012_014/c1_w0_br
+ u_t012_014/c1_w1_bl u_t012_014/c1_w1_br u_t012_014/c1_r0_rbl u_t012_014/c1_r1_rbl
+ u_t012_014/c2_w0_bl u_t012_014/c2_w0_br u_t012_014/c2_w1_bl u_t012_014/c2_w1_br
+ u_t012_014/c2_r0_rbl u_t012_014/c2_r1_rbl u_t012_014/c3_w0_bl u_t012_014/c3_w0_br
+ u_t012_014/c3_w1_bl u_t012_014/c3_w1_br u_t012_014/c3_r0_rbl u_t012_014/c3_r1_rbl
+ u_t012_014/r0_w0_wl u_t012_014/r0_w1_wl u_t012_014/r0_r0_rwl u_t012_014/r0_r1_rwl
+ u_t012_014/r1_w0_wl u_t012_014/r1_w1_wl u_t012_014/r1_r0_rwl u_t012_014/r1_r1_rwl
+ u_t012_014/r2_w0_wl u_t012_014/r2_w1_wl u_t012_014/r2_r0_rwl u_t012_014/r2_r1_rwl
+ u_t012_014/r3_w0_wl u_t012_014/r3_w1_wl u_t012_014/r3_r0_rwl u_t012_014/r3_r1_rwl
+ u_t012_014/VDD u_t012_015/VSS VSUBS detronyx_12t_2w2r_rc4_4x4_routed_5layer_direct
Xu_t012_003 u_t012_003/c0_w0_bl u_t012_003/c0_w0_br u_t012_003/c0_w1_bl u_t012_003/c0_w1_br
+ u_t012_003/c0_r0_rbl u_t012_003/c0_r1_rbl u_t012_003/c1_w0_bl u_t012_003/c1_w0_br
+ u_t012_003/c1_w1_bl u_t012_003/c1_w1_br u_t012_003/c1_r0_rbl u_t012_003/c1_r1_rbl
+ u_t012_003/c2_w0_bl u_t012_003/c2_w0_br u_t012_003/c2_w1_bl u_t012_003/c2_w1_br
+ u_t012_003/c2_r0_rbl u_t012_003/c2_r1_rbl u_t012_003/c3_w0_bl u_t012_003/c3_w0_br
+ u_t012_003/c3_w1_bl u_t012_003/c3_w1_br u_t012_003/c3_r0_rbl u_t012_003/c3_r1_rbl
+ u_t012_003/r0_w0_wl u_t012_003/r0_w1_wl u_t012_003/r0_r0_rwl u_t012_003/r0_r1_rwl
+ u_t012_003/r1_w0_wl u_t012_003/r1_w1_wl u_t012_003/r1_r0_rwl u_t012_003/r1_r1_rwl
+ u_t012_003/r2_w0_wl u_t012_003/r2_w1_wl u_t012_003/r2_r0_rwl u_t012_003/r2_r1_rwl
+ u_t012_003/r3_w0_wl u_t012_003/r3_w1_wl u_t012_003/r3_r0_rwl u_t012_003/r3_r1_rwl
+ u_t012_003/VDD u_t012_015/VSS VSUBS detronyx_12t_2w2r_rc4_4x4_routed_5layer_direct
Xgf180mcu_as_sc_mcu7t3v3__inv_2_924 gf180mcu_as_sc_mcu7t3v3__inv_2_926/VDD gf180mcu_as_sc_mcu7t3v3__inv_2_66/VDD
+ VSS VSS gf180mcu_as_sc_mcu7t3v3__inv_2_926/VNW VSUBS gf180mcu_as_sc_mcu7t3v3__inv_2
Xgf180mcu_as_sc_mcu7t3v3__inv_2_913 gf180mcu_as_sc_mcu7t3v3__inv_2_914/VDD gf180mcu_as_sc_mcu7t3v3__inv_2_917/VDD
+ gf180mcu_as_sc_mcu7t3v3__inv_2_913/Y gf180mcu_as_sc_mcu7t3v3__inv_2_917/Y gf180mcu_as_sc_mcu7t3v3__inv_2_914/VNW
+ VSUBS gf180mcu_as_sc_mcu7t3v3__inv_2
Xgf180mcu_as_sc_mcu7t3v3__inv_2_902 gf180mcu_as_sc_mcu7t3v3__inv_2_902/VDD gf180mcu_as_sc_mcu7t3v3__inv_2_905/VDD
+ gf180mcu_as_sc_mcu7t3v3__inv_2_908/Y VSS gf180mcu_as_sc_mcu7t3v3__inv_2_902/VNW
+ VSUBS gf180mcu_as_sc_mcu7t3v3__inv_2
Xu_t003_003 u_t003_003/c0_w0_bl u_t003_003/c0_w0_br u_t003_003/c0_w1_bl u_t003_003/c0_w1_br
+ u_t003_003/c0_r0_rbl u_t003_003/c0_r1_rbl u_t003_003/c1_w0_bl u_t003_003/c1_w0_br
+ u_t003_003/c1_w1_bl u_t003_003/c1_w1_br u_t003_003/c1_r0_rbl u_t003_003/c1_r1_rbl
+ u_t003_003/c2_w0_bl u_t003_003/c2_w0_br u_t003_003/c2_w1_bl u_t003_003/c2_w1_br
+ u_t003_003/c2_r0_rbl u_t003_003/c2_r1_rbl u_t003_003/c3_w0_bl u_t003_003/c3_w0_br
+ u_t003_003/c3_w1_bl u_t003_003/c3_w1_br u_t003_003/c3_r0_rbl u_t003_003/c3_r1_rbl
+ u_t003_003/r0_w0_wl u_t003_003/r0_w1_wl u_t003_003/r0_r0_rwl u_t003_003/r0_r1_rwl
+ u_t003_003/r1_w0_wl u_t003_003/r1_w1_wl u_t003_003/r1_r0_rwl u_t003_003/r1_r1_rwl
+ u_t003_003/r2_w0_wl u_t003_003/r2_w1_wl u_t003_003/r2_r0_rwl u_t003_003/r2_r1_rwl
+ u_t003_003/r3_w0_wl u_t003_003/r3_w1_wl u_t003_003/r3_r0_rwl u_t003_003/r3_r1_rwl
+ u_t004_003/VDD u_t003_003/VSS VSUBS detronyx_12t_2w2r_rc4_4x4_routed_5layer_direct
Xu_t003_014 u_t003_014/c0_w0_bl u_t003_014/c0_w0_br u_t003_014/c0_w1_bl u_t003_014/c0_w1_br
+ u_t003_014/c0_r0_rbl u_t003_014/c0_r1_rbl u_t003_014/c1_w0_bl u_t003_014/c1_w0_br
+ u_t003_014/c1_w1_bl u_t003_014/c1_w1_br u_t003_014/c1_r0_rbl u_t003_014/c1_r1_rbl
+ u_t003_014/c2_w0_bl u_t003_014/c2_w0_br u_t003_014/c2_w1_bl u_t003_014/c2_w1_br
+ u_t003_014/c2_r0_rbl u_t003_014/c2_r1_rbl u_t003_014/c3_w0_bl u_t003_014/c3_w0_br
+ u_t003_014/c3_w1_bl u_t003_014/c3_w1_br u_t003_014/c3_r0_rbl u_t003_014/c3_r1_rbl
+ u_t003_014/r0_w0_wl u_t003_014/r0_w1_wl u_t003_014/r0_r0_rwl u_t003_014/r0_r1_rwl
+ u_t003_014/r1_w0_wl u_t003_014/r1_w1_wl u_t003_014/r1_r0_rwl u_t003_014/r1_r1_rwl
+ u_t003_014/r2_w0_wl u_t003_014/r2_w1_wl u_t003_014/r2_r0_rwl u_t003_014/r2_r1_rwl
+ u_t003_014/r3_w0_wl u_t003_014/r3_w1_wl u_t003_014/r3_r0_rwl u_t003_014/r3_r1_rwl
+ u_t004_014/VDD u_t003_015/VSS VSUBS detronyx_12t_2w2r_rc4_4x4_routed_5layer_direct
Xgf180mcu_as_sc_mcu7t3v3__nand4_2_201 gf180mcu_as_sc_mcu7t3v3__inv_2_761/VDD VSS VSS
+ VSS VSS VSS VSS gf180mcu_as_sc_mcu7t3v3__inv_2_761/VNW VSUBS gf180mcu_as_sc_mcu7t3v3__nand4_2
Xgf180mcu_as_sc_mcu7t3v3__nand4_2_256 VSS VSS VSS VSS VSS VSS gf180mcu_as_sc_mcu7t3v3__nand4_2_256/Y
+ gf180mcu_as_sc_mcu7t3v3__inv_2_929/VNW VSUBS gf180mcu_as_sc_mcu7t3v3__nand4_2
Xgf180mcu_as_sc_mcu7t3v3__nand4_2_212 gf180mcu_as_sc_mcu7t3v3__inv_2_794/VDD gf180mcu_as_sc_mcu7t3v3__inv_2_797/VDD
+ VSS VSS VSS VSS VSS gf180mcu_as_sc_mcu7t3v3__inv_2_794/VNW VSUBS gf180mcu_as_sc_mcu7t3v3__nand4_2
Xgf180mcu_as_sc_mcu7t3v3__nand4_2_223 gf180mcu_as_sc_mcu7t3v3__inv_2_827/VDD gf180mcu_as_sc_mcu7t3v3__inv_2_830/VSS
+ VSS VSS VSS VSS gf180mcu_as_sc_mcu7t3v3__nand4_2_223/Y gf180mcu_as_sc_mcu7t3v3__inv_2_827/VNW
+ VSUBS gf180mcu_as_sc_mcu7t3v3__nand4_2
Xgf180mcu_as_sc_mcu7t3v3__nand4_2_234 gf180mcu_as_sc_mcu7t3v3__inv_2_860/VDD gf180mcu_as_sc_mcu7t3v3__inv_2_863/VDD
+ VSS VSS VSS VSS VSS gf180mcu_as_sc_mcu7t3v3__inv_2_860/VNW VSUBS gf180mcu_as_sc_mcu7t3v3__nand4_2
Xgf180mcu_as_sc_mcu7t3v3__nand4_2_245 gf180mcu_as_sc_mcu7t3v3__inv_2_893/VDD gf180mcu_as_sc_mcu7t3v3__inv_2_896/VDD
+ VSS VSS VSS VSS VSS gf180mcu_as_sc_mcu7t3v3__inv_2_893/VNW VSUBS gf180mcu_as_sc_mcu7t3v3__nand4_2
Xgf180mcu_as_sc_mcu7t3v3__inv_2_209 gf180mcu_as_sc_mcu7t3v3__nand2_2_9/VDD gf180mcu_as_sc_mcu7t3v3__nor2_2_4/VSS
+ VSS VSS gf180mcu_as_sc_mcu7t3v3__nand2_2_9/VNW VSUBS gf180mcu_as_sc_mcu7t3v3__inv_2
Xu_t000_006 u_t000_006/c0_w0_bl u_t000_006/c0_w0_br u_t000_006/c0_w1_bl u_t000_006/c0_w1_br
+ u_t000_006/c0_r0_rbl u_t000_006/c0_r1_rbl u_t000_006/c1_w0_bl u_t000_006/c1_w0_br
+ u_t000_006/c1_w1_bl u_t000_006/c1_w1_br u_t000_006/c1_r0_rbl u_t000_006/c1_r1_rbl
+ u_t000_006/c2_w0_bl u_t000_006/c2_w0_br u_t000_006/c2_w1_bl u_t000_006/c2_w1_br
+ u_t000_006/c2_r0_rbl u_t000_006/c2_r1_rbl u_t000_006/c3_w0_bl u_t000_006/c3_w0_br
+ u_t000_006/c3_w1_bl u_t000_006/c3_w1_br u_t000_006/c3_r0_rbl u_t000_006/c3_r1_rbl
+ u_t000_006/r0_w0_wl u_t000_006/r0_w1_wl u_t000_006/r0_r0_rwl u_t000_006/r0_r1_rwl
+ u_t000_006/r1_w0_wl u_t000_006/r1_w1_wl u_t000_006/r1_r0_rwl u_t000_006/r1_r1_rwl
+ u_t000_006/r2_w0_wl u_t000_006/r2_w1_wl u_t000_006/r2_r0_rwl u_t000_006/r2_r1_rwl
+ u_t000_006/r3_w0_wl u_t000_006/r3_w1_wl u_t000_006/r3_r0_rwl u_t000_006/r3_r1_rwl
+ u_t000_006/VDD u_t000_015/VSS VSUBS detronyx_12t_2w2r_rc4_4x4_routed_5layer_direct
Xgf180mcu_as_sc_mcu7t3v3__inv_2_765 VSS gf180mcu_as_sc_mcu7t3v3__inv_2_923/VDD VSS
+ gf180mcu_as_sc_mcu7t3v3__inv_2_923/Y gf180mcu_as_sc_mcu7t3v3__inv_2_767/VNW VSUBS
+ gf180mcu_as_sc_mcu7t3v3__inv_2
Xgf180mcu_as_sc_mcu7t3v3__inv_2_754 VSS VSS gf180mcu_as_sc_mcu7t3v3__inv_2_761/Y gf180mcu_as_sc_mcu7t3v3__inv_2_761/Y
+ gf180mcu_as_sc_mcu7t3v3__inv_2_755/VNW VSUBS gf180mcu_as_sc_mcu7t3v3__inv_2
Xgf180mcu_as_sc_mcu7t3v3__inv_2_798 gf180mcu_as_sc_mcu7t3v3__inv_2_800/VDD gf180mcu_as_sc_mcu7t3v3__inv_2_803/VDD
+ gf180mcu_as_sc_mcu7t3v3__inv_2_798/Y VSS gf180mcu_as_sc_mcu7t3v3__inv_2_800/VNW
+ VSUBS gf180mcu_as_sc_mcu7t3v3__inv_2
Xgf180mcu_as_sc_mcu7t3v3__inv_2_743 gf180mcu_as_sc_mcu7t3v3__inv_2_743/VDD gf180mcu_as_sc_mcu7t3v3__inv_2_746/VDD
+ gf180mcu_as_sc_mcu7t3v3__inv_2_743/Y VSS gf180mcu_as_sc_mcu7t3v3__inv_2_743/VNW
+ VSUBS gf180mcu_as_sc_mcu7t3v3__inv_2
Xgf180mcu_as_sc_mcu7t3v3__inv_2_787 gf180mcu_as_sc_mcu7t3v3__inv_2_788/VDD gf180mcu_as_sc_mcu7t3v3__inv_2_791/VDD
+ VSS VSS gf180mcu_as_sc_mcu7t3v3__inv_2_788/VNW VSUBS gf180mcu_as_sc_mcu7t3v3__inv_2
Xgf180mcu_as_sc_mcu7t3v3__inv_2_732 gf180mcu_as_sc_mcu7t3v3__inv_2_734/VDD gf180mcu_as_sc_mcu7t3v3__inv_2_737/VDD
+ VSS gf180mcu_as_sc_mcu7t3v3__inv_2_743/Y gf180mcu_as_sc_mcu7t3v3__inv_2_734/VNW
+ VSUBS gf180mcu_as_sc_mcu7t3v3__inv_2
Xgf180mcu_as_sc_mcu7t3v3__inv_2_776 gf180mcu_as_sc_mcu7t3v3__inv_2_776/VDD gf180mcu_as_sc_mcu7t3v3__inv_2_776/VSS
+ gf180mcu_as_sc_mcu7t3v3__inv_2_776/Y VSS gf180mcu_as_sc_mcu7t3v3__inv_2_776/VNW
+ VSUBS gf180mcu_as_sc_mcu7t3v3__inv_2
Xgf180mcu_as_sc_mcu7t3v3__inv_2_721 VSS VSS VSS VSS gf180mcu_as_sc_mcu7t3v3__inv_2_722/VNW
+ VSUBS gf180mcu_as_sc_mcu7t3v3__inv_2
Xgf180mcu_as_sc_mcu7t3v3__inv_2_710 gf180mcu_as_sc_mcu7t3v3__nor2_2_8/VDD gf180mcu_as_sc_mcu7t3v3__inv_2_710/VSS
+ VSS VSS gf180mcu_as_sc_mcu7t3v3__nor2_2_8/VNW VSUBS gf180mcu_as_sc_mcu7t3v3__inv_2
Xgf180mcu_as_sc_mcu7t3v3__nand4_2_1 gf180mcu_as_sc_mcu7t3v3__inv_2_9/VSS gf180mcu_as_sc_mcu7t3v3__inv_2_8/VDD
+ VSS VSS VSS VSS VSS gf180mcu_as_sc_mcu7t3v3__inv_2_5/VNW VSUBS gf180mcu_as_sc_mcu7t3v3__nand4_2
Xgf180mcu_as_sc_mcu7t3v3__inv_2_562 gf180mcu_as_sc_mcu7t3v3__inv_2_564/VDD VSS VSS
+ gf180mcu_as_sc_mcu7t3v3__inv_2_562/A gf180mcu_as_sc_mcu7t3v3__inv_2_564/VNW VSUBS
+ gf180mcu_as_sc_mcu7t3v3__inv_2
Xgf180mcu_as_sc_mcu7t3v3__inv_2_551 gf180mcu_as_sc_mcu7t3v3__inv_2_552/VDD gf180mcu_as_sc_mcu7t3v3__inv_2_555/VDD
+ gf180mcu_as_sc_mcu7t3v3__inv_2_551/Y gf180mcu_as_sc_mcu7t3v3__inv_2_552/Y gf180mcu_as_sc_mcu7t3v3__inv_2_552/VNW
+ VSUBS gf180mcu_as_sc_mcu7t3v3__inv_2
Xgf180mcu_as_sc_mcu7t3v3__inv_2_540 gf180mcu_as_sc_mcu7t3v3__inv_2_540/VDD gf180mcu_as_sc_mcu7t3v3__inv_2_543/VDD
+ gf180mcu_as_sc_mcu7t3v3__inv_2_540/Y VSS gf180mcu_as_sc_mcu7t3v3__inv_2_540/VNW
+ VSUBS gf180mcu_as_sc_mcu7t3v3__inv_2
Xgf180mcu_as_sc_mcu7t3v3__inv_2_573 VSS VSS gf180mcu_as_sc_mcu7t3v3__inv_2_573/Y VSS
+ gf180mcu_as_sc_mcu7t3v3__inv_2_573/VNW VSUBS gf180mcu_as_sc_mcu7t3v3__inv_2
Xgf180mcu_as_sc_mcu7t3v3__inv_2_595 VSS gf180mcu_as_sc_mcu7t3v3__inv_2_600/VDD gf180mcu_as_sc_mcu7t3v3__inv_2_595/Y
+ gf180mcu_as_sc_mcu7t3v3__inv_2_611/Y gf180mcu_as_sc_mcu7t3v3__inv_2_597/VNW VSUBS
+ gf180mcu_as_sc_mcu7t3v3__inv_2
Xgf180mcu_as_sc_mcu7t3v3__inv_2_584 VSS VSS gf180mcu_as_sc_mcu7t3v3__inv_2_589/A gf180mcu_as_sc_mcu7t3v3__inv_2_585/Y
+ gf180mcu_as_sc_mcu7t3v3__inv_2_585/VNW VSUBS gf180mcu_as_sc_mcu7t3v3__inv_2
Xgf180mcu_as_sc_mcu7t3v3__inv_2_370 gf180mcu_as_sc_mcu7t3v3__inv_2_372/VDD gf180mcu_as_sc_mcu7t3v3__inv_2_375/VDD
+ gf180mcu_as_sc_mcu7t3v3__inv_2_370/Y gf180mcu_as_sc_mcu7t3v3__inv_2_930/A gf180mcu_as_sc_mcu7t3v3__inv_2_372/VNW
+ VSUBS gf180mcu_as_sc_mcu7t3v3__inv_2
Xgf180mcu_as_sc_mcu7t3v3__inv_2_392 VSS gf180mcu_as_sc_mcu7t3v3__inv_2_396/VDD gf180mcu_as_sc_mcu7t3v3__inv_2_392/Y
+ gf180mcu_as_sc_mcu7t3v3__inv_2_393/Y gf180mcu_as_sc_mcu7t3v3__inv_2_393/VNW VSUBS
+ gf180mcu_as_sc_mcu7t3v3__inv_2
Xgf180mcu_as_sc_mcu7t3v3__inv_2_381 VSS gf180mcu_as_sc_mcu7t3v3__inv_2_384/VDD gf180mcu_as_sc_mcu7t3v3__inv_2_381/Y
+ VSS gf180mcu_as_sc_mcu7t3v3__inv_2_381/VNW VSUBS gf180mcu_as_sc_mcu7t3v3__inv_2
Xgf180mcu_as_sc_mcu7t3v3__nand3_2_13 gf180mcu_as_sc_mcu7t3v3__nor2_2_4/VDD gf180mcu_as_sc_mcu7t3v3__nand3_2_8/VSS
+ VSS VSS VSS VSS gf180mcu_as_sc_mcu7t3v3__nor2_2_4/VNW VSUBS gf180mcu_as_sc_mcu7t3v3__nand3_2
Xgf180mcu_as_sc_mcu7t3v3__nand3_2_24 gf180mcu_as_sc_mcu7t3v3__inv_2_713/VDD gf180mcu_as_sc_mcu7t3v3__nor2_2_8/VSS
+ VSS VSS VSS VSS gf180mcu_as_sc_mcu7t3v3__inv_2_713/VNW VSUBS gf180mcu_as_sc_mcu7t3v3__nand3_2
Xu_t015_012 u_t015_012/c0_w0_bl u_t015_012/c0_w0_br u_t015_012/c0_w1_bl u_t015_012/c0_w1_br
+ u_t015_012/c0_r0_rbl u_t015_012/c0_r1_rbl u_t015_012/c1_w0_bl u_t015_012/c1_w0_br
+ u_t015_012/c1_w1_bl u_t015_012/c1_w1_br u_t015_012/c1_r0_rbl u_t015_012/c1_r1_rbl
+ u_t015_012/c2_w0_bl u_t015_012/c2_w0_br u_t015_012/c2_w1_bl u_t015_012/c2_w1_br
+ u_t015_012/c2_r0_rbl u_t015_012/c2_r1_rbl u_t015_012/c3_w0_bl u_t015_012/c3_w0_br
+ u_t015_012/c3_w1_bl u_t015_012/c3_w1_br u_t015_012/c3_r0_rbl u_t015_012/c3_r1_rbl
+ u_t015_012/r0_w0_wl u_t015_012/r0_w1_wl u_t015_012/r0_r0_rwl u_t015_012/r0_r1_rwl
+ u_t015_012/r1_w0_wl u_t015_012/r1_w1_wl u_t015_012/r1_r0_rwl u_t015_012/r1_r1_rwl
+ u_t015_012/r2_w0_wl u_t015_012/r2_w1_wl u_t015_012/r2_r0_rwl u_t015_012/r2_r1_rwl
+ u_t015_012/r3_w0_wl u_t015_012/r3_w1_wl u_t015_012/r3_r0_rwl u_t015_012/r3_r1_rwl
+ u_t015_012/VDD u_t015_012/VSS VSUBS detronyx_12t_2w2r_rc4_4x4_routed_5layer_direct
Xu_t015_001 u_t015_001/c0_w0_bl u_t015_001/c0_w0_br u_t015_001/c0_w1_bl u_t015_001/c0_w1_br
+ u_t015_001/c0_r0_rbl u_t015_001/c0_r1_rbl u_t015_001/c1_w0_bl u_t015_001/c1_w0_br
+ u_t015_001/c1_w1_bl u_t015_001/c1_w1_br u_t015_001/c1_r0_rbl u_t015_001/c1_r1_rbl
+ u_t015_001/c2_w0_bl u_t015_001/c2_w0_br u_t015_001/c2_w1_bl u_t015_001/c2_w1_br
+ u_t015_001/c2_r0_rbl u_t015_001/c2_r1_rbl u_t015_001/c3_w0_bl u_t015_001/c3_w0_br
+ u_t015_001/c3_w1_bl u_t015_001/c3_w1_br u_t015_001/c3_r0_rbl u_t015_001/c3_r1_rbl
+ u_t015_001/r0_w0_wl u_t015_001/r0_w1_wl u_t015_001/r0_r0_rwl u_t015_001/r0_r1_rwl
+ u_t015_001/r1_w0_wl u_t015_001/r1_w1_wl u_t015_001/r1_r0_rwl u_t015_001/r1_r1_rwl
+ u_t015_001/r2_w0_wl u_t015_001/r2_w1_wl u_t015_001/r2_r0_rwl u_t015_001/r2_r1_rwl
+ u_t015_001/r3_w0_wl u_t015_001/r3_w1_wl u_t015_001/r3_r0_rwl u_t015_001/r3_r1_rwl
+ VSS u_t015_002/VSS VSUBS detronyx_12t_2w2r_rc4_4x4_routed_5layer_direct
Xgf180mcu_as_sc_mcu7t3v3__inv_2_6 gf180mcu_as_sc_mcu7t3v3__inv_2_8/VDD VSS VSS gf180mcu_as_sc_mcu7t3v3__inv_2_9/A
+ gf180mcu_as_sc_mcu7t3v3__inv_2_8/VNW VSUBS gf180mcu_as_sc_mcu7t3v3__inv_2
Xu_t006_001 u_t006_001/c0_w0_bl u_t006_001/c0_w0_br u_t006_001/c0_w1_bl u_t006_001/c0_w1_br
+ u_t006_001/c0_r0_rbl u_t006_001/c0_r1_rbl u_t006_001/c1_w0_bl u_t006_001/c1_w0_br
+ u_t006_001/c1_w1_bl u_t006_001/c1_w1_br u_t006_001/c1_r0_rbl u_t006_001/c1_r1_rbl
+ u_t006_001/c2_w0_bl u_t006_001/c2_w0_br u_t006_001/c2_w1_bl u_t006_001/c2_w1_br
+ u_t006_001/c2_r0_rbl u_t006_001/c2_r1_rbl u_t006_001/c3_w0_bl u_t006_001/c3_w0_br
+ u_t006_001/c3_w1_bl u_t006_001/c3_w1_br u_t006_001/c3_r0_rbl u_t006_001/c3_r1_rbl
+ u_t006_001/r0_w0_wl u_t006_001/r0_w1_wl u_t006_001/r0_r0_rwl u_t006_001/r0_r1_rwl
+ u_t006_001/r1_w0_wl u_t006_001/r1_w1_wl u_t006_001/r1_r0_rwl u_t006_001/r1_r1_rwl
+ u_t006_001/r2_w0_wl u_t006_001/r2_w1_wl u_t006_001/r2_r0_rwl u_t006_001/r2_r1_rwl
+ u_t006_001/r3_w0_wl u_t006_001/r3_w1_wl u_t006_001/r3_r0_rwl u_t006_001/r3_r1_rwl
+ VSS u_t006_002/VSS VSUBS detronyx_12t_2w2r_rc4_4x4_routed_5layer_direct
Xu_t006_012 u_t006_012/c0_w0_bl u_t006_012/c0_w0_br u_t006_012/c0_w1_bl u_t006_012/c0_w1_br
+ u_t006_012/c0_r0_rbl u_t006_012/c0_r1_rbl u_t006_012/c1_w0_bl u_t006_012/c1_w0_br
+ u_t006_012/c1_w1_bl u_t006_012/c1_w1_br u_t006_012/c1_r0_rbl u_t006_012/c1_r1_rbl
+ u_t006_012/c2_w0_bl u_t006_012/c2_w0_br u_t006_012/c2_w1_bl u_t006_012/c2_w1_br
+ u_t006_012/c2_r0_rbl u_t006_012/c2_r1_rbl u_t006_012/c3_w0_bl u_t006_012/c3_w0_br
+ u_t006_012/c3_w1_bl u_t006_012/c3_w1_br u_t006_012/c3_r0_rbl u_t006_012/c3_r1_rbl
+ u_t006_012/r0_w0_wl u_t006_012/r0_w1_wl u_t006_012/r0_r0_rwl u_t006_012/r0_r1_rwl
+ u_t006_012/r1_w0_wl u_t006_012/r1_w1_wl u_t006_012/r1_r0_rwl u_t006_012/r1_r1_rwl
+ u_t006_012/r2_w0_wl u_t006_012/r2_w1_wl u_t006_012/r2_r0_rwl u_t006_012/r2_r1_rwl
+ u_t006_012/r3_w0_wl u_t006_012/r3_w1_wl u_t006_012/r3_r0_rwl u_t006_012/r3_r1_rwl
+ u_t006_012/VDD u_t006_012/VSS VSUBS detronyx_12t_2w2r_rc4_4x4_routed_5layer_direct
Xu_t012_015 u_t012_015/c0_w0_bl u_t012_015/c0_w0_br u_t012_015/c0_w1_bl u_t012_015/c0_w1_br
+ u_t012_015/c0_r0_rbl u_t012_015/c0_r1_rbl u_t012_015/c1_w0_bl u_t012_015/c1_w0_br
+ u_t012_015/c1_w1_bl u_t012_015/c1_w1_br u_t012_015/c1_r0_rbl u_t012_015/c1_r1_rbl
+ u_t012_015/c2_w0_bl u_t012_015/c2_w0_br u_t012_015/c2_w1_bl u_t012_015/c2_w1_br
+ u_t012_015/c2_r0_rbl u_t012_015/c2_r1_rbl u_t012_015/c3_w0_bl u_t012_015/c3_w0_br
+ u_t012_015/c3_w1_bl u_t012_015/c3_w1_br u_t012_015/c3_r0_rbl u_t012_015/c3_r1_rbl
+ u_t012_015/r0_w0_wl u_t012_015/r0_w1_wl u_t012_015/r0_r0_rwl u_t012_015/r0_r1_rwl
+ u_t012_015/r1_w0_wl u_t012_015/r1_w1_wl u_t012_015/r1_r0_rwl u_t012_015/r1_r1_rwl
+ u_t012_015/r2_w0_wl u_t012_015/r2_w1_wl u_t012_015/r2_r0_rwl u_t012_015/r2_r1_rwl
+ u_t012_015/r3_w0_wl u_t012_015/r3_w1_wl u_t012_015/r3_r0_rwl u_t012_015/r3_r1_rwl
+ VSS u_t012_015/VSS VSUBS detronyx_12t_2w2r_rc4_4x4_routed_5layer_direct
Xu_t012_004 u_t012_004/c0_w0_bl u_t012_004/c0_w0_br u_t012_004/c0_w1_bl u_t012_004/c0_w1_br
+ u_t012_004/c0_r0_rbl u_t012_004/c0_r1_rbl u_t012_004/c1_w0_bl u_t012_004/c1_w0_br
+ u_t012_004/c1_w1_bl u_t012_004/c1_w1_br u_t012_004/c1_r0_rbl u_t012_004/c1_r1_rbl
+ u_t012_004/c2_w0_bl u_t012_004/c2_w0_br u_t012_004/c2_w1_bl u_t012_004/c2_w1_br
+ u_t012_004/c2_r0_rbl u_t012_004/c2_r1_rbl u_t012_004/c3_w0_bl u_t012_004/c3_w0_br
+ u_t012_004/c3_w1_bl u_t012_004/c3_w1_br u_t012_004/c3_r0_rbl u_t012_004/c3_r1_rbl
+ u_t012_004/r0_w0_wl u_t012_004/r0_w1_wl u_t012_004/r0_r0_rwl u_t012_004/r0_r1_rwl
+ u_t012_004/r1_w0_wl u_t012_004/r1_w1_wl u_t012_004/r1_r0_rwl u_t012_004/r1_r1_rwl
+ u_t012_004/r2_w0_wl u_t012_004/r2_w1_wl u_t012_004/r2_r0_rwl u_t012_004/r2_r1_rwl
+ u_t012_004/r3_w0_wl u_t012_004/r3_w1_wl u_t012_004/r3_r0_rwl u_t012_004/r3_r1_rwl
+ u_t012_004/VDD u_t012_015/VSS VSUBS detronyx_12t_2w2r_rc4_4x4_routed_5layer_direct
Xgf180mcu_as_sc_mcu7t3v3__inv_2_925 gf180mcu_as_sc_mcu7t3v3__inv_2_926/VDD gf180mcu_as_sc_mcu7t3v3__inv_2_66/VDD
+ gf180mcu_as_sc_mcu7t3v3__inv_2_925/Y VSS gf180mcu_as_sc_mcu7t3v3__inv_2_926/VNW
+ VSUBS gf180mcu_as_sc_mcu7t3v3__inv_2
Xgf180mcu_as_sc_mcu7t3v3__inv_2_914 gf180mcu_as_sc_mcu7t3v3__inv_2_914/VDD gf180mcu_as_sc_mcu7t3v3__inv_2_917/VDD
+ gf180mcu_as_sc_mcu7t3v3__inv_2_917/Y VSS gf180mcu_as_sc_mcu7t3v3__inv_2_914/VNW
+ VSUBS gf180mcu_as_sc_mcu7t3v3__inv_2
Xgf180mcu_as_sc_mcu7t3v3__inv_2_903 gf180mcu_as_sc_mcu7t3v3__inv_2_905/VDD gf180mcu_as_sc_mcu7t3v3__inv_2_908/VDD
+ VSS gf180mcu_as_sc_mcu7t3v3__inv_2_908/Y gf180mcu_as_sc_mcu7t3v3__inv_2_905/VNW
+ VSUBS gf180mcu_as_sc_mcu7t3v3__inv_2
Xu_t003_004 u_t003_004/c0_w0_bl u_t003_004/c0_w0_br u_t003_004/c0_w1_bl u_t003_004/c0_w1_br
+ u_t003_004/c0_r0_rbl u_t003_004/c0_r1_rbl u_t003_004/c1_w0_bl u_t003_004/c1_w0_br
+ u_t003_004/c1_w1_bl u_t003_004/c1_w1_br u_t003_004/c1_r0_rbl u_t003_004/c1_r1_rbl
+ u_t003_004/c2_w0_bl u_t003_004/c2_w0_br u_t003_004/c2_w1_bl u_t003_004/c2_w1_br
+ u_t003_004/c2_r0_rbl u_t003_004/c2_r1_rbl u_t003_004/c3_w0_bl u_t003_004/c3_w0_br
+ u_t003_004/c3_w1_bl u_t003_004/c3_w1_br u_t003_004/c3_r0_rbl u_t003_004/c3_r1_rbl
+ u_t003_004/r0_w0_wl u_t003_004/r0_w1_wl u_t003_004/r0_r0_rwl u_t003_004/r0_r1_rwl
+ u_t003_004/r1_w0_wl u_t003_004/r1_w1_wl u_t003_004/r1_r0_rwl u_t003_004/r1_r1_rwl
+ u_t003_004/r2_w0_wl u_t003_004/r2_w1_wl u_t003_004/r2_r0_rwl u_t003_004/r2_r1_rwl
+ u_t003_004/r3_w0_wl u_t003_004/r3_w1_wl u_t003_004/r3_r0_rwl u_t003_004/r3_r1_rwl
+ u_t004_004/VDD u_t003_004/VSS VSUBS detronyx_12t_2w2r_rc4_4x4_routed_5layer_direct
Xu_t003_015 u_t003_015/c0_w0_bl u_t003_015/c0_w0_br u_t003_015/c0_w1_bl u_t003_015/c0_w1_br
+ u_t003_015/c0_r0_rbl u_t003_015/c0_r1_rbl u_t003_015/c1_w0_bl u_t003_015/c1_w0_br
+ u_t003_015/c1_w1_bl u_t003_015/c1_w1_br u_t003_015/c1_r0_rbl u_t003_015/c1_r1_rbl
+ u_t003_015/c2_w0_bl u_t003_015/c2_w0_br u_t003_015/c2_w1_bl u_t003_015/c2_w1_br
+ u_t003_015/c2_r0_rbl u_t003_015/c2_r1_rbl u_t003_015/c3_w0_bl u_t003_015/c3_w0_br
+ u_t003_015/c3_w1_bl u_t003_015/c3_w1_br u_t003_015/c3_r0_rbl u_t003_015/c3_r1_rbl
+ u_t003_015/r0_w0_wl u_t003_015/r0_w1_wl u_t003_015/r0_r0_rwl u_t003_015/r0_r1_rwl
+ u_t003_015/r1_w0_wl u_t003_015/r1_w1_wl u_t003_015/r1_r0_rwl u_t003_015/r1_r1_rwl
+ u_t003_015/r2_w0_wl u_t003_015/r2_w1_wl u_t003_015/r2_r0_rwl u_t003_015/r2_r1_rwl
+ u_t003_015/r3_w0_wl u_t003_015/r3_w1_wl u_t003_015/r3_r0_rwl u_t003_015/r3_r1_rwl
+ VSS u_t003_015/VSS VSUBS detronyx_12t_2w2r_rc4_4x4_routed_5layer_direct
Xgf180mcu_as_sc_mcu7t3v3__nand4_2_202 VSS VSS VSS VSS VSS VSS VSS gf180mcu_as_sc_mcu7t3v3__inv_2_764/VNW
+ VSUBS gf180mcu_as_sc_mcu7t3v3__nand4_2
Xgf180mcu_as_sc_mcu7t3v3__nand4_2_213 gf180mcu_as_sc_mcu7t3v3__inv_2_797/VDD gf180mcu_as_sc_mcu7t3v3__inv_2_800/VDD
+ VSS VSS VSS VSS VSS gf180mcu_as_sc_mcu7t3v3__inv_2_797/VNW VSUBS gf180mcu_as_sc_mcu7t3v3__nand4_2
Xgf180mcu_as_sc_mcu7t3v3__nand4_2_224 VSS gf180mcu_as_sc_mcu7t3v3__inv_2_872/VSS VSS
+ VSS VSS VSS VSS gf180mcu_as_sc_mcu7t3v3__inv_2_872/VNW VSUBS gf180mcu_as_sc_mcu7t3v3__nand4_2
Xgf180mcu_as_sc_mcu7t3v3__nand4_2_235 gf180mcu_as_sc_mcu7t3v3__inv_2_863/VDD gf180mcu_as_sc_mcu7t3v3__inv_2_866/VDD
+ VSS VSS VSS VSS VSS gf180mcu_as_sc_mcu7t3v3__inv_2_863/VNW VSUBS gf180mcu_as_sc_mcu7t3v3__nand4_2
Xgf180mcu_as_sc_mcu7t3v3__nand4_2_257 gf180mcu_as_sc_mcu7t3v3__inv_2_932/VDD gf180mcu_as_sc_mcu7t3v3__inv_2_932/VSS
+ VSS VSS VSS VSS VSS gf180mcu_as_sc_mcu7t3v3__inv_2_932/VNW VSUBS gf180mcu_as_sc_mcu7t3v3__nand4_2
Xgf180mcu_as_sc_mcu7t3v3__nand4_2_246 gf180mcu_as_sc_mcu7t3v3__inv_2_896/VDD gf180mcu_as_sc_mcu7t3v3__inv_2_899/VDD
+ VSS VSS VSS VSS VSS gf180mcu_as_sc_mcu7t3v3__inv_2_896/VNW VSUBS gf180mcu_as_sc_mcu7t3v3__nand4_2
Xu_t000_007 u_t000_007/c0_w0_bl u_t000_007/c0_w0_br u_t000_007/c0_w1_bl u_t000_007/c0_w1_br
+ u_t000_007/c0_r0_rbl u_t000_007/c0_r1_rbl u_t000_007/c1_w0_bl u_t000_007/c1_w0_br
+ u_t000_007/c1_w1_bl u_t000_007/c1_w1_br u_t000_007/c1_r0_rbl u_t000_007/c1_r1_rbl
+ u_t000_007/c2_w0_bl u_t000_007/c2_w0_br u_t000_007/c2_w1_bl u_t000_007/c2_w1_br
+ u_t000_007/c2_r0_rbl u_t000_007/c2_r1_rbl u_t000_007/c3_w0_bl u_t000_007/c3_w0_br
+ u_t000_007/c3_w1_bl u_t000_007/c3_w1_br u_t000_007/c3_r0_rbl u_t000_007/c3_r1_rbl
+ u_t000_007/r0_w0_wl u_t000_007/r0_w1_wl u_t000_007/r0_r0_rwl u_t000_007/r0_r1_rwl
+ u_t000_007/r1_w0_wl u_t000_007/r1_w1_wl u_t000_007/r1_r0_rwl u_t000_007/r1_r1_rwl
+ u_t000_007/r2_w0_wl u_t000_007/r2_w1_wl u_t000_007/r2_r0_rwl u_t000_007/r2_r1_rwl
+ u_t000_007/r3_w0_wl u_t000_007/r3_w1_wl u_t000_007/r3_r0_rwl u_t000_007/r3_r1_rwl
+ VSS u_t000_015/VSS VSUBS detronyx_12t_2w2r_rc4_4x4_routed_5layer_direct
Xgf180mcu_as_sc_mcu7t3v3__inv_2_700 VSS VSS gf180mcu_as_sc_mcu7t3v3__inv_2_700/Y VSS
+ gf180mcu_as_sc_mcu7t3v3__inv_2_709/VNW VSUBS gf180mcu_as_sc_mcu7t3v3__inv_2
Xgf180mcu_as_sc_mcu7t3v3__inv_2_711 gf180mcu_as_sc_mcu7t3v3__nor2_2_8/VDD gf180mcu_as_sc_mcu7t3v3__nor2_2_8/VSS
+ VSS VSS gf180mcu_as_sc_mcu7t3v3__nor2_2_8/VNW VSUBS gf180mcu_as_sc_mcu7t3v3__inv_2
Xgf180mcu_as_sc_mcu7t3v3__inv_2_766 VSS gf180mcu_as_sc_mcu7t3v3__inv_2_923/VDD gf180mcu_as_sc_mcu7t3v3__inv_2_766/Y
+ gf180mcu_as_sc_mcu7t3v3__inv_2_923/Y gf180mcu_as_sc_mcu7t3v3__inv_2_767/VNW VSUBS
+ gf180mcu_as_sc_mcu7t3v3__inv_2
Xgf180mcu_as_sc_mcu7t3v3__inv_2_755 VSS VSS gf180mcu_as_sc_mcu7t3v3__inv_2_761/Y VSS
+ gf180mcu_as_sc_mcu7t3v3__inv_2_755/VNW VSUBS gf180mcu_as_sc_mcu7t3v3__inv_2
Xgf180mcu_as_sc_mcu7t3v3__inv_2_799 gf180mcu_as_sc_mcu7t3v3__inv_2_800/VDD gf180mcu_as_sc_mcu7t3v3__inv_2_803/VDD
+ gf180mcu_as_sc_mcu7t3v3__inv_2_799/Y VSS gf180mcu_as_sc_mcu7t3v3__inv_2_800/VNW
+ VSUBS gf180mcu_as_sc_mcu7t3v3__inv_2
Xgf180mcu_as_sc_mcu7t3v3__inv_2_744 gf180mcu_as_sc_mcu7t3v3__inv_2_746/VDD gf180mcu_as_sc_mcu7t3v3__inv_2_749/VDD
+ VSS gf180mcu_as_sc_mcu7t3v3__inv_2_752/Y gf180mcu_as_sc_mcu7t3v3__inv_2_746/VNW
+ VSUBS gf180mcu_as_sc_mcu7t3v3__inv_2
Xgf180mcu_as_sc_mcu7t3v3__inv_2_788 gf180mcu_as_sc_mcu7t3v3__inv_2_788/VDD gf180mcu_as_sc_mcu7t3v3__inv_2_791/VDD
+ VSS VSS gf180mcu_as_sc_mcu7t3v3__inv_2_788/VNW VSUBS gf180mcu_as_sc_mcu7t3v3__inv_2
Xgf180mcu_as_sc_mcu7t3v3__inv_2_733 gf180mcu_as_sc_mcu7t3v3__inv_2_734/VDD gf180mcu_as_sc_mcu7t3v3__inv_2_737/VDD
+ gf180mcu_as_sc_mcu7t3v3__inv_2_743/Y gf180mcu_as_sc_mcu7t3v3__inv_2_743/Y gf180mcu_as_sc_mcu7t3v3__inv_2_734/VNW
+ VSUBS gf180mcu_as_sc_mcu7t3v3__inv_2
Xgf180mcu_as_sc_mcu7t3v3__inv_2_777 gf180mcu_as_sc_mcu7t3v3__inv_2_830/VSS gf180mcu_as_sc_mcu7t3v3__inv_2_782/VDD
+ gf180mcu_as_sc_mcu7t3v3__inv_2_777/Y VSS gf180mcu_as_sc_mcu7t3v3__inv_2_779/VNW
+ VSUBS gf180mcu_as_sc_mcu7t3v3__inv_2
Xgf180mcu_as_sc_mcu7t3v3__inv_2_722 VSS VSS gf180mcu_as_sc_mcu7t3v3__inv_2_722/Y VSS
+ gf180mcu_as_sc_mcu7t3v3__inv_2_722/VNW VSUBS gf180mcu_as_sc_mcu7t3v3__inv_2
Xgf180mcu_as_sc_mcu7t3v3__nand4_2_2 gf180mcu_as_sc_mcu7t3v3__inv_2_8/VDD VSS VSS VSS
+ VSS VSS VSS gf180mcu_as_sc_mcu7t3v3__inv_2_8/VNW VSUBS gf180mcu_as_sc_mcu7t3v3__nand4_2
Xgf180mcu_as_sc_mcu7t3v3__inv_2_563 gf180mcu_as_sc_mcu7t3v3__inv_2_564/VDD VSS gf180mcu_as_sc_mcu7t3v3__inv_2_563/Y
+ gf180mcu_as_sc_mcu7t3v3__inv_2_564/Y gf180mcu_as_sc_mcu7t3v3__inv_2_564/VNW VSUBS
+ gf180mcu_as_sc_mcu7t3v3__inv_2
Xgf180mcu_as_sc_mcu7t3v3__inv_2_552 gf180mcu_as_sc_mcu7t3v3__inv_2_552/VDD gf180mcu_as_sc_mcu7t3v3__inv_2_555/VDD
+ gf180mcu_as_sc_mcu7t3v3__inv_2_552/Y VSS gf180mcu_as_sc_mcu7t3v3__inv_2_552/VNW
+ VSUBS gf180mcu_as_sc_mcu7t3v3__inv_2
Xgf180mcu_as_sc_mcu7t3v3__inv_2_541 gf180mcu_as_sc_mcu7t3v3__inv_2_543/VDD gf180mcu_as_sc_mcu7t3v3__inv_2_546/VDD
+ gf180mcu_as_sc_mcu7t3v3__inv_2_541/Y gf180mcu_as_sc_mcu7t3v3__inv_2_545/Y gf180mcu_as_sc_mcu7t3v3__inv_2_543/VNW
+ VSUBS gf180mcu_as_sc_mcu7t3v3__inv_2
Xgf180mcu_as_sc_mcu7t3v3__inv_2_530 VSS gf180mcu_as_sc_mcu7t3v3__inv_2_534/VDD gf180mcu_as_sc_mcu7t3v3__inv_2_530/Y
+ gf180mcu_as_sc_mcu7t3v3__inv_2_531/Y gf180mcu_as_sc_mcu7t3v3__inv_2_531/VNW VSUBS
+ gf180mcu_as_sc_mcu7t3v3__inv_2
Xgf180mcu_as_sc_mcu7t3v3__inv_2_574 VSS gf180mcu_as_sc_mcu7t3v3__inv_2_576/VSS VSS
+ gf180mcu_as_sc_mcu7t3v3__inv_2_574/A gf180mcu_as_sc_mcu7t3v3__inv_2_576/VNW VSUBS
+ gf180mcu_as_sc_mcu7t3v3__inv_2
Xgf180mcu_as_sc_mcu7t3v3__inv_2_596 VSS gf180mcu_as_sc_mcu7t3v3__inv_2_600/VDD gf180mcu_as_sc_mcu7t3v3__inv_2_596/Y
+ gf180mcu_as_sc_mcu7t3v3__inv_2_597/Y gf180mcu_as_sc_mcu7t3v3__inv_2_597/VNW VSUBS
+ gf180mcu_as_sc_mcu7t3v3__inv_2
Xgf180mcu_as_sc_mcu7t3v3__inv_2_585 VSS VSS gf180mcu_as_sc_mcu7t3v3__inv_2_585/Y VSS
+ gf180mcu_as_sc_mcu7t3v3__inv_2_585/VNW VSUBS gf180mcu_as_sc_mcu7t3v3__inv_2
Xgf180mcu_as_sc_mcu7t3v3__inv_2_393 VSS gf180mcu_as_sc_mcu7t3v3__inv_2_396/VDD gf180mcu_as_sc_mcu7t3v3__inv_2_393/Y
+ VSS gf180mcu_as_sc_mcu7t3v3__inv_2_393/VNW VSUBS gf180mcu_as_sc_mcu7t3v3__inv_2
Xgf180mcu_as_sc_mcu7t3v3__inv_2_382 gf180mcu_as_sc_mcu7t3v3__inv_2_384/VDD VSS gf180mcu_as_sc_mcu7t3v3__inv_2_382/Y
+ gf180mcu_as_sc_mcu7t3v3__inv_2_382/A gf180mcu_as_sc_mcu7t3v3__inv_2_384/VNW VSUBS
+ gf180mcu_as_sc_mcu7t3v3__inv_2
Xgf180mcu_as_sc_mcu7t3v3__inv_2_371 gf180mcu_as_sc_mcu7t3v3__inv_2_372/VDD gf180mcu_as_sc_mcu7t3v3__inv_2_375/VDD
+ gf180mcu_as_sc_mcu7t3v3__inv_2_371/Y gf180mcu_as_sc_mcu7t3v3__inv_2_372/Y gf180mcu_as_sc_mcu7t3v3__inv_2_372/VNW
+ VSUBS gf180mcu_as_sc_mcu7t3v3__inv_2
Xgf180mcu_as_sc_mcu7t3v3__inv_2_360 VSS gf180mcu_as_sc_mcu7t3v3__inv_2_363/VDD gf180mcu_as_sc_mcu7t3v3__inv_2_360/Y
+ VSS gf180mcu_as_sc_mcu7t3v3__inv_2_360/VNW VSUBS gf180mcu_as_sc_mcu7t3v3__inv_2
Xgf180mcu_as_sc_mcu7t3v3__nand3_2_14 gf180mcu_as_sc_mcu7t3v3__nor2_2_5/VDD gf180mcu_as_sc_mcu7t3v3__nor2_2_5/VSS
+ VSS VSS VSS VSS gf180mcu_as_sc_mcu7t3v3__nor2_2_5/VNW VSUBS gf180mcu_as_sc_mcu7t3v3__nand3_2
Xgf180mcu_as_sc_mcu7t3v3__nand3_2_25 gf180mcu_as_sc_mcu7t3v3__inv_2_713/VDD gf180mcu_as_sc_mcu7t3v3__inv_2_713/VSS
+ VSS VSS VSS VSS gf180mcu_as_sc_mcu7t3v3__inv_2_713/VNW VSUBS gf180mcu_as_sc_mcu7t3v3__nand3_2
Xu_t009_010 u_t009_010/c0_w0_bl u_t009_010/c0_w0_br u_t009_010/c0_w1_bl u_t009_010/c0_w1_br
+ u_t009_010/c0_r0_rbl u_t009_010/c0_r1_rbl u_t009_010/c1_w0_bl u_t009_010/c1_w0_br
+ u_t009_010/c1_w1_bl u_t009_010/c1_w1_br u_t009_010/c1_r0_rbl u_t009_010/c1_r1_rbl
+ u_t009_010/c2_w0_bl u_t009_010/c2_w0_br u_t009_010/c2_w1_bl u_t009_010/c2_w1_br
+ u_t009_010/c2_r0_rbl u_t009_010/c2_r1_rbl u_t009_010/c3_w0_bl u_t009_010/c3_w0_br
+ u_t009_010/c3_w1_bl u_t009_010/c3_w1_br u_t009_010/c3_r0_rbl u_t009_010/c3_r1_rbl
+ u_t009_010/r0_w0_wl u_t009_010/r0_w1_wl u_t009_010/r0_r0_rwl u_t009_010/r0_r1_rwl
+ u_t009_010/r1_w0_wl u_t009_010/r1_w1_wl u_t009_010/r1_r0_rwl u_t009_010/r1_r1_rwl
+ u_t009_010/r2_w0_wl u_t009_010/r2_w1_wl u_t009_010/r2_r0_rwl u_t009_010/r2_r1_rwl
+ u_t009_010/r3_w0_wl u_t009_010/r3_w1_wl u_t009_010/r3_r0_rwl u_t009_010/r3_r1_rwl
+ VSS u_t009_015/VSS VSUBS detronyx_12t_2w2r_rc4_4x4_routed_5layer_direct
Xgf180mcu_as_sc_mcu7t3v3__inv_2_190 gf180mcu_as_sc_mcu7t3v3__nor2_2_4/VDD gf180mcu_as_sc_mcu7t3v3__nand3_2_8/VSS
+ VSS VSS gf180mcu_as_sc_mcu7t3v3__nor2_2_4/VNW VSUBS gf180mcu_as_sc_mcu7t3v3__inv_2
Xu_t015_013 u_t015_013/c0_w0_bl u_t015_013/c0_w0_br u_t015_013/c0_w1_bl u_t015_013/c0_w1_br
+ u_t015_013/c0_r0_rbl u_t015_013/c0_r1_rbl u_t015_013/c1_w0_bl u_t015_013/c1_w0_br
+ u_t015_013/c1_w1_bl u_t015_013/c1_w1_br u_t015_013/c1_r0_rbl u_t015_013/c1_r1_rbl
+ u_t015_013/c2_w0_bl u_t015_013/c2_w0_br u_t015_013/c2_w1_bl u_t015_013/c2_w1_br
+ u_t015_013/c2_r0_rbl u_t015_013/c2_r1_rbl u_t015_013/c3_w0_bl u_t015_013/c3_w0_br
+ u_t015_013/c3_w1_bl u_t015_013/c3_w1_br u_t015_013/c3_r0_rbl u_t015_013/c3_r1_rbl
+ u_t015_013/r0_w0_wl u_t015_013/r0_w1_wl u_t015_013/r0_r0_rwl u_t015_013/r0_r1_rwl
+ u_t015_013/r1_w0_wl u_t015_013/r1_w1_wl u_t015_013/r1_r0_rwl u_t015_013/r1_r1_rwl
+ u_t015_013/r2_w0_wl u_t015_013/r2_w1_wl u_t015_013/r2_r0_rwl u_t015_013/r2_r1_rwl
+ u_t015_013/r3_w0_wl u_t015_013/r3_w1_wl u_t015_013/r3_r0_rwl u_t015_013/r3_r1_rwl
+ u_t015_013/VDD u_t015_013/VSS VSUBS detronyx_12t_2w2r_rc4_4x4_routed_5layer_direct
Xu_t015_002 u_t015_002/c0_w0_bl u_t015_002/c0_w0_br u_t015_002/c0_w1_bl u_t015_002/c0_w1_br
+ u_t015_002/c0_r0_rbl u_t015_002/c0_r1_rbl u_t015_002/c1_w0_bl u_t015_002/c1_w0_br
+ u_t015_002/c1_w1_bl u_t015_002/c1_w1_br u_t015_002/c1_r0_rbl u_t015_002/c1_r1_rbl
+ u_t015_002/c2_w0_bl u_t015_002/c2_w0_br u_t015_002/c2_w1_bl u_t015_002/c2_w1_br
+ u_t015_002/c2_r0_rbl u_t015_002/c2_r1_rbl u_t015_002/c3_w0_bl u_t015_002/c3_w0_br
+ u_t015_002/c3_w1_bl u_t015_002/c3_w1_br u_t015_002/c3_r0_rbl u_t015_002/c3_r1_rbl
+ u_t015_002/r0_w0_wl u_t015_002/r0_w1_wl u_t015_002/r0_r0_rwl u_t015_002/r0_r1_rwl
+ u_t015_002/r1_w0_wl u_t015_002/r1_w1_wl u_t015_002/r1_r0_rwl u_t015_002/r1_r1_rwl
+ u_t015_002/r2_w0_wl u_t015_002/r2_w1_wl u_t015_002/r2_r0_rwl u_t015_002/r2_r1_rwl
+ u_t015_002/r3_w0_wl u_t015_002/r3_w1_wl u_t015_002/r3_r0_rwl u_t015_002/r3_r1_rwl
+ VSS u_t015_002/VSS VSUBS detronyx_12t_2w2r_rc4_4x4_routed_5layer_direct
Xgf180mcu_as_sc_mcu7t3v3__inv_2_7 gf180mcu_as_sc_mcu7t3v3__inv_2_8/VDD VSS gf180mcu_as_sc_mcu7t3v3__inv_2_9/A
+ gf180mcu_as_sc_mcu7t3v3__inv_2_9/A gf180mcu_as_sc_mcu7t3v3__inv_2_8/VNW VSUBS gf180mcu_as_sc_mcu7t3v3__inv_2
Xu_t006_002 u_t006_002/c0_w0_bl u_t006_002/c0_w0_br u_t006_002/c0_w1_bl u_t006_002/c0_w1_br
+ u_t006_002/c0_r0_rbl u_t006_002/c0_r1_rbl u_t006_002/c1_w0_bl u_t006_002/c1_w0_br
+ u_t006_002/c1_w1_bl u_t006_002/c1_w1_br u_t006_002/c1_r0_rbl u_t006_002/c1_r1_rbl
+ u_t006_002/c2_w0_bl u_t006_002/c2_w0_br u_t006_002/c2_w1_bl u_t006_002/c2_w1_br
+ u_t006_002/c2_r0_rbl u_t006_002/c2_r1_rbl u_t006_002/c3_w0_bl u_t006_002/c3_w0_br
+ u_t006_002/c3_w1_bl u_t006_002/c3_w1_br u_t006_002/c3_r0_rbl u_t006_002/c3_r1_rbl
+ u_t006_002/r0_w0_wl u_t006_002/r0_w1_wl u_t006_002/r0_r0_rwl u_t006_002/r0_r1_rwl
+ u_t006_002/r1_w0_wl u_t006_002/r1_w1_wl u_t006_002/r1_r0_rwl u_t006_002/r1_r1_rwl
+ u_t006_002/r2_w0_wl u_t006_002/r2_w1_wl u_t006_002/r2_r0_rwl u_t006_002/r2_r1_rwl
+ u_t006_002/r3_w0_wl u_t006_002/r3_w1_wl u_t006_002/r3_r0_rwl u_t006_002/r3_r1_rwl
+ VSS u_t006_002/VSS VSUBS detronyx_12t_2w2r_rc4_4x4_routed_5layer_direct
Xu_t006_013 u_t006_013/c0_w0_bl u_t006_013/c0_w0_br u_t006_013/c0_w1_bl u_t006_013/c0_w1_br
+ u_t006_013/c0_r0_rbl u_t006_013/c0_r1_rbl u_t006_013/c1_w0_bl u_t006_013/c1_w0_br
+ u_t006_013/c1_w1_bl u_t006_013/c1_w1_br u_t006_013/c1_r0_rbl u_t006_013/c1_r1_rbl
+ u_t006_013/c2_w0_bl u_t006_013/c2_w0_br u_t006_013/c2_w1_bl u_t006_013/c2_w1_br
+ u_t006_013/c2_r0_rbl u_t006_013/c2_r1_rbl u_t006_013/c3_w0_bl u_t006_013/c3_w0_br
+ u_t006_013/c3_w1_bl u_t006_013/c3_w1_br u_t006_013/c3_r0_rbl u_t006_013/c3_r1_rbl
+ u_t006_013/r0_w0_wl u_t006_013/r0_w1_wl u_t006_013/r0_r0_rwl u_t006_013/r0_r1_rwl
+ u_t006_013/r1_w0_wl u_t006_013/r1_w1_wl u_t006_013/r1_r0_rwl u_t006_013/r1_r1_rwl
+ u_t006_013/r2_w0_wl u_t006_013/r2_w1_wl u_t006_013/r2_r0_rwl u_t006_013/r2_r1_rwl
+ u_t006_013/r3_w0_wl u_t006_013/r3_w1_wl u_t006_013/r3_r0_rwl u_t006_013/r3_r1_rwl
+ u_t006_013/VDD u_t006_013/VSS VSUBS detronyx_12t_2w2r_rc4_4x4_routed_5layer_direct
Xu_t012_005 u_t012_005/c0_w0_bl u_t012_005/c0_w0_br u_t012_005/c0_w1_bl u_t012_005/c0_w1_br
+ u_t012_005/c0_r0_rbl u_t012_005/c0_r1_rbl u_t012_005/c1_w0_bl u_t012_005/c1_w0_br
+ u_t012_005/c1_w1_bl u_t012_005/c1_w1_br u_t012_005/c1_r0_rbl u_t012_005/c1_r1_rbl
+ u_t012_005/c2_w0_bl u_t012_005/c2_w0_br u_t012_005/c2_w1_bl u_t012_005/c2_w1_br
+ u_t012_005/c2_r0_rbl u_t012_005/c2_r1_rbl u_t012_005/c3_w0_bl u_t012_005/c3_w0_br
+ u_t012_005/c3_w1_bl u_t012_005/c3_w1_br u_t012_005/c3_r0_rbl u_t012_005/c3_r1_rbl
+ u_t012_005/r0_w0_wl u_t012_005/r0_w1_wl u_t012_005/r0_r0_rwl u_t012_005/r0_r1_rwl
+ u_t012_005/r1_w0_wl u_t012_005/r1_w1_wl u_t012_005/r1_r0_rwl u_t012_005/r1_r1_rwl
+ u_t012_005/r2_w0_wl u_t012_005/r2_w1_wl u_t012_005/r2_r0_rwl u_t012_005/r2_r1_rwl
+ u_t012_005/r3_w0_wl u_t012_005/r3_w1_wl u_t012_005/r3_r0_rwl u_t012_005/r3_r1_rwl
+ u_t012_005/VDD u_t012_015/VSS VSUBS detronyx_12t_2w2r_rc4_4x4_routed_5layer_direct
Xgf180mcu_as_sc_mcu7t3v3__inv_2_904 gf180mcu_as_sc_mcu7t3v3__inv_2_905/VDD gf180mcu_as_sc_mcu7t3v3__inv_2_908/VDD
+ gf180mcu_as_sc_mcu7t3v3__inv_2_904/Y gf180mcu_as_sc_mcu7t3v3__inv_2_908/Y gf180mcu_as_sc_mcu7t3v3__inv_2_905/VNW
+ VSUBS gf180mcu_as_sc_mcu7t3v3__inv_2
Xgf180mcu_as_sc_mcu7t3v3__inv_2_926 gf180mcu_as_sc_mcu7t3v3__inv_2_926/VDD gf180mcu_as_sc_mcu7t3v3__inv_2_66/VDD
+ gf180mcu_as_sc_mcu7t3v3__inv_2_926/Y VSS gf180mcu_as_sc_mcu7t3v3__inv_2_926/VNW
+ VSUBS gf180mcu_as_sc_mcu7t3v3__inv_2
Xgf180mcu_as_sc_mcu7t3v3__inv_2_915 gf180mcu_as_sc_mcu7t3v3__inv_2_917/VDD VSS VSS
+ gf180mcu_as_sc_mcu7t3v3__inv_2_917/Y gf180mcu_as_sc_mcu7t3v3__inv_2_917/VNW VSUBS
+ gf180mcu_as_sc_mcu7t3v3__inv_2
Xu_t003_005 u_t003_005/c0_w0_bl u_t003_005/c0_w0_br u_t003_005/c0_w1_bl u_t003_005/c0_w1_br
+ u_t003_005/c0_r0_rbl u_t003_005/c0_r1_rbl u_t003_005/c1_w0_bl u_t003_005/c1_w0_br
+ u_t003_005/c1_w1_bl u_t003_005/c1_w1_br u_t003_005/c1_r0_rbl u_t003_005/c1_r1_rbl
+ u_t003_005/c2_w0_bl u_t003_005/c2_w0_br u_t003_005/c2_w1_bl u_t003_005/c2_w1_br
+ u_t003_005/c2_r0_rbl u_t003_005/c2_r1_rbl u_t003_005/c3_w0_bl u_t003_005/c3_w0_br
+ u_t003_005/c3_w1_bl u_t003_005/c3_w1_br u_t003_005/c3_r0_rbl u_t003_005/c3_r1_rbl
+ u_t003_005/r0_w0_wl u_t003_005/r0_w1_wl u_t003_005/r0_r0_rwl u_t003_005/r0_r1_rwl
+ u_t003_005/r1_w0_wl u_t003_005/r1_w1_wl u_t003_005/r1_r0_rwl u_t003_005/r1_r1_rwl
+ u_t003_005/r2_w0_wl u_t003_005/r2_w1_wl u_t003_005/r2_r0_rwl u_t003_005/r2_r1_rwl
+ u_t003_005/r3_w0_wl u_t003_005/r3_w1_wl u_t003_005/r3_r0_rwl u_t003_005/r3_r1_rwl
+ u_t004_005/VDD u_t003_005/VSS VSUBS detronyx_12t_2w2r_rc4_4x4_routed_5layer_direct
Xgf180mcu_as_sc_mcu7t3v3__nand4_2_203 VSS gf180mcu_as_sc_mcu7t3v3__inv_2_923/VDD VSS
+ VSS VSS VSS VSS gf180mcu_as_sc_mcu7t3v3__inv_2_767/VNW VSUBS gf180mcu_as_sc_mcu7t3v3__nand4_2
Xgf180mcu_as_sc_mcu7t3v3__nand4_2_214 gf180mcu_as_sc_mcu7t3v3__inv_2_800/VDD gf180mcu_as_sc_mcu7t3v3__inv_2_803/VDD
+ VSS VSS VSS VSS gf180mcu_as_sc_mcu7t3v3__nand4_2_214/Y gf180mcu_as_sc_mcu7t3v3__inv_2_800/VNW
+ VSUBS gf180mcu_as_sc_mcu7t3v3__nand4_2
Xgf180mcu_as_sc_mcu7t3v3__nand4_2_225 gf180mcu_as_sc_mcu7t3v3__inv_2_872/VSS gf180mcu_as_sc_mcu7t3v3__inv_2_920/VDD
+ VSS VSS VSS VSS gf180mcu_as_sc_mcu7t3v3__nand4_2_225/Y gf180mcu_as_sc_mcu7t3v3__inv_2_833/VNW
+ VSUBS gf180mcu_as_sc_mcu7t3v3__nand4_2
Xgf180mcu_as_sc_mcu7t3v3__nand4_2_236 gf180mcu_as_sc_mcu7t3v3__inv_2_866/VDD gf180mcu_as_sc_mcu7t3v3__inv_2_869/VDD
+ VSS VSS VSS VSS gf180mcu_as_sc_mcu7t3v3__nand4_2_236/Y gf180mcu_as_sc_mcu7t3v3__inv_2_866/VNW
+ VSUBS gf180mcu_as_sc_mcu7t3v3__nand4_2
Xgf180mcu_as_sc_mcu7t3v3__nand4_2_247 gf180mcu_as_sc_mcu7t3v3__inv_2_899/VDD gf180mcu_as_sc_mcu7t3v3__inv_2_902/VDD
+ VSS VSS VSS VSS VSS gf180mcu_as_sc_mcu7t3v3__inv_2_899/VNW VSUBS gf180mcu_as_sc_mcu7t3v3__nand4_2
Xu_t000_008 u_t000_008/c0_w0_bl u_t000_008/c0_w0_br u_t000_008/c0_w1_bl u_t000_008/c0_w1_br
+ u_t000_008/c0_r0_rbl u_t000_008/c0_r1_rbl u_t000_008/c1_w0_bl u_t000_008/c1_w0_br
+ u_t000_008/c1_w1_bl u_t000_008/c1_w1_br u_t000_008/c1_r0_rbl u_t000_008/c1_r1_rbl
+ u_t000_008/c2_w0_bl u_t000_008/c2_w0_br u_t000_008/c2_w1_bl u_t000_008/c2_w1_br
+ u_t000_008/c2_r0_rbl u_t000_008/c2_r1_rbl u_t000_008/c3_w0_bl u_t000_008/c3_w0_br
+ u_t000_008/c3_w1_bl u_t000_008/c3_w1_br u_t000_008/c3_r0_rbl u_t000_008/c3_r1_rbl
+ u_t000_008/r0_w0_wl u_t000_008/r0_w1_wl u_t000_008/r0_r0_rwl u_t000_008/r0_r1_rwl
+ u_t000_008/r1_w0_wl u_t000_008/r1_w1_wl u_t000_008/r1_r0_rwl u_t000_008/r1_r1_rwl
+ u_t000_008/r2_w0_wl u_t000_008/r2_w1_wl u_t000_008/r2_r0_rwl u_t000_008/r2_r1_rwl
+ u_t000_008/r3_w0_wl u_t000_008/r3_w1_wl u_t000_008/r3_r0_rwl u_t000_008/r3_r1_rwl
+ VSS u_t000_015/VSS VSUBS detronyx_12t_2w2r_rc4_4x4_routed_5layer_direct
Xgf180mcu_as_sc_mcu7t3v3__inv_2_745 gf180mcu_as_sc_mcu7t3v3__inv_2_746/VDD gf180mcu_as_sc_mcu7t3v3__inv_2_749/VDD
+ gf180mcu_as_sc_mcu7t3v3__inv_2_752/Y gf180mcu_as_sc_mcu7t3v3__inv_2_752/Y gf180mcu_as_sc_mcu7t3v3__inv_2_746/VNW
+ VSUBS gf180mcu_as_sc_mcu7t3v3__inv_2
Xgf180mcu_as_sc_mcu7t3v3__inv_2_734 gf180mcu_as_sc_mcu7t3v3__inv_2_734/VDD gf180mcu_as_sc_mcu7t3v3__inv_2_737/VDD
+ gf180mcu_as_sc_mcu7t3v3__inv_2_743/Y VSS gf180mcu_as_sc_mcu7t3v3__inv_2_734/VNW
+ VSUBS gf180mcu_as_sc_mcu7t3v3__inv_2
Xgf180mcu_as_sc_mcu7t3v3__inv_2_723 gf180mcu_as_sc_mcu7t3v3__inv_2_776/VSS gf180mcu_as_sc_mcu7t3v3__inv_2_776/VSS
+ VSS gf180mcu_as_sc_mcu7t3v3__inv_2_743/Y gf180mcu_as_sc_mcu7t3v3__inv_2_725/VNW
+ VSUBS gf180mcu_as_sc_mcu7t3v3__inv_2
Xgf180mcu_as_sc_mcu7t3v3__inv_2_701 VSS VSS VSS VSS gf180mcu_as_sc_mcu7t3v3__inv_2_708/VNW
+ VSUBS gf180mcu_as_sc_mcu7t3v3__inv_2
Xgf180mcu_as_sc_mcu7t3v3__inv_2_712 gf180mcu_as_sc_mcu7t3v3__inv_2_713/VDD gf180mcu_as_sc_mcu7t3v3__nor2_2_8/VSS
+ VSS VSS gf180mcu_as_sc_mcu7t3v3__inv_2_713/VNW VSUBS gf180mcu_as_sc_mcu7t3v3__inv_2
Xgf180mcu_as_sc_mcu7t3v3__inv_2_767 VSS gf180mcu_as_sc_mcu7t3v3__inv_2_923/VDD gf180mcu_as_sc_mcu7t3v3__inv_2_923/Y
+ VSS gf180mcu_as_sc_mcu7t3v3__inv_2_767/VNW VSUBS gf180mcu_as_sc_mcu7t3v3__inv_2
Xgf180mcu_as_sc_mcu7t3v3__inv_2_756 VSS gf180mcu_as_sc_mcu7t3v3__inv_2_761/VDD VSS
+ gf180mcu_as_sc_mcu7t3v3__inv_2_761/Y gf180mcu_as_sc_mcu7t3v3__inv_2_758/VNW VSUBS
+ gf180mcu_as_sc_mcu7t3v3__inv_2
Xgf180mcu_as_sc_mcu7t3v3__inv_2_789 gf180mcu_as_sc_mcu7t3v3__inv_2_791/VDD gf180mcu_as_sc_mcu7t3v3__inv_2_794/VDD
+ gf180mcu_as_sc_mcu7t3v3__inv_2_789/Y VSS gf180mcu_as_sc_mcu7t3v3__inv_2_791/VNW
+ VSUBS gf180mcu_as_sc_mcu7t3v3__inv_2
Xgf180mcu_as_sc_mcu7t3v3__inv_2_778 gf180mcu_as_sc_mcu7t3v3__inv_2_830/VSS gf180mcu_as_sc_mcu7t3v3__inv_2_782/VDD
+ gf180mcu_as_sc_mcu7t3v3__inv_2_778/Y VSS gf180mcu_as_sc_mcu7t3v3__inv_2_779/VNW
+ VSUBS gf180mcu_as_sc_mcu7t3v3__inv_2
Xgf180mcu_as_sc_mcu7t3v3__nand4_2_3 gf180mcu_as_sc_mcu7t3v3__inv_2_9/VDD gf180mcu_as_sc_mcu7t3v3__inv_2_9/VDD
+ VSS VSS VSS VSS VSS gf180mcu_as_sc_mcu7t3v3__inv_2_0/VNW VSUBS gf180mcu_as_sc_mcu7t3v3__nand4_2
Xgf180mcu_as_sc_mcu7t3v3__inv_2_564 gf180mcu_as_sc_mcu7t3v3__inv_2_564/VDD VSS gf180mcu_as_sc_mcu7t3v3__inv_2_564/Y
+ VSS gf180mcu_as_sc_mcu7t3v3__inv_2_564/VNW VSUBS gf180mcu_as_sc_mcu7t3v3__inv_2
Xgf180mcu_as_sc_mcu7t3v3__inv_2_553 gf180mcu_as_sc_mcu7t3v3__inv_2_555/VDD VSS gf180mcu_as_sc_mcu7t3v3__inv_2_553/Y
+ gf180mcu_as_sc_mcu7t3v3__inv_2_553/A gf180mcu_as_sc_mcu7t3v3__inv_2_555/VNW VSUBS
+ gf180mcu_as_sc_mcu7t3v3__inv_2
Xgf180mcu_as_sc_mcu7t3v3__inv_2_542 gf180mcu_as_sc_mcu7t3v3__inv_2_543/VDD gf180mcu_as_sc_mcu7t3v3__inv_2_546/VDD
+ gf180mcu_as_sc_mcu7t3v3__inv_2_542/Y gf180mcu_as_sc_mcu7t3v3__inv_2_543/Y gf180mcu_as_sc_mcu7t3v3__inv_2_543/VNW
+ VSUBS gf180mcu_as_sc_mcu7t3v3__inv_2
Xgf180mcu_as_sc_mcu7t3v3__inv_2_531 VSS gf180mcu_as_sc_mcu7t3v3__inv_2_534/VDD gf180mcu_as_sc_mcu7t3v3__inv_2_531/Y
+ VSS gf180mcu_as_sc_mcu7t3v3__inv_2_531/VNW VSUBS gf180mcu_as_sc_mcu7t3v3__inv_2
Xgf180mcu_as_sc_mcu7t3v3__inv_2_520 VSS VSS VSS VSS gf180mcu_as_sc_mcu7t3v3__inv_2_522/VNW
+ VSUBS gf180mcu_as_sc_mcu7t3v3__inv_2
Xgf180mcu_as_sc_mcu7t3v3__inv_2_575 VSS gf180mcu_as_sc_mcu7t3v3__inv_2_576/VSS gf180mcu_as_sc_mcu7t3v3__inv_2_575/Y
+ gf180mcu_as_sc_mcu7t3v3__inv_2_576/Y gf180mcu_as_sc_mcu7t3v3__inv_2_576/VNW VSUBS
+ gf180mcu_as_sc_mcu7t3v3__inv_2
Xgf180mcu_as_sc_mcu7t3v3__inv_2_597 VSS gf180mcu_as_sc_mcu7t3v3__inv_2_600/VDD gf180mcu_as_sc_mcu7t3v3__inv_2_597/Y
+ VSS gf180mcu_as_sc_mcu7t3v3__inv_2_597/VNW VSUBS gf180mcu_as_sc_mcu7t3v3__inv_2
Xgf180mcu_as_sc_mcu7t3v3__inv_2_586 VSS VSS gf180mcu_as_sc_mcu7t3v3__inv_2_586/Y gf180mcu_as_sc_mcu7t3v3__inv_2_589/A
+ gf180mcu_as_sc_mcu7t3v3__inv_2_588/VNW VSUBS gf180mcu_as_sc_mcu7t3v3__inv_2
Xgf180mcu_as_sc_mcu7t3v3__inv_2_350 VSS gf180mcu_as_sc_mcu7t3v3__inv_2_354/VDD gf180mcu_as_sc_mcu7t3v3__inv_2_466/A
+ gf180mcu_as_sc_mcu7t3v3__inv_2_351/Y gf180mcu_as_sc_mcu7t3v3__inv_2_351/VNW VSUBS
+ gf180mcu_as_sc_mcu7t3v3__inv_2
Xgf180mcu_as_sc_mcu7t3v3__inv_2_394 gf180mcu_as_sc_mcu7t3v3__inv_2_396/VDD VSS VSS
+ gf180mcu_as_sc_mcu7t3v3__inv_2_466/A gf180mcu_as_sc_mcu7t3v3__inv_2_396/VNW VSUBS
+ gf180mcu_as_sc_mcu7t3v3__inv_2
Xgf180mcu_as_sc_mcu7t3v3__inv_2_383 gf180mcu_as_sc_mcu7t3v3__inv_2_384/VDD VSS gf180mcu_as_sc_mcu7t3v3__inv_2_383/Y
+ gf180mcu_as_sc_mcu7t3v3__inv_2_384/Y gf180mcu_as_sc_mcu7t3v3__inv_2_384/VNW VSUBS
+ gf180mcu_as_sc_mcu7t3v3__inv_2
Xgf180mcu_as_sc_mcu7t3v3__inv_2_372 gf180mcu_as_sc_mcu7t3v3__inv_2_372/VDD gf180mcu_as_sc_mcu7t3v3__inv_2_375/VDD
+ gf180mcu_as_sc_mcu7t3v3__inv_2_372/Y VSS gf180mcu_as_sc_mcu7t3v3__inv_2_372/VNW
+ VSUBS gf180mcu_as_sc_mcu7t3v3__inv_2
Xgf180mcu_as_sc_mcu7t3v3__inv_2_361 gf180mcu_as_sc_mcu7t3v3__inv_2_363/VDD gf180mcu_as_sc_mcu7t3v3__inv_2_366/VDD
+ gf180mcu_as_sc_mcu7t3v3__inv_2_361/Y gf180mcu_as_sc_mcu7t3v3__inv_2_930/A gf180mcu_as_sc_mcu7t3v3__inv_2_363/VNW
+ VSUBS gf180mcu_as_sc_mcu7t3v3__inv_2
Xgf180mcu_as_sc_mcu7t3v3__nand3_2_15 gf180mcu_as_sc_mcu7t3v3__nor2_2_5/VDD gf180mcu_as_sc_mcu7t3v3__nand3_2_8/VSS
+ VSS VSS VSS VSS gf180mcu_as_sc_mcu7t3v3__nor2_2_5/VNW VSUBS gf180mcu_as_sc_mcu7t3v3__nand3_2
Xgf180mcu_as_sc_mcu7t3v3__nand3_2_26 gf180mcu_as_sc_mcu7t3v3__nor2_2_8/VDD gf180mcu_as_sc_mcu7t3v3__inv_2_710/VSS
+ VSS VSS VSS VSS gf180mcu_as_sc_mcu7t3v3__nor2_2_8/VNW VSUBS gf180mcu_as_sc_mcu7t3v3__nand3_2
Xu_t009_000 u_t009_000/c0_w0_bl u_t009_000/c0_w0_br u_t009_000/c0_w1_bl u_t009_000/c0_w1_br
+ u_t009_000/c0_r0_rbl u_t009_000/c0_r1_rbl u_t009_000/c1_w0_bl u_t009_000/c1_w0_br
+ u_t009_000/c1_w1_bl u_t009_000/c1_w1_br u_t009_000/c1_r0_rbl u_t009_000/c1_r1_rbl
+ u_t009_000/c2_w0_bl u_t009_000/c2_w0_br u_t009_000/c2_w1_bl u_t009_000/c2_w1_br
+ u_t009_000/c2_r0_rbl u_t009_000/c2_r1_rbl u_t009_000/c3_w0_bl u_t009_000/c3_w0_br
+ u_t009_000/c3_w1_bl u_t009_000/c3_w1_br u_t009_000/c3_r0_rbl u_t009_000/c3_r1_rbl
+ u_t009_000/r0_w0_wl u_t009_000/r0_w1_wl u_t009_000/r0_r0_rwl u_t009_000/r0_r1_rwl
+ u_t009_000/r1_w0_wl u_t009_000/r1_w1_wl u_t009_000/r1_r0_rwl u_t009_000/r1_r1_rwl
+ u_t009_000/r2_w0_wl u_t009_000/r2_w1_wl u_t009_000/r2_r0_rwl u_t009_000/r2_r1_rwl
+ u_t009_000/r3_w0_wl u_t009_000/r3_w1_wl u_t009_000/r3_r0_rwl u_t009_000/r3_r1_rwl
+ VSS u_t009_015/VSS VSUBS detronyx_12t_2w2r_rc4_4x4_routed_5layer_direct
Xu_t009_011 u_t009_011/c0_w0_bl u_t009_011/c0_w0_br u_t009_011/c0_w1_bl u_t009_011/c0_w1_br
+ u_t009_011/c0_r0_rbl u_t009_011/c0_r1_rbl u_t009_011/c1_w0_bl u_t009_011/c1_w0_br
+ u_t009_011/c1_w1_bl u_t009_011/c1_w1_br u_t009_011/c1_r0_rbl u_t009_011/c1_r1_rbl
+ u_t009_011/c2_w0_bl u_t009_011/c2_w0_br u_t009_011/c2_w1_bl u_t009_011/c2_w1_br
+ u_t009_011/c2_r0_rbl u_t009_011/c2_r1_rbl u_t009_011/c3_w0_bl u_t009_011/c3_w0_br
+ u_t009_011/c3_w1_bl u_t009_011/c3_w1_br u_t009_011/c3_r0_rbl u_t009_011/c3_r1_rbl
+ u_t009_011/r0_w0_wl u_t009_011/r0_w1_wl u_t009_011/r0_r0_rwl u_t009_011/r0_r1_rwl
+ u_t009_011/r1_w0_wl u_t009_011/r1_w1_wl u_t009_011/r1_r0_rwl u_t009_011/r1_r1_rwl
+ u_t009_011/r2_w0_wl u_t009_011/r2_w1_wl u_t009_011/r2_r0_rwl u_t009_011/r2_r1_rwl
+ u_t009_011/r3_w0_wl u_t009_011/r3_w1_wl u_t009_011/r3_r0_rwl u_t009_011/r3_r1_rwl
+ u_t009_011/VDD u_t009_015/VSS VSUBS detronyx_12t_2w2r_rc4_4x4_routed_5layer_direct
Xgf180mcu_as_sc_mcu7t3v3__inv_2_180 gf180mcu_as_sc_mcu7t3v3__nor2_2_6/VDD gf180mcu_as_sc_mcu7t3v3__nand3_2_1/VSS
+ VSS VSS gf180mcu_as_sc_mcu7t3v3__nor2_2_6/VNW VSUBS gf180mcu_as_sc_mcu7t3v3__inv_2
Xgf180mcu_as_sc_mcu7t3v3__inv_2_191 gf180mcu_as_sc_mcu7t3v3__nand2_2_9/VDD gf180mcu_as_sc_mcu7t3v3__nor2_2_4/VSS
+ gf180mcu_as_sc_mcu7t3v3__inv_2_191/Y VSS gf180mcu_as_sc_mcu7t3v3__nand2_2_9/VNW
+ VSUBS gf180mcu_as_sc_mcu7t3v3__inv_2
Xu_t015_014 u_t015_014/c0_w0_bl u_t015_014/c0_w0_br u_t015_014/c0_w1_bl u_t015_014/c0_w1_br
+ u_t015_014/c0_r0_rbl u_t015_014/c0_r1_rbl u_t015_014/c1_w0_bl u_t015_014/c1_w0_br
+ u_t015_014/c1_w1_bl u_t015_014/c1_w1_br u_t015_014/c1_r0_rbl u_t015_014/c1_r1_rbl
+ u_t015_014/c2_w0_bl u_t015_014/c2_w0_br u_t015_014/c2_w1_bl u_t015_014/c2_w1_br
+ u_t015_014/c2_r0_rbl u_t015_014/c2_r1_rbl u_t015_014/c3_w0_bl u_t015_014/c3_w0_br
+ u_t015_014/c3_w1_bl u_t015_014/c3_w1_br u_t015_014/c3_r0_rbl u_t015_014/c3_r1_rbl
+ u_t015_014/r0_w0_wl u_t015_014/r0_w1_wl u_t015_014/r0_r0_rwl u_t015_014/r0_r1_rwl
+ u_t015_014/r1_w0_wl u_t015_014/r1_w1_wl u_t015_014/r1_r0_rwl u_t015_014/r1_r1_rwl
+ u_t015_014/r2_w0_wl u_t015_014/r2_w1_wl u_t015_014/r2_r0_rwl u_t015_014/r2_r1_rwl
+ u_t015_014/r3_w0_wl u_t015_014/r3_w1_wl u_t015_014/r3_r0_rwl u_t015_014/r3_r1_rwl
+ u_t015_014/VDD u_t015_015/VSS VSUBS detronyx_12t_2w2r_rc4_4x4_routed_5layer_direct
Xu_t015_003 u_t015_003/c0_w0_bl u_t015_003/c0_w0_br u_t015_003/c0_w1_bl u_t015_003/c0_w1_br
+ u_t015_003/c0_r0_rbl u_t015_003/c0_r1_rbl u_t015_003/c1_w0_bl u_t015_003/c1_w0_br
+ u_t015_003/c1_w1_bl u_t015_003/c1_w1_br u_t015_003/c1_r0_rbl u_t015_003/c1_r1_rbl
+ u_t015_003/c2_w0_bl u_t015_003/c2_w0_br u_t015_003/c2_w1_bl u_t015_003/c2_w1_br
+ u_t015_003/c2_r0_rbl u_t015_003/c2_r1_rbl u_t015_003/c3_w0_bl u_t015_003/c3_w0_br
+ u_t015_003/c3_w1_bl u_t015_003/c3_w1_br u_t015_003/c3_r0_rbl u_t015_003/c3_r1_rbl
+ u_t015_003/r0_w0_wl u_t015_003/r0_w1_wl u_t015_003/r0_r0_rwl u_t015_003/r0_r1_rwl
+ u_t015_003/r1_w0_wl u_t015_003/r1_w1_wl u_t015_003/r1_r0_rwl u_t015_003/r1_r1_rwl
+ u_t015_003/r2_w0_wl u_t015_003/r2_w1_wl u_t015_003/r2_r0_rwl u_t015_003/r2_r1_rwl
+ u_t015_003/r3_w0_wl u_t015_003/r3_w1_wl u_t015_003/r3_r0_rwl u_t015_003/r3_r1_rwl
+ u_t015_003/VDD u_t015_003/VSS VSUBS detronyx_12t_2w2r_rc4_4x4_routed_5layer_direct
Xgf180mcu_as_sc_mcu7t3v3__inv_2_8 gf180mcu_as_sc_mcu7t3v3__inv_2_8/VDD VSS gf180mcu_as_sc_mcu7t3v3__inv_2_9/A
+ VSS gf180mcu_as_sc_mcu7t3v3__inv_2_8/VNW VSUBS gf180mcu_as_sc_mcu7t3v3__inv_2
Xu_t006_003 u_t006_003/c0_w0_bl u_t006_003/c0_w0_br u_t006_003/c0_w1_bl u_t006_003/c0_w1_br
+ u_t006_003/c0_r0_rbl u_t006_003/c0_r1_rbl u_t006_003/c1_w0_bl u_t006_003/c1_w0_br
+ u_t006_003/c1_w1_bl u_t006_003/c1_w1_br u_t006_003/c1_r0_rbl u_t006_003/c1_r1_rbl
+ u_t006_003/c2_w0_bl u_t006_003/c2_w0_br u_t006_003/c2_w1_bl u_t006_003/c2_w1_br
+ u_t006_003/c2_r0_rbl u_t006_003/c2_r1_rbl u_t006_003/c3_w0_bl u_t006_003/c3_w0_br
+ u_t006_003/c3_w1_bl u_t006_003/c3_w1_br u_t006_003/c3_r0_rbl u_t006_003/c3_r1_rbl
+ u_t006_003/r0_w0_wl u_t006_003/r0_w1_wl u_t006_003/r0_r0_rwl u_t006_003/r0_r1_rwl
+ u_t006_003/r1_w0_wl u_t006_003/r1_w1_wl u_t006_003/r1_r0_rwl u_t006_003/r1_r1_rwl
+ u_t006_003/r2_w0_wl u_t006_003/r2_w1_wl u_t006_003/r2_r0_rwl u_t006_003/r2_r1_rwl
+ u_t006_003/r3_w0_wl u_t006_003/r3_w1_wl u_t006_003/r3_r0_rwl u_t006_003/r3_r1_rwl
+ u_t006_003/VDD u_t006_003/VSS VSUBS detronyx_12t_2w2r_rc4_4x4_routed_5layer_direct
Xu_t006_014 u_t006_014/c0_w0_bl u_t006_014/c0_w0_br u_t006_014/c0_w1_bl u_t006_014/c0_w1_br
+ u_t006_014/c0_r0_rbl u_t006_014/c0_r1_rbl u_t006_014/c1_w0_bl u_t006_014/c1_w0_br
+ u_t006_014/c1_w1_bl u_t006_014/c1_w1_br u_t006_014/c1_r0_rbl u_t006_014/c1_r1_rbl
+ u_t006_014/c2_w0_bl u_t006_014/c2_w0_br u_t006_014/c2_w1_bl u_t006_014/c2_w1_br
+ u_t006_014/c2_r0_rbl u_t006_014/c2_r1_rbl u_t006_014/c3_w0_bl u_t006_014/c3_w0_br
+ u_t006_014/c3_w1_bl u_t006_014/c3_w1_br u_t006_014/c3_r0_rbl u_t006_014/c3_r1_rbl
+ u_t006_014/r0_w0_wl u_t006_014/r0_w1_wl u_t006_014/r0_r0_rwl u_t006_014/r0_r1_rwl
+ u_t006_014/r1_w0_wl u_t006_014/r1_w1_wl u_t006_014/r1_r0_rwl u_t006_014/r1_r1_rwl
+ u_t006_014/r2_w0_wl u_t006_014/r2_w1_wl u_t006_014/r2_r0_rwl u_t006_014/r2_r1_rwl
+ u_t006_014/r3_w0_wl u_t006_014/r3_w1_wl u_t006_014/r3_r0_rwl u_t006_014/r3_r1_rwl
+ u_t006_014/VDD u_t006_015/VSS VSUBS detronyx_12t_2w2r_rc4_4x4_routed_5layer_direct
Xu_t012_006 u_t012_006/c0_w0_bl u_t012_006/c0_w0_br u_t012_006/c0_w1_bl u_t012_006/c0_w1_br
+ u_t012_006/c0_r0_rbl u_t012_006/c0_r1_rbl u_t012_006/c1_w0_bl u_t012_006/c1_w0_br
+ u_t012_006/c1_w1_bl u_t012_006/c1_w1_br u_t012_006/c1_r0_rbl u_t012_006/c1_r1_rbl
+ u_t012_006/c2_w0_bl u_t012_006/c2_w0_br u_t012_006/c2_w1_bl u_t012_006/c2_w1_br
+ u_t012_006/c2_r0_rbl u_t012_006/c2_r1_rbl u_t012_006/c3_w0_bl u_t012_006/c3_w0_br
+ u_t012_006/c3_w1_bl u_t012_006/c3_w1_br u_t012_006/c3_r0_rbl u_t012_006/c3_r1_rbl
+ u_t012_006/r0_w0_wl u_t012_006/r0_w1_wl u_t012_006/r0_r0_rwl u_t012_006/r0_r1_rwl
+ u_t012_006/r1_w0_wl u_t012_006/r1_w1_wl u_t012_006/r1_r0_rwl u_t012_006/r1_r1_rwl
+ u_t012_006/r2_w0_wl u_t012_006/r2_w1_wl u_t012_006/r2_r0_rwl u_t012_006/r2_r1_rwl
+ u_t012_006/r3_w0_wl u_t012_006/r3_w1_wl u_t012_006/r3_r0_rwl u_t012_006/r3_r1_rwl
+ u_t012_006/VDD u_t012_015/VSS VSUBS detronyx_12t_2w2r_rc4_4x4_routed_5layer_direct
Xgf180mcu_as_sc_mcu7t3v3__inv_2_927 VSS VSS VSS VSS gf180mcu_as_sc_mcu7t3v3__inv_2_929/VNW
+ VSUBS gf180mcu_as_sc_mcu7t3v3__inv_2
Xgf180mcu_as_sc_mcu7t3v3__inv_2_916 gf180mcu_as_sc_mcu7t3v3__inv_2_917/VDD VSS gf180mcu_as_sc_mcu7t3v3__inv_2_916/Y
+ gf180mcu_as_sc_mcu7t3v3__inv_2_917/Y gf180mcu_as_sc_mcu7t3v3__inv_2_917/VNW VSUBS
+ gf180mcu_as_sc_mcu7t3v3__inv_2
Xgf180mcu_as_sc_mcu7t3v3__inv_2_905 gf180mcu_as_sc_mcu7t3v3__inv_2_905/VDD gf180mcu_as_sc_mcu7t3v3__inv_2_908/VDD
+ gf180mcu_as_sc_mcu7t3v3__inv_2_908/Y VSS gf180mcu_as_sc_mcu7t3v3__inv_2_905/VNW
+ VSUBS gf180mcu_as_sc_mcu7t3v3__inv_2
Xu_t003_006 u_t003_006/c0_w0_bl u_t003_006/c0_w0_br u_t003_006/c0_w1_bl u_t003_006/c0_w1_br
+ u_t003_006/c0_r0_rbl u_t003_006/c0_r1_rbl u_t003_006/c1_w0_bl u_t003_006/c1_w0_br
+ u_t003_006/c1_w1_bl u_t003_006/c1_w1_br u_t003_006/c1_r0_rbl u_t003_006/c1_r1_rbl
+ u_t003_006/c2_w0_bl u_t003_006/c2_w0_br u_t003_006/c2_w1_bl u_t003_006/c2_w1_br
+ u_t003_006/c2_r0_rbl u_t003_006/c2_r1_rbl u_t003_006/c3_w0_bl u_t003_006/c3_w0_br
+ u_t003_006/c3_w1_bl u_t003_006/c3_w1_br u_t003_006/c3_r0_rbl u_t003_006/c3_r1_rbl
+ u_t003_006/r0_w0_wl u_t003_006/r0_w1_wl u_t003_006/r0_r0_rwl u_t003_006/r0_r1_rwl
+ u_t003_006/r1_w0_wl u_t003_006/r1_w1_wl u_t003_006/r1_r0_rwl u_t003_006/r1_r1_rwl
+ u_t003_006/r2_w0_wl u_t003_006/r2_w1_wl u_t003_006/r2_r0_rwl u_t003_006/r2_r1_rwl
+ u_t003_006/r3_w0_wl u_t003_006/r3_w1_wl u_t003_006/r3_r0_rwl u_t003_006/r3_r1_rwl
+ u_t004_006/VDD u_t003_009/VSS VSUBS detronyx_12t_2w2r_rc4_4x4_routed_5layer_direct
Xgf180mcu_as_sc_mcu7t3v3__nand4_2_215 gf180mcu_as_sc_mcu7t3v3__inv_2_803/VDD VSS VSS
+ VSS VSS VSS gf180mcu_as_sc_mcu7t3v3__nand4_2_215/Y gf180mcu_as_sc_mcu7t3v3__inv_2_803/VNW
+ VSUBS gf180mcu_as_sc_mcu7t3v3__nand4_2
Xgf180mcu_as_sc_mcu7t3v3__nand4_2_204 VSS VSS VSS VSS VSS VSS VSS gf180mcu_as_sc_mcu7t3v3__inv_2_770/VNW
+ VSUBS gf180mcu_as_sc_mcu7t3v3__nand4_2
Xgf180mcu_as_sc_mcu7t3v3__nand4_2_237 gf180mcu_as_sc_mcu7t3v3__inv_2_869/VDD VSS VSS
+ VSS VSS VSS VSS gf180mcu_as_sc_mcu7t3v3__inv_2_869/VNW VSUBS gf180mcu_as_sc_mcu7t3v3__nand4_2
Xgf180mcu_as_sc_mcu7t3v3__nand4_2_248 gf180mcu_as_sc_mcu7t3v3__inv_2_902/VDD gf180mcu_as_sc_mcu7t3v3__inv_2_905/VDD
+ VSS VSS VSS VSS VSS gf180mcu_as_sc_mcu7t3v3__inv_2_902/VNW VSUBS gf180mcu_as_sc_mcu7t3v3__nand4_2
Xgf180mcu_as_sc_mcu7t3v3__nand4_2_226 gf180mcu_as_sc_mcu7t3v3__inv_2_836/VDD gf180mcu_as_sc_mcu7t3v3__inv_2_839/VDD
+ VSS VSS VSS VSS gf180mcu_as_sc_mcu7t3v3__nand4_2_226/Y gf180mcu_as_sc_mcu7t3v3__inv_2_836/VNW
+ VSUBS gf180mcu_as_sc_mcu7t3v3__nand4_2
Xu_t000_009 u_t000_009/c0_w0_bl u_t000_009/c0_w0_br u_t000_009/c0_w1_bl u_t000_009/c0_w1_br
+ u_t000_009/c0_r0_rbl u_t000_009/c0_r1_rbl u_t000_009/c1_w0_bl u_t000_009/c1_w0_br
+ u_t000_009/c1_w1_bl u_t000_009/c1_w1_br u_t000_009/c1_r0_rbl u_t000_009/c1_r1_rbl
+ u_t000_009/c2_w0_bl u_t000_009/c2_w0_br u_t000_009/c2_w1_bl u_t000_009/c2_w1_br
+ u_t000_009/c2_r0_rbl u_t000_009/c2_r1_rbl u_t000_009/c3_w0_bl u_t000_009/c3_w0_br
+ u_t000_009/c3_w1_bl u_t000_009/c3_w1_br u_t000_009/c3_r0_rbl u_t000_009/c3_r1_rbl
+ u_t000_009/r0_w0_wl u_t000_009/r0_w1_wl u_t000_009/r0_r0_rwl u_t000_009/r0_r1_rwl
+ u_t000_009/r1_w0_wl u_t000_009/r1_w1_wl u_t000_009/r1_r0_rwl u_t000_009/r1_r1_rwl
+ u_t000_009/r2_w0_wl u_t000_009/r2_w1_wl u_t000_009/r2_r0_rwl u_t000_009/r2_r1_rwl
+ u_t000_009/r3_w0_wl u_t000_009/r3_w1_wl u_t000_009/r3_r0_rwl u_t000_009/r3_r1_rwl
+ VSS u_t000_015/VSS VSUBS detronyx_12t_2w2r_rc4_4x4_routed_5layer_direct
Xgf180mcu_as_sc_mcu7t3v3__inv_2_757 VSS gf180mcu_as_sc_mcu7t3v3__inv_2_761/VDD gf180mcu_as_sc_mcu7t3v3__inv_2_757/Y
+ gf180mcu_as_sc_mcu7t3v3__inv_2_761/Y gf180mcu_as_sc_mcu7t3v3__inv_2_758/VNW VSUBS
+ gf180mcu_as_sc_mcu7t3v3__inv_2
Xgf180mcu_as_sc_mcu7t3v3__inv_2_746 gf180mcu_as_sc_mcu7t3v3__inv_2_746/VDD gf180mcu_as_sc_mcu7t3v3__inv_2_749/VDD
+ gf180mcu_as_sc_mcu7t3v3__inv_2_752/Y VSS gf180mcu_as_sc_mcu7t3v3__inv_2_746/VNW
+ VSUBS gf180mcu_as_sc_mcu7t3v3__inv_2
Xgf180mcu_as_sc_mcu7t3v3__inv_2_735 gf180mcu_as_sc_mcu7t3v3__inv_2_737/VDD gf180mcu_as_sc_mcu7t3v3__inv_2_740/VDD
+ VSS gf180mcu_as_sc_mcu7t3v3__inv_2_743/Y gf180mcu_as_sc_mcu7t3v3__inv_2_737/VNW
+ VSUBS gf180mcu_as_sc_mcu7t3v3__inv_2
Xgf180mcu_as_sc_mcu7t3v3__inv_2_779 gf180mcu_as_sc_mcu7t3v3__inv_2_830/VSS gf180mcu_as_sc_mcu7t3v3__inv_2_782/VDD
+ gf180mcu_as_sc_mcu7t3v3__inv_2_779/Y VSS gf180mcu_as_sc_mcu7t3v3__inv_2_779/VNW
+ VSUBS gf180mcu_as_sc_mcu7t3v3__inv_2
Xgf180mcu_as_sc_mcu7t3v3__inv_2_724 gf180mcu_as_sc_mcu7t3v3__inv_2_776/VSS gf180mcu_as_sc_mcu7t3v3__inv_2_776/VSS
+ gf180mcu_as_sc_mcu7t3v3__inv_2_743/Y gf180mcu_as_sc_mcu7t3v3__inv_2_743/Y gf180mcu_as_sc_mcu7t3v3__inv_2_725/VNW
+ VSUBS gf180mcu_as_sc_mcu7t3v3__inv_2
Xgf180mcu_as_sc_mcu7t3v3__inv_2_768 VSS VSS VSS gf180mcu_as_sc_mcu7t3v3__inv_2_776/Y
+ gf180mcu_as_sc_mcu7t3v3__inv_2_770/VNW VSUBS gf180mcu_as_sc_mcu7t3v3__inv_2
Xgf180mcu_as_sc_mcu7t3v3__inv_2_702 VSS VSS VSS VSS gf180mcu_as_sc_mcu7t3v3__inv_2_703/VNW
+ VSUBS gf180mcu_as_sc_mcu7t3v3__inv_2
Xgf180mcu_as_sc_mcu7t3v3__inv_2_713 gf180mcu_as_sc_mcu7t3v3__inv_2_713/VDD gf180mcu_as_sc_mcu7t3v3__inv_2_713/VSS
+ VSS VSS gf180mcu_as_sc_mcu7t3v3__inv_2_713/VNW VSUBS gf180mcu_as_sc_mcu7t3v3__inv_2
Xgf180mcu_as_sc_mcu7t3v3__nand4_2_4 gf180mcu_as_sc_mcu7t3v3__inv_2_15/VDD gf180mcu_as_sc_mcu7t3v3__inv_2_15/VDD
+ VSS VSS VSS VSS VSS gf180mcu_as_sc_mcu7t3v3__inv_2_12/VNW VSUBS gf180mcu_as_sc_mcu7t3v3__nand4_2
Xgf180mcu_as_sc_mcu7t3v3__inv_2_565 VSS VSS gf180mcu_as_sc_mcu7t3v3__inv_2_565/Y gf180mcu_as_sc_mcu7t3v3__inv_2_930/A
+ gf180mcu_as_sc_mcu7t3v3__inv_2_567/VNW VSUBS gf180mcu_as_sc_mcu7t3v3__inv_2
Xgf180mcu_as_sc_mcu7t3v3__inv_2_554 gf180mcu_as_sc_mcu7t3v3__inv_2_555/VDD VSS gf180mcu_as_sc_mcu7t3v3__inv_2_554/Y
+ gf180mcu_as_sc_mcu7t3v3__inv_2_555/Y gf180mcu_as_sc_mcu7t3v3__inv_2_555/VNW VSUBS
+ gf180mcu_as_sc_mcu7t3v3__inv_2
Xgf180mcu_as_sc_mcu7t3v3__inv_2_543 gf180mcu_as_sc_mcu7t3v3__inv_2_543/VDD gf180mcu_as_sc_mcu7t3v3__inv_2_546/VDD
+ gf180mcu_as_sc_mcu7t3v3__inv_2_543/Y VSS gf180mcu_as_sc_mcu7t3v3__inv_2_543/VNW
+ VSUBS gf180mcu_as_sc_mcu7t3v3__inv_2
Xgf180mcu_as_sc_mcu7t3v3__inv_2_532 gf180mcu_as_sc_mcu7t3v3__inv_2_534/VDD gf180mcu_as_sc_mcu7t3v3__inv_2_537/VDD
+ gf180mcu_as_sc_mcu7t3v3__inv_2_532/Y gf180mcu_as_sc_mcu7t3v3__inv_2_545/Y gf180mcu_as_sc_mcu7t3v3__inv_2_534/VNW
+ VSUBS gf180mcu_as_sc_mcu7t3v3__inv_2
Xgf180mcu_as_sc_mcu7t3v3__inv_2_521 VSS VSS VSS VSS gf180mcu_as_sc_mcu7t3v3__inv_2_522/VNW
+ VSUBS gf180mcu_as_sc_mcu7t3v3__inv_2
Xgf180mcu_as_sc_mcu7t3v3__inv_2_576 VSS gf180mcu_as_sc_mcu7t3v3__inv_2_576/VSS gf180mcu_as_sc_mcu7t3v3__inv_2_576/Y
+ VSS gf180mcu_as_sc_mcu7t3v3__inv_2_576/VNW VSUBS gf180mcu_as_sc_mcu7t3v3__inv_2
Xgf180mcu_as_sc_mcu7t3v3__inv_2_510 VSS VSS VSS VSS gf180mcu_as_sc_mcu7t3v3__inv_2_510/VNW
+ VSUBS gf180mcu_as_sc_mcu7t3v3__inv_2
Xgf180mcu_as_sc_mcu7t3v3__inv_2_598 gf180mcu_as_sc_mcu7t3v3__inv_2_600/VDD gf180mcu_as_sc_mcu7t3v3__inv_2_603/VDD
+ gf180mcu_as_sc_mcu7t3v3__inv_2_598/Y gf180mcu_as_sc_mcu7t3v3__inv_2_611/Y gf180mcu_as_sc_mcu7t3v3__inv_2_600/VNW
+ VSUBS gf180mcu_as_sc_mcu7t3v3__inv_2
Xgf180mcu_as_sc_mcu7t3v3__inv_2_587 VSS VSS gf180mcu_as_sc_mcu7t3v3__inv_2_587/Y gf180mcu_as_sc_mcu7t3v3__inv_2_588/Y
+ gf180mcu_as_sc_mcu7t3v3__inv_2_588/VNW VSUBS gf180mcu_as_sc_mcu7t3v3__inv_2
Xgf180mcu_as_sc_mcu7t3v3__inv_2_351 VSS gf180mcu_as_sc_mcu7t3v3__inv_2_354/VDD gf180mcu_as_sc_mcu7t3v3__inv_2_351/Y
+ VSS gf180mcu_as_sc_mcu7t3v3__inv_2_351/VNW VSUBS gf180mcu_as_sc_mcu7t3v3__inv_2
Xgf180mcu_as_sc_mcu7t3v3__inv_2_340 VSS VSS gf180mcu_as_sc_mcu7t3v3__inv_2_340/Y gf180mcu_as_sc_mcu7t3v3__inv_2_344/A
+ gf180mcu_as_sc_mcu7t3v3__inv_2_342/VNW VSUBS gf180mcu_as_sc_mcu7t3v3__inv_2
Xgf180mcu_as_sc_mcu7t3v3__inv_2_395 gf180mcu_as_sc_mcu7t3v3__inv_2_396/VDD VSS gf180mcu_as_sc_mcu7t3v3__inv_2_466/A
+ gf180mcu_as_sc_mcu7t3v3__inv_2_396/Y gf180mcu_as_sc_mcu7t3v3__inv_2_396/VNW VSUBS
+ gf180mcu_as_sc_mcu7t3v3__inv_2
Xgf180mcu_as_sc_mcu7t3v3__inv_2_384 gf180mcu_as_sc_mcu7t3v3__inv_2_384/VDD VSS gf180mcu_as_sc_mcu7t3v3__inv_2_384/Y
+ VSS gf180mcu_as_sc_mcu7t3v3__inv_2_384/VNW VSUBS gf180mcu_as_sc_mcu7t3v3__inv_2
Xgf180mcu_as_sc_mcu7t3v3__inv_2_373 gf180mcu_as_sc_mcu7t3v3__inv_2_375/VDD VSS gf180mcu_as_sc_mcu7t3v3__inv_2_373/Y
+ gf180mcu_as_sc_mcu7t3v3__inv_2_930/A gf180mcu_as_sc_mcu7t3v3__inv_2_375/VNW VSUBS
+ gf180mcu_as_sc_mcu7t3v3__inv_2
Xgf180mcu_as_sc_mcu7t3v3__inv_2_362 gf180mcu_as_sc_mcu7t3v3__inv_2_363/VDD gf180mcu_as_sc_mcu7t3v3__inv_2_366/VDD
+ gf180mcu_as_sc_mcu7t3v3__inv_2_362/Y gf180mcu_as_sc_mcu7t3v3__inv_2_363/Y gf180mcu_as_sc_mcu7t3v3__inv_2_363/VNW
+ VSUBS gf180mcu_as_sc_mcu7t3v3__inv_2
Xu_t009_001 u_t009_001/c0_w0_bl u_t009_001/c0_w0_br u_t009_001/c0_w1_bl u_t009_001/c0_w1_br
+ u_t009_001/c0_r0_rbl u_t009_001/c0_r1_rbl u_t009_001/c1_w0_bl u_t009_001/c1_w0_br
+ u_t009_001/c1_w1_bl u_t009_001/c1_w1_br u_t009_001/c1_r0_rbl u_t009_001/c1_r1_rbl
+ u_t009_001/c2_w0_bl u_t009_001/c2_w0_br u_t009_001/c2_w1_bl u_t009_001/c2_w1_br
+ u_t009_001/c2_r0_rbl u_t009_001/c2_r1_rbl u_t009_001/c3_w0_bl u_t009_001/c3_w0_br
+ u_t009_001/c3_w1_bl u_t009_001/c3_w1_br u_t009_001/c3_r0_rbl u_t009_001/c3_r1_rbl
+ u_t009_001/r0_w0_wl u_t009_001/r0_w1_wl u_t009_001/r0_r0_rwl u_t009_001/r0_r1_rwl
+ u_t009_001/r1_w0_wl u_t009_001/r1_w1_wl u_t009_001/r1_r0_rwl u_t009_001/r1_r1_rwl
+ u_t009_001/r2_w0_wl u_t009_001/r2_w1_wl u_t009_001/r2_r0_rwl u_t009_001/r2_r1_rwl
+ u_t009_001/r3_w0_wl u_t009_001/r3_w1_wl u_t009_001/r3_r0_rwl u_t009_001/r3_r1_rwl
+ VSS u_t009_015/VSS VSUBS detronyx_12t_2w2r_rc4_4x4_routed_5layer_direct
Xgf180mcu_as_sc_mcu7t3v3__nand3_2_16 gf180mcu_as_sc_mcu7t3v3__nor2_2_4/VDD gf180mcu_as_sc_mcu7t3v3__nor2_2_4/VSS
+ VSS VSS VSS VSS gf180mcu_as_sc_mcu7t3v3__nor2_2_4/VNW VSUBS gf180mcu_as_sc_mcu7t3v3__nand3_2
Xgf180mcu_as_sc_mcu7t3v3__inv_2_170 gf180mcu_as_sc_mcu7t3v3__inv_2_171/VDD gf180mcu_as_sc_mcu7t3v3__inv_2_173/VDD
+ gf180mcu_as_sc_mcu7t3v3__inv_2_170/Y gf180mcu_as_sc_mcu7t3v3__inv_2_177/Y gf180mcu_as_sc_mcu7t3v3__inv_2_171/VNW
+ VSUBS gf180mcu_as_sc_mcu7t3v3__inv_2
Xgf180mcu_as_sc_mcu7t3v3__nand3_2_27 gf180mcu_as_sc_mcu7t3v3__nor2_2_8/VDD gf180mcu_as_sc_mcu7t3v3__nor2_2_8/VSS
+ VSS VSS VSS VSS gf180mcu_as_sc_mcu7t3v3__nor2_2_8/VNW VSUBS gf180mcu_as_sc_mcu7t3v3__nand3_2
Xu_t009_012 u_t009_012/c0_w0_bl u_t009_012/c0_w0_br u_t009_012/c0_w1_bl u_t009_012/c0_w1_br
+ u_t009_012/c0_r0_rbl u_t009_012/c0_r1_rbl u_t009_012/c1_w0_bl u_t009_012/c1_w0_br
+ u_t009_012/c1_w1_bl u_t009_012/c1_w1_br u_t009_012/c1_r0_rbl u_t009_012/c1_r1_rbl
+ u_t009_012/c2_w0_bl u_t009_012/c2_w0_br u_t009_012/c2_w1_bl u_t009_012/c2_w1_br
+ u_t009_012/c2_r0_rbl u_t009_012/c2_r1_rbl u_t009_012/c3_w0_bl u_t009_012/c3_w0_br
+ u_t009_012/c3_w1_bl u_t009_012/c3_w1_br u_t009_012/c3_r0_rbl u_t009_012/c3_r1_rbl
+ u_t009_012/r0_w0_wl u_t009_012/r0_w1_wl u_t009_012/r0_r0_rwl u_t009_012/r0_r1_rwl
+ u_t009_012/r1_w0_wl u_t009_012/r1_w1_wl u_t009_012/r1_r0_rwl u_t009_012/r1_r1_rwl
+ u_t009_012/r2_w0_wl u_t009_012/r2_w1_wl u_t009_012/r2_r0_rwl u_t009_012/r2_r1_rwl
+ u_t009_012/r3_w0_wl u_t009_012/r3_w1_wl u_t009_012/r3_r0_rwl u_t009_012/r3_r1_rwl
+ u_t009_012/VDD u_t009_015/VSS VSUBS detronyx_12t_2w2r_rc4_4x4_routed_5layer_direct
Xgf180mcu_as_sc_mcu7t3v3__inv_2_181 gf180mcu_as_sc_mcu7t3v3__nor2_2_6/VDD gf180mcu_as_sc_mcu7t3v3__nor2_2_6/VSS
+ VSS VSS gf180mcu_as_sc_mcu7t3v3__nor2_2_6/VNW VSUBS gf180mcu_as_sc_mcu7t3v3__inv_2
Xgf180mcu_as_sc_mcu7t3v3__inv_2_192 gf180mcu_as_sc_mcu7t3v3__nand2_2_9/VDD gf180mcu_as_sc_mcu7t3v3__nor2_2_6/VSS
+ gf180mcu_as_sc_mcu7t3v3__inv_2_192/Y VSS gf180mcu_as_sc_mcu7t3v3__nand2_2_9/VNW
+ VSUBS gf180mcu_as_sc_mcu7t3v3__inv_2
Xu_t015_015 u_t015_015/c0_w0_bl u_t015_015/c0_w0_br u_t015_015/c0_w1_bl u_t015_015/c0_w1_br
+ u_t015_015/c0_r0_rbl u_t015_015/c0_r1_rbl u_t015_015/c1_w0_bl u_t015_015/c1_w0_br
+ u_t015_015/c1_w1_bl u_t015_015/c1_w1_br u_t015_015/c1_r0_rbl u_t015_015/c1_r1_rbl
+ u_t015_015/c2_w0_bl u_t015_015/c2_w0_br u_t015_015/c2_w1_bl u_t015_015/c2_w1_br
+ u_t015_015/c2_r0_rbl u_t015_015/c2_r1_rbl u_t015_015/c3_w0_bl u_t015_015/c3_w0_br
+ u_t015_015/c3_w1_bl u_t015_015/c3_w1_br u_t015_015/c3_r0_rbl u_t015_015/c3_r1_rbl
+ u_t015_015/r0_w0_wl u_t015_015/r0_w1_wl u_t015_015/r0_r0_rwl u_t015_015/r0_r1_rwl
+ u_t015_015/r1_w0_wl u_t015_015/r1_w1_wl u_t015_015/r1_r0_rwl u_t015_015/r1_r1_rwl
+ u_t015_015/r2_w0_wl u_t015_015/r2_w1_wl u_t015_015/r2_r0_rwl u_t015_015/r2_r1_rwl
+ u_t015_015/r3_w0_wl u_t015_015/r3_w1_wl u_t015_015/r3_r0_rwl u_t015_015/r3_r1_rwl
+ VSS u_t015_015/VSS VSUBS detronyx_12t_2w2r_rc4_4x4_routed_5layer_direct
Xu_t015_004 u_t015_004/c0_w0_bl u_t015_004/c0_w0_br u_t015_004/c0_w1_bl u_t015_004/c0_w1_br
+ u_t015_004/c0_r0_rbl u_t015_004/c0_r1_rbl u_t015_004/c1_w0_bl u_t015_004/c1_w0_br
+ u_t015_004/c1_w1_bl u_t015_004/c1_w1_br u_t015_004/c1_r0_rbl u_t015_004/c1_r1_rbl
+ u_t015_004/c2_w0_bl u_t015_004/c2_w0_br u_t015_004/c2_w1_bl u_t015_004/c2_w1_br
+ u_t015_004/c2_r0_rbl u_t015_004/c2_r1_rbl u_t015_004/c3_w0_bl u_t015_004/c3_w0_br
+ u_t015_004/c3_w1_bl u_t015_004/c3_w1_br u_t015_004/c3_r0_rbl u_t015_004/c3_r1_rbl
+ u_t015_004/r0_w0_wl u_t015_004/r0_w1_wl u_t015_004/r0_r0_rwl u_t015_004/r0_r1_rwl
+ u_t015_004/r1_w0_wl u_t015_004/r1_w1_wl u_t015_004/r1_r0_rwl u_t015_004/r1_r1_rwl
+ u_t015_004/r2_w0_wl u_t015_004/r2_w1_wl u_t015_004/r2_r0_rwl u_t015_004/r2_r1_rwl
+ u_t015_004/r3_w0_wl u_t015_004/r3_w1_wl u_t015_004/r3_r0_rwl u_t015_004/r3_r1_rwl
+ u_t015_004/VDD u_t015_004/VSS VSUBS detronyx_12t_2w2r_rc4_4x4_routed_5layer_direct
Xgf180mcu_as_sc_mcu7t3v3__inv_2_9 gf180mcu_as_sc_mcu7t3v3__inv_2_9/VDD gf180mcu_as_sc_mcu7t3v3__inv_2_9/VSS
+ VSS gf180mcu_as_sc_mcu7t3v3__inv_2_9/A gf180mcu_as_sc_mcu7t3v3__inv_2_9/VNW VSUBS
+ gf180mcu_as_sc_mcu7t3v3__inv_2
Xgf180mcu_as_sc_mcu7t3v3__nand2_2_60 gf180mcu_as_sc_mcu7t3v3__inv_2_713/VDD gf180mcu_as_sc_mcu7t3v3__inv_2_713/VSS
+ VSS VSS VSS gf180mcu_as_sc_mcu7t3v3__inv_2_713/VNW VSUBS gf180mcu_as_sc_mcu7t3v3__nand2_2
Xu_t006_004 u_t006_004/c0_w0_bl u_t006_004/c0_w0_br u_t006_004/c0_w1_bl u_t006_004/c0_w1_br
+ u_t006_004/c0_r0_rbl u_t006_004/c0_r1_rbl u_t006_004/c1_w0_bl u_t006_004/c1_w0_br
+ u_t006_004/c1_w1_bl u_t006_004/c1_w1_br u_t006_004/c1_r0_rbl u_t006_004/c1_r1_rbl
+ u_t006_004/c2_w0_bl u_t006_004/c2_w0_br u_t006_004/c2_w1_bl u_t006_004/c2_w1_br
+ u_t006_004/c2_r0_rbl u_t006_004/c2_r1_rbl u_t006_004/c3_w0_bl u_t006_004/c3_w0_br
+ u_t006_004/c3_w1_bl u_t006_004/c3_w1_br u_t006_004/c3_r0_rbl u_t006_004/c3_r1_rbl
+ u_t006_004/r0_w0_wl u_t006_004/r0_w1_wl u_t006_004/r0_r0_rwl u_t006_004/r0_r1_rwl
+ u_t006_004/r1_w0_wl u_t006_004/r1_w1_wl u_t006_004/r1_r0_rwl u_t006_004/r1_r1_rwl
+ u_t006_004/r2_w0_wl u_t006_004/r2_w1_wl u_t006_004/r2_r0_rwl u_t006_004/r2_r1_rwl
+ u_t006_004/r3_w0_wl u_t006_004/r3_w1_wl u_t006_004/r3_r0_rwl u_t006_004/r3_r1_rwl
+ u_t006_004/VDD u_t006_004/VSS VSUBS detronyx_12t_2w2r_rc4_4x4_routed_5layer_direct
Xu_t006_015 u_t006_015/c0_w0_bl u_t006_015/c0_w0_br u_t006_015/c0_w1_bl u_t006_015/c0_w1_br
+ u_t006_015/c0_r0_rbl u_t006_015/c0_r1_rbl u_t006_015/c1_w0_bl u_t006_015/c1_w0_br
+ u_t006_015/c1_w1_bl u_t006_015/c1_w1_br u_t006_015/c1_r0_rbl u_t006_015/c1_r1_rbl
+ u_t006_015/c2_w0_bl u_t006_015/c2_w0_br u_t006_015/c2_w1_bl u_t006_015/c2_w1_br
+ u_t006_015/c2_r0_rbl u_t006_015/c2_r1_rbl u_t006_015/c3_w0_bl u_t006_015/c3_w0_br
+ u_t006_015/c3_w1_bl u_t006_015/c3_w1_br u_t006_015/c3_r0_rbl u_t006_015/c3_r1_rbl
+ u_t006_015/r0_w0_wl u_t006_015/r0_w1_wl u_t006_015/r0_r0_rwl u_t006_015/r0_r1_rwl
+ u_t006_015/r1_w0_wl u_t006_015/r1_w1_wl u_t006_015/r1_r0_rwl u_t006_015/r1_r1_rwl
+ u_t006_015/r2_w0_wl u_t006_015/r2_w1_wl u_t006_015/r2_r0_rwl u_t006_015/r2_r1_rwl
+ u_t006_015/r3_w0_wl u_t006_015/r3_w1_wl u_t006_015/r3_r0_rwl u_t006_015/r3_r1_rwl
+ VSS u_t006_015/VSS VSUBS detronyx_12t_2w2r_rc4_4x4_routed_5layer_direct
Xu_t012_007 u_t012_007/c0_w0_bl u_t012_007/c0_w0_br u_t012_007/c0_w1_bl u_t012_007/c0_w1_br
+ u_t012_007/c0_r0_rbl u_t012_007/c0_r1_rbl u_t012_007/c1_w0_bl u_t012_007/c1_w0_br
+ u_t012_007/c1_w1_bl u_t012_007/c1_w1_br u_t012_007/c1_r0_rbl u_t012_007/c1_r1_rbl
+ u_t012_007/c2_w0_bl u_t012_007/c2_w0_br u_t012_007/c2_w1_bl u_t012_007/c2_w1_br
+ u_t012_007/c2_r0_rbl u_t012_007/c2_r1_rbl u_t012_007/c3_w0_bl u_t012_007/c3_w0_br
+ u_t012_007/c3_w1_bl u_t012_007/c3_w1_br u_t012_007/c3_r0_rbl u_t012_007/c3_r1_rbl
+ u_t012_007/r0_w0_wl u_t012_007/r0_w1_wl u_t012_007/r0_r0_rwl u_t012_007/r0_r1_rwl
+ u_t012_007/r1_w0_wl u_t012_007/r1_w1_wl u_t012_007/r1_r0_rwl u_t012_007/r1_r1_rwl
+ u_t012_007/r2_w0_wl u_t012_007/r2_w1_wl u_t012_007/r2_r0_rwl u_t012_007/r2_r1_rwl
+ u_t012_007/r3_w0_wl u_t012_007/r3_w1_wl u_t012_007/r3_r0_rwl u_t012_007/r3_r1_rwl
+ VSS u_t012_015/VSS VSUBS detronyx_12t_2w2r_rc4_4x4_routed_5layer_direct
Xgf180mcu_as_sc_mcu7t3v3__inv_2_928 VSS VSS VSS VSS gf180mcu_as_sc_mcu7t3v3__inv_2_929/VNW
+ VSUBS gf180mcu_as_sc_mcu7t3v3__inv_2
Xgf180mcu_as_sc_mcu7t3v3__inv_2_917 gf180mcu_as_sc_mcu7t3v3__inv_2_917/VDD VSS gf180mcu_as_sc_mcu7t3v3__inv_2_917/Y
+ VSS gf180mcu_as_sc_mcu7t3v3__inv_2_917/VNW VSUBS gf180mcu_as_sc_mcu7t3v3__inv_2
Xgf180mcu_as_sc_mcu7t3v3__inv_2_906 gf180mcu_as_sc_mcu7t3v3__inv_2_908/VDD VSS VSS
+ gf180mcu_as_sc_mcu7t3v3__inv_2_908/Y gf180mcu_as_sc_mcu7t3v3__inv_2_908/VNW VSUBS
+ gf180mcu_as_sc_mcu7t3v3__inv_2
Xu_t003_007 u_t003_007/c0_w0_bl u_t003_007/c0_w0_br u_t003_007/c0_w1_bl u_t003_007/c0_w1_br
+ u_t003_007/c0_r0_rbl u_t003_007/c0_r1_rbl u_t003_007/c1_w0_bl u_t003_007/c1_w0_br
+ u_t003_007/c1_w1_bl u_t003_007/c1_w1_br u_t003_007/c1_r0_rbl u_t003_007/c1_r1_rbl
+ u_t003_007/c2_w0_bl u_t003_007/c2_w0_br u_t003_007/c2_w1_bl u_t003_007/c2_w1_br
+ u_t003_007/c2_r0_rbl u_t003_007/c2_r1_rbl u_t003_007/c3_w0_bl u_t003_007/c3_w0_br
+ u_t003_007/c3_w1_bl u_t003_007/c3_w1_br u_t003_007/c3_r0_rbl u_t003_007/c3_r1_rbl
+ u_t003_007/r0_w0_wl u_t003_007/r0_w1_wl u_t003_007/r0_r0_rwl u_t003_007/r0_r1_rwl
+ u_t003_007/r1_w0_wl u_t003_007/r1_w1_wl u_t003_007/r1_r0_rwl u_t003_007/r1_r1_rwl
+ u_t003_007/r2_w0_wl u_t003_007/r2_w1_wl u_t003_007/r2_r0_rwl u_t003_007/r2_r1_rwl
+ u_t003_007/r3_w0_wl u_t003_007/r3_w1_wl u_t003_007/r3_r0_rwl u_t003_007/r3_r1_rwl
+ VSS u_t003_009/VSS VSUBS detronyx_12t_2w2r_rc4_4x4_routed_5layer_direct
Xgf180mcu_as_sc_mcu7t3v3__nand4_2_216 VSS VSS VSS VSS VSS VSS VSS gf180mcu_as_sc_mcu7t3v3__inv_2_806/VNW
+ VSUBS gf180mcu_as_sc_mcu7t3v3__nand4_2
Xgf180mcu_as_sc_mcu7t3v3__nand4_2_205 VSS gf180mcu_as_sc_mcu7t3v3__inv_2_776/VDD VSS
+ VSS VSS VSS VSS gf180mcu_as_sc_mcu7t3v3__inv_2_773/VNW VSUBS gf180mcu_as_sc_mcu7t3v3__nand4_2
Xgf180mcu_as_sc_mcu7t3v3__nand4_2_238 gf180mcu_as_sc_mcu7t3v3__inv_2_914/VDD gf180mcu_as_sc_mcu7t3v3__inv_2_917/VDD
+ VSS VSS VSS VSS VSS gf180mcu_as_sc_mcu7t3v3__inv_2_914/VNW VSUBS gf180mcu_as_sc_mcu7t3v3__nand4_2
Xgf180mcu_as_sc_mcu7t3v3__nand4_2_249 gf180mcu_as_sc_mcu7t3v3__inv_2_905/VDD gf180mcu_as_sc_mcu7t3v3__inv_2_908/VDD
+ VSS VSS VSS VSS VSS gf180mcu_as_sc_mcu7t3v3__inv_2_905/VNW VSUBS gf180mcu_as_sc_mcu7t3v3__nand4_2
Xgf180mcu_as_sc_mcu7t3v3__nand4_2_227 gf180mcu_as_sc_mcu7t3v3__inv_2_839/VDD gf180mcu_as_sc_mcu7t3v3__inv_2_845/VDD
+ VSS VSS VSS VSS gf180mcu_as_sc_mcu7t3v3__nand4_2_227/Y gf180mcu_as_sc_mcu7t3v3__inv_2_839/VNW
+ VSUBS gf180mcu_as_sc_mcu7t3v3__nand4_2
Xgf180mcu_as_sc_mcu7t3v3__inv_2_758 VSS gf180mcu_as_sc_mcu7t3v3__inv_2_761/VDD gf180mcu_as_sc_mcu7t3v3__inv_2_761/Y
+ VSS gf180mcu_as_sc_mcu7t3v3__inv_2_758/VNW VSUBS gf180mcu_as_sc_mcu7t3v3__inv_2
Xgf180mcu_as_sc_mcu7t3v3__inv_2_747 gf180mcu_as_sc_mcu7t3v3__inv_2_749/VDD gf180mcu_as_sc_mcu7t3v3__inv_2_752/VDD
+ VSS gf180mcu_as_sc_mcu7t3v3__inv_2_752/Y gf180mcu_as_sc_mcu7t3v3__inv_2_749/VNW
+ VSUBS gf180mcu_as_sc_mcu7t3v3__inv_2
Xgf180mcu_as_sc_mcu7t3v3__inv_2_736 gf180mcu_as_sc_mcu7t3v3__inv_2_737/VDD gf180mcu_as_sc_mcu7t3v3__inv_2_740/VDD
+ gf180mcu_as_sc_mcu7t3v3__inv_2_743/Y gf180mcu_as_sc_mcu7t3v3__inv_2_743/Y gf180mcu_as_sc_mcu7t3v3__inv_2_737/VNW
+ VSUBS gf180mcu_as_sc_mcu7t3v3__inv_2
Xgf180mcu_as_sc_mcu7t3v3__inv_2_725 gf180mcu_as_sc_mcu7t3v3__inv_2_776/VSS gf180mcu_as_sc_mcu7t3v3__inv_2_776/VSS
+ gf180mcu_as_sc_mcu7t3v3__inv_2_743/Y VSS gf180mcu_as_sc_mcu7t3v3__inv_2_725/VNW
+ VSUBS gf180mcu_as_sc_mcu7t3v3__inv_2
Xgf180mcu_as_sc_mcu7t3v3__inv_2_769 VSS VSS gf180mcu_as_sc_mcu7t3v3__inv_2_776/Y gf180mcu_as_sc_mcu7t3v3__inv_2_776/Y
+ gf180mcu_as_sc_mcu7t3v3__inv_2_770/VNW VSUBS gf180mcu_as_sc_mcu7t3v3__inv_2
Xgf180mcu_as_sc_mcu7t3v3__inv_2_714 VSS VSS VSS VSS gf180mcu_as_sc_mcu7t3v3__inv_2_716/VNW
+ VSUBS gf180mcu_as_sc_mcu7t3v3__inv_2
Xgf180mcu_as_sc_mcu7t3v3__inv_2_703 VSS VSS VSS VSS gf180mcu_as_sc_mcu7t3v3__inv_2_703/VNW
+ VSUBS gf180mcu_as_sc_mcu7t3v3__inv_2
Xgf180mcu_as_sc_mcu7t3v3__inv_2_90 VSS gf180mcu_as_sc_mcu7t3v3__inv_2_93/VDD gf180mcu_as_sc_mcu7t3v3__inv_2_90/Y
+ VSS gf180mcu_as_sc_mcu7t3v3__inv_2_90/VNW VSUBS gf180mcu_as_sc_mcu7t3v3__inv_2
Xgf180mcu_as_sc_mcu7t3v3__nand4_2_5 gf180mcu_as_sc_mcu7t3v3__inv_2_15/VDD gf180mcu_as_sc_mcu7t3v3__inv_2_18/VDD
+ VSS VSS VSS VSS VSS gf180mcu_as_sc_mcu7t3v3__inv_2_15/VNW VSUBS gf180mcu_as_sc_mcu7t3v3__nand4_2
Xgf180mcu_as_sc_mcu7t3v3__inv_2_500 VSS VSS VSS VSS gf180mcu_as_sc_mcu7t3v3__inv_2_501/VNW
+ VSUBS gf180mcu_as_sc_mcu7t3v3__inv_2
Xgf180mcu_as_sc_mcu7t3v3__inv_2_511 VSS VSS VSS VSS gf180mcu_as_sc_mcu7t3v3__inv_2_513/VNW
+ VSUBS gf180mcu_as_sc_mcu7t3v3__inv_2
Xgf180mcu_as_sc_mcu7t3v3__inv_2_566 VSS VSS gf180mcu_as_sc_mcu7t3v3__inv_2_930/A gf180mcu_as_sc_mcu7t3v3__inv_2_567/Y
+ gf180mcu_as_sc_mcu7t3v3__inv_2_567/VNW VSUBS gf180mcu_as_sc_mcu7t3v3__inv_2
Xgf180mcu_as_sc_mcu7t3v3__inv_2_555 gf180mcu_as_sc_mcu7t3v3__inv_2_555/VDD VSS gf180mcu_as_sc_mcu7t3v3__inv_2_555/Y
+ VSS gf180mcu_as_sc_mcu7t3v3__inv_2_555/VNW VSUBS gf180mcu_as_sc_mcu7t3v3__inv_2
Xgf180mcu_as_sc_mcu7t3v3__inv_2_544 gf180mcu_as_sc_mcu7t3v3__inv_2_546/VDD VSS gf180mcu_as_sc_mcu7t3v3__inv_2_544/Y
+ gf180mcu_as_sc_mcu7t3v3__inv_2_545/Y gf180mcu_as_sc_mcu7t3v3__inv_2_546/VNW VSUBS
+ gf180mcu_as_sc_mcu7t3v3__inv_2
Xgf180mcu_as_sc_mcu7t3v3__inv_2_533 gf180mcu_as_sc_mcu7t3v3__inv_2_534/VDD gf180mcu_as_sc_mcu7t3v3__inv_2_537/VDD
+ gf180mcu_as_sc_mcu7t3v3__inv_2_533/Y gf180mcu_as_sc_mcu7t3v3__inv_2_534/Y gf180mcu_as_sc_mcu7t3v3__inv_2_534/VNW
+ VSUBS gf180mcu_as_sc_mcu7t3v3__inv_2
Xgf180mcu_as_sc_mcu7t3v3__inv_2_522 VSS VSS gf180mcu_as_sc_mcu7t3v3__inv_2_522/Y VSS
+ gf180mcu_as_sc_mcu7t3v3__inv_2_522/VNW VSUBS gf180mcu_as_sc_mcu7t3v3__inv_2
Xgf180mcu_as_sc_mcu7t3v3__inv_2_599 gf180mcu_as_sc_mcu7t3v3__inv_2_600/VDD gf180mcu_as_sc_mcu7t3v3__inv_2_603/VDD
+ gf180mcu_as_sc_mcu7t3v3__inv_2_599/Y gf180mcu_as_sc_mcu7t3v3__inv_2_600/Y gf180mcu_as_sc_mcu7t3v3__inv_2_600/VNW
+ VSUBS gf180mcu_as_sc_mcu7t3v3__inv_2
Xgf180mcu_as_sc_mcu7t3v3__inv_2_588 VSS VSS gf180mcu_as_sc_mcu7t3v3__inv_2_588/Y VSS
+ gf180mcu_as_sc_mcu7t3v3__inv_2_588/VNW VSUBS gf180mcu_as_sc_mcu7t3v3__inv_2
Xgf180mcu_as_sc_mcu7t3v3__inv_2_577 gf180mcu_as_sc_mcu7t3v3__inv_2_579/VDD VSS gf180mcu_as_sc_mcu7t3v3__inv_2_577/Y
+ gf180mcu_as_sc_mcu7t3v3__inv_2_580/A gf180mcu_as_sc_mcu7t3v3__inv_2_579/VNW VSUBS
+ gf180mcu_as_sc_mcu7t3v3__inv_2
Xgf180mcu_as_sc_mcu7t3v3__inv_2_352 gf180mcu_as_sc_mcu7t3v3__inv_2_354/VDD gf180mcu_as_sc_mcu7t3v3__inv_2_468/VDD
+ gf180mcu_as_sc_mcu7t3v3__inv_2_352/Y gf180mcu_as_sc_mcu7t3v3__inv_2_466/A gf180mcu_as_sc_mcu7t3v3__inv_2_354/VNW
+ VSUBS gf180mcu_as_sc_mcu7t3v3__inv_2
Xgf180mcu_as_sc_mcu7t3v3__inv_2_330 VSS VSS gf180mcu_as_sc_mcu7t3v3__inv_2_330/Y VSS
+ gf180mcu_as_sc_mcu7t3v3__inv_2_330/VNW VSUBS gf180mcu_as_sc_mcu7t3v3__inv_2
Xgf180mcu_as_sc_mcu7t3v3__inv_2_341 VSS VSS gf180mcu_as_sc_mcu7t3v3__inv_2_344/A gf180mcu_as_sc_mcu7t3v3__inv_2_342/Y
+ gf180mcu_as_sc_mcu7t3v3__inv_2_342/VNW VSUBS gf180mcu_as_sc_mcu7t3v3__inv_2
Xgf180mcu_as_sc_mcu7t3v3__inv_2_396 gf180mcu_as_sc_mcu7t3v3__inv_2_396/VDD VSS gf180mcu_as_sc_mcu7t3v3__inv_2_396/Y
+ VSS gf180mcu_as_sc_mcu7t3v3__inv_2_396/VNW VSUBS gf180mcu_as_sc_mcu7t3v3__inv_2
Xgf180mcu_as_sc_mcu7t3v3__inv_2_385 VSS VSS VSS gf180mcu_as_sc_mcu7t3v3__inv_2_466/A
+ gf180mcu_as_sc_mcu7t3v3__inv_2_387/VNW VSUBS gf180mcu_as_sc_mcu7t3v3__inv_2
Xgf180mcu_as_sc_mcu7t3v3__inv_2_374 gf180mcu_as_sc_mcu7t3v3__inv_2_375/VDD VSS gf180mcu_as_sc_mcu7t3v3__inv_2_374/Y
+ gf180mcu_as_sc_mcu7t3v3__inv_2_375/Y gf180mcu_as_sc_mcu7t3v3__inv_2_375/VNW VSUBS
+ gf180mcu_as_sc_mcu7t3v3__inv_2
Xgf180mcu_as_sc_mcu7t3v3__inv_2_363 gf180mcu_as_sc_mcu7t3v3__inv_2_363/VDD gf180mcu_as_sc_mcu7t3v3__inv_2_366/VDD
+ gf180mcu_as_sc_mcu7t3v3__inv_2_363/Y VSS gf180mcu_as_sc_mcu7t3v3__inv_2_363/VNW
+ VSUBS gf180mcu_as_sc_mcu7t3v3__inv_2
Xgf180mcu_as_sc_mcu7t3v3__nand3_2_17 gf180mcu_as_sc_mcu7t3v3__nand2_2_9/VDD gf180mcu_as_sc_mcu7t3v3__nor2_2_4/VSS
+ VSS VSS VSS VSS gf180mcu_as_sc_mcu7t3v3__nand2_2_9/VNW VSUBS gf180mcu_as_sc_mcu7t3v3__nand3_2
Xgf180mcu_as_sc_mcu7t3v3__nand3_2_28 gf180mcu_as_sc_mcu7t3v3__inv_2_713/VDD gf180mcu_as_sc_mcu7t3v3__nor2_2_8/VSS
+ VSS VSS VSS VSS gf180mcu_as_sc_mcu7t3v3__inv_2_713/VNW VSUBS gf180mcu_as_sc_mcu7t3v3__nand3_2
Xu_t009_002 u_t009_002/c0_w0_bl u_t009_002/c0_w0_br u_t009_002/c0_w1_bl u_t009_002/c0_w1_br
+ u_t009_002/c0_r0_rbl u_t009_002/c0_r1_rbl u_t009_002/c1_w0_bl u_t009_002/c1_w0_br
+ u_t009_002/c1_w1_bl u_t009_002/c1_w1_br u_t009_002/c1_r0_rbl u_t009_002/c1_r1_rbl
+ u_t009_002/c2_w0_bl u_t009_002/c2_w0_br u_t009_002/c2_w1_bl u_t009_002/c2_w1_br
+ u_t009_002/c2_r0_rbl u_t009_002/c2_r1_rbl u_t009_002/c3_w0_bl u_t009_002/c3_w0_br
+ u_t009_002/c3_w1_bl u_t009_002/c3_w1_br u_t009_002/c3_r0_rbl u_t009_002/c3_r1_rbl
+ u_t009_002/r0_w0_wl u_t009_002/r0_w1_wl u_t009_002/r0_r0_rwl u_t009_002/r0_r1_rwl
+ u_t009_002/r1_w0_wl u_t009_002/r1_w1_wl u_t009_002/r1_r0_rwl u_t009_002/r1_r1_rwl
+ u_t009_002/r2_w0_wl u_t009_002/r2_w1_wl u_t009_002/r2_r0_rwl u_t009_002/r2_r1_rwl
+ u_t009_002/r3_w0_wl u_t009_002/r3_w1_wl u_t009_002/r3_r0_rwl u_t009_002/r3_r1_rwl
+ VSS u_t009_015/VSS VSUBS detronyx_12t_2w2r_rc4_4x4_routed_5layer_direct
Xu_t009_013 u_t009_013/c0_w0_bl u_t009_013/c0_w0_br u_t009_013/c0_w1_bl u_t009_013/c0_w1_br
+ u_t009_013/c0_r0_rbl u_t009_013/c0_r1_rbl u_t009_013/c1_w0_bl u_t009_013/c1_w0_br
+ u_t009_013/c1_w1_bl u_t009_013/c1_w1_br u_t009_013/c1_r0_rbl u_t009_013/c1_r1_rbl
+ u_t009_013/c2_w0_bl u_t009_013/c2_w0_br u_t009_013/c2_w1_bl u_t009_013/c2_w1_br
+ u_t009_013/c2_r0_rbl u_t009_013/c2_r1_rbl u_t009_013/c3_w0_bl u_t009_013/c3_w0_br
+ u_t009_013/c3_w1_bl u_t009_013/c3_w1_br u_t009_013/c3_r0_rbl u_t009_013/c3_r1_rbl
+ u_t009_013/r0_w0_wl u_t009_013/r0_w1_wl u_t009_013/r0_r0_rwl u_t009_013/r0_r1_rwl
+ u_t009_013/r1_w0_wl u_t009_013/r1_w1_wl u_t009_013/r1_r0_rwl u_t009_013/r1_r1_rwl
+ u_t009_013/r2_w0_wl u_t009_013/r2_w1_wl u_t009_013/r2_r0_rwl u_t009_013/r2_r1_rwl
+ u_t009_013/r3_w0_wl u_t009_013/r3_w1_wl u_t009_013/r3_r0_rwl u_t009_013/r3_r1_rwl
+ u_t009_013/VDD u_t009_015/VSS VSUBS detronyx_12t_2w2r_rc4_4x4_routed_5layer_direct
Xgf180mcu_as_sc_mcu7t3v3__inv_2_193 gf180mcu_as_sc_mcu7t3v3__nor2_2_6/VDD gf180mcu_as_sc_mcu7t3v3__nor2_2_6/VSS
+ gf180mcu_as_sc_mcu7t3v3__inv_2_193/Y VSS gf180mcu_as_sc_mcu7t3v3__nor2_2_6/VNW VSUBS
+ gf180mcu_as_sc_mcu7t3v3__inv_2
Xgf180mcu_as_sc_mcu7t3v3__inv_2_182 gf180mcu_as_sc_mcu7t3v3__nor2_2_6/VDD gf180mcu_as_sc_mcu7t3v3__nand3_2_1/VSS
+ VSS VSS gf180mcu_as_sc_mcu7t3v3__nor2_2_6/VNW VSUBS gf180mcu_as_sc_mcu7t3v3__inv_2
Xgf180mcu_as_sc_mcu7t3v3__inv_2_171 gf180mcu_as_sc_mcu7t3v3__inv_2_171/VDD gf180mcu_as_sc_mcu7t3v3__inv_2_173/VDD
+ gf180mcu_as_sc_mcu7t3v3__inv_2_177/Y VSS gf180mcu_as_sc_mcu7t3v3__inv_2_171/VNW
+ VSUBS gf180mcu_as_sc_mcu7t3v3__inv_2
Xgf180mcu_as_sc_mcu7t3v3__inv_2_160 gf180mcu_as_sc_mcu7t3v3__inv_2_162/VDD gf180mcu_as_sc_mcu7t3v3__inv_2_165/VDD
+ VSS gf180mcu_as_sc_mcu7t3v3__inv_2_177/Y gf180mcu_as_sc_mcu7t3v3__inv_2_162/VNW
+ VSUBS gf180mcu_as_sc_mcu7t3v3__inv_2
Xu_t015_005 u_t015_005/c0_w0_bl u_t015_005/c0_w0_br u_t015_005/c0_w1_bl u_t015_005/c0_w1_br
+ u_t015_005/c0_r0_rbl u_t015_005/c0_r1_rbl u_t015_005/c1_w0_bl u_t015_005/c1_w0_br
+ u_t015_005/c1_w1_bl u_t015_005/c1_w1_br u_t015_005/c1_r0_rbl u_t015_005/c1_r1_rbl
+ u_t015_005/c2_w0_bl u_t015_005/c2_w0_br u_t015_005/c2_w1_bl u_t015_005/c2_w1_br
+ u_t015_005/c2_r0_rbl u_t015_005/c2_r1_rbl u_t015_005/c3_w0_bl u_t015_005/c3_w0_br
+ u_t015_005/c3_w1_bl u_t015_005/c3_w1_br u_t015_005/c3_r0_rbl u_t015_005/c3_r1_rbl
+ u_t015_005/r0_w0_wl u_t015_005/r0_w1_wl u_t015_005/r0_r0_rwl u_t015_005/r0_r1_rwl
+ u_t015_005/r1_w0_wl u_t015_005/r1_w1_wl u_t015_005/r1_r0_rwl u_t015_005/r1_r1_rwl
+ u_t015_005/r2_w0_wl u_t015_005/r2_w1_wl u_t015_005/r2_r0_rwl u_t015_005/r2_r1_rwl
+ u_t015_005/r3_w0_wl u_t015_005/r3_w1_wl u_t015_005/r3_r0_rwl u_t015_005/r3_r1_rwl
+ u_t015_005/VDD u_t015_005/VSS VSUBS detronyx_12t_2w2r_rc4_4x4_routed_5layer_direct
Xgf180mcu_as_sc_mcu7t3v3__nand2_2_50 gf180mcu_as_sc_mcu7t3v3__nor2_2_8/VDD gf180mcu_as_sc_mcu7t3v3__nor2_2_8/VSS
+ VSS VSS VSS gf180mcu_as_sc_mcu7t3v3__nor2_2_8/VNW VSUBS gf180mcu_as_sc_mcu7t3v3__nand2_2
Xgf180mcu_as_sc_mcu7t3v3__nand2_2_61 gf180mcu_as_sc_mcu7t3v3__nor2_2_8/VDD gf180mcu_as_sc_mcu7t3v3__inv_2_710/VSS
+ VSS VSS VSS gf180mcu_as_sc_mcu7t3v3__nor2_2_8/VNW VSUBS gf180mcu_as_sc_mcu7t3v3__nand2_2
Xu_t006_005 u_t006_005/c0_w0_bl u_t006_005/c0_w0_br u_t006_005/c0_w1_bl u_t006_005/c0_w1_br
+ u_t006_005/c0_r0_rbl u_t006_005/c0_r1_rbl u_t006_005/c1_w0_bl u_t006_005/c1_w0_br
+ u_t006_005/c1_w1_bl u_t006_005/c1_w1_br u_t006_005/c1_r0_rbl u_t006_005/c1_r1_rbl
+ u_t006_005/c2_w0_bl u_t006_005/c2_w0_br u_t006_005/c2_w1_bl u_t006_005/c2_w1_br
+ u_t006_005/c2_r0_rbl u_t006_005/c2_r1_rbl u_t006_005/c3_w0_bl u_t006_005/c3_w0_br
+ u_t006_005/c3_w1_bl u_t006_005/c3_w1_br u_t006_005/c3_r0_rbl u_t006_005/c3_r1_rbl
+ u_t006_005/r0_w0_wl u_t006_005/r0_w1_wl u_t006_005/r0_r0_rwl u_t006_005/r0_r1_rwl
+ u_t006_005/r1_w0_wl u_t006_005/r1_w1_wl u_t006_005/r1_r0_rwl u_t006_005/r1_r1_rwl
+ u_t006_005/r2_w0_wl u_t006_005/r2_w1_wl u_t006_005/r2_r0_rwl u_t006_005/r2_r1_rwl
+ u_t006_005/r3_w0_wl u_t006_005/r3_w1_wl u_t006_005/r3_r0_rwl u_t006_005/r3_r1_rwl
+ u_t006_005/VDD u_t006_005/VSS VSUBS detronyx_12t_2w2r_rc4_4x4_routed_5layer_direct
Xu_t012_008 u_t012_008/c0_w0_bl u_t012_008/c0_w0_br u_t012_008/c0_w1_bl u_t012_008/c0_w1_br
+ u_t012_008/c0_r0_rbl u_t012_008/c0_r1_rbl u_t012_008/c1_w0_bl u_t012_008/c1_w0_br
+ u_t012_008/c1_w1_bl u_t012_008/c1_w1_br u_t012_008/c1_r0_rbl u_t012_008/c1_r1_rbl
+ u_t012_008/c2_w0_bl u_t012_008/c2_w0_br u_t012_008/c2_w1_bl u_t012_008/c2_w1_br
+ u_t012_008/c2_r0_rbl u_t012_008/c2_r1_rbl u_t012_008/c3_w0_bl u_t012_008/c3_w0_br
+ u_t012_008/c3_w1_bl u_t012_008/c3_w1_br u_t012_008/c3_r0_rbl u_t012_008/c3_r1_rbl
+ u_t012_008/r0_w0_wl u_t012_008/r0_w1_wl u_t012_008/r0_r0_rwl u_t012_008/r0_r1_rwl
+ u_t012_008/r1_w0_wl u_t012_008/r1_w1_wl u_t012_008/r1_r0_rwl u_t012_008/r1_r1_rwl
+ u_t012_008/r2_w0_wl u_t012_008/r2_w1_wl u_t012_008/r2_r0_rwl u_t012_008/r2_r1_rwl
+ u_t012_008/r3_w0_wl u_t012_008/r3_w1_wl u_t012_008/r3_r0_rwl u_t012_008/r3_r1_rwl
+ VSS u_t012_015/VSS VSUBS detronyx_12t_2w2r_rc4_4x4_routed_5layer_direct
Xgf180mcu_as_sc_mcu7t3v3__inv_2_929 VSS VSS gf180mcu_as_sc_mcu7t3v3__inv_2_929/Y VSS
+ gf180mcu_as_sc_mcu7t3v3__inv_2_929/VNW VSUBS gf180mcu_as_sc_mcu7t3v3__inv_2
Xgf180mcu_as_sc_mcu7t3v3__inv_2_918 gf180mcu_as_sc_mcu7t3v3__inv_2_920/VDD VSS gf180mcu_as_sc_mcu7t3v3__inv_2_918/Y
+ VSS gf180mcu_as_sc_mcu7t3v3__inv_2_920/VNW VSUBS gf180mcu_as_sc_mcu7t3v3__inv_2
Xgf180mcu_as_sc_mcu7t3v3__inv_2_907 gf180mcu_as_sc_mcu7t3v3__inv_2_908/VDD VSS gf180mcu_as_sc_mcu7t3v3__inv_2_908/Y
+ gf180mcu_as_sc_mcu7t3v3__inv_2_908/Y gf180mcu_as_sc_mcu7t3v3__inv_2_908/VNW VSUBS
+ gf180mcu_as_sc_mcu7t3v3__inv_2
Xu_t003_008 u_t003_008/c0_w0_bl u_t003_008/c0_w0_br u_t003_008/c0_w1_bl u_t003_008/c0_w1_br
+ u_t003_008/c0_r0_rbl u_t003_008/c0_r1_rbl u_t003_008/c1_w0_bl u_t003_008/c1_w0_br
+ u_t003_008/c1_w1_bl u_t003_008/c1_w1_br u_t003_008/c1_r0_rbl u_t003_008/c1_r1_rbl
+ u_t003_008/c2_w0_bl u_t003_008/c2_w0_br u_t003_008/c2_w1_bl u_t003_008/c2_w1_br
+ u_t003_008/c2_r0_rbl u_t003_008/c2_r1_rbl u_t003_008/c3_w0_bl u_t003_008/c3_w0_br
+ u_t003_008/c3_w1_bl u_t003_008/c3_w1_br u_t003_008/c3_r0_rbl u_t003_008/c3_r1_rbl
+ u_t003_008/r0_w0_wl u_t003_008/r0_w1_wl u_t003_008/r0_r0_rwl u_t003_008/r0_r1_rwl
+ u_t003_008/r1_w0_wl u_t003_008/r1_w1_wl u_t003_008/r1_r0_rwl u_t003_008/r1_r1_rwl
+ u_t003_008/r2_w0_wl u_t003_008/r2_w1_wl u_t003_008/r2_r0_rwl u_t003_008/r2_r1_rwl
+ u_t003_008/r3_w0_wl u_t003_008/r3_w1_wl u_t003_008/r3_r0_rwl u_t003_008/r3_r1_rwl
+ VSS u_t003_009/VSS VSUBS detronyx_12t_2w2r_rc4_4x4_routed_5layer_direct
Xgf180mcu_as_sc_mcu7t3v3__nand4_2_217 VSS gf180mcu_as_sc_mcu7t3v3__inv_2_812/VDD VSS
+ VSS VSS VSS gf180mcu_as_sc_mcu7t3v3__nand4_2_217/Y gf180mcu_as_sc_mcu7t3v3__inv_2_809/VNW
+ VSUBS gf180mcu_as_sc_mcu7t3v3__nand4_2
Xgf180mcu_as_sc_mcu7t3v3__nand4_2_206 gf180mcu_as_sc_mcu7t3v3__inv_2_830/VSS gf180mcu_as_sc_mcu7t3v3__inv_2_830/VSS
+ VSS VSS VSS VSS VSS gf180mcu_as_sc_mcu7t3v3__inv_2_830/VNW VSUBS gf180mcu_as_sc_mcu7t3v3__nand4_2
Xgf180mcu_as_sc_mcu7t3v3__nand4_2_228 gf180mcu_as_sc_mcu7t3v3__inv_2_845/VDD gf180mcu_as_sc_mcu7t3v3__inv_2_845/VDD
+ VSS VSS VSS VSS VSS gf180mcu_as_sc_mcu7t3v3__inv_2_842/VNW VSUBS gf180mcu_as_sc_mcu7t3v3__nand4_2
Xgf180mcu_as_sc_mcu7t3v3__nand4_2_239 gf180mcu_as_sc_mcu7t3v3__inv_2_875/VDD gf180mcu_as_sc_mcu7t3v3__inv_2_878/VDD
+ VSS VSS VSS VSS VSS gf180mcu_as_sc_mcu7t3v3__inv_2_875/VNW VSUBS gf180mcu_as_sc_mcu7t3v3__nand4_2
Xgf180mcu_as_sc_mcu7t3v3__inv_2_759 gf180mcu_as_sc_mcu7t3v3__inv_2_761/VDD VSS VSS
+ gf180mcu_as_sc_mcu7t3v3__inv_2_761/Y gf180mcu_as_sc_mcu7t3v3__inv_2_761/VNW VSUBS
+ gf180mcu_as_sc_mcu7t3v3__inv_2
Xgf180mcu_as_sc_mcu7t3v3__inv_2_748 gf180mcu_as_sc_mcu7t3v3__inv_2_749/VDD gf180mcu_as_sc_mcu7t3v3__inv_2_752/VDD
+ gf180mcu_as_sc_mcu7t3v3__inv_2_748/Y gf180mcu_as_sc_mcu7t3v3__inv_2_752/Y gf180mcu_as_sc_mcu7t3v3__inv_2_749/VNW
+ VSUBS gf180mcu_as_sc_mcu7t3v3__inv_2
Xgf180mcu_as_sc_mcu7t3v3__inv_2_737 gf180mcu_as_sc_mcu7t3v3__inv_2_737/VDD gf180mcu_as_sc_mcu7t3v3__inv_2_740/VDD
+ gf180mcu_as_sc_mcu7t3v3__inv_2_743/Y VSS gf180mcu_as_sc_mcu7t3v3__inv_2_737/VNW
+ VSUBS gf180mcu_as_sc_mcu7t3v3__inv_2
Xgf180mcu_as_sc_mcu7t3v3__inv_2_726 gf180mcu_as_sc_mcu7t3v3__inv_2_776/VSS gf180mcu_as_sc_mcu7t3v3__inv_2_731/VDD
+ VSS gf180mcu_as_sc_mcu7t3v3__inv_2_743/Y gf180mcu_as_sc_mcu7t3v3__inv_2_728/VNW
+ VSUBS gf180mcu_as_sc_mcu7t3v3__inv_2
Xgf180mcu_as_sc_mcu7t3v3__inv_2_715 VSS VSS VSS VSS gf180mcu_as_sc_mcu7t3v3__inv_2_716/VNW
+ VSUBS gf180mcu_as_sc_mcu7t3v3__inv_2
Xgf180mcu_as_sc_mcu7t3v3__inv_2_704 VSS VSS VSS VSS gf180mcu_as_sc_mcu7t3v3__inv_2_708/VNW
+ VSUBS gf180mcu_as_sc_mcu7t3v3__inv_2
Xgf180mcu_as_sc_mcu7t3v3__inv_2_91 gf180mcu_as_sc_mcu7t3v3__inv_2_93/VDD VSS gf180mcu_as_sc_mcu7t3v3__inv_2_91/Y
+ VSS gf180mcu_as_sc_mcu7t3v3__inv_2_93/VNW VSUBS gf180mcu_as_sc_mcu7t3v3__inv_2
Xgf180mcu_as_sc_mcu7t3v3__inv_2_80 gf180mcu_as_sc_mcu7t3v3__inv_2_81/VDD gf180mcu_as_sc_mcu7t3v3__inv_2_84/VDD
+ gf180mcu_as_sc_mcu7t3v3__inv_2_80/Y VSS gf180mcu_as_sc_mcu7t3v3__inv_2_81/VNW VSUBS
+ gf180mcu_as_sc_mcu7t3v3__inv_2
Xgf180mcu_as_sc_mcu7t3v3__nand4_2_6 gf180mcu_as_sc_mcu7t3v3__inv_2_18/VDD VSS VSS
+ VSS VSS VSS VSS gf180mcu_as_sc_mcu7t3v3__inv_2_18/VNW VSUBS gf180mcu_as_sc_mcu7t3v3__nand4_2
Xgf180mcu_as_sc_mcu7t3v3__inv_2_501 VSS VSS gf180mcu_as_sc_mcu7t3v3__inv_2_501/Y VSS
+ gf180mcu_as_sc_mcu7t3v3__inv_2_501/VNW VSUBS gf180mcu_as_sc_mcu7t3v3__inv_2
Xgf180mcu_as_sc_mcu7t3v3__inv_2_545 gf180mcu_as_sc_mcu7t3v3__inv_2_546/VDD VSS gf180mcu_as_sc_mcu7t3v3__inv_2_545/Y
+ gf180mcu_as_sc_mcu7t3v3__inv_2_546/Y gf180mcu_as_sc_mcu7t3v3__inv_2_546/VNW VSUBS
+ gf180mcu_as_sc_mcu7t3v3__inv_2
Xgf180mcu_as_sc_mcu7t3v3__inv_2_534 gf180mcu_as_sc_mcu7t3v3__inv_2_534/VDD gf180mcu_as_sc_mcu7t3v3__inv_2_537/VDD
+ gf180mcu_as_sc_mcu7t3v3__inv_2_534/Y VSS gf180mcu_as_sc_mcu7t3v3__inv_2_534/VNW
+ VSUBS gf180mcu_as_sc_mcu7t3v3__inv_2
Xgf180mcu_as_sc_mcu7t3v3__inv_2_523 gf180mcu_as_sc_mcu7t3v3__inv_2_576/VSS VSS gf180mcu_as_sc_mcu7t3v3__inv_2_523/Y
+ gf180mcu_as_sc_mcu7t3v3__inv_2_574/A gf180mcu_as_sc_mcu7t3v3__inv_2_525/VNW VSUBS
+ gf180mcu_as_sc_mcu7t3v3__inv_2
Xgf180mcu_as_sc_mcu7t3v3__inv_2_512 VSS VSS VSS VSS gf180mcu_as_sc_mcu7t3v3__inv_2_513/VNW
+ VSUBS gf180mcu_as_sc_mcu7t3v3__inv_2
Xgf180mcu_as_sc_mcu7t3v3__inv_2_567 VSS VSS gf180mcu_as_sc_mcu7t3v3__inv_2_567/Y VSS
+ gf180mcu_as_sc_mcu7t3v3__inv_2_567/VNW VSUBS gf180mcu_as_sc_mcu7t3v3__inv_2
Xgf180mcu_as_sc_mcu7t3v3__inv_2_556 VSS VSS gf180mcu_as_sc_mcu7t3v3__inv_2_556/Y gf180mcu_as_sc_mcu7t3v3__inv_2_562/A
+ gf180mcu_as_sc_mcu7t3v3__inv_2_558/VNW VSUBS gf180mcu_as_sc_mcu7t3v3__inv_2
Xgf180mcu_as_sc_mcu7t3v3__inv_2_589 VSS VSS gf180mcu_as_sc_mcu7t3v3__inv_2_589/Y gf180mcu_as_sc_mcu7t3v3__inv_2_589/A
+ gf180mcu_as_sc_mcu7t3v3__inv_2_591/VNW VSUBS gf180mcu_as_sc_mcu7t3v3__inv_2
Xgf180mcu_as_sc_mcu7t3v3__inv_2_578 gf180mcu_as_sc_mcu7t3v3__inv_2_579/VDD VSS gf180mcu_as_sc_mcu7t3v3__inv_2_578/Y
+ gf180mcu_as_sc_mcu7t3v3__inv_2_579/Y gf180mcu_as_sc_mcu7t3v3__inv_2_579/VNW VSUBS
+ gf180mcu_as_sc_mcu7t3v3__inv_2
Xgf180mcu_as_sc_mcu7t3v3__inv_2_353 gf180mcu_as_sc_mcu7t3v3__inv_2_354/VDD gf180mcu_as_sc_mcu7t3v3__inv_2_468/VDD
+ gf180mcu_as_sc_mcu7t3v3__inv_2_353/Y gf180mcu_as_sc_mcu7t3v3__inv_2_354/Y gf180mcu_as_sc_mcu7t3v3__inv_2_354/VNW
+ VSUBS gf180mcu_as_sc_mcu7t3v3__inv_2
Xgf180mcu_as_sc_mcu7t3v3__inv_2_342 VSS VSS gf180mcu_as_sc_mcu7t3v3__inv_2_342/Y VSS
+ gf180mcu_as_sc_mcu7t3v3__inv_2_342/VNW VSUBS gf180mcu_as_sc_mcu7t3v3__inv_2
Xgf180mcu_as_sc_mcu7t3v3__inv_2_331 VSS VSS gf180mcu_as_sc_mcu7t3v3__inv_2_331/Y VSS
+ gf180mcu_as_sc_mcu7t3v3__inv_2_339/VNW VSUBS gf180mcu_as_sc_mcu7t3v3__inv_2
Xgf180mcu_as_sc_mcu7t3v3__inv_2_320 gf180mcu_as_sc_mcu7t3v3__inv_2_348/VSS VSS gf180mcu_as_sc_mcu7t3v3__inv_2_320/Y
+ VSS gf180mcu_as_sc_mcu7t3v3__inv_2_321/VNW VSUBS gf180mcu_as_sc_mcu7t3v3__inv_2
Xgf180mcu_as_sc_mcu7t3v3__inv_2_386 VSS VSS gf180mcu_as_sc_mcu7t3v3__inv_2_466/A gf180mcu_as_sc_mcu7t3v3__inv_2_387/Y
+ gf180mcu_as_sc_mcu7t3v3__inv_2_387/VNW VSUBS gf180mcu_as_sc_mcu7t3v3__inv_2
Xgf180mcu_as_sc_mcu7t3v3__inv_2_375 gf180mcu_as_sc_mcu7t3v3__inv_2_375/VDD VSS gf180mcu_as_sc_mcu7t3v3__inv_2_375/Y
+ VSS gf180mcu_as_sc_mcu7t3v3__inv_2_375/VNW VSUBS gf180mcu_as_sc_mcu7t3v3__inv_2
Xgf180mcu_as_sc_mcu7t3v3__inv_2_364 gf180mcu_as_sc_mcu7t3v3__inv_2_366/VDD VSS gf180mcu_as_sc_mcu7t3v3__inv_2_364/Y
+ gf180mcu_as_sc_mcu7t3v3__inv_2_930/A gf180mcu_as_sc_mcu7t3v3__inv_2_366/VNW VSUBS
+ gf180mcu_as_sc_mcu7t3v3__inv_2
Xgf180mcu_as_sc_mcu7t3v3__inv_2_397 VSS VSS gf180mcu_as_sc_mcu7t3v3__inv_2_397/Y gf180mcu_as_sc_mcu7t3v3__inv_2_466/A
+ gf180mcu_as_sc_mcu7t3v3__inv_2_399/VNW VSUBS gf180mcu_as_sc_mcu7t3v3__inv_2
Xgf180mcu_as_sc_mcu7t3v3__nand3_2_18 gf180mcu_as_sc_mcu7t3v3__nand2_2_9/VDD gf180mcu_as_sc_mcu7t3v3__nor2_2_4/VSS
+ VSS VSS VSS VSS gf180mcu_as_sc_mcu7t3v3__nand2_2_9/VNW VSUBS gf180mcu_as_sc_mcu7t3v3__nand3_2
Xgf180mcu_as_sc_mcu7t3v3__nand3_2_29 gf180mcu_as_sc_mcu7t3v3__inv_2_713/VDD gf180mcu_as_sc_mcu7t3v3__inv_2_713/VSS
+ VSS VSS VSS VSS gf180mcu_as_sc_mcu7t3v3__inv_2_713/VNW VSUBS gf180mcu_as_sc_mcu7t3v3__nand3_2
Xu_t009_003 u_t009_003/c0_w0_bl u_t009_003/c0_w0_br u_t009_003/c0_w1_bl u_t009_003/c0_w1_br
+ u_t009_003/c0_r0_rbl u_t009_003/c0_r1_rbl u_t009_003/c1_w0_bl u_t009_003/c1_w0_br
+ u_t009_003/c1_w1_bl u_t009_003/c1_w1_br u_t009_003/c1_r0_rbl u_t009_003/c1_r1_rbl
+ u_t009_003/c2_w0_bl u_t009_003/c2_w0_br u_t009_003/c2_w1_bl u_t009_003/c2_w1_br
+ u_t009_003/c2_r0_rbl u_t009_003/c2_r1_rbl u_t009_003/c3_w0_bl u_t009_003/c3_w0_br
+ u_t009_003/c3_w1_bl u_t009_003/c3_w1_br u_t009_003/c3_r0_rbl u_t009_003/c3_r1_rbl
+ u_t009_003/r0_w0_wl u_t009_003/r0_w1_wl u_t009_003/r0_r0_rwl u_t009_003/r0_r1_rwl
+ u_t009_003/r1_w0_wl u_t009_003/r1_w1_wl u_t009_003/r1_r0_rwl u_t009_003/r1_r1_rwl
+ u_t009_003/r2_w0_wl u_t009_003/r2_w1_wl u_t009_003/r2_r0_rwl u_t009_003/r2_r1_rwl
+ u_t009_003/r3_w0_wl u_t009_003/r3_w1_wl u_t009_003/r3_r0_rwl u_t009_003/r3_r1_rwl
+ u_t009_003/VDD u_t009_015/VSS VSUBS detronyx_12t_2w2r_rc4_4x4_routed_5layer_direct
Xu_t009_014 u_t009_014/c0_w0_bl u_t009_014/c0_w0_br u_t009_014/c0_w1_bl u_t009_014/c0_w1_br
+ u_t009_014/c0_r0_rbl u_t009_014/c0_r1_rbl u_t009_014/c1_w0_bl u_t009_014/c1_w0_br
+ u_t009_014/c1_w1_bl u_t009_014/c1_w1_br u_t009_014/c1_r0_rbl u_t009_014/c1_r1_rbl
+ u_t009_014/c2_w0_bl u_t009_014/c2_w0_br u_t009_014/c2_w1_bl u_t009_014/c2_w1_br
+ u_t009_014/c2_r0_rbl u_t009_014/c2_r1_rbl u_t009_014/c3_w0_bl u_t009_014/c3_w0_br
+ u_t009_014/c3_w1_bl u_t009_014/c3_w1_br u_t009_014/c3_r0_rbl u_t009_014/c3_r1_rbl
+ u_t009_014/r0_w0_wl u_t009_014/r0_w1_wl u_t009_014/r0_r0_rwl u_t009_014/r0_r1_rwl
+ u_t009_014/r1_w0_wl u_t009_014/r1_w1_wl u_t009_014/r1_r0_rwl u_t009_014/r1_r1_rwl
+ u_t009_014/r2_w0_wl u_t009_014/r2_w1_wl u_t009_014/r2_r0_rwl u_t009_014/r2_r1_rwl
+ u_t009_014/r3_w0_wl u_t009_014/r3_w1_wl u_t009_014/r3_r0_rwl u_t009_014/r3_r1_rwl
+ u_t009_014/VDD u_t009_015/VSS VSUBS detronyx_12t_2w2r_rc4_4x4_routed_5layer_direct
Xgf180mcu_as_sc_mcu7t3v3__inv_2_183 gf180mcu_as_sc_mcu7t3v3__nor2_2_4/VDD gf180mcu_as_sc_mcu7t3v3__nor2_2_4/VSS
+ gf180mcu_as_sc_mcu7t3v3__inv_2_183/Y VSS gf180mcu_as_sc_mcu7t3v3__nor2_2_4/VNW VSUBS
+ gf180mcu_as_sc_mcu7t3v3__inv_2
Xgf180mcu_as_sc_mcu7t3v3__inv_2_194 gf180mcu_as_sc_mcu7t3v3__nor2_2_6/VDD gf180mcu_as_sc_mcu7t3v3__nand3_2_1/VSS
+ gf180mcu_as_sc_mcu7t3v3__inv_2_194/Y VSS gf180mcu_as_sc_mcu7t3v3__nor2_2_6/VNW VSUBS
+ gf180mcu_as_sc_mcu7t3v3__inv_2
Xgf180mcu_as_sc_mcu7t3v3__inv_2_172 gf180mcu_as_sc_mcu7t3v3__inv_2_173/VDD VSS VSS
+ gf180mcu_as_sc_mcu7t3v3__inv_2_177/Y gf180mcu_as_sc_mcu7t3v3__inv_2_173/VNW VSUBS
+ gf180mcu_as_sc_mcu7t3v3__inv_2
Xgf180mcu_as_sc_mcu7t3v3__inv_2_161 gf180mcu_as_sc_mcu7t3v3__inv_2_162/VDD gf180mcu_as_sc_mcu7t3v3__inv_2_165/VDD
+ gf180mcu_as_sc_mcu7t3v3__inv_2_161/Y gf180mcu_as_sc_mcu7t3v3__inv_2_177/Y gf180mcu_as_sc_mcu7t3v3__inv_2_162/VNW
+ VSUBS gf180mcu_as_sc_mcu7t3v3__inv_2
Xgf180mcu_as_sc_mcu7t3v3__inv_2_150 VSS gf180mcu_as_sc_mcu7t3v3__inv_2_153/VDD gf180mcu_as_sc_mcu7t3v3__inv_2_153/Y
+ VSS gf180mcu_as_sc_mcu7t3v3__inv_2_150/VNW VSUBS gf180mcu_as_sc_mcu7t3v3__inv_2
Xu_t015_006 u_t015_006/c0_w0_bl u_t015_006/c0_w0_br u_t015_006/c0_w1_bl u_t015_006/c0_w1_br
+ u_t015_006/c0_r0_rbl u_t015_006/c0_r1_rbl u_t015_006/c1_w0_bl u_t015_006/c1_w0_br
+ u_t015_006/c1_w1_bl u_t015_006/c1_w1_br u_t015_006/c1_r0_rbl u_t015_006/c1_r1_rbl
+ u_t015_006/c2_w0_bl u_t015_006/c2_w0_br u_t015_006/c2_w1_bl u_t015_006/c2_w1_br
+ u_t015_006/c2_r0_rbl u_t015_006/c2_r1_rbl u_t015_006/c3_w0_bl u_t015_006/c3_w0_br
+ u_t015_006/c3_w1_bl u_t015_006/c3_w1_br u_t015_006/c3_r0_rbl u_t015_006/c3_r1_rbl
+ u_t015_006/r0_w0_wl u_t015_006/r0_w1_wl u_t015_006/r0_r0_rwl u_t015_006/r0_r1_rwl
+ u_t015_006/r1_w0_wl u_t015_006/r1_w1_wl u_t015_006/r1_r0_rwl u_t015_006/r1_r1_rwl
+ u_t015_006/r2_w0_wl u_t015_006/r2_w1_wl u_t015_006/r2_r0_rwl u_t015_006/r2_r1_rwl
+ u_t015_006/r3_w0_wl u_t015_006/r3_w1_wl u_t015_006/r3_r0_rwl u_t015_006/r3_r1_rwl
+ u_t015_006/VDD u_t015_009/VSS VSUBS detronyx_12t_2w2r_rc4_4x4_routed_5layer_direct
Xgf180mcu_as_sc_mcu7t3v3__nand2_2_40 gf180mcu_as_sc_mcu7t3v3__nand2_2_9/VDD gf180mcu_as_sc_mcu7t3v3__nor2_2_4/VSS
+ VSS VSS VSS gf180mcu_as_sc_mcu7t3v3__nand2_2_9/VNW VSUBS gf180mcu_as_sc_mcu7t3v3__nand2_2
Xgf180mcu_as_sc_mcu7t3v3__nand2_2_62 gf180mcu_as_sc_mcu7t3v3__inv_2_713/VDD gf180mcu_as_sc_mcu7t3v3__nor2_2_8/VSS
+ VSS VSS VSS gf180mcu_as_sc_mcu7t3v3__inv_2_713/VNW VSUBS gf180mcu_as_sc_mcu7t3v3__nand2_2
Xgf180mcu_as_sc_mcu7t3v3__nand2_2_51 gf180mcu_as_sc_mcu7t3v3__inv_2_713/VDD gf180mcu_as_sc_mcu7t3v3__nor2_2_8/VSS
+ VSS VSS VSS gf180mcu_as_sc_mcu7t3v3__inv_2_713/VNW VSUBS gf180mcu_as_sc_mcu7t3v3__nand2_2
Xu_t006_006 u_t006_006/c0_w0_bl u_t006_006/c0_w0_br u_t006_006/c0_w1_bl u_t006_006/c0_w1_br
+ u_t006_006/c0_r0_rbl u_t006_006/c0_r1_rbl u_t006_006/c1_w0_bl u_t006_006/c1_w0_br
+ u_t006_006/c1_w1_bl u_t006_006/c1_w1_br u_t006_006/c1_r0_rbl u_t006_006/c1_r1_rbl
+ u_t006_006/c2_w0_bl u_t006_006/c2_w0_br u_t006_006/c2_w1_bl u_t006_006/c2_w1_br
+ u_t006_006/c2_r0_rbl u_t006_006/c2_r1_rbl u_t006_006/c3_w0_bl u_t006_006/c3_w0_br
+ u_t006_006/c3_w1_bl u_t006_006/c3_w1_br u_t006_006/c3_r0_rbl u_t006_006/c3_r1_rbl
+ u_t006_006/r0_w0_wl u_t006_006/r0_w1_wl u_t006_006/r0_r0_rwl u_t006_006/r0_r1_rwl
+ u_t006_006/r1_w0_wl u_t006_006/r1_w1_wl u_t006_006/r1_r0_rwl u_t006_006/r1_r1_rwl
+ u_t006_006/r2_w0_wl u_t006_006/r2_w1_wl u_t006_006/r2_r0_rwl u_t006_006/r2_r1_rwl
+ u_t006_006/r3_w0_wl u_t006_006/r3_w1_wl u_t006_006/r3_r0_rwl u_t006_006/r3_r1_rwl
+ u_t006_006/VDD u_t006_009/VSS VSUBS detronyx_12t_2w2r_rc4_4x4_routed_5layer_direct
Xu_t012_009 u_t012_009/c0_w0_bl u_t012_009/c0_w0_br u_t012_009/c0_w1_bl u_t012_009/c0_w1_br
+ u_t012_009/c0_r0_rbl u_t012_009/c0_r1_rbl u_t012_009/c1_w0_bl u_t012_009/c1_w0_br
+ u_t012_009/c1_w1_bl u_t012_009/c1_w1_br u_t012_009/c1_r0_rbl u_t012_009/c1_r1_rbl
+ u_t012_009/c2_w0_bl u_t012_009/c2_w0_br u_t012_009/c2_w1_bl u_t012_009/c2_w1_br
+ u_t012_009/c2_r0_rbl u_t012_009/c2_r1_rbl u_t012_009/c3_w0_bl u_t012_009/c3_w0_br
+ u_t012_009/c3_w1_bl u_t012_009/c3_w1_br u_t012_009/c3_r0_rbl u_t012_009/c3_r1_rbl
+ u_t012_009/r0_w0_wl u_t012_009/r0_w1_wl u_t012_009/r0_r0_rwl u_t012_009/r0_r1_rwl
+ u_t012_009/r1_w0_wl u_t012_009/r1_w1_wl u_t012_009/r1_r0_rwl u_t012_009/r1_r1_rwl
+ u_t012_009/r2_w0_wl u_t012_009/r2_w1_wl u_t012_009/r2_r0_rwl u_t012_009/r2_r1_rwl
+ u_t012_009/r3_w0_wl u_t012_009/r3_w1_wl u_t012_009/r3_r0_rwl u_t012_009/r3_r1_rwl
+ VSS u_t012_015/VSS VSUBS detronyx_12t_2w2r_rc4_4x4_routed_5layer_direct
Xgf180mcu_as_sc_mcu7t3v3__inv_2_919 gf180mcu_as_sc_mcu7t3v3__inv_2_920/VDD VSS gf180mcu_as_sc_mcu7t3v3__inv_2_919/Y
+ VSS gf180mcu_as_sc_mcu7t3v3__inv_2_920/VNW VSUBS gf180mcu_as_sc_mcu7t3v3__inv_2
Xgf180mcu_as_sc_mcu7t3v3__inv_2_908 gf180mcu_as_sc_mcu7t3v3__inv_2_908/VDD VSS gf180mcu_as_sc_mcu7t3v3__inv_2_908/Y
+ VSS gf180mcu_as_sc_mcu7t3v3__inv_2_908/VNW VSUBS gf180mcu_as_sc_mcu7t3v3__inv_2
Xu_t003_009 u_t003_009/c0_w0_bl u_t003_009/c0_w0_br u_t003_009/c0_w1_bl u_t003_009/c0_w1_br
+ u_t003_009/c0_r0_rbl u_t003_009/c0_r1_rbl u_t003_009/c1_w0_bl u_t003_009/c1_w0_br
+ u_t003_009/c1_w1_bl u_t003_009/c1_w1_br u_t003_009/c1_r0_rbl u_t003_009/c1_r1_rbl
+ u_t003_009/c2_w0_bl u_t003_009/c2_w0_br u_t003_009/c2_w1_bl u_t003_009/c2_w1_br
+ u_t003_009/c2_r0_rbl u_t003_009/c2_r1_rbl u_t003_009/c3_w0_bl u_t003_009/c3_w0_br
+ u_t003_009/c3_w1_bl u_t003_009/c3_w1_br u_t003_009/c3_r0_rbl u_t003_009/c3_r1_rbl
+ u_t003_009/r0_w0_wl u_t003_009/r0_w1_wl u_t003_009/r0_r0_rwl u_t003_009/r0_r1_rwl
+ u_t003_009/r1_w0_wl u_t003_009/r1_w1_wl u_t003_009/r1_r0_rwl u_t003_009/r1_r1_rwl
+ u_t003_009/r2_w0_wl u_t003_009/r2_w1_wl u_t003_009/r2_r0_rwl u_t003_009/r2_r1_rwl
+ u_t003_009/r3_w0_wl u_t003_009/r3_w1_wl u_t003_009/r3_r0_rwl u_t003_009/r3_r1_rwl
+ VSS u_t003_009/VSS VSUBS detronyx_12t_2w2r_rc4_4x4_routed_5layer_direct
Xgf180mcu_as_sc_mcu7t3v3__nand4_2_218 gf180mcu_as_sc_mcu7t3v3__inv_2_812/VDD VSS VSS
+ VSS VSS VSS gf180mcu_as_sc_mcu7t3v3__nand4_2_218/Y gf180mcu_as_sc_mcu7t3v3__inv_2_812/VNW
+ VSUBS gf180mcu_as_sc_mcu7t3v3__nand4_2
Xgf180mcu_as_sc_mcu7t3v3__nand4_2_207 gf180mcu_as_sc_mcu7t3v3__inv_2_830/VSS gf180mcu_as_sc_mcu7t3v3__inv_2_782/VDD
+ VSS VSS VSS VSS gf180mcu_as_sc_mcu7t3v3__nand4_2_207/Y gf180mcu_as_sc_mcu7t3v3__inv_2_779/VNW
+ VSUBS gf180mcu_as_sc_mcu7t3v3__nand4_2
Xgf180mcu_as_sc_mcu7t3v3__nand4_2_229 gf180mcu_as_sc_mcu7t3v3__inv_2_845/VDD gf180mcu_as_sc_mcu7t3v3__inv_2_848/VDD
+ VSS VSS VSS VSS gf180mcu_as_sc_mcu7t3v3__nand4_2_229/Y gf180mcu_as_sc_mcu7t3v3__inv_2_845/VNW
+ VSUBS gf180mcu_as_sc_mcu7t3v3__nand4_2
Xgf180mcu_as_sc_mcu7t3v3__inv_2_727 gf180mcu_as_sc_mcu7t3v3__inv_2_776/VSS gf180mcu_as_sc_mcu7t3v3__inv_2_731/VDD
+ gf180mcu_as_sc_mcu7t3v3__inv_2_727/Y gf180mcu_as_sc_mcu7t3v3__inv_2_743/Y gf180mcu_as_sc_mcu7t3v3__inv_2_728/VNW
+ VSUBS gf180mcu_as_sc_mcu7t3v3__inv_2
Xgf180mcu_as_sc_mcu7t3v3__inv_2_716 VSS VSS gf180mcu_as_sc_mcu7t3v3__inv_2_716/Y VSS
+ gf180mcu_as_sc_mcu7t3v3__inv_2_716/VNW VSUBS gf180mcu_as_sc_mcu7t3v3__inv_2
Xgf180mcu_as_sc_mcu7t3v3__inv_2_705 VSS VSS VSS VSS gf180mcu_as_sc_mcu7t3v3__inv_2_707/VNW
+ VSUBS gf180mcu_as_sc_mcu7t3v3__inv_2
Xgf180mcu_as_sc_mcu7t3v3__inv_2_749 gf180mcu_as_sc_mcu7t3v3__inv_2_749/VDD gf180mcu_as_sc_mcu7t3v3__inv_2_752/VDD
+ gf180mcu_as_sc_mcu7t3v3__inv_2_752/Y VSS gf180mcu_as_sc_mcu7t3v3__inv_2_749/VNW
+ VSUBS gf180mcu_as_sc_mcu7t3v3__inv_2
Xgf180mcu_as_sc_mcu7t3v3__inv_2_738 gf180mcu_as_sc_mcu7t3v3__inv_2_740/VDD gf180mcu_as_sc_mcu7t3v3__inv_2_743/VDD
+ VSS gf180mcu_as_sc_mcu7t3v3__inv_2_743/Y gf180mcu_as_sc_mcu7t3v3__inv_2_740/VNW
+ VSUBS gf180mcu_as_sc_mcu7t3v3__inv_2
Xgf180mcu_as_sc_mcu7t3v3__inv_2_70 gf180mcu_as_sc_mcu7t3v3__inv_2_72/VDD gf180mcu_as_sc_mcu7t3v3__inv_2_75/VDD
+ gf180mcu_as_sc_mcu7t3v3__inv_2_70/Y VSS gf180mcu_as_sc_mcu7t3v3__inv_2_72/VNW VSUBS
+ gf180mcu_as_sc_mcu7t3v3__inv_2
Xgf180mcu_as_sc_mcu7t3v3__inv_2_92 gf180mcu_as_sc_mcu7t3v3__inv_2_93/VDD VSS gf180mcu_as_sc_mcu7t3v3__inv_2_92/Y
+ VSS gf180mcu_as_sc_mcu7t3v3__inv_2_93/VNW VSUBS gf180mcu_as_sc_mcu7t3v3__inv_2
Xgf180mcu_as_sc_mcu7t3v3__inv_2_81 gf180mcu_as_sc_mcu7t3v3__inv_2_81/VDD gf180mcu_as_sc_mcu7t3v3__inv_2_84/VDD
+ gf180mcu_as_sc_mcu7t3v3__inv_2_81/Y VSS gf180mcu_as_sc_mcu7t3v3__inv_2_81/VNW VSUBS
+ gf180mcu_as_sc_mcu7t3v3__inv_2
Xgf180mcu_as_sc_mcu7t3v3__nand4_2_7 VSS VSS VSS VSS VSS VSS VSS gf180mcu_as_sc_mcu7t3v3__inv_2_21/VNW
+ VSUBS gf180mcu_as_sc_mcu7t3v3__nand4_2
Xgf180mcu_as_sc_mcu7t3v3__inv_2_568 VSS gf180mcu_as_sc_mcu7t3v3__inv_2_932/VDD gf180mcu_as_sc_mcu7t3v3__inv_2_568/Y
+ gf180mcu_as_sc_mcu7t3v3__inv_2_930/A gf180mcu_as_sc_mcu7t3v3__inv_2_570/VNW VSUBS
+ gf180mcu_as_sc_mcu7t3v3__inv_2
Xgf180mcu_as_sc_mcu7t3v3__inv_2_502 VSS VSS VSS VSS gf180mcu_as_sc_mcu7t3v3__inv_2_504/VNW
+ VSUBS gf180mcu_as_sc_mcu7t3v3__inv_2
Xgf180mcu_as_sc_mcu7t3v3__inv_2_557 VSS VSS gf180mcu_as_sc_mcu7t3v3__inv_2_562/A gf180mcu_as_sc_mcu7t3v3__inv_2_558/Y
+ gf180mcu_as_sc_mcu7t3v3__inv_2_558/VNW VSUBS gf180mcu_as_sc_mcu7t3v3__inv_2
Xgf180mcu_as_sc_mcu7t3v3__inv_2_546 gf180mcu_as_sc_mcu7t3v3__inv_2_546/VDD VSS gf180mcu_as_sc_mcu7t3v3__inv_2_546/Y
+ VSS gf180mcu_as_sc_mcu7t3v3__inv_2_546/VNW VSUBS gf180mcu_as_sc_mcu7t3v3__inv_2
Xgf180mcu_as_sc_mcu7t3v3__inv_2_535 gf180mcu_as_sc_mcu7t3v3__inv_2_537/VDD gf180mcu_as_sc_mcu7t3v3__inv_2_540/VDD
+ gf180mcu_as_sc_mcu7t3v3__inv_2_535/Y gf180mcu_as_sc_mcu7t3v3__inv_2_545/Y gf180mcu_as_sc_mcu7t3v3__inv_2_537/VNW
+ VSUBS gf180mcu_as_sc_mcu7t3v3__inv_2
Xgf180mcu_as_sc_mcu7t3v3__inv_2_524 gf180mcu_as_sc_mcu7t3v3__inv_2_576/VSS VSS gf180mcu_as_sc_mcu7t3v3__inv_2_524/Y
+ gf180mcu_as_sc_mcu7t3v3__inv_2_525/Y gf180mcu_as_sc_mcu7t3v3__inv_2_525/VNW VSUBS
+ gf180mcu_as_sc_mcu7t3v3__inv_2
Xgf180mcu_as_sc_mcu7t3v3__inv_2_513 VSS VSS gf180mcu_as_sc_mcu7t3v3__inv_2_513/Y VSS
+ gf180mcu_as_sc_mcu7t3v3__inv_2_513/VNW VSUBS gf180mcu_as_sc_mcu7t3v3__inv_2
Xgf180mcu_as_sc_mcu7t3v3__inv_2_579 gf180mcu_as_sc_mcu7t3v3__inv_2_579/VDD VSS gf180mcu_as_sc_mcu7t3v3__inv_2_579/Y
+ VSS gf180mcu_as_sc_mcu7t3v3__inv_2_579/VNW VSUBS gf180mcu_as_sc_mcu7t3v3__inv_2
Xgf180mcu_as_sc_mcu7t3v3__inv_2_354 gf180mcu_as_sc_mcu7t3v3__inv_2_354/VDD gf180mcu_as_sc_mcu7t3v3__inv_2_468/VDD
+ gf180mcu_as_sc_mcu7t3v3__inv_2_354/Y VSS gf180mcu_as_sc_mcu7t3v3__inv_2_354/VNW
+ VSUBS gf180mcu_as_sc_mcu7t3v3__inv_2
Xgf180mcu_as_sc_mcu7t3v3__inv_2_332 VSS gf180mcu_as_sc_mcu7t3v3__inv_2_338/VDD gf180mcu_as_sc_mcu7t3v3__inv_2_332/Y
+ gf180mcu_as_sc_mcu7t3v3__inv_2_336/A gf180mcu_as_sc_mcu7t3v3__inv_2_334/VNW VSUBS
+ gf180mcu_as_sc_mcu7t3v3__inv_2
Xgf180mcu_as_sc_mcu7t3v3__inv_2_343 VSS gf180mcu_as_sc_mcu7t3v3__inv_2_348/VDD gf180mcu_as_sc_mcu7t3v3__inv_2_343/Y
+ VSS gf180mcu_as_sc_mcu7t3v3__inv_2_343/VNW VSUBS gf180mcu_as_sc_mcu7t3v3__inv_2
Xgf180mcu_as_sc_mcu7t3v3__inv_2_321 gf180mcu_as_sc_mcu7t3v3__inv_2_348/VSS VSS VSS
+ gf180mcu_as_sc_mcu7t3v3__inv_2_321/A gf180mcu_as_sc_mcu7t3v3__inv_2_321/VNW VSUBS
+ gf180mcu_as_sc_mcu7t3v3__inv_2
Xgf180mcu_as_sc_mcu7t3v3__inv_2_310 gf180mcu_as_sc_mcu7t3v3__nand2_2_9/VDD gf180mcu_as_sc_mcu7t3v3__nor2_2_6/VSS
+ VSS VSS gf180mcu_as_sc_mcu7t3v3__nand2_2_9/VNW VSUBS gf180mcu_as_sc_mcu7t3v3__inv_2
Xgf180mcu_as_sc_mcu7t3v3__inv_2_398 VSS VSS gf180mcu_as_sc_mcu7t3v3__inv_2_466/A gf180mcu_as_sc_mcu7t3v3__inv_2_399/Y
+ gf180mcu_as_sc_mcu7t3v3__inv_2_399/VNW VSUBS gf180mcu_as_sc_mcu7t3v3__inv_2
Xgf180mcu_as_sc_mcu7t3v3__inv_2_387 VSS VSS gf180mcu_as_sc_mcu7t3v3__inv_2_387/Y VSS
+ gf180mcu_as_sc_mcu7t3v3__inv_2_387/VNW VSUBS gf180mcu_as_sc_mcu7t3v3__inv_2
Xgf180mcu_as_sc_mcu7t3v3__inv_2_376 VSS VSS gf180mcu_as_sc_mcu7t3v3__inv_2_376/Y gf180mcu_as_sc_mcu7t3v3__inv_2_382/A
+ gf180mcu_as_sc_mcu7t3v3__inv_2_378/VNW VSUBS gf180mcu_as_sc_mcu7t3v3__inv_2
Xgf180mcu_as_sc_mcu7t3v3__inv_2_365 gf180mcu_as_sc_mcu7t3v3__inv_2_366/VDD VSS gf180mcu_as_sc_mcu7t3v3__inv_2_930/A
+ gf180mcu_as_sc_mcu7t3v3__inv_2_366/Y gf180mcu_as_sc_mcu7t3v3__inv_2_366/VNW VSUBS
+ gf180mcu_as_sc_mcu7t3v3__inv_2
Xgf180mcu_as_sc_mcu7t3v3__nand3_2_19 gf180mcu_as_sc_mcu7t3v3__nand2_2_9/VDD gf180mcu_as_sc_mcu7t3v3__nor2_2_6/VSS
+ VSS VSS VSS VSS gf180mcu_as_sc_mcu7t3v3__nand2_2_9/VNW VSUBS gf180mcu_as_sc_mcu7t3v3__nand3_2
Xu_t009_004 u_t009_004/c0_w0_bl u_t009_004/c0_w0_br u_t009_004/c0_w1_bl u_t009_004/c0_w1_br
+ u_t009_004/c0_r0_rbl u_t009_004/c0_r1_rbl u_t009_004/c1_w0_bl u_t009_004/c1_w0_br
+ u_t009_004/c1_w1_bl u_t009_004/c1_w1_br u_t009_004/c1_r0_rbl u_t009_004/c1_r1_rbl
+ u_t009_004/c2_w0_bl u_t009_004/c2_w0_br u_t009_004/c2_w1_bl u_t009_004/c2_w1_br
+ u_t009_004/c2_r0_rbl u_t009_004/c2_r1_rbl u_t009_004/c3_w0_bl u_t009_004/c3_w0_br
+ u_t009_004/c3_w1_bl u_t009_004/c3_w1_br u_t009_004/c3_r0_rbl u_t009_004/c3_r1_rbl
+ u_t009_004/r0_w0_wl u_t009_004/r0_w1_wl u_t009_004/r0_r0_rwl u_t009_004/r0_r1_rwl
+ u_t009_004/r1_w0_wl u_t009_004/r1_w1_wl u_t009_004/r1_r0_rwl u_t009_004/r1_r1_rwl
+ u_t009_004/r2_w0_wl u_t009_004/r2_w1_wl u_t009_004/r2_r0_rwl u_t009_004/r2_r1_rwl
+ u_t009_004/r3_w0_wl u_t009_004/r3_w1_wl u_t009_004/r3_r0_rwl u_t009_004/r3_r1_rwl
+ u_t009_004/VDD u_t009_015/VSS VSUBS detronyx_12t_2w2r_rc4_4x4_routed_5layer_direct
Xu_t009_015 u_t009_015/c0_w0_bl u_t009_015/c0_w0_br u_t009_015/c0_w1_bl u_t009_015/c0_w1_br
+ u_t009_015/c0_r0_rbl u_t009_015/c0_r1_rbl u_t009_015/c1_w0_bl u_t009_015/c1_w0_br
+ u_t009_015/c1_w1_bl u_t009_015/c1_w1_br u_t009_015/c1_r0_rbl u_t009_015/c1_r1_rbl
+ u_t009_015/c2_w0_bl u_t009_015/c2_w0_br u_t009_015/c2_w1_bl u_t009_015/c2_w1_br
+ u_t009_015/c2_r0_rbl u_t009_015/c2_r1_rbl u_t009_015/c3_w0_bl u_t009_015/c3_w0_br
+ u_t009_015/c3_w1_bl u_t009_015/c3_w1_br u_t009_015/c3_r0_rbl u_t009_015/c3_r1_rbl
+ u_t009_015/r0_w0_wl u_t009_015/r0_w1_wl u_t009_015/r0_r0_rwl u_t009_015/r0_r1_rwl
+ u_t009_015/r1_w0_wl u_t009_015/r1_w1_wl u_t009_015/r1_r0_rwl u_t009_015/r1_r1_rwl
+ u_t009_015/r2_w0_wl u_t009_015/r2_w1_wl u_t009_015/r2_r0_rwl u_t009_015/r2_r1_rwl
+ u_t009_015/r3_w0_wl u_t009_015/r3_w1_wl u_t009_015/r3_r0_rwl u_t009_015/r3_r1_rwl
+ VSS u_t009_015/VSS VSUBS detronyx_12t_2w2r_rc4_4x4_routed_5layer_direct
Xgf180mcu_as_sc_mcu7t3v3__inv_2_195 gf180mcu_as_sc_mcu7t3v3__nor2_2_4/VDD gf180mcu_as_sc_mcu7t3v3__nor2_2_4/VSS
+ VSS VSS gf180mcu_as_sc_mcu7t3v3__nor2_2_4/VNW VSUBS gf180mcu_as_sc_mcu7t3v3__inv_2
Xgf180mcu_as_sc_mcu7t3v3__inv_2_184 gf180mcu_as_sc_mcu7t3v3__nand2_2_9/VDD gf180mcu_as_sc_mcu7t3v3__nor2_2_4/VSS
+ VSS VSS gf180mcu_as_sc_mcu7t3v3__nand2_2_9/VNW VSUBS gf180mcu_as_sc_mcu7t3v3__inv_2
Xgf180mcu_as_sc_mcu7t3v3__inv_2_173 gf180mcu_as_sc_mcu7t3v3__inv_2_173/VDD VSS gf180mcu_as_sc_mcu7t3v3__inv_2_177/Y
+ gf180mcu_as_sc_mcu7t3v3__inv_2_177/Y gf180mcu_as_sc_mcu7t3v3__inv_2_173/VNW VSUBS
+ gf180mcu_as_sc_mcu7t3v3__inv_2
Xgf180mcu_as_sc_mcu7t3v3__inv_2_162 gf180mcu_as_sc_mcu7t3v3__inv_2_162/VDD gf180mcu_as_sc_mcu7t3v3__inv_2_165/VDD
+ gf180mcu_as_sc_mcu7t3v3__inv_2_177/Y VSS gf180mcu_as_sc_mcu7t3v3__inv_2_162/VNW
+ VSUBS gf180mcu_as_sc_mcu7t3v3__inv_2
Xgf180mcu_as_sc_mcu7t3v3__inv_2_151 gf180mcu_as_sc_mcu7t3v3__inv_2_153/VDD gf180mcu_as_sc_mcu7t3v3__inv_2_159/VDD
+ VSS gf180mcu_as_sc_mcu7t3v3__inv_2_153/Y gf180mcu_as_sc_mcu7t3v3__inv_2_153/VNW
+ VSUBS gf180mcu_as_sc_mcu7t3v3__inv_2
Xgf180mcu_as_sc_mcu7t3v3__inv_2_140 gf180mcu_as_sc_mcu7t3v3__inv_2_141/VDD gf180mcu_as_sc_mcu7t3v3__inv_2_144/VDD
+ gf180mcu_as_sc_mcu7t3v3__inv_2_140/Y gf180mcu_as_sc_mcu7t3v3__inv_2_923/Y gf180mcu_as_sc_mcu7t3v3__inv_2_141/VNW
+ VSUBS gf180mcu_as_sc_mcu7t3v3__inv_2
Xu_t015_007 u_t015_007/c0_w0_bl u_t015_007/c0_w0_br u_t015_007/c0_w1_bl u_t015_007/c0_w1_br
+ u_t015_007/c0_r0_rbl u_t015_007/c0_r1_rbl u_t015_007/c1_w0_bl u_t015_007/c1_w0_br
+ u_t015_007/c1_w1_bl u_t015_007/c1_w1_br u_t015_007/c1_r0_rbl u_t015_007/c1_r1_rbl
+ u_t015_007/c2_w0_bl u_t015_007/c2_w0_br u_t015_007/c2_w1_bl u_t015_007/c2_w1_br
+ u_t015_007/c2_r0_rbl u_t015_007/c2_r1_rbl u_t015_007/c3_w0_bl u_t015_007/c3_w0_br
+ u_t015_007/c3_w1_bl u_t015_007/c3_w1_br u_t015_007/c3_r0_rbl u_t015_007/c3_r1_rbl
+ u_t015_007/r0_w0_wl u_t015_007/r0_w1_wl u_t015_007/r0_r0_rwl u_t015_007/r0_r1_rwl
+ u_t015_007/r1_w0_wl u_t015_007/r1_w1_wl u_t015_007/r1_r0_rwl u_t015_007/r1_r1_rwl
+ u_t015_007/r2_w0_wl u_t015_007/r2_w1_wl u_t015_007/r2_r0_rwl u_t015_007/r2_r1_rwl
+ u_t015_007/r3_w0_wl u_t015_007/r3_w1_wl u_t015_007/r3_r0_rwl u_t015_007/r3_r1_rwl
+ VSS u_t015_009/VSS VSUBS detronyx_12t_2w2r_rc4_4x4_routed_5layer_direct
Xgf180mcu_as_sc_mcu7t3v3__nand2_2_30 gf180mcu_as_sc_mcu7t3v3__nand2_2_9/VDD gf180mcu_as_sc_mcu7t3v3__nor2_2_6/VSS
+ VSS VSS VSS gf180mcu_as_sc_mcu7t3v3__nand2_2_9/VNW VSUBS gf180mcu_as_sc_mcu7t3v3__nand2_2
Xgf180mcu_as_sc_mcu7t3v3__nand2_2_41 gf180mcu_as_sc_mcu7t3v3__nand2_2_9/VDD gf180mcu_as_sc_mcu7t3v3__nor2_2_6/VSS
+ VSS VSS VSS gf180mcu_as_sc_mcu7t3v3__nand2_2_9/VNW VSUBS gf180mcu_as_sc_mcu7t3v3__nand2_2
Xu_t006_007 u_t006_007/c0_w0_bl u_t006_007/c0_w0_br u_t006_007/c0_w1_bl u_t006_007/c0_w1_br
+ u_t006_007/c0_r0_rbl u_t006_007/c0_r1_rbl u_t006_007/c1_w0_bl u_t006_007/c1_w0_br
+ u_t006_007/c1_w1_bl u_t006_007/c1_w1_br u_t006_007/c1_r0_rbl u_t006_007/c1_r1_rbl
+ u_t006_007/c2_w0_bl u_t006_007/c2_w0_br u_t006_007/c2_w1_bl u_t006_007/c2_w1_br
+ u_t006_007/c2_r0_rbl u_t006_007/c2_r1_rbl u_t006_007/c3_w0_bl u_t006_007/c3_w0_br
+ u_t006_007/c3_w1_bl u_t006_007/c3_w1_br u_t006_007/c3_r0_rbl u_t006_007/c3_r1_rbl
+ u_t006_007/r0_w0_wl u_t006_007/r0_w1_wl u_t006_007/r0_r0_rwl u_t006_007/r0_r1_rwl
+ u_t006_007/r1_w0_wl u_t006_007/r1_w1_wl u_t006_007/r1_r0_rwl u_t006_007/r1_r1_rwl
+ u_t006_007/r2_w0_wl u_t006_007/r2_w1_wl u_t006_007/r2_r0_rwl u_t006_007/r2_r1_rwl
+ u_t006_007/r3_w0_wl u_t006_007/r3_w1_wl u_t006_007/r3_r0_rwl u_t006_007/r3_r1_rwl
+ VSS u_t006_009/VSS VSUBS detronyx_12t_2w2r_rc4_4x4_routed_5layer_direct
Xgf180mcu_as_sc_mcu7t3v3__nand2_2_52 gf180mcu_as_sc_mcu7t3v3__inv_2_713/VDD gf180mcu_as_sc_mcu7t3v3__inv_2_713/VSS
+ VSS VSS VSS gf180mcu_as_sc_mcu7t3v3__inv_2_713/VNW VSUBS gf180mcu_as_sc_mcu7t3v3__nand2_2
Xgf180mcu_as_sc_mcu7t3v3__nand2_2_63 gf180mcu_as_sc_mcu7t3v3__nor2_2_8/VDD gf180mcu_as_sc_mcu7t3v3__inv_2_710/VSS
+ VSS VSS VSS gf180mcu_as_sc_mcu7t3v3__nor2_2_8/VNW VSUBS gf180mcu_as_sc_mcu7t3v3__nand2_2
Xgf180mcu_as_sc_mcu7t3v3__inv_2_909 VSS gf180mcu_as_sc_mcu7t3v3__inv_2_914/VDD VSS
+ gf180mcu_as_sc_mcu7t3v3__inv_2_917/Y gf180mcu_as_sc_mcu7t3v3__inv_2_911/VNW VSUBS
+ gf180mcu_as_sc_mcu7t3v3__inv_2
Xu_t011_010 u_t011_010/c0_w0_bl u_t011_010/c0_w0_br u_t011_010/c0_w1_bl u_t011_010/c0_w1_br
+ u_t011_010/c0_r0_rbl u_t011_010/c0_r1_rbl u_t011_010/c1_w0_bl u_t011_010/c1_w0_br
+ u_t011_010/c1_w1_bl u_t011_010/c1_w1_br u_t011_010/c1_r0_rbl u_t011_010/c1_r1_rbl
+ u_t011_010/c2_w0_bl u_t011_010/c2_w0_br u_t011_010/c2_w1_bl u_t011_010/c2_w1_br
+ u_t011_010/c2_r0_rbl u_t011_010/c2_r1_rbl u_t011_010/c3_w0_bl u_t011_010/c3_w0_br
+ u_t011_010/c3_w1_bl u_t011_010/c3_w1_br u_t011_010/c3_r0_rbl u_t011_010/c3_r1_rbl
+ u_t011_010/r0_w0_wl u_t011_010/r0_w1_wl u_t011_010/r0_r0_rwl u_t011_010/r0_r1_rwl
+ u_t011_010/r1_w0_wl u_t011_010/r1_w1_wl u_t011_010/r1_r0_rwl u_t011_010/r1_r1_rwl
+ u_t011_010/r2_w0_wl u_t011_010/r2_w1_wl u_t011_010/r2_r0_rwl u_t011_010/r2_r1_rwl
+ u_t011_010/r3_w0_wl u_t011_010/r3_w1_wl u_t011_010/r3_r0_rwl u_t011_010/r3_r1_rwl
+ VSS u_t011_010/VSS VSUBS detronyx_12t_2w2r_rc4_4x4_routed_5layer_direct
Xgf180mcu_as_sc_mcu7t3v3__nand4_2_219 VSS VSS VSS VSS VSS VSS VSS gf180mcu_as_sc_mcu7t3v3__inv_2_815/VNW
+ VSUBS gf180mcu_as_sc_mcu7t3v3__nand4_2
Xgf180mcu_as_sc_mcu7t3v3__nand4_2_208 gf180mcu_as_sc_mcu7t3v3__inv_2_782/VDD gf180mcu_as_sc_mcu7t3v3__inv_2_785/VDD
+ VSS VSS VSS VSS gf180mcu_as_sc_mcu7t3v3__nand4_2_208/Y gf180mcu_as_sc_mcu7t3v3__inv_2_782/VNW
+ VSUBS gf180mcu_as_sc_mcu7t3v3__nand4_2
Xu_t002_010 u_t002_010/c0_w0_bl u_t002_010/c0_w0_br u_t002_010/c0_w1_bl u_t002_010/c0_w1_br
+ u_t002_010/c0_r0_rbl u_t002_010/c0_r1_rbl u_t002_010/c1_w0_bl u_t002_010/c1_w0_br
+ u_t002_010/c1_w1_bl u_t002_010/c1_w1_br u_t002_010/c1_r0_rbl u_t002_010/c1_r1_rbl
+ u_t002_010/c2_w0_bl u_t002_010/c2_w0_br u_t002_010/c2_w1_bl u_t002_010/c2_w1_br
+ u_t002_010/c2_r0_rbl u_t002_010/c2_r1_rbl u_t002_010/c3_w0_bl u_t002_010/c3_w0_br
+ u_t002_010/c3_w1_bl u_t002_010/c3_w1_br u_t002_010/c3_r0_rbl u_t002_010/c3_r1_rbl
+ u_t002_010/r0_w0_wl u_t002_010/r0_w1_wl u_t002_010/r0_r0_rwl u_t002_010/r0_r1_rwl
+ u_t002_010/r1_w0_wl u_t002_010/r1_w1_wl u_t002_010/r1_r0_rwl u_t002_010/r1_r1_rwl
+ u_t002_010/r2_w0_wl u_t002_010/r2_w1_wl u_t002_010/r2_r0_rwl u_t002_010/r2_r1_rwl
+ u_t002_010/r3_w0_wl u_t002_010/r3_w1_wl u_t002_010/r3_r0_rwl u_t002_010/r3_r1_rwl
+ VSS u_t002_010/VSS VSUBS detronyx_12t_2w2r_rc4_4x4_routed_5layer_direct
Xgf180mcu_as_sc_mcu7t3v3__inv_2_739 gf180mcu_as_sc_mcu7t3v3__inv_2_740/VDD gf180mcu_as_sc_mcu7t3v3__inv_2_743/VDD
+ gf180mcu_as_sc_mcu7t3v3__inv_2_739/Y gf180mcu_as_sc_mcu7t3v3__inv_2_743/Y gf180mcu_as_sc_mcu7t3v3__inv_2_740/VNW
+ VSUBS gf180mcu_as_sc_mcu7t3v3__inv_2
Xgf180mcu_as_sc_mcu7t3v3__inv_2_728 gf180mcu_as_sc_mcu7t3v3__inv_2_776/VSS gf180mcu_as_sc_mcu7t3v3__inv_2_731/VDD
+ gf180mcu_as_sc_mcu7t3v3__inv_2_743/Y VSS gf180mcu_as_sc_mcu7t3v3__inv_2_728/VNW
+ VSUBS gf180mcu_as_sc_mcu7t3v3__inv_2
Xgf180mcu_as_sc_mcu7t3v3__inv_2_717 gf180mcu_as_sc_mcu7t3v3__inv_2_719/VDD VSS gf180mcu_as_sc_mcu7t3v3__inv_2_717/Y
+ gf180mcu_as_sc_mcu7t3v3__inv_2_717/A gf180mcu_as_sc_mcu7t3v3__inv_2_719/VNW VSUBS
+ gf180mcu_as_sc_mcu7t3v3__inv_2
Xgf180mcu_as_sc_mcu7t3v3__inv_2_706 VSS VSS VSS VSS gf180mcu_as_sc_mcu7t3v3__inv_2_707/VNW
+ VSUBS gf180mcu_as_sc_mcu7t3v3__inv_2
Xgf180mcu_as_sc_mcu7t3v3__inv_2_60 VSS gf180mcu_as_sc_mcu7t3v3__inv_2_63/VDD VSS VSS
+ gf180mcu_as_sc_mcu7t3v3__inv_2_60/VNW VSUBS gf180mcu_as_sc_mcu7t3v3__inv_2
Xgf180mcu_as_sc_mcu7t3v3__inv_2_93 gf180mcu_as_sc_mcu7t3v3__inv_2_93/VDD VSS gf180mcu_as_sc_mcu7t3v3__inv_2_93/Y
+ VSS gf180mcu_as_sc_mcu7t3v3__inv_2_93/VNW VSUBS gf180mcu_as_sc_mcu7t3v3__inv_2
Xgf180mcu_as_sc_mcu7t3v3__inv_2_82 gf180mcu_as_sc_mcu7t3v3__inv_2_84/VDD VSS gf180mcu_as_sc_mcu7t3v3__inv_2_82/Y
+ VSS gf180mcu_as_sc_mcu7t3v3__inv_2_84/VNW VSUBS gf180mcu_as_sc_mcu7t3v3__inv_2
Xgf180mcu_as_sc_mcu7t3v3__inv_2_71 gf180mcu_as_sc_mcu7t3v3__inv_2_72/VDD gf180mcu_as_sc_mcu7t3v3__inv_2_75/VDD
+ gf180mcu_as_sc_mcu7t3v3__inv_2_71/Y VSS gf180mcu_as_sc_mcu7t3v3__inv_2_72/VNW VSUBS
+ gf180mcu_as_sc_mcu7t3v3__inv_2
Xgf180mcu_as_sc_mcu7t3v3__nand4_2_8 VSS gf180mcu_as_sc_mcu7t3v3__inv_2_27/VDD VSS
+ VSS VSS VSS VSS gf180mcu_as_sc_mcu7t3v3__inv_2_24/VNW VSUBS gf180mcu_as_sc_mcu7t3v3__nand4_2
Xgf180mcu_as_sc_mcu7t3v3__inv_2_569 VSS gf180mcu_as_sc_mcu7t3v3__inv_2_932/VDD gf180mcu_as_sc_mcu7t3v3__inv_2_569/Y
+ gf180mcu_as_sc_mcu7t3v3__inv_2_570/Y gf180mcu_as_sc_mcu7t3v3__inv_2_570/VNW VSUBS
+ gf180mcu_as_sc_mcu7t3v3__inv_2
Xgf180mcu_as_sc_mcu7t3v3__inv_2_503 VSS VSS VSS VSS gf180mcu_as_sc_mcu7t3v3__inv_2_504/VNW
+ VSUBS gf180mcu_as_sc_mcu7t3v3__inv_2
Xgf180mcu_as_sc_mcu7t3v3__inv_2_558 VSS VSS gf180mcu_as_sc_mcu7t3v3__inv_2_558/Y VSS
+ gf180mcu_as_sc_mcu7t3v3__inv_2_558/VNW VSUBS gf180mcu_as_sc_mcu7t3v3__inv_2
Xgf180mcu_as_sc_mcu7t3v3__inv_2_547 VSS gf180mcu_as_sc_mcu7t3v3__inv_2_552/VDD gf180mcu_as_sc_mcu7t3v3__inv_2_547/Y
+ gf180mcu_as_sc_mcu7t3v3__inv_2_553/A gf180mcu_as_sc_mcu7t3v3__inv_2_549/VNW VSUBS
+ gf180mcu_as_sc_mcu7t3v3__inv_2
Xgf180mcu_as_sc_mcu7t3v3__inv_2_536 gf180mcu_as_sc_mcu7t3v3__inv_2_537/VDD gf180mcu_as_sc_mcu7t3v3__inv_2_540/VDD
+ gf180mcu_as_sc_mcu7t3v3__inv_2_545/Y gf180mcu_as_sc_mcu7t3v3__inv_2_537/Y gf180mcu_as_sc_mcu7t3v3__inv_2_537/VNW
+ VSUBS gf180mcu_as_sc_mcu7t3v3__inv_2
Xgf180mcu_as_sc_mcu7t3v3__inv_2_525 gf180mcu_as_sc_mcu7t3v3__inv_2_576/VSS VSS gf180mcu_as_sc_mcu7t3v3__inv_2_525/Y
+ VSS gf180mcu_as_sc_mcu7t3v3__inv_2_525/VNW VSUBS gf180mcu_as_sc_mcu7t3v3__inv_2
Xgf180mcu_as_sc_mcu7t3v3__inv_2_514 VSS VSS VSS VSS gf180mcu_as_sc_mcu7t3v3__inv_2_516/VNW
+ VSUBS gf180mcu_as_sc_mcu7t3v3__inv_2
Xgf180mcu_as_sc_mcu7t3v3__inv_2_300 VSS VSS VSS VSS gf180mcu_as_sc_mcu7t3v3__inv_2_302/VNW
+ VSUBS gf180mcu_as_sc_mcu7t3v3__inv_2
Xgf180mcu_as_sc_mcu7t3v3__inv_2_311 gf180mcu_as_sc_mcu7t3v3__nor2_2_6/VDD gf180mcu_as_sc_mcu7t3v3__nor2_2_6/VSS
+ VSS VSS gf180mcu_as_sc_mcu7t3v3__nor2_2_6/VNW VSUBS gf180mcu_as_sc_mcu7t3v3__inv_2
Xgf180mcu_as_sc_mcu7t3v3__inv_2_333 VSS gf180mcu_as_sc_mcu7t3v3__inv_2_338/VDD gf180mcu_as_sc_mcu7t3v3__inv_2_333/Y
+ gf180mcu_as_sc_mcu7t3v3__inv_2_334/Y gf180mcu_as_sc_mcu7t3v3__inv_2_334/VNW VSUBS
+ gf180mcu_as_sc_mcu7t3v3__inv_2
Xgf180mcu_as_sc_mcu7t3v3__inv_2_344 VSS gf180mcu_as_sc_mcu7t3v3__inv_2_345/VSS gf180mcu_as_sc_mcu7t3v3__inv_2_344/Y
+ gf180mcu_as_sc_mcu7t3v3__inv_2_344/A gf180mcu_as_sc_mcu7t3v3__inv_2_345/VNW VSUBS
+ gf180mcu_as_sc_mcu7t3v3__inv_2
Xgf180mcu_as_sc_mcu7t3v3__inv_2_322 VSS gf180mcu_as_sc_mcu7t3v3__inv_2_345/VSS gf180mcu_as_sc_mcu7t3v3__inv_2_345/A
+ VSS gf180mcu_as_sc_mcu7t3v3__inv_2_345/VNW VSUBS gf180mcu_as_sc_mcu7t3v3__inv_2
Xgf180mcu_as_sc_mcu7t3v3__inv_2_399 VSS VSS gf180mcu_as_sc_mcu7t3v3__inv_2_399/Y VSS
+ gf180mcu_as_sc_mcu7t3v3__inv_2_399/VNW VSUBS gf180mcu_as_sc_mcu7t3v3__inv_2
Xgf180mcu_as_sc_mcu7t3v3__inv_2_388 VSS VSS gf180mcu_as_sc_mcu7t3v3__inv_2_388/Y gf180mcu_as_sc_mcu7t3v3__inv_2_466/A
+ gf180mcu_as_sc_mcu7t3v3__inv_2_390/VNW VSUBS gf180mcu_as_sc_mcu7t3v3__inv_2
Xgf180mcu_as_sc_mcu7t3v3__inv_2_377 VSS VSS gf180mcu_as_sc_mcu7t3v3__inv_2_382/A gf180mcu_as_sc_mcu7t3v3__inv_2_378/Y
+ gf180mcu_as_sc_mcu7t3v3__inv_2_378/VNW VSUBS gf180mcu_as_sc_mcu7t3v3__inv_2
Xgf180mcu_as_sc_mcu7t3v3__inv_2_366 gf180mcu_as_sc_mcu7t3v3__inv_2_366/VDD VSS gf180mcu_as_sc_mcu7t3v3__inv_2_366/Y
+ VSS gf180mcu_as_sc_mcu7t3v3__inv_2_366/VNW VSUBS gf180mcu_as_sc_mcu7t3v3__inv_2
Xgf180mcu_as_sc_mcu7t3v3__inv_2_355 gf180mcu_as_sc_mcu7t3v3__inv_2_932/VSS VSS gf180mcu_as_sc_mcu7t3v3__inv_2_355/Y
+ gf180mcu_as_sc_mcu7t3v3__inv_2_930/A gf180mcu_as_sc_mcu7t3v3__inv_2_357/VNW VSUBS
+ gf180mcu_as_sc_mcu7t3v3__inv_2
Xgf180mcu_as_sc_mcu7t3v3__inv_2_152 gf180mcu_as_sc_mcu7t3v3__inv_2_153/VDD gf180mcu_as_sc_mcu7t3v3__inv_2_159/VDD
+ gf180mcu_as_sc_mcu7t3v3__inv_2_152/Y gf180mcu_as_sc_mcu7t3v3__inv_2_153/Y gf180mcu_as_sc_mcu7t3v3__inv_2_153/VNW
+ VSUBS gf180mcu_as_sc_mcu7t3v3__inv_2
Xgf180mcu_as_sc_mcu7t3v3__inv_2_141 gf180mcu_as_sc_mcu7t3v3__inv_2_141/VDD gf180mcu_as_sc_mcu7t3v3__inv_2_144/VDD
+ gf180mcu_as_sc_mcu7t3v3__inv_2_923/Y VSS gf180mcu_as_sc_mcu7t3v3__inv_2_141/VNW
+ VSUBS gf180mcu_as_sc_mcu7t3v3__inv_2
Xgf180mcu_as_sc_mcu7t3v3__inv_2_130 gf180mcu_as_sc_mcu7t3v3__inv_2_132/VDD gf180mcu_as_sc_mcu7t3v3__inv_2_135/VDD
+ VSS gf180mcu_as_sc_mcu7t3v3__inv_2_923/Y gf180mcu_as_sc_mcu7t3v3__inv_2_132/VNW
+ VSUBS gf180mcu_as_sc_mcu7t3v3__inv_2
Xu_t009_005 u_t009_005/c0_w0_bl u_t009_005/c0_w0_br u_t009_005/c0_w1_bl u_t009_005/c0_w1_br
+ u_t009_005/c0_r0_rbl u_t009_005/c0_r1_rbl u_t009_005/c1_w0_bl u_t009_005/c1_w0_br
+ u_t009_005/c1_w1_bl u_t009_005/c1_w1_br u_t009_005/c1_r0_rbl u_t009_005/c1_r1_rbl
+ u_t009_005/c2_w0_bl u_t009_005/c2_w0_br u_t009_005/c2_w1_bl u_t009_005/c2_w1_br
+ u_t009_005/c2_r0_rbl u_t009_005/c2_r1_rbl u_t009_005/c3_w0_bl u_t009_005/c3_w0_br
+ u_t009_005/c3_w1_bl u_t009_005/c3_w1_br u_t009_005/c3_r0_rbl u_t009_005/c3_r1_rbl
+ u_t009_005/r0_w0_wl u_t009_005/r0_w1_wl u_t009_005/r0_r0_rwl u_t009_005/r0_r1_rwl
+ u_t009_005/r1_w0_wl u_t009_005/r1_w1_wl u_t009_005/r1_r0_rwl u_t009_005/r1_r1_rwl
+ u_t009_005/r2_w0_wl u_t009_005/r2_w1_wl u_t009_005/r2_r0_rwl u_t009_005/r2_r1_rwl
+ u_t009_005/r3_w0_wl u_t009_005/r3_w1_wl u_t009_005/r3_r0_rwl u_t009_005/r3_r1_rwl
+ u_t009_005/VDD u_t009_015/VSS VSUBS detronyx_12t_2w2r_rc4_4x4_routed_5layer_direct
Xgf180mcu_as_sc_mcu7t3v3__inv_2_174 gf180mcu_as_sc_mcu7t3v3__inv_2_63/VSS VSS gf180mcu_as_sc_mcu7t3v3__inv_2_174/Y
+ VSS gf180mcu_as_sc_mcu7t3v3__inv_2_179/VNW VSUBS gf180mcu_as_sc_mcu7t3v3__inv_2
Xgf180mcu_as_sc_mcu7t3v3__inv_2_196 gf180mcu_as_sc_mcu7t3v3__nor2_2_5/VDD gf180mcu_as_sc_mcu7t3v3__nor2_2_5/VSS
+ VSS VSS gf180mcu_as_sc_mcu7t3v3__nor2_2_5/VNW VSUBS gf180mcu_as_sc_mcu7t3v3__inv_2
Xgf180mcu_as_sc_mcu7t3v3__inv_2_185 gf180mcu_as_sc_mcu7t3v3__nand2_2_9/VDD gf180mcu_as_sc_mcu7t3v3__nor2_2_6/VSS
+ VSS VSS gf180mcu_as_sc_mcu7t3v3__nand2_2_9/VNW VSUBS gf180mcu_as_sc_mcu7t3v3__inv_2
Xgf180mcu_as_sc_mcu7t3v3__inv_2_163 gf180mcu_as_sc_mcu7t3v3__inv_2_165/VDD VSS VSS
+ gf180mcu_as_sc_mcu7t3v3__inv_2_177/Y gf180mcu_as_sc_mcu7t3v3__inv_2_165/VNW VSUBS
+ gf180mcu_as_sc_mcu7t3v3__inv_2
Xu_t015_008 u_t015_008/c0_w0_bl u_t015_008/c0_w0_br u_t015_008/c0_w1_bl u_t015_008/c0_w1_br
+ u_t015_008/c0_r0_rbl u_t015_008/c0_r1_rbl u_t015_008/c1_w0_bl u_t015_008/c1_w0_br
+ u_t015_008/c1_w1_bl u_t015_008/c1_w1_br u_t015_008/c1_r0_rbl u_t015_008/c1_r1_rbl
+ u_t015_008/c2_w0_bl u_t015_008/c2_w0_br u_t015_008/c2_w1_bl u_t015_008/c2_w1_br
+ u_t015_008/c2_r0_rbl u_t015_008/c2_r1_rbl u_t015_008/c3_w0_bl u_t015_008/c3_w0_br
+ u_t015_008/c3_w1_bl u_t015_008/c3_w1_br u_t015_008/c3_r0_rbl u_t015_008/c3_r1_rbl
+ u_t015_008/r0_w0_wl u_t015_008/r0_w1_wl u_t015_008/r0_r0_rwl u_t015_008/r0_r1_rwl
+ u_t015_008/r1_w0_wl u_t015_008/r1_w1_wl u_t015_008/r1_r0_rwl u_t015_008/r1_r1_rwl
+ u_t015_008/r2_w0_wl u_t015_008/r2_w1_wl u_t015_008/r2_r0_rwl u_t015_008/r2_r1_rwl
+ u_t015_008/r3_w0_wl u_t015_008/r3_w1_wl u_t015_008/r3_r0_rwl u_t015_008/r3_r1_rwl
+ VSS u_t015_009/VSS VSUBS detronyx_12t_2w2r_rc4_4x4_routed_5layer_direct
Xgf180mcu_as_sc_mcu7t3v3__nand2_2_42 gf180mcu_as_sc_mcu7t3v3__nor2_2_5/VDD gf180mcu_as_sc_mcu7t3v3__nand3_2_8/VSS
+ VSS VSS VSS gf180mcu_as_sc_mcu7t3v3__nor2_2_5/VNW VSUBS gf180mcu_as_sc_mcu7t3v3__nand2_2
Xgf180mcu_as_sc_mcu7t3v3__nand2_2_31 gf180mcu_as_sc_mcu7t3v3__nor2_2_6/VDD gf180mcu_as_sc_mcu7t3v3__nor2_2_6/VSS
+ VSS VSS VSS gf180mcu_as_sc_mcu7t3v3__nor2_2_6/VNW VSUBS gf180mcu_as_sc_mcu7t3v3__nand2_2
Xgf180mcu_as_sc_mcu7t3v3__nand2_2_20 gf180mcu_as_sc_mcu7t3v3__nand2_2_9/VDD gf180mcu_as_sc_mcu7t3v3__nor2_2_6/VSS
+ VSS VSS VSS gf180mcu_as_sc_mcu7t3v3__nand2_2_9/VNW VSUBS gf180mcu_as_sc_mcu7t3v3__nand2_2
Xgf180mcu_as_sc_mcu7t3v3__nand2_2_64 gf180mcu_as_sc_mcu7t3v3__inv_2_713/VDD gf180mcu_as_sc_mcu7t3v3__nor2_2_8/VSS
+ VSS VSS VSS gf180mcu_as_sc_mcu7t3v3__inv_2_713/VNW VSUBS gf180mcu_as_sc_mcu7t3v3__nand2_2
Xgf180mcu_as_sc_mcu7t3v3__nand2_2_53 gf180mcu_as_sc_mcu7t3v3__nor2_2_8/VDD gf180mcu_as_sc_mcu7t3v3__inv_2_710/VSS
+ VSS VSS VSS gf180mcu_as_sc_mcu7t3v3__nor2_2_8/VNW VSUBS gf180mcu_as_sc_mcu7t3v3__nand2_2
Xu_t006_008 u_t006_008/c0_w0_bl u_t006_008/c0_w0_br u_t006_008/c0_w1_bl u_t006_008/c0_w1_br
+ u_t006_008/c0_r0_rbl u_t006_008/c0_r1_rbl u_t006_008/c1_w0_bl u_t006_008/c1_w0_br
+ u_t006_008/c1_w1_bl u_t006_008/c1_w1_br u_t006_008/c1_r0_rbl u_t006_008/c1_r1_rbl
+ u_t006_008/c2_w0_bl u_t006_008/c2_w0_br u_t006_008/c2_w1_bl u_t006_008/c2_w1_br
+ u_t006_008/c2_r0_rbl u_t006_008/c2_r1_rbl u_t006_008/c3_w0_bl u_t006_008/c3_w0_br
+ u_t006_008/c3_w1_bl u_t006_008/c3_w1_br u_t006_008/c3_r0_rbl u_t006_008/c3_r1_rbl
+ u_t006_008/r0_w0_wl u_t006_008/r0_w1_wl u_t006_008/r0_r0_rwl u_t006_008/r0_r1_rwl
+ u_t006_008/r1_w0_wl u_t006_008/r1_w1_wl u_t006_008/r1_r0_rwl u_t006_008/r1_r1_rwl
+ u_t006_008/r2_w0_wl u_t006_008/r2_w1_wl u_t006_008/r2_r0_rwl u_t006_008/r2_r1_rwl
+ u_t006_008/r3_w0_wl u_t006_008/r3_w1_wl u_t006_008/r3_r0_rwl u_t006_008/r3_r1_rwl
+ VSS u_t006_009/VSS VSUBS detronyx_12t_2w2r_rc4_4x4_routed_5layer_direct
Xu_t011_000 u_t011_000/c0_w0_bl u_t011_000/c0_w0_br u_t011_000/c0_w1_bl u_t011_000/c0_w1_br
+ u_t011_000/c0_r0_rbl u_t011_000/c0_r1_rbl u_t011_000/c1_w0_bl u_t011_000/c1_w0_br
+ u_t011_000/c1_w1_bl u_t011_000/c1_w1_br u_t011_000/c1_r0_rbl u_t011_000/c1_r1_rbl
+ u_t011_000/c2_w0_bl u_t011_000/c2_w0_br u_t011_000/c2_w1_bl u_t011_000/c2_w1_br
+ u_t011_000/c2_r0_rbl u_t011_000/c2_r1_rbl u_t011_000/c3_w0_bl u_t011_000/c3_w0_br
+ u_t011_000/c3_w1_bl u_t011_000/c3_w1_br u_t011_000/c3_r0_rbl u_t011_000/c3_r1_rbl
+ u_t011_000/r0_w0_wl u_t011_000/r0_w1_wl u_t011_000/r0_r0_rwl u_t011_000/r0_r1_rwl
+ u_t011_000/r1_w0_wl u_t011_000/r1_w1_wl u_t011_000/r1_r0_rwl u_t011_000/r1_r1_rwl
+ u_t011_000/r2_w0_wl u_t011_000/r2_w1_wl u_t011_000/r2_r0_rwl u_t011_000/r2_r1_rwl
+ u_t011_000/r3_w0_wl u_t011_000/r3_w1_wl u_t011_000/r3_r0_rwl u_t011_000/r3_r1_rwl
+ VSS u_t011_002/VSS VSUBS detronyx_12t_2w2r_rc4_4x4_routed_5layer_direct
Xu_t011_011 u_t011_011/c0_w0_bl u_t011_011/c0_w0_br u_t011_011/c0_w1_bl u_t011_011/c0_w1_br
+ u_t011_011/c0_r0_rbl u_t011_011/c0_r1_rbl u_t011_011/c1_w0_bl u_t011_011/c1_w0_br
+ u_t011_011/c1_w1_bl u_t011_011/c1_w1_br u_t011_011/c1_r0_rbl u_t011_011/c1_r1_rbl
+ u_t011_011/c2_w0_bl u_t011_011/c2_w0_br u_t011_011/c2_w1_bl u_t011_011/c2_w1_br
+ u_t011_011/c2_r0_rbl u_t011_011/c2_r1_rbl u_t011_011/c3_w0_bl u_t011_011/c3_w0_br
+ u_t011_011/c3_w1_bl u_t011_011/c3_w1_br u_t011_011/c3_r0_rbl u_t011_011/c3_r1_rbl
+ u_t011_011/r0_w0_wl u_t011_011/r0_w1_wl u_t011_011/r0_r0_rwl u_t011_011/r0_r1_rwl
+ u_t011_011/r1_w0_wl u_t011_011/r1_w1_wl u_t011_011/r1_r0_rwl u_t011_011/r1_r1_rwl
+ u_t011_011/r2_w0_wl u_t011_011/r2_w1_wl u_t011_011/r2_r0_rwl u_t011_011/r2_r1_rwl
+ u_t011_011/r3_w0_wl u_t011_011/r3_w1_wl u_t011_011/r3_r0_rwl u_t011_011/r3_r1_rwl
+ u_t011_011/VDD u_t011_011/VSS VSUBS detronyx_12t_2w2r_rc4_4x4_routed_5layer_direct
Xgf180mcu_as_sc_mcu7t3v3__nand4_2_209 gf180mcu_as_sc_mcu7t3v3__inv_2_785/VDD gf180mcu_as_sc_mcu7t3v3__inv_2_788/VDD
+ VSS VSS VSS VSS VSS gf180mcu_as_sc_mcu7t3v3__inv_2_785/VNW VSUBS gf180mcu_as_sc_mcu7t3v3__nand4_2
Xu_t002_000 u_t002_000/c0_w0_bl u_t002_000/c0_w0_br u_t002_000/c0_w1_bl u_t002_000/c0_w1_br
+ u_t002_000/c0_r0_rbl u_t002_000/c0_r1_rbl u_t002_000/c1_w0_bl u_t002_000/c1_w0_br
+ u_t002_000/c1_w1_bl u_t002_000/c1_w1_br u_t002_000/c1_r0_rbl u_t002_000/c1_r1_rbl
+ u_t002_000/c2_w0_bl u_t002_000/c2_w0_br u_t002_000/c2_w1_bl u_t002_000/c2_w1_br
+ u_t002_000/c2_r0_rbl u_t002_000/c2_r1_rbl u_t002_000/c3_w0_bl u_t002_000/c3_w0_br
+ u_t002_000/c3_w1_bl u_t002_000/c3_w1_br u_t002_000/c3_r0_rbl u_t002_000/c3_r1_rbl
+ u_t002_000/r0_w0_wl u_t002_000/r0_w1_wl u_t002_000/r0_r0_rwl u_t002_000/r0_r1_rwl
+ u_t002_000/r1_w0_wl u_t002_000/r1_w1_wl u_t002_000/r1_r0_rwl u_t002_000/r1_r1_rwl
+ u_t002_000/r2_w0_wl u_t002_000/r2_w1_wl u_t002_000/r2_r0_rwl u_t002_000/r2_r1_rwl
+ u_t002_000/r3_w0_wl u_t002_000/r3_w1_wl u_t002_000/r3_r0_rwl u_t002_000/r3_r1_rwl
+ VSS u_t002_002/VSS VSUBS detronyx_12t_2w2r_rc4_4x4_routed_5layer_direct
Xu_t002_011 u_t002_011/c0_w0_bl u_t002_011/c0_w0_br u_t002_011/c0_w1_bl u_t002_011/c0_w1_br
+ u_t002_011/c0_r0_rbl u_t002_011/c0_r1_rbl u_t002_011/c1_w0_bl u_t002_011/c1_w0_br
+ u_t002_011/c1_w1_bl u_t002_011/c1_w1_br u_t002_011/c1_r0_rbl u_t002_011/c1_r1_rbl
+ u_t002_011/c2_w0_bl u_t002_011/c2_w0_br u_t002_011/c2_w1_bl u_t002_011/c2_w1_br
+ u_t002_011/c2_r0_rbl u_t002_011/c2_r1_rbl u_t002_011/c3_w0_bl u_t002_011/c3_w0_br
+ u_t002_011/c3_w1_bl u_t002_011/c3_w1_br u_t002_011/c3_r0_rbl u_t002_011/c3_r1_rbl
+ u_t002_011/r0_w0_wl u_t002_011/r0_w1_wl u_t002_011/r0_r0_rwl u_t002_011/r0_r1_rwl
+ u_t002_011/r1_w0_wl u_t002_011/r1_w1_wl u_t002_011/r1_r0_rwl u_t002_011/r1_r1_rwl
+ u_t002_011/r2_w0_wl u_t002_011/r2_w1_wl u_t002_011/r2_r0_rwl u_t002_011/r2_r1_rwl
+ u_t002_011/r3_w0_wl u_t002_011/r3_w1_wl u_t002_011/r3_r0_rwl u_t002_011/r3_r1_rwl
+ u_t002_011/VDD u_t002_011/VSS VSUBS detronyx_12t_2w2r_rc4_4x4_routed_5layer_direct
Xgf180mcu_as_sc_mcu7t3v3__inv_2_729 gf180mcu_as_sc_mcu7t3v3__inv_2_731/VDD gf180mcu_as_sc_mcu7t3v3__inv_2_734/VDD
+ VSS gf180mcu_as_sc_mcu7t3v3__inv_2_743/Y gf180mcu_as_sc_mcu7t3v3__inv_2_731/VNW
+ VSUBS gf180mcu_as_sc_mcu7t3v3__inv_2
Xgf180mcu_as_sc_mcu7t3v3__inv_2_718 gf180mcu_as_sc_mcu7t3v3__inv_2_719/VDD VSS gf180mcu_as_sc_mcu7t3v3__inv_2_718/Y
+ gf180mcu_as_sc_mcu7t3v3__inv_2_719/Y gf180mcu_as_sc_mcu7t3v3__inv_2_719/VNW VSUBS
+ gf180mcu_as_sc_mcu7t3v3__inv_2
Xgf180mcu_as_sc_mcu7t3v3__inv_2_707 VSS VSS VSS VSS gf180mcu_as_sc_mcu7t3v3__inv_2_707/VNW
+ VSUBS gf180mcu_as_sc_mcu7t3v3__inv_2
Xgf180mcu_as_sc_mcu7t3v3__inv_2_61 gf180mcu_as_sc_mcu7t3v3__inv_2_63/VDD gf180mcu_as_sc_mcu7t3v3__inv_2_63/VSS
+ gf180mcu_as_sc_mcu7t3v3__inv_2_61/Y VSS gf180mcu_as_sc_mcu7t3v3__inv_2_63/VNW VSUBS
+ gf180mcu_as_sc_mcu7t3v3__inv_2
Xgf180mcu_as_sc_mcu7t3v3__inv_2_50 VSS VSS VSS VSS gf180mcu_as_sc_mcu7t3v3__inv_2_50/VNW
+ VSUBS gf180mcu_as_sc_mcu7t3v3__inv_2
Xgf180mcu_as_sc_mcu7t3v3__inv_2_94 VSS VSS VSS VSS gf180mcu_as_sc_mcu7t3v3__inv_2_96/VNW
+ VSUBS gf180mcu_as_sc_mcu7t3v3__inv_2
Xgf180mcu_as_sc_mcu7t3v3__inv_2_83 gf180mcu_as_sc_mcu7t3v3__inv_2_84/VDD VSS gf180mcu_as_sc_mcu7t3v3__inv_2_83/Y
+ VSS gf180mcu_as_sc_mcu7t3v3__inv_2_84/VNW VSUBS gf180mcu_as_sc_mcu7t3v3__inv_2
Xgf180mcu_as_sc_mcu7t3v3__inv_2_72 gf180mcu_as_sc_mcu7t3v3__inv_2_72/VDD gf180mcu_as_sc_mcu7t3v3__inv_2_75/VDD
+ gf180mcu_as_sc_mcu7t3v3__inv_2_72/Y VSS gf180mcu_as_sc_mcu7t3v3__inv_2_72/VNW VSUBS
+ gf180mcu_as_sc_mcu7t3v3__inv_2
Xgf180mcu_as_sc_mcu7t3v3__nand4_2_9 gf180mcu_as_sc_mcu7t3v3__inv_2_27/VDD gf180mcu_as_sc_mcu7t3v3__inv_2_9/VDD
+ VSS VSS VSS VSS VSS gf180mcu_as_sc_mcu7t3v3__inv_2_27/VNW VSUBS gf180mcu_as_sc_mcu7t3v3__nand4_2
Xgf180mcu_as_sc_mcu7t3v3__inv_2_504 VSS VSS VSS VSS gf180mcu_as_sc_mcu7t3v3__inv_2_504/VNW
+ VSUBS gf180mcu_as_sc_mcu7t3v3__inv_2
Xgf180mcu_as_sc_mcu7t3v3__inv_2_559 VSS gf180mcu_as_sc_mcu7t3v3__inv_2_564/VDD gf180mcu_as_sc_mcu7t3v3__inv_2_559/Y
+ gf180mcu_as_sc_mcu7t3v3__inv_2_562/A gf180mcu_as_sc_mcu7t3v3__inv_2_561/VNW VSUBS
+ gf180mcu_as_sc_mcu7t3v3__inv_2
Xgf180mcu_as_sc_mcu7t3v3__inv_2_548 VSS gf180mcu_as_sc_mcu7t3v3__inv_2_552/VDD gf180mcu_as_sc_mcu7t3v3__inv_2_553/A
+ gf180mcu_as_sc_mcu7t3v3__inv_2_549/Y gf180mcu_as_sc_mcu7t3v3__inv_2_549/VNW VSUBS
+ gf180mcu_as_sc_mcu7t3v3__inv_2
Xgf180mcu_as_sc_mcu7t3v3__inv_2_537 gf180mcu_as_sc_mcu7t3v3__inv_2_537/VDD gf180mcu_as_sc_mcu7t3v3__inv_2_540/VDD
+ gf180mcu_as_sc_mcu7t3v3__inv_2_537/Y VSS gf180mcu_as_sc_mcu7t3v3__inv_2_537/VNW
+ VSUBS gf180mcu_as_sc_mcu7t3v3__inv_2
Xgf180mcu_as_sc_mcu7t3v3__inv_2_526 VSS VSS gf180mcu_as_sc_mcu7t3v3__inv_2_526/Y gf180mcu_as_sc_mcu7t3v3__inv_2_545/Y
+ gf180mcu_as_sc_mcu7t3v3__inv_2_528/VNW VSUBS gf180mcu_as_sc_mcu7t3v3__inv_2
Xgf180mcu_as_sc_mcu7t3v3__inv_2_515 VSS VSS VSS VSS gf180mcu_as_sc_mcu7t3v3__inv_2_516/VNW
+ VSUBS gf180mcu_as_sc_mcu7t3v3__inv_2
Xgf180mcu_as_sc_mcu7t3v3__inv_2_301 VSS VSS VSS VSS gf180mcu_as_sc_mcu7t3v3__inv_2_302/VNW
+ VSUBS gf180mcu_as_sc_mcu7t3v3__inv_2
Xgf180mcu_as_sc_mcu7t3v3__inv_2_334 VSS gf180mcu_as_sc_mcu7t3v3__inv_2_338/VDD gf180mcu_as_sc_mcu7t3v3__inv_2_334/Y
+ VSS gf180mcu_as_sc_mcu7t3v3__inv_2_334/VNW VSUBS gf180mcu_as_sc_mcu7t3v3__inv_2
Xgf180mcu_as_sc_mcu7t3v3__inv_2_323 VSS gf180mcu_as_sc_mcu7t3v3__inv_2_348/VDD gf180mcu_as_sc_mcu7t3v3__inv_2_323/Y
+ VSS gf180mcu_as_sc_mcu7t3v3__inv_2_343/VNW VSUBS gf180mcu_as_sc_mcu7t3v3__inv_2
Xgf180mcu_as_sc_mcu7t3v3__inv_2_312 gf180mcu_as_sc_mcu7t3v3__nor2_2_6/VDD gf180mcu_as_sc_mcu7t3v3__nand3_2_1/VSS
+ VSS VSS gf180mcu_as_sc_mcu7t3v3__nor2_2_6/VNW VSUBS gf180mcu_as_sc_mcu7t3v3__inv_2
Xgf180mcu_as_sc_mcu7t3v3__inv_2_345 VSS gf180mcu_as_sc_mcu7t3v3__inv_2_345/VSS gf180mcu_as_sc_mcu7t3v3__inv_2_345/Y
+ gf180mcu_as_sc_mcu7t3v3__inv_2_345/A gf180mcu_as_sc_mcu7t3v3__inv_2_345/VNW VSUBS
+ gf180mcu_as_sc_mcu7t3v3__inv_2
Xgf180mcu_as_sc_mcu7t3v3__inv_2_389 VSS VSS gf180mcu_as_sc_mcu7t3v3__inv_2_389/Y gf180mcu_as_sc_mcu7t3v3__inv_2_390/Y
+ gf180mcu_as_sc_mcu7t3v3__inv_2_390/VNW VSUBS gf180mcu_as_sc_mcu7t3v3__inv_2
Xgf180mcu_as_sc_mcu7t3v3__inv_2_378 VSS VSS gf180mcu_as_sc_mcu7t3v3__inv_2_378/Y VSS
+ gf180mcu_as_sc_mcu7t3v3__inv_2_378/VNW VSUBS gf180mcu_as_sc_mcu7t3v3__inv_2
Xgf180mcu_as_sc_mcu7t3v3__inv_2_367 VSS gf180mcu_as_sc_mcu7t3v3__inv_2_372/VDD gf180mcu_as_sc_mcu7t3v3__inv_2_367/Y
+ gf180mcu_as_sc_mcu7t3v3__inv_2_930/A gf180mcu_as_sc_mcu7t3v3__inv_2_369/VNW VSUBS
+ gf180mcu_as_sc_mcu7t3v3__inv_2
Xgf180mcu_as_sc_mcu7t3v3__inv_2_356 gf180mcu_as_sc_mcu7t3v3__inv_2_932/VSS VSS gf180mcu_as_sc_mcu7t3v3__inv_2_930/A
+ gf180mcu_as_sc_mcu7t3v3__inv_2_357/Y gf180mcu_as_sc_mcu7t3v3__inv_2_357/VNW VSUBS
+ gf180mcu_as_sc_mcu7t3v3__inv_2
Xgf180mcu_as_sc_mcu7t3v3__inv_2_890 gf180mcu_as_sc_mcu7t3v3__inv_2_893/VDD gf180mcu_as_sc_mcu7t3v3__inv_2_893/VDD
+ gf180mcu_as_sc_mcu7t3v3__inv_2_908/Y VSS gf180mcu_as_sc_mcu7t3v3__inv_2_890/VNW
+ VSUBS gf180mcu_as_sc_mcu7t3v3__inv_2
Xu_t009_006 u_t009_006/c0_w0_bl u_t009_006/c0_w0_br u_t009_006/c0_w1_bl u_t009_006/c0_w1_br
+ u_t009_006/c0_r0_rbl u_t009_006/c0_r1_rbl u_t009_006/c1_w0_bl u_t009_006/c1_w0_br
+ u_t009_006/c1_w1_bl u_t009_006/c1_w1_br u_t009_006/c1_r0_rbl u_t009_006/c1_r1_rbl
+ u_t009_006/c2_w0_bl u_t009_006/c2_w0_br u_t009_006/c2_w1_bl u_t009_006/c2_w1_br
+ u_t009_006/c2_r0_rbl u_t009_006/c2_r1_rbl u_t009_006/c3_w0_bl u_t009_006/c3_w0_br
+ u_t009_006/c3_w1_bl u_t009_006/c3_w1_br u_t009_006/c3_r0_rbl u_t009_006/c3_r1_rbl
+ u_t009_006/r0_w0_wl u_t009_006/r0_w1_wl u_t009_006/r0_r0_rwl u_t009_006/r0_r1_rwl
+ u_t009_006/r1_w0_wl u_t009_006/r1_w1_wl u_t009_006/r1_r0_rwl u_t009_006/r1_r1_rwl
+ u_t009_006/r2_w0_wl u_t009_006/r2_w1_wl u_t009_006/r2_r0_rwl u_t009_006/r2_r1_rwl
+ u_t009_006/r3_w0_wl u_t009_006/r3_w1_wl u_t009_006/r3_r0_rwl u_t009_006/r3_r1_rwl
+ u_t009_006/VDD u_t009_015/VSS VSUBS detronyx_12t_2w2r_rc4_4x4_routed_5layer_direct
Xgf180mcu_as_sc_mcu7t3v3__inv_2_175 gf180mcu_as_sc_mcu7t3v3__inv_2_177/VDD gf180mcu_as_sc_mcu7t3v3__inv_2_15/VDD
+ VSS gf180mcu_as_sc_mcu7t3v3__inv_2_177/Y gf180mcu_as_sc_mcu7t3v3__inv_2_177/VNW
+ VSUBS gf180mcu_as_sc_mcu7t3v3__inv_2
Xgf180mcu_as_sc_mcu7t3v3__inv_2_186 gf180mcu_as_sc_mcu7t3v3__nor2_2_6/VDD gf180mcu_as_sc_mcu7t3v3__nor2_2_6/VSS
+ VSS VSS gf180mcu_as_sc_mcu7t3v3__nor2_2_6/VNW VSUBS gf180mcu_as_sc_mcu7t3v3__inv_2
Xgf180mcu_as_sc_mcu7t3v3__inv_2_120 VSS gf180mcu_as_sc_mcu7t3v3__inv_2_123/VDD gf180mcu_as_sc_mcu7t3v3__inv_2_177/Y
+ VSS gf180mcu_as_sc_mcu7t3v3__inv_2_120/VNW VSUBS gf180mcu_as_sc_mcu7t3v3__inv_2
Xgf180mcu_as_sc_mcu7t3v3__inv_2_164 gf180mcu_as_sc_mcu7t3v3__inv_2_165/VDD VSS gf180mcu_as_sc_mcu7t3v3__inv_2_177/Y
+ gf180mcu_as_sc_mcu7t3v3__inv_2_177/Y gf180mcu_as_sc_mcu7t3v3__inv_2_165/VNW VSUBS
+ gf180mcu_as_sc_mcu7t3v3__inv_2
Xgf180mcu_as_sc_mcu7t3v3__inv_2_153 gf180mcu_as_sc_mcu7t3v3__inv_2_153/VDD gf180mcu_as_sc_mcu7t3v3__inv_2_159/VDD
+ gf180mcu_as_sc_mcu7t3v3__inv_2_153/Y VSS gf180mcu_as_sc_mcu7t3v3__inv_2_153/VNW
+ VSUBS gf180mcu_as_sc_mcu7t3v3__inv_2
Xgf180mcu_as_sc_mcu7t3v3__inv_2_142 gf180mcu_as_sc_mcu7t3v3__inv_2_144/VDD VSS VSS
+ gf180mcu_as_sc_mcu7t3v3__inv_2_923/Y gf180mcu_as_sc_mcu7t3v3__inv_2_144/VNW VSUBS
+ gf180mcu_as_sc_mcu7t3v3__inv_2
Xgf180mcu_as_sc_mcu7t3v3__inv_2_131 gf180mcu_as_sc_mcu7t3v3__inv_2_132/VDD gf180mcu_as_sc_mcu7t3v3__inv_2_135/VDD
+ gf180mcu_as_sc_mcu7t3v3__inv_2_131/Y gf180mcu_as_sc_mcu7t3v3__inv_2_923/Y gf180mcu_as_sc_mcu7t3v3__inv_2_132/VNW
+ VSUBS gf180mcu_as_sc_mcu7t3v3__inv_2
Xgf180mcu_as_sc_mcu7t3v3__inv_2_197 gf180mcu_as_sc_mcu7t3v3__nor2_2_5/VDD gf180mcu_as_sc_mcu7t3v3__nand3_2_8/VSS
+ VSS VSS gf180mcu_as_sc_mcu7t3v3__nor2_2_5/VNW VSUBS gf180mcu_as_sc_mcu7t3v3__inv_2
Xu_t015_009 u_t015_009/c0_w0_bl u_t015_009/c0_w0_br u_t015_009/c0_w1_bl u_t015_009/c0_w1_br
+ u_t015_009/c0_r0_rbl u_t015_009/c0_r1_rbl u_t015_009/c1_w0_bl u_t015_009/c1_w0_br
+ u_t015_009/c1_w1_bl u_t015_009/c1_w1_br u_t015_009/c1_r0_rbl u_t015_009/c1_r1_rbl
+ u_t015_009/c2_w0_bl u_t015_009/c2_w0_br u_t015_009/c2_w1_bl u_t015_009/c2_w1_br
+ u_t015_009/c2_r0_rbl u_t015_009/c2_r1_rbl u_t015_009/c3_w0_bl u_t015_009/c3_w0_br
+ u_t015_009/c3_w1_bl u_t015_009/c3_w1_br u_t015_009/c3_r0_rbl u_t015_009/c3_r1_rbl
+ u_t015_009/r0_w0_wl u_t015_009/r0_w1_wl u_t015_009/r0_r0_rwl u_t015_009/r0_r1_rwl
+ u_t015_009/r1_w0_wl u_t015_009/r1_w1_wl u_t015_009/r1_r0_rwl u_t015_009/r1_r1_rwl
+ u_t015_009/r2_w0_wl u_t015_009/r2_w1_wl u_t015_009/r2_r0_rwl u_t015_009/r2_r1_rwl
+ u_t015_009/r3_w0_wl u_t015_009/r3_w1_wl u_t015_009/r3_r0_rwl u_t015_009/r3_r1_rwl
+ VSS u_t015_009/VSS VSUBS detronyx_12t_2w2r_rc4_4x4_routed_5layer_direct
Xgf180mcu_as_sc_mcu7t3v3__nand2_2_32 gf180mcu_as_sc_mcu7t3v3__nor2_2_6/VDD gf180mcu_as_sc_mcu7t3v3__nand3_2_1/VSS
+ VSS VSS VSS gf180mcu_as_sc_mcu7t3v3__nor2_2_6/VNW VSUBS gf180mcu_as_sc_mcu7t3v3__nand2_2
Xgf180mcu_as_sc_mcu7t3v3__nand2_2_21 gf180mcu_as_sc_mcu7t3v3__nor2_2_6/VDD gf180mcu_as_sc_mcu7t3v3__nor2_2_6/VSS
+ VSS VSS VSS gf180mcu_as_sc_mcu7t3v3__nor2_2_6/VNW VSUBS gf180mcu_as_sc_mcu7t3v3__nand2_2
Xgf180mcu_as_sc_mcu7t3v3__nand2_2_10 gf180mcu_as_sc_mcu7t3v3__nor2_2_6/VDD gf180mcu_as_sc_mcu7t3v3__nor2_2_6/VSS
+ VSS VSS VSS gf180mcu_as_sc_mcu7t3v3__nor2_2_6/VNW VSUBS gf180mcu_as_sc_mcu7t3v3__nand2_2
Xgf180mcu_as_sc_mcu7t3v3__nand2_2_43 gf180mcu_as_sc_mcu7t3v3__nor2_2_6/VDD gf180mcu_as_sc_mcu7t3v3__nand3_2_1/VSS
+ VSS VSS VSS gf180mcu_as_sc_mcu7t3v3__nor2_2_6/VNW VSUBS gf180mcu_as_sc_mcu7t3v3__nand2_2
Xgf180mcu_as_sc_mcu7t3v3__nand2_2_65 gf180mcu_as_sc_mcu7t3v3__inv_2_713/VDD gf180mcu_as_sc_mcu7t3v3__inv_2_713/VSS
+ VSS VSS VSS gf180mcu_as_sc_mcu7t3v3__inv_2_713/VNW VSUBS gf180mcu_as_sc_mcu7t3v3__nand2_2
Xgf180mcu_as_sc_mcu7t3v3__nand2_2_54 gf180mcu_as_sc_mcu7t3v3__nor2_2_8/VDD gf180mcu_as_sc_mcu7t3v3__nor2_2_8/VSS
+ VSS VSS VSS gf180mcu_as_sc_mcu7t3v3__nor2_2_8/VNW VSUBS gf180mcu_as_sc_mcu7t3v3__nand2_2
Xu_t006_009 u_t006_009/c0_w0_bl u_t006_009/c0_w0_br u_t006_009/c0_w1_bl u_t006_009/c0_w1_br
+ u_t006_009/c0_r0_rbl u_t006_009/c0_r1_rbl u_t006_009/c1_w0_bl u_t006_009/c1_w0_br
+ u_t006_009/c1_w1_bl u_t006_009/c1_w1_br u_t006_009/c1_r0_rbl u_t006_009/c1_r1_rbl
+ u_t006_009/c2_w0_bl u_t006_009/c2_w0_br u_t006_009/c2_w1_bl u_t006_009/c2_w1_br
+ u_t006_009/c2_r0_rbl u_t006_009/c2_r1_rbl u_t006_009/c3_w0_bl u_t006_009/c3_w0_br
+ u_t006_009/c3_w1_bl u_t006_009/c3_w1_br u_t006_009/c3_r0_rbl u_t006_009/c3_r1_rbl
+ u_t006_009/r0_w0_wl u_t006_009/r0_w1_wl u_t006_009/r0_r0_rwl u_t006_009/r0_r1_rwl
+ u_t006_009/r1_w0_wl u_t006_009/r1_w1_wl u_t006_009/r1_r0_rwl u_t006_009/r1_r1_rwl
+ u_t006_009/r2_w0_wl u_t006_009/r2_w1_wl u_t006_009/r2_r0_rwl u_t006_009/r2_r1_rwl
+ u_t006_009/r3_w0_wl u_t006_009/r3_w1_wl u_t006_009/r3_r0_rwl u_t006_009/r3_r1_rwl
+ VSS u_t006_009/VSS VSUBS detronyx_12t_2w2r_rc4_4x4_routed_5layer_direct
Xu_t011_001 u_t011_001/c0_w0_bl u_t011_001/c0_w0_br u_t011_001/c0_w1_bl u_t011_001/c0_w1_br
+ u_t011_001/c0_r0_rbl u_t011_001/c0_r1_rbl u_t011_001/c1_w0_bl u_t011_001/c1_w0_br
+ u_t011_001/c1_w1_bl u_t011_001/c1_w1_br u_t011_001/c1_r0_rbl u_t011_001/c1_r1_rbl
+ u_t011_001/c2_w0_bl u_t011_001/c2_w0_br u_t011_001/c2_w1_bl u_t011_001/c2_w1_br
+ u_t011_001/c2_r0_rbl u_t011_001/c2_r1_rbl u_t011_001/c3_w0_bl u_t011_001/c3_w0_br
+ u_t011_001/c3_w1_bl u_t011_001/c3_w1_br u_t011_001/c3_r0_rbl u_t011_001/c3_r1_rbl
+ u_t011_001/r0_w0_wl u_t011_001/r0_w1_wl u_t011_001/r0_r0_rwl u_t011_001/r0_r1_rwl
+ u_t011_001/r1_w0_wl u_t011_001/r1_w1_wl u_t011_001/r1_r0_rwl u_t011_001/r1_r1_rwl
+ u_t011_001/r2_w0_wl u_t011_001/r2_w1_wl u_t011_001/r2_r0_rwl u_t011_001/r2_r1_rwl
+ u_t011_001/r3_w0_wl u_t011_001/r3_w1_wl u_t011_001/r3_r0_rwl u_t011_001/r3_r1_rwl
+ VSS u_t011_002/VSS VSUBS detronyx_12t_2w2r_rc4_4x4_routed_5layer_direct
Xu_t011_012 u_t011_012/c0_w0_bl u_t011_012/c0_w0_br u_t011_012/c0_w1_bl u_t011_012/c0_w1_br
+ u_t011_012/c0_r0_rbl u_t011_012/c0_r1_rbl u_t011_012/c1_w0_bl u_t011_012/c1_w0_br
+ u_t011_012/c1_w1_bl u_t011_012/c1_w1_br u_t011_012/c1_r0_rbl u_t011_012/c1_r1_rbl
+ u_t011_012/c2_w0_bl u_t011_012/c2_w0_br u_t011_012/c2_w1_bl u_t011_012/c2_w1_br
+ u_t011_012/c2_r0_rbl u_t011_012/c2_r1_rbl u_t011_012/c3_w0_bl u_t011_012/c3_w0_br
+ u_t011_012/c3_w1_bl u_t011_012/c3_w1_br u_t011_012/c3_r0_rbl u_t011_012/c3_r1_rbl
+ u_t011_012/r0_w0_wl u_t011_012/r0_w1_wl u_t011_012/r0_r0_rwl u_t011_012/r0_r1_rwl
+ u_t011_012/r1_w0_wl u_t011_012/r1_w1_wl u_t011_012/r1_r0_rwl u_t011_012/r1_r1_rwl
+ u_t011_012/r2_w0_wl u_t011_012/r2_w1_wl u_t011_012/r2_r0_rwl u_t011_012/r2_r1_rwl
+ u_t011_012/r3_w0_wl u_t011_012/r3_w1_wl u_t011_012/r3_r0_rwl u_t011_012/r3_r1_rwl
+ u_t011_012/VDD u_t011_012/VSS VSUBS detronyx_12t_2w2r_rc4_4x4_routed_5layer_direct
Xu_t002_001 u_t002_001/c0_w0_bl u_t002_001/c0_w0_br u_t002_001/c0_w1_bl u_t002_001/c0_w1_br
+ u_t002_001/c0_r0_rbl u_t002_001/c0_r1_rbl u_t002_001/c1_w0_bl u_t002_001/c1_w0_br
+ u_t002_001/c1_w1_bl u_t002_001/c1_w1_br u_t002_001/c1_r0_rbl u_t002_001/c1_r1_rbl
+ u_t002_001/c2_w0_bl u_t002_001/c2_w0_br u_t002_001/c2_w1_bl u_t002_001/c2_w1_br
+ u_t002_001/c2_r0_rbl u_t002_001/c2_r1_rbl u_t002_001/c3_w0_bl u_t002_001/c3_w0_br
+ u_t002_001/c3_w1_bl u_t002_001/c3_w1_br u_t002_001/c3_r0_rbl u_t002_001/c3_r1_rbl
+ u_t002_001/r0_w0_wl u_t002_001/r0_w1_wl u_t002_001/r0_r0_rwl u_t002_001/r0_r1_rwl
+ u_t002_001/r1_w0_wl u_t002_001/r1_w1_wl u_t002_001/r1_r0_rwl u_t002_001/r1_r1_rwl
+ u_t002_001/r2_w0_wl u_t002_001/r2_w1_wl u_t002_001/r2_r0_rwl u_t002_001/r2_r1_rwl
+ u_t002_001/r3_w0_wl u_t002_001/r3_w1_wl u_t002_001/r3_r0_rwl u_t002_001/r3_r1_rwl
+ VSS u_t002_002/VSS VSUBS detronyx_12t_2w2r_rc4_4x4_routed_5layer_direct
Xu_t002_012 u_t002_012/c0_w0_bl u_t002_012/c0_w0_br u_t002_012/c0_w1_bl u_t002_012/c0_w1_br
+ u_t002_012/c0_r0_rbl u_t002_012/c0_r1_rbl u_t002_012/c1_w0_bl u_t002_012/c1_w0_br
+ u_t002_012/c1_w1_bl u_t002_012/c1_w1_br u_t002_012/c1_r0_rbl u_t002_012/c1_r1_rbl
+ u_t002_012/c2_w0_bl u_t002_012/c2_w0_br u_t002_012/c2_w1_bl u_t002_012/c2_w1_br
+ u_t002_012/c2_r0_rbl u_t002_012/c2_r1_rbl u_t002_012/c3_w0_bl u_t002_012/c3_w0_br
+ u_t002_012/c3_w1_bl u_t002_012/c3_w1_br u_t002_012/c3_r0_rbl u_t002_012/c3_r1_rbl
+ u_t002_012/r0_w0_wl u_t002_012/r0_w1_wl u_t002_012/r0_r0_rwl u_t002_012/r0_r1_rwl
+ u_t002_012/r1_w0_wl u_t002_012/r1_w1_wl u_t002_012/r1_r0_rwl u_t002_012/r1_r1_rwl
+ u_t002_012/r2_w0_wl u_t002_012/r2_w1_wl u_t002_012/r2_r0_rwl u_t002_012/r2_r1_rwl
+ u_t002_012/r3_w0_wl u_t002_012/r3_w1_wl u_t002_012/r3_r0_rwl u_t002_012/r3_r1_rwl
+ u_t002_012/VDD u_t002_012/VSS VSUBS detronyx_12t_2w2r_rc4_4x4_routed_5layer_direct
Xgf180mcu_as_sc_mcu7t3v3__inv_2_719 gf180mcu_as_sc_mcu7t3v3__inv_2_719/VDD VSS gf180mcu_as_sc_mcu7t3v3__inv_2_719/Y
+ VSS gf180mcu_as_sc_mcu7t3v3__inv_2_719/VNW VSUBS gf180mcu_as_sc_mcu7t3v3__inv_2
Xgf180mcu_as_sc_mcu7t3v3__inv_2_708 VSS VSS gf180mcu_as_sc_mcu7t3v3__inv_2_708/Y VSS
+ gf180mcu_as_sc_mcu7t3v3__inv_2_708/VNW VSUBS gf180mcu_as_sc_mcu7t3v3__inv_2
Xgf180mcu_as_sc_mcu7t3v3__inv_2_62 gf180mcu_as_sc_mcu7t3v3__inv_2_63/VDD gf180mcu_as_sc_mcu7t3v3__inv_2_63/VSS
+ gf180mcu_as_sc_mcu7t3v3__inv_2_62/Y VSS gf180mcu_as_sc_mcu7t3v3__inv_2_63/VNW VSUBS
+ gf180mcu_as_sc_mcu7t3v3__inv_2
Xgf180mcu_as_sc_mcu7t3v3__inv_2_51 VSS gf180mcu_as_sc_mcu7t3v3__inv_2_56/VDD gf180mcu_as_sc_mcu7t3v3__inv_2_51/Y
+ VSS gf180mcu_as_sc_mcu7t3v3__inv_2_53/VNW VSUBS gf180mcu_as_sc_mcu7t3v3__inv_2
Xgf180mcu_as_sc_mcu7t3v3__inv_2_40 gf180mcu_as_sc_mcu7t3v3__inv_2_45/VDD gf180mcu_as_sc_mcu7t3v3__inv_2_45/VDD
+ gf180mcu_as_sc_mcu7t3v3__inv_2_40/Y VSS gf180mcu_as_sc_mcu7t3v3__inv_2_42/VNW VSUBS
+ gf180mcu_as_sc_mcu7t3v3__inv_2
Xgf180mcu_as_sc_mcu7t3v3__inv_2_95 VSS VSS VSS VSS gf180mcu_as_sc_mcu7t3v3__inv_2_96/VNW
+ VSUBS gf180mcu_as_sc_mcu7t3v3__inv_2
Xgf180mcu_as_sc_mcu7t3v3__inv_2_84 gf180mcu_as_sc_mcu7t3v3__inv_2_84/VDD VSS gf180mcu_as_sc_mcu7t3v3__inv_2_84/Y
+ VSS gf180mcu_as_sc_mcu7t3v3__inv_2_84/VNW VSUBS gf180mcu_as_sc_mcu7t3v3__inv_2
Xgf180mcu_as_sc_mcu7t3v3__inv_2_73 gf180mcu_as_sc_mcu7t3v3__inv_2_75/VDD VSS gf180mcu_as_sc_mcu7t3v3__inv_2_73/Y
+ VSS gf180mcu_as_sc_mcu7t3v3__inv_2_75/VNW VSUBS gf180mcu_as_sc_mcu7t3v3__inv_2
Xgf180mcu_as_sc_mcu7t3v3__inv_2_505 VSS VSS VSS VSS gf180mcu_as_sc_mcu7t3v3__inv_2_507/VNW
+ VSUBS gf180mcu_as_sc_mcu7t3v3__inv_2
Xgf180mcu_as_sc_mcu7t3v3__inv_2_527 VSS VSS gf180mcu_as_sc_mcu7t3v3__inv_2_545/Y gf180mcu_as_sc_mcu7t3v3__inv_2_528/Y
+ gf180mcu_as_sc_mcu7t3v3__inv_2_528/VNW VSUBS gf180mcu_as_sc_mcu7t3v3__inv_2
Xgf180mcu_as_sc_mcu7t3v3__inv_2_516 VSS VSS gf180mcu_as_sc_mcu7t3v3__inv_2_516/Y VSS
+ gf180mcu_as_sc_mcu7t3v3__inv_2_516/VNW VSUBS gf180mcu_as_sc_mcu7t3v3__inv_2
Xgf180mcu_as_sc_mcu7t3v3__inv_2_549 VSS gf180mcu_as_sc_mcu7t3v3__inv_2_552/VDD gf180mcu_as_sc_mcu7t3v3__inv_2_549/Y
+ VSS gf180mcu_as_sc_mcu7t3v3__inv_2_549/VNW VSUBS gf180mcu_as_sc_mcu7t3v3__inv_2
Xgf180mcu_as_sc_mcu7t3v3__inv_2_538 gf180mcu_as_sc_mcu7t3v3__inv_2_540/VDD gf180mcu_as_sc_mcu7t3v3__inv_2_543/VDD
+ gf180mcu_as_sc_mcu7t3v3__inv_2_538/Y gf180mcu_as_sc_mcu7t3v3__inv_2_545/Y gf180mcu_as_sc_mcu7t3v3__inv_2_540/VNW
+ VSUBS gf180mcu_as_sc_mcu7t3v3__inv_2
Xgf180mcu_as_sc_mcu7t3v3__inv_2_302 VSS VSS VSS VSS gf180mcu_as_sc_mcu7t3v3__inv_2_302/VNW
+ VSUBS gf180mcu_as_sc_mcu7t3v3__inv_2
Xgf180mcu_as_sc_mcu7t3v3__inv_2_324 gf180mcu_as_sc_mcu7t3v3__inv_2_345/VSS VSS gf180mcu_as_sc_mcu7t3v3__inv_2_324/Y
+ gf180mcu_as_sc_mcu7t3v3__inv_2_344/A gf180mcu_as_sc_mcu7t3v3__inv_2_326/VNW VSUBS
+ gf180mcu_as_sc_mcu7t3v3__inv_2
Xgf180mcu_as_sc_mcu7t3v3__inv_2_335 VSS VSS VSS gf180mcu_as_sc_mcu7t3v3__inv_2_339/Y
+ gf180mcu_as_sc_mcu7t3v3__inv_2_339/VNW VSUBS gf180mcu_as_sc_mcu7t3v3__inv_2
Xgf180mcu_as_sc_mcu7t3v3__inv_2_346 gf180mcu_as_sc_mcu7t3v3__inv_2_348/VDD gf180mcu_as_sc_mcu7t3v3__inv_2_348/VSS
+ gf180mcu_as_sc_mcu7t3v3__inv_2_346/Y VSS gf180mcu_as_sc_mcu7t3v3__inv_2_348/VNW
+ VSUBS gf180mcu_as_sc_mcu7t3v3__inv_2
Xgf180mcu_as_sc_mcu7t3v3__inv_2_313 gf180mcu_as_sc_mcu7t3v3__nor2_2_5/VDD gf180mcu_as_sc_mcu7t3v3__nand3_2_8/VSS
+ VSS VSS gf180mcu_as_sc_mcu7t3v3__nor2_2_5/VNW VSUBS gf180mcu_as_sc_mcu7t3v3__inv_2
Xgf180mcu_as_sc_mcu7t3v3__inv_2_368 VSS gf180mcu_as_sc_mcu7t3v3__inv_2_372/VDD gf180mcu_as_sc_mcu7t3v3__inv_2_930/A
+ gf180mcu_as_sc_mcu7t3v3__inv_2_369/Y gf180mcu_as_sc_mcu7t3v3__inv_2_369/VNW VSUBS
+ gf180mcu_as_sc_mcu7t3v3__inv_2
Xgf180mcu_as_sc_mcu7t3v3__inv_2_357 gf180mcu_as_sc_mcu7t3v3__inv_2_932/VSS VSS gf180mcu_as_sc_mcu7t3v3__inv_2_357/Y
+ VSS gf180mcu_as_sc_mcu7t3v3__inv_2_357/VNW VSUBS gf180mcu_as_sc_mcu7t3v3__inv_2
Xgf180mcu_as_sc_mcu7t3v3__inv_2_379 VSS gf180mcu_as_sc_mcu7t3v3__inv_2_384/VDD gf180mcu_as_sc_mcu7t3v3__inv_2_379/Y
+ gf180mcu_as_sc_mcu7t3v3__inv_2_382/A gf180mcu_as_sc_mcu7t3v3__inv_2_381/VNW VSUBS
+ gf180mcu_as_sc_mcu7t3v3__inv_2
Xgf180mcu_as_sc_mcu7t3v3__inv_2_891 gf180mcu_as_sc_mcu7t3v3__inv_2_893/VDD gf180mcu_as_sc_mcu7t3v3__inv_2_896/VDD
+ VSS gf180mcu_as_sc_mcu7t3v3__inv_2_908/Y gf180mcu_as_sc_mcu7t3v3__inv_2_893/VNW
+ VSUBS gf180mcu_as_sc_mcu7t3v3__inv_2
Xgf180mcu_as_sc_mcu7t3v3__inv_2_880 gf180mcu_as_sc_mcu7t3v3__inv_2_884/VDD gf180mcu_as_sc_mcu7t3v3__inv_2_884/VDD
+ gf180mcu_as_sc_mcu7t3v3__inv_2_887/Y gf180mcu_as_sc_mcu7t3v3__inv_2_887/Y gf180mcu_as_sc_mcu7t3v3__inv_2_881/VNW
+ VSUBS gf180mcu_as_sc_mcu7t3v3__inv_2
Xgf180mcu_as_sc_mcu7t3v3__nand4_2_190 gf180mcu_as_sc_mcu7t3v3__inv_2_776/VSS gf180mcu_as_sc_mcu7t3v3__inv_2_731/VDD
+ VSS VSS VSS VSS VSS gf180mcu_as_sc_mcu7t3v3__inv_2_728/VNW VSUBS gf180mcu_as_sc_mcu7t3v3__nand4_2
Xu_t009_007 u_t009_007/c0_w0_bl u_t009_007/c0_w0_br u_t009_007/c0_w1_bl u_t009_007/c0_w1_br
+ u_t009_007/c0_r0_rbl u_t009_007/c0_r1_rbl u_t009_007/c1_w0_bl u_t009_007/c1_w0_br
+ u_t009_007/c1_w1_bl u_t009_007/c1_w1_br u_t009_007/c1_r0_rbl u_t009_007/c1_r1_rbl
+ u_t009_007/c2_w0_bl u_t009_007/c2_w0_br u_t009_007/c2_w1_bl u_t009_007/c2_w1_br
+ u_t009_007/c2_r0_rbl u_t009_007/c2_r1_rbl u_t009_007/c3_w0_bl u_t009_007/c3_w0_br
+ u_t009_007/c3_w1_bl u_t009_007/c3_w1_br u_t009_007/c3_r0_rbl u_t009_007/c3_r1_rbl
+ u_t009_007/r0_w0_wl u_t009_007/r0_w1_wl u_t009_007/r0_r0_rwl u_t009_007/r0_r1_rwl
+ u_t009_007/r1_w0_wl u_t009_007/r1_w1_wl u_t009_007/r1_r0_rwl u_t009_007/r1_r1_rwl
+ u_t009_007/r2_w0_wl u_t009_007/r2_w1_wl u_t009_007/r2_r0_rwl u_t009_007/r2_r1_rwl
+ u_t009_007/r3_w0_wl u_t009_007/r3_w1_wl u_t009_007/r3_r0_rwl u_t009_007/r3_r1_rwl
+ VSS u_t009_015/VSS VSUBS detronyx_12t_2w2r_rc4_4x4_routed_5layer_direct
Xgf180mcu_as_sc_mcu7t3v3__inv_2_121 gf180mcu_as_sc_mcu7t3v3__inv_2_123/VDD gf180mcu_as_sc_mcu7t3v3__inv_2_177/VDD
+ VSS gf180mcu_as_sc_mcu7t3v3__inv_2_177/Y gf180mcu_as_sc_mcu7t3v3__inv_2_123/VNW
+ VSUBS gf180mcu_as_sc_mcu7t3v3__inv_2
Xgf180mcu_as_sc_mcu7t3v3__inv_2_176 gf180mcu_as_sc_mcu7t3v3__inv_2_177/VDD gf180mcu_as_sc_mcu7t3v3__inv_2_15/VDD
+ gf180mcu_as_sc_mcu7t3v3__inv_2_176/Y gf180mcu_as_sc_mcu7t3v3__inv_2_177/Y gf180mcu_as_sc_mcu7t3v3__inv_2_177/VNW
+ VSUBS gf180mcu_as_sc_mcu7t3v3__inv_2
Xgf180mcu_as_sc_mcu7t3v3__inv_2_198 gf180mcu_as_sc_mcu7t3v3__nor2_2_4/VDD gf180mcu_as_sc_mcu7t3v3__nand3_2_8/VSS
+ VSS VSS gf180mcu_as_sc_mcu7t3v3__nor2_2_4/VNW VSUBS gf180mcu_as_sc_mcu7t3v3__inv_2
Xgf180mcu_as_sc_mcu7t3v3__inv_2_187 gf180mcu_as_sc_mcu7t3v3__nor2_2_6/VDD gf180mcu_as_sc_mcu7t3v3__nand3_2_1/VSS
+ VSS VSS gf180mcu_as_sc_mcu7t3v3__nor2_2_6/VNW VSUBS gf180mcu_as_sc_mcu7t3v3__inv_2
Xgf180mcu_as_sc_mcu7t3v3__inv_2_110 VSS gf180mcu_as_sc_mcu7t3v3__inv_2_114/VDD gf180mcu_as_sc_mcu7t3v3__inv_2_110/Y
+ VSS gf180mcu_as_sc_mcu7t3v3__inv_2_111/VNW VSUBS gf180mcu_as_sc_mcu7t3v3__inv_2
Xgf180mcu_as_sc_mcu7t3v3__inv_2_165 gf180mcu_as_sc_mcu7t3v3__inv_2_165/VDD VSS gf180mcu_as_sc_mcu7t3v3__inv_2_177/Y
+ VSS gf180mcu_as_sc_mcu7t3v3__inv_2_165/VNW VSUBS gf180mcu_as_sc_mcu7t3v3__inv_2
Xgf180mcu_as_sc_mcu7t3v3__inv_2_154 gf180mcu_as_sc_mcu7t3v3__inv_2_159/VDD gf180mcu_as_sc_mcu7t3v3__inv_2_159/VDD
+ VSS gf180mcu_as_sc_mcu7t3v3__inv_2_177/Y gf180mcu_as_sc_mcu7t3v3__inv_2_156/VNW
+ VSUBS gf180mcu_as_sc_mcu7t3v3__inv_2
Xgf180mcu_as_sc_mcu7t3v3__inv_2_143 gf180mcu_as_sc_mcu7t3v3__inv_2_144/VDD VSS gf180mcu_as_sc_mcu7t3v3__inv_2_143/Y
+ gf180mcu_as_sc_mcu7t3v3__inv_2_923/Y gf180mcu_as_sc_mcu7t3v3__inv_2_144/VNW VSUBS
+ gf180mcu_as_sc_mcu7t3v3__inv_2
Xgf180mcu_as_sc_mcu7t3v3__inv_2_132 gf180mcu_as_sc_mcu7t3v3__inv_2_132/VDD gf180mcu_as_sc_mcu7t3v3__inv_2_135/VDD
+ gf180mcu_as_sc_mcu7t3v3__inv_2_923/Y VSS gf180mcu_as_sc_mcu7t3v3__inv_2_132/VNW
+ VSUBS gf180mcu_as_sc_mcu7t3v3__inv_2
Xgf180mcu_as_sc_mcu7t3v3__nand2_2_33 gf180mcu_as_sc_mcu7t3v3__nor2_2_5/VDD gf180mcu_as_sc_mcu7t3v3__nor2_2_5/VSS
+ VSS VSS VSS gf180mcu_as_sc_mcu7t3v3__nor2_2_5/VNW VSUBS gf180mcu_as_sc_mcu7t3v3__nand2_2
Xgf180mcu_as_sc_mcu7t3v3__nand2_2_22 gf180mcu_as_sc_mcu7t3v3__nor2_2_6/VDD gf180mcu_as_sc_mcu7t3v3__nand3_2_1/VSS
+ VSS VSS VSS gf180mcu_as_sc_mcu7t3v3__nor2_2_6/VNW VSUBS gf180mcu_as_sc_mcu7t3v3__nand2_2
Xgf180mcu_as_sc_mcu7t3v3__nand2_2_11 gf180mcu_as_sc_mcu7t3v3__nor2_2_6/VDD gf180mcu_as_sc_mcu7t3v3__nand3_2_1/VSS
+ VSS VSS VSS gf180mcu_as_sc_mcu7t3v3__nor2_2_6/VNW VSUBS gf180mcu_as_sc_mcu7t3v3__nand2_2
Xgf180mcu_as_sc_mcu7t3v3__nand2_2_44 gf180mcu_as_sc_mcu7t3v3__inv_2_713/VDD gf180mcu_as_sc_mcu7t3v3__inv_2_713/VSS
+ VSS VSS VSS gf180mcu_as_sc_mcu7t3v3__inv_2_713/VNW VSUBS gf180mcu_as_sc_mcu7t3v3__nand2_2
Xgf180mcu_as_sc_mcu7t3v3__nand2_2_55 gf180mcu_as_sc_mcu7t3v3__inv_2_713/VDD gf180mcu_as_sc_mcu7t3v3__nor2_2_8/VSS
+ VSS VSS VSS gf180mcu_as_sc_mcu7t3v3__inv_2_713/VNW VSUBS gf180mcu_as_sc_mcu7t3v3__nand2_2
Xu_t014_010 u_t014_010/c0_w0_bl u_t014_010/c0_w0_br u_t014_010/c0_w1_bl u_t014_010/c0_w1_br
+ u_t014_010/c0_r0_rbl u_t014_010/c0_r1_rbl u_t014_010/c1_w0_bl u_t014_010/c1_w0_br
+ u_t014_010/c1_w1_bl u_t014_010/c1_w1_br u_t014_010/c1_r0_rbl u_t014_010/c1_r1_rbl
+ u_t014_010/c2_w0_bl u_t014_010/c2_w0_br u_t014_010/c2_w1_bl u_t014_010/c2_w1_br
+ u_t014_010/c2_r0_rbl u_t014_010/c2_r1_rbl u_t014_010/c3_w0_bl u_t014_010/c3_w0_br
+ u_t014_010/c3_w1_bl u_t014_010/c3_w1_br u_t014_010/c3_r0_rbl u_t014_010/c3_r1_rbl
+ u_t014_010/r0_w0_wl u_t014_010/r0_w1_wl u_t014_010/r0_r0_rwl u_t014_010/r0_r1_rwl
+ u_t014_010/r1_w0_wl u_t014_010/r1_w1_wl u_t014_010/r1_r0_rwl u_t014_010/r1_r1_rwl
+ u_t014_010/r2_w0_wl u_t014_010/r2_w1_wl u_t014_010/r2_r0_rwl u_t014_010/r2_r1_rwl
+ u_t014_010/r3_w0_wl u_t014_010/r3_w1_wl u_t014_010/r3_r0_rwl u_t014_010/r3_r1_rwl
+ VSS u_t014_010/VSS VSUBS detronyx_12t_2w2r_rc4_4x4_routed_5layer_direct
Xu_t005_010 u_t005_010/c0_w0_bl u_t005_010/c0_w0_br u_t005_010/c0_w1_bl u_t005_010/c0_w1_br
+ u_t005_010/c0_r0_rbl u_t005_010/c0_r1_rbl u_t005_010/c1_w0_bl u_t005_010/c1_w0_br
+ u_t005_010/c1_w1_bl u_t005_010/c1_w1_br u_t005_010/c1_r0_rbl u_t005_010/c1_r1_rbl
+ u_t005_010/c2_w0_bl u_t005_010/c2_w0_br u_t005_010/c2_w1_bl u_t005_010/c2_w1_br
+ u_t005_010/c2_r0_rbl u_t005_010/c2_r1_rbl u_t005_010/c3_w0_bl u_t005_010/c3_w0_br
+ u_t005_010/c3_w1_bl u_t005_010/c3_w1_br u_t005_010/c3_r0_rbl u_t005_010/c3_r1_rbl
+ u_t005_010/r0_w0_wl u_t005_010/r0_w1_wl u_t005_010/r0_r0_rwl u_t005_010/r0_r1_rwl
+ u_t005_010/r1_w0_wl u_t005_010/r1_w1_wl u_t005_010/r1_r0_rwl u_t005_010/r1_r1_rwl
+ u_t005_010/r2_w0_wl u_t005_010/r2_w1_wl u_t005_010/r2_r0_rwl u_t005_010/r2_r1_rwl
+ u_t005_010/r3_w0_wl u_t005_010/r3_w1_wl u_t005_010/r3_r0_rwl u_t005_010/r3_r1_rwl
+ VSS u_t005_015/VSS VSUBS detronyx_12t_2w2r_rc4_4x4_routed_5layer_direct
Xu_t011_002 u_t011_002/c0_w0_bl u_t011_002/c0_w0_br u_t011_002/c0_w1_bl u_t011_002/c0_w1_br
+ u_t011_002/c0_r0_rbl u_t011_002/c0_r1_rbl u_t011_002/c1_w0_bl u_t011_002/c1_w0_br
+ u_t011_002/c1_w1_bl u_t011_002/c1_w1_br u_t011_002/c1_r0_rbl u_t011_002/c1_r1_rbl
+ u_t011_002/c2_w0_bl u_t011_002/c2_w0_br u_t011_002/c2_w1_bl u_t011_002/c2_w1_br
+ u_t011_002/c2_r0_rbl u_t011_002/c2_r1_rbl u_t011_002/c3_w0_bl u_t011_002/c3_w0_br
+ u_t011_002/c3_w1_bl u_t011_002/c3_w1_br u_t011_002/c3_r0_rbl u_t011_002/c3_r1_rbl
+ u_t011_002/r0_w0_wl u_t011_002/r0_w1_wl u_t011_002/r0_r0_rwl u_t011_002/r0_r1_rwl
+ u_t011_002/r1_w0_wl u_t011_002/r1_w1_wl u_t011_002/r1_r0_rwl u_t011_002/r1_r1_rwl
+ u_t011_002/r2_w0_wl u_t011_002/r2_w1_wl u_t011_002/r2_r0_rwl u_t011_002/r2_r1_rwl
+ u_t011_002/r3_w0_wl u_t011_002/r3_w1_wl u_t011_002/r3_r0_rwl u_t011_002/r3_r1_rwl
+ VSS u_t011_002/VSS VSUBS detronyx_12t_2w2r_rc4_4x4_routed_5layer_direct
Xu_t011_013 u_t011_013/c0_w0_bl u_t011_013/c0_w0_br u_t011_013/c0_w1_bl u_t011_013/c0_w1_br
+ u_t011_013/c0_r0_rbl u_t011_013/c0_r1_rbl u_t011_013/c1_w0_bl u_t011_013/c1_w0_br
+ u_t011_013/c1_w1_bl u_t011_013/c1_w1_br u_t011_013/c1_r0_rbl u_t011_013/c1_r1_rbl
+ u_t011_013/c2_w0_bl u_t011_013/c2_w0_br u_t011_013/c2_w1_bl u_t011_013/c2_w1_br
+ u_t011_013/c2_r0_rbl u_t011_013/c2_r1_rbl u_t011_013/c3_w0_bl u_t011_013/c3_w0_br
+ u_t011_013/c3_w1_bl u_t011_013/c3_w1_br u_t011_013/c3_r0_rbl u_t011_013/c3_r1_rbl
+ u_t011_013/r0_w0_wl u_t011_013/r0_w1_wl u_t011_013/r0_r0_rwl u_t011_013/r0_r1_rwl
+ u_t011_013/r1_w0_wl u_t011_013/r1_w1_wl u_t011_013/r1_r0_rwl u_t011_013/r1_r1_rwl
+ u_t011_013/r2_w0_wl u_t011_013/r2_w1_wl u_t011_013/r2_r0_rwl u_t011_013/r2_r1_rwl
+ u_t011_013/r3_w0_wl u_t011_013/r3_w1_wl u_t011_013/r3_r0_rwl u_t011_013/r3_r1_rwl
+ u_t011_013/VDD u_t011_013/VSS VSUBS detronyx_12t_2w2r_rc4_4x4_routed_5layer_direct
Xu_t002_002 u_t002_002/c0_w0_bl u_t002_002/c0_w0_br u_t002_002/c0_w1_bl u_t002_002/c0_w1_br
+ u_t002_002/c0_r0_rbl u_t002_002/c0_r1_rbl u_t002_002/c1_w0_bl u_t002_002/c1_w0_br
+ u_t002_002/c1_w1_bl u_t002_002/c1_w1_br u_t002_002/c1_r0_rbl u_t002_002/c1_r1_rbl
+ u_t002_002/c2_w0_bl u_t002_002/c2_w0_br u_t002_002/c2_w1_bl u_t002_002/c2_w1_br
+ u_t002_002/c2_r0_rbl u_t002_002/c2_r1_rbl u_t002_002/c3_w0_bl u_t002_002/c3_w0_br
+ u_t002_002/c3_w1_bl u_t002_002/c3_w1_br u_t002_002/c3_r0_rbl u_t002_002/c3_r1_rbl
+ u_t002_002/r0_w0_wl u_t002_002/r0_w1_wl u_t002_002/r0_r0_rwl u_t002_002/r0_r1_rwl
+ u_t002_002/r1_w0_wl u_t002_002/r1_w1_wl u_t002_002/r1_r0_rwl u_t002_002/r1_r1_rwl
+ u_t002_002/r2_w0_wl u_t002_002/r2_w1_wl u_t002_002/r2_r0_rwl u_t002_002/r2_r1_rwl
+ u_t002_002/r3_w0_wl u_t002_002/r3_w1_wl u_t002_002/r3_r0_rwl u_t002_002/r3_r1_rwl
+ VSS u_t002_002/VSS VSUBS detronyx_12t_2w2r_rc4_4x4_routed_5layer_direct
Xu_t002_013 u_t002_013/c0_w0_bl u_t002_013/c0_w0_br u_t002_013/c0_w1_bl u_t002_013/c0_w1_br
+ u_t002_013/c0_r0_rbl u_t002_013/c0_r1_rbl u_t002_013/c1_w0_bl u_t002_013/c1_w0_br
+ u_t002_013/c1_w1_bl u_t002_013/c1_w1_br u_t002_013/c1_r0_rbl u_t002_013/c1_r1_rbl
+ u_t002_013/c2_w0_bl u_t002_013/c2_w0_br u_t002_013/c2_w1_bl u_t002_013/c2_w1_br
+ u_t002_013/c2_r0_rbl u_t002_013/c2_r1_rbl u_t002_013/c3_w0_bl u_t002_013/c3_w0_br
+ u_t002_013/c3_w1_bl u_t002_013/c3_w1_br u_t002_013/c3_r0_rbl u_t002_013/c3_r1_rbl
+ u_t002_013/r0_w0_wl u_t002_013/r0_w1_wl u_t002_013/r0_r0_rwl u_t002_013/r0_r1_rwl
+ u_t002_013/r1_w0_wl u_t002_013/r1_w1_wl u_t002_013/r1_r0_rwl u_t002_013/r1_r1_rwl
+ u_t002_013/r2_w0_wl u_t002_013/r2_w1_wl u_t002_013/r2_r0_rwl u_t002_013/r2_r1_rwl
+ u_t002_013/r3_w0_wl u_t002_013/r3_w1_wl u_t002_013/r3_r0_rwl u_t002_013/r3_r1_rwl
+ u_t002_013/VDD u_t002_013/VSS VSUBS detronyx_12t_2w2r_rc4_4x4_routed_5layer_direct
Xgf180mcu_as_sc_mcu7t3v3__inv_2_709 VSS VSS VSS VSS gf180mcu_as_sc_mcu7t3v3__inv_2_709/VNW
+ VSUBS gf180mcu_as_sc_mcu7t3v3__inv_2
Xgf180mcu_as_sc_mcu7t3v3__inv_2_52 VSS gf180mcu_as_sc_mcu7t3v3__inv_2_56/VDD gf180mcu_as_sc_mcu7t3v3__inv_2_52/Y
+ VSS gf180mcu_as_sc_mcu7t3v3__inv_2_53/VNW VSUBS gf180mcu_as_sc_mcu7t3v3__inv_2
Xgf180mcu_as_sc_mcu7t3v3__inv_2_30 VSS gf180mcu_as_sc_mcu7t3v3__inv_2_39/VDD gf180mcu_as_sc_mcu7t3v3__inv_2_30/Y
+ VSS gf180mcu_as_sc_mcu7t3v3__inv_2_36/VNW VSUBS gf180mcu_as_sc_mcu7t3v3__inv_2
Xgf180mcu_as_sc_mcu7t3v3__inv_2_41 gf180mcu_as_sc_mcu7t3v3__inv_2_45/VDD gf180mcu_as_sc_mcu7t3v3__inv_2_45/VDD
+ VSS VSS gf180mcu_as_sc_mcu7t3v3__inv_2_42/VNW VSUBS gf180mcu_as_sc_mcu7t3v3__inv_2
Xgf180mcu_as_sc_mcu7t3v3__inv_2_63 gf180mcu_as_sc_mcu7t3v3__inv_2_63/VDD gf180mcu_as_sc_mcu7t3v3__inv_2_63/VSS
+ gf180mcu_as_sc_mcu7t3v3__inv_2_63/Y VSS gf180mcu_as_sc_mcu7t3v3__inv_2_63/VNW VSUBS
+ gf180mcu_as_sc_mcu7t3v3__inv_2
Xgf180mcu_as_sc_mcu7t3v3__inv_2_96 VSS VSS VSS VSS gf180mcu_as_sc_mcu7t3v3__inv_2_96/VNW
+ VSUBS gf180mcu_as_sc_mcu7t3v3__inv_2
Xgf180mcu_as_sc_mcu7t3v3__inv_2_85 VSS VSS gf180mcu_as_sc_mcu7t3v3__inv_2_85/Y VSS
+ gf180mcu_as_sc_mcu7t3v3__inv_2_87/VNW VSUBS gf180mcu_as_sc_mcu7t3v3__inv_2
Xgf180mcu_as_sc_mcu7t3v3__inv_2_74 gf180mcu_as_sc_mcu7t3v3__inv_2_75/VDD VSS VSS VSS
+ gf180mcu_as_sc_mcu7t3v3__inv_2_75/VNW VSUBS gf180mcu_as_sc_mcu7t3v3__inv_2
Xgf180mcu_as_sc_mcu7t3v3__inv_2_506 VSS VSS VSS VSS gf180mcu_as_sc_mcu7t3v3__inv_2_507/VNW
+ VSUBS gf180mcu_as_sc_mcu7t3v3__inv_2
Xgf180mcu_as_sc_mcu7t3v3__inv_2_539 gf180mcu_as_sc_mcu7t3v3__inv_2_540/VDD gf180mcu_as_sc_mcu7t3v3__inv_2_543/VDD
+ gf180mcu_as_sc_mcu7t3v3__inv_2_545/Y gf180mcu_as_sc_mcu7t3v3__inv_2_540/Y gf180mcu_as_sc_mcu7t3v3__inv_2_540/VNW
+ VSUBS gf180mcu_as_sc_mcu7t3v3__inv_2
Xgf180mcu_as_sc_mcu7t3v3__inv_2_528 VSS VSS gf180mcu_as_sc_mcu7t3v3__inv_2_528/Y VSS
+ gf180mcu_as_sc_mcu7t3v3__inv_2_528/VNW VSUBS gf180mcu_as_sc_mcu7t3v3__inv_2
Xgf180mcu_as_sc_mcu7t3v3__inv_2_517 VSS VSS VSS VSS gf180mcu_as_sc_mcu7t3v3__inv_2_519/VNW
+ VSUBS gf180mcu_as_sc_mcu7t3v3__inv_2
Xgf180mcu_as_sc_mcu7t3v3__nand3_2_0 gf180mcu_as_sc_mcu7t3v3__nor2_2_6/VDD gf180mcu_as_sc_mcu7t3v3__nor2_2_6/VSS
+ VSS VSS VSS VSS gf180mcu_as_sc_mcu7t3v3__nor2_2_6/VNW VSUBS gf180mcu_as_sc_mcu7t3v3__nand3_2
Xgf180mcu_as_sc_mcu7t3v3__inv_2_336 gf180mcu_as_sc_mcu7t3v3__inv_2_338/VDD VSS gf180mcu_as_sc_mcu7t3v3__inv_2_336/Y
+ gf180mcu_as_sc_mcu7t3v3__inv_2_336/A gf180mcu_as_sc_mcu7t3v3__inv_2_338/VNW VSUBS
+ gf180mcu_as_sc_mcu7t3v3__inv_2
Xgf180mcu_as_sc_mcu7t3v3__inv_2_325 gf180mcu_as_sc_mcu7t3v3__inv_2_345/VSS VSS gf180mcu_as_sc_mcu7t3v3__inv_2_325/Y
+ gf180mcu_as_sc_mcu7t3v3__inv_2_326/Y gf180mcu_as_sc_mcu7t3v3__inv_2_326/VNW VSUBS
+ gf180mcu_as_sc_mcu7t3v3__inv_2
Xgf180mcu_as_sc_mcu7t3v3__inv_2_303 VSS VSS VSS VSS gf180mcu_as_sc_mcu7t3v3__inv_2_307/VNW
+ VSUBS gf180mcu_as_sc_mcu7t3v3__inv_2
Xgf180mcu_as_sc_mcu7t3v3__inv_2_347 gf180mcu_as_sc_mcu7t3v3__inv_2_348/VDD gf180mcu_as_sc_mcu7t3v3__inv_2_348/VSS
+ gf180mcu_as_sc_mcu7t3v3__inv_2_347/Y gf180mcu_as_sc_mcu7t3v3__inv_2_348/Y gf180mcu_as_sc_mcu7t3v3__inv_2_348/VNW
+ VSUBS gf180mcu_as_sc_mcu7t3v3__inv_2
Xgf180mcu_as_sc_mcu7t3v3__inv_2_314 gf180mcu_as_sc_mcu7t3v3__nor2_2_4/VDD gf180mcu_as_sc_mcu7t3v3__nand3_2_8/VSS
+ VSS VSS gf180mcu_as_sc_mcu7t3v3__nor2_2_4/VNW VSUBS gf180mcu_as_sc_mcu7t3v3__inv_2
Xgf180mcu_as_sc_mcu7t3v3__inv_2_369 VSS gf180mcu_as_sc_mcu7t3v3__inv_2_372/VDD gf180mcu_as_sc_mcu7t3v3__inv_2_369/Y
+ VSS gf180mcu_as_sc_mcu7t3v3__inv_2_369/VNW VSUBS gf180mcu_as_sc_mcu7t3v3__inv_2
Xgf180mcu_as_sc_mcu7t3v3__inv_2_358 VSS gf180mcu_as_sc_mcu7t3v3__inv_2_363/VDD gf180mcu_as_sc_mcu7t3v3__inv_2_358/Y
+ gf180mcu_as_sc_mcu7t3v3__inv_2_930/A gf180mcu_as_sc_mcu7t3v3__inv_2_360/VNW VSUBS
+ gf180mcu_as_sc_mcu7t3v3__inv_2
Xgf180mcu_as_sc_mcu7t3v3__inv_2_870 VSS gf180mcu_as_sc_mcu7t3v3__inv_2_872/VSS gf180mcu_as_sc_mcu7t3v3__inv_2_870/Y
+ VSS gf180mcu_as_sc_mcu7t3v3__inv_2_872/VNW VSUBS gf180mcu_as_sc_mcu7t3v3__inv_2
Xgf180mcu_as_sc_mcu7t3v3__inv_2_892 gf180mcu_as_sc_mcu7t3v3__inv_2_893/VDD gf180mcu_as_sc_mcu7t3v3__inv_2_896/VDD
+ gf180mcu_as_sc_mcu7t3v3__inv_2_892/Y gf180mcu_as_sc_mcu7t3v3__inv_2_908/Y gf180mcu_as_sc_mcu7t3v3__inv_2_893/VNW
+ VSUBS gf180mcu_as_sc_mcu7t3v3__inv_2
Xgf180mcu_as_sc_mcu7t3v3__inv_2_881 gf180mcu_as_sc_mcu7t3v3__inv_2_884/VDD gf180mcu_as_sc_mcu7t3v3__inv_2_884/VDD
+ gf180mcu_as_sc_mcu7t3v3__inv_2_887/Y VSS gf180mcu_as_sc_mcu7t3v3__inv_2_881/VNW
+ VSUBS gf180mcu_as_sc_mcu7t3v3__inv_2
Xgf180mcu_as_sc_mcu7t3v3__nand4_2_180 VSS VSS VSS VSS VSS VSS VSS gf180mcu_as_sc_mcu7t3v3__inv_2_637/VNW
+ VSUBS gf180mcu_as_sc_mcu7t3v3__nand4_2
Xgf180mcu_as_sc_mcu7t3v3__nand4_2_191 gf180mcu_as_sc_mcu7t3v3__inv_2_731/VDD gf180mcu_as_sc_mcu7t3v3__inv_2_734/VDD
+ VSS VSS VSS VSS VSS gf180mcu_as_sc_mcu7t3v3__inv_2_731/VNW VSUBS gf180mcu_as_sc_mcu7t3v3__nand4_2
Xgf180mcu_as_sc_mcu7t3v3__inv_2_100 VSS gf180mcu_as_sc_mcu7t3v3__inv_2_105/VDD gf180mcu_as_sc_mcu7t3v3__inv_2_100/Y
+ VSS gf180mcu_as_sc_mcu7t3v3__inv_2_102/VNW VSUBS gf180mcu_as_sc_mcu7t3v3__inv_2
Xu_t009_008 u_t009_008/c0_w0_bl u_t009_008/c0_w0_br u_t009_008/c0_w1_bl u_t009_008/c0_w1_br
+ u_t009_008/c0_r0_rbl u_t009_008/c0_r1_rbl u_t009_008/c1_w0_bl u_t009_008/c1_w0_br
+ u_t009_008/c1_w1_bl u_t009_008/c1_w1_br u_t009_008/c1_r0_rbl u_t009_008/c1_r1_rbl
+ u_t009_008/c2_w0_bl u_t009_008/c2_w0_br u_t009_008/c2_w1_bl u_t009_008/c2_w1_br
+ u_t009_008/c2_r0_rbl u_t009_008/c2_r1_rbl u_t009_008/c3_w0_bl u_t009_008/c3_w0_br
+ u_t009_008/c3_w1_bl u_t009_008/c3_w1_br u_t009_008/c3_r0_rbl u_t009_008/c3_r1_rbl
+ u_t009_008/r0_w0_wl u_t009_008/r0_w1_wl u_t009_008/r0_r0_rwl u_t009_008/r0_r1_rwl
+ u_t009_008/r1_w0_wl u_t009_008/r1_w1_wl u_t009_008/r1_r0_rwl u_t009_008/r1_r1_rwl
+ u_t009_008/r2_w0_wl u_t009_008/r2_w1_wl u_t009_008/r2_r0_rwl u_t009_008/r2_r1_rwl
+ u_t009_008/r3_w0_wl u_t009_008/r3_w1_wl u_t009_008/r3_r0_rwl u_t009_008/r3_r1_rwl
+ VSS u_t009_015/VSS VSUBS detronyx_12t_2w2r_rc4_4x4_routed_5layer_direct
Xgf180mcu_as_sc_mcu7t3v3__inv_2_122 gf180mcu_as_sc_mcu7t3v3__inv_2_123/VDD gf180mcu_as_sc_mcu7t3v3__inv_2_177/VDD
+ gf180mcu_as_sc_mcu7t3v3__inv_2_122/Y gf180mcu_as_sc_mcu7t3v3__inv_2_177/Y gf180mcu_as_sc_mcu7t3v3__inv_2_123/VNW
+ VSUBS gf180mcu_as_sc_mcu7t3v3__inv_2
Xgf180mcu_as_sc_mcu7t3v3__inv_2_177 gf180mcu_as_sc_mcu7t3v3__inv_2_177/VDD gf180mcu_as_sc_mcu7t3v3__inv_2_15/VDD
+ gf180mcu_as_sc_mcu7t3v3__inv_2_177/Y VSS gf180mcu_as_sc_mcu7t3v3__inv_2_177/VNW
+ VSUBS gf180mcu_as_sc_mcu7t3v3__inv_2
Xgf180mcu_as_sc_mcu7t3v3__inv_2_188 gf180mcu_as_sc_mcu7t3v3__nor2_2_5/VDD gf180mcu_as_sc_mcu7t3v3__nor2_2_5/VSS
+ VSS VSS gf180mcu_as_sc_mcu7t3v3__nor2_2_5/VNW VSUBS gf180mcu_as_sc_mcu7t3v3__inv_2
Xgf180mcu_as_sc_mcu7t3v3__inv_2_199 gf180mcu_as_sc_mcu7t3v3__nor2_2_4/VDD gf180mcu_as_sc_mcu7t3v3__nor2_2_4/VSS
+ VSS VSS gf180mcu_as_sc_mcu7t3v3__nor2_2_4/VNW VSUBS gf180mcu_as_sc_mcu7t3v3__inv_2
Xgf180mcu_as_sc_mcu7t3v3__inv_2_111 VSS gf180mcu_as_sc_mcu7t3v3__inv_2_114/VDD gf180mcu_as_sc_mcu7t3v3__inv_2_111/Y
+ VSS gf180mcu_as_sc_mcu7t3v3__inv_2_111/VNW VSUBS gf180mcu_as_sc_mcu7t3v3__inv_2
Xgf180mcu_as_sc_mcu7t3v3__inv_2_166 VSS gf180mcu_as_sc_mcu7t3v3__inv_2_171/VDD VSS
+ gf180mcu_as_sc_mcu7t3v3__inv_2_177/Y gf180mcu_as_sc_mcu7t3v3__inv_2_168/VNW VSUBS
+ gf180mcu_as_sc_mcu7t3v3__inv_2
Xgf180mcu_as_sc_mcu7t3v3__inv_2_155 gf180mcu_as_sc_mcu7t3v3__inv_2_159/VDD gf180mcu_as_sc_mcu7t3v3__inv_2_159/VDD
+ gf180mcu_as_sc_mcu7t3v3__inv_2_177/Y gf180mcu_as_sc_mcu7t3v3__inv_2_177/Y gf180mcu_as_sc_mcu7t3v3__inv_2_156/VNW
+ VSUBS gf180mcu_as_sc_mcu7t3v3__inv_2
Xgf180mcu_as_sc_mcu7t3v3__inv_2_144 gf180mcu_as_sc_mcu7t3v3__inv_2_144/VDD VSS gf180mcu_as_sc_mcu7t3v3__inv_2_923/Y
+ VSS gf180mcu_as_sc_mcu7t3v3__inv_2_144/VNW VSUBS gf180mcu_as_sc_mcu7t3v3__inv_2
Xgf180mcu_as_sc_mcu7t3v3__inv_2_133 gf180mcu_as_sc_mcu7t3v3__inv_2_135/VDD VSS VSS
+ gf180mcu_as_sc_mcu7t3v3__inv_2_923/Y gf180mcu_as_sc_mcu7t3v3__inv_2_135/VNW VSUBS
+ gf180mcu_as_sc_mcu7t3v3__inv_2
Xgf180mcu_as_sc_mcu7t3v3__nand2_2_23 gf180mcu_as_sc_mcu7t3v3__nor2_2_5/VDD gf180mcu_as_sc_mcu7t3v3__nand3_2_8/VSS
+ VSS VSS VSS gf180mcu_as_sc_mcu7t3v3__nor2_2_5/VNW VSUBS gf180mcu_as_sc_mcu7t3v3__nand2_2
Xgf180mcu_as_sc_mcu7t3v3__nand2_2_12 gf180mcu_as_sc_mcu7t3v3__nand2_2_9/VDD gf180mcu_as_sc_mcu7t3v3__nor2_2_4/VSS
+ VSS VSS VSS gf180mcu_as_sc_mcu7t3v3__nand2_2_9/VNW VSUBS gf180mcu_as_sc_mcu7t3v3__nand2_2
Xgf180mcu_as_sc_mcu7t3v3__nand2_2_34 gf180mcu_as_sc_mcu7t3v3__nor2_2_5/VDD gf180mcu_as_sc_mcu7t3v3__nand3_2_8/VSS
+ VSS VSS VSS gf180mcu_as_sc_mcu7t3v3__nor2_2_5/VNW VSUBS gf180mcu_as_sc_mcu7t3v3__nand2_2
Xgf180mcu_as_sc_mcu7t3v3__nand2_2_56 gf180mcu_as_sc_mcu7t3v3__inv_2_713/VDD gf180mcu_as_sc_mcu7t3v3__inv_2_713/VSS
+ VSS VSS VSS gf180mcu_as_sc_mcu7t3v3__inv_2_713/VNW VSUBS gf180mcu_as_sc_mcu7t3v3__nand2_2
Xgf180mcu_as_sc_mcu7t3v3__nand2_2_45 gf180mcu_as_sc_mcu7t3v3__nor2_2_8/VDD gf180mcu_as_sc_mcu7t3v3__inv_2_710/VSS
+ VSS VSS VSS gf180mcu_as_sc_mcu7t3v3__nor2_2_8/VNW VSUBS gf180mcu_as_sc_mcu7t3v3__nand2_2
Xu_t014_000 u_t014_000/c0_w0_bl u_t014_000/c0_w0_br u_t014_000/c0_w1_bl u_t014_000/c0_w1_br
+ u_t014_000/c0_r0_rbl u_t014_000/c0_r1_rbl u_t014_000/c1_w0_bl u_t014_000/c1_w0_br
+ u_t014_000/c1_w1_bl u_t014_000/c1_w1_br u_t014_000/c1_r0_rbl u_t014_000/c1_r1_rbl
+ u_t014_000/c2_w0_bl u_t014_000/c2_w0_br u_t014_000/c2_w1_bl u_t014_000/c2_w1_br
+ u_t014_000/c2_r0_rbl u_t014_000/c2_r1_rbl u_t014_000/c3_w0_bl u_t014_000/c3_w0_br
+ u_t014_000/c3_w1_bl u_t014_000/c3_w1_br u_t014_000/c3_r0_rbl u_t014_000/c3_r1_rbl
+ u_t014_000/r0_w0_wl u_t014_000/r0_w1_wl u_t014_000/r0_r0_rwl u_t014_000/r0_r1_rwl
+ u_t014_000/r1_w0_wl u_t014_000/r1_w1_wl u_t014_000/r1_r0_rwl u_t014_000/r1_r1_rwl
+ u_t014_000/r2_w0_wl u_t014_000/r2_w1_wl u_t014_000/r2_r0_rwl u_t014_000/r2_r1_rwl
+ u_t014_000/r3_w0_wl u_t014_000/r3_w1_wl u_t014_000/r3_r0_rwl u_t014_000/r3_r1_rwl
+ VSS u_t014_002/VSS VSUBS detronyx_12t_2w2r_rc4_4x4_routed_5layer_direct
Xu_t014_011 u_t014_011/c0_w0_bl u_t014_011/c0_w0_br u_t014_011/c0_w1_bl u_t014_011/c0_w1_br
+ u_t014_011/c0_r0_rbl u_t014_011/c0_r1_rbl u_t014_011/c1_w0_bl u_t014_011/c1_w0_br
+ u_t014_011/c1_w1_bl u_t014_011/c1_w1_br u_t014_011/c1_r0_rbl u_t014_011/c1_r1_rbl
+ u_t014_011/c2_w0_bl u_t014_011/c2_w0_br u_t014_011/c2_w1_bl u_t014_011/c2_w1_br
+ u_t014_011/c2_r0_rbl u_t014_011/c2_r1_rbl u_t014_011/c3_w0_bl u_t014_011/c3_w0_br
+ u_t014_011/c3_w1_bl u_t014_011/c3_w1_br u_t014_011/c3_r0_rbl u_t014_011/c3_r1_rbl
+ u_t014_011/r0_w0_wl u_t014_011/r0_w1_wl u_t014_011/r0_r0_rwl u_t014_011/r0_r1_rwl
+ u_t014_011/r1_w0_wl u_t014_011/r1_w1_wl u_t014_011/r1_r0_rwl u_t014_011/r1_r1_rwl
+ u_t014_011/r2_w0_wl u_t014_011/r2_w1_wl u_t014_011/r2_r0_rwl u_t014_011/r2_r1_rwl
+ u_t014_011/r3_w0_wl u_t014_011/r3_w1_wl u_t014_011/r3_r0_rwl u_t014_011/r3_r1_rwl
+ u_t014_011/VDD u_t014_011/VSS VSUBS detronyx_12t_2w2r_rc4_4x4_routed_5layer_direct
Xu_t005_000 u_t005_000/c0_w0_bl u_t005_000/c0_w0_br u_t005_000/c0_w1_bl u_t005_000/c0_w1_br
+ u_t005_000/c0_r0_rbl u_t005_000/c0_r1_rbl u_t005_000/c1_w0_bl u_t005_000/c1_w0_br
+ u_t005_000/c1_w1_bl u_t005_000/c1_w1_br u_t005_000/c1_r0_rbl u_t005_000/c1_r1_rbl
+ u_t005_000/c2_w0_bl u_t005_000/c2_w0_br u_t005_000/c2_w1_bl u_t005_000/c2_w1_br
+ u_t005_000/c2_r0_rbl u_t005_000/c2_r1_rbl u_t005_000/c3_w0_bl u_t005_000/c3_w0_br
+ u_t005_000/c3_w1_bl u_t005_000/c3_w1_br u_t005_000/c3_r0_rbl u_t005_000/c3_r1_rbl
+ u_t005_000/r0_w0_wl u_t005_000/r0_w1_wl u_t005_000/r0_r0_rwl u_t005_000/r0_r1_rwl
+ u_t005_000/r1_w0_wl u_t005_000/r1_w1_wl u_t005_000/r1_r0_rwl u_t005_000/r1_r1_rwl
+ u_t005_000/r2_w0_wl u_t005_000/r2_w1_wl u_t005_000/r2_r0_rwl u_t005_000/r2_r1_rwl
+ u_t005_000/r3_w0_wl u_t005_000/r3_w1_wl u_t005_000/r3_r0_rwl u_t005_000/r3_r1_rwl
+ VSS u_t005_015/VSS VSUBS detronyx_12t_2w2r_rc4_4x4_routed_5layer_direct
Xu_t005_011 u_t005_011/c0_w0_bl u_t005_011/c0_w0_br u_t005_011/c0_w1_bl u_t005_011/c0_w1_br
+ u_t005_011/c0_r0_rbl u_t005_011/c0_r1_rbl u_t005_011/c1_w0_bl u_t005_011/c1_w0_br
+ u_t005_011/c1_w1_bl u_t005_011/c1_w1_br u_t005_011/c1_r0_rbl u_t005_011/c1_r1_rbl
+ u_t005_011/c2_w0_bl u_t005_011/c2_w0_br u_t005_011/c2_w1_bl u_t005_011/c2_w1_br
+ u_t005_011/c2_r0_rbl u_t005_011/c2_r1_rbl u_t005_011/c3_w0_bl u_t005_011/c3_w0_br
+ u_t005_011/c3_w1_bl u_t005_011/c3_w1_br u_t005_011/c3_r0_rbl u_t005_011/c3_r1_rbl
+ u_t005_011/r0_w0_wl u_t005_011/r0_w1_wl u_t005_011/r0_r0_rwl u_t005_011/r0_r1_rwl
+ u_t005_011/r1_w0_wl u_t005_011/r1_w1_wl u_t005_011/r1_r0_rwl u_t005_011/r1_r1_rwl
+ u_t005_011/r2_w0_wl u_t005_011/r2_w1_wl u_t005_011/r2_r0_rwl u_t005_011/r2_r1_rwl
+ u_t005_011/r3_w0_wl u_t005_011/r3_w1_wl u_t005_011/r3_r0_rwl u_t005_011/r3_r1_rwl
+ u_t005_011/VDD u_t005_015/VSS VSUBS detronyx_12t_2w2r_rc4_4x4_routed_5layer_direct
Xu_t011_014 u_t011_014/c0_w0_bl u_t011_014/c0_w0_br u_t011_014/c0_w1_bl u_t011_014/c0_w1_br
+ u_t011_014/c0_r0_rbl u_t011_014/c0_r1_rbl u_t011_014/c1_w0_bl u_t011_014/c1_w0_br
+ u_t011_014/c1_w1_bl u_t011_014/c1_w1_br u_t011_014/c1_r0_rbl u_t011_014/c1_r1_rbl
+ u_t011_014/c2_w0_bl u_t011_014/c2_w0_br u_t011_014/c2_w1_bl u_t011_014/c2_w1_br
+ u_t011_014/c2_r0_rbl u_t011_014/c2_r1_rbl u_t011_014/c3_w0_bl u_t011_014/c3_w0_br
+ u_t011_014/c3_w1_bl u_t011_014/c3_w1_br u_t011_014/c3_r0_rbl u_t011_014/c3_r1_rbl
+ u_t011_014/r0_w0_wl u_t011_014/r0_w1_wl u_t011_014/r0_r0_rwl u_t011_014/r0_r1_rwl
+ u_t011_014/r1_w0_wl u_t011_014/r1_w1_wl u_t011_014/r1_r0_rwl u_t011_014/r1_r1_rwl
+ u_t011_014/r2_w0_wl u_t011_014/r2_w1_wl u_t011_014/r2_r0_rwl u_t011_014/r2_r1_rwl
+ u_t011_014/r3_w0_wl u_t011_014/r3_w1_wl u_t011_014/r3_r0_rwl u_t011_014/r3_r1_rwl
+ u_t011_014/VDD u_t011_015/VSS VSUBS detronyx_12t_2w2r_rc4_4x4_routed_5layer_direct
Xu_t011_003 u_t011_003/c0_w0_bl u_t011_003/c0_w0_br u_t011_003/c0_w1_bl u_t011_003/c0_w1_br
+ u_t011_003/c0_r0_rbl u_t011_003/c0_r1_rbl u_t011_003/c1_w0_bl u_t011_003/c1_w0_br
+ u_t011_003/c1_w1_bl u_t011_003/c1_w1_br u_t011_003/c1_r0_rbl u_t011_003/c1_r1_rbl
+ u_t011_003/c2_w0_bl u_t011_003/c2_w0_br u_t011_003/c2_w1_bl u_t011_003/c2_w1_br
+ u_t011_003/c2_r0_rbl u_t011_003/c2_r1_rbl u_t011_003/c3_w0_bl u_t011_003/c3_w0_br
+ u_t011_003/c3_w1_bl u_t011_003/c3_w1_br u_t011_003/c3_r0_rbl u_t011_003/c3_r1_rbl
+ u_t011_003/r0_w0_wl u_t011_003/r0_w1_wl u_t011_003/r0_r0_rwl u_t011_003/r0_r1_rwl
+ u_t011_003/r1_w0_wl u_t011_003/r1_w1_wl u_t011_003/r1_r0_rwl u_t011_003/r1_r1_rwl
+ u_t011_003/r2_w0_wl u_t011_003/r2_w1_wl u_t011_003/r2_r0_rwl u_t011_003/r2_r1_rwl
+ u_t011_003/r3_w0_wl u_t011_003/r3_w1_wl u_t011_003/r3_r0_rwl u_t011_003/r3_r1_rwl
+ u_t011_003/VDD u_t011_003/VSS VSUBS detronyx_12t_2w2r_rc4_4x4_routed_5layer_direct
Xu_t002_003 u_t002_003/c0_w0_bl u_t002_003/c0_w0_br u_t002_003/c0_w1_bl u_t002_003/c0_w1_br
+ u_t002_003/c0_r0_rbl u_t002_003/c0_r1_rbl u_t002_003/c1_w0_bl u_t002_003/c1_w0_br
+ u_t002_003/c1_w1_bl u_t002_003/c1_w1_br u_t002_003/c1_r0_rbl u_t002_003/c1_r1_rbl
+ u_t002_003/c2_w0_bl u_t002_003/c2_w0_br u_t002_003/c2_w1_bl u_t002_003/c2_w1_br
+ u_t002_003/c2_r0_rbl u_t002_003/c2_r1_rbl u_t002_003/c3_w0_bl u_t002_003/c3_w0_br
+ u_t002_003/c3_w1_bl u_t002_003/c3_w1_br u_t002_003/c3_r0_rbl u_t002_003/c3_r1_rbl
+ u_t002_003/r0_w0_wl u_t002_003/r0_w1_wl u_t002_003/r0_r0_rwl u_t002_003/r0_r1_rwl
+ u_t002_003/r1_w0_wl u_t002_003/r1_w1_wl u_t002_003/r1_r0_rwl u_t002_003/r1_r1_rwl
+ u_t002_003/r2_w0_wl u_t002_003/r2_w1_wl u_t002_003/r2_r0_rwl u_t002_003/r2_r1_rwl
+ u_t002_003/r3_w0_wl u_t002_003/r3_w1_wl u_t002_003/r3_r0_rwl u_t002_003/r3_r1_rwl
+ u_t002_003/VDD u_t002_003/VSS VSUBS detronyx_12t_2w2r_rc4_4x4_routed_5layer_direct
Xu_t002_014 u_t002_014/c0_w0_bl u_t002_014/c0_w0_br u_t002_014/c0_w1_bl u_t002_014/c0_w1_br
+ u_t002_014/c0_r0_rbl u_t002_014/c0_r1_rbl u_t002_014/c1_w0_bl u_t002_014/c1_w0_br
+ u_t002_014/c1_w1_bl u_t002_014/c1_w1_br u_t002_014/c1_r0_rbl u_t002_014/c1_r1_rbl
+ u_t002_014/c2_w0_bl u_t002_014/c2_w0_br u_t002_014/c2_w1_bl u_t002_014/c2_w1_br
+ u_t002_014/c2_r0_rbl u_t002_014/c2_r1_rbl u_t002_014/c3_w0_bl u_t002_014/c3_w0_br
+ u_t002_014/c3_w1_bl u_t002_014/c3_w1_br u_t002_014/c3_r0_rbl u_t002_014/c3_r1_rbl
+ u_t002_014/r0_w0_wl u_t002_014/r0_w1_wl u_t002_014/r0_r0_rwl u_t002_014/r0_r1_rwl
+ u_t002_014/r1_w0_wl u_t002_014/r1_w1_wl u_t002_014/r1_r0_rwl u_t002_014/r1_r1_rwl
+ u_t002_014/r2_w0_wl u_t002_014/r2_w1_wl u_t002_014/r2_r0_rwl u_t002_014/r2_r1_rwl
+ u_t002_014/r3_w0_wl u_t002_014/r3_w1_wl u_t002_014/r3_r0_rwl u_t002_014/r3_r1_rwl
+ u_t002_014/VDD u_t002_015/VSS VSUBS detronyx_12t_2w2r_rc4_4x4_routed_5layer_direct
Xgf180mcu_as_sc_mcu7t3v3__inv_2_53 VSS gf180mcu_as_sc_mcu7t3v3__inv_2_56/VDD gf180mcu_as_sc_mcu7t3v3__inv_2_53/Y
+ VSS gf180mcu_as_sc_mcu7t3v3__inv_2_53/VNW VSUBS gf180mcu_as_sc_mcu7t3v3__inv_2
Xgf180mcu_as_sc_mcu7t3v3__inv_2_20 VSS VSS gf180mcu_as_sc_mcu7t3v3__inv_2_27/Y gf180mcu_as_sc_mcu7t3v3__inv_2_27/Y
+ gf180mcu_as_sc_mcu7t3v3__inv_2_21/VNW VSUBS gf180mcu_as_sc_mcu7t3v3__inv_2
Xgf180mcu_as_sc_mcu7t3v3__inv_2_42 gf180mcu_as_sc_mcu7t3v3__inv_2_45/VDD gf180mcu_as_sc_mcu7t3v3__inv_2_45/VDD
+ VSS VSS gf180mcu_as_sc_mcu7t3v3__inv_2_42/VNW VSUBS gf180mcu_as_sc_mcu7t3v3__inv_2
Xgf180mcu_as_sc_mcu7t3v3__inv_2_31 gf180mcu_as_sc_mcu7t3v3__inv_2_47/VDD gf180mcu_as_sc_mcu7t3v3__inv_2_47/VSS
+ gf180mcu_as_sc_mcu7t3v3__inv_2_31/Y VSS gf180mcu_as_sc_mcu7t3v3__inv_2_47/VNW VSUBS
+ gf180mcu_as_sc_mcu7t3v3__inv_2
Xgf180mcu_as_sc_mcu7t3v3__inv_2_86 VSS VSS VSS VSS gf180mcu_as_sc_mcu7t3v3__inv_2_87/VNW
+ VSUBS gf180mcu_as_sc_mcu7t3v3__inv_2
Xgf180mcu_as_sc_mcu7t3v3__inv_2_75 gf180mcu_as_sc_mcu7t3v3__inv_2_75/VDD VSS VSS VSS
+ gf180mcu_as_sc_mcu7t3v3__inv_2_75/VNW VSUBS gf180mcu_as_sc_mcu7t3v3__inv_2
Xgf180mcu_as_sc_mcu7t3v3__inv_2_64 gf180mcu_as_sc_mcu7t3v3__inv_2_66/VDD VSS gf180mcu_as_sc_mcu7t3v3__inv_2_64/Y
+ VSS gf180mcu_as_sc_mcu7t3v3__inv_2_66/VNW VSUBS gf180mcu_as_sc_mcu7t3v3__inv_2
Xgf180mcu_as_sc_mcu7t3v3__inv_2_97 VSS VSS gf180mcu_as_sc_mcu7t3v3__inv_2_97/Y VSS
+ gf180mcu_as_sc_mcu7t3v3__inv_2_99/VNW VSUBS gf180mcu_as_sc_mcu7t3v3__inv_2
Xgf180mcu_as_sc_mcu7t3v3__inv_2_507 VSS VSS gf180mcu_as_sc_mcu7t3v3__inv_2_507/Y VSS
+ gf180mcu_as_sc_mcu7t3v3__inv_2_507/VNW VSUBS gf180mcu_as_sc_mcu7t3v3__inv_2
Xgf180mcu_as_sc_mcu7t3v3__inv_2_529 VSS gf180mcu_as_sc_mcu7t3v3__inv_2_534/VDD gf180mcu_as_sc_mcu7t3v3__inv_2_529/Y
+ gf180mcu_as_sc_mcu7t3v3__inv_2_545/Y gf180mcu_as_sc_mcu7t3v3__inv_2_531/VNW VSUBS
+ gf180mcu_as_sc_mcu7t3v3__inv_2
Xgf180mcu_as_sc_mcu7t3v3__inv_2_518 VSS VSS VSS VSS gf180mcu_as_sc_mcu7t3v3__inv_2_519/VNW
+ VSUBS gf180mcu_as_sc_mcu7t3v3__inv_2
Xgf180mcu_as_sc_mcu7t3v3__nand3_2_1 gf180mcu_as_sc_mcu7t3v3__nor2_2_6/VDD gf180mcu_as_sc_mcu7t3v3__nand3_2_1/VSS
+ VSS VSS VSS VSS gf180mcu_as_sc_mcu7t3v3__nor2_2_6/VNW VSUBS gf180mcu_as_sc_mcu7t3v3__nand3_2
Xgf180mcu_as_sc_mcu7t3v3__inv_2_304 VSS VSS VSS VSS gf180mcu_as_sc_mcu7t3v3__inv_2_306/VNW
+ VSUBS gf180mcu_as_sc_mcu7t3v3__inv_2
Xgf180mcu_as_sc_mcu7t3v3__inv_2_337 gf180mcu_as_sc_mcu7t3v3__inv_2_338/VDD VSS gf180mcu_as_sc_mcu7t3v3__inv_2_337/Y
+ gf180mcu_as_sc_mcu7t3v3__inv_2_338/Y gf180mcu_as_sc_mcu7t3v3__inv_2_338/VNW VSUBS
+ gf180mcu_as_sc_mcu7t3v3__inv_2
Xgf180mcu_as_sc_mcu7t3v3__inv_2_326 gf180mcu_as_sc_mcu7t3v3__inv_2_345/VSS VSS gf180mcu_as_sc_mcu7t3v3__inv_2_326/Y
+ VSS gf180mcu_as_sc_mcu7t3v3__inv_2_326/VNW VSUBS gf180mcu_as_sc_mcu7t3v3__inv_2
Xgf180mcu_as_sc_mcu7t3v3__inv_2_348 gf180mcu_as_sc_mcu7t3v3__inv_2_348/VDD gf180mcu_as_sc_mcu7t3v3__inv_2_348/VSS
+ gf180mcu_as_sc_mcu7t3v3__inv_2_348/Y VSS gf180mcu_as_sc_mcu7t3v3__inv_2_348/VNW
+ VSUBS gf180mcu_as_sc_mcu7t3v3__inv_2
Xgf180mcu_as_sc_mcu7t3v3__inv_2_315 gf180mcu_as_sc_mcu7t3v3__nor2_2_4/VDD gf180mcu_as_sc_mcu7t3v3__nor2_2_4/VSS
+ VSS VSS gf180mcu_as_sc_mcu7t3v3__nor2_2_4/VNW VSUBS gf180mcu_as_sc_mcu7t3v3__inv_2
Xgf180mcu_as_sc_mcu7t3v3__inv_2_359 VSS gf180mcu_as_sc_mcu7t3v3__inv_2_363/VDD gf180mcu_as_sc_mcu7t3v3__inv_2_930/A
+ gf180mcu_as_sc_mcu7t3v3__inv_2_360/Y gf180mcu_as_sc_mcu7t3v3__inv_2_360/VNW VSUBS
+ gf180mcu_as_sc_mcu7t3v3__inv_2
Xgf180mcu_as_sc_mcu7t3v3__inv_2_871 VSS gf180mcu_as_sc_mcu7t3v3__inv_2_872/VSS VSS
+ VSS gf180mcu_as_sc_mcu7t3v3__inv_2_872/VNW VSUBS gf180mcu_as_sc_mcu7t3v3__inv_2
Xgf180mcu_as_sc_mcu7t3v3__inv_2_860 gf180mcu_as_sc_mcu7t3v3__inv_2_860/VDD gf180mcu_as_sc_mcu7t3v3__inv_2_863/VDD
+ VSS VSS gf180mcu_as_sc_mcu7t3v3__inv_2_860/VNW VSUBS gf180mcu_as_sc_mcu7t3v3__inv_2
Xgf180mcu_as_sc_mcu7t3v3__inv_2_893 gf180mcu_as_sc_mcu7t3v3__inv_2_893/VDD gf180mcu_as_sc_mcu7t3v3__inv_2_896/VDD
+ gf180mcu_as_sc_mcu7t3v3__inv_2_908/Y VSS gf180mcu_as_sc_mcu7t3v3__inv_2_893/VNW
+ VSUBS gf180mcu_as_sc_mcu7t3v3__inv_2
Xgf180mcu_as_sc_mcu7t3v3__inv_2_882 gf180mcu_as_sc_mcu7t3v3__inv_2_884/VDD gf180mcu_as_sc_mcu7t3v3__inv_2_887/VDD
+ VSS gf180mcu_as_sc_mcu7t3v3__inv_2_887/Y gf180mcu_as_sc_mcu7t3v3__inv_2_884/VNW
+ VSUBS gf180mcu_as_sc_mcu7t3v3__inv_2
Xgf180mcu_as_sc_mcu7t3v3__nand4_2_192 gf180mcu_as_sc_mcu7t3v3__inv_2_734/VDD gf180mcu_as_sc_mcu7t3v3__inv_2_737/VDD
+ VSS VSS VSS VSS VSS gf180mcu_as_sc_mcu7t3v3__inv_2_734/VNW VSUBS gf180mcu_as_sc_mcu7t3v3__nand4_2
Xgf180mcu_as_sc_mcu7t3v3__nand4_2_170 VSS gf180mcu_as_sc_mcu7t3v3__inv_2_618/VDD VSS
+ VSS VSS VSS VSS gf180mcu_as_sc_mcu7t3v3__inv_2_615/VNW VSUBS gf180mcu_as_sc_mcu7t3v3__nand4_2
Xgf180mcu_as_sc_mcu7t3v3__nand4_2_181 VSS VSS VSS VSS VSS VSS gf180mcu_as_sc_mcu7t3v3__nand4_2_181/Y
+ gf180mcu_as_sc_mcu7t3v3__inv_2_641/VNW VSUBS gf180mcu_as_sc_mcu7t3v3__nand4_2
Xgf180mcu_as_sc_mcu7t3v3__inv_2_123 gf180mcu_as_sc_mcu7t3v3__inv_2_123/VDD gf180mcu_as_sc_mcu7t3v3__inv_2_177/VDD
+ gf180mcu_as_sc_mcu7t3v3__inv_2_177/Y VSS gf180mcu_as_sc_mcu7t3v3__inv_2_123/VNW
+ VSUBS gf180mcu_as_sc_mcu7t3v3__inv_2
Xgf180mcu_as_sc_mcu7t3v3__inv_2_112 gf180mcu_as_sc_mcu7t3v3__inv_2_114/VDD VSS gf180mcu_as_sc_mcu7t3v3__inv_2_112/Y
+ VSS gf180mcu_as_sc_mcu7t3v3__inv_2_114/VNW VSUBS gf180mcu_as_sc_mcu7t3v3__inv_2
Xgf180mcu_as_sc_mcu7t3v3__inv_2_101 VSS gf180mcu_as_sc_mcu7t3v3__inv_2_105/VDD gf180mcu_as_sc_mcu7t3v3__inv_2_101/Y
+ VSS gf180mcu_as_sc_mcu7t3v3__inv_2_102/VNW VSUBS gf180mcu_as_sc_mcu7t3v3__inv_2
Xgf180mcu_as_sc_mcu7t3v3__inv_2_134 gf180mcu_as_sc_mcu7t3v3__inv_2_135/VDD VSS gf180mcu_as_sc_mcu7t3v3__inv_2_923/Y
+ gf180mcu_as_sc_mcu7t3v3__inv_2_923/Y gf180mcu_as_sc_mcu7t3v3__inv_2_135/VNW VSUBS
+ gf180mcu_as_sc_mcu7t3v3__inv_2
Xu_t009_009 u_t009_009/c0_w0_bl u_t009_009/c0_w0_br u_t009_009/c0_w1_bl u_t009_009/c0_w1_br
+ u_t009_009/c0_r0_rbl u_t009_009/c0_r1_rbl u_t009_009/c1_w0_bl u_t009_009/c1_w0_br
+ u_t009_009/c1_w1_bl u_t009_009/c1_w1_br u_t009_009/c1_r0_rbl u_t009_009/c1_r1_rbl
+ u_t009_009/c2_w0_bl u_t009_009/c2_w0_br u_t009_009/c2_w1_bl u_t009_009/c2_w1_br
+ u_t009_009/c2_r0_rbl u_t009_009/c2_r1_rbl u_t009_009/c3_w0_bl u_t009_009/c3_w0_br
+ u_t009_009/c3_w1_bl u_t009_009/c3_w1_br u_t009_009/c3_r0_rbl u_t009_009/c3_r1_rbl
+ u_t009_009/r0_w0_wl u_t009_009/r0_w1_wl u_t009_009/r0_r0_rwl u_t009_009/r0_r1_rwl
+ u_t009_009/r1_w0_wl u_t009_009/r1_w1_wl u_t009_009/r1_r0_rwl u_t009_009/r1_r1_rwl
+ u_t009_009/r2_w0_wl u_t009_009/r2_w1_wl u_t009_009/r2_r0_rwl u_t009_009/r2_r1_rwl
+ u_t009_009/r3_w0_wl u_t009_009/r3_w1_wl u_t009_009/r3_r0_rwl u_t009_009/r3_r1_rwl
+ VSS u_t009_015/VSS VSUBS detronyx_12t_2w2r_rc4_4x4_routed_5layer_direct
Xgf180mcu_as_sc_mcu7t3v3__inv_2_178 gf180mcu_as_sc_mcu7t3v3__inv_2_63/VSS VSS gf180mcu_as_sc_mcu7t3v3__inv_2_178/Y
+ VSS gf180mcu_as_sc_mcu7t3v3__inv_2_179/VNW VSUBS gf180mcu_as_sc_mcu7t3v3__inv_2
Xgf180mcu_as_sc_mcu7t3v3__inv_2_189 gf180mcu_as_sc_mcu7t3v3__nor2_2_5/VDD gf180mcu_as_sc_mcu7t3v3__nand3_2_8/VSS
+ VSS VSS gf180mcu_as_sc_mcu7t3v3__nor2_2_5/VNW VSUBS gf180mcu_as_sc_mcu7t3v3__inv_2
Xgf180mcu_as_sc_mcu7t3v3__inv_2_167 VSS gf180mcu_as_sc_mcu7t3v3__inv_2_171/VDD gf180mcu_as_sc_mcu7t3v3__inv_2_177/Y
+ gf180mcu_as_sc_mcu7t3v3__inv_2_177/Y gf180mcu_as_sc_mcu7t3v3__inv_2_168/VNW VSUBS
+ gf180mcu_as_sc_mcu7t3v3__inv_2
Xgf180mcu_as_sc_mcu7t3v3__inv_2_156 gf180mcu_as_sc_mcu7t3v3__inv_2_159/VDD gf180mcu_as_sc_mcu7t3v3__inv_2_159/VDD
+ gf180mcu_as_sc_mcu7t3v3__inv_2_177/Y VSS gf180mcu_as_sc_mcu7t3v3__inv_2_156/VNW
+ VSUBS gf180mcu_as_sc_mcu7t3v3__inv_2
Xgf180mcu_as_sc_mcu7t3v3__inv_2_145 VSS VSS VSS gf180mcu_as_sc_mcu7t3v3__inv_2_153/Y
+ gf180mcu_as_sc_mcu7t3v3__inv_2_147/VNW VSUBS gf180mcu_as_sc_mcu7t3v3__inv_2
Xgf180mcu_as_sc_mcu7t3v3__inv_2_690 gf180mcu_as_sc_mcu7t3v3__inv_2_713/VDD gf180mcu_as_sc_mcu7t3v3__nor2_2_8/VSS
+ VSS VSS gf180mcu_as_sc_mcu7t3v3__inv_2_713/VNW VSUBS gf180mcu_as_sc_mcu7t3v3__inv_2
Xgf180mcu_as_sc_mcu7t3v3__nand2_2_24 gf180mcu_as_sc_mcu7t3v3__nor2_2_4/VDD gf180mcu_as_sc_mcu7t3v3__nand3_2_8/VSS
+ VSS VSS VSS gf180mcu_as_sc_mcu7t3v3__nor2_2_4/VNW VSUBS gf180mcu_as_sc_mcu7t3v3__nand2_2
Xgf180mcu_as_sc_mcu7t3v3__nand2_2_35 gf180mcu_as_sc_mcu7t3v3__nor2_2_4/VDD gf180mcu_as_sc_mcu7t3v3__nand3_2_8/VSS
+ VSS VSS VSS gf180mcu_as_sc_mcu7t3v3__nor2_2_4/VNW VSUBS gf180mcu_as_sc_mcu7t3v3__nand2_2
Xgf180mcu_as_sc_mcu7t3v3__nand2_2_13 gf180mcu_as_sc_mcu7t3v3__nand2_2_9/VDD gf180mcu_as_sc_mcu7t3v3__nor2_2_6/VSS
+ VSS VSS VSS gf180mcu_as_sc_mcu7t3v3__nand2_2_9/VNW VSUBS gf180mcu_as_sc_mcu7t3v3__nand2_2
Xgf180mcu_as_sc_mcu7t3v3__nand2_2_46 gf180mcu_as_sc_mcu7t3v3__nor2_2_8/VDD gf180mcu_as_sc_mcu7t3v3__nor2_2_8/VSS
+ VSS VSS VSS gf180mcu_as_sc_mcu7t3v3__nor2_2_8/VNW VSUBS gf180mcu_as_sc_mcu7t3v3__nand2_2
Xgf180mcu_as_sc_mcu7t3v3__nand2_2_57 gf180mcu_as_sc_mcu7t3v3__nor2_2_8/VDD gf180mcu_as_sc_mcu7t3v3__inv_2_710/VSS
+ VSS VSS VSS gf180mcu_as_sc_mcu7t3v3__nor2_2_8/VNW VSUBS gf180mcu_as_sc_mcu7t3v3__nand2_2
Xu_t014_012 u_t014_012/c0_w0_bl u_t014_012/c0_w0_br u_t014_012/c0_w1_bl u_t014_012/c0_w1_br
+ u_t014_012/c0_r0_rbl u_t014_012/c0_r1_rbl u_t014_012/c1_w0_bl u_t014_012/c1_w0_br
+ u_t014_012/c1_w1_bl u_t014_012/c1_w1_br u_t014_012/c1_r0_rbl u_t014_012/c1_r1_rbl
+ u_t014_012/c2_w0_bl u_t014_012/c2_w0_br u_t014_012/c2_w1_bl u_t014_012/c2_w1_br
+ u_t014_012/c2_r0_rbl u_t014_012/c2_r1_rbl u_t014_012/c3_w0_bl u_t014_012/c3_w0_br
+ u_t014_012/c3_w1_bl u_t014_012/c3_w1_br u_t014_012/c3_r0_rbl u_t014_012/c3_r1_rbl
+ u_t014_012/r0_w0_wl u_t014_012/r0_w1_wl u_t014_012/r0_r0_rwl u_t014_012/r0_r1_rwl
+ u_t014_012/r1_w0_wl u_t014_012/r1_w1_wl u_t014_012/r1_r0_rwl u_t014_012/r1_r1_rwl
+ u_t014_012/r2_w0_wl u_t014_012/r2_w1_wl u_t014_012/r2_r0_rwl u_t014_012/r2_r1_rwl
+ u_t014_012/r3_w0_wl u_t014_012/r3_w1_wl u_t014_012/r3_r0_rwl u_t014_012/r3_r1_rwl
+ u_t014_012/VDD u_t014_012/VSS VSUBS detronyx_12t_2w2r_rc4_4x4_routed_5layer_direct
Xu_t014_001 u_t014_001/c0_w0_bl u_t014_001/c0_w0_br u_t014_001/c0_w1_bl u_t014_001/c0_w1_br
+ u_t014_001/c0_r0_rbl u_t014_001/c0_r1_rbl u_t014_001/c1_w0_bl u_t014_001/c1_w0_br
+ u_t014_001/c1_w1_bl u_t014_001/c1_w1_br u_t014_001/c1_r0_rbl u_t014_001/c1_r1_rbl
+ u_t014_001/c2_w0_bl u_t014_001/c2_w0_br u_t014_001/c2_w1_bl u_t014_001/c2_w1_br
+ u_t014_001/c2_r0_rbl u_t014_001/c2_r1_rbl u_t014_001/c3_w0_bl u_t014_001/c3_w0_br
+ u_t014_001/c3_w1_bl u_t014_001/c3_w1_br u_t014_001/c3_r0_rbl u_t014_001/c3_r1_rbl
+ u_t014_001/r0_w0_wl u_t014_001/r0_w1_wl u_t014_001/r0_r0_rwl u_t014_001/r0_r1_rwl
+ u_t014_001/r1_w0_wl u_t014_001/r1_w1_wl u_t014_001/r1_r0_rwl u_t014_001/r1_r1_rwl
+ u_t014_001/r2_w0_wl u_t014_001/r2_w1_wl u_t014_001/r2_r0_rwl u_t014_001/r2_r1_rwl
+ u_t014_001/r3_w0_wl u_t014_001/r3_w1_wl u_t014_001/r3_r0_rwl u_t014_001/r3_r1_rwl
+ VSS u_t014_002/VSS VSUBS detronyx_12t_2w2r_rc4_4x4_routed_5layer_direct
Xu_t005_001 u_t005_001/c0_w0_bl u_t005_001/c0_w0_br u_t005_001/c0_w1_bl u_t005_001/c0_w1_br
+ u_t005_001/c0_r0_rbl u_t005_001/c0_r1_rbl u_t005_001/c1_w0_bl u_t005_001/c1_w0_br
+ u_t005_001/c1_w1_bl u_t005_001/c1_w1_br u_t005_001/c1_r0_rbl u_t005_001/c1_r1_rbl
+ u_t005_001/c2_w0_bl u_t005_001/c2_w0_br u_t005_001/c2_w1_bl u_t005_001/c2_w1_br
+ u_t005_001/c2_r0_rbl u_t005_001/c2_r1_rbl u_t005_001/c3_w0_bl u_t005_001/c3_w0_br
+ u_t005_001/c3_w1_bl u_t005_001/c3_w1_br u_t005_001/c3_r0_rbl u_t005_001/c3_r1_rbl
+ u_t005_001/r0_w0_wl u_t005_001/r0_w1_wl u_t005_001/r0_r0_rwl u_t005_001/r0_r1_rwl
+ u_t005_001/r1_w0_wl u_t005_001/r1_w1_wl u_t005_001/r1_r0_rwl u_t005_001/r1_r1_rwl
+ u_t005_001/r2_w0_wl u_t005_001/r2_w1_wl u_t005_001/r2_r0_rwl u_t005_001/r2_r1_rwl
+ u_t005_001/r3_w0_wl u_t005_001/r3_w1_wl u_t005_001/r3_r0_rwl u_t005_001/r3_r1_rwl
+ VSS u_t005_015/VSS VSUBS detronyx_12t_2w2r_rc4_4x4_routed_5layer_direct
Xu_t005_012 u_t005_012/c0_w0_bl u_t005_012/c0_w0_br u_t005_012/c0_w1_bl u_t005_012/c0_w1_br
+ u_t005_012/c0_r0_rbl u_t005_012/c0_r1_rbl u_t005_012/c1_w0_bl u_t005_012/c1_w0_br
+ u_t005_012/c1_w1_bl u_t005_012/c1_w1_br u_t005_012/c1_r0_rbl u_t005_012/c1_r1_rbl
+ u_t005_012/c2_w0_bl u_t005_012/c2_w0_br u_t005_012/c2_w1_bl u_t005_012/c2_w1_br
+ u_t005_012/c2_r0_rbl u_t005_012/c2_r1_rbl u_t005_012/c3_w0_bl u_t005_012/c3_w0_br
+ u_t005_012/c3_w1_bl u_t005_012/c3_w1_br u_t005_012/c3_r0_rbl u_t005_012/c3_r1_rbl
+ u_t005_012/r0_w0_wl u_t005_012/r0_w1_wl u_t005_012/r0_r0_rwl u_t005_012/r0_r1_rwl
+ u_t005_012/r1_w0_wl u_t005_012/r1_w1_wl u_t005_012/r1_r0_rwl u_t005_012/r1_r1_rwl
+ u_t005_012/r2_w0_wl u_t005_012/r2_w1_wl u_t005_012/r2_r0_rwl u_t005_012/r2_r1_rwl
+ u_t005_012/r3_w0_wl u_t005_012/r3_w1_wl u_t005_012/r3_r0_rwl u_t005_012/r3_r1_rwl
+ u_t005_012/VDD u_t005_015/VSS VSUBS detronyx_12t_2w2r_rc4_4x4_routed_5layer_direct
Xu_t011_015 u_t011_015/c0_w0_bl u_t011_015/c0_w0_br u_t011_015/c0_w1_bl u_t011_015/c0_w1_br
+ u_t011_015/c0_r0_rbl u_t011_015/c0_r1_rbl u_t011_015/c1_w0_bl u_t011_015/c1_w0_br
+ u_t011_015/c1_w1_bl u_t011_015/c1_w1_br u_t011_015/c1_r0_rbl u_t011_015/c1_r1_rbl
+ u_t011_015/c2_w0_bl u_t011_015/c2_w0_br u_t011_015/c2_w1_bl u_t011_015/c2_w1_br
+ u_t011_015/c2_r0_rbl u_t011_015/c2_r1_rbl u_t011_015/c3_w0_bl u_t011_015/c3_w0_br
+ u_t011_015/c3_w1_bl u_t011_015/c3_w1_br u_t011_015/c3_r0_rbl u_t011_015/c3_r1_rbl
+ u_t011_015/r0_w0_wl u_t011_015/r0_w1_wl u_t011_015/r0_r0_rwl u_t011_015/r0_r1_rwl
+ u_t011_015/r1_w0_wl u_t011_015/r1_w1_wl u_t011_015/r1_r0_rwl u_t011_015/r1_r1_rwl
+ u_t011_015/r2_w0_wl u_t011_015/r2_w1_wl u_t011_015/r2_r0_rwl u_t011_015/r2_r1_rwl
+ u_t011_015/r3_w0_wl u_t011_015/r3_w1_wl u_t011_015/r3_r0_rwl u_t011_015/r3_r1_rwl
+ VSS u_t011_015/VSS VSUBS detronyx_12t_2w2r_rc4_4x4_routed_5layer_direct
Xu_t011_004 u_t011_004/c0_w0_bl u_t011_004/c0_w0_br u_t011_004/c0_w1_bl u_t011_004/c0_w1_br
+ u_t011_004/c0_r0_rbl u_t011_004/c0_r1_rbl u_t011_004/c1_w0_bl u_t011_004/c1_w0_br
+ u_t011_004/c1_w1_bl u_t011_004/c1_w1_br u_t011_004/c1_r0_rbl u_t011_004/c1_r1_rbl
+ u_t011_004/c2_w0_bl u_t011_004/c2_w0_br u_t011_004/c2_w1_bl u_t011_004/c2_w1_br
+ u_t011_004/c2_r0_rbl u_t011_004/c2_r1_rbl u_t011_004/c3_w0_bl u_t011_004/c3_w0_br
+ u_t011_004/c3_w1_bl u_t011_004/c3_w1_br u_t011_004/c3_r0_rbl u_t011_004/c3_r1_rbl
+ u_t011_004/r0_w0_wl u_t011_004/r0_w1_wl u_t011_004/r0_r0_rwl u_t011_004/r0_r1_rwl
+ u_t011_004/r1_w0_wl u_t011_004/r1_w1_wl u_t011_004/r1_r0_rwl u_t011_004/r1_r1_rwl
+ u_t011_004/r2_w0_wl u_t011_004/r2_w1_wl u_t011_004/r2_r0_rwl u_t011_004/r2_r1_rwl
+ u_t011_004/r3_w0_wl u_t011_004/r3_w1_wl u_t011_004/r3_r0_rwl u_t011_004/r3_r1_rwl
+ u_t011_004/VDD u_t011_004/VSS VSUBS detronyx_12t_2w2r_rc4_4x4_routed_5layer_direct
Xu_t002_004 u_t002_004/c0_w0_bl u_t002_004/c0_w0_br u_t002_004/c0_w1_bl u_t002_004/c0_w1_br
+ u_t002_004/c0_r0_rbl u_t002_004/c0_r1_rbl u_t002_004/c1_w0_bl u_t002_004/c1_w0_br
+ u_t002_004/c1_w1_bl u_t002_004/c1_w1_br u_t002_004/c1_r0_rbl u_t002_004/c1_r1_rbl
+ u_t002_004/c2_w0_bl u_t002_004/c2_w0_br u_t002_004/c2_w1_bl u_t002_004/c2_w1_br
+ u_t002_004/c2_r0_rbl u_t002_004/c2_r1_rbl u_t002_004/c3_w0_bl u_t002_004/c3_w0_br
+ u_t002_004/c3_w1_bl u_t002_004/c3_w1_br u_t002_004/c3_r0_rbl u_t002_004/c3_r1_rbl
+ u_t002_004/r0_w0_wl u_t002_004/r0_w1_wl u_t002_004/r0_r0_rwl u_t002_004/r0_r1_rwl
+ u_t002_004/r1_w0_wl u_t002_004/r1_w1_wl u_t002_004/r1_r0_rwl u_t002_004/r1_r1_rwl
+ u_t002_004/r2_w0_wl u_t002_004/r2_w1_wl u_t002_004/r2_r0_rwl u_t002_004/r2_r1_rwl
+ u_t002_004/r3_w0_wl u_t002_004/r3_w1_wl u_t002_004/r3_r0_rwl u_t002_004/r3_r1_rwl
+ u_t002_004/VDD u_t002_004/VSS VSUBS detronyx_12t_2w2r_rc4_4x4_routed_5layer_direct
Xu_t002_015 u_t002_015/c0_w0_bl u_t002_015/c0_w0_br u_t002_015/c0_w1_bl u_t002_015/c0_w1_br
+ u_t002_015/c0_r0_rbl u_t002_015/c0_r1_rbl u_t002_015/c1_w0_bl u_t002_015/c1_w0_br
+ u_t002_015/c1_w1_bl u_t002_015/c1_w1_br u_t002_015/c1_r0_rbl u_t002_015/c1_r1_rbl
+ u_t002_015/c2_w0_bl u_t002_015/c2_w0_br u_t002_015/c2_w1_bl u_t002_015/c2_w1_br
+ u_t002_015/c2_r0_rbl u_t002_015/c2_r1_rbl u_t002_015/c3_w0_bl u_t002_015/c3_w0_br
+ u_t002_015/c3_w1_bl u_t002_015/c3_w1_br u_t002_015/c3_r0_rbl u_t002_015/c3_r1_rbl
+ u_t002_015/r0_w0_wl u_t002_015/r0_w1_wl u_t002_015/r0_r0_rwl u_t002_015/r0_r1_rwl
+ u_t002_015/r1_w0_wl u_t002_015/r1_w1_wl u_t002_015/r1_r0_rwl u_t002_015/r1_r1_rwl
+ u_t002_015/r2_w0_wl u_t002_015/r2_w1_wl u_t002_015/r2_r0_rwl u_t002_015/r2_r1_rwl
+ u_t002_015/r3_w0_wl u_t002_015/r3_w1_wl u_t002_015/r3_r0_rwl u_t002_015/r3_r1_rwl
+ VSS u_t002_015/VSS VSUBS detronyx_12t_2w2r_rc4_4x4_routed_5layer_direct
Xgf180mcu_as_sc_mcu7t3v3__inv_2_10 gf180mcu_as_sc_mcu7t3v3__inv_2_15/VDD gf180mcu_as_sc_mcu7t3v3__inv_2_15/VDD
+ VSS gf180mcu_as_sc_mcu7t3v3__inv_2_18/Y gf180mcu_as_sc_mcu7t3v3__inv_2_12/VNW VSUBS
+ gf180mcu_as_sc_mcu7t3v3__inv_2
Xgf180mcu_as_sc_mcu7t3v3__inv_2_21 VSS VSS gf180mcu_as_sc_mcu7t3v3__inv_2_27/Y VSS
+ gf180mcu_as_sc_mcu7t3v3__inv_2_21/VNW VSUBS gf180mcu_as_sc_mcu7t3v3__inv_2
Xgf180mcu_as_sc_mcu7t3v3__inv_2_54 gf180mcu_as_sc_mcu7t3v3__inv_2_56/VDD VSS gf180mcu_as_sc_mcu7t3v3__inv_2_54/Y
+ VSS gf180mcu_as_sc_mcu7t3v3__inv_2_56/VNW VSUBS gf180mcu_as_sc_mcu7t3v3__inv_2
Xgf180mcu_as_sc_mcu7t3v3__inv_2_43 gf180mcu_as_sc_mcu7t3v3__inv_2_45/VDD gf180mcu_as_sc_mcu7t3v3__inv_2_47/VDD
+ gf180mcu_as_sc_mcu7t3v3__inv_2_43/Y VSS gf180mcu_as_sc_mcu7t3v3__inv_2_45/VNW VSUBS
+ gf180mcu_as_sc_mcu7t3v3__inv_2
Xgf180mcu_as_sc_mcu7t3v3__inv_2_32 gf180mcu_as_sc_mcu7t3v3__inv_2_47/VSS VSS gf180mcu_as_sc_mcu7t3v3__inv_2_32/Y
+ VSS gf180mcu_as_sc_mcu7t3v3__inv_2_34/VNW VSUBS gf180mcu_as_sc_mcu7t3v3__inv_2
Xgf180mcu_as_sc_mcu7t3v3__inv_2_98 VSS VSS gf180mcu_as_sc_mcu7t3v3__inv_2_98/Y VSS
+ gf180mcu_as_sc_mcu7t3v3__inv_2_99/VNW VSUBS gf180mcu_as_sc_mcu7t3v3__inv_2
Xgf180mcu_as_sc_mcu7t3v3__inv_2_87 VSS VSS VSS VSS gf180mcu_as_sc_mcu7t3v3__inv_2_87/VNW
+ VSUBS gf180mcu_as_sc_mcu7t3v3__inv_2
Xgf180mcu_as_sc_mcu7t3v3__inv_2_76 VSS gf180mcu_as_sc_mcu7t3v3__inv_2_81/VDD gf180mcu_as_sc_mcu7t3v3__inv_2_76/Y
+ VSS gf180mcu_as_sc_mcu7t3v3__inv_2_78/VNW VSUBS gf180mcu_as_sc_mcu7t3v3__inv_2
Xgf180mcu_as_sc_mcu7t3v3__inv_2_65 gf180mcu_as_sc_mcu7t3v3__inv_2_66/VDD VSS VSS VSS
+ gf180mcu_as_sc_mcu7t3v3__inv_2_66/VNW VSUBS gf180mcu_as_sc_mcu7t3v3__inv_2
Xgf180mcu_as_sc_mcu7t3v3__inv_2_519 VSS VSS VSS VSS gf180mcu_as_sc_mcu7t3v3__inv_2_519/VNW
+ VSUBS gf180mcu_as_sc_mcu7t3v3__inv_2
Xgf180mcu_as_sc_mcu7t3v3__inv_2_508 VSS VSS VSS VSS gf180mcu_as_sc_mcu7t3v3__inv_2_510/VNW
+ VSUBS gf180mcu_as_sc_mcu7t3v3__inv_2
Xgf180mcu_as_sc_mcu7t3v3__nand3_2_2 gf180mcu_as_sc_mcu7t3v3__nor2_2_5/VDD gf180mcu_as_sc_mcu7t3v3__nor2_2_5/VSS
+ VSS VSS VSS VSS gf180mcu_as_sc_mcu7t3v3__nor2_2_5/VNW VSUBS gf180mcu_as_sc_mcu7t3v3__nand3_2
Xgf180mcu_as_sc_mcu7t3v3__inv_2_305 VSS VSS VSS VSS gf180mcu_as_sc_mcu7t3v3__inv_2_306/VNW
+ VSUBS gf180mcu_as_sc_mcu7t3v3__inv_2
Xgf180mcu_as_sc_mcu7t3v3__inv_2_316 VSS VSS VSS VSS gf180mcu_as_sc_mcu7t3v3__inv_2_318/VNW
+ VSUBS gf180mcu_as_sc_mcu7t3v3__inv_2
Xgf180mcu_as_sc_mcu7t3v3__inv_2_349 VSS gf180mcu_as_sc_mcu7t3v3__inv_2_354/VDD gf180mcu_as_sc_mcu7t3v3__inv_2_349/Y
+ gf180mcu_as_sc_mcu7t3v3__inv_2_466/A gf180mcu_as_sc_mcu7t3v3__inv_2_351/VNW VSUBS
+ gf180mcu_as_sc_mcu7t3v3__inv_2
Xgf180mcu_as_sc_mcu7t3v3__inv_2_338 gf180mcu_as_sc_mcu7t3v3__inv_2_338/VDD VSS gf180mcu_as_sc_mcu7t3v3__inv_2_338/Y
+ VSS gf180mcu_as_sc_mcu7t3v3__inv_2_338/VNW VSUBS gf180mcu_as_sc_mcu7t3v3__inv_2
Xgf180mcu_as_sc_mcu7t3v3__inv_2_327 VSS gf180mcu_as_sc_mcu7t3v3__inv_2_348/VDD gf180mcu_as_sc_mcu7t3v3__inv_2_327/Y
+ gf180mcu_as_sc_mcu7t3v3__inv_2_343/Y gf180mcu_as_sc_mcu7t3v3__inv_2_343/VNW VSUBS
+ gf180mcu_as_sc_mcu7t3v3__inv_2
Xgf180mcu_as_sc_mcu7t3v3__inv_2_872 VSS gf180mcu_as_sc_mcu7t3v3__inv_2_872/VSS VSS
+ VSS gf180mcu_as_sc_mcu7t3v3__inv_2_872/VNW VSUBS gf180mcu_as_sc_mcu7t3v3__inv_2
Xgf180mcu_as_sc_mcu7t3v3__inv_2_861 gf180mcu_as_sc_mcu7t3v3__inv_2_863/VDD gf180mcu_as_sc_mcu7t3v3__inv_2_866/VDD
+ gf180mcu_as_sc_mcu7t3v3__inv_2_861/Y VSS gf180mcu_as_sc_mcu7t3v3__inv_2_863/VNW
+ VSUBS gf180mcu_as_sc_mcu7t3v3__inv_2
Xgf180mcu_as_sc_mcu7t3v3__inv_2_850 gf180mcu_as_sc_mcu7t3v3__inv_2_854/VDD gf180mcu_as_sc_mcu7t3v3__inv_2_854/VDD
+ VSS VSS gf180mcu_as_sc_mcu7t3v3__inv_2_851/VNW VSUBS gf180mcu_as_sc_mcu7t3v3__inv_2
Xgf180mcu_as_sc_mcu7t3v3__inv_2_894 gf180mcu_as_sc_mcu7t3v3__inv_2_896/VDD gf180mcu_as_sc_mcu7t3v3__inv_2_899/VDD
+ VSS gf180mcu_as_sc_mcu7t3v3__inv_2_908/Y gf180mcu_as_sc_mcu7t3v3__inv_2_896/VNW
+ VSUBS gf180mcu_as_sc_mcu7t3v3__inv_2
Xgf180mcu_as_sc_mcu7t3v3__inv_2_883 gf180mcu_as_sc_mcu7t3v3__inv_2_884/VDD gf180mcu_as_sc_mcu7t3v3__inv_2_887/VDD
+ gf180mcu_as_sc_mcu7t3v3__inv_2_883/Y gf180mcu_as_sc_mcu7t3v3__inv_2_887/Y gf180mcu_as_sc_mcu7t3v3__inv_2_884/VNW
+ VSUBS gf180mcu_as_sc_mcu7t3v3__inv_2
Xgf180mcu_as_sc_mcu7t3v3__nand4_2_193 gf180mcu_as_sc_mcu7t3v3__inv_2_737/VDD gf180mcu_as_sc_mcu7t3v3__inv_2_740/VDD
+ VSS VSS VSS VSS VSS gf180mcu_as_sc_mcu7t3v3__inv_2_737/VNW VSUBS gf180mcu_as_sc_mcu7t3v3__nand4_2
Xgf180mcu_as_sc_mcu7t3v3__nand4_2_171 gf180mcu_as_sc_mcu7t3v3__inv_2_618/VDD gf180mcu_as_sc_mcu7t3v3__inv_2_719/VDD
+ VSS VSS VSS VSS VSS gf180mcu_as_sc_mcu7t3v3__inv_2_618/VNW VSUBS gf180mcu_as_sc_mcu7t3v3__nand4_2
Xgf180mcu_as_sc_mcu7t3v3__nand4_2_182 VSS VSS VSS VSS VSS VSS gf180mcu_as_sc_mcu7t3v3__nand4_2_182/Y
+ gf180mcu_as_sc_mcu7t3v3__inv_2_645/VNW VSUBS gf180mcu_as_sc_mcu7t3v3__nand4_2
Xgf180mcu_as_sc_mcu7t3v3__nand4_2_160 VSS VSS VSS VSS VSS VSS VSS gf180mcu_as_sc_mcu7t3v3__inv_2_585/VNW
+ VSUBS gf180mcu_as_sc_mcu7t3v3__nand4_2
Xgf180mcu_as_sc_mcu7t3v3__inv_2_113 gf180mcu_as_sc_mcu7t3v3__inv_2_114/VDD VSS VSS
+ VSS gf180mcu_as_sc_mcu7t3v3__inv_2_114/VNW VSUBS gf180mcu_as_sc_mcu7t3v3__inv_2
Xgf180mcu_as_sc_mcu7t3v3__inv_2_168 VSS gf180mcu_as_sc_mcu7t3v3__inv_2_171/VDD gf180mcu_as_sc_mcu7t3v3__inv_2_177/Y
+ VSS gf180mcu_as_sc_mcu7t3v3__inv_2_168/VNW VSUBS gf180mcu_as_sc_mcu7t3v3__inv_2
Xgf180mcu_as_sc_mcu7t3v3__inv_2_102 VSS gf180mcu_as_sc_mcu7t3v3__inv_2_105/VDD gf180mcu_as_sc_mcu7t3v3__inv_2_102/Y
+ VSS gf180mcu_as_sc_mcu7t3v3__inv_2_102/VNW VSUBS gf180mcu_as_sc_mcu7t3v3__inv_2
Xgf180mcu_as_sc_mcu7t3v3__inv_2_157 gf180mcu_as_sc_mcu7t3v3__inv_2_159/VDD gf180mcu_as_sc_mcu7t3v3__inv_2_162/VDD
+ VSS gf180mcu_as_sc_mcu7t3v3__inv_2_177/Y gf180mcu_as_sc_mcu7t3v3__inv_2_159/VNW
+ VSUBS gf180mcu_as_sc_mcu7t3v3__inv_2
Xgf180mcu_as_sc_mcu7t3v3__inv_2_146 VSS VSS gf180mcu_as_sc_mcu7t3v3__inv_2_153/Y gf180mcu_as_sc_mcu7t3v3__inv_2_153/Y
+ gf180mcu_as_sc_mcu7t3v3__inv_2_147/VNW VSUBS gf180mcu_as_sc_mcu7t3v3__inv_2
Xgf180mcu_as_sc_mcu7t3v3__inv_2_135 gf180mcu_as_sc_mcu7t3v3__inv_2_135/VDD VSS gf180mcu_as_sc_mcu7t3v3__inv_2_923/Y
+ VSS gf180mcu_as_sc_mcu7t3v3__inv_2_135/VNW VSUBS gf180mcu_as_sc_mcu7t3v3__inv_2
Xgf180mcu_as_sc_mcu7t3v3__inv_2_124 gf180mcu_as_sc_mcu7t3v3__inv_2_923/VSS VSS VSS
+ gf180mcu_as_sc_mcu7t3v3__inv_2_923/Y gf180mcu_as_sc_mcu7t3v3__inv_2_126/VNW VSUBS
+ gf180mcu_as_sc_mcu7t3v3__inv_2
Xgf180mcu_as_sc_mcu7t3v3__inv_2_179 gf180mcu_as_sc_mcu7t3v3__inv_2_63/VSS VSS gf180mcu_as_sc_mcu7t3v3__inv_2_179/Y
+ VSS gf180mcu_as_sc_mcu7t3v3__inv_2_179/VNW VSUBS gf180mcu_as_sc_mcu7t3v3__inv_2
Xu_t008_010 u_t008_010/c0_w0_bl u_t008_010/c0_w0_br u_t008_010/c0_w1_bl u_t008_010/c0_w1_br
+ u_t008_010/c0_r0_rbl u_t008_010/c0_r1_rbl u_t008_010/c1_w0_bl u_t008_010/c1_w0_br
+ u_t008_010/c1_w1_bl u_t008_010/c1_w1_br u_t008_010/c1_r0_rbl u_t008_010/c1_r1_rbl
+ u_t008_010/c2_w0_bl u_t008_010/c2_w0_br u_t008_010/c2_w1_bl u_t008_010/c2_w1_br
+ u_t008_010/c2_r0_rbl u_t008_010/c2_r1_rbl u_t008_010/c3_w0_bl u_t008_010/c3_w0_br
+ u_t008_010/c3_w1_bl u_t008_010/c3_w1_br u_t008_010/c3_r0_rbl u_t008_010/c3_r1_rbl
+ u_t008_010/r0_w0_wl u_t008_010/r0_w1_wl u_t008_010/r0_r0_rwl u_t008_010/r0_r1_rwl
+ u_t008_010/r1_w0_wl u_t008_010/r1_w1_wl u_t008_010/r1_r0_rwl u_t008_010/r1_r1_rwl
+ u_t008_010/r2_w0_wl u_t008_010/r2_w1_wl u_t008_010/r2_r0_rwl u_t008_010/r2_r1_rwl
+ u_t008_010/r3_w0_wl u_t008_010/r3_w1_wl u_t008_010/r3_r0_rwl u_t008_010/r3_r1_rwl
+ VSS u_t008_015/VSS VSUBS detronyx_12t_2w2r_rc4_4x4_routed_5layer_direct
Xgf180mcu_as_sc_mcu7t3v3__inv_2_691 gf180mcu_as_sc_mcu7t3v3__inv_2_713/VDD gf180mcu_as_sc_mcu7t3v3__inv_2_713/VSS
+ VSS VSS gf180mcu_as_sc_mcu7t3v3__inv_2_713/VNW VSUBS gf180mcu_as_sc_mcu7t3v3__inv_2
Xgf180mcu_as_sc_mcu7t3v3__inv_2_680 gf180mcu_as_sc_mcu7t3v3__nor2_2_8/VDD gf180mcu_as_sc_mcu7t3v3__inv_2_710/VSS
+ VSS VSS gf180mcu_as_sc_mcu7t3v3__nor2_2_8/VNW VSUBS gf180mcu_as_sc_mcu7t3v3__inv_2
Xu_t014_013 u_t014_013/c0_w0_bl u_t014_013/c0_w0_br u_t014_013/c0_w1_bl u_t014_013/c0_w1_br
+ u_t014_013/c0_r0_rbl u_t014_013/c0_r1_rbl u_t014_013/c1_w0_bl u_t014_013/c1_w0_br
+ u_t014_013/c1_w1_bl u_t014_013/c1_w1_br u_t014_013/c1_r0_rbl u_t014_013/c1_r1_rbl
+ u_t014_013/c2_w0_bl u_t014_013/c2_w0_br u_t014_013/c2_w1_bl u_t014_013/c2_w1_br
+ u_t014_013/c2_r0_rbl u_t014_013/c2_r1_rbl u_t014_013/c3_w0_bl u_t014_013/c3_w0_br
+ u_t014_013/c3_w1_bl u_t014_013/c3_w1_br u_t014_013/c3_r0_rbl u_t014_013/c3_r1_rbl
+ u_t014_013/r0_w0_wl u_t014_013/r0_w1_wl u_t014_013/r0_r0_rwl u_t014_013/r0_r1_rwl
+ u_t014_013/r1_w0_wl u_t014_013/r1_w1_wl u_t014_013/r1_r0_rwl u_t014_013/r1_r1_rwl
+ u_t014_013/r2_w0_wl u_t014_013/r2_w1_wl u_t014_013/r2_r0_rwl u_t014_013/r2_r1_rwl
+ u_t014_013/r3_w0_wl u_t014_013/r3_w1_wl u_t014_013/r3_r0_rwl u_t014_013/r3_r1_rwl
+ u_t014_013/VDD u_t014_013/VSS VSUBS detronyx_12t_2w2r_rc4_4x4_routed_5layer_direct
Xgf180mcu_as_sc_mcu7t3v3__nand2_2_14 gf180mcu_as_sc_mcu7t3v3__nor2_2_5/VDD gf180mcu_as_sc_mcu7t3v3__nor2_2_5/VSS
+ VSS VSS VSS gf180mcu_as_sc_mcu7t3v3__nor2_2_5/VNW VSUBS gf180mcu_as_sc_mcu7t3v3__nand2_2
Xgf180mcu_as_sc_mcu7t3v3__nand2_2_25 gf180mcu_as_sc_mcu7t3v3__nor2_2_5/VDD gf180mcu_as_sc_mcu7t3v3__nor2_2_5/VSS
+ VSS VSS VSS gf180mcu_as_sc_mcu7t3v3__nor2_2_5/VNW VSUBS gf180mcu_as_sc_mcu7t3v3__nand2_2
Xgf180mcu_as_sc_mcu7t3v3__nand2_2_36 gf180mcu_as_sc_mcu7t3v3__nor2_2_4/VDD gf180mcu_as_sc_mcu7t3v3__nor2_2_4/VSS
+ VSS VSS VSS gf180mcu_as_sc_mcu7t3v3__nor2_2_4/VNW VSUBS gf180mcu_as_sc_mcu7t3v3__nand2_2
Xgf180mcu_as_sc_mcu7t3v3__nand2_2_47 gf180mcu_as_sc_mcu7t3v3__inv_2_713/VDD gf180mcu_as_sc_mcu7t3v3__nor2_2_8/VSS
+ VSS VSS VSS gf180mcu_as_sc_mcu7t3v3__inv_2_713/VNW VSUBS gf180mcu_as_sc_mcu7t3v3__nand2_2
Xgf180mcu_as_sc_mcu7t3v3__nand2_2_58 gf180mcu_as_sc_mcu7t3v3__nor2_2_8/VDD gf180mcu_as_sc_mcu7t3v3__nor2_2_8/VSS
+ VSS VSS VSS gf180mcu_as_sc_mcu7t3v3__nor2_2_8/VNW VSUBS gf180mcu_as_sc_mcu7t3v3__nand2_2
Xu_t014_002 u_t014_002/c0_w0_bl u_t014_002/c0_w0_br u_t014_002/c0_w1_bl u_t014_002/c0_w1_br
+ u_t014_002/c0_r0_rbl u_t014_002/c0_r1_rbl u_t014_002/c1_w0_bl u_t014_002/c1_w0_br
+ u_t014_002/c1_w1_bl u_t014_002/c1_w1_br u_t014_002/c1_r0_rbl u_t014_002/c1_r1_rbl
+ u_t014_002/c2_w0_bl u_t014_002/c2_w0_br u_t014_002/c2_w1_bl u_t014_002/c2_w1_br
+ u_t014_002/c2_r0_rbl u_t014_002/c2_r1_rbl u_t014_002/c3_w0_bl u_t014_002/c3_w0_br
+ u_t014_002/c3_w1_bl u_t014_002/c3_w1_br u_t014_002/c3_r0_rbl u_t014_002/c3_r1_rbl
+ u_t014_002/r0_w0_wl u_t014_002/r0_w1_wl u_t014_002/r0_r0_rwl u_t014_002/r0_r1_rwl
+ u_t014_002/r1_w0_wl u_t014_002/r1_w1_wl u_t014_002/r1_r0_rwl u_t014_002/r1_r1_rwl
+ u_t014_002/r2_w0_wl u_t014_002/r2_w1_wl u_t014_002/r2_r0_rwl u_t014_002/r2_r1_rwl
+ u_t014_002/r3_w0_wl u_t014_002/r3_w1_wl u_t014_002/r3_r0_rwl u_t014_002/r3_r1_rwl
+ VSS u_t014_002/VSS VSUBS detronyx_12t_2w2r_rc4_4x4_routed_5layer_direct
Xu_t005_002 u_t005_002/c0_w0_bl u_t005_002/c0_w0_br u_t005_002/c0_w1_bl u_t005_002/c0_w1_br
+ u_t005_002/c0_r0_rbl u_t005_002/c0_r1_rbl u_t005_002/c1_w0_bl u_t005_002/c1_w0_br
+ u_t005_002/c1_w1_bl u_t005_002/c1_w1_br u_t005_002/c1_r0_rbl u_t005_002/c1_r1_rbl
+ u_t005_002/c2_w0_bl u_t005_002/c2_w0_br u_t005_002/c2_w1_bl u_t005_002/c2_w1_br
+ u_t005_002/c2_r0_rbl u_t005_002/c2_r1_rbl u_t005_002/c3_w0_bl u_t005_002/c3_w0_br
+ u_t005_002/c3_w1_bl u_t005_002/c3_w1_br u_t005_002/c3_r0_rbl u_t005_002/c3_r1_rbl
+ u_t005_002/r0_w0_wl u_t005_002/r0_w1_wl u_t005_002/r0_r0_rwl u_t005_002/r0_r1_rwl
+ u_t005_002/r1_w0_wl u_t005_002/r1_w1_wl u_t005_002/r1_r0_rwl u_t005_002/r1_r1_rwl
+ u_t005_002/r2_w0_wl u_t005_002/r2_w1_wl u_t005_002/r2_r0_rwl u_t005_002/r2_r1_rwl
+ u_t005_002/r3_w0_wl u_t005_002/r3_w1_wl u_t005_002/r3_r0_rwl u_t005_002/r3_r1_rwl
+ VSS u_t005_015/VSS VSUBS detronyx_12t_2w2r_rc4_4x4_routed_5layer_direct
Xu_t005_013 u_t005_013/c0_w0_bl u_t005_013/c0_w0_br u_t005_013/c0_w1_bl u_t005_013/c0_w1_br
+ u_t005_013/c0_r0_rbl u_t005_013/c0_r1_rbl u_t005_013/c1_w0_bl u_t005_013/c1_w0_br
+ u_t005_013/c1_w1_bl u_t005_013/c1_w1_br u_t005_013/c1_r0_rbl u_t005_013/c1_r1_rbl
+ u_t005_013/c2_w0_bl u_t005_013/c2_w0_br u_t005_013/c2_w1_bl u_t005_013/c2_w1_br
+ u_t005_013/c2_r0_rbl u_t005_013/c2_r1_rbl u_t005_013/c3_w0_bl u_t005_013/c3_w0_br
+ u_t005_013/c3_w1_bl u_t005_013/c3_w1_br u_t005_013/c3_r0_rbl u_t005_013/c3_r1_rbl
+ u_t005_013/r0_w0_wl u_t005_013/r0_w1_wl u_t005_013/r0_r0_rwl u_t005_013/r0_r1_rwl
+ u_t005_013/r1_w0_wl u_t005_013/r1_w1_wl u_t005_013/r1_r0_rwl u_t005_013/r1_r1_rwl
+ u_t005_013/r2_w0_wl u_t005_013/r2_w1_wl u_t005_013/r2_r0_rwl u_t005_013/r2_r1_rwl
+ u_t005_013/r3_w0_wl u_t005_013/r3_w1_wl u_t005_013/r3_r0_rwl u_t005_013/r3_r1_rwl
+ u_t005_013/VDD u_t005_015/VSS VSUBS detronyx_12t_2w2r_rc4_4x4_routed_5layer_direct
Xu_t011_005 u_t011_005/c0_w0_bl u_t011_005/c0_w0_br u_t011_005/c0_w1_bl u_t011_005/c0_w1_br
+ u_t011_005/c0_r0_rbl u_t011_005/c0_r1_rbl u_t011_005/c1_w0_bl u_t011_005/c1_w0_br
+ u_t011_005/c1_w1_bl u_t011_005/c1_w1_br u_t011_005/c1_r0_rbl u_t011_005/c1_r1_rbl
+ u_t011_005/c2_w0_bl u_t011_005/c2_w0_br u_t011_005/c2_w1_bl u_t011_005/c2_w1_br
+ u_t011_005/c2_r0_rbl u_t011_005/c2_r1_rbl u_t011_005/c3_w0_bl u_t011_005/c3_w0_br
+ u_t011_005/c3_w1_bl u_t011_005/c3_w1_br u_t011_005/c3_r0_rbl u_t011_005/c3_r1_rbl
+ u_t011_005/r0_w0_wl u_t011_005/r0_w1_wl u_t011_005/r0_r0_rwl u_t011_005/r0_r1_rwl
+ u_t011_005/r1_w0_wl u_t011_005/r1_w1_wl u_t011_005/r1_r0_rwl u_t011_005/r1_r1_rwl
+ u_t011_005/r2_w0_wl u_t011_005/r2_w1_wl u_t011_005/r2_r0_rwl u_t011_005/r2_r1_rwl
+ u_t011_005/r3_w0_wl u_t011_005/r3_w1_wl u_t011_005/r3_r0_rwl u_t011_005/r3_r1_rwl
+ u_t011_005/VDD u_t011_005/VSS VSUBS detronyx_12t_2w2r_rc4_4x4_routed_5layer_direct
Xu_t002_005 u_t002_005/c0_w0_bl u_t002_005/c0_w0_br u_t002_005/c0_w1_bl u_t002_005/c0_w1_br
+ u_t002_005/c0_r0_rbl u_t002_005/c0_r1_rbl u_t002_005/c1_w0_bl u_t002_005/c1_w0_br
+ u_t002_005/c1_w1_bl u_t002_005/c1_w1_br u_t002_005/c1_r0_rbl u_t002_005/c1_r1_rbl
+ u_t002_005/c2_w0_bl u_t002_005/c2_w0_br u_t002_005/c2_w1_bl u_t002_005/c2_w1_br
+ u_t002_005/c2_r0_rbl u_t002_005/c2_r1_rbl u_t002_005/c3_w0_bl u_t002_005/c3_w0_br
+ u_t002_005/c3_w1_bl u_t002_005/c3_w1_br u_t002_005/c3_r0_rbl u_t002_005/c3_r1_rbl
+ u_t002_005/r0_w0_wl u_t002_005/r0_w1_wl u_t002_005/r0_r0_rwl u_t002_005/r0_r1_rwl
+ u_t002_005/r1_w0_wl u_t002_005/r1_w1_wl u_t002_005/r1_r0_rwl u_t002_005/r1_r1_rwl
+ u_t002_005/r2_w0_wl u_t002_005/r2_w1_wl u_t002_005/r2_r0_rwl u_t002_005/r2_r1_rwl
+ u_t002_005/r3_w0_wl u_t002_005/r3_w1_wl u_t002_005/r3_r0_rwl u_t002_005/r3_r1_rwl
+ u_t002_005/VDD u_t002_005/VSS VSUBS detronyx_12t_2w2r_rc4_4x4_routed_5layer_direct
Xgf180mcu_as_sc_mcu7t3v3__inv_2_11 gf180mcu_as_sc_mcu7t3v3__inv_2_15/VDD gf180mcu_as_sc_mcu7t3v3__inv_2_15/VDD
+ gf180mcu_as_sc_mcu7t3v3__inv_2_18/Y gf180mcu_as_sc_mcu7t3v3__inv_2_18/Y gf180mcu_as_sc_mcu7t3v3__inv_2_12/VNW
+ VSUBS gf180mcu_as_sc_mcu7t3v3__inv_2
Xgf180mcu_as_sc_mcu7t3v3__inv_2_55 gf180mcu_as_sc_mcu7t3v3__inv_2_56/VDD VSS gf180mcu_as_sc_mcu7t3v3__inv_2_55/Y
+ VSS gf180mcu_as_sc_mcu7t3v3__inv_2_56/VNW VSUBS gf180mcu_as_sc_mcu7t3v3__inv_2
Xgf180mcu_as_sc_mcu7t3v3__inv_2_22 VSS gf180mcu_as_sc_mcu7t3v3__inv_2_27/VDD VSS gf180mcu_as_sc_mcu7t3v3__inv_2_27/Y
+ gf180mcu_as_sc_mcu7t3v3__inv_2_24/VNW VSUBS gf180mcu_as_sc_mcu7t3v3__inv_2
Xgf180mcu_as_sc_mcu7t3v3__inv_2_44 gf180mcu_as_sc_mcu7t3v3__inv_2_45/VDD gf180mcu_as_sc_mcu7t3v3__inv_2_47/VDD
+ gf180mcu_as_sc_mcu7t3v3__inv_2_44/Y VSS gf180mcu_as_sc_mcu7t3v3__inv_2_45/VNW VSUBS
+ gf180mcu_as_sc_mcu7t3v3__inv_2
Xgf180mcu_as_sc_mcu7t3v3__inv_2_33 gf180mcu_as_sc_mcu7t3v3__inv_2_47/VSS VSS VSS VSS
+ gf180mcu_as_sc_mcu7t3v3__inv_2_34/VNW VSUBS gf180mcu_as_sc_mcu7t3v3__inv_2
Xgf180mcu_as_sc_mcu7t3v3__inv_2_99 VSS VSS gf180mcu_as_sc_mcu7t3v3__inv_2_99/Y VSS
+ gf180mcu_as_sc_mcu7t3v3__inv_2_99/VNW VSUBS gf180mcu_as_sc_mcu7t3v3__inv_2
Xgf180mcu_as_sc_mcu7t3v3__inv_2_88 VSS gf180mcu_as_sc_mcu7t3v3__inv_2_93/VDD gf180mcu_as_sc_mcu7t3v3__inv_2_88/Y
+ VSS gf180mcu_as_sc_mcu7t3v3__inv_2_90/VNW VSUBS gf180mcu_as_sc_mcu7t3v3__inv_2
Xgf180mcu_as_sc_mcu7t3v3__inv_2_77 VSS gf180mcu_as_sc_mcu7t3v3__inv_2_81/VDD VSS VSS
+ gf180mcu_as_sc_mcu7t3v3__inv_2_78/VNW VSUBS gf180mcu_as_sc_mcu7t3v3__inv_2
Xgf180mcu_as_sc_mcu7t3v3__inv_2_66 gf180mcu_as_sc_mcu7t3v3__inv_2_66/VDD VSS VSS VSS
+ gf180mcu_as_sc_mcu7t3v3__inv_2_66/VNW VSUBS gf180mcu_as_sc_mcu7t3v3__inv_2
Xgf180mcu_as_sc_mcu7t3v3__inv_2_509 VSS VSS VSS VSS gf180mcu_as_sc_mcu7t3v3__inv_2_510/VNW
+ VSUBS gf180mcu_as_sc_mcu7t3v3__inv_2
Xgf180mcu_as_sc_mcu7t3v3__nand3_2_3 gf180mcu_as_sc_mcu7t3v3__nor2_2_5/VDD gf180mcu_as_sc_mcu7t3v3__nand3_2_8/VSS
+ VSS VSS VSS VSS gf180mcu_as_sc_mcu7t3v3__nor2_2_5/VNW VSUBS gf180mcu_as_sc_mcu7t3v3__nand3_2
Xgf180mcu_as_sc_mcu7t3v3__inv_2_328 VSS VSS gf180mcu_as_sc_mcu7t3v3__inv_2_328/Y gf180mcu_as_sc_mcu7t3v3__inv_2_336/A
+ gf180mcu_as_sc_mcu7t3v3__inv_2_330/VNW VSUBS gf180mcu_as_sc_mcu7t3v3__inv_2
Xgf180mcu_as_sc_mcu7t3v3__inv_2_306 VSS VSS gf180mcu_as_sc_mcu7t3v3__inv_2_306/Y VSS
+ gf180mcu_as_sc_mcu7t3v3__inv_2_306/VNW VSUBS gf180mcu_as_sc_mcu7t3v3__inv_2
Xgf180mcu_as_sc_mcu7t3v3__inv_2_339 VSS VSS gf180mcu_as_sc_mcu7t3v3__inv_2_339/Y VSS
+ gf180mcu_as_sc_mcu7t3v3__inv_2_339/VNW VSUBS gf180mcu_as_sc_mcu7t3v3__inv_2
Xgf180mcu_as_sc_mcu7t3v3__inv_2_317 VSS VSS VSS VSS gf180mcu_as_sc_mcu7t3v3__inv_2_318/VNW
+ VSUBS gf180mcu_as_sc_mcu7t3v3__inv_2
Xgf180mcu_as_sc_mcu7t3v3__inv_2_862 gf180mcu_as_sc_mcu7t3v3__inv_2_863/VDD gf180mcu_as_sc_mcu7t3v3__inv_2_866/VDD
+ VSS VSS gf180mcu_as_sc_mcu7t3v3__inv_2_863/VNW VSUBS gf180mcu_as_sc_mcu7t3v3__inv_2
Xgf180mcu_as_sc_mcu7t3v3__inv_2_895 gf180mcu_as_sc_mcu7t3v3__inv_2_896/VDD gf180mcu_as_sc_mcu7t3v3__inv_2_899/VDD
+ gf180mcu_as_sc_mcu7t3v3__inv_2_895/Y gf180mcu_as_sc_mcu7t3v3__inv_2_908/Y gf180mcu_as_sc_mcu7t3v3__inv_2_896/VNW
+ VSUBS gf180mcu_as_sc_mcu7t3v3__inv_2
Xgf180mcu_as_sc_mcu7t3v3__inv_2_851 gf180mcu_as_sc_mcu7t3v3__inv_2_854/VDD gf180mcu_as_sc_mcu7t3v3__inv_2_854/VDD
+ VSS VSS gf180mcu_as_sc_mcu7t3v3__inv_2_851/VNW VSUBS gf180mcu_as_sc_mcu7t3v3__inv_2
Xgf180mcu_as_sc_mcu7t3v3__inv_2_884 gf180mcu_as_sc_mcu7t3v3__inv_2_884/VDD gf180mcu_as_sc_mcu7t3v3__inv_2_887/VDD
+ gf180mcu_as_sc_mcu7t3v3__inv_2_887/Y VSS gf180mcu_as_sc_mcu7t3v3__inv_2_884/VNW
+ VSUBS gf180mcu_as_sc_mcu7t3v3__inv_2
Xgf180mcu_as_sc_mcu7t3v3__inv_2_840 gf180mcu_as_sc_mcu7t3v3__inv_2_845/VDD gf180mcu_as_sc_mcu7t3v3__inv_2_845/VDD
+ gf180mcu_as_sc_mcu7t3v3__inv_2_840/Y VSS gf180mcu_as_sc_mcu7t3v3__inv_2_842/VNW
+ VSUBS gf180mcu_as_sc_mcu7t3v3__inv_2
Xgf180mcu_as_sc_mcu7t3v3__inv_2_873 gf180mcu_as_sc_mcu7t3v3__inv_2_875/VDD gf180mcu_as_sc_mcu7t3v3__inv_2_878/VDD
+ VSS gf180mcu_as_sc_mcu7t3v3__inv_2_878/Y gf180mcu_as_sc_mcu7t3v3__inv_2_875/VNW
+ VSUBS gf180mcu_as_sc_mcu7t3v3__inv_2
Xgf180mcu_as_sc_mcu7t3v3__nand4_2_150 gf180mcu_as_sc_mcu7t3v3__inv_2_552/VDD gf180mcu_as_sc_mcu7t3v3__inv_2_555/VDD
+ VSS VSS VSS VSS VSS gf180mcu_as_sc_mcu7t3v3__inv_2_552/VNW VSUBS gf180mcu_as_sc_mcu7t3v3__nand4_2
Xgf180mcu_as_sc_mcu7t3v3__nand4_2_194 gf180mcu_as_sc_mcu7t3v3__inv_2_740/VDD gf180mcu_as_sc_mcu7t3v3__inv_2_743/VDD
+ VSS VSS VSS VSS VSS gf180mcu_as_sc_mcu7t3v3__inv_2_740/VNW VSUBS gf180mcu_as_sc_mcu7t3v3__nand4_2
Xgf180mcu_as_sc_mcu7t3v3__nand4_2_172 VSS VSS VSS VSS VSS VSS VSS gf180mcu_as_sc_mcu7t3v3__inv_2_630/VNW
+ VSUBS gf180mcu_as_sc_mcu7t3v3__nand4_2
Xgf180mcu_as_sc_mcu7t3v3__nand4_2_183 VSS VSS VSS VSS VSS VSS VSS gf180mcu_as_sc_mcu7t3v3__inv_2_625/VNW
+ VSUBS gf180mcu_as_sc_mcu7t3v3__nand4_2
Xgf180mcu_as_sc_mcu7t3v3__nand4_2_161 VSS VSS VSS VSS VSS VSS VSS gf180mcu_as_sc_mcu7t3v3__inv_2_588/VNW
+ VSUBS gf180mcu_as_sc_mcu7t3v3__nand4_2
Xgf180mcu_as_sc_mcu7t3v3__inv_2_114 gf180mcu_as_sc_mcu7t3v3__inv_2_114/VDD VSS VSS
+ VSS gf180mcu_as_sc_mcu7t3v3__inv_2_114/VNW VSUBS gf180mcu_as_sc_mcu7t3v3__inv_2
Xgf180mcu_as_sc_mcu7t3v3__inv_2_169 gf180mcu_as_sc_mcu7t3v3__inv_2_171/VDD gf180mcu_as_sc_mcu7t3v3__inv_2_173/VDD
+ VSS gf180mcu_as_sc_mcu7t3v3__inv_2_177/Y gf180mcu_as_sc_mcu7t3v3__inv_2_171/VNW
+ VSUBS gf180mcu_as_sc_mcu7t3v3__inv_2
Xgf180mcu_as_sc_mcu7t3v3__inv_2_103 gf180mcu_as_sc_mcu7t3v3__inv_2_105/VDD VSS VSS
+ VSS gf180mcu_as_sc_mcu7t3v3__inv_2_105/VNW VSUBS gf180mcu_as_sc_mcu7t3v3__inv_2
Xgf180mcu_as_sc_mcu7t3v3__inv_2_158 gf180mcu_as_sc_mcu7t3v3__inv_2_159/VDD gf180mcu_as_sc_mcu7t3v3__inv_2_162/VDD
+ gf180mcu_as_sc_mcu7t3v3__inv_2_158/Y gf180mcu_as_sc_mcu7t3v3__inv_2_177/Y gf180mcu_as_sc_mcu7t3v3__inv_2_159/VNW
+ VSUBS gf180mcu_as_sc_mcu7t3v3__inv_2
Xgf180mcu_as_sc_mcu7t3v3__inv_2_147 VSS VSS gf180mcu_as_sc_mcu7t3v3__inv_2_153/Y VSS
+ gf180mcu_as_sc_mcu7t3v3__inv_2_147/VNW VSUBS gf180mcu_as_sc_mcu7t3v3__inv_2
Xgf180mcu_as_sc_mcu7t3v3__inv_2_136 VSS gf180mcu_as_sc_mcu7t3v3__inv_2_141/VDD VSS
+ gf180mcu_as_sc_mcu7t3v3__inv_2_923/Y gf180mcu_as_sc_mcu7t3v3__inv_2_138/VNW VSUBS
+ gf180mcu_as_sc_mcu7t3v3__inv_2
Xgf180mcu_as_sc_mcu7t3v3__inv_2_125 gf180mcu_as_sc_mcu7t3v3__inv_2_923/VSS VSS gf180mcu_as_sc_mcu7t3v3__inv_2_923/Y
+ gf180mcu_as_sc_mcu7t3v3__inv_2_923/Y gf180mcu_as_sc_mcu7t3v3__inv_2_126/VNW VSUBS
+ gf180mcu_as_sc_mcu7t3v3__inv_2
Xu_t008_000 u_t008_000/c0_w0_bl u_t008_000/c0_w0_br u_t008_000/c0_w1_bl u_t008_000/c0_w1_br
+ u_t008_000/c0_r0_rbl u_t008_000/c0_r1_rbl u_t008_000/c1_w0_bl u_t008_000/c1_w0_br
+ u_t008_000/c1_w1_bl u_t008_000/c1_w1_br u_t008_000/c1_r0_rbl u_t008_000/c1_r1_rbl
+ u_t008_000/c2_w0_bl u_t008_000/c2_w0_br u_t008_000/c2_w1_bl u_t008_000/c2_w1_br
+ u_t008_000/c2_r0_rbl u_t008_000/c2_r1_rbl u_t008_000/c3_w0_bl u_t008_000/c3_w0_br
+ u_t008_000/c3_w1_bl u_t008_000/c3_w1_br u_t008_000/c3_r0_rbl u_t008_000/c3_r1_rbl
+ u_t008_000/r0_w0_wl u_t008_000/r0_w1_wl u_t008_000/r0_r0_rwl u_t008_000/r0_r1_rwl
+ u_t008_000/r1_w0_wl u_t008_000/r1_w1_wl u_t008_000/r1_r0_rwl u_t008_000/r1_r1_rwl
+ u_t008_000/r2_w0_wl u_t008_000/r2_w1_wl u_t008_000/r2_r0_rwl u_t008_000/r2_r1_rwl
+ u_t008_000/r3_w0_wl u_t008_000/r3_w1_wl u_t008_000/r3_r0_rwl u_t008_000/r3_r1_rwl
+ VSS u_t008_015/VSS VSUBS detronyx_12t_2w2r_rc4_4x4_routed_5layer_direct
Xu_t008_011 u_t008_011/c0_w0_bl u_t008_011/c0_w0_br u_t008_011/c0_w1_bl u_t008_011/c0_w1_br
+ u_t008_011/c0_r0_rbl u_t008_011/c0_r1_rbl u_t008_011/c1_w0_bl u_t008_011/c1_w0_br
+ u_t008_011/c1_w1_bl u_t008_011/c1_w1_br u_t008_011/c1_r0_rbl u_t008_011/c1_r1_rbl
+ u_t008_011/c2_w0_bl u_t008_011/c2_w0_br u_t008_011/c2_w1_bl u_t008_011/c2_w1_br
+ u_t008_011/c2_r0_rbl u_t008_011/c2_r1_rbl u_t008_011/c3_w0_bl u_t008_011/c3_w0_br
+ u_t008_011/c3_w1_bl u_t008_011/c3_w1_br u_t008_011/c3_r0_rbl u_t008_011/c3_r1_rbl
+ u_t008_011/r0_w0_wl u_t008_011/r0_w1_wl u_t008_011/r0_r0_rwl u_t008_011/r0_r1_rwl
+ u_t008_011/r1_w0_wl u_t008_011/r1_w1_wl u_t008_011/r1_r0_rwl u_t008_011/r1_r1_rwl
+ u_t008_011/r2_w0_wl u_t008_011/r2_w1_wl u_t008_011/r2_r0_rwl u_t008_011/r2_r1_rwl
+ u_t008_011/r3_w0_wl u_t008_011/r3_w1_wl u_t008_011/r3_r0_rwl u_t008_011/r3_r1_rwl
+ u_t008_011/VDD u_t008_015/VSS VSUBS detronyx_12t_2w2r_rc4_4x4_routed_5layer_direct
Xgf180mcu_as_sc_mcu7t3v3__inv_2_670 gf180mcu_as_sc_mcu7t3v3__inv_2_713/VDD gf180mcu_as_sc_mcu7t3v3__nor2_2_8/VSS
+ gf180mcu_as_sc_mcu7t3v3__inv_2_670/Y VSS gf180mcu_as_sc_mcu7t3v3__inv_2_713/VNW
+ VSUBS gf180mcu_as_sc_mcu7t3v3__inv_2
Xgf180mcu_as_sc_mcu7t3v3__inv_2_681 gf180mcu_as_sc_mcu7t3v3__nor2_2_8/VDD gf180mcu_as_sc_mcu7t3v3__nor2_2_8/VSS
+ VSS VSS gf180mcu_as_sc_mcu7t3v3__nor2_2_8/VNW VSUBS gf180mcu_as_sc_mcu7t3v3__inv_2
Xgf180mcu_as_sc_mcu7t3v3__inv_2_692 gf180mcu_as_sc_mcu7t3v3__nor2_2_8/VDD gf180mcu_as_sc_mcu7t3v3__inv_2_710/VSS
+ VSS VSS gf180mcu_as_sc_mcu7t3v3__nor2_2_8/VNW VSUBS gf180mcu_as_sc_mcu7t3v3__inv_2
Xu_t014_014 u_t014_014/c0_w0_bl u_t014_014/c0_w0_br u_t014_014/c0_w1_bl u_t014_014/c0_w1_br
+ u_t014_014/c0_r0_rbl u_t014_014/c0_r1_rbl u_t014_014/c1_w0_bl u_t014_014/c1_w0_br
+ u_t014_014/c1_w1_bl u_t014_014/c1_w1_br u_t014_014/c1_r0_rbl u_t014_014/c1_r1_rbl
+ u_t014_014/c2_w0_bl u_t014_014/c2_w0_br u_t014_014/c2_w1_bl u_t014_014/c2_w1_br
+ u_t014_014/c2_r0_rbl u_t014_014/c2_r1_rbl u_t014_014/c3_w0_bl u_t014_014/c3_w0_br
+ u_t014_014/c3_w1_bl u_t014_014/c3_w1_br u_t014_014/c3_r0_rbl u_t014_014/c3_r1_rbl
+ u_t014_014/r0_w0_wl u_t014_014/r0_w1_wl u_t014_014/r0_r0_rwl u_t014_014/r0_r1_rwl
+ u_t014_014/r1_w0_wl u_t014_014/r1_w1_wl u_t014_014/r1_r0_rwl u_t014_014/r1_r1_rwl
+ u_t014_014/r2_w0_wl u_t014_014/r2_w1_wl u_t014_014/r2_r0_rwl u_t014_014/r2_r1_rwl
+ u_t014_014/r3_w0_wl u_t014_014/r3_w1_wl u_t014_014/r3_r0_rwl u_t014_014/r3_r1_rwl
+ u_t014_014/VDD u_t014_015/VSS VSUBS detronyx_12t_2w2r_rc4_4x4_routed_5layer_direct
Xgf180mcu_as_sc_mcu7t3v3__nand2_2_15 gf180mcu_as_sc_mcu7t3v3__nor2_2_5/VDD gf180mcu_as_sc_mcu7t3v3__nor2_2_5/VSS
+ VSS VSS VSS gf180mcu_as_sc_mcu7t3v3__nor2_2_5/VNW VSUBS gf180mcu_as_sc_mcu7t3v3__nand2_2
Xgf180mcu_as_sc_mcu7t3v3__nand2_2_26 gf180mcu_as_sc_mcu7t3v3__nor2_2_5/VDD gf180mcu_as_sc_mcu7t3v3__nand3_2_8/VSS
+ VSS VSS VSS gf180mcu_as_sc_mcu7t3v3__nor2_2_5/VNW VSUBS gf180mcu_as_sc_mcu7t3v3__nand2_2
Xgf180mcu_as_sc_mcu7t3v3__nand2_2_37 gf180mcu_as_sc_mcu7t3v3__nand2_2_9/VDD gf180mcu_as_sc_mcu7t3v3__nor2_2_4/VSS
+ VSS VSS VSS gf180mcu_as_sc_mcu7t3v3__nand2_2_9/VNW VSUBS gf180mcu_as_sc_mcu7t3v3__nand2_2
Xgf180mcu_as_sc_mcu7t3v3__nand2_2_48 gf180mcu_as_sc_mcu7t3v3__inv_2_713/VDD gf180mcu_as_sc_mcu7t3v3__inv_2_713/VSS
+ VSS VSS VSS gf180mcu_as_sc_mcu7t3v3__inv_2_713/VNW VSUBS gf180mcu_as_sc_mcu7t3v3__nand2_2
Xgf180mcu_as_sc_mcu7t3v3__nand2_2_59 gf180mcu_as_sc_mcu7t3v3__inv_2_713/VDD gf180mcu_as_sc_mcu7t3v3__nor2_2_8/VSS
+ VSS VSS VSS gf180mcu_as_sc_mcu7t3v3__inv_2_713/VNW VSUBS gf180mcu_as_sc_mcu7t3v3__nand2_2
Xu_t014_003 u_t014_003/c0_w0_bl u_t014_003/c0_w0_br u_t014_003/c0_w1_bl u_t014_003/c0_w1_br
+ u_t014_003/c0_r0_rbl u_t014_003/c0_r1_rbl u_t014_003/c1_w0_bl u_t014_003/c1_w0_br
+ u_t014_003/c1_w1_bl u_t014_003/c1_w1_br u_t014_003/c1_r0_rbl u_t014_003/c1_r1_rbl
+ u_t014_003/c2_w0_bl u_t014_003/c2_w0_br u_t014_003/c2_w1_bl u_t014_003/c2_w1_br
+ u_t014_003/c2_r0_rbl u_t014_003/c2_r1_rbl u_t014_003/c3_w0_bl u_t014_003/c3_w0_br
+ u_t014_003/c3_w1_bl u_t014_003/c3_w1_br u_t014_003/c3_r0_rbl u_t014_003/c3_r1_rbl
+ u_t014_003/r0_w0_wl u_t014_003/r0_w1_wl u_t014_003/r0_r0_rwl u_t014_003/r0_r1_rwl
+ u_t014_003/r1_w0_wl u_t014_003/r1_w1_wl u_t014_003/r1_r0_rwl u_t014_003/r1_r1_rwl
+ u_t014_003/r2_w0_wl u_t014_003/r2_w1_wl u_t014_003/r2_r0_rwl u_t014_003/r2_r1_rwl
+ u_t014_003/r3_w0_wl u_t014_003/r3_w1_wl u_t014_003/r3_r0_rwl u_t014_003/r3_r1_rwl
+ u_t014_003/VDD u_t014_003/VSS VSUBS detronyx_12t_2w2r_rc4_4x4_routed_5layer_direct
Xu_t005_003 u_t005_003/c0_w0_bl u_t005_003/c0_w0_br u_t005_003/c0_w1_bl u_t005_003/c0_w1_br
+ u_t005_003/c0_r0_rbl u_t005_003/c0_r1_rbl u_t005_003/c1_w0_bl u_t005_003/c1_w0_br
+ u_t005_003/c1_w1_bl u_t005_003/c1_w1_br u_t005_003/c1_r0_rbl u_t005_003/c1_r1_rbl
+ u_t005_003/c2_w0_bl u_t005_003/c2_w0_br u_t005_003/c2_w1_bl u_t005_003/c2_w1_br
+ u_t005_003/c2_r0_rbl u_t005_003/c2_r1_rbl u_t005_003/c3_w0_bl u_t005_003/c3_w0_br
+ u_t005_003/c3_w1_bl u_t005_003/c3_w1_br u_t005_003/c3_r0_rbl u_t005_003/c3_r1_rbl
+ u_t005_003/r0_w0_wl u_t005_003/r0_w1_wl u_t005_003/r0_r0_rwl u_t005_003/r0_r1_rwl
+ u_t005_003/r1_w0_wl u_t005_003/r1_w1_wl u_t005_003/r1_r0_rwl u_t005_003/r1_r1_rwl
+ u_t005_003/r2_w0_wl u_t005_003/r2_w1_wl u_t005_003/r2_r0_rwl u_t005_003/r2_r1_rwl
+ u_t005_003/r3_w0_wl u_t005_003/r3_w1_wl u_t005_003/r3_r0_rwl u_t005_003/r3_r1_rwl
+ u_t005_003/VDD u_t005_015/VSS VSUBS detronyx_12t_2w2r_rc4_4x4_routed_5layer_direct
Xu_t005_014 u_t005_014/c0_w0_bl u_t005_014/c0_w0_br u_t005_014/c0_w1_bl u_t005_014/c0_w1_br
+ u_t005_014/c0_r0_rbl u_t005_014/c0_r1_rbl u_t005_014/c1_w0_bl u_t005_014/c1_w0_br
+ u_t005_014/c1_w1_bl u_t005_014/c1_w1_br u_t005_014/c1_r0_rbl u_t005_014/c1_r1_rbl
+ u_t005_014/c2_w0_bl u_t005_014/c2_w0_br u_t005_014/c2_w1_bl u_t005_014/c2_w1_br
+ u_t005_014/c2_r0_rbl u_t005_014/c2_r1_rbl u_t005_014/c3_w0_bl u_t005_014/c3_w0_br
+ u_t005_014/c3_w1_bl u_t005_014/c3_w1_br u_t005_014/c3_r0_rbl u_t005_014/c3_r1_rbl
+ u_t005_014/r0_w0_wl u_t005_014/r0_w1_wl u_t005_014/r0_r0_rwl u_t005_014/r0_r1_rwl
+ u_t005_014/r1_w0_wl u_t005_014/r1_w1_wl u_t005_014/r1_r0_rwl u_t005_014/r1_r1_rwl
+ u_t005_014/r2_w0_wl u_t005_014/r2_w1_wl u_t005_014/r2_r0_rwl u_t005_014/r2_r1_rwl
+ u_t005_014/r3_w0_wl u_t005_014/r3_w1_wl u_t005_014/r3_r0_rwl u_t005_014/r3_r1_rwl
+ u_t005_014/VDD u_t005_015/VSS VSUBS detronyx_12t_2w2r_rc4_4x4_routed_5layer_direct
Xu_t011_006 u_t011_006/c0_w0_bl u_t011_006/c0_w0_br u_t011_006/c0_w1_bl u_t011_006/c0_w1_br
+ u_t011_006/c0_r0_rbl u_t011_006/c0_r1_rbl u_t011_006/c1_w0_bl u_t011_006/c1_w0_br
+ u_t011_006/c1_w1_bl u_t011_006/c1_w1_br u_t011_006/c1_r0_rbl u_t011_006/c1_r1_rbl
+ u_t011_006/c2_w0_bl u_t011_006/c2_w0_br u_t011_006/c2_w1_bl u_t011_006/c2_w1_br
+ u_t011_006/c2_r0_rbl u_t011_006/c2_r1_rbl u_t011_006/c3_w0_bl u_t011_006/c3_w0_br
+ u_t011_006/c3_w1_bl u_t011_006/c3_w1_br u_t011_006/c3_r0_rbl u_t011_006/c3_r1_rbl
+ u_t011_006/r0_w0_wl u_t011_006/r0_w1_wl u_t011_006/r0_r0_rwl u_t011_006/r0_r1_rwl
+ u_t011_006/r1_w0_wl u_t011_006/r1_w1_wl u_t011_006/r1_r0_rwl u_t011_006/r1_r1_rwl
+ u_t011_006/r2_w0_wl u_t011_006/r2_w1_wl u_t011_006/r2_r0_rwl u_t011_006/r2_r1_rwl
+ u_t011_006/r3_w0_wl u_t011_006/r3_w1_wl u_t011_006/r3_r0_rwl u_t011_006/r3_r1_rwl
+ u_t011_006/VDD u_t011_009/VSS VSUBS detronyx_12t_2w2r_rc4_4x4_routed_5layer_direct
Xu_t002_006 u_t002_006/c0_w0_bl u_t002_006/c0_w0_br u_t002_006/c0_w1_bl u_t002_006/c0_w1_br
+ u_t002_006/c0_r0_rbl u_t002_006/c0_r1_rbl u_t002_006/c1_w0_bl u_t002_006/c1_w0_br
+ u_t002_006/c1_w1_bl u_t002_006/c1_w1_br u_t002_006/c1_r0_rbl u_t002_006/c1_r1_rbl
+ u_t002_006/c2_w0_bl u_t002_006/c2_w0_br u_t002_006/c2_w1_bl u_t002_006/c2_w1_br
+ u_t002_006/c2_r0_rbl u_t002_006/c2_r1_rbl u_t002_006/c3_w0_bl u_t002_006/c3_w0_br
+ u_t002_006/c3_w1_bl u_t002_006/c3_w1_br u_t002_006/c3_r0_rbl u_t002_006/c3_r1_rbl
+ u_t002_006/r0_w0_wl u_t002_006/r0_w1_wl u_t002_006/r0_r0_rwl u_t002_006/r0_r1_rwl
+ u_t002_006/r1_w0_wl u_t002_006/r1_w1_wl u_t002_006/r1_r0_rwl u_t002_006/r1_r1_rwl
+ u_t002_006/r2_w0_wl u_t002_006/r2_w1_wl u_t002_006/r2_r0_rwl u_t002_006/r2_r1_rwl
+ u_t002_006/r3_w0_wl u_t002_006/r3_w1_wl u_t002_006/r3_r0_rwl u_t002_006/r3_r1_rwl
+ u_t002_006/VDD u_t002_009/VSS VSUBS detronyx_12t_2w2r_rc4_4x4_routed_5layer_direct
Xgf180mcu_as_sc_mcu7t3v3__inv_2_12 gf180mcu_as_sc_mcu7t3v3__inv_2_15/VDD gf180mcu_as_sc_mcu7t3v3__inv_2_15/VDD
+ gf180mcu_as_sc_mcu7t3v3__inv_2_18/Y VSS gf180mcu_as_sc_mcu7t3v3__inv_2_12/VNW VSUBS
+ gf180mcu_as_sc_mcu7t3v3__inv_2
Xgf180mcu_as_sc_mcu7t3v3__inv_2_23 VSS gf180mcu_as_sc_mcu7t3v3__inv_2_27/VDD gf180mcu_as_sc_mcu7t3v3__inv_2_23/Y
+ gf180mcu_as_sc_mcu7t3v3__inv_2_27/Y gf180mcu_as_sc_mcu7t3v3__inv_2_24/VNW VSUBS
+ gf180mcu_as_sc_mcu7t3v3__inv_2
Xgf180mcu_as_sc_mcu7t3v3__inv_2_34 gf180mcu_as_sc_mcu7t3v3__inv_2_47/VSS VSS VSS VSS
+ gf180mcu_as_sc_mcu7t3v3__inv_2_34/VNW VSUBS gf180mcu_as_sc_mcu7t3v3__inv_2
Xgf180mcu_as_sc_mcu7t3v3__inv_2_56 gf180mcu_as_sc_mcu7t3v3__inv_2_56/VDD VSS gf180mcu_as_sc_mcu7t3v3__inv_2_56/Y
+ VSS gf180mcu_as_sc_mcu7t3v3__inv_2_56/VNW VSUBS gf180mcu_as_sc_mcu7t3v3__inv_2
Xgf180mcu_as_sc_mcu7t3v3__inv_2_45 gf180mcu_as_sc_mcu7t3v3__inv_2_45/VDD gf180mcu_as_sc_mcu7t3v3__inv_2_47/VDD
+ gf180mcu_as_sc_mcu7t3v3__inv_2_45/Y VSS gf180mcu_as_sc_mcu7t3v3__inv_2_45/VNW VSUBS
+ gf180mcu_as_sc_mcu7t3v3__inv_2
Xgf180mcu_as_sc_mcu7t3v3__inv_2_89 VSS gf180mcu_as_sc_mcu7t3v3__inv_2_93/VDD gf180mcu_as_sc_mcu7t3v3__inv_2_89/Y
+ VSS gf180mcu_as_sc_mcu7t3v3__inv_2_90/VNW VSUBS gf180mcu_as_sc_mcu7t3v3__inv_2
Xgf180mcu_as_sc_mcu7t3v3__inv_2_78 VSS gf180mcu_as_sc_mcu7t3v3__inv_2_81/VDD VSS VSS
+ gf180mcu_as_sc_mcu7t3v3__inv_2_78/VNW VSUBS gf180mcu_as_sc_mcu7t3v3__inv_2
Xgf180mcu_as_sc_mcu7t3v3__inv_2_67 VSS gf180mcu_as_sc_mcu7t3v3__inv_2_72/VDD gf180mcu_as_sc_mcu7t3v3__inv_2_67/Y
+ VSS gf180mcu_as_sc_mcu7t3v3__inv_2_69/VNW VSUBS gf180mcu_as_sc_mcu7t3v3__inv_2
Xgf180mcu_as_sc_mcu7t3v3__nand3_2_4 gf180mcu_as_sc_mcu7t3v3__nor2_2_4/VDD gf180mcu_as_sc_mcu7t3v3__nand3_2_8/VSS
+ VSS VSS VSS VSS gf180mcu_as_sc_mcu7t3v3__nor2_2_4/VNW VSUBS gf180mcu_as_sc_mcu7t3v3__nand3_2
Xgf180mcu_as_sc_mcu7t3v3__inv_2_329 VSS VSS gf180mcu_as_sc_mcu7t3v3__inv_2_336/A gf180mcu_as_sc_mcu7t3v3__inv_2_330/Y
+ gf180mcu_as_sc_mcu7t3v3__inv_2_330/VNW VSUBS gf180mcu_as_sc_mcu7t3v3__inv_2
Xgf180mcu_as_sc_mcu7t3v3__inv_2_307 VSS VSS VSS VSS gf180mcu_as_sc_mcu7t3v3__inv_2_307/VNW
+ VSUBS gf180mcu_as_sc_mcu7t3v3__inv_2
Xgf180mcu_as_sc_mcu7t3v3__inv_2_318 VSS VSS gf180mcu_as_sc_mcu7t3v3__inv_2_318/Y VSS
+ gf180mcu_as_sc_mcu7t3v3__inv_2_318/VNW VSUBS gf180mcu_as_sc_mcu7t3v3__inv_2
Xgf180mcu_as_sc_mcu7t3v3__inv_2_830 gf180mcu_as_sc_mcu7t3v3__inv_2_830/VSS gf180mcu_as_sc_mcu7t3v3__inv_2_830/VSS
+ VSS VSS gf180mcu_as_sc_mcu7t3v3__inv_2_830/VNW VSUBS gf180mcu_as_sc_mcu7t3v3__inv_2
Xgf180mcu_as_sc_mcu7t3v3__inv_2_863 gf180mcu_as_sc_mcu7t3v3__inv_2_863/VDD gf180mcu_as_sc_mcu7t3v3__inv_2_866/VDD
+ VSS VSS gf180mcu_as_sc_mcu7t3v3__inv_2_863/VNW VSUBS gf180mcu_as_sc_mcu7t3v3__inv_2
Xgf180mcu_as_sc_mcu7t3v3__inv_2_896 gf180mcu_as_sc_mcu7t3v3__inv_2_896/VDD gf180mcu_as_sc_mcu7t3v3__inv_2_899/VDD
+ gf180mcu_as_sc_mcu7t3v3__inv_2_908/Y VSS gf180mcu_as_sc_mcu7t3v3__inv_2_896/VNW
+ VSUBS gf180mcu_as_sc_mcu7t3v3__inv_2
Xgf180mcu_as_sc_mcu7t3v3__inv_2_852 gf180mcu_as_sc_mcu7t3v3__inv_2_854/VDD gf180mcu_as_sc_mcu7t3v3__inv_2_857/VDD
+ gf180mcu_as_sc_mcu7t3v3__inv_2_852/Y VSS gf180mcu_as_sc_mcu7t3v3__inv_2_854/VNW
+ VSUBS gf180mcu_as_sc_mcu7t3v3__inv_2
Xgf180mcu_as_sc_mcu7t3v3__inv_2_885 gf180mcu_as_sc_mcu7t3v3__inv_2_887/VDD gf180mcu_as_sc_mcu7t3v3__inv_2_893/VDD
+ VSS gf180mcu_as_sc_mcu7t3v3__inv_2_887/Y gf180mcu_as_sc_mcu7t3v3__inv_2_887/VNW
+ VSUBS gf180mcu_as_sc_mcu7t3v3__inv_2
Xgf180mcu_as_sc_mcu7t3v3__inv_2_841 gf180mcu_as_sc_mcu7t3v3__inv_2_845/VDD gf180mcu_as_sc_mcu7t3v3__inv_2_845/VDD
+ VSS VSS gf180mcu_as_sc_mcu7t3v3__inv_2_842/VNW VSUBS gf180mcu_as_sc_mcu7t3v3__inv_2
Xgf180mcu_as_sc_mcu7t3v3__inv_2_874 gf180mcu_as_sc_mcu7t3v3__inv_2_875/VDD gf180mcu_as_sc_mcu7t3v3__inv_2_878/VDD
+ gf180mcu_as_sc_mcu7t3v3__inv_2_874/Y gf180mcu_as_sc_mcu7t3v3__inv_2_878/Y gf180mcu_as_sc_mcu7t3v3__inv_2_875/VNW
+ VSUBS gf180mcu_as_sc_mcu7t3v3__inv_2
Xgf180mcu_as_sc_mcu7t3v3__nand4_2_151 gf180mcu_as_sc_mcu7t3v3__inv_2_555/VDD VSS VSS
+ VSS VSS VSS VSS gf180mcu_as_sc_mcu7t3v3__inv_2_555/VNW VSUBS gf180mcu_as_sc_mcu7t3v3__nand4_2
Xgf180mcu_as_sc_mcu7t3v3__nand4_2_140 VSS gf180mcu_as_sc_mcu7t3v3__inv_2_576/VSS VSS
+ VSS VSS VSS VSS gf180mcu_as_sc_mcu7t3v3__inv_2_576/VNW VSUBS gf180mcu_as_sc_mcu7t3v3__nand4_2
Xgf180mcu_as_sc_mcu7t3v3__nand4_2_162 VSS VSS VSS VSS VSS VSS VSS gf180mcu_as_sc_mcu7t3v3__inv_2_591/VNW
+ VSUBS gf180mcu_as_sc_mcu7t3v3__nand4_2
Xgf180mcu_as_sc_mcu7t3v3__nand4_2_90 gf180mcu_as_sc_mcu7t3v3__inv_2_372/VDD gf180mcu_as_sc_mcu7t3v3__inv_2_375/VDD
+ VSS VSS VSS VSS VSS gf180mcu_as_sc_mcu7t3v3__inv_2_372/VNW VSUBS gf180mcu_as_sc_mcu7t3v3__nand4_2
Xgf180mcu_as_sc_mcu7t3v3__nand4_2_195 gf180mcu_as_sc_mcu7t3v3__inv_2_743/VDD gf180mcu_as_sc_mcu7t3v3__inv_2_746/VDD
+ VSS VSS VSS VSS VSS gf180mcu_as_sc_mcu7t3v3__inv_2_743/VNW VSUBS gf180mcu_as_sc_mcu7t3v3__nand4_2
Xgf180mcu_as_sc_mcu7t3v3__nand4_2_173 VSS VSS VSS VSS VSS VSS VSS gf180mcu_as_sc_mcu7t3v3__inv_2_622/VNW
+ VSUBS gf180mcu_as_sc_mcu7t3v3__nand4_2
Xgf180mcu_as_sc_mcu7t3v3__nand4_2_184 VSS VSS VSS VSS VSS VSS VSS gf180mcu_as_sc_mcu7t3v3__inv_2_629/VNW
+ VSUBS gf180mcu_as_sc_mcu7t3v3__nand4_2
Xgf180mcu_as_sc_mcu7t3v3__inv_2_115 VSS gf180mcu_as_sc_mcu7t3v3__inv_2_63/VDD gf180mcu_as_sc_mcu7t3v3__inv_2_115/Y
+ VSS gf180mcu_as_sc_mcu7t3v3__inv_2_60/VNW VSUBS gf180mcu_as_sc_mcu7t3v3__inv_2
Xgf180mcu_as_sc_mcu7t3v3__inv_2_104 gf180mcu_as_sc_mcu7t3v3__inv_2_105/VDD VSS VSS
+ VSS gf180mcu_as_sc_mcu7t3v3__inv_2_105/VNW VSUBS gf180mcu_as_sc_mcu7t3v3__inv_2
Xgf180mcu_as_sc_mcu7t3v3__inv_2_159 gf180mcu_as_sc_mcu7t3v3__inv_2_159/VDD gf180mcu_as_sc_mcu7t3v3__inv_2_162/VDD
+ gf180mcu_as_sc_mcu7t3v3__inv_2_177/Y VSS gf180mcu_as_sc_mcu7t3v3__inv_2_159/VNW
+ VSUBS gf180mcu_as_sc_mcu7t3v3__inv_2
Xgf180mcu_as_sc_mcu7t3v3__inv_2_148 VSS gf180mcu_as_sc_mcu7t3v3__inv_2_153/VDD VSS
+ gf180mcu_as_sc_mcu7t3v3__inv_2_153/Y gf180mcu_as_sc_mcu7t3v3__inv_2_150/VNW VSUBS
+ gf180mcu_as_sc_mcu7t3v3__inv_2
Xgf180mcu_as_sc_mcu7t3v3__inv_2_137 VSS gf180mcu_as_sc_mcu7t3v3__inv_2_141/VDD gf180mcu_as_sc_mcu7t3v3__inv_2_923/Y
+ gf180mcu_as_sc_mcu7t3v3__inv_2_923/Y gf180mcu_as_sc_mcu7t3v3__inv_2_138/VNW VSUBS
+ gf180mcu_as_sc_mcu7t3v3__inv_2
Xgf180mcu_as_sc_mcu7t3v3__inv_2_126 gf180mcu_as_sc_mcu7t3v3__inv_2_923/VSS VSS gf180mcu_as_sc_mcu7t3v3__inv_2_923/Y
+ VSS gf180mcu_as_sc_mcu7t3v3__inv_2_126/VNW VSUBS gf180mcu_as_sc_mcu7t3v3__inv_2
Xu_t008_001 u_t008_001/c0_w0_bl u_t008_001/c0_w0_br u_t008_001/c0_w1_bl u_t008_001/c0_w1_br
+ u_t008_001/c0_r0_rbl u_t008_001/c0_r1_rbl u_t008_001/c1_w0_bl u_t008_001/c1_w0_br
+ u_t008_001/c1_w1_bl u_t008_001/c1_w1_br u_t008_001/c1_r0_rbl u_t008_001/c1_r1_rbl
+ u_t008_001/c2_w0_bl u_t008_001/c2_w0_br u_t008_001/c2_w1_bl u_t008_001/c2_w1_br
+ u_t008_001/c2_r0_rbl u_t008_001/c2_r1_rbl u_t008_001/c3_w0_bl u_t008_001/c3_w0_br
+ u_t008_001/c3_w1_bl u_t008_001/c3_w1_br u_t008_001/c3_r0_rbl u_t008_001/c3_r1_rbl
+ u_t008_001/r0_w0_wl u_t008_001/r0_w1_wl u_t008_001/r0_r0_rwl u_t008_001/r0_r1_rwl
+ u_t008_001/r1_w0_wl u_t008_001/r1_w1_wl u_t008_001/r1_r0_rwl u_t008_001/r1_r1_rwl
+ u_t008_001/r2_w0_wl u_t008_001/r2_w1_wl u_t008_001/r2_r0_rwl u_t008_001/r2_r1_rwl
+ u_t008_001/r3_w0_wl u_t008_001/r3_w1_wl u_t008_001/r3_r0_rwl u_t008_001/r3_r1_rwl
+ VSS u_t008_015/VSS VSUBS detronyx_12t_2w2r_rc4_4x4_routed_5layer_direct
Xu_t008_012 u_t008_012/c0_w0_bl u_t008_012/c0_w0_br u_t008_012/c0_w1_bl u_t008_012/c0_w1_br
+ u_t008_012/c0_r0_rbl u_t008_012/c0_r1_rbl u_t008_012/c1_w0_bl u_t008_012/c1_w0_br
+ u_t008_012/c1_w1_bl u_t008_012/c1_w1_br u_t008_012/c1_r0_rbl u_t008_012/c1_r1_rbl
+ u_t008_012/c2_w0_bl u_t008_012/c2_w0_br u_t008_012/c2_w1_bl u_t008_012/c2_w1_br
+ u_t008_012/c2_r0_rbl u_t008_012/c2_r1_rbl u_t008_012/c3_w0_bl u_t008_012/c3_w0_br
+ u_t008_012/c3_w1_bl u_t008_012/c3_w1_br u_t008_012/c3_r0_rbl u_t008_012/c3_r1_rbl
+ u_t008_012/r0_w0_wl u_t008_012/r0_w1_wl u_t008_012/r0_r0_rwl u_t008_012/r0_r1_rwl
+ u_t008_012/r1_w0_wl u_t008_012/r1_w1_wl u_t008_012/r1_r0_rwl u_t008_012/r1_r1_rwl
+ u_t008_012/r2_w0_wl u_t008_012/r2_w1_wl u_t008_012/r2_r0_rwl u_t008_012/r2_r1_rwl
+ u_t008_012/r3_w0_wl u_t008_012/r3_w1_wl u_t008_012/r3_r0_rwl u_t008_012/r3_r1_rwl
+ u_t008_012/VDD u_t008_015/VSS VSUBS detronyx_12t_2w2r_rc4_4x4_routed_5layer_direct
Xgf180mcu_as_sc_mcu7t3v3__inv_2_671 gf180mcu_as_sc_mcu7t3v3__inv_2_713/VDD gf180mcu_as_sc_mcu7t3v3__inv_2_713/VSS
+ VSS VSS gf180mcu_as_sc_mcu7t3v3__inv_2_713/VNW VSUBS gf180mcu_as_sc_mcu7t3v3__inv_2
Xgf180mcu_as_sc_mcu7t3v3__inv_2_682 gf180mcu_as_sc_mcu7t3v3__inv_2_713/VDD gf180mcu_as_sc_mcu7t3v3__nor2_2_8/VSS
+ VSS VSS gf180mcu_as_sc_mcu7t3v3__inv_2_713/VNW VSUBS gf180mcu_as_sc_mcu7t3v3__inv_2
Xgf180mcu_as_sc_mcu7t3v3__inv_2_693 gf180mcu_as_sc_mcu7t3v3__nor2_2_8/VDD gf180mcu_as_sc_mcu7t3v3__nor2_2_8/VSS
+ VSS VSS gf180mcu_as_sc_mcu7t3v3__nor2_2_8/VNW VSUBS gf180mcu_as_sc_mcu7t3v3__inv_2
Xgf180mcu_as_sc_mcu7t3v3__inv_2_660 gf180mcu_as_sc_mcu7t3v3__nor2_2_8/VDD gf180mcu_as_sc_mcu7t3v3__inv_2_710/VSS
+ gf180mcu_as_sc_mcu7t3v3__inv_2_660/Y VSS gf180mcu_as_sc_mcu7t3v3__nor2_2_8/VNW VSUBS
+ gf180mcu_as_sc_mcu7t3v3__inv_2
Xu_t014_015 u_t014_015/c0_w0_bl u_t014_015/c0_w0_br u_t014_015/c0_w1_bl u_t014_015/c0_w1_br
+ u_t014_015/c0_r0_rbl u_t014_015/c0_r1_rbl u_t014_015/c1_w0_bl u_t014_015/c1_w0_br
+ u_t014_015/c1_w1_bl u_t014_015/c1_w1_br u_t014_015/c1_r0_rbl u_t014_015/c1_r1_rbl
+ u_t014_015/c2_w0_bl u_t014_015/c2_w0_br u_t014_015/c2_w1_bl u_t014_015/c2_w1_br
+ u_t014_015/c2_r0_rbl u_t014_015/c2_r1_rbl u_t014_015/c3_w0_bl u_t014_015/c3_w0_br
+ u_t014_015/c3_w1_bl u_t014_015/c3_w1_br u_t014_015/c3_r0_rbl u_t014_015/c3_r1_rbl
+ u_t014_015/r0_w0_wl u_t014_015/r0_w1_wl u_t014_015/r0_r0_rwl u_t014_015/r0_r1_rwl
+ u_t014_015/r1_w0_wl u_t014_015/r1_w1_wl u_t014_015/r1_r0_rwl u_t014_015/r1_r1_rwl
+ u_t014_015/r2_w0_wl u_t014_015/r2_w1_wl u_t014_015/r2_r0_rwl u_t014_015/r2_r1_rwl
+ u_t014_015/r3_w0_wl u_t014_015/r3_w1_wl u_t014_015/r3_r0_rwl u_t014_015/r3_r1_rwl
+ VSS u_t014_015/VSS VSUBS detronyx_12t_2w2r_rc4_4x4_routed_5layer_direct
Xgf180mcu_as_sc_mcu7t3v3__nand2_2_16 gf180mcu_as_sc_mcu7t3v3__nor2_2_5/VDD gf180mcu_as_sc_mcu7t3v3__nand3_2_8/VSS
+ VSS VSS VSS gf180mcu_as_sc_mcu7t3v3__nor2_2_5/VNW VSUBS gf180mcu_as_sc_mcu7t3v3__nand2_2
Xgf180mcu_as_sc_mcu7t3v3__nand2_2_27 gf180mcu_as_sc_mcu7t3v3__nor2_2_4/VDD gf180mcu_as_sc_mcu7t3v3__nand3_2_8/VSS
+ VSS VSS VSS gf180mcu_as_sc_mcu7t3v3__nor2_2_4/VNW VSUBS gf180mcu_as_sc_mcu7t3v3__nand2_2
Xgf180mcu_as_sc_mcu7t3v3__nand2_2_38 gf180mcu_as_sc_mcu7t3v3__nand2_2_9/VDD gf180mcu_as_sc_mcu7t3v3__nor2_2_6/VSS
+ VSS VSS VSS gf180mcu_as_sc_mcu7t3v3__nand2_2_9/VNW VSUBS gf180mcu_as_sc_mcu7t3v3__nand2_2
Xgf180mcu_as_sc_mcu7t3v3__nand2_2_49 gf180mcu_as_sc_mcu7t3v3__nor2_2_8/VDD gf180mcu_as_sc_mcu7t3v3__inv_2_710/VSS
+ VSS VSS VSS gf180mcu_as_sc_mcu7t3v3__nor2_2_8/VNW VSUBS gf180mcu_as_sc_mcu7t3v3__nand2_2
Xu_t014_004 u_t014_004/c0_w0_bl u_t014_004/c0_w0_br u_t014_004/c0_w1_bl u_t014_004/c0_w1_br
+ u_t014_004/c0_r0_rbl u_t014_004/c0_r1_rbl u_t014_004/c1_w0_bl u_t014_004/c1_w0_br
+ u_t014_004/c1_w1_bl u_t014_004/c1_w1_br u_t014_004/c1_r0_rbl u_t014_004/c1_r1_rbl
+ u_t014_004/c2_w0_bl u_t014_004/c2_w0_br u_t014_004/c2_w1_bl u_t014_004/c2_w1_br
+ u_t014_004/c2_r0_rbl u_t014_004/c2_r1_rbl u_t014_004/c3_w0_bl u_t014_004/c3_w0_br
+ u_t014_004/c3_w1_bl u_t014_004/c3_w1_br u_t014_004/c3_r0_rbl u_t014_004/c3_r1_rbl
+ u_t014_004/r0_w0_wl u_t014_004/r0_w1_wl u_t014_004/r0_r0_rwl u_t014_004/r0_r1_rwl
+ u_t014_004/r1_w0_wl u_t014_004/r1_w1_wl u_t014_004/r1_r0_rwl u_t014_004/r1_r1_rwl
+ u_t014_004/r2_w0_wl u_t014_004/r2_w1_wl u_t014_004/r2_r0_rwl u_t014_004/r2_r1_rwl
+ u_t014_004/r3_w0_wl u_t014_004/r3_w1_wl u_t014_004/r3_r0_rwl u_t014_004/r3_r1_rwl
+ u_t014_004/VDD u_t014_004/VSS VSUBS detronyx_12t_2w2r_rc4_4x4_routed_5layer_direct
Xu_t005_004 u_t005_004/c0_w0_bl u_t005_004/c0_w0_br u_t005_004/c0_w1_bl u_t005_004/c0_w1_br
+ u_t005_004/c0_r0_rbl u_t005_004/c0_r1_rbl u_t005_004/c1_w0_bl u_t005_004/c1_w0_br
+ u_t005_004/c1_w1_bl u_t005_004/c1_w1_br u_t005_004/c1_r0_rbl u_t005_004/c1_r1_rbl
+ u_t005_004/c2_w0_bl u_t005_004/c2_w0_br u_t005_004/c2_w1_bl u_t005_004/c2_w1_br
+ u_t005_004/c2_r0_rbl u_t005_004/c2_r1_rbl u_t005_004/c3_w0_bl u_t005_004/c3_w0_br
+ u_t005_004/c3_w1_bl u_t005_004/c3_w1_br u_t005_004/c3_r0_rbl u_t005_004/c3_r1_rbl
+ u_t005_004/r0_w0_wl u_t005_004/r0_w1_wl u_t005_004/r0_r0_rwl u_t005_004/r0_r1_rwl
+ u_t005_004/r1_w0_wl u_t005_004/r1_w1_wl u_t005_004/r1_r0_rwl u_t005_004/r1_r1_rwl
+ u_t005_004/r2_w0_wl u_t005_004/r2_w1_wl u_t005_004/r2_r0_rwl u_t005_004/r2_r1_rwl
+ u_t005_004/r3_w0_wl u_t005_004/r3_w1_wl u_t005_004/r3_r0_rwl u_t005_004/r3_r1_rwl
+ u_t005_004/VDD u_t005_015/VSS VSUBS detronyx_12t_2w2r_rc4_4x4_routed_5layer_direct
Xu_t005_015 u_t005_015/c0_w0_bl u_t005_015/c0_w0_br u_t005_015/c0_w1_bl u_t005_015/c0_w1_br
+ u_t005_015/c0_r0_rbl u_t005_015/c0_r1_rbl u_t005_015/c1_w0_bl u_t005_015/c1_w0_br
+ u_t005_015/c1_w1_bl u_t005_015/c1_w1_br u_t005_015/c1_r0_rbl u_t005_015/c1_r1_rbl
+ u_t005_015/c2_w0_bl u_t005_015/c2_w0_br u_t005_015/c2_w1_bl u_t005_015/c2_w1_br
+ u_t005_015/c2_r0_rbl u_t005_015/c2_r1_rbl u_t005_015/c3_w0_bl u_t005_015/c3_w0_br
+ u_t005_015/c3_w1_bl u_t005_015/c3_w1_br u_t005_015/c3_r0_rbl u_t005_015/c3_r1_rbl
+ u_t005_015/r0_w0_wl u_t005_015/r0_w1_wl u_t005_015/r0_r0_rwl u_t005_015/r0_r1_rwl
+ u_t005_015/r1_w0_wl u_t005_015/r1_w1_wl u_t005_015/r1_r0_rwl u_t005_015/r1_r1_rwl
+ u_t005_015/r2_w0_wl u_t005_015/r2_w1_wl u_t005_015/r2_r0_rwl u_t005_015/r2_r1_rwl
+ u_t005_015/r3_w0_wl u_t005_015/r3_w1_wl u_t005_015/r3_r0_rwl u_t005_015/r3_r1_rwl
+ VSS u_t005_015/VSS VSUBS detronyx_12t_2w2r_rc4_4x4_routed_5layer_direct
Xgf180mcu_as_sc_mcu7t3v3__inv_2_490 VSS VSS VSS VSS gf180mcu_as_sc_mcu7t3v3__inv_2_492/VNW
+ VSUBS gf180mcu_as_sc_mcu7t3v3__inv_2
Xu_t011_007 u_t011_007/c0_w0_bl u_t011_007/c0_w0_br u_t011_007/c0_w1_bl u_t011_007/c0_w1_br
+ u_t011_007/c0_r0_rbl u_t011_007/c0_r1_rbl u_t011_007/c1_w0_bl u_t011_007/c1_w0_br
+ u_t011_007/c1_w1_bl u_t011_007/c1_w1_br u_t011_007/c1_r0_rbl u_t011_007/c1_r1_rbl
+ u_t011_007/c2_w0_bl u_t011_007/c2_w0_br u_t011_007/c2_w1_bl u_t011_007/c2_w1_br
+ u_t011_007/c2_r0_rbl u_t011_007/c2_r1_rbl u_t011_007/c3_w0_bl u_t011_007/c3_w0_br
+ u_t011_007/c3_w1_bl u_t011_007/c3_w1_br u_t011_007/c3_r0_rbl u_t011_007/c3_r1_rbl
+ u_t011_007/r0_w0_wl u_t011_007/r0_w1_wl u_t011_007/r0_r0_rwl u_t011_007/r0_r1_rwl
+ u_t011_007/r1_w0_wl u_t011_007/r1_w1_wl u_t011_007/r1_r0_rwl u_t011_007/r1_r1_rwl
+ u_t011_007/r2_w0_wl u_t011_007/r2_w1_wl u_t011_007/r2_r0_rwl u_t011_007/r2_r1_rwl
+ u_t011_007/r3_w0_wl u_t011_007/r3_w1_wl u_t011_007/r3_r0_rwl u_t011_007/r3_r1_rwl
+ VSS u_t011_009/VSS VSUBS detronyx_12t_2w2r_rc4_4x4_routed_5layer_direct
Xu_t002_007 u_t002_007/c0_w0_bl u_t002_007/c0_w0_br u_t002_007/c0_w1_bl u_t002_007/c0_w1_br
+ u_t002_007/c0_r0_rbl u_t002_007/c0_r1_rbl u_t002_007/c1_w0_bl u_t002_007/c1_w0_br
+ u_t002_007/c1_w1_bl u_t002_007/c1_w1_br u_t002_007/c1_r0_rbl u_t002_007/c1_r1_rbl
+ u_t002_007/c2_w0_bl u_t002_007/c2_w0_br u_t002_007/c2_w1_bl u_t002_007/c2_w1_br
+ u_t002_007/c2_r0_rbl u_t002_007/c2_r1_rbl u_t002_007/c3_w0_bl u_t002_007/c3_w0_br
+ u_t002_007/c3_w1_bl u_t002_007/c3_w1_br u_t002_007/c3_r0_rbl u_t002_007/c3_r1_rbl
+ u_t002_007/r0_w0_wl u_t002_007/r0_w1_wl u_t002_007/r0_r0_rwl u_t002_007/r0_r1_rwl
+ u_t002_007/r1_w0_wl u_t002_007/r1_w1_wl u_t002_007/r1_r0_rwl u_t002_007/r1_r1_rwl
+ u_t002_007/r2_w0_wl u_t002_007/r2_w1_wl u_t002_007/r2_r0_rwl u_t002_007/r2_r1_rwl
+ u_t002_007/r3_w0_wl u_t002_007/r3_w1_wl u_t002_007/r3_r0_rwl u_t002_007/r3_r1_rwl
+ VSS u_t002_009/VSS VSUBS detronyx_12t_2w2r_rc4_4x4_routed_5layer_direct
Xgf180mcu_as_sc_mcu7t3v3__inv_2_13 gf180mcu_as_sc_mcu7t3v3__inv_2_15/VDD gf180mcu_as_sc_mcu7t3v3__inv_2_18/VDD
+ VSS gf180mcu_as_sc_mcu7t3v3__inv_2_18/Y gf180mcu_as_sc_mcu7t3v3__inv_2_15/VNW VSUBS
+ gf180mcu_as_sc_mcu7t3v3__inv_2
Xgf180mcu_as_sc_mcu7t3v3__inv_2_57 VSS VSS gf180mcu_as_sc_mcu7t3v3__inv_2_57/Y VSS
+ gf180mcu_as_sc_mcu7t3v3__inv_2_59/VNW VSUBS gf180mcu_as_sc_mcu7t3v3__inv_2
Xgf180mcu_as_sc_mcu7t3v3__inv_2_24 VSS gf180mcu_as_sc_mcu7t3v3__inv_2_27/VDD gf180mcu_as_sc_mcu7t3v3__inv_2_27/Y
+ VSS gf180mcu_as_sc_mcu7t3v3__inv_2_24/VNW VSUBS gf180mcu_as_sc_mcu7t3v3__inv_2
Xgf180mcu_as_sc_mcu7t3v3__inv_2_35 VSS gf180mcu_as_sc_mcu7t3v3__inv_2_39/VDD gf180mcu_as_sc_mcu7t3v3__inv_2_35/Y
+ VSS gf180mcu_as_sc_mcu7t3v3__inv_2_36/VNW VSUBS gf180mcu_as_sc_mcu7t3v3__inv_2
Xgf180mcu_as_sc_mcu7t3v3__inv_2_46 gf180mcu_as_sc_mcu7t3v3__inv_2_47/VDD gf180mcu_as_sc_mcu7t3v3__inv_2_47/VSS
+ gf180mcu_as_sc_mcu7t3v3__inv_2_46/Y VSS gf180mcu_as_sc_mcu7t3v3__inv_2_47/VNW VSUBS
+ gf180mcu_as_sc_mcu7t3v3__inv_2
Xgf180mcu_as_sc_mcu7t3v3__inv_2_68 VSS gf180mcu_as_sc_mcu7t3v3__inv_2_72/VDD VSS VSS
+ gf180mcu_as_sc_mcu7t3v3__inv_2_69/VNW VSUBS gf180mcu_as_sc_mcu7t3v3__inv_2
Xgf180mcu_as_sc_mcu7t3v3__inv_2_79 gf180mcu_as_sc_mcu7t3v3__inv_2_81/VDD gf180mcu_as_sc_mcu7t3v3__inv_2_84/VDD
+ gf180mcu_as_sc_mcu7t3v3__inv_2_79/Y VSS gf180mcu_as_sc_mcu7t3v3__inv_2_81/VNW VSUBS
+ gf180mcu_as_sc_mcu7t3v3__inv_2
Xgf180mcu_as_sc_mcu7t3v3__nand3_2_5 gf180mcu_as_sc_mcu7t3v3__nor2_2_4/VDD gf180mcu_as_sc_mcu7t3v3__nor2_2_4/VSS
+ VSS VSS VSS VSS gf180mcu_as_sc_mcu7t3v3__nor2_2_4/VNW VSUBS gf180mcu_as_sc_mcu7t3v3__nand3_2
Xgf180mcu_as_sc_mcu7t3v3__inv_2_319 gf180mcu_as_sc_mcu7t3v3__inv_2_348/VSS VSS gf180mcu_as_sc_mcu7t3v3__inv_2_321/A
+ VSS gf180mcu_as_sc_mcu7t3v3__inv_2_321/VNW VSUBS gf180mcu_as_sc_mcu7t3v3__inv_2
Xgf180mcu_as_sc_mcu7t3v3__inv_2_308 gf180mcu_as_sc_mcu7t3v3__nor2_2_5/VDD gf180mcu_as_sc_mcu7t3v3__nor2_2_5/VSS
+ VSS VSS gf180mcu_as_sc_mcu7t3v3__nor2_2_5/VNW VSUBS gf180mcu_as_sc_mcu7t3v3__inv_2
Xgf180mcu_as_sc_mcu7t3v3__inv_2_820 VSS gf180mcu_as_sc_mcu7t3v3__inv_2_827/VDD gf180mcu_as_sc_mcu7t3v3__inv_2_820/Y
+ VSS gf180mcu_as_sc_mcu7t3v3__inv_2_821/VNW VSUBS gf180mcu_as_sc_mcu7t3v3__inv_2
Xgf180mcu_as_sc_mcu7t3v3__inv_2_831 gf180mcu_as_sc_mcu7t3v3__inv_2_872/VSS gf180mcu_as_sc_mcu7t3v3__inv_2_920/VDD
+ gf180mcu_as_sc_mcu7t3v3__inv_2_831/Y VSS gf180mcu_as_sc_mcu7t3v3__inv_2_833/VNW
+ VSUBS gf180mcu_as_sc_mcu7t3v3__inv_2
Xgf180mcu_as_sc_mcu7t3v3__inv_2_864 gf180mcu_as_sc_mcu7t3v3__inv_2_866/VDD gf180mcu_as_sc_mcu7t3v3__inv_2_869/VDD
+ gf180mcu_as_sc_mcu7t3v3__inv_2_864/Y VSS gf180mcu_as_sc_mcu7t3v3__inv_2_866/VNW
+ VSUBS gf180mcu_as_sc_mcu7t3v3__inv_2
Xgf180mcu_as_sc_mcu7t3v3__inv_2_897 gf180mcu_as_sc_mcu7t3v3__inv_2_899/VDD gf180mcu_as_sc_mcu7t3v3__inv_2_902/VDD
+ VSS gf180mcu_as_sc_mcu7t3v3__inv_2_908/Y gf180mcu_as_sc_mcu7t3v3__inv_2_899/VNW
+ VSUBS gf180mcu_as_sc_mcu7t3v3__inv_2
Xgf180mcu_as_sc_mcu7t3v3__inv_2_853 gf180mcu_as_sc_mcu7t3v3__inv_2_854/VDD gf180mcu_as_sc_mcu7t3v3__inv_2_857/VDD
+ gf180mcu_as_sc_mcu7t3v3__inv_2_853/Y VSS gf180mcu_as_sc_mcu7t3v3__inv_2_854/VNW
+ VSUBS gf180mcu_as_sc_mcu7t3v3__inv_2
Xgf180mcu_as_sc_mcu7t3v3__inv_2_886 gf180mcu_as_sc_mcu7t3v3__inv_2_887/VDD gf180mcu_as_sc_mcu7t3v3__inv_2_893/VDD
+ gf180mcu_as_sc_mcu7t3v3__inv_2_886/Y gf180mcu_as_sc_mcu7t3v3__inv_2_887/Y gf180mcu_as_sc_mcu7t3v3__inv_2_887/VNW
+ VSUBS gf180mcu_as_sc_mcu7t3v3__inv_2
Xgf180mcu_as_sc_mcu7t3v3__inv_2_842 gf180mcu_as_sc_mcu7t3v3__inv_2_845/VDD gf180mcu_as_sc_mcu7t3v3__inv_2_845/VDD
+ VSS VSS gf180mcu_as_sc_mcu7t3v3__inv_2_842/VNW VSUBS gf180mcu_as_sc_mcu7t3v3__inv_2
Xgf180mcu_as_sc_mcu7t3v3__inv_2_875 gf180mcu_as_sc_mcu7t3v3__inv_2_875/VDD gf180mcu_as_sc_mcu7t3v3__inv_2_878/VDD
+ gf180mcu_as_sc_mcu7t3v3__inv_2_878/Y VSS gf180mcu_as_sc_mcu7t3v3__inv_2_875/VNW
+ VSUBS gf180mcu_as_sc_mcu7t3v3__inv_2
Xgf180mcu_as_sc_mcu7t3v3__nand4_2_152 VSS VSS VSS VSS VSS VSS VSS gf180mcu_as_sc_mcu7t3v3__inv_2_558/VNW
+ VSUBS gf180mcu_as_sc_mcu7t3v3__nand4_2
Xgf180mcu_as_sc_mcu7t3v3__nand4_2_130 VSS VSS VSS VSS VSS VSS gf180mcu_as_sc_mcu7t3v3__nand4_2_130/Y
+ gf180mcu_as_sc_mcu7t3v3__inv_2_492/VNW VSUBS gf180mcu_as_sc_mcu7t3v3__nand4_2
Xgf180mcu_as_sc_mcu7t3v3__nand4_2_196 gf180mcu_as_sc_mcu7t3v3__inv_2_746/VDD gf180mcu_as_sc_mcu7t3v3__inv_2_749/VDD
+ VSS VSS VSS VSS VSS gf180mcu_as_sc_mcu7t3v3__inv_2_746/VNW VSUBS gf180mcu_as_sc_mcu7t3v3__nand4_2
Xgf180mcu_as_sc_mcu7t3v3__nand4_2_141 gf180mcu_as_sc_mcu7t3v3__inv_2_576/VSS VSS VSS
+ VSS VSS VSS VSS gf180mcu_as_sc_mcu7t3v3__inv_2_525/VNW VSUBS gf180mcu_as_sc_mcu7t3v3__nand4_2
Xgf180mcu_as_sc_mcu7t3v3__nand4_2_174 VSS VSS VSS VSS VSS VSS gf180mcu_as_sc_mcu7t3v3__nand4_2_174/Y
+ gf180mcu_as_sc_mcu7t3v3__inv_2_634/VNW VSUBS gf180mcu_as_sc_mcu7t3v3__nand4_2
Xgf180mcu_as_sc_mcu7t3v3__nand4_2_185 VSS VSS VSS VSS VSS VSS gf180mcu_as_sc_mcu7t3v3__nand4_2_185/Y
+ gf180mcu_as_sc_mcu7t3v3__inv_2_642/VNW VSUBS gf180mcu_as_sc_mcu7t3v3__nand4_2
Xgf180mcu_as_sc_mcu7t3v3__nand4_2_163 VSS VSS VSS VSS VSS VSS VSS gf180mcu_as_sc_mcu7t3v3__inv_2_594/VNW
+ VSUBS gf180mcu_as_sc_mcu7t3v3__nand4_2
Xgf180mcu_as_sc_mcu7t3v3__nand4_2_80 gf180mcu_as_sc_mcu7t3v3__inv_2_348/VDD gf180mcu_as_sc_mcu7t3v3__inv_2_348/VSS
+ VSS VSS VSS VSS VSS gf180mcu_as_sc_mcu7t3v3__inv_2_348/VNW VSUBS gf180mcu_as_sc_mcu7t3v3__nand4_2
Xgf180mcu_as_sc_mcu7t3v3__nand4_2_91 gf180mcu_as_sc_mcu7t3v3__inv_2_375/VDD VSS VSS
+ VSS VSS VSS VSS gf180mcu_as_sc_mcu7t3v3__inv_2_375/VNW VSUBS gf180mcu_as_sc_mcu7t3v3__nand4_2
Xgf180mcu_as_sc_mcu7t3v3__inv_2_116 VSS gf180mcu_as_sc_mcu7t3v3__inv_2_63/VDD VSS
+ VSS gf180mcu_as_sc_mcu7t3v3__inv_2_60/VNW VSUBS gf180mcu_as_sc_mcu7t3v3__inv_2
Xgf180mcu_as_sc_mcu7t3v3__inv_2_105 gf180mcu_as_sc_mcu7t3v3__inv_2_105/VDD VSS VSS
+ VSS gf180mcu_as_sc_mcu7t3v3__inv_2_105/VNW VSUBS gf180mcu_as_sc_mcu7t3v3__inv_2
Xgf180mcu_as_sc_mcu7t3v3__inv_2_149 VSS gf180mcu_as_sc_mcu7t3v3__inv_2_153/VDD gf180mcu_as_sc_mcu7t3v3__inv_2_149/Y
+ gf180mcu_as_sc_mcu7t3v3__inv_2_153/Y gf180mcu_as_sc_mcu7t3v3__inv_2_150/VNW VSUBS
+ gf180mcu_as_sc_mcu7t3v3__inv_2
Xgf180mcu_as_sc_mcu7t3v3__inv_2_138 VSS gf180mcu_as_sc_mcu7t3v3__inv_2_141/VDD gf180mcu_as_sc_mcu7t3v3__inv_2_923/Y
+ VSS gf180mcu_as_sc_mcu7t3v3__inv_2_138/VNW VSUBS gf180mcu_as_sc_mcu7t3v3__inv_2
Xgf180mcu_as_sc_mcu7t3v3__inv_2_127 VSS gf180mcu_as_sc_mcu7t3v3__inv_2_132/VDD VSS
+ gf180mcu_as_sc_mcu7t3v3__inv_2_923/Y gf180mcu_as_sc_mcu7t3v3__inv_2_129/VNW VSUBS
+ gf180mcu_as_sc_mcu7t3v3__inv_2
Xgf180mcu_as_sc_mcu7t3v3__inv_2_650 gf180mcu_as_sc_mcu7t3v3__inv_2_713/VDD gf180mcu_as_sc_mcu7t3v3__nor2_2_8/VSS
+ VSS VSS gf180mcu_as_sc_mcu7t3v3__inv_2_713/VNW VSUBS gf180mcu_as_sc_mcu7t3v3__inv_2
Xgf180mcu_as_sc_mcu7t3v3__inv_2_661 gf180mcu_as_sc_mcu7t3v3__nor2_2_8/VDD gf180mcu_as_sc_mcu7t3v3__nor2_2_8/VSS
+ gf180mcu_as_sc_mcu7t3v3__inv_2_661/Y VSS gf180mcu_as_sc_mcu7t3v3__nor2_2_8/VNW VSUBS
+ gf180mcu_as_sc_mcu7t3v3__inv_2
Xgf180mcu_as_sc_mcu7t3v3__inv_2_672 gf180mcu_as_sc_mcu7t3v3__nor2_2_8/VDD gf180mcu_as_sc_mcu7t3v3__inv_2_710/VSS
+ VSS VSS gf180mcu_as_sc_mcu7t3v3__nor2_2_8/VNW VSUBS gf180mcu_as_sc_mcu7t3v3__inv_2
Xu_t008_002 u_t008_002/c0_w0_bl u_t008_002/c0_w0_br u_t008_002/c0_w1_bl u_t008_002/c0_w1_br
+ u_t008_002/c0_r0_rbl u_t008_002/c0_r1_rbl u_t008_002/c1_w0_bl u_t008_002/c1_w0_br
+ u_t008_002/c1_w1_bl u_t008_002/c1_w1_br u_t008_002/c1_r0_rbl u_t008_002/c1_r1_rbl
+ u_t008_002/c2_w0_bl u_t008_002/c2_w0_br u_t008_002/c2_w1_bl u_t008_002/c2_w1_br
+ u_t008_002/c2_r0_rbl u_t008_002/c2_r1_rbl u_t008_002/c3_w0_bl u_t008_002/c3_w0_br
+ u_t008_002/c3_w1_bl u_t008_002/c3_w1_br u_t008_002/c3_r0_rbl u_t008_002/c3_r1_rbl
+ u_t008_002/r0_w0_wl u_t008_002/r0_w1_wl u_t008_002/r0_r0_rwl u_t008_002/r0_r1_rwl
+ u_t008_002/r1_w0_wl u_t008_002/r1_w1_wl u_t008_002/r1_r0_rwl u_t008_002/r1_r1_rwl
+ u_t008_002/r2_w0_wl u_t008_002/r2_w1_wl u_t008_002/r2_r0_rwl u_t008_002/r2_r1_rwl
+ u_t008_002/r3_w0_wl u_t008_002/r3_w1_wl u_t008_002/r3_r0_rwl u_t008_002/r3_r1_rwl
+ VSS u_t008_015/VSS VSUBS detronyx_12t_2w2r_rc4_4x4_routed_5layer_direct
Xu_t008_013 u_t008_013/c0_w0_bl u_t008_013/c0_w0_br u_t008_013/c0_w1_bl u_t008_013/c0_w1_br
+ u_t008_013/c0_r0_rbl u_t008_013/c0_r1_rbl u_t008_013/c1_w0_bl u_t008_013/c1_w0_br
+ u_t008_013/c1_w1_bl u_t008_013/c1_w1_br u_t008_013/c1_r0_rbl u_t008_013/c1_r1_rbl
+ u_t008_013/c2_w0_bl u_t008_013/c2_w0_br u_t008_013/c2_w1_bl u_t008_013/c2_w1_br
+ u_t008_013/c2_r0_rbl u_t008_013/c2_r1_rbl u_t008_013/c3_w0_bl u_t008_013/c3_w0_br
+ u_t008_013/c3_w1_bl u_t008_013/c3_w1_br u_t008_013/c3_r0_rbl u_t008_013/c3_r1_rbl
+ u_t008_013/r0_w0_wl u_t008_013/r0_w1_wl u_t008_013/r0_r0_rwl u_t008_013/r0_r1_rwl
+ u_t008_013/r1_w0_wl u_t008_013/r1_w1_wl u_t008_013/r1_r0_rwl u_t008_013/r1_r1_rwl
+ u_t008_013/r2_w0_wl u_t008_013/r2_w1_wl u_t008_013/r2_r0_rwl u_t008_013/r2_r1_rwl
+ u_t008_013/r3_w0_wl u_t008_013/r3_w1_wl u_t008_013/r3_r0_rwl u_t008_013/r3_r1_rwl
+ u_t008_013/VDD u_t008_015/VSS VSUBS detronyx_12t_2w2r_rc4_4x4_routed_5layer_direct
Xgf180mcu_as_sc_mcu7t3v3__inv_2_683 gf180mcu_as_sc_mcu7t3v3__inv_2_713/VDD gf180mcu_as_sc_mcu7t3v3__inv_2_713/VSS
+ VSS VSS gf180mcu_as_sc_mcu7t3v3__inv_2_713/VNW VSUBS gf180mcu_as_sc_mcu7t3v3__inv_2
Xgf180mcu_as_sc_mcu7t3v3__inv_2_694 gf180mcu_as_sc_mcu7t3v3__inv_2_713/VDD gf180mcu_as_sc_mcu7t3v3__nor2_2_8/VSS
+ VSS VSS gf180mcu_as_sc_mcu7t3v3__inv_2_713/VNW VSUBS gf180mcu_as_sc_mcu7t3v3__inv_2
Xgf180mcu_as_sc_mcu7t3v3__nand2_2_17 gf180mcu_as_sc_mcu7t3v3__nor2_2_4/VDD gf180mcu_as_sc_mcu7t3v3__nand3_2_8/VSS
+ VSS VSS VSS gf180mcu_as_sc_mcu7t3v3__nor2_2_4/VNW VSUBS gf180mcu_as_sc_mcu7t3v3__nand2_2
Xgf180mcu_as_sc_mcu7t3v3__nand2_2_28 gf180mcu_as_sc_mcu7t3v3__nor2_2_4/VDD gf180mcu_as_sc_mcu7t3v3__nor2_2_4/VSS
+ VSS VSS VSS gf180mcu_as_sc_mcu7t3v3__nor2_2_4/VNW VSUBS gf180mcu_as_sc_mcu7t3v3__nand2_2
Xgf180mcu_as_sc_mcu7t3v3__nand2_2_39 gf180mcu_as_sc_mcu7t3v3__nor2_2_4/VDD gf180mcu_as_sc_mcu7t3v3__nand3_2_8/VSS
+ VSS VSS VSS gf180mcu_as_sc_mcu7t3v3__nor2_2_4/VNW VSUBS gf180mcu_as_sc_mcu7t3v3__nand2_2
Xu_t014_005 u_t014_005/c0_w0_bl u_t014_005/c0_w0_br u_t014_005/c0_w1_bl u_t014_005/c0_w1_br
+ u_t014_005/c0_r0_rbl u_t014_005/c0_r1_rbl u_t014_005/c1_w0_bl u_t014_005/c1_w0_br
+ u_t014_005/c1_w1_bl u_t014_005/c1_w1_br u_t014_005/c1_r0_rbl u_t014_005/c1_r1_rbl
+ u_t014_005/c2_w0_bl u_t014_005/c2_w0_br u_t014_005/c2_w1_bl u_t014_005/c2_w1_br
+ u_t014_005/c2_r0_rbl u_t014_005/c2_r1_rbl u_t014_005/c3_w0_bl u_t014_005/c3_w0_br
+ u_t014_005/c3_w1_bl u_t014_005/c3_w1_br u_t014_005/c3_r0_rbl u_t014_005/c3_r1_rbl
+ u_t014_005/r0_w0_wl u_t014_005/r0_w1_wl u_t014_005/r0_r0_rwl u_t014_005/r0_r1_rwl
+ u_t014_005/r1_w0_wl u_t014_005/r1_w1_wl u_t014_005/r1_r0_rwl u_t014_005/r1_r1_rwl
+ u_t014_005/r2_w0_wl u_t014_005/r2_w1_wl u_t014_005/r2_r0_rwl u_t014_005/r2_r1_rwl
+ u_t014_005/r3_w0_wl u_t014_005/r3_w1_wl u_t014_005/r3_r0_rwl u_t014_005/r3_r1_rwl
+ u_t014_005/VDD u_t014_005/VSS VSUBS detronyx_12t_2w2r_rc4_4x4_routed_5layer_direct
Xu_t005_005 u_t005_005/c0_w0_bl u_t005_005/c0_w0_br u_t005_005/c0_w1_bl u_t005_005/c0_w1_br
+ u_t005_005/c0_r0_rbl u_t005_005/c0_r1_rbl u_t005_005/c1_w0_bl u_t005_005/c1_w0_br
+ u_t005_005/c1_w1_bl u_t005_005/c1_w1_br u_t005_005/c1_r0_rbl u_t005_005/c1_r1_rbl
+ u_t005_005/c2_w0_bl u_t005_005/c2_w0_br u_t005_005/c2_w1_bl u_t005_005/c2_w1_br
+ u_t005_005/c2_r0_rbl u_t005_005/c2_r1_rbl u_t005_005/c3_w0_bl u_t005_005/c3_w0_br
+ u_t005_005/c3_w1_bl u_t005_005/c3_w1_br u_t005_005/c3_r0_rbl u_t005_005/c3_r1_rbl
+ u_t005_005/r0_w0_wl u_t005_005/r0_w1_wl u_t005_005/r0_r0_rwl u_t005_005/r0_r1_rwl
+ u_t005_005/r1_w0_wl u_t005_005/r1_w1_wl u_t005_005/r1_r0_rwl u_t005_005/r1_r1_rwl
+ u_t005_005/r2_w0_wl u_t005_005/r2_w1_wl u_t005_005/r2_r0_rwl u_t005_005/r2_r1_rwl
+ u_t005_005/r3_w0_wl u_t005_005/r3_w1_wl u_t005_005/r3_r0_rwl u_t005_005/r3_r1_rwl
+ u_t005_005/VDD u_t005_015/VSS VSUBS detronyx_12t_2w2r_rc4_4x4_routed_5layer_direct
Xgf180mcu_as_sc_mcu7t3v3__inv_2_491 VSS VSS VSS VSS gf180mcu_as_sc_mcu7t3v3__inv_2_492/VNW
+ VSUBS gf180mcu_as_sc_mcu7t3v3__inv_2
Xgf180mcu_as_sc_mcu7t3v3__inv_2_480 VSS VSS gf180mcu_as_sc_mcu7t3v3__inv_2_480/Y VSS
+ gf180mcu_as_sc_mcu7t3v3__inv_2_480/VNW VSUBS gf180mcu_as_sc_mcu7t3v3__inv_2
Xu_t011_008 u_t011_008/c0_w0_bl u_t011_008/c0_w0_br u_t011_008/c0_w1_bl u_t011_008/c0_w1_br
+ u_t011_008/c0_r0_rbl u_t011_008/c0_r1_rbl u_t011_008/c1_w0_bl u_t011_008/c1_w0_br
+ u_t011_008/c1_w1_bl u_t011_008/c1_w1_br u_t011_008/c1_r0_rbl u_t011_008/c1_r1_rbl
+ u_t011_008/c2_w0_bl u_t011_008/c2_w0_br u_t011_008/c2_w1_bl u_t011_008/c2_w1_br
+ u_t011_008/c2_r0_rbl u_t011_008/c2_r1_rbl u_t011_008/c3_w0_bl u_t011_008/c3_w0_br
+ u_t011_008/c3_w1_bl u_t011_008/c3_w1_br u_t011_008/c3_r0_rbl u_t011_008/c3_r1_rbl
+ u_t011_008/r0_w0_wl u_t011_008/r0_w1_wl u_t011_008/r0_r0_rwl u_t011_008/r0_r1_rwl
+ u_t011_008/r1_w0_wl u_t011_008/r1_w1_wl u_t011_008/r1_r0_rwl u_t011_008/r1_r1_rwl
+ u_t011_008/r2_w0_wl u_t011_008/r2_w1_wl u_t011_008/r2_r0_rwl u_t011_008/r2_r1_rwl
+ u_t011_008/r3_w0_wl u_t011_008/r3_w1_wl u_t011_008/r3_r0_rwl u_t011_008/r3_r1_rwl
+ VSS u_t011_009/VSS VSUBS detronyx_12t_2w2r_rc4_4x4_routed_5layer_direct
Xu_t002_008 u_t002_008/c0_w0_bl u_t002_008/c0_w0_br u_t002_008/c0_w1_bl u_t002_008/c0_w1_br
+ u_t002_008/c0_r0_rbl u_t002_008/c0_r1_rbl u_t002_008/c1_w0_bl u_t002_008/c1_w0_br
+ u_t002_008/c1_w1_bl u_t002_008/c1_w1_br u_t002_008/c1_r0_rbl u_t002_008/c1_r1_rbl
+ u_t002_008/c2_w0_bl u_t002_008/c2_w0_br u_t002_008/c2_w1_bl u_t002_008/c2_w1_br
+ u_t002_008/c2_r0_rbl u_t002_008/c2_r1_rbl u_t002_008/c3_w0_bl u_t002_008/c3_w0_br
+ u_t002_008/c3_w1_bl u_t002_008/c3_w1_br u_t002_008/c3_r0_rbl u_t002_008/c3_r1_rbl
+ u_t002_008/r0_w0_wl u_t002_008/r0_w1_wl u_t002_008/r0_r0_rwl u_t002_008/r0_r1_rwl
+ u_t002_008/r1_w0_wl u_t002_008/r1_w1_wl u_t002_008/r1_r0_rwl u_t002_008/r1_r1_rwl
+ u_t002_008/r2_w0_wl u_t002_008/r2_w1_wl u_t002_008/r2_r0_rwl u_t002_008/r2_r1_rwl
+ u_t002_008/r3_w0_wl u_t002_008/r3_w1_wl u_t002_008/r3_r0_rwl u_t002_008/r3_r1_rwl
+ VSS u_t002_009/VSS VSUBS detronyx_12t_2w2r_rc4_4x4_routed_5layer_direct
Xgf180mcu_as_sc_mcu7t3v3__inv_2_14 gf180mcu_as_sc_mcu7t3v3__inv_2_15/VDD gf180mcu_as_sc_mcu7t3v3__inv_2_18/VDD
+ gf180mcu_as_sc_mcu7t3v3__inv_2_14/Y gf180mcu_as_sc_mcu7t3v3__inv_2_18/Y gf180mcu_as_sc_mcu7t3v3__inv_2_15/VNW
+ VSUBS gf180mcu_as_sc_mcu7t3v3__inv_2
Xgf180mcu_as_sc_mcu7t3v3__inv_2_58 VSS VSS VSS VSS gf180mcu_as_sc_mcu7t3v3__inv_2_59/VNW
+ VSUBS gf180mcu_as_sc_mcu7t3v3__inv_2
Xgf180mcu_as_sc_mcu7t3v3__inv_2_36 VSS gf180mcu_as_sc_mcu7t3v3__inv_2_39/VDD gf180mcu_as_sc_mcu7t3v3__inv_2_36/Y
+ VSS gf180mcu_as_sc_mcu7t3v3__inv_2_36/VNW VSUBS gf180mcu_as_sc_mcu7t3v3__inv_2
Xgf180mcu_as_sc_mcu7t3v3__inv_2_25 gf180mcu_as_sc_mcu7t3v3__inv_2_27/VDD gf180mcu_as_sc_mcu7t3v3__inv_2_9/VDD
+ VSS gf180mcu_as_sc_mcu7t3v3__inv_2_27/Y gf180mcu_as_sc_mcu7t3v3__inv_2_27/VNW VSUBS
+ gf180mcu_as_sc_mcu7t3v3__inv_2
Xgf180mcu_as_sc_mcu7t3v3__inv_2_47 gf180mcu_as_sc_mcu7t3v3__inv_2_47/VDD gf180mcu_as_sc_mcu7t3v3__inv_2_47/VSS
+ gf180mcu_as_sc_mcu7t3v3__inv_2_47/Y VSS gf180mcu_as_sc_mcu7t3v3__inv_2_47/VNW VSUBS
+ gf180mcu_as_sc_mcu7t3v3__inv_2
Xgf180mcu_as_sc_mcu7t3v3__inv_2_69 VSS gf180mcu_as_sc_mcu7t3v3__inv_2_72/VDD VSS VSS
+ gf180mcu_as_sc_mcu7t3v3__inv_2_69/VNW VSUBS gf180mcu_as_sc_mcu7t3v3__inv_2
Xgf180mcu_as_sc_mcu7t3v3__nand3_2_6 gf180mcu_as_sc_mcu7t3v3__nor2_2_5/VDD gf180mcu_as_sc_mcu7t3v3__nor2_2_5/VSS
+ VSS VSS VSS VSS gf180mcu_as_sc_mcu7t3v3__nor2_2_5/VNW VSUBS gf180mcu_as_sc_mcu7t3v3__nand3_2
Xgf180mcu_as_sc_mcu7t3v3__inv_2_309 gf180mcu_as_sc_mcu7t3v3__nand2_2_9/VDD gf180mcu_as_sc_mcu7t3v3__nor2_2_4/VSS
+ VSS VSS gf180mcu_as_sc_mcu7t3v3__nand2_2_9/VNW VSUBS gf180mcu_as_sc_mcu7t3v3__inv_2
Xgf180mcu_as_sc_mcu7t3v3__inv_2_810 gf180mcu_as_sc_mcu7t3v3__inv_2_812/VDD VSS VSS
+ VSS gf180mcu_as_sc_mcu7t3v3__inv_2_812/VNW VSUBS gf180mcu_as_sc_mcu7t3v3__inv_2
Xgf180mcu_as_sc_mcu7t3v3__inv_2_821 VSS gf180mcu_as_sc_mcu7t3v3__inv_2_827/VDD gf180mcu_as_sc_mcu7t3v3__inv_2_821/Y
+ VSS gf180mcu_as_sc_mcu7t3v3__inv_2_821/VNW VSUBS gf180mcu_as_sc_mcu7t3v3__inv_2
Xgf180mcu_as_sc_mcu7t3v3__inv_2_832 gf180mcu_as_sc_mcu7t3v3__inv_2_872/VSS gf180mcu_as_sc_mcu7t3v3__inv_2_920/VDD
+ gf180mcu_as_sc_mcu7t3v3__inv_2_832/Y VSS gf180mcu_as_sc_mcu7t3v3__inv_2_833/VNW
+ VSUBS gf180mcu_as_sc_mcu7t3v3__inv_2
Xgf180mcu_as_sc_mcu7t3v3__inv_2_854 gf180mcu_as_sc_mcu7t3v3__inv_2_854/VDD gf180mcu_as_sc_mcu7t3v3__inv_2_857/VDD
+ gf180mcu_as_sc_mcu7t3v3__inv_2_854/Y VSS gf180mcu_as_sc_mcu7t3v3__inv_2_854/VNW
+ VSUBS gf180mcu_as_sc_mcu7t3v3__inv_2
Xgf180mcu_as_sc_mcu7t3v3__inv_2_843 gf180mcu_as_sc_mcu7t3v3__inv_2_845/VDD gf180mcu_as_sc_mcu7t3v3__inv_2_848/VDD
+ gf180mcu_as_sc_mcu7t3v3__inv_2_843/Y VSS gf180mcu_as_sc_mcu7t3v3__inv_2_845/VNW
+ VSUBS gf180mcu_as_sc_mcu7t3v3__inv_2
Xgf180mcu_as_sc_mcu7t3v3__inv_2_865 gf180mcu_as_sc_mcu7t3v3__inv_2_866/VDD gf180mcu_as_sc_mcu7t3v3__inv_2_869/VDD
+ gf180mcu_as_sc_mcu7t3v3__inv_2_865/Y VSS gf180mcu_as_sc_mcu7t3v3__inv_2_866/VNW
+ VSUBS gf180mcu_as_sc_mcu7t3v3__inv_2
Xgf180mcu_as_sc_mcu7t3v3__inv_2_898 gf180mcu_as_sc_mcu7t3v3__inv_2_899/VDD gf180mcu_as_sc_mcu7t3v3__inv_2_902/VDD
+ gf180mcu_as_sc_mcu7t3v3__inv_2_908/Y gf180mcu_as_sc_mcu7t3v3__inv_2_908/Y gf180mcu_as_sc_mcu7t3v3__inv_2_899/VNW
+ VSUBS gf180mcu_as_sc_mcu7t3v3__inv_2
Xgf180mcu_as_sc_mcu7t3v3__inv_2_887 gf180mcu_as_sc_mcu7t3v3__inv_2_887/VDD gf180mcu_as_sc_mcu7t3v3__inv_2_893/VDD
+ gf180mcu_as_sc_mcu7t3v3__inv_2_887/Y VSS gf180mcu_as_sc_mcu7t3v3__inv_2_887/VNW
+ VSUBS gf180mcu_as_sc_mcu7t3v3__inv_2
Xgf180mcu_as_sc_mcu7t3v3__inv_2_876 gf180mcu_as_sc_mcu7t3v3__inv_2_878/VDD gf180mcu_as_sc_mcu7t3v3__inv_2_884/VDD
+ VSS gf180mcu_as_sc_mcu7t3v3__inv_2_878/Y gf180mcu_as_sc_mcu7t3v3__inv_2_878/VNW
+ VSUBS gf180mcu_as_sc_mcu7t3v3__inv_2
Xgf180mcu_as_sc_mcu7t3v3__nand4_2_120 VSS VSS VSS VSS VSS VSS gf180mcu_as_sc_mcu7t3v3__nand4_2_120/Y
+ gf180mcu_as_sc_mcu7t3v3__inv_2_465/VNW VSUBS gf180mcu_as_sc_mcu7t3v3__nand4_2
Xgf180mcu_as_sc_mcu7t3v3__nand4_2_153 VSS gf180mcu_as_sc_mcu7t3v3__inv_2_564/VDD VSS
+ VSS VSS VSS VSS gf180mcu_as_sc_mcu7t3v3__inv_2_561/VNW VSUBS gf180mcu_as_sc_mcu7t3v3__nand4_2
Xgf180mcu_as_sc_mcu7t3v3__nand4_2_131 VSS VSS VSS VSS VSS VSS VSS gf180mcu_as_sc_mcu7t3v3__inv_2_495/VNW
+ VSUBS gf180mcu_as_sc_mcu7t3v3__nand4_2
Xgf180mcu_as_sc_mcu7t3v3__nand4_2_197 gf180mcu_as_sc_mcu7t3v3__inv_2_749/VDD gf180mcu_as_sc_mcu7t3v3__inv_2_752/VDD
+ VSS VSS VSS VSS VSS gf180mcu_as_sc_mcu7t3v3__inv_2_749/VNW VSUBS gf180mcu_as_sc_mcu7t3v3__nand4_2
Xgf180mcu_as_sc_mcu7t3v3__nand4_2_142 VSS VSS VSS VSS VSS VSS VSS gf180mcu_as_sc_mcu7t3v3__inv_2_528/VNW
+ VSUBS gf180mcu_as_sc_mcu7t3v3__nand4_2
Xgf180mcu_as_sc_mcu7t3v3__nand4_2_186 gf180mcu_as_sc_mcu7t3v3__inv_2_719/VDD VSS VSS
+ VSS VSS VSS VSS gf180mcu_as_sc_mcu7t3v3__inv_2_719/VNW VSUBS gf180mcu_as_sc_mcu7t3v3__nand4_2
Xgf180mcu_as_sc_mcu7t3v3__nand4_2_164 VSS gf180mcu_as_sc_mcu7t3v3__inv_2_600/VDD VSS
+ VSS VSS VSS VSS gf180mcu_as_sc_mcu7t3v3__inv_2_597/VNW VSUBS gf180mcu_as_sc_mcu7t3v3__nand4_2
Xgf180mcu_as_sc_mcu7t3v3__nand4_2_175 VSS VSS VSS VSS VSS VSS gf180mcu_as_sc_mcu7t3v3__nand4_2_175/Y
+ gf180mcu_as_sc_mcu7t3v3__inv_2_709/VNW VSUBS gf180mcu_as_sc_mcu7t3v3__nand4_2
Xgf180mcu_as_sc_mcu7t3v3__nand4_2_81 gf180mcu_as_sc_mcu7t3v3__inv_2_348/VSS VSS VSS
+ VSS VSS VSS VSS gf180mcu_as_sc_mcu7t3v3__inv_2_321/VNW VSUBS gf180mcu_as_sc_mcu7t3v3__nand4_2
Xgf180mcu_as_sc_mcu7t3v3__nand4_2_70 gf180mcu_as_sc_mcu7t3v3__nor2_2_6/VDD gf180mcu_as_sc_mcu7t3v3__nor2_2_6/VSS
+ VSS VSS VSS VSS VSS gf180mcu_as_sc_mcu7t3v3__nor2_2_6/VNW VSUBS gf180mcu_as_sc_mcu7t3v3__nand4_2
Xgf180mcu_as_sc_mcu7t3v3__nand4_2_92 VSS VSS VSS VSS VSS VSS VSS gf180mcu_as_sc_mcu7t3v3__inv_2_378/VNW
+ VSUBS gf180mcu_as_sc_mcu7t3v3__nand4_2
Xgf180mcu_as_sc_mcu7t3v3__inv_2_117 gf180mcu_as_sc_mcu7t3v3__inv_2_173/VDD VSS gf180mcu_as_sc_mcu7t3v3__inv_2_177/Y
+ VSS gf180mcu_as_sc_mcu7t3v3__inv_2_173/VNW VSUBS gf180mcu_as_sc_mcu7t3v3__inv_2
Xgf180mcu_as_sc_mcu7t3v3__inv_2_106 VSS VSS gf180mcu_as_sc_mcu7t3v3__inv_2_106/Y VSS
+ gf180mcu_as_sc_mcu7t3v3__inv_2_108/VNW VSUBS gf180mcu_as_sc_mcu7t3v3__inv_2
Xgf180mcu_as_sc_mcu7t3v3__inv_2_139 gf180mcu_as_sc_mcu7t3v3__inv_2_141/VDD gf180mcu_as_sc_mcu7t3v3__inv_2_144/VDD
+ VSS gf180mcu_as_sc_mcu7t3v3__inv_2_923/Y gf180mcu_as_sc_mcu7t3v3__inv_2_141/VNW
+ VSUBS gf180mcu_as_sc_mcu7t3v3__inv_2
Xgf180mcu_as_sc_mcu7t3v3__inv_2_128 VSS gf180mcu_as_sc_mcu7t3v3__inv_2_132/VDD gf180mcu_as_sc_mcu7t3v3__inv_2_923/Y
+ gf180mcu_as_sc_mcu7t3v3__inv_2_923/Y gf180mcu_as_sc_mcu7t3v3__inv_2_129/VNW VSUBS
+ gf180mcu_as_sc_mcu7t3v3__inv_2
Xu_t008_003 u_t008_003/c0_w0_bl u_t008_003/c0_w0_br u_t008_003/c0_w1_bl u_t008_003/c0_w1_br
+ u_t008_003/c0_r0_rbl u_t008_003/c0_r1_rbl u_t008_003/c1_w0_bl u_t008_003/c1_w0_br
+ u_t008_003/c1_w1_bl u_t008_003/c1_w1_br u_t008_003/c1_r0_rbl u_t008_003/c1_r1_rbl
+ u_t008_003/c2_w0_bl u_t008_003/c2_w0_br u_t008_003/c2_w1_bl u_t008_003/c2_w1_br
+ u_t008_003/c2_r0_rbl u_t008_003/c2_r1_rbl u_t008_003/c3_w0_bl u_t008_003/c3_w0_br
+ u_t008_003/c3_w1_bl u_t008_003/c3_w1_br u_t008_003/c3_r0_rbl u_t008_003/c3_r1_rbl
+ u_t008_003/r0_w0_wl u_t008_003/r0_w1_wl u_t008_003/r0_r0_rwl u_t008_003/r0_r1_rwl
+ u_t008_003/r1_w0_wl u_t008_003/r1_w1_wl u_t008_003/r1_r0_rwl u_t008_003/r1_r1_rwl
+ u_t008_003/r2_w0_wl u_t008_003/r2_w1_wl u_t008_003/r2_r0_rwl u_t008_003/r2_r1_rwl
+ u_t008_003/r3_w0_wl u_t008_003/r3_w1_wl u_t008_003/r3_r0_rwl u_t008_003/r3_r1_rwl
+ u_t008_003/VDD u_t008_015/VSS VSUBS detronyx_12t_2w2r_rc4_4x4_routed_5layer_direct
Xgf180mcu_as_sc_mcu7t3v3__inv_2_640 VSS VSS VSS VSS gf180mcu_as_sc_mcu7t3v3__inv_2_641/VNW
+ VSUBS gf180mcu_as_sc_mcu7t3v3__inv_2
Xgf180mcu_as_sc_mcu7t3v3__inv_2_651 gf180mcu_as_sc_mcu7t3v3__inv_2_713/VDD gf180mcu_as_sc_mcu7t3v3__inv_2_713/VSS
+ VSS VSS gf180mcu_as_sc_mcu7t3v3__inv_2_713/VNW VSUBS gf180mcu_as_sc_mcu7t3v3__inv_2
Xgf180mcu_as_sc_mcu7t3v3__inv_2_695 gf180mcu_as_sc_mcu7t3v3__inv_2_713/VDD gf180mcu_as_sc_mcu7t3v3__inv_2_713/VSS
+ VSS VSS gf180mcu_as_sc_mcu7t3v3__inv_2_713/VNW VSUBS gf180mcu_as_sc_mcu7t3v3__inv_2
Xgf180mcu_as_sc_mcu7t3v3__inv_2_662 gf180mcu_as_sc_mcu7t3v3__inv_2_713/VDD gf180mcu_as_sc_mcu7t3v3__nor2_2_8/VSS
+ VSS VSS gf180mcu_as_sc_mcu7t3v3__inv_2_713/VNW VSUBS gf180mcu_as_sc_mcu7t3v3__inv_2
Xgf180mcu_as_sc_mcu7t3v3__inv_2_673 gf180mcu_as_sc_mcu7t3v3__nor2_2_8/VDD gf180mcu_as_sc_mcu7t3v3__nor2_2_8/VSS
+ gf180mcu_as_sc_mcu7t3v3__inv_2_673/Y VSS gf180mcu_as_sc_mcu7t3v3__nor2_2_8/VNW VSUBS
+ gf180mcu_as_sc_mcu7t3v3__inv_2
Xgf180mcu_as_sc_mcu7t3v3__inv_2_684 gf180mcu_as_sc_mcu7t3v3__nor2_2_8/VDD gf180mcu_as_sc_mcu7t3v3__inv_2_710/VSS
+ VSS VSS gf180mcu_as_sc_mcu7t3v3__nor2_2_8/VNW VSUBS gf180mcu_as_sc_mcu7t3v3__inv_2
Xu_t008_014 u_t008_014/c0_w0_bl u_t008_014/c0_w0_br u_t008_014/c0_w1_bl u_t008_014/c0_w1_br
+ u_t008_014/c0_r0_rbl u_t008_014/c0_r1_rbl u_t008_014/c1_w0_bl u_t008_014/c1_w0_br
+ u_t008_014/c1_w1_bl u_t008_014/c1_w1_br u_t008_014/c1_r0_rbl u_t008_014/c1_r1_rbl
+ u_t008_014/c2_w0_bl u_t008_014/c2_w0_br u_t008_014/c2_w1_bl u_t008_014/c2_w1_br
+ u_t008_014/c2_r0_rbl u_t008_014/c2_r1_rbl u_t008_014/c3_w0_bl u_t008_014/c3_w0_br
+ u_t008_014/c3_w1_bl u_t008_014/c3_w1_br u_t008_014/c3_r0_rbl u_t008_014/c3_r1_rbl
+ u_t008_014/r0_w0_wl u_t008_014/r0_w1_wl u_t008_014/r0_r0_rwl u_t008_014/r0_r1_rwl
+ u_t008_014/r1_w0_wl u_t008_014/r1_w1_wl u_t008_014/r1_r0_rwl u_t008_014/r1_r1_rwl
+ u_t008_014/r2_w0_wl u_t008_014/r2_w1_wl u_t008_014/r2_r0_rwl u_t008_014/r2_r1_rwl
+ u_t008_014/r3_w0_wl u_t008_014/r3_w1_wl u_t008_014/r3_r0_rwl u_t008_014/r3_r1_rwl
+ u_t008_014/VDD u_t008_015/VSS VSUBS detronyx_12t_2w2r_rc4_4x4_routed_5layer_direct
Xgf180mcu_as_sc_mcu7t3v3__nand2_2_18 gf180mcu_as_sc_mcu7t3v3__nor2_2_4/VDD gf180mcu_as_sc_mcu7t3v3__nor2_2_4/VSS
+ VSS VSS VSS gf180mcu_as_sc_mcu7t3v3__nor2_2_4/VNW VSUBS gf180mcu_as_sc_mcu7t3v3__nand2_2
Xgf180mcu_as_sc_mcu7t3v3__nand2_2_29 gf180mcu_as_sc_mcu7t3v3__nand2_2_9/VDD gf180mcu_as_sc_mcu7t3v3__nor2_2_4/VSS
+ VSS VSS VSS gf180mcu_as_sc_mcu7t3v3__nand2_2_9/VNW VSUBS gf180mcu_as_sc_mcu7t3v3__nand2_2
Xu_t014_006 u_t014_006/c0_w0_bl u_t014_006/c0_w0_br u_t014_006/c0_w1_bl u_t014_006/c0_w1_br
+ u_t014_006/c0_r0_rbl u_t014_006/c0_r1_rbl u_t014_006/c1_w0_bl u_t014_006/c1_w0_br
+ u_t014_006/c1_w1_bl u_t014_006/c1_w1_br u_t014_006/c1_r0_rbl u_t014_006/c1_r1_rbl
+ u_t014_006/c2_w0_bl u_t014_006/c2_w0_br u_t014_006/c2_w1_bl u_t014_006/c2_w1_br
+ u_t014_006/c2_r0_rbl u_t014_006/c2_r1_rbl u_t014_006/c3_w0_bl u_t014_006/c3_w0_br
+ u_t014_006/c3_w1_bl u_t014_006/c3_w1_br u_t014_006/c3_r0_rbl u_t014_006/c3_r1_rbl
+ u_t014_006/r0_w0_wl u_t014_006/r0_w1_wl u_t014_006/r0_r0_rwl u_t014_006/r0_r1_rwl
+ u_t014_006/r1_w0_wl u_t014_006/r1_w1_wl u_t014_006/r1_r0_rwl u_t014_006/r1_r1_rwl
+ u_t014_006/r2_w0_wl u_t014_006/r2_w1_wl u_t014_006/r2_r0_rwl u_t014_006/r2_r1_rwl
+ u_t014_006/r3_w0_wl u_t014_006/r3_w1_wl u_t014_006/r3_r0_rwl u_t014_006/r3_r1_rwl
+ u_t014_006/VDD u_t014_009/VSS VSUBS detronyx_12t_2w2r_rc4_4x4_routed_5layer_direct
Xu_t005_006 u_t005_006/c0_w0_bl u_t005_006/c0_w0_br u_t005_006/c0_w1_bl u_t005_006/c0_w1_br
+ u_t005_006/c0_r0_rbl u_t005_006/c0_r1_rbl u_t005_006/c1_w0_bl u_t005_006/c1_w0_br
+ u_t005_006/c1_w1_bl u_t005_006/c1_w1_br u_t005_006/c1_r0_rbl u_t005_006/c1_r1_rbl
+ u_t005_006/c2_w0_bl u_t005_006/c2_w0_br u_t005_006/c2_w1_bl u_t005_006/c2_w1_br
+ u_t005_006/c2_r0_rbl u_t005_006/c2_r1_rbl u_t005_006/c3_w0_bl u_t005_006/c3_w0_br
+ u_t005_006/c3_w1_bl u_t005_006/c3_w1_br u_t005_006/c3_r0_rbl u_t005_006/c3_r1_rbl
+ u_t005_006/r0_w0_wl u_t005_006/r0_w1_wl u_t005_006/r0_r0_rwl u_t005_006/r0_r1_rwl
+ u_t005_006/r1_w0_wl u_t005_006/r1_w1_wl u_t005_006/r1_r0_rwl u_t005_006/r1_r1_rwl
+ u_t005_006/r2_w0_wl u_t005_006/r2_w1_wl u_t005_006/r2_r0_rwl u_t005_006/r2_r1_rwl
+ u_t005_006/r3_w0_wl u_t005_006/r3_w1_wl u_t005_006/r3_r0_rwl u_t005_006/r3_r1_rwl
+ u_t005_006/VDD u_t005_015/VSS VSUBS detronyx_12t_2w2r_rc4_4x4_routed_5layer_direct
Xgf180mcu_as_sc_mcu7t3v3__inv_2_492 VSS VSS gf180mcu_as_sc_mcu7t3v3__inv_2_492/Y VSS
+ gf180mcu_as_sc_mcu7t3v3__inv_2_492/VNW VSUBS gf180mcu_as_sc_mcu7t3v3__inv_2
Xgf180mcu_as_sc_mcu7t3v3__inv_2_481 VSS VSS VSS VSS gf180mcu_as_sc_mcu7t3v3__inv_2_483/VNW
+ VSUBS gf180mcu_as_sc_mcu7t3v3__inv_2
Xgf180mcu_as_sc_mcu7t3v3__inv_2_470 VSS VSS VSS VSS gf180mcu_as_sc_mcu7t3v3__inv_2_471/VNW
+ VSUBS gf180mcu_as_sc_mcu7t3v3__inv_2
Xu_t011_009 u_t011_009/c0_w0_bl u_t011_009/c0_w0_br u_t011_009/c0_w1_bl u_t011_009/c0_w1_br
+ u_t011_009/c0_r0_rbl u_t011_009/c0_r1_rbl u_t011_009/c1_w0_bl u_t011_009/c1_w0_br
+ u_t011_009/c1_w1_bl u_t011_009/c1_w1_br u_t011_009/c1_r0_rbl u_t011_009/c1_r1_rbl
+ u_t011_009/c2_w0_bl u_t011_009/c2_w0_br u_t011_009/c2_w1_bl u_t011_009/c2_w1_br
+ u_t011_009/c2_r0_rbl u_t011_009/c2_r1_rbl u_t011_009/c3_w0_bl u_t011_009/c3_w0_br
+ u_t011_009/c3_w1_bl u_t011_009/c3_w1_br u_t011_009/c3_r0_rbl u_t011_009/c3_r1_rbl
+ u_t011_009/r0_w0_wl u_t011_009/r0_w1_wl u_t011_009/r0_r0_rwl u_t011_009/r0_r1_rwl
+ u_t011_009/r1_w0_wl u_t011_009/r1_w1_wl u_t011_009/r1_r0_rwl u_t011_009/r1_r1_rwl
+ u_t011_009/r2_w0_wl u_t011_009/r2_w1_wl u_t011_009/r2_r0_rwl u_t011_009/r2_r1_rwl
+ u_t011_009/r3_w0_wl u_t011_009/r3_w1_wl u_t011_009/r3_r0_rwl u_t011_009/r3_r1_rwl
+ VSS u_t011_009/VSS VSUBS detronyx_12t_2w2r_rc4_4x4_routed_5layer_direct
Xu_t002_009 u_t002_009/c0_w0_bl u_t002_009/c0_w0_br u_t002_009/c0_w1_bl u_t002_009/c0_w1_br
+ u_t002_009/c0_r0_rbl u_t002_009/c0_r1_rbl u_t002_009/c1_w0_bl u_t002_009/c1_w0_br
+ u_t002_009/c1_w1_bl u_t002_009/c1_w1_br u_t002_009/c1_r0_rbl u_t002_009/c1_r1_rbl
+ u_t002_009/c2_w0_bl u_t002_009/c2_w0_br u_t002_009/c2_w1_bl u_t002_009/c2_w1_br
+ u_t002_009/c2_r0_rbl u_t002_009/c2_r1_rbl u_t002_009/c3_w0_bl u_t002_009/c3_w0_br
+ u_t002_009/c3_w1_bl u_t002_009/c3_w1_br u_t002_009/c3_r0_rbl u_t002_009/c3_r1_rbl
+ u_t002_009/r0_w0_wl u_t002_009/r0_w1_wl u_t002_009/r0_r0_rwl u_t002_009/r0_r1_rwl
+ u_t002_009/r1_w0_wl u_t002_009/r1_w1_wl u_t002_009/r1_r0_rwl u_t002_009/r1_r1_rwl
+ u_t002_009/r2_w0_wl u_t002_009/r2_w1_wl u_t002_009/r2_r0_rwl u_t002_009/r2_r1_rwl
+ u_t002_009/r3_w0_wl u_t002_009/r3_w1_wl u_t002_009/r3_r0_rwl u_t002_009/r3_r1_rwl
+ VSS u_t002_009/VSS VSUBS detronyx_12t_2w2r_rc4_4x4_routed_5layer_direct
Xgf180mcu_as_sc_mcu7t3v3__inv_2_48 VSS VSS gf180mcu_as_sc_mcu7t3v3__inv_2_48/Y VSS
+ gf180mcu_as_sc_mcu7t3v3__inv_2_50/VNW VSUBS gf180mcu_as_sc_mcu7t3v3__inv_2
Xgf180mcu_as_sc_mcu7t3v3__inv_2_15 gf180mcu_as_sc_mcu7t3v3__inv_2_15/VDD gf180mcu_as_sc_mcu7t3v3__inv_2_18/VDD
+ gf180mcu_as_sc_mcu7t3v3__inv_2_18/Y VSS gf180mcu_as_sc_mcu7t3v3__inv_2_15/VNW VSUBS
+ gf180mcu_as_sc_mcu7t3v3__inv_2
Xgf180mcu_as_sc_mcu7t3v3__inv_2_59 VSS VSS VSS VSS gf180mcu_as_sc_mcu7t3v3__inv_2_59/VNW
+ VSUBS gf180mcu_as_sc_mcu7t3v3__inv_2
Xgf180mcu_as_sc_mcu7t3v3__inv_2_26 gf180mcu_as_sc_mcu7t3v3__inv_2_27/VDD gf180mcu_as_sc_mcu7t3v3__inv_2_9/VDD
+ gf180mcu_as_sc_mcu7t3v3__inv_2_26/Y gf180mcu_as_sc_mcu7t3v3__inv_2_27/Y gf180mcu_as_sc_mcu7t3v3__inv_2_27/VNW
+ VSUBS gf180mcu_as_sc_mcu7t3v3__inv_2
Xgf180mcu_as_sc_mcu7t3v3__inv_2_37 gf180mcu_as_sc_mcu7t3v3__inv_2_39/VDD gf180mcu_as_sc_mcu7t3v3__inv_2_45/VDD
+ gf180mcu_as_sc_mcu7t3v3__inv_2_37/Y VSS gf180mcu_as_sc_mcu7t3v3__inv_2_39/VNW VSUBS
+ gf180mcu_as_sc_mcu7t3v3__inv_2
Xgf180mcu_as_sc_mcu7t3v3__nand3_2_7 gf180mcu_as_sc_mcu7t3v3__nor2_2_5/VDD gf180mcu_as_sc_mcu7t3v3__nand3_2_8/VSS
+ VSS VSS VSS VSS gf180mcu_as_sc_mcu7t3v3__nor2_2_5/VNW VSUBS gf180mcu_as_sc_mcu7t3v3__nand3_2
Xgf180mcu_as_sc_mcu7t3v3__inv_2_822 VSS gf180mcu_as_sc_mcu7t3v3__inv_2_926/VDD gf180mcu_as_sc_mcu7t3v3__inv_2_822/Y
+ VSS gf180mcu_as_sc_mcu7t3v3__inv_2_824/VNW VSUBS gf180mcu_as_sc_mcu7t3v3__inv_2
Xgf180mcu_as_sc_mcu7t3v3__inv_2_811 gf180mcu_as_sc_mcu7t3v3__inv_2_812/VDD VSS gf180mcu_as_sc_mcu7t3v3__inv_2_811/Y
+ VSS gf180mcu_as_sc_mcu7t3v3__inv_2_812/VNW VSUBS gf180mcu_as_sc_mcu7t3v3__inv_2
Xgf180mcu_as_sc_mcu7t3v3__inv_2_800 gf180mcu_as_sc_mcu7t3v3__inv_2_800/VDD gf180mcu_as_sc_mcu7t3v3__inv_2_803/VDD
+ gf180mcu_as_sc_mcu7t3v3__inv_2_800/Y VSS gf180mcu_as_sc_mcu7t3v3__inv_2_800/VNW
+ VSUBS gf180mcu_as_sc_mcu7t3v3__inv_2
Xgf180mcu_as_sc_mcu7t3v3__inv_2_833 gf180mcu_as_sc_mcu7t3v3__inv_2_872/VSS gf180mcu_as_sc_mcu7t3v3__inv_2_920/VDD
+ gf180mcu_as_sc_mcu7t3v3__inv_2_833/Y VSS gf180mcu_as_sc_mcu7t3v3__inv_2_833/VNW
+ VSUBS gf180mcu_as_sc_mcu7t3v3__inv_2
Xgf180mcu_as_sc_mcu7t3v3__inv_2_866 gf180mcu_as_sc_mcu7t3v3__inv_2_866/VDD gf180mcu_as_sc_mcu7t3v3__inv_2_869/VDD
+ gf180mcu_as_sc_mcu7t3v3__inv_2_866/Y VSS gf180mcu_as_sc_mcu7t3v3__inv_2_866/VNW
+ VSUBS gf180mcu_as_sc_mcu7t3v3__inv_2
Xgf180mcu_as_sc_mcu7t3v3__inv_2_855 gf180mcu_as_sc_mcu7t3v3__inv_2_857/VDD gf180mcu_as_sc_mcu7t3v3__inv_2_860/VDD
+ gf180mcu_as_sc_mcu7t3v3__inv_2_855/Y VSS gf180mcu_as_sc_mcu7t3v3__inv_2_857/VNW
+ VSUBS gf180mcu_as_sc_mcu7t3v3__inv_2
Xgf180mcu_as_sc_mcu7t3v3__inv_2_888 gf180mcu_as_sc_mcu7t3v3__inv_2_893/VDD gf180mcu_as_sc_mcu7t3v3__inv_2_893/VDD
+ VSS gf180mcu_as_sc_mcu7t3v3__inv_2_908/Y gf180mcu_as_sc_mcu7t3v3__inv_2_890/VNW
+ VSUBS gf180mcu_as_sc_mcu7t3v3__inv_2
Xgf180mcu_as_sc_mcu7t3v3__inv_2_844 gf180mcu_as_sc_mcu7t3v3__inv_2_845/VDD gf180mcu_as_sc_mcu7t3v3__inv_2_848/VDD
+ gf180mcu_as_sc_mcu7t3v3__inv_2_844/Y VSS gf180mcu_as_sc_mcu7t3v3__inv_2_845/VNW
+ VSUBS gf180mcu_as_sc_mcu7t3v3__inv_2
Xgf180mcu_as_sc_mcu7t3v3__inv_2_877 gf180mcu_as_sc_mcu7t3v3__inv_2_878/VDD gf180mcu_as_sc_mcu7t3v3__inv_2_884/VDD
+ gf180mcu_as_sc_mcu7t3v3__inv_2_877/Y gf180mcu_as_sc_mcu7t3v3__inv_2_878/Y gf180mcu_as_sc_mcu7t3v3__inv_2_878/VNW
+ VSUBS gf180mcu_as_sc_mcu7t3v3__inv_2
Xgf180mcu_as_sc_mcu7t3v3__inv_2_899 gf180mcu_as_sc_mcu7t3v3__inv_2_899/VDD gf180mcu_as_sc_mcu7t3v3__inv_2_902/VDD
+ gf180mcu_as_sc_mcu7t3v3__inv_2_908/Y VSS gf180mcu_as_sc_mcu7t3v3__inv_2_899/VNW
+ VSUBS gf180mcu_as_sc_mcu7t3v3__inv_2
Xgf180mcu_as_sc_mcu7t3v3__nand4_2_110 VSS VSS VSS VSS VSS VSS gf180mcu_as_sc_mcu7t3v3__nand4_2_110/Y
+ gf180mcu_as_sc_mcu7t3v3__inv_2_434/VNW VSUBS gf180mcu_as_sc_mcu7t3v3__nand4_2
Xgf180mcu_as_sc_mcu7t3v3__nand4_2_121 gf180mcu_as_sc_mcu7t3v3__inv_2_468/VDD VSS VSS
+ VSS VSS VSS VSS gf180mcu_as_sc_mcu7t3v3__inv_2_468/VNW VSUBS gf180mcu_as_sc_mcu7t3v3__nand4_2
Xgf180mcu_as_sc_mcu7t3v3__nand4_2_60 VSS VSS VSS VSS VSS VSS VSS gf180mcu_as_sc_mcu7t3v3__inv_2_302/VNW
+ VSUBS gf180mcu_as_sc_mcu7t3v3__nand4_2
Xgf180mcu_as_sc_mcu7t3v3__nand4_2_71 gf180mcu_as_sc_mcu7t3v3__nor2_2_6/VDD gf180mcu_as_sc_mcu7t3v3__nand3_2_1/VSS
+ VSS VSS VSS VSS VSS gf180mcu_as_sc_mcu7t3v3__nor2_2_6/VNW VSUBS gf180mcu_as_sc_mcu7t3v3__nand4_2
Xgf180mcu_as_sc_mcu7t3v3__nand4_2_154 gf180mcu_as_sc_mcu7t3v3__inv_2_564/VDD VSS VSS
+ VSS VSS VSS VSS gf180mcu_as_sc_mcu7t3v3__inv_2_564/VNW VSUBS gf180mcu_as_sc_mcu7t3v3__nand4_2
Xgf180mcu_as_sc_mcu7t3v3__nand4_2_132 VSS VSS VSS VSS VSS VSS gf180mcu_as_sc_mcu7t3v3__nand4_2_132/Y
+ gf180mcu_as_sc_mcu7t3v3__inv_2_498/VNW VSUBS gf180mcu_as_sc_mcu7t3v3__nand4_2
Xgf180mcu_as_sc_mcu7t3v3__nand4_2_198 gf180mcu_as_sc_mcu7t3v3__inv_2_752/VDD VSS VSS
+ VSS VSS VSS VSS gf180mcu_as_sc_mcu7t3v3__inv_2_752/VNW VSUBS gf180mcu_as_sc_mcu7t3v3__nand4_2
Xgf180mcu_as_sc_mcu7t3v3__nand4_2_143 VSS gf180mcu_as_sc_mcu7t3v3__inv_2_534/VDD VSS
+ VSS VSS VSS VSS gf180mcu_as_sc_mcu7t3v3__inv_2_531/VNW VSUBS gf180mcu_as_sc_mcu7t3v3__nand4_2
Xgf180mcu_as_sc_mcu7t3v3__nand4_2_187 VSS VSS VSS VSS VSS VSS gf180mcu_as_sc_mcu7t3v3__nand4_2_187/Y
+ gf180mcu_as_sc_mcu7t3v3__inv_2_722/VNW VSUBS gf180mcu_as_sc_mcu7t3v3__nand4_2
Xgf180mcu_as_sc_mcu7t3v3__nand4_2_165 gf180mcu_as_sc_mcu7t3v3__inv_2_600/VDD gf180mcu_as_sc_mcu7t3v3__inv_2_603/VDD
+ VSS VSS VSS VSS VSS gf180mcu_as_sc_mcu7t3v3__inv_2_600/VNW VSUBS gf180mcu_as_sc_mcu7t3v3__nand4_2
Xgf180mcu_as_sc_mcu7t3v3__nand4_2_176 VSS VSS VSS VSS VSS VSS gf180mcu_as_sc_mcu7t3v3__nand4_2_176/Y
+ gf180mcu_as_sc_mcu7t3v3__inv_2_703/VNW VSUBS gf180mcu_as_sc_mcu7t3v3__nand4_2
Xgf180mcu_as_sc_mcu7t3v3__nand4_2_82 gf180mcu_as_sc_mcu7t3v3__inv_2_405/VDD VSS VSS
+ VSS VSS VSS VSS gf180mcu_as_sc_mcu7t3v3__inv_2_405/VNW VSUBS gf180mcu_as_sc_mcu7t3v3__nand4_2
Xgf180mcu_as_sc_mcu7t3v3__nand4_2_93 VSS gf180mcu_as_sc_mcu7t3v3__inv_2_384/VDD VSS
+ VSS VSS VSS VSS gf180mcu_as_sc_mcu7t3v3__inv_2_381/VNW VSUBS gf180mcu_as_sc_mcu7t3v3__nand4_2
Xgf180mcu_as_sc_mcu7t3v3__inv_2_118 VSS gf180mcu_as_sc_mcu7t3v3__inv_2_123/VDD VSS
+ gf180mcu_as_sc_mcu7t3v3__inv_2_177/Y gf180mcu_as_sc_mcu7t3v3__inv_2_120/VNW VSUBS
+ gf180mcu_as_sc_mcu7t3v3__inv_2
Xgf180mcu_as_sc_mcu7t3v3__inv_2_107 VSS VSS VSS VSS gf180mcu_as_sc_mcu7t3v3__inv_2_108/VNW
+ VSUBS gf180mcu_as_sc_mcu7t3v3__inv_2
Xgf180mcu_as_sc_mcu7t3v3__inv_2_129 VSS gf180mcu_as_sc_mcu7t3v3__inv_2_132/VDD gf180mcu_as_sc_mcu7t3v3__inv_2_923/Y
+ VSS gf180mcu_as_sc_mcu7t3v3__inv_2_129/VNW VSUBS gf180mcu_as_sc_mcu7t3v3__inv_2
Xu_t008_004 u_t008_004/c0_w0_bl u_t008_004/c0_w0_br u_t008_004/c0_w1_bl u_t008_004/c0_w1_br
+ u_t008_004/c0_r0_rbl u_t008_004/c0_r1_rbl u_t008_004/c1_w0_bl u_t008_004/c1_w0_br
+ u_t008_004/c1_w1_bl u_t008_004/c1_w1_br u_t008_004/c1_r0_rbl u_t008_004/c1_r1_rbl
+ u_t008_004/c2_w0_bl u_t008_004/c2_w0_br u_t008_004/c2_w1_bl u_t008_004/c2_w1_br
+ u_t008_004/c2_r0_rbl u_t008_004/c2_r1_rbl u_t008_004/c3_w0_bl u_t008_004/c3_w0_br
+ u_t008_004/c3_w1_bl u_t008_004/c3_w1_br u_t008_004/c3_r0_rbl u_t008_004/c3_r1_rbl
+ u_t008_004/r0_w0_wl u_t008_004/r0_w1_wl u_t008_004/r0_r0_rwl u_t008_004/r0_r1_rwl
+ u_t008_004/r1_w0_wl u_t008_004/r1_w1_wl u_t008_004/r1_r0_rwl u_t008_004/r1_r1_rwl
+ u_t008_004/r2_w0_wl u_t008_004/r2_w1_wl u_t008_004/r2_r0_rwl u_t008_004/r2_r1_rwl
+ u_t008_004/r3_w0_wl u_t008_004/r3_w1_wl u_t008_004/r3_r0_rwl u_t008_004/r3_r1_rwl
+ u_t008_004/VDD u_t008_015/VSS VSUBS detronyx_12t_2w2r_rc4_4x4_routed_5layer_direct
Xu_t008_015 u_t008_015/c0_w0_bl u_t008_015/c0_w0_br u_t008_015/c0_w1_bl u_t008_015/c0_w1_br
+ u_t008_015/c0_r0_rbl u_t008_015/c0_r1_rbl u_t008_015/c1_w0_bl u_t008_015/c1_w0_br
+ u_t008_015/c1_w1_bl u_t008_015/c1_w1_br u_t008_015/c1_r0_rbl u_t008_015/c1_r1_rbl
+ u_t008_015/c2_w0_bl u_t008_015/c2_w0_br u_t008_015/c2_w1_bl u_t008_015/c2_w1_br
+ u_t008_015/c2_r0_rbl u_t008_015/c2_r1_rbl u_t008_015/c3_w0_bl u_t008_015/c3_w0_br
+ u_t008_015/c3_w1_bl u_t008_015/c3_w1_br u_t008_015/c3_r0_rbl u_t008_015/c3_r1_rbl
+ u_t008_015/r0_w0_wl u_t008_015/r0_w1_wl u_t008_015/r0_r0_rwl u_t008_015/r0_r1_rwl
+ u_t008_015/r1_w0_wl u_t008_015/r1_w1_wl u_t008_015/r1_r0_rwl u_t008_015/r1_r1_rwl
+ u_t008_015/r2_w0_wl u_t008_015/r2_w1_wl u_t008_015/r2_r0_rwl u_t008_015/r2_r1_rwl
+ u_t008_015/r3_w0_wl u_t008_015/r3_w1_wl u_t008_015/r3_r0_rwl u_t008_015/r3_r1_rwl
+ VSS u_t008_015/VSS VSUBS detronyx_12t_2w2r_rc4_4x4_routed_5layer_direct
Xgf180mcu_as_sc_mcu7t3v3__inv_2_630 VSS VSS VSS VSS gf180mcu_as_sc_mcu7t3v3__inv_2_630/VNW
+ VSUBS gf180mcu_as_sc_mcu7t3v3__inv_2
Xgf180mcu_as_sc_mcu7t3v3__inv_2_641 VSS VSS gf180mcu_as_sc_mcu7t3v3__inv_2_641/Y VSS
+ gf180mcu_as_sc_mcu7t3v3__inv_2_641/VNW VSUBS gf180mcu_as_sc_mcu7t3v3__inv_2
Xgf180mcu_as_sc_mcu7t3v3__inv_2_663 gf180mcu_as_sc_mcu7t3v3__inv_2_713/VDD gf180mcu_as_sc_mcu7t3v3__inv_2_713/VSS
+ VSS VSS gf180mcu_as_sc_mcu7t3v3__inv_2_713/VNW VSUBS gf180mcu_as_sc_mcu7t3v3__inv_2
Xgf180mcu_as_sc_mcu7t3v3__inv_2_652 gf180mcu_as_sc_mcu7t3v3__inv_2_713/VDD gf180mcu_as_sc_mcu7t3v3__inv_2_713/VSS
+ gf180mcu_as_sc_mcu7t3v3__inv_2_652/Y VSS gf180mcu_as_sc_mcu7t3v3__inv_2_713/VNW
+ VSUBS gf180mcu_as_sc_mcu7t3v3__inv_2
Xgf180mcu_as_sc_mcu7t3v3__inv_2_674 gf180mcu_as_sc_mcu7t3v3__inv_2_713/VDD gf180mcu_as_sc_mcu7t3v3__inv_2_713/VSS
+ VSS VSS gf180mcu_as_sc_mcu7t3v3__inv_2_713/VNW VSUBS gf180mcu_as_sc_mcu7t3v3__inv_2
Xgf180mcu_as_sc_mcu7t3v3__inv_2_685 gf180mcu_as_sc_mcu7t3v3__nor2_2_8/VDD gf180mcu_as_sc_mcu7t3v3__nor2_2_8/VSS
+ VSS VSS gf180mcu_as_sc_mcu7t3v3__nor2_2_8/VNW VSUBS gf180mcu_as_sc_mcu7t3v3__inv_2
Xgf180mcu_as_sc_mcu7t3v3__inv_2_696 gf180mcu_as_sc_mcu7t3v3__nor2_2_8/VDD gf180mcu_as_sc_mcu7t3v3__inv_2_710/VSS
+ gf180mcu_as_sc_mcu7t3v3__inv_2_696/Y VSS gf180mcu_as_sc_mcu7t3v3__nor2_2_8/VNW VSUBS
+ gf180mcu_as_sc_mcu7t3v3__inv_2
Xgf180mcu_as_sc_mcu7t3v3__nand2_2_19 gf180mcu_as_sc_mcu7t3v3__nand2_2_9/VDD gf180mcu_as_sc_mcu7t3v3__nor2_2_4/VSS
+ VSS VSS VSS gf180mcu_as_sc_mcu7t3v3__nand2_2_9/VNW VSUBS gf180mcu_as_sc_mcu7t3v3__nand2_2
Xu_t014_007 u_t014_007/c0_w0_bl u_t014_007/c0_w0_br u_t014_007/c0_w1_bl u_t014_007/c0_w1_br
+ u_t014_007/c0_r0_rbl u_t014_007/c0_r1_rbl u_t014_007/c1_w0_bl u_t014_007/c1_w0_br
+ u_t014_007/c1_w1_bl u_t014_007/c1_w1_br u_t014_007/c1_r0_rbl u_t014_007/c1_r1_rbl
+ u_t014_007/c2_w0_bl u_t014_007/c2_w0_br u_t014_007/c2_w1_bl u_t014_007/c2_w1_br
+ u_t014_007/c2_r0_rbl u_t014_007/c2_r1_rbl u_t014_007/c3_w0_bl u_t014_007/c3_w0_br
+ u_t014_007/c3_w1_bl u_t014_007/c3_w1_br u_t014_007/c3_r0_rbl u_t014_007/c3_r1_rbl
+ u_t014_007/r0_w0_wl u_t014_007/r0_w1_wl u_t014_007/r0_r0_rwl u_t014_007/r0_r1_rwl
+ u_t014_007/r1_w0_wl u_t014_007/r1_w1_wl u_t014_007/r1_r0_rwl u_t014_007/r1_r1_rwl
+ u_t014_007/r2_w0_wl u_t014_007/r2_w1_wl u_t014_007/r2_r0_rwl u_t014_007/r2_r1_rwl
+ u_t014_007/r3_w0_wl u_t014_007/r3_w1_wl u_t014_007/r3_r0_rwl u_t014_007/r3_r1_rwl
+ VSS u_t014_009/VSS VSUBS detronyx_12t_2w2r_rc4_4x4_routed_5layer_direct
Xu_t005_007 u_t005_007/c0_w0_bl u_t005_007/c0_w0_br u_t005_007/c0_w1_bl u_t005_007/c0_w1_br
+ u_t005_007/c0_r0_rbl u_t005_007/c0_r1_rbl u_t005_007/c1_w0_bl u_t005_007/c1_w0_br
+ u_t005_007/c1_w1_bl u_t005_007/c1_w1_br u_t005_007/c1_r0_rbl u_t005_007/c1_r1_rbl
+ u_t005_007/c2_w0_bl u_t005_007/c2_w0_br u_t005_007/c2_w1_bl u_t005_007/c2_w1_br
+ u_t005_007/c2_r0_rbl u_t005_007/c2_r1_rbl u_t005_007/c3_w0_bl u_t005_007/c3_w0_br
+ u_t005_007/c3_w1_bl u_t005_007/c3_w1_br u_t005_007/c3_r0_rbl u_t005_007/c3_r1_rbl
+ u_t005_007/r0_w0_wl u_t005_007/r0_w1_wl u_t005_007/r0_r0_rwl u_t005_007/r0_r1_rwl
+ u_t005_007/r1_w0_wl u_t005_007/r1_w1_wl u_t005_007/r1_r0_rwl u_t005_007/r1_r1_rwl
+ u_t005_007/r2_w0_wl u_t005_007/r2_w1_wl u_t005_007/r2_r0_rwl u_t005_007/r2_r1_rwl
+ u_t005_007/r3_w0_wl u_t005_007/r3_w1_wl u_t005_007/r3_r0_rwl u_t005_007/r3_r1_rwl
+ VSS u_t005_015/VSS VSUBS detronyx_12t_2w2r_rc4_4x4_routed_5layer_direct
Xgf180mcu_as_sc_mcu7t3v3__inv_2_460 VSS VSS VSS VSS gf180mcu_as_sc_mcu7t3v3__inv_2_461/VNW
+ VSUBS gf180mcu_as_sc_mcu7t3v3__inv_2
Xgf180mcu_as_sc_mcu7t3v3__inv_2_493 VSS VSS VSS VSS gf180mcu_as_sc_mcu7t3v3__inv_2_495/VNW
+ VSUBS gf180mcu_as_sc_mcu7t3v3__inv_2
Xgf180mcu_as_sc_mcu7t3v3__inv_2_482 VSS VSS VSS VSS gf180mcu_as_sc_mcu7t3v3__inv_2_483/VNW
+ VSUBS gf180mcu_as_sc_mcu7t3v3__inv_2
Xgf180mcu_as_sc_mcu7t3v3__inv_2_471 VSS VSS gf180mcu_as_sc_mcu7t3v3__inv_2_471/Y VSS
+ gf180mcu_as_sc_mcu7t3v3__inv_2_471/VNW VSUBS gf180mcu_as_sc_mcu7t3v3__inv_2
Xu_t010_010 u_t010_010/c0_w0_bl u_t010_010/c0_w0_br u_t010_010/c0_w1_bl u_t010_010/c0_w1_br
+ u_t010_010/c0_r0_rbl u_t010_010/c0_r1_rbl u_t010_010/c1_w0_bl u_t010_010/c1_w0_br
+ u_t010_010/c1_w1_bl u_t010_010/c1_w1_br u_t010_010/c1_r0_rbl u_t010_010/c1_r1_rbl
+ u_t010_010/c2_w0_bl u_t010_010/c2_w0_br u_t010_010/c2_w1_bl u_t010_010/c2_w1_br
+ u_t010_010/c2_r0_rbl u_t010_010/c2_r1_rbl u_t010_010/c3_w0_bl u_t010_010/c3_w0_br
+ u_t010_010/c3_w1_bl u_t010_010/c3_w1_br u_t010_010/c3_r0_rbl u_t010_010/c3_r1_rbl
+ u_t010_010/r0_w0_wl u_t010_010/r0_w1_wl u_t010_010/r0_r0_rwl u_t010_010/r0_r1_rwl
+ u_t010_010/r1_w0_wl u_t010_010/r1_w1_wl u_t010_010/r1_r0_rwl u_t010_010/r1_r1_rwl
+ u_t010_010/r2_w0_wl u_t010_010/r2_w1_wl u_t010_010/r2_r0_rwl u_t010_010/r2_r1_rwl
+ u_t010_010/r3_w0_wl u_t010_010/r3_w1_wl u_t010_010/r3_r0_rwl u_t010_010/r3_r1_rwl
+ VSS u_t010_010/VSS VSUBS detronyx_12t_2w2r_rc4_4x4_routed_5layer_direct
Xu_t001_010 u_t001_010/c0_w0_bl u_t001_010/c0_w0_br u_t001_010/c0_w1_bl u_t001_010/c0_w1_br
+ u_t001_010/c0_r0_rbl u_t001_010/c0_r1_rbl u_t001_010/c1_w0_bl u_t001_010/c1_w0_br
+ u_t001_010/c1_w1_bl u_t001_010/c1_w1_br u_t001_010/c1_r0_rbl u_t001_010/c1_r1_rbl
+ u_t001_010/c2_w0_bl u_t001_010/c2_w0_br u_t001_010/c2_w1_bl u_t001_010/c2_w1_br
+ u_t001_010/c2_r0_rbl u_t001_010/c2_r1_rbl u_t001_010/c3_w0_bl u_t001_010/c3_w0_br
+ u_t001_010/c3_w1_bl u_t001_010/c3_w1_br u_t001_010/c3_r0_rbl u_t001_010/c3_r1_rbl
+ u_t001_010/r0_w0_wl u_t001_010/r0_w1_wl u_t001_010/r0_r0_rwl u_t001_010/r0_r1_rwl
+ u_t001_010/r1_w0_wl u_t001_010/r1_w1_wl u_t001_010/r1_r0_rwl u_t001_010/r1_r1_rwl
+ u_t001_010/r2_w0_wl u_t001_010/r2_w1_wl u_t001_010/r2_r0_rwl u_t001_010/r2_r1_rwl
+ u_t001_010/r3_w0_wl u_t001_010/r3_w1_wl u_t001_010/r3_r0_rwl u_t001_010/r3_r1_rwl
+ VSS u_t001_015/VSS VSUBS detronyx_12t_2w2r_rc4_4x4_routed_5layer_direct
Xgf180mcu_as_sc_mcu7t3v3__inv_2_290 VSS VSS VSS VSS gf180mcu_as_sc_mcu7t3v3__inv_2_290/VNW
+ VSUBS gf180mcu_as_sc_mcu7t3v3__inv_2
Xgf180mcu_as_sc_mcu7t3v3__inv_2_16 gf180mcu_as_sc_mcu7t3v3__inv_2_18/VDD VSS VSS gf180mcu_as_sc_mcu7t3v3__inv_2_18/Y
+ gf180mcu_as_sc_mcu7t3v3__inv_2_18/VNW VSUBS gf180mcu_as_sc_mcu7t3v3__inv_2
Xgf180mcu_as_sc_mcu7t3v3__inv_2_49 VSS VSS VSS VSS gf180mcu_as_sc_mcu7t3v3__inv_2_50/VNW
+ VSUBS gf180mcu_as_sc_mcu7t3v3__inv_2
Xgf180mcu_as_sc_mcu7t3v3__inv_2_27 gf180mcu_as_sc_mcu7t3v3__inv_2_27/VDD gf180mcu_as_sc_mcu7t3v3__inv_2_9/VDD
+ gf180mcu_as_sc_mcu7t3v3__inv_2_27/Y VSS gf180mcu_as_sc_mcu7t3v3__inv_2_27/VNW VSUBS
+ gf180mcu_as_sc_mcu7t3v3__inv_2
Xgf180mcu_as_sc_mcu7t3v3__inv_2_38 gf180mcu_as_sc_mcu7t3v3__inv_2_39/VDD gf180mcu_as_sc_mcu7t3v3__inv_2_45/VDD
+ gf180mcu_as_sc_mcu7t3v3__inv_2_38/Y VSS gf180mcu_as_sc_mcu7t3v3__inv_2_39/VNW VSUBS
+ gf180mcu_as_sc_mcu7t3v3__inv_2
Xgf180mcu_as_sc_mcu7t3v3__nand3_2_8 gf180mcu_as_sc_mcu7t3v3__nor2_2_4/VDD gf180mcu_as_sc_mcu7t3v3__nand3_2_8/VSS
+ VSS VSS VSS VSS gf180mcu_as_sc_mcu7t3v3__nor2_2_4/VNW VSUBS gf180mcu_as_sc_mcu7t3v3__nand3_2
Xgf180mcu_as_sc_mcu7t3v3__inv_2_823 VSS gf180mcu_as_sc_mcu7t3v3__inv_2_926/VDD gf180mcu_as_sc_mcu7t3v3__inv_2_823/Y
+ VSS gf180mcu_as_sc_mcu7t3v3__inv_2_824/VNW VSUBS gf180mcu_as_sc_mcu7t3v3__inv_2
Xgf180mcu_as_sc_mcu7t3v3__inv_2_812 gf180mcu_as_sc_mcu7t3v3__inv_2_812/VDD VSS gf180mcu_as_sc_mcu7t3v3__inv_2_812/Y
+ VSS gf180mcu_as_sc_mcu7t3v3__inv_2_812/VNW VSUBS gf180mcu_as_sc_mcu7t3v3__inv_2
Xgf180mcu_as_sc_mcu7t3v3__inv_2_801 gf180mcu_as_sc_mcu7t3v3__inv_2_803/VDD VSS gf180mcu_as_sc_mcu7t3v3__inv_2_801/Y
+ VSS gf180mcu_as_sc_mcu7t3v3__inv_2_803/VNW VSUBS gf180mcu_as_sc_mcu7t3v3__inv_2
Xgf180mcu_as_sc_mcu7t3v3__inv_2_867 gf180mcu_as_sc_mcu7t3v3__inv_2_869/VDD VSS gf180mcu_as_sc_mcu7t3v3__inv_2_867/Y
+ VSS gf180mcu_as_sc_mcu7t3v3__inv_2_869/VNW VSUBS gf180mcu_as_sc_mcu7t3v3__inv_2
Xgf180mcu_as_sc_mcu7t3v3__inv_2_856 gf180mcu_as_sc_mcu7t3v3__inv_2_857/VDD gf180mcu_as_sc_mcu7t3v3__inv_2_860/VDD
+ gf180mcu_as_sc_mcu7t3v3__inv_2_856/Y VSS gf180mcu_as_sc_mcu7t3v3__inv_2_857/VNW
+ VSUBS gf180mcu_as_sc_mcu7t3v3__inv_2
Xgf180mcu_as_sc_mcu7t3v3__inv_2_889 gf180mcu_as_sc_mcu7t3v3__inv_2_893/VDD gf180mcu_as_sc_mcu7t3v3__inv_2_893/VDD
+ gf180mcu_as_sc_mcu7t3v3__inv_2_908/Y gf180mcu_as_sc_mcu7t3v3__inv_2_908/Y gf180mcu_as_sc_mcu7t3v3__inv_2_890/VNW
+ VSUBS gf180mcu_as_sc_mcu7t3v3__inv_2
Xgf180mcu_as_sc_mcu7t3v3__inv_2_845 gf180mcu_as_sc_mcu7t3v3__inv_2_845/VDD gf180mcu_as_sc_mcu7t3v3__inv_2_848/VDD
+ gf180mcu_as_sc_mcu7t3v3__inv_2_845/Y VSS gf180mcu_as_sc_mcu7t3v3__inv_2_845/VNW
+ VSUBS gf180mcu_as_sc_mcu7t3v3__inv_2
Xgf180mcu_as_sc_mcu7t3v3__inv_2_878 gf180mcu_as_sc_mcu7t3v3__inv_2_878/VDD gf180mcu_as_sc_mcu7t3v3__inv_2_884/VDD
+ gf180mcu_as_sc_mcu7t3v3__inv_2_878/Y VSS gf180mcu_as_sc_mcu7t3v3__inv_2_878/VNW
+ VSUBS gf180mcu_as_sc_mcu7t3v3__inv_2
Xgf180mcu_as_sc_mcu7t3v3__inv_2_834 gf180mcu_as_sc_mcu7t3v3__inv_2_836/VDD gf180mcu_as_sc_mcu7t3v3__inv_2_839/VDD
+ gf180mcu_as_sc_mcu7t3v3__inv_2_834/Y VSS gf180mcu_as_sc_mcu7t3v3__inv_2_836/VNW
+ VSUBS gf180mcu_as_sc_mcu7t3v3__inv_2
Xgf180mcu_as_sc_mcu7t3v3__nand4_2_100 VSS gf180mcu_as_sc_mcu7t3v3__inv_2_405/VDD VSS
+ VSS VSS VSS VSS gf180mcu_as_sc_mcu7t3v3__inv_2_402/VNW VSUBS gf180mcu_as_sc_mcu7t3v3__nand4_2
Xgf180mcu_as_sc_mcu7t3v3__nand4_2_111 VSS VSS VSS VSS VSS VSS gf180mcu_as_sc_mcu7t3v3__nand4_2_111/Y
+ gf180mcu_as_sc_mcu7t3v3__inv_2_437/VNW VSUBS gf180mcu_as_sc_mcu7t3v3__nand4_2
Xgf180mcu_as_sc_mcu7t3v3__nand4_2_133 VSS VSS VSS VSS VSS VSS gf180mcu_as_sc_mcu7t3v3__nand4_2_133/Y
+ gf180mcu_as_sc_mcu7t3v3__inv_2_501/VNW VSUBS gf180mcu_as_sc_mcu7t3v3__nand4_2
Xgf180mcu_as_sc_mcu7t3v3__nand4_2_144 gf180mcu_as_sc_mcu7t3v3__inv_2_534/VDD gf180mcu_as_sc_mcu7t3v3__inv_2_537/VDD
+ VSS VSS VSS VSS VSS gf180mcu_as_sc_mcu7t3v3__inv_2_534/VNW VSUBS gf180mcu_as_sc_mcu7t3v3__nand4_2
Xgf180mcu_as_sc_mcu7t3v3__nand4_2_122 VSS VSS VSS VSS VSS VSS gf180mcu_as_sc_mcu7t3v3__nand4_2_122/Y
+ gf180mcu_as_sc_mcu7t3v3__inv_2_522/VNW VSUBS gf180mcu_as_sc_mcu7t3v3__nand4_2
Xgf180mcu_as_sc_mcu7t3v3__nand4_2_83 VSS gf180mcu_as_sc_mcu7t3v3__inv_2_354/VDD VSS
+ VSS VSS VSS VSS gf180mcu_as_sc_mcu7t3v3__inv_2_351/VNW VSUBS gf180mcu_as_sc_mcu7t3v3__nand4_2
Xgf180mcu_as_sc_mcu7t3v3__nand4_2_72 VSS VSS VSS VSS VSS VSS VSS gf180mcu_as_sc_mcu7t3v3__inv_2_330/VNW
+ VSUBS gf180mcu_as_sc_mcu7t3v3__nand4_2
Xgf180mcu_as_sc_mcu7t3v3__nand4_2_61 VSS VSS VSS VSS VSS VSS gf180mcu_as_sc_mcu7t3v3__nand4_2_61/Y
+ gf180mcu_as_sc_mcu7t3v3__inv_2_306/VNW VSUBS gf180mcu_as_sc_mcu7t3v3__nand4_2
Xgf180mcu_as_sc_mcu7t3v3__nand4_2_94 gf180mcu_as_sc_mcu7t3v3__inv_2_384/VDD VSS VSS
+ VSS VSS VSS VSS gf180mcu_as_sc_mcu7t3v3__inv_2_384/VNW VSUBS gf180mcu_as_sc_mcu7t3v3__nand4_2
Xgf180mcu_as_sc_mcu7t3v3__nand4_2_50 VSS gf180mcu_as_sc_mcu7t3v3__inv_2_153/VDD VSS
+ VSS VSS VSS VSS gf180mcu_as_sc_mcu7t3v3__inv_2_150/VNW VSUBS gf180mcu_as_sc_mcu7t3v3__nand4_2
Xgf180mcu_as_sc_mcu7t3v3__nand4_2_155 VSS VSS VSS VSS VSS VSS VSS gf180mcu_as_sc_mcu7t3v3__inv_2_567/VNW
+ VSUBS gf180mcu_as_sc_mcu7t3v3__nand4_2
Xgf180mcu_as_sc_mcu7t3v3__nand4_2_199 VSS VSS VSS VSS VSS VSS VSS gf180mcu_as_sc_mcu7t3v3__inv_2_755/VNW
+ VSUBS gf180mcu_as_sc_mcu7t3v3__nand4_2
Xgf180mcu_as_sc_mcu7t3v3__nand4_2_188 gf180mcu_as_sc_mcu7t3v3__inv_2_776/VDD gf180mcu_as_sc_mcu7t3v3__inv_2_776/VSS
+ VSS VSS VSS VSS VSS gf180mcu_as_sc_mcu7t3v3__inv_2_776/VNW VSUBS gf180mcu_as_sc_mcu7t3v3__nand4_2
Xgf180mcu_as_sc_mcu7t3v3__nand4_2_166 gf180mcu_as_sc_mcu7t3v3__inv_2_603/VDD VSS VSS
+ VSS VSS VSS VSS gf180mcu_as_sc_mcu7t3v3__inv_2_603/VNW VSUBS gf180mcu_as_sc_mcu7t3v3__nand4_2
Xgf180mcu_as_sc_mcu7t3v3__nand4_2_177 VSS VSS VSS VSS VSS VSS VSS gf180mcu_as_sc_mcu7t3v3__inv_2_707/VNW
+ VSUBS gf180mcu_as_sc_mcu7t3v3__nand4_2
Xgf180mcu_as_sc_mcu7t3v3__inv_2_119 VSS gf180mcu_as_sc_mcu7t3v3__inv_2_123/VDD gf180mcu_as_sc_mcu7t3v3__inv_2_177/Y
+ gf180mcu_as_sc_mcu7t3v3__inv_2_177/Y gf180mcu_as_sc_mcu7t3v3__inv_2_120/VNW VSUBS
+ gf180mcu_as_sc_mcu7t3v3__inv_2
Xgf180mcu_as_sc_mcu7t3v3__inv_2_108 VSS VSS VSS VSS gf180mcu_as_sc_mcu7t3v3__inv_2_108/VNW
+ VSUBS gf180mcu_as_sc_mcu7t3v3__inv_2
Xgf180mcu_as_sc_mcu7t3v3__inv_2_620 VSS VSS VSS VSS gf180mcu_as_sc_mcu7t3v3__inv_2_622/VNW
+ VSUBS gf180mcu_as_sc_mcu7t3v3__inv_2
Xu_t008_005 u_t008_005/c0_w0_bl u_t008_005/c0_w0_br u_t008_005/c0_w1_bl u_t008_005/c0_w1_br
+ u_t008_005/c0_r0_rbl u_t008_005/c0_r1_rbl u_t008_005/c1_w0_bl u_t008_005/c1_w0_br
+ u_t008_005/c1_w1_bl u_t008_005/c1_w1_br u_t008_005/c1_r0_rbl u_t008_005/c1_r1_rbl
+ u_t008_005/c2_w0_bl u_t008_005/c2_w0_br u_t008_005/c2_w1_bl u_t008_005/c2_w1_br
+ u_t008_005/c2_r0_rbl u_t008_005/c2_r1_rbl u_t008_005/c3_w0_bl u_t008_005/c3_w0_br
+ u_t008_005/c3_w1_bl u_t008_005/c3_w1_br u_t008_005/c3_r0_rbl u_t008_005/c3_r1_rbl
+ u_t008_005/r0_w0_wl u_t008_005/r0_w1_wl u_t008_005/r0_r0_rwl u_t008_005/r0_r1_rwl
+ u_t008_005/r1_w0_wl u_t008_005/r1_w1_wl u_t008_005/r1_r0_rwl u_t008_005/r1_r1_rwl
+ u_t008_005/r2_w0_wl u_t008_005/r2_w1_wl u_t008_005/r2_r0_rwl u_t008_005/r2_r1_rwl
+ u_t008_005/r3_w0_wl u_t008_005/r3_w1_wl u_t008_005/r3_r0_rwl u_t008_005/r3_r1_rwl
+ u_t008_005/VDD u_t008_015/VSS VSUBS detronyx_12t_2w2r_rc4_4x4_routed_5layer_direct
Xgf180mcu_as_sc_mcu7t3v3__inv_2_642 VSS VSS gf180mcu_as_sc_mcu7t3v3__inv_2_642/Y VSS
+ gf180mcu_as_sc_mcu7t3v3__inv_2_642/VNW VSUBS gf180mcu_as_sc_mcu7t3v3__inv_2
Xgf180mcu_as_sc_mcu7t3v3__inv_2_631 VSS VSS VSS VSS gf180mcu_as_sc_mcu7t3v3__inv_2_642/VNW
+ VSUBS gf180mcu_as_sc_mcu7t3v3__inv_2
Xgf180mcu_as_sc_mcu7t3v3__inv_2_675 VSS VSS VSS VSS gf180mcu_as_sc_mcu7t3v3__inv_2_709/VNW
+ VSUBS gf180mcu_as_sc_mcu7t3v3__inv_2
Xgf180mcu_as_sc_mcu7t3v3__inv_2_686 gf180mcu_as_sc_mcu7t3v3__inv_2_713/VDD gf180mcu_as_sc_mcu7t3v3__nor2_2_8/VSS
+ VSS VSS gf180mcu_as_sc_mcu7t3v3__inv_2_713/VNW VSUBS gf180mcu_as_sc_mcu7t3v3__inv_2
Xgf180mcu_as_sc_mcu7t3v3__inv_2_697 gf180mcu_as_sc_mcu7t3v3__nor2_2_8/VDD gf180mcu_as_sc_mcu7t3v3__nor2_2_8/VSS
+ gf180mcu_as_sc_mcu7t3v3__inv_2_697/Y VSS gf180mcu_as_sc_mcu7t3v3__nor2_2_8/VNW VSUBS
+ gf180mcu_as_sc_mcu7t3v3__inv_2
Xgf180mcu_as_sc_mcu7t3v3__inv_2_664 gf180mcu_as_sc_mcu7t3v3__nor2_2_8/VDD gf180mcu_as_sc_mcu7t3v3__inv_2_710/VSS
+ VSS VSS gf180mcu_as_sc_mcu7t3v3__nor2_2_8/VNW VSUBS gf180mcu_as_sc_mcu7t3v3__inv_2
Xgf180mcu_as_sc_mcu7t3v3__inv_2_653 gf180mcu_as_sc_mcu7t3v3__nor2_2_8/VDD gf180mcu_as_sc_mcu7t3v3__inv_2_710/VSS
+ VSS VSS gf180mcu_as_sc_mcu7t3v3__nor2_2_8/VNW VSUBS gf180mcu_as_sc_mcu7t3v3__inv_2
Xu_t014_008 u_t014_008/c0_w0_bl u_t014_008/c0_w0_br u_t014_008/c0_w1_bl u_t014_008/c0_w1_br
+ u_t014_008/c0_r0_rbl u_t014_008/c0_r1_rbl u_t014_008/c1_w0_bl u_t014_008/c1_w0_br
+ u_t014_008/c1_w1_bl u_t014_008/c1_w1_br u_t014_008/c1_r0_rbl u_t014_008/c1_r1_rbl
+ u_t014_008/c2_w0_bl u_t014_008/c2_w0_br u_t014_008/c2_w1_bl u_t014_008/c2_w1_br
+ u_t014_008/c2_r0_rbl u_t014_008/c2_r1_rbl u_t014_008/c3_w0_bl u_t014_008/c3_w0_br
+ u_t014_008/c3_w1_bl u_t014_008/c3_w1_br u_t014_008/c3_r0_rbl u_t014_008/c3_r1_rbl
+ u_t014_008/r0_w0_wl u_t014_008/r0_w1_wl u_t014_008/r0_r0_rwl u_t014_008/r0_r1_rwl
+ u_t014_008/r1_w0_wl u_t014_008/r1_w1_wl u_t014_008/r1_r0_rwl u_t014_008/r1_r1_rwl
+ u_t014_008/r2_w0_wl u_t014_008/r2_w1_wl u_t014_008/r2_r0_rwl u_t014_008/r2_r1_rwl
+ u_t014_008/r3_w0_wl u_t014_008/r3_w1_wl u_t014_008/r3_r0_rwl u_t014_008/r3_r1_rwl
+ VSS u_t014_009/VSS VSUBS detronyx_12t_2w2r_rc4_4x4_routed_5layer_direct
Xu_t005_008 u_t005_008/c0_w0_bl u_t005_008/c0_w0_br u_t005_008/c0_w1_bl u_t005_008/c0_w1_br
+ u_t005_008/c0_r0_rbl u_t005_008/c0_r1_rbl u_t005_008/c1_w0_bl u_t005_008/c1_w0_br
+ u_t005_008/c1_w1_bl u_t005_008/c1_w1_br u_t005_008/c1_r0_rbl u_t005_008/c1_r1_rbl
+ u_t005_008/c2_w0_bl u_t005_008/c2_w0_br u_t005_008/c2_w1_bl u_t005_008/c2_w1_br
+ u_t005_008/c2_r0_rbl u_t005_008/c2_r1_rbl u_t005_008/c3_w0_bl u_t005_008/c3_w0_br
+ u_t005_008/c3_w1_bl u_t005_008/c3_w1_br u_t005_008/c3_r0_rbl u_t005_008/c3_r1_rbl
+ u_t005_008/r0_w0_wl u_t005_008/r0_w1_wl u_t005_008/r0_r0_rwl u_t005_008/r0_r1_rwl
+ u_t005_008/r1_w0_wl u_t005_008/r1_w1_wl u_t005_008/r1_r0_rwl u_t005_008/r1_r1_rwl
+ u_t005_008/r2_w0_wl u_t005_008/r2_w1_wl u_t005_008/r2_r0_rwl u_t005_008/r2_r1_rwl
+ u_t005_008/r3_w0_wl u_t005_008/r3_w1_wl u_t005_008/r3_r0_rwl u_t005_008/r3_r1_rwl
+ VSS u_t005_015/VSS VSUBS detronyx_12t_2w2r_rc4_4x4_routed_5layer_direct
Xgf180mcu_as_sc_mcu7t3v3__inv_2_461 VSS VSS VSS VSS gf180mcu_as_sc_mcu7t3v3__inv_2_461/VNW
+ VSUBS gf180mcu_as_sc_mcu7t3v3__inv_2
Xgf180mcu_as_sc_mcu7t3v3__inv_2_450 VSS VSS VSS VSS gf180mcu_as_sc_mcu7t3v3__inv_2_452/VNW
+ VSUBS gf180mcu_as_sc_mcu7t3v3__inv_2
Xgf180mcu_as_sc_mcu7t3v3__inv_2_472 VSS VSS VSS VSS gf180mcu_as_sc_mcu7t3v3__inv_2_474/VNW
+ VSUBS gf180mcu_as_sc_mcu7t3v3__inv_2
Xgf180mcu_as_sc_mcu7t3v3__inv_2_494 VSS VSS VSS VSS gf180mcu_as_sc_mcu7t3v3__inv_2_495/VNW
+ VSUBS gf180mcu_as_sc_mcu7t3v3__inv_2
Xgf180mcu_as_sc_mcu7t3v3__inv_2_483 VSS VSS VSS VSS gf180mcu_as_sc_mcu7t3v3__inv_2_483/VNW
+ VSUBS gf180mcu_as_sc_mcu7t3v3__inv_2
Xu_t010_000 u_t010_000/c0_w0_bl u_t010_000/c0_w0_br u_t010_000/c0_w1_bl u_t010_000/c0_w1_br
+ u_t010_000/c0_r0_rbl u_t010_000/c0_r1_rbl u_t010_000/c1_w0_bl u_t010_000/c1_w0_br
+ u_t010_000/c1_w1_bl u_t010_000/c1_w1_br u_t010_000/c1_r0_rbl u_t010_000/c1_r1_rbl
+ u_t010_000/c2_w0_bl u_t010_000/c2_w0_br u_t010_000/c2_w1_bl u_t010_000/c2_w1_br
+ u_t010_000/c2_r0_rbl u_t010_000/c2_r1_rbl u_t010_000/c3_w0_bl u_t010_000/c3_w0_br
+ u_t010_000/c3_w1_bl u_t010_000/c3_w1_br u_t010_000/c3_r0_rbl u_t010_000/c3_r1_rbl
+ u_t010_000/r0_w0_wl u_t010_000/r0_w1_wl u_t010_000/r0_r0_rwl u_t010_000/r0_r1_rwl
+ u_t010_000/r1_w0_wl u_t010_000/r1_w1_wl u_t010_000/r1_r0_rwl u_t010_000/r1_r1_rwl
+ u_t010_000/r2_w0_wl u_t010_000/r2_w1_wl u_t010_000/r2_r0_rwl u_t010_000/r2_r1_rwl
+ u_t010_000/r3_w0_wl u_t010_000/r3_w1_wl u_t010_000/r3_r0_rwl u_t010_000/r3_r1_rwl
+ VSS u_t010_002/VSS VSUBS detronyx_12t_2w2r_rc4_4x4_routed_5layer_direct
Xu_t010_011 u_t010_011/c0_w0_bl u_t010_011/c0_w0_br u_t010_011/c0_w1_bl u_t010_011/c0_w1_br
+ u_t010_011/c0_r0_rbl u_t010_011/c0_r1_rbl u_t010_011/c1_w0_bl u_t010_011/c1_w0_br
+ u_t010_011/c1_w1_bl u_t010_011/c1_w1_br u_t010_011/c1_r0_rbl u_t010_011/c1_r1_rbl
+ u_t010_011/c2_w0_bl u_t010_011/c2_w0_br u_t010_011/c2_w1_bl u_t010_011/c2_w1_br
+ u_t010_011/c2_r0_rbl u_t010_011/c2_r1_rbl u_t010_011/c3_w0_bl u_t010_011/c3_w0_br
+ u_t010_011/c3_w1_bl u_t010_011/c3_w1_br u_t010_011/c3_r0_rbl u_t010_011/c3_r1_rbl
+ u_t010_011/r0_w0_wl u_t010_011/r0_w1_wl u_t010_011/r0_r0_rwl u_t010_011/r0_r1_rwl
+ u_t010_011/r1_w0_wl u_t010_011/r1_w1_wl u_t010_011/r1_r0_rwl u_t010_011/r1_r1_rwl
+ u_t010_011/r2_w0_wl u_t010_011/r2_w1_wl u_t010_011/r2_r0_rwl u_t010_011/r2_r1_rwl
+ u_t010_011/r3_w0_wl u_t010_011/r3_w1_wl u_t010_011/r3_r0_rwl u_t010_011/r3_r1_rwl
+ u_t010_011/VDD u_t010_011/VSS VSUBS detronyx_12t_2w2r_rc4_4x4_routed_5layer_direct
Xu_t001_000 u_t001_000/c0_w0_bl u_t001_000/c0_w0_br u_t001_000/c0_w1_bl u_t001_000/c0_w1_br
+ u_t001_000/c0_r0_rbl u_t001_000/c0_r1_rbl u_t001_000/c1_w0_bl u_t001_000/c1_w0_br
+ u_t001_000/c1_w1_bl u_t001_000/c1_w1_br u_t001_000/c1_r0_rbl u_t001_000/c1_r1_rbl
+ u_t001_000/c2_w0_bl u_t001_000/c2_w0_br u_t001_000/c2_w1_bl u_t001_000/c2_w1_br
+ u_t001_000/c2_r0_rbl u_t001_000/c2_r1_rbl u_t001_000/c3_w0_bl u_t001_000/c3_w0_br
+ u_t001_000/c3_w1_bl u_t001_000/c3_w1_br u_t001_000/c3_r0_rbl u_t001_000/c3_r1_rbl
+ u_t001_000/r0_w0_wl u_t001_000/r0_w1_wl u_t001_000/r0_r0_rwl u_t001_000/r0_r1_rwl
+ u_t001_000/r1_w0_wl u_t001_000/r1_w1_wl u_t001_000/r1_r0_rwl u_t001_000/r1_r1_rwl
+ u_t001_000/r2_w0_wl u_t001_000/r2_w1_wl u_t001_000/r2_r0_rwl u_t001_000/r2_r1_rwl
+ u_t001_000/r3_w0_wl u_t001_000/r3_w1_wl u_t001_000/r3_r0_rwl u_t001_000/r3_r1_rwl
+ VSS u_t001_015/VSS VSUBS detronyx_12t_2w2r_rc4_4x4_routed_5layer_direct
Xu_t001_011 u_t001_011/c0_w0_bl u_t001_011/c0_w0_br u_t001_011/c0_w1_bl u_t001_011/c0_w1_br
+ u_t001_011/c0_r0_rbl u_t001_011/c0_r1_rbl u_t001_011/c1_w0_bl u_t001_011/c1_w0_br
+ u_t001_011/c1_w1_bl u_t001_011/c1_w1_br u_t001_011/c1_r0_rbl u_t001_011/c1_r1_rbl
+ u_t001_011/c2_w0_bl u_t001_011/c2_w0_br u_t001_011/c2_w1_bl u_t001_011/c2_w1_br
+ u_t001_011/c2_r0_rbl u_t001_011/c2_r1_rbl u_t001_011/c3_w0_bl u_t001_011/c3_w0_br
+ u_t001_011/c3_w1_bl u_t001_011/c3_w1_br u_t001_011/c3_r0_rbl u_t001_011/c3_r1_rbl
+ u_t001_011/r0_w0_wl u_t001_011/r0_w1_wl u_t001_011/r0_r0_rwl u_t001_011/r0_r1_rwl
+ u_t001_011/r1_w0_wl u_t001_011/r1_w1_wl u_t001_011/r1_r0_rwl u_t001_011/r1_r1_rwl
+ u_t001_011/r2_w0_wl u_t001_011/r2_w1_wl u_t001_011/r2_r0_rwl u_t001_011/r2_r1_rwl
+ u_t001_011/r3_w0_wl u_t001_011/r3_w1_wl u_t001_011/r3_r0_rwl u_t001_011/r3_r1_rwl
+ u_t001_011/VDD u_t001_015/VSS VSUBS detronyx_12t_2w2r_rc4_4x4_routed_5layer_direct
Xgf180mcu_as_sc_mcu7t3v3__inv_2_291 VSS VSS gf180mcu_as_sc_mcu7t3v3__inv_2_291/Y VSS
+ gf180mcu_as_sc_mcu7t3v3__inv_2_299/VNW VSUBS gf180mcu_as_sc_mcu7t3v3__inv_2
Xgf180mcu_as_sc_mcu7t3v3__inv_2_280 gf180mcu_as_sc_mcu7t3v3__nor2_2_6/VDD gf180mcu_as_sc_mcu7t3v3__nor2_2_6/VSS
+ gf180mcu_as_sc_mcu7t3v3__inv_2_280/Y VSS gf180mcu_as_sc_mcu7t3v3__nor2_2_6/VNW VSUBS
+ gf180mcu_as_sc_mcu7t3v3__inv_2
Xgf180mcu_as_sc_mcu7t3v3__inv_2_17 gf180mcu_as_sc_mcu7t3v3__inv_2_18/VDD VSS gf180mcu_as_sc_mcu7t3v3__inv_2_17/Y
+ gf180mcu_as_sc_mcu7t3v3__inv_2_18/Y gf180mcu_as_sc_mcu7t3v3__inv_2_18/VNW VSUBS
+ gf180mcu_as_sc_mcu7t3v3__inv_2
Xgf180mcu_as_sc_mcu7t3v3__inv_2_39 gf180mcu_as_sc_mcu7t3v3__inv_2_39/VDD gf180mcu_as_sc_mcu7t3v3__inv_2_45/VDD
+ gf180mcu_as_sc_mcu7t3v3__inv_2_39/Y VSS gf180mcu_as_sc_mcu7t3v3__inv_2_39/VNW VSUBS
+ gf180mcu_as_sc_mcu7t3v3__inv_2
Xgf180mcu_as_sc_mcu7t3v3__inv_2_28 gf180mcu_as_sc_mcu7t3v3__inv_2_9/VDD gf180mcu_as_sc_mcu7t3v3__inv_2_9/VDD
+ VSS gf180mcu_as_sc_mcu7t3v3__inv_2_9/A gf180mcu_as_sc_mcu7t3v3__inv_2_0/VNW VSUBS
+ gf180mcu_as_sc_mcu7t3v3__inv_2
Xgf180mcu_as_sc_mcu7t3v3__nand3_2_9 gf180mcu_as_sc_mcu7t3v3__nor2_2_4/VDD gf180mcu_as_sc_mcu7t3v3__nor2_2_4/VSS
+ VSS VSS VSS VSS gf180mcu_as_sc_mcu7t3v3__nor2_2_4/VNW VSUBS gf180mcu_as_sc_mcu7t3v3__nand3_2
Xgf180mcu_as_sc_mcu7t3v3__inv_2_802 gf180mcu_as_sc_mcu7t3v3__inv_2_803/VDD VSS gf180mcu_as_sc_mcu7t3v3__inv_2_802/Y
+ VSS gf180mcu_as_sc_mcu7t3v3__inv_2_803/VNW VSUBS gf180mcu_as_sc_mcu7t3v3__inv_2
Xgf180mcu_as_sc_mcu7t3v3__inv_2_824 VSS gf180mcu_as_sc_mcu7t3v3__inv_2_926/VDD gf180mcu_as_sc_mcu7t3v3__inv_2_824/Y
+ VSS gf180mcu_as_sc_mcu7t3v3__inv_2_824/VNW VSUBS gf180mcu_as_sc_mcu7t3v3__inv_2
Xgf180mcu_as_sc_mcu7t3v3__inv_2_813 VSS VSS gf180mcu_as_sc_mcu7t3v3__inv_2_813/Y VSS
+ gf180mcu_as_sc_mcu7t3v3__inv_2_815/VNW VSUBS gf180mcu_as_sc_mcu7t3v3__inv_2
Xgf180mcu_as_sc_mcu7t3v3__inv_2_868 gf180mcu_as_sc_mcu7t3v3__inv_2_869/VDD VSS VSS
+ VSS gf180mcu_as_sc_mcu7t3v3__inv_2_869/VNW VSUBS gf180mcu_as_sc_mcu7t3v3__inv_2
Xgf180mcu_as_sc_mcu7t3v3__inv_2_857 gf180mcu_as_sc_mcu7t3v3__inv_2_857/VDD gf180mcu_as_sc_mcu7t3v3__inv_2_860/VDD
+ gf180mcu_as_sc_mcu7t3v3__inv_2_857/Y VSS gf180mcu_as_sc_mcu7t3v3__inv_2_857/VNW
+ VSUBS gf180mcu_as_sc_mcu7t3v3__inv_2
Xgf180mcu_as_sc_mcu7t3v3__inv_2_846 gf180mcu_as_sc_mcu7t3v3__inv_2_848/VDD gf180mcu_as_sc_mcu7t3v3__inv_2_854/VDD
+ gf180mcu_as_sc_mcu7t3v3__inv_2_846/Y VSS gf180mcu_as_sc_mcu7t3v3__inv_2_848/VNW
+ VSUBS gf180mcu_as_sc_mcu7t3v3__inv_2
Xgf180mcu_as_sc_mcu7t3v3__inv_2_879 gf180mcu_as_sc_mcu7t3v3__inv_2_884/VDD gf180mcu_as_sc_mcu7t3v3__inv_2_884/VDD
+ VSS gf180mcu_as_sc_mcu7t3v3__inv_2_887/Y gf180mcu_as_sc_mcu7t3v3__inv_2_881/VNW
+ VSUBS gf180mcu_as_sc_mcu7t3v3__inv_2
Xgf180mcu_as_sc_mcu7t3v3__inv_2_835 gf180mcu_as_sc_mcu7t3v3__inv_2_836/VDD gf180mcu_as_sc_mcu7t3v3__inv_2_839/VDD
+ gf180mcu_as_sc_mcu7t3v3__inv_2_835/Y VSS gf180mcu_as_sc_mcu7t3v3__inv_2_836/VNW
+ VSUBS gf180mcu_as_sc_mcu7t3v3__inv_2
Xgf180mcu_as_sc_mcu7t3v3__nand4_2_101 VSS VSS VSS VSS VSS VSS gf180mcu_as_sc_mcu7t3v3__nand4_2_101/Y
+ gf180mcu_as_sc_mcu7t3v3__inv_2_462/VNW VSUBS gf180mcu_as_sc_mcu7t3v3__nand4_2
Xgf180mcu_as_sc_mcu7t3v3__nand4_2_112 VSS VSS VSS VSS VSS VSS VSS gf180mcu_as_sc_mcu7t3v3__inv_2_440/VNW
+ VSUBS gf180mcu_as_sc_mcu7t3v3__nand4_2
Xgf180mcu_as_sc_mcu7t3v3__nand4_2_156 VSS gf180mcu_as_sc_mcu7t3v3__inv_2_932/VDD VSS
+ VSS VSS VSS VSS gf180mcu_as_sc_mcu7t3v3__inv_2_570/VNW VSUBS gf180mcu_as_sc_mcu7t3v3__nand4_2
Xgf180mcu_as_sc_mcu7t3v3__nand4_2_134 VSS VSS VSS VSS VSS VSS VSS gf180mcu_as_sc_mcu7t3v3__inv_2_504/VNW
+ VSUBS gf180mcu_as_sc_mcu7t3v3__nand4_2
Xgf180mcu_as_sc_mcu7t3v3__nand4_2_145 gf180mcu_as_sc_mcu7t3v3__inv_2_537/VDD gf180mcu_as_sc_mcu7t3v3__inv_2_540/VDD
+ VSS VSS VSS VSS VSS gf180mcu_as_sc_mcu7t3v3__inv_2_537/VNW VSUBS gf180mcu_as_sc_mcu7t3v3__nand4_2
Xgf180mcu_as_sc_mcu7t3v3__nand4_2_123 VSS VSS VSS VSS VSS VSS gf180mcu_as_sc_mcu7t3v3__nand4_2_123/Y
+ gf180mcu_as_sc_mcu7t3v3__inv_2_471/VNW VSUBS gf180mcu_as_sc_mcu7t3v3__nand4_2
Xgf180mcu_as_sc_mcu7t3v3__nand4_2_167 VSS gf180mcu_as_sc_mcu7t3v3__inv_2_609/VDD VSS
+ VSS VSS VSS VSS gf180mcu_as_sc_mcu7t3v3__inv_2_606/VNW VSUBS gf180mcu_as_sc_mcu7t3v3__nand4_2
Xgf180mcu_as_sc_mcu7t3v3__nand4_2_84 gf180mcu_as_sc_mcu7t3v3__inv_2_354/VDD gf180mcu_as_sc_mcu7t3v3__inv_2_468/VDD
+ VSS VSS VSS VSS VSS gf180mcu_as_sc_mcu7t3v3__inv_2_354/VNW VSUBS gf180mcu_as_sc_mcu7t3v3__nand4_2
Xgf180mcu_as_sc_mcu7t3v3__nand4_2_73 VSS gf180mcu_as_sc_mcu7t3v3__inv_2_338/VDD VSS
+ VSS VSS VSS VSS gf180mcu_as_sc_mcu7t3v3__inv_2_334/VNW VSUBS gf180mcu_as_sc_mcu7t3v3__nand4_2
Xgf180mcu_as_sc_mcu7t3v3__nand4_2_62 VSS VSS VSS VSS VSS VSS gf180mcu_as_sc_mcu7t3v3__nand4_2_62/Y
+ gf180mcu_as_sc_mcu7t3v3__inv_2_286/VNW VSUBS gf180mcu_as_sc_mcu7t3v3__nand4_2
Xgf180mcu_as_sc_mcu7t3v3__nand4_2_40 VSS gf180mcu_as_sc_mcu7t3v3__inv_2_123/VDD VSS
+ VSS VSS VSS VSS gf180mcu_as_sc_mcu7t3v3__inv_2_120/VNW VSUBS gf180mcu_as_sc_mcu7t3v3__nand4_2
Xgf180mcu_as_sc_mcu7t3v3__nand4_2_95 VSS VSS VSS VSS VSS VSS VSS gf180mcu_as_sc_mcu7t3v3__inv_2_387/VNW
+ VSUBS gf180mcu_as_sc_mcu7t3v3__nand4_2
Xgf180mcu_as_sc_mcu7t3v3__nand4_2_51 gf180mcu_as_sc_mcu7t3v3__inv_2_153/VDD gf180mcu_as_sc_mcu7t3v3__inv_2_159/VDD
+ VSS VSS VSS VSS VSS gf180mcu_as_sc_mcu7t3v3__inv_2_153/VNW VSUBS gf180mcu_as_sc_mcu7t3v3__nand4_2
Xgf180mcu_as_sc_mcu7t3v3__nand4_2_189 gf180mcu_as_sc_mcu7t3v3__inv_2_776/VSS gf180mcu_as_sc_mcu7t3v3__inv_2_776/VSS
+ VSS VSS VSS VSS VSS gf180mcu_as_sc_mcu7t3v3__inv_2_725/VNW VSUBS gf180mcu_as_sc_mcu7t3v3__nand4_2
Xgf180mcu_as_sc_mcu7t3v3__nand4_2_178 VSS VSS VSS VSS VSS VSS gf180mcu_as_sc_mcu7t3v3__nand4_2_178/Y
+ gf180mcu_as_sc_mcu7t3v3__inv_2_708/VNW VSUBS gf180mcu_as_sc_mcu7t3v3__nand4_2
Xgf180mcu_as_sc_mcu7t3v3__inv_2_109 VSS gf180mcu_as_sc_mcu7t3v3__inv_2_114/VDD gf180mcu_as_sc_mcu7t3v3__inv_2_109/Y
+ VSS gf180mcu_as_sc_mcu7t3v3__inv_2_111/VNW VSUBS gf180mcu_as_sc_mcu7t3v3__inv_2
Xgf180mcu_as_sc_mcu7t3v3__inv_2_632 VSS VSS VSS VSS gf180mcu_as_sc_mcu7t3v3__inv_2_634/VNW
+ VSUBS gf180mcu_as_sc_mcu7t3v3__inv_2
Xgf180mcu_as_sc_mcu7t3v3__inv_2_621 VSS VSS VSS VSS gf180mcu_as_sc_mcu7t3v3__inv_2_622/VNW
+ VSUBS gf180mcu_as_sc_mcu7t3v3__inv_2
Xgf180mcu_as_sc_mcu7t3v3__inv_2_610 gf180mcu_as_sc_mcu7t3v3__inv_2_612/VDD VSS gf180mcu_as_sc_mcu7t3v3__inv_2_610/Y
+ gf180mcu_as_sc_mcu7t3v3__inv_2_611/Y gf180mcu_as_sc_mcu7t3v3__inv_2_612/VNW VSUBS
+ gf180mcu_as_sc_mcu7t3v3__inv_2
Xgf180mcu_as_sc_mcu7t3v3__inv_2_643 VSS VSS VSS VSS gf180mcu_as_sc_mcu7t3v3__inv_2_645/VNW
+ VSUBS gf180mcu_as_sc_mcu7t3v3__inv_2
Xgf180mcu_as_sc_mcu7t3v3__inv_2_654 gf180mcu_as_sc_mcu7t3v3__nor2_2_8/VDD gf180mcu_as_sc_mcu7t3v3__nor2_2_8/VSS
+ VSS VSS gf180mcu_as_sc_mcu7t3v3__nor2_2_8/VNW VSUBS gf180mcu_as_sc_mcu7t3v3__inv_2
Xu_t008_006 u_t008_006/c0_w0_bl u_t008_006/c0_w0_br u_t008_006/c0_w1_bl u_t008_006/c0_w1_br
+ u_t008_006/c0_r0_rbl u_t008_006/c0_r1_rbl u_t008_006/c1_w0_bl u_t008_006/c1_w0_br
+ u_t008_006/c1_w1_bl u_t008_006/c1_w1_br u_t008_006/c1_r0_rbl u_t008_006/c1_r1_rbl
+ u_t008_006/c2_w0_bl u_t008_006/c2_w0_br u_t008_006/c2_w1_bl u_t008_006/c2_w1_br
+ u_t008_006/c2_r0_rbl u_t008_006/c2_r1_rbl u_t008_006/c3_w0_bl u_t008_006/c3_w0_br
+ u_t008_006/c3_w1_bl u_t008_006/c3_w1_br u_t008_006/c3_r0_rbl u_t008_006/c3_r1_rbl
+ u_t008_006/r0_w0_wl u_t008_006/r0_w1_wl u_t008_006/r0_r0_rwl u_t008_006/r0_r1_rwl
+ u_t008_006/r1_w0_wl u_t008_006/r1_w1_wl u_t008_006/r1_r0_rwl u_t008_006/r1_r1_rwl
+ u_t008_006/r2_w0_wl u_t008_006/r2_w1_wl u_t008_006/r2_r0_rwl u_t008_006/r2_r1_rwl
+ u_t008_006/r3_w0_wl u_t008_006/r3_w1_wl u_t008_006/r3_r0_rwl u_t008_006/r3_r1_rwl
+ u_t008_006/VDD u_t008_015/VSS VSUBS detronyx_12t_2w2r_rc4_4x4_routed_5layer_direct
Xgf180mcu_as_sc_mcu7t3v3__inv_2_687 gf180mcu_as_sc_mcu7t3v3__inv_2_713/VDD gf180mcu_as_sc_mcu7t3v3__inv_2_713/VSS
+ VSS VSS gf180mcu_as_sc_mcu7t3v3__inv_2_713/VNW VSUBS gf180mcu_as_sc_mcu7t3v3__inv_2
Xgf180mcu_as_sc_mcu7t3v3__inv_2_698 gf180mcu_as_sc_mcu7t3v3__inv_2_713/VDD gf180mcu_as_sc_mcu7t3v3__nor2_2_8/VSS
+ gf180mcu_as_sc_mcu7t3v3__inv_2_698/Y VSS gf180mcu_as_sc_mcu7t3v3__inv_2_713/VNW
+ VSUBS gf180mcu_as_sc_mcu7t3v3__inv_2
Xgf180mcu_as_sc_mcu7t3v3__inv_2_665 gf180mcu_as_sc_mcu7t3v3__nor2_2_8/VDD gf180mcu_as_sc_mcu7t3v3__nor2_2_8/VSS
+ VSS VSS gf180mcu_as_sc_mcu7t3v3__nor2_2_8/VNW VSUBS gf180mcu_as_sc_mcu7t3v3__inv_2
Xgf180mcu_as_sc_mcu7t3v3__inv_2_676 gf180mcu_as_sc_mcu7t3v3__nor2_2_8/VDD gf180mcu_as_sc_mcu7t3v3__nor2_2_8/VSS
+ VSS VSS gf180mcu_as_sc_mcu7t3v3__nor2_2_8/VNW VSUBS gf180mcu_as_sc_mcu7t3v3__inv_2
Xu_t014_009 u_t014_009/c0_w0_bl u_t014_009/c0_w0_br u_t014_009/c0_w1_bl u_t014_009/c0_w1_br
+ u_t014_009/c0_r0_rbl u_t014_009/c0_r1_rbl u_t014_009/c1_w0_bl u_t014_009/c1_w0_br
+ u_t014_009/c1_w1_bl u_t014_009/c1_w1_br u_t014_009/c1_r0_rbl u_t014_009/c1_r1_rbl
+ u_t014_009/c2_w0_bl u_t014_009/c2_w0_br u_t014_009/c2_w1_bl u_t014_009/c2_w1_br
+ u_t014_009/c2_r0_rbl u_t014_009/c2_r1_rbl u_t014_009/c3_w0_bl u_t014_009/c3_w0_br
+ u_t014_009/c3_w1_bl u_t014_009/c3_w1_br u_t014_009/c3_r0_rbl u_t014_009/c3_r1_rbl
+ u_t014_009/r0_w0_wl u_t014_009/r0_w1_wl u_t014_009/r0_r0_rwl u_t014_009/r0_r1_rwl
+ u_t014_009/r1_w0_wl u_t014_009/r1_w1_wl u_t014_009/r1_r0_rwl u_t014_009/r1_r1_rwl
+ u_t014_009/r2_w0_wl u_t014_009/r2_w1_wl u_t014_009/r2_r0_rwl u_t014_009/r2_r1_rwl
+ u_t014_009/r3_w0_wl u_t014_009/r3_w1_wl u_t014_009/r3_r0_rwl u_t014_009/r3_r1_rwl
+ VSS u_t014_009/VSS VSUBS detronyx_12t_2w2r_rc4_4x4_routed_5layer_direct
Xu_t005_009 u_t005_009/c0_w0_bl u_t005_009/c0_w0_br u_t005_009/c0_w1_bl u_t005_009/c0_w1_br
+ u_t005_009/c0_r0_rbl u_t005_009/c0_r1_rbl u_t005_009/c1_w0_bl u_t005_009/c1_w0_br
+ u_t005_009/c1_w1_bl u_t005_009/c1_w1_br u_t005_009/c1_r0_rbl u_t005_009/c1_r1_rbl
+ u_t005_009/c2_w0_bl u_t005_009/c2_w0_br u_t005_009/c2_w1_bl u_t005_009/c2_w1_br
+ u_t005_009/c2_r0_rbl u_t005_009/c2_r1_rbl u_t005_009/c3_w0_bl u_t005_009/c3_w0_br
+ u_t005_009/c3_w1_bl u_t005_009/c3_w1_br u_t005_009/c3_r0_rbl u_t005_009/c3_r1_rbl
+ u_t005_009/r0_w0_wl u_t005_009/r0_w1_wl u_t005_009/r0_r0_rwl u_t005_009/r0_r1_rwl
+ u_t005_009/r1_w0_wl u_t005_009/r1_w1_wl u_t005_009/r1_r0_rwl u_t005_009/r1_r1_rwl
+ u_t005_009/r2_w0_wl u_t005_009/r2_w1_wl u_t005_009/r2_r0_rwl u_t005_009/r2_r1_rwl
+ u_t005_009/r3_w0_wl u_t005_009/r3_w1_wl u_t005_009/r3_r0_rwl u_t005_009/r3_r1_rwl
+ VSS u_t005_015/VSS VSUBS detronyx_12t_2w2r_rc4_4x4_routed_5layer_direct
Xgf180mcu_as_sc_mcu7t3v3__inv_2_462 VSS VSS VSS VSS gf180mcu_as_sc_mcu7t3v3__inv_2_462/VNW
+ VSUBS gf180mcu_as_sc_mcu7t3v3__inv_2
Xgf180mcu_as_sc_mcu7t3v3__inv_2_451 VSS VSS VSS VSS gf180mcu_as_sc_mcu7t3v3__inv_2_452/VNW
+ VSUBS gf180mcu_as_sc_mcu7t3v3__inv_2
Xgf180mcu_as_sc_mcu7t3v3__inv_2_440 VSS VSS VSS VSS gf180mcu_as_sc_mcu7t3v3__inv_2_440/VNW
+ VSUBS gf180mcu_as_sc_mcu7t3v3__inv_2
Xgf180mcu_as_sc_mcu7t3v3__inv_2_495 VSS VSS VSS VSS gf180mcu_as_sc_mcu7t3v3__inv_2_495/VNW
+ VSUBS gf180mcu_as_sc_mcu7t3v3__inv_2
Xgf180mcu_as_sc_mcu7t3v3__inv_2_484 VSS VSS VSS VSS gf180mcu_as_sc_mcu7t3v3__inv_2_486/VNW
+ VSUBS gf180mcu_as_sc_mcu7t3v3__inv_2
Xgf180mcu_as_sc_mcu7t3v3__inv_2_473 VSS VSS VSS VSS gf180mcu_as_sc_mcu7t3v3__inv_2_474/VNW
+ VSUBS gf180mcu_as_sc_mcu7t3v3__inv_2
Xu_t010_001 u_t010_001/c0_w0_bl u_t010_001/c0_w0_br u_t010_001/c0_w1_bl u_t010_001/c0_w1_br
+ u_t010_001/c0_r0_rbl u_t010_001/c0_r1_rbl u_t010_001/c1_w0_bl u_t010_001/c1_w0_br
+ u_t010_001/c1_w1_bl u_t010_001/c1_w1_br u_t010_001/c1_r0_rbl u_t010_001/c1_r1_rbl
+ u_t010_001/c2_w0_bl u_t010_001/c2_w0_br u_t010_001/c2_w1_bl u_t010_001/c2_w1_br
+ u_t010_001/c2_r0_rbl u_t010_001/c2_r1_rbl u_t010_001/c3_w0_bl u_t010_001/c3_w0_br
+ u_t010_001/c3_w1_bl u_t010_001/c3_w1_br u_t010_001/c3_r0_rbl u_t010_001/c3_r1_rbl
+ u_t010_001/r0_w0_wl u_t010_001/r0_w1_wl u_t010_001/r0_r0_rwl u_t010_001/r0_r1_rwl
+ u_t010_001/r1_w0_wl u_t010_001/r1_w1_wl u_t010_001/r1_r0_rwl u_t010_001/r1_r1_rwl
+ u_t010_001/r2_w0_wl u_t010_001/r2_w1_wl u_t010_001/r2_r0_rwl u_t010_001/r2_r1_rwl
+ u_t010_001/r3_w0_wl u_t010_001/r3_w1_wl u_t010_001/r3_r0_rwl u_t010_001/r3_r1_rwl
+ VSS u_t010_002/VSS VSUBS detronyx_12t_2w2r_rc4_4x4_routed_5layer_direct
Xu_t010_012 u_t010_012/c0_w0_bl u_t010_012/c0_w0_br u_t010_012/c0_w1_bl u_t010_012/c0_w1_br
+ u_t010_012/c0_r0_rbl u_t010_012/c0_r1_rbl u_t010_012/c1_w0_bl u_t010_012/c1_w0_br
+ u_t010_012/c1_w1_bl u_t010_012/c1_w1_br u_t010_012/c1_r0_rbl u_t010_012/c1_r1_rbl
+ u_t010_012/c2_w0_bl u_t010_012/c2_w0_br u_t010_012/c2_w1_bl u_t010_012/c2_w1_br
+ u_t010_012/c2_r0_rbl u_t010_012/c2_r1_rbl u_t010_012/c3_w0_bl u_t010_012/c3_w0_br
+ u_t010_012/c3_w1_bl u_t010_012/c3_w1_br u_t010_012/c3_r0_rbl u_t010_012/c3_r1_rbl
+ u_t010_012/r0_w0_wl u_t010_012/r0_w1_wl u_t010_012/r0_r0_rwl u_t010_012/r0_r1_rwl
+ u_t010_012/r1_w0_wl u_t010_012/r1_w1_wl u_t010_012/r1_r0_rwl u_t010_012/r1_r1_rwl
+ u_t010_012/r2_w0_wl u_t010_012/r2_w1_wl u_t010_012/r2_r0_rwl u_t010_012/r2_r1_rwl
+ u_t010_012/r3_w0_wl u_t010_012/r3_w1_wl u_t010_012/r3_r0_rwl u_t010_012/r3_r1_rwl
+ u_t010_012/VDD u_t010_012/VSS VSUBS detronyx_12t_2w2r_rc4_4x4_routed_5layer_direct
Xu_t001_001 u_t001_001/c0_w0_bl u_t001_001/c0_w0_br u_t001_001/c0_w1_bl u_t001_001/c0_w1_br
+ u_t001_001/c0_r0_rbl u_t001_001/c0_r1_rbl u_t001_001/c1_w0_bl u_t001_001/c1_w0_br
+ u_t001_001/c1_w1_bl u_t001_001/c1_w1_br u_t001_001/c1_r0_rbl u_t001_001/c1_r1_rbl
+ u_t001_001/c2_w0_bl u_t001_001/c2_w0_br u_t001_001/c2_w1_bl u_t001_001/c2_w1_br
+ u_t001_001/c2_r0_rbl u_t001_001/c2_r1_rbl u_t001_001/c3_w0_bl u_t001_001/c3_w0_br
+ u_t001_001/c3_w1_bl u_t001_001/c3_w1_br u_t001_001/c3_r0_rbl u_t001_001/c3_r1_rbl
+ u_t001_001/r0_w0_wl u_t001_001/r0_w1_wl u_t001_001/r0_r0_rwl u_t001_001/r0_r1_rwl
+ u_t001_001/r1_w0_wl u_t001_001/r1_w1_wl u_t001_001/r1_r0_rwl u_t001_001/r1_r1_rwl
+ u_t001_001/r2_w0_wl u_t001_001/r2_w1_wl u_t001_001/r2_r0_rwl u_t001_001/r2_r1_rwl
+ u_t001_001/r3_w0_wl u_t001_001/r3_w1_wl u_t001_001/r3_r0_rwl u_t001_001/r3_r1_rwl
+ VSS u_t001_015/VSS VSUBS detronyx_12t_2w2r_rc4_4x4_routed_5layer_direct
Xu_t001_012 u_t001_012/c0_w0_bl u_t001_012/c0_w0_br u_t001_012/c0_w1_bl u_t001_012/c0_w1_br
+ u_t001_012/c0_r0_rbl u_t001_012/c0_r1_rbl u_t001_012/c1_w0_bl u_t001_012/c1_w0_br
+ u_t001_012/c1_w1_bl u_t001_012/c1_w1_br u_t001_012/c1_r0_rbl u_t001_012/c1_r1_rbl
+ u_t001_012/c2_w0_bl u_t001_012/c2_w0_br u_t001_012/c2_w1_bl u_t001_012/c2_w1_br
+ u_t001_012/c2_r0_rbl u_t001_012/c2_r1_rbl u_t001_012/c3_w0_bl u_t001_012/c3_w0_br
+ u_t001_012/c3_w1_bl u_t001_012/c3_w1_br u_t001_012/c3_r0_rbl u_t001_012/c3_r1_rbl
+ u_t001_012/r0_w0_wl u_t001_012/r0_w1_wl u_t001_012/r0_r0_rwl u_t001_012/r0_r1_rwl
+ u_t001_012/r1_w0_wl u_t001_012/r1_w1_wl u_t001_012/r1_r0_rwl u_t001_012/r1_r1_rwl
+ u_t001_012/r2_w0_wl u_t001_012/r2_w1_wl u_t001_012/r2_r0_rwl u_t001_012/r2_r1_rwl
+ u_t001_012/r3_w0_wl u_t001_012/r3_w1_wl u_t001_012/r3_r0_rwl u_t001_012/r3_r1_rwl
+ u_t001_012/VDD u_t001_015/VSS VSUBS detronyx_12t_2w2r_rc4_4x4_routed_5layer_direct
Xgf180mcu_as_sc_mcu7t3v3__inv_2_292 VSS VSS VSS VSS gf180mcu_as_sc_mcu7t3v3__inv_2_294/VNW
+ VSUBS gf180mcu_as_sc_mcu7t3v3__inv_2
Xgf180mcu_as_sc_mcu7t3v3__inv_2_281 gf180mcu_as_sc_mcu7t3v3__nor2_2_6/VDD gf180mcu_as_sc_mcu7t3v3__nand3_2_1/VSS
+ gf180mcu_as_sc_mcu7t3v3__inv_2_281/Y VSS gf180mcu_as_sc_mcu7t3v3__nor2_2_6/VNW VSUBS
+ gf180mcu_as_sc_mcu7t3v3__inv_2
Xgf180mcu_as_sc_mcu7t3v3__inv_2_270 gf180mcu_as_sc_mcu7t3v3__nor2_2_6/VDD gf180mcu_as_sc_mcu7t3v3__nor2_2_6/VSS
+ VSS VSS gf180mcu_as_sc_mcu7t3v3__nor2_2_6/VNW VSUBS gf180mcu_as_sc_mcu7t3v3__inv_2
Xgf180mcu_as_sc_mcu7t3v3__inv_2_18 gf180mcu_as_sc_mcu7t3v3__inv_2_18/VDD VSS gf180mcu_as_sc_mcu7t3v3__inv_2_18/Y
+ VSS gf180mcu_as_sc_mcu7t3v3__inv_2_18/VNW VSUBS gf180mcu_as_sc_mcu7t3v3__inv_2
Xgf180mcu_as_sc_mcu7t3v3__inv_2_29 gf180mcu_as_sc_mcu7t3v3__inv_2_9/VDD gf180mcu_as_sc_mcu7t3v3__inv_2_9/VDD
+ gf180mcu_as_sc_mcu7t3v3__inv_2_9/A gf180mcu_as_sc_mcu7t3v3__inv_2_9/A gf180mcu_as_sc_mcu7t3v3__inv_2_0/VNW
+ VSUBS gf180mcu_as_sc_mcu7t3v3__inv_2
.ends

.subckt gf180mcu_3v3_12t_2r2w_sram_512x8
Xdetronyx_12t_write_driver_rc1_12 detronyx_12t_write_driver_rc1_12/VDD VSUBS detronyx_12t_write_driver_rc1_12/din
+ detronyx_12t_write_driver_rc1_9/wen detronyx_12t_write_driver_rc1_12/wbl0 detronyx_12t_write_driver_rc1_9/wen
+ detronyx_12t_write_driver_rc1
Xdetronyx_12t_write_driver_rc1_11 detronyx_12t_write_driver_rc1_11/VDD VSUBS detronyx_12t_write_driver_rc1_11/din
+ detronyx_12t_write_driver_rc1_9/wen detronyx_12t_write_driver_rc1_11/wbl0 detronyx_12t_write_driver_rc1_9/wen
+ detronyx_12t_write_driver_rc1
Xdetronyx_12t_write_driver_rc1_13 detronyx_12t_write_driver_rc1_13/VDD VSUBS detronyx_12t_write_driver_rc1_13/din
+ detronyx_12t_write_driver_rc1_9/wen detronyx_12t_write_driver_rc1_13/wbl0 detronyx_12t_write_driver_rc1_9/wen
+ detronyx_12t_write_driver_rc1
Xdetronyx_12t_write_driver_rc1_14 detronyx_12t_write_driver_rc1_14/VDD VSUBS detronyx_12t_write_driver_rc1_14/din
+ detronyx_12t_write_driver_rc1_9/wen detronyx_12t_write_driver_rc1_14/wbl0 detronyx_12t_write_driver_rc1_9/wen
+ detronyx_12t_write_driver_rc1
Xdetronyx_12t_write_driver_rc1_15 detronyx_12t_write_driver_rc1_15/VDD VSUBS detronyx_12t_write_driver_rc1_15/din
+ detronyx_12t_write_driver_rc1_9/wen detronyx_12t_write_driver_rc1_15/wbl0 detronyx_12t_write_driver_rc1_9/wen
+ detronyx_12t_write_driver_rc1
Xdetronyx_12t_precharge_sense_rc1_10 detronyx_12t_precharge_sense_rc1_10/VDD VSUBS
+ detronyx_12t_precharge_sense_rc1_10/dout detronyx_12t_precharge_sense_rc1_10/ren
+ detronyx_12t_precharge_sense_rc1_10/ren detronyx_12t_precharge_sense_rc1_10/dout
+ detronyx_12t_precharge_sense_rc1
Xdetronyx_12t_precharge_sense_rc1_11 detronyx_12t_precharge_sense_rc1_11/VDD VSUBS
+ detronyx_12t_precharge_sense_rc1_11/dout detronyx_12t_precharge_sense_rc1_11/ren
+ detronyx_12t_precharge_sense_rc1_11/ren detronyx_12t_precharge_sense_rc1_11/dout
+ detronyx_12t_precharge_sense_rc1
Xdetronyx_12t_precharge_sense_rc1_13 detronyx_12t_precharge_sense_rc1_13/VDD VSUBS
+ detronyx_12t_write_driver_rc1_9/wen detronyx_12t_write_driver_rc1_9/wen detronyx_12t_write_driver_rc1_9/wen
+ detronyx_12t_write_driver_rc1_9/wen detronyx_12t_precharge_sense_rc1
Xdetronyx_12t_precharge_sense_rc1_12 detronyx_12t_precharge_sense_rc1_12/VDD VSUBS
+ detronyx_12t_precharge_sense_rc1_12/dout detronyx_12t_write_driver_rc1_9/wen detronyx_12t_write_driver_rc1_9/wen
+ detronyx_12t_precharge_sense_rc1_12/dout detronyx_12t_precharge_sense_rc1
Xdetronyx_12t_precharge_sense_rc1_14 detronyx_12t_precharge_sense_rc1_14/VDD VSUBS
+ detronyx_12t_write_driver_rc1_9/wen detronyx_12t_write_driver_rc1_9/wen detronyx_12t_write_driver_rc1_9/wen
+ detronyx_12t_write_driver_rc1_9/wen detronyx_12t_precharge_sense_rc1
Xdetronyx_12t_precharge_sense_rc1_15 detronyx_12t_precharge_sense_rc1_15/VDD VSUBS
+ detronyx_12t_write_driver_rc1_9/wen detronyx_12t_write_driver_rc1_9/wen detronyx_12t_write_driver_rc1_9/wen
+ detronyx_12t_write_driver_rc1_9/wen detronyx_12t_precharge_sense_rc1
Xdetronyx_12t_write_driver_rc1_0 detronyx_12t_write_driver_rc1_0/VDD VSUBS detronyx_12t_write_driver_rc1_0/din
+ detronyx_12t_write_driver_rc1_9/wen detronyx_12t_write_driver_rc1_0/wbl0 detronyx_12t_write_driver_rc1_0/wbr0
+ detronyx_12t_write_driver_rc1
Xdetronyx_12t_write_driver_rc1_1 detronyx_12t_write_driver_rc1_1/VDD VSUBS detronyx_12t_write_driver_rc1_1/din
+ detronyx_12t_write_driver_rc1_9/wen detronyx_12t_write_driver_rc1_1/wbl0 detronyx_12t_write_driver_rc1_9/wen
+ detronyx_12t_write_driver_rc1
Xdetronyx_12t_write_driver_rc1_2 detronyx_12t_write_driver_rc1_2/VDD VSUBS detronyx_12t_write_driver_rc1_2/din
+ detronyx_12t_write_driver_rc1_9/wen detronyx_12t_write_driver_rc1_2/wbl0 detronyx_12t_write_driver_rc1_9/wen
+ detronyx_12t_write_driver_rc1
Xdetronyx_12t_write_driver_rc1_4 detronyx_12t_write_driver_rc1_4/VDD VSUBS detronyx_12t_write_driver_rc1_4/din
+ detronyx_12t_write_driver_rc1_9/wen detronyx_12t_write_driver_rc1_4/wbl0 detronyx_12t_write_driver_rc1_9/wen
+ detronyx_12t_write_driver_rc1
Xdetronyx_12t_write_driver_rc1_3 detronyx_12t_write_driver_rc1_3/VDD VSUBS detronyx_12t_write_driver_rc1_3/din
+ detronyx_12t_write_driver_rc1_9/wen detronyx_12t_write_driver_rc1_3/wbl0 detronyx_12t_write_driver_rc1_9/wen
+ detronyx_12t_write_driver_rc1
Xdetronyx_12t_precharge_sense_rc1_0 detronyx_12t_precharge_sense_rc1_0/VDD VSUBS detronyx_12t_precharge_sense_rc1_0/dout
+ detronyx_12t_write_driver_rc1_9/wen detronyx_12t_write_driver_rc1_9/wen detronyx_12t_precharge_sense_rc1_0/dout
+ detronyx_12t_precharge_sense_rc1
Xdetronyx_12t_write_driver_rc1_5 detronyx_12t_write_driver_rc1_5/VDD VSUBS detronyx_12t_write_driver_rc1_5/din
+ detronyx_12t_write_driver_rc1_9/wen detronyx_12t_write_driver_rc1_5/wbl0 detronyx_12t_write_driver_rc1_9/wen
+ detronyx_12t_write_driver_rc1
Xdetronyx_12t_precharge_sense_rc1_1 detronyx_12t_precharge_sense_rc1_1/VDD VSUBS detronyx_12t_write_driver_rc1_9/wen
+ detronyx_12t_precharge_sense_rc1_1/ren detronyx_12t_precharge_sense_rc1_1/ren detronyx_12t_write_driver_rc1_9/wen
+ detronyx_12t_precharge_sense_rc1
Xgf180mcu_3v3_12t_2r2w_sram_512x8_array_control_core_0 gf180mcu_3v3_12t_2r2w_sram_512x8_array_control_core_0/clk
+ detronyx_12t_write_driver_rc1_15/din detronyx_12t_write_driver_rc1_14/din detronyx_12t_write_driver_rc1_13/din
+ detronyx_12t_write_driver_rc1_12/din detronyx_12t_write_driver_rc1_11/din detronyx_12t_write_driver_rc1_10/din
+ detronyx_12t_write_driver_rc1_9/din detronyx_12t_write_driver_rc1_8/din detronyx_12t_write_driver_rc1_7/din
+ detronyx_12t_write_driver_rc1_6/din detronyx_12t_write_driver_rc1_5/din detronyx_12t_write_driver_rc1_4/din
+ detronyx_12t_write_driver_rc1_3/din detronyx_12t_write_driver_rc1_2/din detronyx_12t_write_driver_rc1_1/din
+ detronyx_12t_write_driver_rc1_0/din detronyx_12t_write_driver_rc1_9/wen detronyx_12t_write_driver_rc1_9/wen
+ detronyx_12t_write_driver_rc1_9/wen detronyx_12t_precharge_sense_rc1_12/dout detronyx_12t_precharge_sense_rc1_11/dout
+ detronyx_12t_precharge_sense_rc1_10/dout detronyx_12t_precharge_sense_rc1_9/dout
+ detronyx_12t_write_driver_rc1_9/wen detronyx_12t_write_driver_rc1_9/wen detronyx_12t_write_driver_rc1_9/wen
+ detronyx_12t_precharge_sense_rc1_5/dout detronyx_12t_precharge_sense_rc1_4/dout
+ detronyx_12t_precharge_sense_rc1_3/dout detronyx_12t_precharge_sense_rc1_2/dout
+ detronyx_12t_write_driver_rc1_9/wen detronyx_12t_precharge_sense_rc1_0/dout detronyx_12t_write_driver_rc1_9/wen
+ detronyx_12t_write_driver_rc1_9/wen detronyx_12t_write_driver_rc1_9/wen detronyx_12t_write_driver_rc1_9/wen
+ detronyx_12t_write_driver_rc1_9/wen detronyx_12t_write_driver_rc1_9/wen detronyx_12t_write_driver_rc1_9/wen
+ detronyx_12t_write_driver_rc1_9/wen detronyx_12t_write_driver_rc1_9/wen detronyx_12t_write_driver_rc1_9/wen
+ detronyx_12t_write_driver_rc1_9/wen detronyx_12t_write_driver_rc1_9/wen detronyx_12t_write_driver_rc1_9/wen
+ gf180mcu_3v3_12t_2r2w_sram_512x8_array_control_core_0/a_200_39400# detronyx_12t_write_driver_rc1_9/wen
+ detronyx_12t_write_driver_rc1_9/wen detronyx_12t_write_driver_rc1_9/wen detronyx_12t_write_driver_rc1_9/wen
+ detronyx_12t_write_driver_rc1_9/wen detronyx_12t_write_driver_rc1_9/wen gf180mcu_3v3_12t_2r2w_sram_512x8_array_control_core_0/u_t014_013/c2_w0_bl
+ detronyx_12t_write_driver_rc1_9/wen detronyx_12t_write_driver_rc1_9/wen detronyx_12t_write_driver_rc1_9/wen
+ detronyx_12t_write_driver_rc1_9/wen detronyx_12t_write_driver_rc1_9/wen detronyx_12t_write_driver_rc1_9/wen
+ detronyx_12t_write_driver_rc1_9/wen detronyx_12t_write_driver_rc1_9/wen gf180mcu_3v3_12t_2r2w_sram_512x8_array_control_core_0/a_22600_3000#
+ detronyx_12t_write_driver_rc1_9/wen gf180mcu_3v3_12t_2r2w_sram_512x8_array_control_core_0/a_14200_45000#
+ detronyx_12t_write_driver_rc1_9/wen detronyx_12t_write_driver_rc1_9/wen detronyx_12t_write_driver_rc1_9/wen
+ gf180mcu_3v3_12t_2r2w_sram_512x8_array_control_core_0/u_t011_011/c2_w0_bl gf180mcu_3v3_12t_2r2w_sram_512x8_array_control_core_0/u_t009_011/c2_w0_bl
+ detronyx_12t_write_driver_rc1_9/wen gf180mcu_3v3_12t_2r2w_sram_512x8_array_control_core_0/a_200_19800#
+ detronyx_12t_write_driver_rc1_9/wen gf180mcu_3v3_12t_2r2w_sram_512x8_array_control_core_0/u_t014_005/c2_w1_bl
+ detronyx_12t_write_driver_rc1_9/wen gf180mcu_3v3_12t_2r2w_sram_512x8_array_control_core_0/u_t009_013/c2_w0_bl
+ gf180mcu_3v3_12t_2r2w_sram_512x8_array_control_core_0/u_t013_007/c2_w1_bl detronyx_12t_write_driver_rc1_9/wen
+ detronyx_12t_write_driver_rc1_9/wen detronyx_12t_write_driver_rc1_9/wen detronyx_12t_write_driver_rc1_9/wen
+ detronyx_12t_write_driver_rc1_9/wen detronyx_12t_write_driver_rc1_9/wen detronyx_12t_write_driver_rc1_9/wen
+ detronyx_12t_write_driver_rc1_9/wen detronyx_12t_write_driver_rc1_9/wen detronyx_12t_write_driver_rc1_9/wen
+ detronyx_12t_write_driver_rc1_9/wen gf180mcu_3v3_12t_2r2w_sram_512x8_array_control_core_0/a_14200_25400#
+ detronyx_12t_write_driver_rc1_9/wen detronyx_12t_write_driver_rc1_9/wen gf180mcu_3v3_12t_2r2w_sram_512x8_array_control_core_0/u_t005_011/c2_w0_bl
+ detronyx_12t_write_driver_rc1_9/wen detronyx_12t_write_driver_rc1_9/wen gf180mcu_3v3_12t_2r2w_sram_512x8_array_control_core_0/m4_4600_10138#
+ detronyx_12t_write_driver_rc1_9/wen gf180mcu_3v3_12t_2r2w_sram_512x8_array_control_core_0/u_t009_005/c2_w1_bl
+ detronyx_12t_write_driver_rc1_9/wen gf180mcu_3v3_12t_2r2w_sram_512x8_array_control_core_0/u_t002_013/c2_w0_bl
+ detronyx_12t_write_driver_rc1_9/wen detronyx_12t_write_driver_rc1_9/wen detronyx_12t_write_driver_rc1_9/wen
+ detronyx_12t_write_driver_rc1_9/wen detronyx_12t_write_driver_rc1_9/wen detronyx_12t_write_driver_rc1_9/wen
+ gf180mcu_3v3_12t_2r2w_sram_512x8_array_control_core_0/u_t005_007/c2_w1_bl detronyx_12t_write_driver_rc1_9/wen
+ detronyx_12t_write_driver_rc1_9/wen detronyx_12t_write_driver_rc1_9/wen detronyx_12t_write_driver_rc1_9/wen
+ detronyx_12t_write_driver_rc1_9/wen detronyx_12t_write_driver_rc1_9/wen detronyx_12t_write_driver_rc1_9/wen
+ detronyx_12t_write_driver_rc1_9/wen gf180mcu_3v3_12t_2r2w_sram_512x8_array_control_core_0/u_t002_005/c2_w1_bl
+ detronyx_12t_write_driver_rc1_9/wen gf180mcu_3v3_12t_2r2w_sram_512x8_array_control_core_0/a_200_28200#
+ detronyx_12t_write_driver_rc1_9/wen gf180mcu_3v3_12t_2r2w_sram_512x8_array_control_core_0/u_t000_007/c2_w1_bl
+ detronyx_12t_write_driver_rc1_9/wen detronyx_12t_write_driver_rc1_9/wen detronyx_12t_write_driver_rc1_9/wen
+ detronyx_12t_write_driver_rc1_9/wen detronyx_12t_write_driver_rc1_9/wen detronyx_12t_write_driver_rc1_9/wen
+ detronyx_12t_write_driver_rc1_9/wen detronyx_12t_write_driver_rc1_9/wen detronyx_12t_write_driver_rc1_9/wen
+ detronyx_12t_write_driver_rc1_9/wen detronyx_12t_write_driver_rc1_9/wen detronyx_12t_write_driver_rc1_9/wen
+ detronyx_12t_write_driver_rc1_9/wen detronyx_12t_write_driver_rc1_9/wen detronyx_12t_write_driver_rc1_9/wen
+ detronyx_12t_write_driver_rc1_9/wen detronyx_12t_write_driver_rc1_9/wen detronyx_12t_write_driver_rc1_9/wen
+ detronyx_12t_write_driver_rc1_9/wen detronyx_12t_write_driver_rc1_9/wen detronyx_12t_write_driver_rc1_9/wen
+ detronyx_12t_write_driver_rc1_9/wen detronyx_12t_write_driver_rc1_9/wen detronyx_12t_write_driver_rc1_9/wen
+ gf180mcu_3v3_12t_2r2w_sram_512x8_array_control_core_0/a_22600_64600# detronyx_12t_write_driver_rc1_9/wen
+ detronyx_12t_write_driver_rc1_9/wen detronyx_12t_write_driver_rc1_9/wen detronyx_12t_write_driver_rc1_9/wen
+ detronyx_12t_write_driver_rc1_9/wen detronyx_12t_write_driver_rc1_9/wen detronyx_12t_write_driver_rc1_9/wen
+ detronyx_12t_write_driver_rc1_9/wen detronyx_12t_write_driver_rc1_9/wen gf180mcu_3v3_12t_2r2w_sram_512x8_array_control_core_0/a_14200_14200#
+ detronyx_12t_write_driver_rc1_9/wen gf180mcu_3v3_12t_2r2w_sram_512x8_array_control_core_0/u_t015_014/c2_w0_bl
+ detronyx_12t_write_driver_rc1_9/wen detronyx_12t_write_driver_rc1_9/wen detronyx_12t_write_driver_rc1_9/wen
+ detronyx_12t_write_driver_rc1_9/wen detronyx_12t_write_driver_rc1_9/wen detronyx_12t_write_driver_rc1_9/wen
+ detronyx_12t_write_driver_rc1_9/wen detronyx_12t_write_driver_rc1_9/wen detronyx_12t_write_driver_rc1_9/wen
+ detronyx_12t_write_driver_rc1_9/wen detronyx_12t_write_driver_rc1_9/wen detronyx_12t_write_driver_rc1_9/wen
+ detronyx_12t_write_driver_rc1_9/wen gf180mcu_3v3_12t_2r2w_sram_512x8_array_control_core_0/a_200_61800#
+ detronyx_12t_write_driver_rc1_9/wen detronyx_12t_write_driver_rc1_9/wen gf180mcu_3v3_12t_2r2w_sram_512x8_array_control_core_0/u_t013_012/c2_w0_bl
+ detronyx_12t_write_driver_rc1_9/wen detronyx_12t_write_driver_rc1_9/wen gf180mcu_3v3_12t_2r2w_sram_512x8_array_control_core_0/u_t015_006/c2_w1_bl
+ gf180mcu_3v3_12t_2r2w_sram_512x8_array_control_core_0/u_t010_014/c2_w0_bl detronyx_12t_write_driver_rc1_9/wen
+ gf180mcu_3v3_12t_2r2w_sram_512x8_array_control_core_0/u_t009_014/c2_w0_bl detronyx_12t_write_driver_rc1_9/wen
+ detronyx_12t_write_driver_rc1_9/wen detronyx_12t_write_driver_rc1_9/wen gf180mcu_3v3_12t_2r2w_sram_512x8_array_control_core_0/a_200_17000#
+ detronyx_12t_write_driver_rc1_9/wen detronyx_12t_write_driver_rc1_9/wen detronyx_12t_write_driver_rc1_9/wen
+ detronyx_12t_write_driver_rc1_9/wen gf180mcu_3v3_12t_2r2w_sram_512x8_array_control_core_0/u_t013_004/c2_w1_bl
+ detronyx_12t_write_driver_rc1_9/wen gf180mcu_3v3_12t_2r2w_sram_512x8_array_control_core_0/gf180mcu_as_sc_mcu7t3v3__inv_2_761/Y
+ detronyx_12t_write_driver_rc1_9/wen detronyx_12t_write_driver_rc1_9/wen detronyx_12t_write_driver_rc1_9/wen
+ gf180mcu_3v3_12t_2r2w_sram_512x8_array_control_core_0/u_t005_012/c2_w0_bl detronyx_12t_write_driver_rc1_9/wen
+ gf180mcu_3v3_12t_2r2w_sram_512x8_array_control_core_0/u_t010_006/c2_w1_bl detronyx_12t_write_driver_rc1_9/wen
+ detronyx_12t_write_driver_rc1_9/wen detronyx_12t_write_driver_rc1_9/wen detronyx_12t_write_driver_rc1_9/wen
+ detronyx_12t_write_driver_rc1_9/wen gf180mcu_3v3_12t_2r2w_sram_512x8_array_control_core_0/u_t009_006/c2_w1_bl
+ detronyx_12t_write_driver_rc1_9/wen detronyx_12t_write_driver_rc1_9/wen detronyx_12t_write_driver_rc1_9/wen
+ detronyx_12t_write_driver_rc1_9/wen gf180mcu_3v3_12t_2r2w_sram_512x8_array_control_core_0/u_t005_014/c2_w0_bl
+ detronyx_12t_write_driver_rc1_9/wen detronyx_12t_write_driver_rc1_9/wen detronyx_12t_write_driver_rc1_9/wen
+ detronyx_12t_write_driver_rc1_9/wen detronyx_12t_write_driver_rc1_9/wen detronyx_12t_write_driver_rc1_9/wen
+ detronyx_12t_write_driver_rc1_9/wen detronyx_12t_write_driver_rc1_9/wen detronyx_12t_write_driver_rc1_9/wen
+ detronyx_12t_write_driver_rc1_9/wen detronyx_12t_write_driver_rc1_9/wen detronyx_12t_write_driver_rc1_9/wen
+ detronyx_12t_write_driver_rc1_9/wen gf180mcu_3v3_12t_2r2w_sram_512x8_array_control_core_0/a_22600_53400#
+ gf180mcu_3v3_12t_2r2w_sram_512x8_array_control_core_0/u_t005_004/c2_w1_bl detronyx_12t_write_driver_rc1_9/wen
+ detronyx_12t_write_driver_rc1_9/wen detronyx_12t_write_driver_rc1_9/wen gf180mcu_3v3_12t_2r2w_sram_512x8_array_control_core_0/u_t005_006/c2_w1_bl
+ detronyx_12t_write_driver_rc1_9/wen detronyx_12t_write_driver_rc1_9/wen detronyx_12t_write_driver_rc1_9/wen
+ detronyx_12t_write_driver_rc1_9/wen detronyx_12t_write_driver_rc1_9/wen detronyx_12t_write_driver_rc1_9/wen
+ detronyx_12t_write_driver_rc1_9/wen detronyx_12t_write_driver_rc1_9/wen detronyx_12t_write_driver_rc1_9/wen
+ detronyx_12t_write_driver_rc1_9/wen detronyx_12t_write_driver_rc1_9/wen detronyx_12t_write_driver_rc1_9/wen
+ detronyx_12t_write_driver_rc1_9/wen detronyx_12t_write_driver_rc1_9/wen detronyx_12t_write_driver_rc1_9/wen
+ detronyx_12t_write_driver_rc1_9/wen detronyx_12t_write_driver_rc1_9/wen gf180mcu_3v3_12t_2r2w_sram_512x8_array_control_core_0/u_t000_004/c2_w1_bl
+ detronyx_12t_write_driver_rc1_9/wen detronyx_12t_write_driver_rc1_9/wen gf180mcu_3v3_12t_2r2w_sram_512x8_array_control_core_0/m4_7400_10138#
+ detronyx_12t_write_driver_rc1_9/wen detronyx_12t_write_driver_rc1_9/wen detronyx_12t_write_driver_rc1_9/wen
+ gf180mcu_3v3_12t_2r2w_sram_512x8_array_control_core_0/a_200_50600# detronyx_12t_write_driver_rc1_9/wen
+ detronyx_12t_write_driver_rc1_9/wen gf180mcu_3v3_12t_2r2w_sram_512x8_array_control_core_0/a_22600_33800#
+ detronyx_12t_write_driver_rc1_9/wen detronyx_12t_write_driver_rc1_9/wen detronyx_12t_write_driver_rc1_9/wen
+ detronyx_12t_write_driver_rc1_9/wen detronyx_12t_write_driver_rc1_9/wen gf180mcu_3v3_12t_2r2w_sram_512x8_array_control_core_0/a_22600_200#
+ detronyx_12t_write_driver_rc1_9/wen detronyx_12t_write_driver_rc1_9/wen detronyx_12t_write_driver_rc1_9/wen
+ detronyx_12t_write_driver_rc1_9/wen detronyx_12t_write_driver_rc1_9/wen detronyx_12t_write_driver_rc1_9/wen
+ detronyx_12t_write_driver_rc1_9/wen detronyx_12t_write_driver_rc1_9/wen detronyx_12t_write_driver_rc1_9/wen
+ detronyx_12t_write_driver_rc1_9/wen detronyx_12t_write_driver_rc1_9/wen detronyx_12t_write_driver_rc1_9/wen
+ detronyx_12t_write_driver_rc1_9/wen detronyx_12t_write_driver_rc1_9/wen detronyx_12t_write_driver_rc1_9/wen
+ detronyx_12t_write_driver_rc1_9/wen detronyx_12t_write_driver_rc1_9/wen detronyx_12t_write_driver_rc1_9/wen
+ detronyx_12t_write_driver_rc1_9/wen detronyx_12t_write_driver_rc1_9/wen detronyx_12t_write_driver_rc1_9/wen
+ detronyx_12t_write_driver_rc1_9/wen detronyx_12t_write_driver_rc1_9/wen gf180mcu_3v3_12t_2r2w_sram_512x8_array_control_core_0/u_t015_011/c2_w0_bl
+ detronyx_12t_write_driver_rc1_9/wen detronyx_12t_write_driver_rc1_9/wen detronyx_12t_write_driver_rc1_9/wen
+ gf180mcu_3v3_12t_2r2w_sram_512x8_array_control_core_0/u_t013_013/c2_w0_bl detronyx_12t_write_driver_rc1_9/wen
+ detronyx_12t_write_driver_rc1_9/wen detronyx_12t_write_driver_rc1_9/wen gf180mcu_3v3_12t_2r2w_sram_512x8_array_control_core_0/a_22600_42200#
+ detronyx_12t_write_driver_rc1_9/wen detronyx_12t_write_driver_rc1_9/wen detronyx_12t_write_driver_rc1_9/wen
+ detronyx_12t_write_driver_rc1_9/wen gf180mcu_3v3_12t_2r2w_sram_512x8_array_control_core_0/a_25400_64600#
+ detronyx_12t_write_driver_rc1_9/wen detronyx_12t_write_driver_rc1_9/wen detronyx_12t_write_driver_rc1_9/wen
+ detronyx_12t_write_driver_rc1_9/wen detronyx_12t_write_driver_rc1_9/wen detronyx_12t_write_driver_rc1_9/wen
+ detronyx_12t_write_driver_rc1_9/wen gf180mcu_3v3_12t_2r2w_sram_512x8_array_control_core_0/u_t010_011/c2_w0_bl
+ detronyx_12t_write_driver_rc1_9/wen detronyx_12t_write_driver_rc1_9/wen detronyx_12t_write_driver_rc1_9/wen
+ gf180mcu_3v3_12t_2r2w_sram_512x8_array_control_core_0/u_t009_011/c2_w0_bl gf180mcu_3v3_12t_2r2w_sram_512x8_array_control_core_0/u_t013_005/c2_w1_bl
+ detronyx_12t_write_driver_rc1_9/wen detronyx_12t_write_driver_rc1_9/wen detronyx_12t_write_driver_rc1_9/wen
+ detronyx_12t_write_driver_rc1_9/wen detronyx_12t_write_driver_rc1_9/wen gf180mcu_3v3_12t_2r2w_sram_512x8_array_control_core_0/a_17000_200#
+ gf180mcu_3v3_12t_2r2w_sram_512x8_array_control_core_0/u_t006_013/c2_w0_bl detronyx_12t_write_driver_rc1_9/wen
+ gf180mcu_3v3_12t_2r2w_sram_512x8_array_control_core_0/u_t011_007/c2_w1_bl detronyx_12t_write_driver_rc1_9/wen
+ gf180mcu_3v3_12t_2r2w_sram_512x8_array_control_core_0/u_t009_007/c2_w1_bl detronyx_12t_write_driver_rc1_9/wen
+ detronyx_12t_write_driver_rc1_9/wen detronyx_12t_write_driver_rc1_9/wen detronyx_12t_write_driver_rc1_9/wen
+ detronyx_12t_write_driver_rc1_9/wen detronyx_12t_write_driver_rc1_9/wen gf180mcu_3v3_12t_2r2w_sram_512x8_array_control_core_0/a_22600_22600#
+ detronyx_12t_write_driver_rc1_9/wen detronyx_12t_write_driver_rc1_9/wen detronyx_12t_write_driver_rc1_9/wen
+ detronyx_12t_write_driver_rc1_9/wen detronyx_12t_write_driver_rc1_9/wen detronyx_12t_write_driver_rc1_9/wen
+ gf180mcu_3v3_12t_2r2w_sram_512x8_array_control_core_0/u_t005_011/c2_w0_bl detronyx_12t_write_driver_rc1_9/wen
+ detronyx_12t_write_driver_rc1_9/wen gf180mcu_3v3_12t_2r2w_sram_512x8_array_control_core_0/u_t006_005/c2_w1_bl
+ detronyx_12t_write_driver_rc1_9/wen detronyx_12t_write_driver_rc1_9/wen detronyx_12t_write_driver_rc1_9/wen
+ detronyx_12t_write_driver_rc1_9/wen detronyx_12t_write_driver_rc1_9/wen detronyx_12t_write_driver_rc1_9/wen
+ gf180mcu_3v3_12t_2r2w_sram_512x8_array_control_core_0/u_t005_007/c2_w1_bl detronyx_12t_write_driver_rc1_9/wen
+ detronyx_12t_write_driver_rc1_9/wen detronyx_12t_write_driver_rc1_9/wen detronyx_12t_write_driver_rc1_9/wen
+ detronyx_12t_write_driver_rc1_9/wen detronyx_12t_write_driver_rc1_9/wen detronyx_12t_write_driver_rc1_9/wen
+ detronyx_12t_write_driver_rc1_9/wen detronyx_12t_write_driver_rc1_9/wen detronyx_12t_write_driver_rc1_9/wen
+ detronyx_12t_write_driver_rc1_9/wen detronyx_12t_write_driver_rc1_9/wen detronyx_12t_write_driver_rc1_9/wen
+ detronyx_12t_write_driver_rc1_9/wen detronyx_12t_write_driver_rc1_9/wen detronyx_12t_write_driver_rc1_9/wen
+ detronyx_12t_write_driver_rc1_9/wen detronyx_12t_write_driver_rc1_9/wen detronyx_12t_write_driver_rc1_9/wen
+ detronyx_12t_write_driver_rc1_9/wen detronyx_12t_write_driver_rc1_9/wen detronyx_12t_write_driver_rc1_9/wen
+ detronyx_12t_write_driver_rc1_9/wen detronyx_12t_write_driver_rc1_9/wen detronyx_12t_write_driver_rc1_9/wen
+ detronyx_12t_write_driver_rc1_9/wen gf180mcu_3v3_12t_2r2w_sram_512x8_array_control_core_0/a_22600_31000#
+ detronyx_12t_write_driver_rc1_9/wen detronyx_12t_write_driver_rc1_9/wen detronyx_12t_write_driver_rc1_9/wen
+ detronyx_12t_write_driver_rc1_9/wen detronyx_12t_write_driver_rc1_9/wen detronyx_12t_write_driver_rc1_9/wen
+ detronyx_12t_write_driver_rc1_9/wen detronyx_12t_write_driver_rc1_9/wen detronyx_12t_write_driver_rc1_9/wen
+ detronyx_12t_write_driver_rc1_9/wen detronyx_12t_write_driver_rc1_9/wen detronyx_12t_write_driver_rc1_9/wen
+ detronyx_12t_write_driver_rc1_9/wen detronyx_12t_write_driver_rc1_9/wen detronyx_12t_write_driver_rc1_9/wen
+ detronyx_12t_write_driver_rc1_9/wen gf180mcu_3v3_12t_2r2w_sram_512x8_array_control_core_0/a_19800_64600#
+ detronyx_12t_write_driver_rc1_9/wen detronyx_12t_write_driver_rc1_9/wen detronyx_12t_write_driver_rc1_9/wen
+ detronyx_12t_write_driver_rc1_9/wen gf180mcu_3v3_12t_2r2w_sram_512x8_array_control_core_0/a_22600_11400#
+ gf180mcu_3v3_12t_2r2w_sram_512x8_array_control_core_0/a_25400_200# detronyx_12t_write_driver_rc1_9/wen
+ detronyx_12t_write_driver_rc1_9/wen detronyx_12t_write_driver_rc1_9/wen gf180mcu_3v3_12t_2r2w_sram_512x8_array_control_core_0/u_t014_014/c2_w0_bl
+ detronyx_12t_write_driver_rc1_9/wen detronyx_12t_write_driver_rc1_9/wen detronyx_12t_write_driver_rc1_9/wen
+ detronyx_12t_write_driver_rc1_9/wen detronyx_12t_write_driver_rc1_9/wen detronyx_12t_write_driver_rc1_9/wen
+ detronyx_12t_write_driver_rc1_9/wen detronyx_12t_write_driver_rc1_9/wen detronyx_12t_write_driver_rc1_9/wen
+ detronyx_12t_write_driver_rc1_9/wen gf180mcu_3v3_12t_2r2w_sram_512x8_array_control_core_0/a_19800_200#
+ detronyx_12t_write_driver_rc1_9/wen detronyx_12t_write_driver_rc1_9/wen detronyx_12t_write_driver_rc1_9/wen
+ detronyx_12t_write_driver_rc1_9/wen detronyx_12t_write_driver_rc1_9/wen detronyx_12t_write_driver_rc1_9/wen
+ gf180mcu_3v3_12t_2r2w_sram_512x8_array_control_core_0/u_t011_012/c2_w0_bl detronyx_12t_write_driver_rc1_9/wen
+ gf180mcu_3v3_12t_2r2w_sram_512x8_array_control_core_0/u_t009_012/c2_w0_bl detronyx_12t_write_driver_rc1_9/wen
+ gf180mcu_3v3_12t_2r2w_sram_512x8_array_control_core_0/u_t014_006/c2_w1_bl detronyx_12t_write_driver_rc1_9/wen
+ detronyx_12t_write_driver_rc1_9/wen gf180mcu_3v3_12t_2r2w_sram_512x8_array_control_core_0/u_t009_014/c2_w0_bl
+ detronyx_12t_write_driver_rc1_9/wen detronyx_12t_write_driver_rc1_9/wen detronyx_12t_write_driver_rc1_9/wen
+ detronyx_12t_write_driver_rc1_9/wen detronyx_12t_write_driver_rc1_9/wen detronyx_12t_write_driver_rc1_9/wen
+ detronyx_12t_write_driver_rc1_9/wen detronyx_12t_write_driver_rc1_9/wen gf180mcu_3v3_12t_2r2w_sram_512x8_array_control_core_0/a_200_47800#
+ gf180mcu_3v3_12t_2r2w_sram_512x8_array_control_core_0/u_t011_004/c2_w1_bl detronyx_12t_write_driver_rc1_9/wen
+ detronyx_12t_write_driver_rc1_9/wen detronyx_12t_write_driver_rc1_9/wen gf180mcu_3v3_12t_2r2w_sram_512x8_array_control_core_0/u_t009_004/c2_w1_bl
+ detronyx_12t_write_driver_rc1_9/wen gf180mcu_3v3_12t_2r2w_sram_512x8_array_control_core_0/u_t005_012/c2_w0_bl
+ detronyx_12t_write_driver_rc1_9/wen gf180mcu_3v3_12t_2r2w_sram_512x8_array_control_core_0/u_t009_006/c2_w1_bl
+ detronyx_12t_write_driver_rc1_9/wen detronyx_12t_write_driver_rc1_9/wen detronyx_12t_write_driver_rc1_9/wen
+ detronyx_12t_write_driver_rc1_9/wen gf180mcu_3v3_12t_2r2w_sram_512x8_array_control_core_0/u_t002_014/c2_w0_bl
+ detronyx_12t_write_driver_rc1_9/wen detronyx_12t_write_driver_rc1_9/wen detronyx_12t_write_driver_rc1_9/wen
+ detronyx_12t_write_driver_rc1_9/wen detronyx_12t_write_driver_rc1_9/wen detronyx_12t_write_driver_rc1_9/wen
+ detronyx_12t_write_driver_rc1_9/wen gf180mcu_3v3_12t_2r2w_sram_512x8_array_control_core_0/a_28200_64600#
+ gf180mcu_3v3_12t_2r2w_sram_512x8_array_control_core_0/a_14200_53400# detronyx_12t_write_driver_rc1_9/wen
+ gf180mcu_3v3_12t_2r2w_sram_512x8_array_control_core_0/a_22600_59000# detronyx_12t_write_driver_rc1_9/wen
+ detronyx_12t_write_driver_rc1_9/wen detronyx_12t_write_driver_rc1_9/wen detronyx_12t_write_driver_rc1_9/wen
+ gf180mcu_3v3_12t_2r2w_sram_512x8_array_control_core_0/u_t005_004/c2_w1_bl detronyx_12t_write_driver_rc1_9/wen
+ gf180mcu_3v3_12t_2r2w_sram_512x8_array_control_core_0/u_t002_006/c2_w1_bl detronyx_12t_write_driver_rc1_9/wen
+ detronyx_12t_write_driver_rc1_9/wen detronyx_12t_write_driver_rc1_9/wen detronyx_12t_write_driver_rc1_9/wen
+ detronyx_12t_write_driver_rc1_9/wen detronyx_12t_write_driver_rc1_9/wen detronyx_12t_write_driver_rc1_9/wen
+ detronyx_12t_write_driver_rc1_9/wen detronyx_12t_write_driver_rc1_9/wen detronyx_12t_write_driver_rc1_9/wen
+ detronyx_12t_write_driver_rc1_9/wen detronyx_12t_write_driver_rc1_9/wen detronyx_12t_write_driver_rc1_9/wen
+ detronyx_12t_write_driver_rc1_9/wen gf180mcu_3v3_12t_2r2w_sram_512x8_array_control_core_0/a_14200_33800#
+ gf180mcu_3v3_12t_2r2w_sram_512x8_array_control_core_0/a_200_56200# detronyx_12t_write_driver_rc1_9/wen
+ gf180mcu_3v3_12t_2r2w_sram_512x8_array_control_core_0/a_22600_39400# gf180mcu_3v3_12t_2r2w_sram_512x8_array_control_core_0/a_19800_3000#
+ detronyx_12t_write_driver_rc1_9/wen detronyx_12t_write_driver_rc1_9/wen detronyx_12t_write_driver_rc1_9/wen
+ detronyx_12t_write_driver_rc1_9/wen detronyx_12t_write_driver_rc1_9/wen detronyx_12t_write_driver_rc1_9/wen
+ detronyx_12t_write_driver_rc1_9/wen detronyx_12t_write_driver_rc1_9/wen detronyx_12t_write_driver_rc1_9/wen
+ detronyx_12t_write_driver_rc1_9/wen detronyx_12t_write_driver_rc1_9/wen detronyx_12t_write_driver_rc1_9/wen
+ detronyx_12t_write_driver_rc1_9/wen detronyx_12t_write_driver_rc1_9/wen detronyx_12t_write_driver_rc1_9/wen
+ detronyx_12t_write_driver_rc1_9/wen detronyx_12t_write_driver_rc1_9/wen detronyx_12t_write_driver_rc1_9/wen
+ detronyx_12t_write_driver_rc1_9/wen detronyx_12t_write_driver_rc1_9/wen detronyx_12t_write_driver_rc1_9/wen
+ detronyx_12t_write_driver_rc1_9/wen detronyx_12t_write_driver_rc1_9/wen detronyx_12t_write_driver_rc1_9/wen
+ gf180mcu_3v3_12t_2r2w_sram_512x8_array_control_core_0/a_25400_3000# gf180mcu_3v3_12t_2r2w_sram_512x8_array_control_core_0/a_200_36600#
+ detronyx_12t_write_driver_rc1_9/wen gf180mcu_3v3_12t_2r2w_sram_512x8_array_control_core_0/a_22600_19800#
+ detronyx_12t_write_driver_rc1_9/wen detronyx_12t_write_driver_rc1_9/wen detronyx_12t_write_driver_rc1_9/wen
+ detronyx_12t_write_driver_rc1_9/wen detronyx_12t_write_driver_rc1_9/wen detronyx_12t_write_driver_rc1_9/wen
+ detronyx_12t_write_driver_rc1_9/wen detronyx_12t_write_driver_rc1_9/wen detronyx_12t_write_driver_rc1_9/wen
+ detronyx_12t_write_driver_rc1_9/wen detronyx_12t_write_driver_rc1_9/wen detronyx_12t_write_driver_rc1_9/wen
+ detronyx_12t_write_driver_rc1_9/wen detronyx_12t_write_driver_rc1_9/wen detronyx_12t_write_driver_rc1_9/wen
+ gf180mcu_3v3_12t_2r2w_sram_512x8_array_control_core_0/u_t014_011/c2_w0_bl detronyx_12t_write_driver_rc1_9/wen
+ gf180mcu_3v3_12t_2r2w_sram_512x8_array_control_core_0/a_14200_42200# detronyx_12t_write_driver_rc1_9/wen
+ gf180mcu_3v3_12t_2r2w_sram_512x8_array_control_core_0/u_t013_013/c2_w0_bl gf180mcu_3v3_12t_2r2w_sram_512x8_array_control_core_0/a_17000_64600#
+ detronyx_12t_write_driver_rc1_9/wen detronyx_12t_write_driver_rc1_9/wen detronyx_12t_write_driver_rc1_9/wen
+ detronyx_12t_write_driver_rc1_9/wen gf180mcu_3v3_12t_2r2w_sram_512x8_array_control_core_0/u_t015_007/c2_w1_bl
+ detronyx_12t_write_driver_rc1_9/wen detronyx_12t_write_driver_rc1_9/wen detronyx_12t_write_driver_rc1_9/wen
+ detronyx_12t_write_driver_rc1_9/wen detronyx_12t_write_driver_rc1_9/wen detronyx_12t_write_driver_rc1_9/wen
+ detronyx_12t_write_driver_rc1_9/wen detronyx_12t_write_driver_rc1_9/wen gf180mcu_3v3_12t_2r2w_sram_512x8_array_control_core_0/a_28200_200#
+ detronyx_12t_write_driver_rc1_9/wen gf180mcu_3v3_12t_2r2w_sram_512x8_array_control_core_0/u_t009_011/c2_w0_bl
+ gf180mcu_3v3_12t_2r2w_sram_512x8_array_control_core_0/u_t013_005/c2_w1_bl detronyx_12t_write_driver_rc1_9/wen
+ detronyx_12t_write_driver_rc1_9/wen detronyx_12t_write_driver_rc1_9/wen detronyx_12t_write_driver_rc1_9/wen
+ detronyx_12t_write_driver_rc1_9/wen detronyx_12t_write_driver_rc1_9/wen detronyx_12t_write_driver_rc1_9/wen
+ gf180mcu_3v3_12t_2r2w_sram_512x8_array_control_core_0/u_t005_013/c2_w0_bl detronyx_12t_write_driver_rc1_9/wen
+ gf180mcu_3v3_12t_2r2w_sram_512x8_array_control_core_0/u_t010_007/c2_w1_bl detronyx_12t_write_driver_rc1_9/wen
+ detronyx_12t_write_driver_rc1_9/wen gf180mcu_3v3_12t_2r2w_sram_512x8_array_control_core_0/a_200_45000#
+ gf180mcu_3v3_12t_2r2w_sram_512x8_array_control_core_0/a_14200_22600# detronyx_12t_write_driver_rc1_9/wen
+ gf180mcu_3v3_12t_2r2w_sram_512x8_array_control_core_0/u_t009_007/c2_w1_bl detronyx_12t_write_driver_rc1_9/wen
+ gf180mcu_3v3_12t_2r2w_sram_512x8_array_control_core_0/a_22600_28200# detronyx_12t_write_driver_rc1_9/wen
+ detronyx_12t_write_driver_rc1_9/wen detronyx_12t_write_driver_rc1_9/wen detronyx_12t_write_driver_rc1_9/wen
+ detronyx_12t_write_driver_rc1_9/wen detronyx_12t_write_driver_rc1_9/wen detronyx_12t_write_driver_rc1_9/wen
+ detronyx_12t_write_driver_rc1_9/wen detronyx_12t_write_driver_rc1_9/wen detronyx_12t_write_driver_rc1_9/wen
+ gf180mcu_3v3_12t_2r2w_sram_512x8_array_control_core_0/u_t002_011/c2_w0_bl detronyx_12t_write_driver_rc1_9/wen
+ detronyx_12t_write_driver_rc1_9/wen detronyx_12t_write_driver_rc1_9/wen gf180mcu_3v3_12t_2r2w_sram_512x8_array_control_core_0/u_t005_005/c2_w1_bl
+ detronyx_12t_write_driver_rc1_9/wen gf180mcu_3v3_12t_2r2w_sram_512x8_array_control_core_0/u_t005_007/c2_w1_bl
+ detronyx_12t_write_driver_rc1_9/wen detronyx_12t_write_driver_rc1_9/wen detronyx_12t_precharge_sense_rc1_0/dout
+ detronyx_12t_write_driver_rc1_9/wen detronyx_12t_write_driver_rc1_9/wen detronyx_12t_write_driver_rc1_9/wen
+ detronyx_12t_write_driver_rc1_9/wen detronyx_12t_write_driver_rc1_9/wen gf180mcu_3v3_12t_2r2w_sram_512x8_array_control_core_0/a_200_25400#
+ detronyx_12t_write_driver_rc1_9/wen gf180mcu_3v3_12t_2r2w_sram_512x8_array_control_core_0/m4_21400_10138#
+ detronyx_12t_write_driver_rc1_9/wen detronyx_12t_write_driver_rc1_9/wen detronyx_12t_write_driver_rc1_9/wen
+ detronyx_12t_write_driver_rc1_9/wen detronyx_12t_write_driver_rc1_9/wen detronyx_12t_write_driver_rc1_9/wen
+ gf180mcu_3v3_12t_2r2w_sram_512x8_array_control_core_0/gf180mcu_as_sc_mcu7t3v3__inv_2_336/A
+ gf180mcu_3v3_12t_2r2w_sram_512x8_array_control_core_0/u_t000_005/c2_w1_bl detronyx_12t_write_driver_rc1_9/wen
+ detronyx_12t_write_driver_rc1_9/wen detronyx_12t_write_driver_rc1_9/wen detronyx_12t_write_driver_rc1_9/wen
+ detronyx_12t_write_driver_rc1_9/wen detronyx_12t_write_driver_rc1_9/wen detronyx_12t_write_driver_rc1_9/wen
+ detronyx_12t_write_driver_rc1_9/wen detronyx_12t_write_driver_rc1_9/wen detronyx_12t_write_driver_rc1_9/wen
+ detronyx_12t_write_driver_rc1_9/wen detronyx_12t_write_driver_rc1_9/wen detronyx_12t_write_driver_rc1_9/wen
+ gf180mcu_3v3_12t_2r2w_sram_512x8_array_control_core_0/a_14200_31000# detronyx_12t_write_driver_rc1_9/wen
+ detronyx_12t_write_driver_rc1_9/wen detronyx_12t_write_driver_rc1_9/wen detronyx_12t_write_driver_rc1_9/wen
+ detronyx_12t_write_driver_rc1_9/wen detronyx_12t_write_driver_rc1_9/wen detronyx_12t_write_driver_rc1_9/wen
+ detronyx_12t_write_driver_rc1_9/wen detronyx_12t_write_driver_rc1_9/wen gf180mcu_3v3_12t_2r2w_sram_512x8_array_control_core_0/a_22600_61800#
+ detronyx_12t_write_driver_rc1_9/wen detronyx_12t_write_driver_rc1_9/wen detronyx_12t_write_driver_rc1_9/wen
+ detronyx_12t_write_driver_rc1_9/wen detronyx_12t_write_driver_rc1_9/wen detronyx_12t_write_driver_rc1_9/wen
+ detronyx_12t_write_driver_rc1_9/wen detronyx_12t_write_driver_rc1_9/wen detronyx_12t_write_driver_rc1_9/wen
+ detronyx_12t_write_driver_rc1_9/wen detronyx_12t_write_driver_rc1_9/wen detronyx_12t_write_driver_rc1_9/wen
+ detronyx_12t_write_driver_rc1_9/wen detronyx_12t_write_driver_rc1_9/wen detronyx_12t_write_driver_rc1_9/wen
+ gf180mcu_3v3_12t_2r2w_sram_512x8_array_control_core_0/a_14200_11400# detronyx_12t_write_driver_rc1_9/wen
+ gf180mcu_3v3_12t_2r2w_sram_512x8_array_control_core_0/a_22600_17000# detronyx_12t_write_driver_rc1_9/wen
+ gf180mcu_3v3_12t_2r2w_sram_512x8_array_control_core_0/u_t015_012/c2_w0_bl detronyx_12t_write_driver_rc1_9/wen
+ detronyx_12t_write_driver_rc1_9/wen gf180mcu_3v3_12t_2r2w_sram_512x8_array_control_core_0/a_22600_8600#
+ detronyx_12t_precharge_sense_rc1_0/dout gf180mcu_3v3_12t_2r2w_sram_512x8_array_control_core_0/u_t013_014/c2_w0_bl
+ detronyx_12t_write_driver_rc1_9/wen detronyx_12t_write_driver_rc1_9/wen detronyx_12t_write_driver_rc1_9/wen
+ detronyx_12t_write_driver_rc1_9/wen detronyx_12t_write_driver_rc1_9/wen detronyx_12t_write_driver_rc1_9/wen
+ detronyx_12t_write_driver_rc1_9/wen gf180mcu_3v3_12t_2r2w_sram_512x8_array_control_core_0/u_t015_004/c2_w1_bl
+ detronyx_12t_write_driver_rc1_9/wen gf180mcu_3v3_12t_2r2w_sram_512x8_array_control_core_0/u_t010_012/c2_w0_bl
+ detronyx_12t_write_driver_rc1_9/wen detronyx_12t_write_driver_rc1_9/wen gf180mcu_3v3_12t_2r2w_sram_512x8_array_control_core_0/u_t009_012/c2_w0_bl
+ gf180mcu_3v3_12t_2r2w_sram_512x8_array_control_core_0/a_200_14200# detronyx_12t_write_driver_rc1_9/wen
+ gf180mcu_3v3_12t_2r2w_sram_512x8_array_control_core_0/u_t013_006/c2_w1_bl detronyx_12t_write_driver_rc1_9/wen
+ detronyx_12t_write_driver_rc1_9/wen detronyx_12t_write_driver_rc1_9/wen gf180mcu_3v3_12t_2r2w_sram_512x8_array_control_core_0/u_t006_014/c2_w0_bl
+ detronyx_12t_write_driver_rc1_9/wen detronyx_12t_write_driver_rc1_9/wen gf180mcu_3v3_12t_2r2w_sram_512x8_array_control_core_0/m4_10808_10138#
+ detronyx_12t_write_driver_rc1_9/wen detronyx_12t_write_driver_rc1_9/wen detronyx_12t_write_driver_rc1_9/wen
+ detronyx_12t_write_driver_rc1_9/wen detronyx_12t_write_driver_rc1_9/wen detronyx_12t_write_driver_rc1_9/wen
+ detronyx_12t_write_driver_rc1_9/wen detronyx_12t_write_driver_rc1_9/wen detronyx_12t_write_driver_rc1_9/wen
+ detronyx_12t_write_driver_rc1_9/wen detronyx_12t_write_driver_rc1_9/wen detronyx_12t_write_driver_rc1_9/wen
+ detronyx_12t_write_driver_rc1_9/wen gf180mcu_3v3_12t_2r2w_sram_512x8_array_control_core_0/u_t010_004/c2_w1_bl
+ detronyx_12t_write_driver_rc1_9/wen detronyx_12t_write_driver_rc1_9/wen detronyx_12t_write_driver_rc1_9/wen
+ detronyx_12t_write_driver_rc1_9/wen gf180mcu_3v3_12t_2r2w_sram_512x8_array_control_core_0/u_t009_004/c2_w1_bl
+ detronyx_12t_write_driver_rc1_9/wen gf180mcu_3v3_12t_2r2w_sram_512x8_array_control_core_0/m4_15800_10138#
+ gf180mcu_3v3_12t_2r2w_sram_512x8_array_control_core_0/u_t005_012/c2_w0_bl detronyx_12t_write_driver_rc1_9/wen
+ gf180mcu_3v3_12t_2r2w_sram_512x8_array_control_core_0/u_t006_006/c2_w1_bl detronyx_12t_write_driver_rc1_9/wen
+ detronyx_12t_write_driver_rc1_9/wen detronyx_12t_write_driver_rc1_9/wen detronyx_12t_write_driver_rc1_9/wen
+ gf180mcu_3v3_12t_2r2w_sram_512x8_array_control_core_0/a_14200_59000# detronyx_12t_write_driver_rc1_9/wen
+ detronyx_12t_write_driver_rc1_9/wen detronyx_12t_write_driver_rc1_9/wen detronyx_12t_write_driver_rc1_9/wen
+ detronyx_12t_write_driver_rc1_9/wen gf180mcu_3v3_12t_2r2w_sram_512x8_array_control_core_0/a_22600_50600#
+ detronyx_12t_write_driver_rc1_9/wen detronyx_12t_write_driver_rc1_9/wen detronyx_12t_write_driver_rc1_9/wen
+ detronyx_12t_write_driver_rc1_9/wen gf180mcu_3v3_12t_2r2w_sram_512x8_array_control_core_0/a_200_8600#
+ detronyx_12t_write_driver_rc1_9/wen detronyx_12t_write_driver_rc1_9/wen gf180mcu_3v3_12t_2r2w_sram_512x8_array_control_core_0/u_t005_004/c2_w1_bl
+ detronyx_12t_write_driver_rc1_9/wen detronyx_12t_write_driver_rc1_9/wen detronyx_12t_write_driver_rc1_9/wen
+ detronyx_12t_write_driver_rc1_9/wen detronyx_12t_write_driver_rc1_9/wen detronyx_12t_write_driver_rc1_9/wen
+ detronyx_12t_write_driver_rc1_9/wen detronyx_12t_write_driver_rc1_9/wen detronyx_12t_write_driver_rc1_9/wen
+ detronyx_12t_write_driver_rc1_9/wen detronyx_12t_write_driver_rc1_9/wen detronyx_12t_write_driver_rc1_9/wen
+ detronyx_12t_write_driver_rc1_9/wen detronyx_12t_write_driver_rc1_9/wen detronyx_12t_write_driver_rc1_9/wen
+ gf180mcu_3v3_12t_2r2w_sram_512x8_array_control_core_0/gf180mcu_as_sc_mcu7t3v3__inv_2_153/Y
+ detronyx_12t_write_driver_rc1_9/wen gf180mcu_3v3_12t_2r2w_sram_512x8_array_control_core_0/a_14200_39400#
+ detronyx_12t_write_driver_rc1_9/wen detronyx_12t_write_driver_rc1_9/wen detronyx_12t_write_driver_rc1_9/wen
+ detronyx_12t_write_driver_rc1_9/wen detronyx_12t_write_driver_rc1_9/wen detronyx_12t_write_driver_rc1_9/wen
+ detronyx_12t_write_driver_rc1_9/wen detronyx_12t_write_driver_rc1_9/wen detronyx_12t_write_driver_rc1_9/wen
+ detronyx_12t_write_driver_rc1_9/wen detronyx_12t_write_driver_rc1_9/wen detronyx_12t_write_driver_rc1_9/wen
+ detronyx_12t_write_driver_rc1_9/wen detronyx_12t_write_driver_rc1_9/wen detronyx_12t_write_driver_rc1_9/wen
+ detronyx_12t_write_driver_rc1_9/wen detronyx_12t_write_driver_rc1_9/wen detronyx_12t_write_driver_rc1_9/wen
+ gf180mcu_3v3_12t_2r2w_sram_512x8_array_control_core_0/m4_24200_10138# detronyx_12t_write_driver_rc1_9/wen
+ detronyx_12t_write_driver_rc1_9/wen detronyx_12t_write_driver_rc1_9/wen gf180mcu_3v3_12t_2r2w_sram_512x8_array_control_core_0/a_14200_19800#
+ detronyx_12t_write_driver_rc1_9/wen detronyx_12t_write_driver_rc1_9/wen detronyx_12t_write_driver_rc1_9/wen
+ gf180mcu_3v3_12t_2r2w_sram_512x8_array_control_core_0/gf180mcu_as_sc_mcu7t3v3__inv_2_743/Y
+ detronyx_12t_write_driver_rc1_9/wen gf180mcu_3v3_12t_2r2w_sram_512x8_array_control_core_0/m4_29800_10138#
+ detronyx_12t_write_driver_rc1_9/wen detronyx_12t_write_driver_rc1_9/wen detronyx_12t_write_driver_rc1_9/wen
+ detronyx_12t_write_driver_rc1_9/wen detronyx_12t_write_driver_rc1_9/wen detronyx_12t_write_driver_rc1_9/wen
+ detronyx_12t_write_driver_rc1_9/wen detronyx_12t_write_driver_rc1_9/wen detronyx_12t_write_driver_rc1_9/wen
+ detronyx_12t_write_driver_rc1_9/wen gf180mcu_3v3_12t_2r2w_sram_512x8_array_control_core_0/gf180mcu_as_sc_mcu7t3v3__inv_2_344/A
+ gf180mcu_3v3_12t_2r2w_sram_512x8_array_control_core_0/u_t013_011/c2_w0_bl detronyx_12t_write_driver_rc1_9/wen
+ detronyx_12t_write_driver_rc1_9/wen detronyx_12t_write_driver_rc1_9/wen detronyx_12t_write_driver_rc1_9/wen
+ detronyx_12t_write_driver_rc1_9/wen gf180mcu_3v3_12t_2r2w_sram_512x8_array_control_core_0/u_t011_013/c2_w0_bl
+ gf180mcu_3v3_12t_2r2w_sram_512x8_array_control_core_0/u_t009_013/c2_w0_bl detronyx_12t_write_driver_rc1_9/wen
+ detronyx_12t_write_driver_rc1_9/wen detronyx_12t_write_driver_rc1_9/wen gf180mcu_3v3_12t_2r2w_sram_512x8_array_control_core_0/u_t014_007/c2_w1_bl
+ detronyx_12t_write_driver_rc1_9/wen detronyx_12t_write_driver_rc1_9/wen detronyx_12t_write_driver_rc1_9/wen
+ detronyx_12t_write_driver_rc1_9/wen detronyx_12t_write_driver_rc1_9/wen detronyx_12t_write_driver_rc1_9/wen
+ detronyx_12t_write_driver_rc1_9/wen detronyx_12t_write_driver_rc1_9/wen detronyx_12t_write_driver_rc1_9/wen
+ gf180mcu_3v3_12t_2r2w_sram_512x8_array_control_core_0/u_t006_011/c2_w0_bl gf180mcu_3v3_12t_2r2w_sram_512x8_array_control_core_0/u_t011_005/c2_w1_bl
+ detronyx_12t_write_driver_rc1_9/wen detronyx_12t_write_driver_rc1_9/wen detronyx_12t_write_driver_rc1_9/wen
+ detronyx_12t_write_driver_rc1_9/wen gf180mcu_3v3_12t_2r2w_sram_512x8_array_control_core_0/u_t009_005/c2_w1_bl
+ detronyx_12t_write_driver_rc1_9/wen detronyx_12t_write_driver_rc1_9/wen gf180mcu_3v3_12t_2r2w_sram_512x8_array_control_core_0/a_14200_28200#
+ detronyx_12t_write_driver_rc1_9/wen gf180mcu_3v3_12t_2r2w_sram_512x8_array_control_core_0/u_t005_013/c2_w0_bl
+ detronyx_12t_write_driver_rc1_9/wen detronyx_12t_write_driver_rc1_9/wen gf180mcu_3v3_12t_2r2w_sram_512x8_array_control_core_0/gf180mcu_as_sc_mcu7t3v3__inv_2_18/Y
+ gf180mcu_3v3_12t_2r2w_sram_512x8_array_control_core_0/u_t009_007/c2_w1_bl detronyx_12t_write_driver_rc1_9/wen
+ detronyx_12t_write_driver_rc1_9/wen detronyx_12t_write_driver_rc1_9/wen detronyx_12t_write_driver_rc1_9/wen
+ detronyx_12t_write_driver_rc1_9/wen detronyx_12t_write_driver_rc1_9/wen detronyx_12t_write_driver_rc1_9/wen
+ detronyx_12t_write_driver_rc1_9/wen detronyx_12t_write_driver_rc1_9/wen detronyx_12t_write_driver_rc1_9/wen
+ detronyx_12t_write_driver_rc1_9/wen detronyx_12t_write_driver_rc1_9/wen detronyx_12t_write_driver_rc1_9/wen
+ gf180mcu_3v3_12t_2r2w_sram_512x8_array_control_core_0/u_t005_005/c2_w1_bl detronyx_12t_write_driver_rc1_9/wen
+ gf180mcu_3v3_12t_2r2w_sram_512x8_array_control_core_0/u_t002_007/c2_w1_bl detronyx_12t_write_driver_rc1_9/wen
+ detronyx_12t_write_driver_rc1_9/wen detronyx_12t_write_driver_rc1_9/wen detronyx_12t_write_driver_rc1_9/wen
+ detronyx_12t_write_driver_rc1_9/wen detronyx_12t_write_driver_rc1_9/wen detronyx_12t_write_driver_rc1_9/wen
+ detronyx_12t_write_driver_rc1_9/wen detronyx_12t_write_driver_rc1_9/wen detronyx_12t_write_driver_rc1_9/wen
+ detronyx_12t_write_driver_rc1_9/wen gf180mcu_3v3_12t_2r2w_sram_512x8_array_control_core_0/m4_18600_10138#
+ detronyx_12t_write_driver_rc1_9/wen detronyx_12t_write_driver_rc1_9/wen detronyx_12t_write_driver_rc1_9/wen
+ detronyx_12t_write_driver_rc1_9/wen detronyx_12t_write_driver_rc1_9/wen detronyx_12t_write_driver_rc1_9/wen
+ detronyx_12t_write_driver_rc1_9/wen detronyx_12t_write_driver_rc1_9/wen detronyx_12t_write_driver_rc1_9/wen
+ detronyx_12t_write_driver_rc1_9/wen detronyx_12t_write_driver_rc1_9/wen detronyx_12t_write_driver_rc1_9/wen
+ detronyx_12t_write_driver_rc1_9/wen gf180mcu_3v3_12t_2r2w_sram_512x8_array_control_core_0/gf180mcu_as_sc_mcu7t3v3__inv_2_9/A
+ detronyx_12t_write_driver_rc1_9/wen gf180mcu_3v3_12t_2r2w_sram_512x8_array_control_core_0/gf180mcu_as_sc_mcu7t3v3__inv_2_382/A
+ detronyx_12t_write_driver_rc1_9/wen gf180mcu_3v3_12t_2r2w_sram_512x8_array_control_core_0/a_14200_61800#
+ detronyx_12t_write_driver_rc1_9/wen detronyx_12t_write_driver_rc1_9/wen gf180mcu_3v3_12t_2r2w_sram_512x8_array_control_core_0/gf180mcu_as_sc_mcu7t3v3__inv_2_27/Y
+ detronyx_12t_write_driver_rc1_9/wen detronyx_12t_write_driver_rc1_9/wen detronyx_12t_write_driver_rc1_9/wen
+ detronyx_12t_write_driver_rc1_9/wen detronyx_12t_write_driver_rc1_9/wen detronyx_12t_write_driver_rc1_9/wen
+ detronyx_12t_write_driver_rc1_9/wen gf180mcu_3v3_12t_2r2w_sram_512x8_array_control_core_0/gf180mcu_as_sc_mcu7t3v3__inv_2_923/Y
+ gf180mcu_3v3_12t_2r2w_sram_512x8_array_control_core_0/a_14200_17000# detronyx_12t_write_driver_rc1_9/wen
+ detronyx_12t_write_driver_rc1_9/wen detronyx_12t_write_driver_rc1_9/wen detronyx_12t_write_driver_rc1_9/wen
+ detronyx_12t_write_driver_rc1_9/wen detronyx_12t_write_driver_rc1_9/wen detronyx_12t_write_driver_rc1_9/wen
+ detronyx_12t_write_driver_rc1_9/wen detronyx_12t_write_driver_rc1_9/wen detronyx_12t_write_driver_rc1_9/wen
+ detronyx_12t_write_driver_rc1_9/wen gf180mcu_3v3_12t_2r2w_sram_512x8_array_control_core_0/u_t014_012/c2_w0_bl
+ detronyx_12t_write_driver_rc1_9/wen detronyx_12t_write_driver_rc1_9/wen detronyx_12t_write_driver_rc1_9/wen
+ gf180mcu_3v3_12t_2r2w_sram_512x8_array_control_core_0/a_22600_47800# detronyx_12t_write_driver_rc1_9/wen
+ detronyx_12t_write_driver_rc1_9/wen gf180mcu_3v3_12t_2r2w_sram_512x8_array_control_core_0/u_t013_014/c2_w0_bl
+ detronyx_12t_write_driver_rc1_9/wen detronyx_12t_write_driver_rc1_9/wen detronyx_12t_write_driver_rc1_9/wen
+ detronyx_12t_write_driver_rc1_9/wen detronyx_12t_write_driver_rc1_9/wen detronyx_12t_write_driver_rc1_9/wen
+ detronyx_12t_write_driver_rc1_9/wen detronyx_12t_write_driver_rc1_9/wen detronyx_12t_write_driver_rc1_9/wen
+ detronyx_12t_write_driver_rc1_9/wen gf180mcu_3v3_12t_2r2w_sram_512x8_array_control_core_0/m4_27000_10138#
+ gf180mcu_3v3_12t_2r2w_sram_512x8_array_control_core_0/u_t014_004/c2_w1_bl detronyx_12t_write_driver_rc1_9/wen
+ gf180mcu_3v3_12t_2r2w_sram_512x8_array_control_core_0/u_t009_012/c2_w0_bl gf180mcu_3v3_12t_2r2w_sram_512x8_array_control_core_0/u_t013_006/c2_w1_bl
+ detronyx_12t_write_driver_rc1_9/wen gf180mcu_3v3_12t_2r2w_sram_512x8_array_control_core_0/a_17000_3000#
+ detronyx_12t_write_driver_rc1_9/wen detronyx_12t_write_driver_rc1_9/wen detronyx_12t_write_driver_rc1_9/wen
+ detronyx_12t_write_driver_rc1_9/wen detronyx_12t_write_driver_rc1_9/wen detronyx_12t_write_driver_rc1_9/wen
+ gf180mcu_3v3_12t_2r2w_sram_512x8_array_control_core_0/gf180mcu_as_sc_mcu7t3v3__inv_2_466/A
+ gf180mcu_3v3_12t_2r2w_sram_512x8_array_control_core_0/u_t005_014/c2_w0_bl detronyx_12t_write_driver_rc1_9/wen
+ detronyx_12t_write_driver_rc1_9/wen detronyx_12t_write_driver_rc1_9/wen detronyx_12t_write_driver_rc1_9/wen
+ detronyx_12t_write_driver_rc1_9/wen detronyx_12t_write_driver_rc1_9/wen detronyx_12t_write_driver_rc1_9/wen
+ detronyx_12t_write_driver_rc1_9/wen detronyx_12t_write_driver_rc1_9/wen detronyx_12t_write_driver_rc1_9/wen
+ detronyx_12t_write_driver_rc1_9/wen detronyx_12t_write_driver_rc1_9/wen detronyx_12t_write_driver_rc1_9/wen
+ detronyx_12t_write_driver_rc1_9/wen gf180mcu_3v3_12t_2r2w_sram_512x8_array_control_core_0/gf180mcu_as_sc_mcu7t3v3__inv_2_545/Y
+ detronyx_12t_write_driver_rc1_9/wen detronyx_12t_write_driver_rc1_9/wen detronyx_12t_write_driver_rc1_9/wen
+ detronyx_12t_write_driver_rc1_9/wen gf180mcu_3v3_12t_2r2w_sram_512x8_array_control_core_0/u_t009_004/c2_w1_bl
+ gf180mcu_3v3_12t_2r2w_sram_512x8_array_control_core_0/u_t002_012/c2_w0_bl detronyx_12t_write_driver_rc1_9/wen
+ gf180mcu_3v3_12t_2r2w_sram_512x8_array_control_core_0/a_14200_50600# gf180mcu_3v3_12t_2r2w_sram_512x8_array_control_core_0/u_t005_006/c2_w1_bl
+ gf180mcu_3v3_12t_2r2w_sram_512x8_array_control_core_0/a_22600_56200# detronyx_12t_write_driver_rc1_9/wen
+ detronyx_12t_write_driver_rc1_9/wen detronyx_12t_write_driver_rc1_9/wen detronyx_12t_write_driver_rc1_9/wen
+ detronyx_12t_write_driver_rc1_9/wen detronyx_12t_write_driver_rc1_9/wen gf180mcu_3v3_12t_2r2w_sram_512x8_array_control_core_0/gf180mcu_as_sc_mcu7t3v3__inv_2_717/A
+ gf180mcu_3v3_12t_2r2w_sram_512x8_array_control_core_0/gf180mcu_as_sc_mcu7t3v3__inv_2_878/Y
+ gf180mcu_3v3_12t_2r2w_sram_512x8_array_control_core_0/u_t002_004/c2_w1_bl detronyx_12t_write_driver_rc1_9/wen
+ detronyx_12t_write_driver_rc1_9/wen detronyx_12t_write_driver_rc1_9/wen detronyx_12t_write_driver_rc1_9/wen
+ detronyx_12t_write_driver_rc1_9/wen detronyx_12t_precharge_sense_rc1_0/dout detronyx_12t_write_driver_rc1_9/wen
+ gf180mcu_3v3_12t_2r2w_sram_512x8_array_control_core_0/u_t000_006/c2_w1_bl detronyx_12t_write_driver_rc1_9/wen
+ detronyx_12t_write_driver_rc1_9/wen detronyx_12t_write_driver_rc1_9/wen detronyx_12t_write_driver_rc1_9/wen
+ detronyx_12t_write_driver_rc1_9/wen detronyx_12t_write_driver_rc1_9/wen detronyx_12t_write_driver_rc1_9/wen
+ detronyx_12t_write_driver_rc1_9/wen detronyx_12t_write_driver_rc1_9/wen detronyx_12t_write_driver_rc1_9/wen
+ detronyx_12t_write_driver_rc1_9/wen detronyx_12t_write_driver_rc1_9/wen detronyx_12t_write_driver_rc1_9/wen
+ detronyx_12t_write_driver_rc1_9/wen gf180mcu_3v3_12t_2r2w_sram_512x8_array_control_core_0/a_200_53400#
+ detronyx_12t_write_driver_rc1_9/wen detronyx_12t_write_driver_rc1_9/wen gf180mcu_3v3_12t_2r2w_sram_512x8_array_control_core_0/a_22600_36600#
+ detronyx_12t_write_driver_rc1_9/wen detronyx_12t_write_driver_rc1_9/wen detronyx_12t_write_driver_rc1_9/wen
+ gf180mcu_3v3_12t_2r2w_sram_512x8_array_control_core_0/gf180mcu_as_sc_mcu7t3v3__inv_2_908/Y
+ detronyx_12t_write_driver_rc1_9/wen detronyx_12t_write_driver_rc1_9/wen detronyx_12t_write_driver_rc1_9/wen
+ detronyx_12t_write_driver_rc1_9/wen gf180mcu_3v3_12t_2r2w_sram_512x8_array_control_core_0/a_28200_3000#
+ detronyx_12t_write_driver_rc1_9/wen detronyx_12t_write_driver_rc1_9/wen detronyx_12t_write_driver_rc1_9/wen
+ detronyx_12t_write_driver_rc1_9/wen detronyx_12t_write_driver_rc1_9/wen detronyx_12t_write_driver_rc1_9/wen
+ detronyx_12t_write_driver_rc1_9/wen detronyx_12t_write_driver_rc1_9/wen gf180mcu_3v3_12t_2r2w_sram_512x8_array_control_core_0/a_200_33800#
+ detronyx_12t_write_driver_rc1_9/wen detronyx_12t_write_driver_rc1_9/wen detronyx_12t_write_driver_rc1_9/wen
+ detronyx_12t_write_driver_rc1_9/wen detronyx_12t_write_driver_rc1_9/wen detronyx_12t_write_driver_rc1_9/wen
+ detronyx_12t_write_driver_rc1_9/wen detronyx_12t_write_driver_rc1_9/wen gf180mcu_3v3_12t_2r2w_sram_512x8_array_control_core_0/u_t015_013/c2_w0_bl
+ detronyx_12t_write_driver_rc1_9/wen detronyx_12t_write_driver_rc1_9/wen detronyx_12t_write_driver_rc1_9/wen
+ detronyx_12t_write_driver_rc1_9/wen detronyx_12t_write_driver_rc1_9/wen detronyx_12t_write_driver_rc1_9/wen
+ detronyx_12t_write_driver_rc1_9/wen detronyx_12t_write_driver_rc1_9/wen detronyx_12t_write_driver_rc1_9/wen
+ detronyx_12t_write_driver_rc1_9/wen gf180mcu_3v3_12t_2r2w_sram_512x8_array_control_core_0/gf180mcu_as_sc_mcu7t3v3__inv_2_917/Y
+ gf180mcu_3v3_12t_2r2w_sram_512x8_array_control_core_0/a_22600_45000# gf180mcu_3v3_12t_2r2w_sram_512x8_array_control_core_0/u_t013_011/c2_w0_bl
+ detronyx_12t_write_driver_rc1_9/wen detronyx_12t_write_driver_rc1_9/wen detronyx_12t_write_driver_rc1_9/wen
+ gf180mcu_3v3_12t_2r2w_sram_512x8_array_control_core_0/u_t015_005/c2_w1_bl gf180mcu_3v3_12t_2r2w_sram_512x8_array_control_core_0/u_t010_013/c2_w0_bl
+ gf180mcu_3v3_12t_2r2w_sram_512x8_array_control_core_0/u_t009_013/c2_w0_bl gf180mcu_3v3_12t_2r2w_sram_512x8_array_control_core_0/u_t013_007/c2_w1_bl
+ detronyx_12t_write_driver_rc1_9/wen detronyx_12t_write_driver_rc1_9/wen detronyx_12t_write_driver_rc1_9/wen
+ detronyx_12t_write_driver_rc1_9/wen detronyx_12t_write_driver_rc1_9/wen detronyx_12t_write_driver_rc1_9/wen
+ detronyx_12t_write_driver_rc1_9/wen detronyx_12t_write_driver_rc1_9/wen detronyx_12t_write_driver_rc1_9/wen
+ detronyx_12t_write_driver_rc1_9/wen detronyx_12t_write_driver_rc1_9/wen detronyx_12t_write_driver_rc1_9/wen
+ detronyx_12t_write_driver_rc1_9/wen detronyx_12t_write_driver_rc1_9/wen detronyx_12t_write_driver_rc1_9/wen
+ detronyx_12t_write_driver_rc1_9/wen gf180mcu_3v3_12t_2r2w_sram_512x8_array_control_core_0/gf180mcu_as_sc_mcu7t3v3__inv_2_177/Y
+ gf180mcu_3v3_12t_2r2w_sram_512x8_array_control_core_0/u_t005_011/c2_w0_bl detronyx_12t_write_driver_rc1_9/wen
+ detronyx_12t_write_driver_rc1_9/wen gf180mcu_3v3_12t_2r2w_sram_512x8_array_control_core_0/a_200_42200#
+ gf180mcu_3v3_12t_2r2w_sram_512x8_array_control_core_0/u_t010_005/c2_w1_bl detronyx_12t_write_driver_rc1_9/wen
+ detronyx_12t_write_driver_rc1_9/wen detronyx_12t_write_driver_rc1_9/wen gf180mcu_3v3_12t_2r2w_sram_512x8_array_control_core_0/a_22600_25400#
+ detronyx_12t_write_driver_rc1_9/wen detronyx_12t_write_driver_rc1_9/wen gf180mcu_3v3_12t_2r2w_sram_512x8_array_control_core_0/gf180mcu_as_sc_mcu7t3v3__inv_2_580/A
+ gf180mcu_3v3_12t_2r2w_sram_512x8_array_control_core_0/u_t009_005/c2_w1_bl detronyx_12t_write_driver_rc1_9/wen
+ gf180mcu_3v3_12t_2r2w_sram_512x8_array_control_core_0/a_14200_8600# detronyx_12t_write_driver_rc1_9/wen
+ gf180mcu_3v3_12t_2r2w_sram_512x8_array_control_core_0/u_t005_013/c2_w0_bl detronyx_12t_write_driver_rc1_9/wen
+ detronyx_12t_write_driver_rc1_9/wen gf180mcu_3v3_12t_2r2w_sram_512x8_array_control_core_0/u_t006_007/c2_w1_bl
+ detronyx_12t_write_driver_rc1_9/wen detronyx_12t_write_driver_rc1_9/wen detronyx_12t_precharge_sense_rc1_0/dout
+ detronyx_12t_write_driver_rc1_9/wen detronyx_12t_write_driver_rc1_9/wen detronyx_12t_write_driver_rc1_9/wen
+ detronyx_12t_write_driver_rc1_9/wen detronyx_12t_write_driver_rc1_9/wen detronyx_12t_write_driver_rc1_9/wen
+ detronyx_12t_write_driver_rc1_9/wen gf180mcu_3v3_12t_2r2w_sram_512x8_array_control_core_0/u_t005_005/c2_w1_bl
+ detronyx_12t_write_driver_rc1_9/wen gf180mcu_3v3_12t_2r2w_sram_512x8_array_control_core_0/gf180mcu_as_sc_mcu7t3v3__inv_2_553/A
+ detronyx_12t_write_driver_rc1_9/wen detronyx_12t_write_driver_rc1_9/wen detronyx_12t_write_driver_rc1_9/wen
+ detronyx_12t_write_driver_rc1_9/wen gf180mcu_3v3_12t_2r2w_sram_512x8_array_control_core_0/a_200_22600#
+ detronyx_12t_write_driver_rc1_9/wen detronyx_12t_write_driver_rc1_9/wen detronyx_12t_write_driver_rc1_9/wen
+ detronyx_12t_write_driver_rc1_9/wen detronyx_12t_write_driver_rc1_9/wen detronyx_12t_write_driver_rc1_9/wen
+ gf180mcu_3v3_12t_2r2w_sram_512x8_array_control_core_0/gf180mcu_as_sc_mcu7t3v3__inv_2_752/Y
+ detronyx_12t_write_driver_rc1_9/wen detronyx_12t_write_driver_rc1_9/wen detronyx_12t_write_driver_rc1_9/wen
+ detronyx_12t_write_driver_rc1_9/wen detronyx_12t_write_driver_rc1_9/wen detronyx_12t_write_driver_rc1_9/wen
+ detronyx_12t_write_driver_rc1_9/wen detronyx_12t_write_driver_rc1_9/wen detronyx_12t_write_driver_rc1_9/wen
+ detronyx_12t_write_driver_rc1_9/wen detronyx_12t_write_driver_rc1_9/wen gf180mcu_3v3_12t_2r2w_sram_512x8_array_control_core_0/gf180mcu_as_sc_mcu7t3v3__inv_2_887/Y
+ detronyx_12t_write_driver_rc1_9/wen detronyx_12t_write_driver_rc1_9/wen detronyx_12t_write_driver_rc1_9/wen
+ detronyx_12t_write_driver_rc1_9/wen detronyx_12t_write_driver_rc1_9/wen detronyx_12t_write_driver_rc1_9/wen
+ detronyx_12t_write_driver_rc1_9/wen detronyx_12t_write_driver_rc1_9/wen detronyx_12t_write_driver_rc1_9/wen
+ detronyx_12t_write_driver_rc1_9/wen detronyx_12t_write_driver_rc1_9/wen detronyx_12t_write_driver_rc1_9/wen
+ detronyx_12t_write_driver_rc1_9/wen detronyx_12t_write_driver_rc1_9/wen detronyx_12t_write_driver_rc1_9/wen
+ detronyx_12t_write_driver_rc1_9/wen detronyx_12t_write_driver_rc1_9/wen detronyx_12t_write_driver_rc1_9/wen
+ detronyx_12t_write_driver_rc1_9/wen detronyx_12t_write_driver_rc1_9/wen gf180mcu_3v3_12t_2r2w_sram_512x8_array_control_core_0/m4_10808_10138#
+ detronyx_12t_write_driver_rc1_9/wen detronyx_12t_write_driver_rc1_9/wen gf180mcu_3v3_12t_2r2w_sram_512x8_array_control_core_0/a_200_31000#
+ detronyx_12t_write_driver_rc1_9/wen gf180mcu_3v3_12t_2r2w_sram_512x8_array_control_core_0/a_22600_14200#
+ detronyx_12t_write_driver_rc1_9/wen detronyx_12t_write_driver_rc1_9/wen detronyx_12t_write_driver_rc1_9/wen
+ detronyx_12t_write_driver_rc1_9/wen detronyx_12t_write_driver_rc1_9/wen detronyx_12t_write_driver_rc1_9/wen
+ detronyx_12t_write_driver_rc1_9/wen gf180mcu_3v3_12t_2r2w_sram_512x8_array_control_core_0/a_22600_5800#
+ detronyx_12t_write_driver_rc1_9/wen gf180mcu_3v3_12t_2r2w_sram_512x8_array_control_core_0/a_14200_47800#
+ detronyx_12t_write_driver_rc1_9/wen detronyx_12t_write_driver_rc1_9/wen gf180mcu_3v3_12t_2r2w_sram_512x8_array_control_core_0/u_t013_012/c2_w0_bl
+ detronyx_12t_write_driver_rc1_9/wen detronyx_12t_write_driver_rc1_9/wen detronyx_12t_write_driver_rc1_9/wen
+ detronyx_12t_write_driver_rc1_9/wen detronyx_12t_write_driver_rc1_9/wen detronyx_12t_write_driver_rc1_9/wen
+ detronyx_12t_write_driver_rc1_9/wen gf180mcu_3v3_12t_2r2w_sram_512x8_array_control_core_0/gf180mcu_as_sc_mcu7t3v3__inv_2_574/A
+ gf180mcu_3v3_12t_2r2w_sram_512x8_array_control_core_0/u_t011_014/c2_w0_bl detronyx_12t_write_driver_rc1_9/wen
+ detronyx_12t_write_driver_rc1_9/wen gf180mcu_3v3_12t_2r2w_sram_512x8_array_control_core_0/u_t009_014/c2_w0_bl
+ detronyx_12t_write_driver_rc1_9/wen detronyx_12t_write_driver_rc1_9/wen detronyx_12t_write_driver_rc1_9/wen
+ detronyx_12t_write_driver_rc1_9/wen detronyx_12t_write_driver_rc1_9/wen detronyx_12t_write_driver_rc1_9/wen
+ detronyx_12t_write_driver_rc1_9/wen detronyx_12t_write_driver_rc1_9/wen detronyx_12t_write_driver_rc1_9/wen
+ detronyx_12t_write_driver_rc1_9/wen gf180mcu_3v3_12t_2r2w_sram_512x8_array_control_core_0/a_200_11400#
+ detronyx_12t_write_driver_rc1_9/wen gf180mcu_3v3_12t_2r2w_sram_512x8_array_control_core_0/u_t013_004/c2_w1_bl
+ detronyx_12t_write_driver_rc1_9/wen detronyx_12t_write_driver_rc1_9/wen detronyx_12t_write_driver_rc1_9/wen
+ gf180mcu_3v3_12t_2r2w_sram_512x8_array_control_core_0/u_t006_012/c2_w0_bl detronyx_12t_write_driver_rc1_9/wen
+ gf180mcu_3v3_12t_2r2w_sram_512x8_array_control_core_0/u_t011_006/c2_w1_bl gf180mcu_3v3_12t_2r2w_sram_512x8_array_control_core_0/gf180mcu_as_sc_mcu7t3v3__inv_2_930/A
+ detronyx_12t_write_driver_rc1_9/wen gf180mcu_3v3_12t_2r2w_sram_512x8_array_control_core_0/u_t009_006/c2_w1_bl
+ detronyx_12t_write_driver_rc1_9/wen detronyx_12t_write_driver_rc1_9/wen detronyx_12t_write_driver_rc1_9/wen
+ gf180mcu_3v3_12t_2r2w_sram_512x8_array_control_core_0/u_t005_014/c2_w0_bl detronyx_12t_write_driver_rc1_9/wen
+ detronyx_12t_write_driver_rc1_9/wen detronyx_12t_write_driver_rc1_9/wen detronyx_12t_write_driver_rc1_9/wen
+ detronyx_12t_write_driver_rc1_9/wen detronyx_12t_write_driver_rc1_9/wen detronyx_12t_write_driver_rc1_9/wen
+ detronyx_12t_write_driver_rc1_9/wen detronyx_12t_write_driver_rc1_9/wen detronyx_12t_write_driver_rc1_9/wen
+ detronyx_12t_write_driver_rc1_9/wen detronyx_12t_write_driver_rc1_9/wen detronyx_12t_write_driver_rc1_9/wen
+ gf180mcu_3v3_12t_2r2w_sram_512x8_array_control_core_0/u_t006_004/c2_w1_bl detronyx_12t_write_driver_rc1_9/wen
+ gf180mcu_3v3_12t_2r2w_sram_512x8_array_control_core_0/a_14200_56200# detronyx_12t_write_driver_rc1_9/wen
+ detronyx_12t_write_driver_rc1_9/wen detronyx_12t_write_driver_rc1_9/wen gf180mcu_3v3_12t_2r2w_sram_512x8_array_control_core_0/u_t005_006/c2_w1_bl
+ detronyx_12t_write_driver_rc1_9/wen detronyx_12t_write_driver_rc1_9/wen gf180mcu_3v3_12t_2r2w_sram_512x8_array_control_core_0/gf180mcu_as_sc_mcu7t3v3__inv_2_611/Y
+ detronyx_12t_write_driver_rc1_9/wen detronyx_12t_write_driver_rc1_9/wen detronyx_12t_write_driver_rc1_9/wen
+ gf180mcu_3v3_12t_2r2w_sram_512x8_array_control_core_0/gf180mcu_as_sc_mcu7t3v3__inv_2_589/A
+ detronyx_12t_write_driver_rc1_9/wen detronyx_12t_write_driver_rc1_9/wen detronyx_12t_write_driver_rc1_9/wen
+ detronyx_12t_write_driver_rc1_9/wen detronyx_12t_write_driver_rc1_9/wen detronyx_12t_write_driver_rc1_9/wen
+ detronyx_12t_write_driver_rc1_9/wen detronyx_12t_write_driver_rc1_9/wen VSUBS detronyx_12t_write_driver_rc1_9/wen
+ detronyx_12t_write_driver_rc1_9/wen detronyx_12t_write_driver_rc1_9/wen detronyx_12t_write_driver_rc1_9/wen
+ detronyx_12t_write_driver_rc1_9/wen detronyx_12t_write_driver_rc1_9/wen gf180mcu_3v3_12t_2r2w_sram_512x8_array_control_core_0/gf180mcu_as_sc_mcu7t3v3__inv_2_776/Y
+ gf180mcu_3v3_12t_2r2w_sram_512x8_array_control_core_0/a_14200_36600# gf180mcu_3v3_12t_2r2w_sram_512x8_array_control_core_0/a_200_59000#
+ detronyx_12t_write_driver_rc1_9/wen detronyx_12t_write_driver_rc1_9/wen detronyx_12t_write_driver_rc1_9/wen
+ detronyx_12t_write_driver_rc1_9/wen detronyx_12t_write_driver_rc1_9/wen detronyx_12t_write_driver_rc1_9/wen
+ detronyx_12t_write_driver_rc1_9/wen detronyx_12t_write_driver_rc1_9/wen detronyx_12t_write_driver_rc1_9/wen
+ detronyx_12t_write_driver_rc1_9/wen detronyx_12t_write_driver_rc1_9/wen gf180mcu_3v3_12t_2r2w_sram_512x8_array_control_core_0/gf180mcu_as_sc_mcu7t3v3__inv_2_562/A
+ detronyx_12t_write_driver_rc1_9/wen detronyx_12t_write_driver_rc1_9/wen gf180mcu_3v3_12t_2r2w_sram_512x8_array_control_core
Xdetronyx_12t_write_driver_rc1_6 detronyx_12t_write_driver_rc1_6/VDD VSUBS detronyx_12t_write_driver_rc1_6/din
+ detronyx_12t_write_driver_rc1_9/wen detronyx_12t_write_driver_rc1_6/wbl0 detronyx_12t_write_driver_rc1_9/wen
+ detronyx_12t_write_driver_rc1
Xdetronyx_12t_precharge_sense_rc1_2 detronyx_12t_precharge_sense_rc1_2/VDD VSUBS detronyx_12t_precharge_sense_rc1_2/dout
+ detronyx_12t_precharge_sense_rc1_2/ren detronyx_12t_precharge_sense_rc1_2/ren detronyx_12t_precharge_sense_rc1_2/dout
+ detronyx_12t_precharge_sense_rc1
Xdetronyx_12t_write_driver_rc1_7 detronyx_12t_write_driver_rc1_7/VDD VSUBS detronyx_12t_write_driver_rc1_7/din
+ detronyx_12t_write_driver_rc1_9/wen detronyx_12t_write_driver_rc1_7/wbl0 detronyx_12t_write_driver_rc1_9/wen
+ detronyx_12t_write_driver_rc1
Xdetronyx_12t_precharge_sense_rc1_3 detronyx_12t_precharge_sense_rc1_3/VDD VSUBS detronyx_12t_precharge_sense_rc1_3/dout
+ detronyx_12t_precharge_sense_rc1_3/ren detronyx_12t_precharge_sense_rc1_3/ren detronyx_12t_precharge_sense_rc1_3/dout
+ detronyx_12t_precharge_sense_rc1
Xdetronyx_12t_write_driver_rc1_8 detronyx_12t_write_driver_rc1_8/VDD VSUBS detronyx_12t_write_driver_rc1_8/din
+ detronyx_12t_write_driver_rc1_9/wen detronyx_12t_write_driver_rc1_8/wbl0 detronyx_12t_write_driver_rc1_9/wen
+ detronyx_12t_write_driver_rc1
Xdetronyx_12t_precharge_sense_rc1_4 detronyx_12t_precharge_sense_rc1_4/VDD VSUBS detronyx_12t_precharge_sense_rc1_4/dout
+ detronyx_12t_precharge_sense_rc1_4/ren detronyx_12t_precharge_sense_rc1_4/ren detronyx_12t_precharge_sense_rc1_4/dout
+ detronyx_12t_precharge_sense_rc1
Xdetronyx_12t_write_driver_rc1_9 detronyx_12t_write_driver_rc1_9/VDD VSUBS detronyx_12t_write_driver_rc1_9/din
+ detronyx_12t_write_driver_rc1_9/wen detronyx_12t_write_driver_rc1_9/wbl0 detronyx_12t_write_driver_rc1_9/wen
+ detronyx_12t_write_driver_rc1
Xdetronyx_12t_precharge_sense_rc1_5 detronyx_12t_precharge_sense_rc1_5/VDD VSUBS detronyx_12t_precharge_sense_rc1_5/dout
+ detronyx_12t_write_driver_rc1_9/wen detronyx_12t_write_driver_rc1_9/wen detronyx_12t_precharge_sense_rc1_5/dout
+ detronyx_12t_precharge_sense_rc1
Xdetronyx_12t_precharge_sense_rc1_6 detronyx_12t_precharge_sense_rc1_6/VDD VSUBS detronyx_12t_write_driver_rc1_9/wen
+ detronyx_12t_write_driver_rc1_9/wen detronyx_12t_write_driver_rc1_9/wen detronyx_12t_write_driver_rc1_9/wen
+ detronyx_12t_precharge_sense_rc1
Xdetronyx_12t_precharge_sense_rc1_7 detronyx_12t_precharge_sense_rc1_7/VDD VSUBS detronyx_12t_write_driver_rc1_9/wen
+ detronyx_12t_write_driver_rc1_9/wen detronyx_12t_write_driver_rc1_9/wen detronyx_12t_write_driver_rc1_9/wen
+ detronyx_12t_precharge_sense_rc1
Xdetronyx_12t_precharge_sense_rc1_8 detronyx_12t_precharge_sense_rc1_8/VDD VSUBS detronyx_12t_write_driver_rc1_9/wen
+ detronyx_12t_precharge_sense_rc1_8/ren detronyx_12t_precharge_sense_rc1_8/ren detronyx_12t_write_driver_rc1_9/wen
+ detronyx_12t_precharge_sense_rc1
Xdetronyx_12t_precharge_sense_rc1_9 detronyx_12t_precharge_sense_rc1_9/VDD VSUBS detronyx_12t_precharge_sense_rc1_9/dout
+ detronyx_12t_precharge_sense_rc1_9/ren detronyx_12t_precharge_sense_rc1_9/ren detronyx_12t_precharge_sense_rc1_9/dout
+ detronyx_12t_precharge_sense_rc1
Xdetronyx_12t_write_driver_rc1_10 detronyx_12t_write_driver_rc1_10/VDD VSUBS detronyx_12t_write_driver_rc1_10/din
+ detronyx_12t_write_driver_rc1_9/wen detronyx_12t_write_driver_rc1_10/wbl0 detronyx_12t_write_driver_rc1_9/wen
+ detronyx_12t_write_driver_rc1
.ends
